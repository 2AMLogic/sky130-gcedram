* refresh_op.spice -- closed-loop row refresh operation (sense -> write-back), issue #110
* GENERATED by gen_refresh_op.py; do not edit by hand.
*
* PROPOSED/UNRATIFIED SCOPE: corners/temperatures (27 C, 125 C, five global corners, 1.8 V)
* come from spec/operating-range-decision-PROPOSED.md. CIRCUIT BODY for `klt sim`.
*
* One op = precharge (rbl/ref to VRBL/VREF) -> RWL select -> latch enable at select+SENSE ->
* (+T_LATCH) WWL pulse of width WB with the latch COMPLEMENT node `ref` connected to WBL
* (stored '1' pulls rbl down, so ref goes high and writes '1') -> +T_GUARD release of
* latch, WBL connection and RWL -> SN read T_MEAS later.
* Instances: op1_* / op0_* = full op, pre-read SN level in name (n=negative, mV), s<ns> =
* sense time, w<ns> = WWL pulse (p = decimal point). refw = in-deck reference write:
* SN from 0 V, ideal 1.8 V WBL, 20 ns WWL (the 'post-write level' the restore test is
* measured against). w0p2 = NEGATIVE CONTROL pulse (too short; must be flagged unrestored).
*
* ASSUMPTIONS (none is a spec value): ideal switches for precharge / WBL connect (100 ohm),
* ideal WWL/RWL/enable drivers, C_RBL = C_WBL = 10 fF (not extracted), 4-row column all rows
* at one level, ideal matched dummy reference load, reference = VRBL - 100 mV, latch sizes
* (first pass), T_LATCH and T_GUARD fixed, global corners only (no mismatch).

.param VDD   = 1.8
.param VRBL  = 0.9   $ ASSUMPTION (contract)
.param TEDGE = 1e-10
.param T_READ = 4e-09   $ select edge = T_PRE_ON + T_PRE_GAP
.param T_PGAP = 2e-09
.param C_RBL = 1e-14   $ ASSUMPTION (contract; not extracted)
.param C_WBL = 1e-14   $ ASSUMPTION (not extracted)
.param C_SN  = 6.05354e-16   $ extracted-from-netlist (layout/gain_cell_2t.extract.parasitics.json)

* ---- shared drivers (ideal) ----
vdd   vdd 0 dc {VDD}
vctl  ctl 0 pwl(0 {VDD} {T_READ-T_PGAP} {VDD} {T_READ-T_PGAP+TEDGE} 0)
vrwld rwl_des 0 dc {VDD}
vwwld wwl_des 0 dc 0
vpre  prea 0 dc {VRBL}
vref  pref 0 dc 0.8   $ reference = VRBL - 0.1 (ASSUMPTION)
vwbi  wbl_ideal 0 dc {VDD}
.model swpre sw(vt=0.9 vh=0.1 ron=100 roff=1e12)
.model swwbl sw(vt=0.9 vh=0.1 ron=100 roff=1e12)

* ---- instance 0: op1_0900_s0p5_w0p2 (t_en 4.5 ns, WWL 5.5..5.7 ns, release 7.7 ns) ----
ven_op1_0900_s0p5_w0p2  en_op1_0900_s0p5_w0p2  0 pwl(0 0 4.5000e-09 0 4.6000e-09 {VDD} 7.7000e-09 {VDD} 7.8000e-09 0)
venb_op1_0900_s0p5_w0p2 enb_op1_0900_s0p5_w0p2 0 pwl(0 {VDD} 4.5000e-09 {VDD} 4.6000e-09 0 7.7000e-09 0 7.8000e-09 {VDD})
vrs_op1_0900_s0p5_w0p2  rwls_op1_0900_s0p5_w0p2 0 pwl(0 {VDD} {T_READ} {VDD} {T_READ+TEDGE} 0 7.7000e-09 0 7.8000e-09 {VDD})
vww_op1_0900_s0p5_w0p2  wwl_op1_0900_s0p5_w0p2 0 pwl(0 0 5.5000e-09 0 5.6000e-09 {VDD} 5.7000e-09 {VDD} 5.8000e-09 0)
vwc_op1_0900_s0p5_w0p2  wbc_op1_0900_s0p5_w0p2 0 pwl(0 0 5.5000e-09 0 5.6000e-09 {VDD} 7.7000e-09 {VDD} 7.8000e-09 0)
swb_op1_0900_s0p5_w0p2 ref_op1_0900_s0p5_w0p2 wbl_op1_0900_s0p5_w0p2 wbc_op1_0900_s0p5_w0p2 0 swwbl
cwbl_op1_0900_s0p5_w0p2 wbl_op1_0900_s0p5_w0p2 0 {C_WBL}
spa_op1_0900_s0p5_w0p2 prea rbl_op1_0900_s0p5_w0p2 ctl 0 swpre
spr_op1_0900_s0p5_w0p2 pref ref_op1_0900_s0p5_w0p2 ctl 0 swpre
crbl_op1_0900_s0p5_w0p2 rbl_op1_0900_s0p5_w0p2 0 {C_RBL}
cref_op1_0900_s0p5_w0p2 ref_op1_0900_s0p5_w0p2 0 {C_RBL}   $ ASSUMPTION: ideal matched dummy load
XMWR_op1_0900_s0p5_w0p2_0 sn_op1_0900_s0p5_w0p2_0 wwl_op1_0900_s0p5_w0p2 wbl_op1_0900_s0p5_w0p2 0 sky130_fd_pr__nfet_01v8 L=0.15 W=0.42 nf=1 ad=0.1218 as=0.1218 pd=1.42 ps=1.42 nrd=0.69047619047619  nrs=0.69047619047619 sa=0 sb=0 sd=0 mult=1 m=1
XMRD_op1_0900_s0p5_w0p2_0 rbl_op1_0900_s0p5_w0p2 sn_op1_0900_s0p5_w0p2_0 rwls_op1_0900_s0p5_w0p2 0 sky130_fd_pr__nfet_01v8 L=0.15 W=0.42 nf=1 ad=0.1218 as=0.1218 pd=1.42 ps=1.42 nrd=0.69047619047619  nrs=0.69047619047619 sa=0 sb=0 sd=0 mult=1 m=1
csn_op1_0900_s0p5_w0p2_0 sn_op1_0900_s0p5_w0p2_0 0 {C_SN}
XMWR_op1_0900_s0p5_w0p2_1 sn_op1_0900_s0p5_w0p2_1 wwl_des wbl_op1_0900_s0p5_w0p2 0 sky130_fd_pr__nfet_01v8 L=0.15 W=0.42 nf=1 ad=0.1218 as=0.1218 pd=1.42 ps=1.42 nrd=0.69047619047619  nrs=0.69047619047619 sa=0 sb=0 sd=0 mult=1 m=1
XMRD_op1_0900_s0p5_w0p2_1 rbl_op1_0900_s0p5_w0p2 sn_op1_0900_s0p5_w0p2_1 rwl_des 0 sky130_fd_pr__nfet_01v8 L=0.15 W=0.42 nf=1 ad=0.1218 as=0.1218 pd=1.42 ps=1.42 nrd=0.69047619047619  nrs=0.69047619047619 sa=0 sb=0 sd=0 mult=1 m=1
csn_op1_0900_s0p5_w0p2_1 sn_op1_0900_s0p5_w0p2_1 0 {C_SN}
XMWR_op1_0900_s0p5_w0p2_2 sn_op1_0900_s0p5_w0p2_2 wwl_des wbl_op1_0900_s0p5_w0p2 0 sky130_fd_pr__nfet_01v8 L=0.15 W=0.42 nf=1 ad=0.1218 as=0.1218 pd=1.42 ps=1.42 nrd=0.69047619047619  nrs=0.69047619047619 sa=0 sb=0 sd=0 mult=1 m=1
XMRD_op1_0900_s0p5_w0p2_2 rbl_op1_0900_s0p5_w0p2 sn_op1_0900_s0p5_w0p2_2 rwl_des 0 sky130_fd_pr__nfet_01v8 L=0.15 W=0.42 nf=1 ad=0.1218 as=0.1218 pd=1.42 ps=1.42 nrd=0.69047619047619  nrs=0.69047619047619 sa=0 sb=0 sd=0 mult=1 m=1
csn_op1_0900_s0p5_w0p2_2 sn_op1_0900_s0p5_w0p2_2 0 {C_SN}
XMWR_op1_0900_s0p5_w0p2_3 sn_op1_0900_s0p5_w0p2_3 wwl_des wbl_op1_0900_s0p5_w0p2 0 sky130_fd_pr__nfet_01v8 L=0.15 W=0.42 nf=1 ad=0.1218 as=0.1218 pd=1.42 ps=1.42 nrd=0.69047619047619  nrs=0.69047619047619 sa=0 sb=0 sd=0 mult=1 m=1
XMRD_op1_0900_s0p5_w0p2_3 rbl_op1_0900_s0p5_w0p2 sn_op1_0900_s0p5_w0p2_3 rwl_des 0 sky130_fd_pr__nfet_01v8 L=0.15 W=0.42 nf=1 ad=0.1218 as=0.1218 pd=1.42 ps=1.42 nrd=0.69047619047619  nrs=0.69047619047619 sa=0 sb=0 sd=0 mult=1 m=1
csn_op1_0900_s0p5_w0p2_3 sn_op1_0900_s0p5_w0p2_3 0 {C_SN}
XMN1_op1_0900_s0p5_w0p2 rbl_op1_0900_s0p5_w0p2 ref_op1_0900_s0p5_w0p2 vn_op1_0900_s0p5_w0p2 0 sky130_fd_pr__nfet_01v8 L=0.15 W=1 nf=1 ad=0.29 as=0.29 pd=2.58 ps=2.58 mult=1 m=1
XMN2_op1_0900_s0p5_w0p2 ref_op1_0900_s0p5_w0p2 rbl_op1_0900_s0p5_w0p2 vn_op1_0900_s0p5_w0p2 0 sky130_fd_pr__nfet_01v8 L=0.15 W=1 nf=1 ad=0.29 as=0.29 pd=2.58 ps=2.58 mult=1 m=1
XMP1_op1_0900_s0p5_w0p2 rbl_op1_0900_s0p5_w0p2 ref_op1_0900_s0p5_w0p2 vp_op1_0900_s0p5_w0p2 vdd sky130_fd_pr__pfet_01v8 L=0.15 W=2 nf=1 ad=0.58 as=0.58 pd=4.58 ps=4.58 mult=1 m=1
XMP2_op1_0900_s0p5_w0p2 ref_op1_0900_s0p5_w0p2 rbl_op1_0900_s0p5_w0p2 vp_op1_0900_s0p5_w0p2 vdd sky130_fd_pr__pfet_01v8 L=0.15 W=2 nf=1 ad=0.58 as=0.58 pd=4.58 ps=4.58 mult=1 m=1
XMNF_op1_0900_s0p5_w0p2 vn_op1_0900_s0p5_w0p2 en_op1_0900_s0p5_w0p2 0 0 sky130_fd_pr__nfet_01v8 L=0.15 W=2 nf=1 ad=0.58 as=0.58 pd=4.58 ps=4.58 mult=1 m=1
XMPH_op1_0900_s0p5_w0p2 vp_op1_0900_s0p5_w0p2 enb_op1_0900_s0p5_w0p2 vdd vdd sky130_fd_pr__pfet_01v8 L=0.15 W=4 nf=1 ad=1.16 as=1.16 pd=8.58 ps=8.58 mult=1 m=1
bd_op1_0900_s0p5_w0p2 d_op1_0900_s0p5_w0p2 0 v=v(rbl_op1_0900_s0p5_w0p2)-v(ref_op1_0900_s0p5_w0p2)

* ---- instance 1: op1_0900_s0p5_w0p5 (t_en 4.5 ns, WWL 5.5..6 ns, release 8 ns) ----
ven_op1_0900_s0p5_w0p5  en_op1_0900_s0p5_w0p5  0 pwl(0 0 4.5000e-09 0 4.6000e-09 {VDD} 8.0000e-09 {VDD} 8.1000e-09 0)
venb_op1_0900_s0p5_w0p5 enb_op1_0900_s0p5_w0p5 0 pwl(0 {VDD} 4.5000e-09 {VDD} 4.6000e-09 0 8.0000e-09 0 8.1000e-09 {VDD})
vrs_op1_0900_s0p5_w0p5  rwls_op1_0900_s0p5_w0p5 0 pwl(0 {VDD} {T_READ} {VDD} {T_READ+TEDGE} 0 8.0000e-09 0 8.1000e-09 {VDD})
vww_op1_0900_s0p5_w0p5  wwl_op1_0900_s0p5_w0p5 0 pwl(0 0 5.5000e-09 0 5.6000e-09 {VDD} 6.0000e-09 {VDD} 6.1000e-09 0)
vwc_op1_0900_s0p5_w0p5  wbc_op1_0900_s0p5_w0p5 0 pwl(0 0 5.5000e-09 0 5.6000e-09 {VDD} 8.0000e-09 {VDD} 8.1000e-09 0)
swb_op1_0900_s0p5_w0p5 ref_op1_0900_s0p5_w0p5 wbl_op1_0900_s0p5_w0p5 wbc_op1_0900_s0p5_w0p5 0 swwbl
cwbl_op1_0900_s0p5_w0p5 wbl_op1_0900_s0p5_w0p5 0 {C_WBL}
spa_op1_0900_s0p5_w0p5 prea rbl_op1_0900_s0p5_w0p5 ctl 0 swpre
spr_op1_0900_s0p5_w0p5 pref ref_op1_0900_s0p5_w0p5 ctl 0 swpre
crbl_op1_0900_s0p5_w0p5 rbl_op1_0900_s0p5_w0p5 0 {C_RBL}
cref_op1_0900_s0p5_w0p5 ref_op1_0900_s0p5_w0p5 0 {C_RBL}   $ ASSUMPTION: ideal matched dummy load
XMWR_op1_0900_s0p5_w0p5_0 sn_op1_0900_s0p5_w0p5_0 wwl_op1_0900_s0p5_w0p5 wbl_op1_0900_s0p5_w0p5 0 sky130_fd_pr__nfet_01v8 L=0.15 W=0.42 nf=1 ad=0.1218 as=0.1218 pd=1.42 ps=1.42 nrd=0.69047619047619  nrs=0.69047619047619 sa=0 sb=0 sd=0 mult=1 m=1
XMRD_op1_0900_s0p5_w0p5_0 rbl_op1_0900_s0p5_w0p5 sn_op1_0900_s0p5_w0p5_0 rwls_op1_0900_s0p5_w0p5 0 sky130_fd_pr__nfet_01v8 L=0.15 W=0.42 nf=1 ad=0.1218 as=0.1218 pd=1.42 ps=1.42 nrd=0.69047619047619  nrs=0.69047619047619 sa=0 sb=0 sd=0 mult=1 m=1
csn_op1_0900_s0p5_w0p5_0 sn_op1_0900_s0p5_w0p5_0 0 {C_SN}
XMWR_op1_0900_s0p5_w0p5_1 sn_op1_0900_s0p5_w0p5_1 wwl_des wbl_op1_0900_s0p5_w0p5 0 sky130_fd_pr__nfet_01v8 L=0.15 W=0.42 nf=1 ad=0.1218 as=0.1218 pd=1.42 ps=1.42 nrd=0.69047619047619  nrs=0.69047619047619 sa=0 sb=0 sd=0 mult=1 m=1
XMRD_op1_0900_s0p5_w0p5_1 rbl_op1_0900_s0p5_w0p5 sn_op1_0900_s0p5_w0p5_1 rwl_des 0 sky130_fd_pr__nfet_01v8 L=0.15 W=0.42 nf=1 ad=0.1218 as=0.1218 pd=1.42 ps=1.42 nrd=0.69047619047619  nrs=0.69047619047619 sa=0 sb=0 sd=0 mult=1 m=1
csn_op1_0900_s0p5_w0p5_1 sn_op1_0900_s0p5_w0p5_1 0 {C_SN}
XMWR_op1_0900_s0p5_w0p5_2 sn_op1_0900_s0p5_w0p5_2 wwl_des wbl_op1_0900_s0p5_w0p5 0 sky130_fd_pr__nfet_01v8 L=0.15 W=0.42 nf=1 ad=0.1218 as=0.1218 pd=1.42 ps=1.42 nrd=0.69047619047619  nrs=0.69047619047619 sa=0 sb=0 sd=0 mult=1 m=1
XMRD_op1_0900_s0p5_w0p5_2 rbl_op1_0900_s0p5_w0p5 sn_op1_0900_s0p5_w0p5_2 rwl_des 0 sky130_fd_pr__nfet_01v8 L=0.15 W=0.42 nf=1 ad=0.1218 as=0.1218 pd=1.42 ps=1.42 nrd=0.69047619047619  nrs=0.69047619047619 sa=0 sb=0 sd=0 mult=1 m=1
csn_op1_0900_s0p5_w0p5_2 sn_op1_0900_s0p5_w0p5_2 0 {C_SN}
XMWR_op1_0900_s0p5_w0p5_3 sn_op1_0900_s0p5_w0p5_3 wwl_des wbl_op1_0900_s0p5_w0p5 0 sky130_fd_pr__nfet_01v8 L=0.15 W=0.42 nf=1 ad=0.1218 as=0.1218 pd=1.42 ps=1.42 nrd=0.69047619047619  nrs=0.69047619047619 sa=0 sb=0 sd=0 mult=1 m=1
XMRD_op1_0900_s0p5_w0p5_3 rbl_op1_0900_s0p5_w0p5 sn_op1_0900_s0p5_w0p5_3 rwl_des 0 sky130_fd_pr__nfet_01v8 L=0.15 W=0.42 nf=1 ad=0.1218 as=0.1218 pd=1.42 ps=1.42 nrd=0.69047619047619  nrs=0.69047619047619 sa=0 sb=0 sd=0 mult=1 m=1
csn_op1_0900_s0p5_w0p5_3 sn_op1_0900_s0p5_w0p5_3 0 {C_SN}
XMN1_op1_0900_s0p5_w0p5 rbl_op1_0900_s0p5_w0p5 ref_op1_0900_s0p5_w0p5 vn_op1_0900_s0p5_w0p5 0 sky130_fd_pr__nfet_01v8 L=0.15 W=1 nf=1 ad=0.29 as=0.29 pd=2.58 ps=2.58 mult=1 m=1
XMN2_op1_0900_s0p5_w0p5 ref_op1_0900_s0p5_w0p5 rbl_op1_0900_s0p5_w0p5 vn_op1_0900_s0p5_w0p5 0 sky130_fd_pr__nfet_01v8 L=0.15 W=1 nf=1 ad=0.29 as=0.29 pd=2.58 ps=2.58 mult=1 m=1
XMP1_op1_0900_s0p5_w0p5 rbl_op1_0900_s0p5_w0p5 ref_op1_0900_s0p5_w0p5 vp_op1_0900_s0p5_w0p5 vdd sky130_fd_pr__pfet_01v8 L=0.15 W=2 nf=1 ad=0.58 as=0.58 pd=4.58 ps=4.58 mult=1 m=1
XMP2_op1_0900_s0p5_w0p5 ref_op1_0900_s0p5_w0p5 rbl_op1_0900_s0p5_w0p5 vp_op1_0900_s0p5_w0p5 vdd sky130_fd_pr__pfet_01v8 L=0.15 W=2 nf=1 ad=0.58 as=0.58 pd=4.58 ps=4.58 mult=1 m=1
XMNF_op1_0900_s0p5_w0p5 vn_op1_0900_s0p5_w0p5 en_op1_0900_s0p5_w0p5 0 0 sky130_fd_pr__nfet_01v8 L=0.15 W=2 nf=1 ad=0.58 as=0.58 pd=4.58 ps=4.58 mult=1 m=1
XMPH_op1_0900_s0p5_w0p5 vp_op1_0900_s0p5_w0p5 enb_op1_0900_s0p5_w0p5 vdd vdd sky130_fd_pr__pfet_01v8 L=0.15 W=4 nf=1 ad=1.16 as=1.16 pd=8.58 ps=8.58 mult=1 m=1
bd_op1_0900_s0p5_w0p5 d_op1_0900_s0p5_w0p5 0 v=v(rbl_op1_0900_s0p5_w0p5)-v(ref_op1_0900_s0p5_w0p5)

* ---- instance 2: op1_0900_s0p5_w1 (t_en 4.5 ns, WWL 5.5..6.5 ns, release 8.5 ns) ----
ven_op1_0900_s0p5_w1  en_op1_0900_s0p5_w1  0 pwl(0 0 4.5000e-09 0 4.6000e-09 {VDD} 8.5000e-09 {VDD} 8.6000e-09 0)
venb_op1_0900_s0p5_w1 enb_op1_0900_s0p5_w1 0 pwl(0 {VDD} 4.5000e-09 {VDD} 4.6000e-09 0 8.5000e-09 0 8.6000e-09 {VDD})
vrs_op1_0900_s0p5_w1  rwls_op1_0900_s0p5_w1 0 pwl(0 {VDD} {T_READ} {VDD} {T_READ+TEDGE} 0 8.5000e-09 0 8.6000e-09 {VDD})
vww_op1_0900_s0p5_w1  wwl_op1_0900_s0p5_w1 0 pwl(0 0 5.5000e-09 0 5.6000e-09 {VDD} 6.5000e-09 {VDD} 6.6000e-09 0)
vwc_op1_0900_s0p5_w1  wbc_op1_0900_s0p5_w1 0 pwl(0 0 5.5000e-09 0 5.6000e-09 {VDD} 8.5000e-09 {VDD} 8.6000e-09 0)
swb_op1_0900_s0p5_w1 ref_op1_0900_s0p5_w1 wbl_op1_0900_s0p5_w1 wbc_op1_0900_s0p5_w1 0 swwbl
cwbl_op1_0900_s0p5_w1 wbl_op1_0900_s0p5_w1 0 {C_WBL}
spa_op1_0900_s0p5_w1 prea rbl_op1_0900_s0p5_w1 ctl 0 swpre
spr_op1_0900_s0p5_w1 pref ref_op1_0900_s0p5_w1 ctl 0 swpre
crbl_op1_0900_s0p5_w1 rbl_op1_0900_s0p5_w1 0 {C_RBL}
cref_op1_0900_s0p5_w1 ref_op1_0900_s0p5_w1 0 {C_RBL}   $ ASSUMPTION: ideal matched dummy load
XMWR_op1_0900_s0p5_w1_0 sn_op1_0900_s0p5_w1_0 wwl_op1_0900_s0p5_w1 wbl_op1_0900_s0p5_w1 0 sky130_fd_pr__nfet_01v8 L=0.15 W=0.42 nf=1 ad=0.1218 as=0.1218 pd=1.42 ps=1.42 nrd=0.69047619047619  nrs=0.69047619047619 sa=0 sb=0 sd=0 mult=1 m=1
XMRD_op1_0900_s0p5_w1_0 rbl_op1_0900_s0p5_w1 sn_op1_0900_s0p5_w1_0 rwls_op1_0900_s0p5_w1 0 sky130_fd_pr__nfet_01v8 L=0.15 W=0.42 nf=1 ad=0.1218 as=0.1218 pd=1.42 ps=1.42 nrd=0.69047619047619  nrs=0.69047619047619 sa=0 sb=0 sd=0 mult=1 m=1
csn_op1_0900_s0p5_w1_0 sn_op1_0900_s0p5_w1_0 0 {C_SN}
XMWR_op1_0900_s0p5_w1_1 sn_op1_0900_s0p5_w1_1 wwl_des wbl_op1_0900_s0p5_w1 0 sky130_fd_pr__nfet_01v8 L=0.15 W=0.42 nf=1 ad=0.1218 as=0.1218 pd=1.42 ps=1.42 nrd=0.69047619047619  nrs=0.69047619047619 sa=0 sb=0 sd=0 mult=1 m=1
XMRD_op1_0900_s0p5_w1_1 rbl_op1_0900_s0p5_w1 sn_op1_0900_s0p5_w1_1 rwl_des 0 sky130_fd_pr__nfet_01v8 L=0.15 W=0.42 nf=1 ad=0.1218 as=0.1218 pd=1.42 ps=1.42 nrd=0.69047619047619  nrs=0.69047619047619 sa=0 sb=0 sd=0 mult=1 m=1
csn_op1_0900_s0p5_w1_1 sn_op1_0900_s0p5_w1_1 0 {C_SN}
XMWR_op1_0900_s0p5_w1_2 sn_op1_0900_s0p5_w1_2 wwl_des wbl_op1_0900_s0p5_w1 0 sky130_fd_pr__nfet_01v8 L=0.15 W=0.42 nf=1 ad=0.1218 as=0.1218 pd=1.42 ps=1.42 nrd=0.69047619047619  nrs=0.69047619047619 sa=0 sb=0 sd=0 mult=1 m=1
XMRD_op1_0900_s0p5_w1_2 rbl_op1_0900_s0p5_w1 sn_op1_0900_s0p5_w1_2 rwl_des 0 sky130_fd_pr__nfet_01v8 L=0.15 W=0.42 nf=1 ad=0.1218 as=0.1218 pd=1.42 ps=1.42 nrd=0.69047619047619  nrs=0.69047619047619 sa=0 sb=0 sd=0 mult=1 m=1
csn_op1_0900_s0p5_w1_2 sn_op1_0900_s0p5_w1_2 0 {C_SN}
XMWR_op1_0900_s0p5_w1_3 sn_op1_0900_s0p5_w1_3 wwl_des wbl_op1_0900_s0p5_w1 0 sky130_fd_pr__nfet_01v8 L=0.15 W=0.42 nf=1 ad=0.1218 as=0.1218 pd=1.42 ps=1.42 nrd=0.69047619047619  nrs=0.69047619047619 sa=0 sb=0 sd=0 mult=1 m=1
XMRD_op1_0900_s0p5_w1_3 rbl_op1_0900_s0p5_w1 sn_op1_0900_s0p5_w1_3 rwl_des 0 sky130_fd_pr__nfet_01v8 L=0.15 W=0.42 nf=1 ad=0.1218 as=0.1218 pd=1.42 ps=1.42 nrd=0.69047619047619  nrs=0.69047619047619 sa=0 sb=0 sd=0 mult=1 m=1
csn_op1_0900_s0p5_w1_3 sn_op1_0900_s0p5_w1_3 0 {C_SN}
XMN1_op1_0900_s0p5_w1 rbl_op1_0900_s0p5_w1 ref_op1_0900_s0p5_w1 vn_op1_0900_s0p5_w1 0 sky130_fd_pr__nfet_01v8 L=0.15 W=1 nf=1 ad=0.29 as=0.29 pd=2.58 ps=2.58 mult=1 m=1
XMN2_op1_0900_s0p5_w1 ref_op1_0900_s0p5_w1 rbl_op1_0900_s0p5_w1 vn_op1_0900_s0p5_w1 0 sky130_fd_pr__nfet_01v8 L=0.15 W=1 nf=1 ad=0.29 as=0.29 pd=2.58 ps=2.58 mult=1 m=1
XMP1_op1_0900_s0p5_w1 rbl_op1_0900_s0p5_w1 ref_op1_0900_s0p5_w1 vp_op1_0900_s0p5_w1 vdd sky130_fd_pr__pfet_01v8 L=0.15 W=2 nf=1 ad=0.58 as=0.58 pd=4.58 ps=4.58 mult=1 m=1
XMP2_op1_0900_s0p5_w1 ref_op1_0900_s0p5_w1 rbl_op1_0900_s0p5_w1 vp_op1_0900_s0p5_w1 vdd sky130_fd_pr__pfet_01v8 L=0.15 W=2 nf=1 ad=0.58 as=0.58 pd=4.58 ps=4.58 mult=1 m=1
XMNF_op1_0900_s0p5_w1 vn_op1_0900_s0p5_w1 en_op1_0900_s0p5_w1 0 0 sky130_fd_pr__nfet_01v8 L=0.15 W=2 nf=1 ad=0.58 as=0.58 pd=4.58 ps=4.58 mult=1 m=1
XMPH_op1_0900_s0p5_w1 vp_op1_0900_s0p5_w1 enb_op1_0900_s0p5_w1 vdd vdd sky130_fd_pr__pfet_01v8 L=0.15 W=4 nf=1 ad=1.16 as=1.16 pd=8.58 ps=8.58 mult=1 m=1
bd_op1_0900_s0p5_w1 d_op1_0900_s0p5_w1 0 v=v(rbl_op1_0900_s0p5_w1)-v(ref_op1_0900_s0p5_w1)

* ---- instance 3: op1_0900_s0p5_w2 (t_en 4.5 ns, WWL 5.5..7.5 ns, release 9.5 ns) ----
ven_op1_0900_s0p5_w2  en_op1_0900_s0p5_w2  0 pwl(0 0 4.5000e-09 0 4.6000e-09 {VDD} 9.5000e-09 {VDD} 9.6000e-09 0)
venb_op1_0900_s0p5_w2 enb_op1_0900_s0p5_w2 0 pwl(0 {VDD} 4.5000e-09 {VDD} 4.6000e-09 0 9.5000e-09 0 9.6000e-09 {VDD})
vrs_op1_0900_s0p5_w2  rwls_op1_0900_s0p5_w2 0 pwl(0 {VDD} {T_READ} {VDD} {T_READ+TEDGE} 0 9.5000e-09 0 9.6000e-09 {VDD})
vww_op1_0900_s0p5_w2  wwl_op1_0900_s0p5_w2 0 pwl(0 0 5.5000e-09 0 5.6000e-09 {VDD} 7.5000e-09 {VDD} 7.6000e-09 0)
vwc_op1_0900_s0p5_w2  wbc_op1_0900_s0p5_w2 0 pwl(0 0 5.5000e-09 0 5.6000e-09 {VDD} 9.5000e-09 {VDD} 9.6000e-09 0)
swb_op1_0900_s0p5_w2 ref_op1_0900_s0p5_w2 wbl_op1_0900_s0p5_w2 wbc_op1_0900_s0p5_w2 0 swwbl
cwbl_op1_0900_s0p5_w2 wbl_op1_0900_s0p5_w2 0 {C_WBL}
spa_op1_0900_s0p5_w2 prea rbl_op1_0900_s0p5_w2 ctl 0 swpre
spr_op1_0900_s0p5_w2 pref ref_op1_0900_s0p5_w2 ctl 0 swpre
crbl_op1_0900_s0p5_w2 rbl_op1_0900_s0p5_w2 0 {C_RBL}
cref_op1_0900_s0p5_w2 ref_op1_0900_s0p5_w2 0 {C_RBL}   $ ASSUMPTION: ideal matched dummy load
XMWR_op1_0900_s0p5_w2_0 sn_op1_0900_s0p5_w2_0 wwl_op1_0900_s0p5_w2 wbl_op1_0900_s0p5_w2 0 sky130_fd_pr__nfet_01v8 L=0.15 W=0.42 nf=1 ad=0.1218 as=0.1218 pd=1.42 ps=1.42 nrd=0.69047619047619  nrs=0.69047619047619 sa=0 sb=0 sd=0 mult=1 m=1
XMRD_op1_0900_s0p5_w2_0 rbl_op1_0900_s0p5_w2 sn_op1_0900_s0p5_w2_0 rwls_op1_0900_s0p5_w2 0 sky130_fd_pr__nfet_01v8 L=0.15 W=0.42 nf=1 ad=0.1218 as=0.1218 pd=1.42 ps=1.42 nrd=0.69047619047619  nrs=0.69047619047619 sa=0 sb=0 sd=0 mult=1 m=1
csn_op1_0900_s0p5_w2_0 sn_op1_0900_s0p5_w2_0 0 {C_SN}
XMWR_op1_0900_s0p5_w2_1 sn_op1_0900_s0p5_w2_1 wwl_des wbl_op1_0900_s0p5_w2 0 sky130_fd_pr__nfet_01v8 L=0.15 W=0.42 nf=1 ad=0.1218 as=0.1218 pd=1.42 ps=1.42 nrd=0.69047619047619  nrs=0.69047619047619 sa=0 sb=0 sd=0 mult=1 m=1
XMRD_op1_0900_s0p5_w2_1 rbl_op1_0900_s0p5_w2 sn_op1_0900_s0p5_w2_1 rwl_des 0 sky130_fd_pr__nfet_01v8 L=0.15 W=0.42 nf=1 ad=0.1218 as=0.1218 pd=1.42 ps=1.42 nrd=0.69047619047619  nrs=0.69047619047619 sa=0 sb=0 sd=0 mult=1 m=1
csn_op1_0900_s0p5_w2_1 sn_op1_0900_s0p5_w2_1 0 {C_SN}
XMWR_op1_0900_s0p5_w2_2 sn_op1_0900_s0p5_w2_2 wwl_des wbl_op1_0900_s0p5_w2 0 sky130_fd_pr__nfet_01v8 L=0.15 W=0.42 nf=1 ad=0.1218 as=0.1218 pd=1.42 ps=1.42 nrd=0.69047619047619  nrs=0.69047619047619 sa=0 sb=0 sd=0 mult=1 m=1
XMRD_op1_0900_s0p5_w2_2 rbl_op1_0900_s0p5_w2 sn_op1_0900_s0p5_w2_2 rwl_des 0 sky130_fd_pr__nfet_01v8 L=0.15 W=0.42 nf=1 ad=0.1218 as=0.1218 pd=1.42 ps=1.42 nrd=0.69047619047619  nrs=0.69047619047619 sa=0 sb=0 sd=0 mult=1 m=1
csn_op1_0900_s0p5_w2_2 sn_op1_0900_s0p5_w2_2 0 {C_SN}
XMWR_op1_0900_s0p5_w2_3 sn_op1_0900_s0p5_w2_3 wwl_des wbl_op1_0900_s0p5_w2 0 sky130_fd_pr__nfet_01v8 L=0.15 W=0.42 nf=1 ad=0.1218 as=0.1218 pd=1.42 ps=1.42 nrd=0.69047619047619  nrs=0.69047619047619 sa=0 sb=0 sd=0 mult=1 m=1
XMRD_op1_0900_s0p5_w2_3 rbl_op1_0900_s0p5_w2 sn_op1_0900_s0p5_w2_3 rwl_des 0 sky130_fd_pr__nfet_01v8 L=0.15 W=0.42 nf=1 ad=0.1218 as=0.1218 pd=1.42 ps=1.42 nrd=0.69047619047619  nrs=0.69047619047619 sa=0 sb=0 sd=0 mult=1 m=1
csn_op1_0900_s0p5_w2_3 sn_op1_0900_s0p5_w2_3 0 {C_SN}
XMN1_op1_0900_s0p5_w2 rbl_op1_0900_s0p5_w2 ref_op1_0900_s0p5_w2 vn_op1_0900_s0p5_w2 0 sky130_fd_pr__nfet_01v8 L=0.15 W=1 nf=1 ad=0.29 as=0.29 pd=2.58 ps=2.58 mult=1 m=1
XMN2_op1_0900_s0p5_w2 ref_op1_0900_s0p5_w2 rbl_op1_0900_s0p5_w2 vn_op1_0900_s0p5_w2 0 sky130_fd_pr__nfet_01v8 L=0.15 W=1 nf=1 ad=0.29 as=0.29 pd=2.58 ps=2.58 mult=1 m=1
XMP1_op1_0900_s0p5_w2 rbl_op1_0900_s0p5_w2 ref_op1_0900_s0p5_w2 vp_op1_0900_s0p5_w2 vdd sky130_fd_pr__pfet_01v8 L=0.15 W=2 nf=1 ad=0.58 as=0.58 pd=4.58 ps=4.58 mult=1 m=1
XMP2_op1_0900_s0p5_w2 ref_op1_0900_s0p5_w2 rbl_op1_0900_s0p5_w2 vp_op1_0900_s0p5_w2 vdd sky130_fd_pr__pfet_01v8 L=0.15 W=2 nf=1 ad=0.58 as=0.58 pd=4.58 ps=4.58 mult=1 m=1
XMNF_op1_0900_s0p5_w2 vn_op1_0900_s0p5_w2 en_op1_0900_s0p5_w2 0 0 sky130_fd_pr__nfet_01v8 L=0.15 W=2 nf=1 ad=0.58 as=0.58 pd=4.58 ps=4.58 mult=1 m=1
XMPH_op1_0900_s0p5_w2 vp_op1_0900_s0p5_w2 enb_op1_0900_s0p5_w2 vdd vdd sky130_fd_pr__pfet_01v8 L=0.15 W=4 nf=1 ad=1.16 as=1.16 pd=8.58 ps=8.58 mult=1 m=1
bd_op1_0900_s0p5_w2 d_op1_0900_s0p5_w2 0 v=v(rbl_op1_0900_s0p5_w2)-v(ref_op1_0900_s0p5_w2)

* ---- instance 4: op1_0900_s0p5_w3 (t_en 4.5 ns, WWL 5.5..8.5 ns, release 10.5 ns) ----
ven_op1_0900_s0p5_w3  en_op1_0900_s0p5_w3  0 pwl(0 0 4.5000e-09 0 4.6000e-09 {VDD} 1.0500e-08 {VDD} 1.0600e-08 0)
venb_op1_0900_s0p5_w3 enb_op1_0900_s0p5_w3 0 pwl(0 {VDD} 4.5000e-09 {VDD} 4.6000e-09 0 1.0500e-08 0 1.0600e-08 {VDD})
vrs_op1_0900_s0p5_w3  rwls_op1_0900_s0p5_w3 0 pwl(0 {VDD} {T_READ} {VDD} {T_READ+TEDGE} 0 1.0500e-08 0 1.0600e-08 {VDD})
vww_op1_0900_s0p5_w3  wwl_op1_0900_s0p5_w3 0 pwl(0 0 5.5000e-09 0 5.6000e-09 {VDD} 8.5000e-09 {VDD} 8.6000e-09 0)
vwc_op1_0900_s0p5_w3  wbc_op1_0900_s0p5_w3 0 pwl(0 0 5.5000e-09 0 5.6000e-09 {VDD} 1.0500e-08 {VDD} 1.0600e-08 0)
swb_op1_0900_s0p5_w3 ref_op1_0900_s0p5_w3 wbl_op1_0900_s0p5_w3 wbc_op1_0900_s0p5_w3 0 swwbl
cwbl_op1_0900_s0p5_w3 wbl_op1_0900_s0p5_w3 0 {C_WBL}
spa_op1_0900_s0p5_w3 prea rbl_op1_0900_s0p5_w3 ctl 0 swpre
spr_op1_0900_s0p5_w3 pref ref_op1_0900_s0p5_w3 ctl 0 swpre
crbl_op1_0900_s0p5_w3 rbl_op1_0900_s0p5_w3 0 {C_RBL}
cref_op1_0900_s0p5_w3 ref_op1_0900_s0p5_w3 0 {C_RBL}   $ ASSUMPTION: ideal matched dummy load
XMWR_op1_0900_s0p5_w3_0 sn_op1_0900_s0p5_w3_0 wwl_op1_0900_s0p5_w3 wbl_op1_0900_s0p5_w3 0 sky130_fd_pr__nfet_01v8 L=0.15 W=0.42 nf=1 ad=0.1218 as=0.1218 pd=1.42 ps=1.42 nrd=0.69047619047619  nrs=0.69047619047619 sa=0 sb=0 sd=0 mult=1 m=1
XMRD_op1_0900_s0p5_w3_0 rbl_op1_0900_s0p5_w3 sn_op1_0900_s0p5_w3_0 rwls_op1_0900_s0p5_w3 0 sky130_fd_pr__nfet_01v8 L=0.15 W=0.42 nf=1 ad=0.1218 as=0.1218 pd=1.42 ps=1.42 nrd=0.69047619047619  nrs=0.69047619047619 sa=0 sb=0 sd=0 mult=1 m=1
csn_op1_0900_s0p5_w3_0 sn_op1_0900_s0p5_w3_0 0 {C_SN}
XMWR_op1_0900_s0p5_w3_1 sn_op1_0900_s0p5_w3_1 wwl_des wbl_op1_0900_s0p5_w3 0 sky130_fd_pr__nfet_01v8 L=0.15 W=0.42 nf=1 ad=0.1218 as=0.1218 pd=1.42 ps=1.42 nrd=0.69047619047619  nrs=0.69047619047619 sa=0 sb=0 sd=0 mult=1 m=1
XMRD_op1_0900_s0p5_w3_1 rbl_op1_0900_s0p5_w3 sn_op1_0900_s0p5_w3_1 rwl_des 0 sky130_fd_pr__nfet_01v8 L=0.15 W=0.42 nf=1 ad=0.1218 as=0.1218 pd=1.42 ps=1.42 nrd=0.69047619047619  nrs=0.69047619047619 sa=0 sb=0 sd=0 mult=1 m=1
csn_op1_0900_s0p5_w3_1 sn_op1_0900_s0p5_w3_1 0 {C_SN}
XMWR_op1_0900_s0p5_w3_2 sn_op1_0900_s0p5_w3_2 wwl_des wbl_op1_0900_s0p5_w3 0 sky130_fd_pr__nfet_01v8 L=0.15 W=0.42 nf=1 ad=0.1218 as=0.1218 pd=1.42 ps=1.42 nrd=0.69047619047619  nrs=0.69047619047619 sa=0 sb=0 sd=0 mult=1 m=1
XMRD_op1_0900_s0p5_w3_2 rbl_op1_0900_s0p5_w3 sn_op1_0900_s0p5_w3_2 rwl_des 0 sky130_fd_pr__nfet_01v8 L=0.15 W=0.42 nf=1 ad=0.1218 as=0.1218 pd=1.42 ps=1.42 nrd=0.69047619047619  nrs=0.69047619047619 sa=0 sb=0 sd=0 mult=1 m=1
csn_op1_0900_s0p5_w3_2 sn_op1_0900_s0p5_w3_2 0 {C_SN}
XMWR_op1_0900_s0p5_w3_3 sn_op1_0900_s0p5_w3_3 wwl_des wbl_op1_0900_s0p5_w3 0 sky130_fd_pr__nfet_01v8 L=0.15 W=0.42 nf=1 ad=0.1218 as=0.1218 pd=1.42 ps=1.42 nrd=0.69047619047619  nrs=0.69047619047619 sa=0 sb=0 sd=0 mult=1 m=1
XMRD_op1_0900_s0p5_w3_3 rbl_op1_0900_s0p5_w3 sn_op1_0900_s0p5_w3_3 rwl_des 0 sky130_fd_pr__nfet_01v8 L=0.15 W=0.42 nf=1 ad=0.1218 as=0.1218 pd=1.42 ps=1.42 nrd=0.69047619047619  nrs=0.69047619047619 sa=0 sb=0 sd=0 mult=1 m=1
csn_op1_0900_s0p5_w3_3 sn_op1_0900_s0p5_w3_3 0 {C_SN}
XMN1_op1_0900_s0p5_w3 rbl_op1_0900_s0p5_w3 ref_op1_0900_s0p5_w3 vn_op1_0900_s0p5_w3 0 sky130_fd_pr__nfet_01v8 L=0.15 W=1 nf=1 ad=0.29 as=0.29 pd=2.58 ps=2.58 mult=1 m=1
XMN2_op1_0900_s0p5_w3 ref_op1_0900_s0p5_w3 rbl_op1_0900_s0p5_w3 vn_op1_0900_s0p5_w3 0 sky130_fd_pr__nfet_01v8 L=0.15 W=1 nf=1 ad=0.29 as=0.29 pd=2.58 ps=2.58 mult=1 m=1
XMP1_op1_0900_s0p5_w3 rbl_op1_0900_s0p5_w3 ref_op1_0900_s0p5_w3 vp_op1_0900_s0p5_w3 vdd sky130_fd_pr__pfet_01v8 L=0.15 W=2 nf=1 ad=0.58 as=0.58 pd=4.58 ps=4.58 mult=1 m=1
XMP2_op1_0900_s0p5_w3 ref_op1_0900_s0p5_w3 rbl_op1_0900_s0p5_w3 vp_op1_0900_s0p5_w3 vdd sky130_fd_pr__pfet_01v8 L=0.15 W=2 nf=1 ad=0.58 as=0.58 pd=4.58 ps=4.58 mult=1 m=1
XMNF_op1_0900_s0p5_w3 vn_op1_0900_s0p5_w3 en_op1_0900_s0p5_w3 0 0 sky130_fd_pr__nfet_01v8 L=0.15 W=2 nf=1 ad=0.58 as=0.58 pd=4.58 ps=4.58 mult=1 m=1
XMPH_op1_0900_s0p5_w3 vp_op1_0900_s0p5_w3 enb_op1_0900_s0p5_w3 vdd vdd sky130_fd_pr__pfet_01v8 L=0.15 W=4 nf=1 ad=1.16 as=1.16 pd=8.58 ps=8.58 mult=1 m=1
bd_op1_0900_s0p5_w3 d_op1_0900_s0p5_w3 0 v=v(rbl_op1_0900_s0p5_w3)-v(ref_op1_0900_s0p5_w3)

* ---- instance 5: op1_0900_s0p5_w5 (t_en 4.5 ns, WWL 5.5..10.5 ns, release 12.5 ns) ----
ven_op1_0900_s0p5_w5  en_op1_0900_s0p5_w5  0 pwl(0 0 4.5000e-09 0 4.6000e-09 {VDD} 1.2500e-08 {VDD} 1.2600e-08 0)
venb_op1_0900_s0p5_w5 enb_op1_0900_s0p5_w5 0 pwl(0 {VDD} 4.5000e-09 {VDD} 4.6000e-09 0 1.2500e-08 0 1.2600e-08 {VDD})
vrs_op1_0900_s0p5_w5  rwls_op1_0900_s0p5_w5 0 pwl(0 {VDD} {T_READ} {VDD} {T_READ+TEDGE} 0 1.2500e-08 0 1.2600e-08 {VDD})
vww_op1_0900_s0p5_w5  wwl_op1_0900_s0p5_w5 0 pwl(0 0 5.5000e-09 0 5.6000e-09 {VDD} 1.0500e-08 {VDD} 1.0600e-08 0)
vwc_op1_0900_s0p5_w5  wbc_op1_0900_s0p5_w5 0 pwl(0 0 5.5000e-09 0 5.6000e-09 {VDD} 1.2500e-08 {VDD} 1.2600e-08 0)
swb_op1_0900_s0p5_w5 ref_op1_0900_s0p5_w5 wbl_op1_0900_s0p5_w5 wbc_op1_0900_s0p5_w5 0 swwbl
cwbl_op1_0900_s0p5_w5 wbl_op1_0900_s0p5_w5 0 {C_WBL}
spa_op1_0900_s0p5_w5 prea rbl_op1_0900_s0p5_w5 ctl 0 swpre
spr_op1_0900_s0p5_w5 pref ref_op1_0900_s0p5_w5 ctl 0 swpre
crbl_op1_0900_s0p5_w5 rbl_op1_0900_s0p5_w5 0 {C_RBL}
cref_op1_0900_s0p5_w5 ref_op1_0900_s0p5_w5 0 {C_RBL}   $ ASSUMPTION: ideal matched dummy load
XMWR_op1_0900_s0p5_w5_0 sn_op1_0900_s0p5_w5_0 wwl_op1_0900_s0p5_w5 wbl_op1_0900_s0p5_w5 0 sky130_fd_pr__nfet_01v8 L=0.15 W=0.42 nf=1 ad=0.1218 as=0.1218 pd=1.42 ps=1.42 nrd=0.69047619047619  nrs=0.69047619047619 sa=0 sb=0 sd=0 mult=1 m=1
XMRD_op1_0900_s0p5_w5_0 rbl_op1_0900_s0p5_w5 sn_op1_0900_s0p5_w5_0 rwls_op1_0900_s0p5_w5 0 sky130_fd_pr__nfet_01v8 L=0.15 W=0.42 nf=1 ad=0.1218 as=0.1218 pd=1.42 ps=1.42 nrd=0.69047619047619  nrs=0.69047619047619 sa=0 sb=0 sd=0 mult=1 m=1
csn_op1_0900_s0p5_w5_0 sn_op1_0900_s0p5_w5_0 0 {C_SN}
XMWR_op1_0900_s0p5_w5_1 sn_op1_0900_s0p5_w5_1 wwl_des wbl_op1_0900_s0p5_w5 0 sky130_fd_pr__nfet_01v8 L=0.15 W=0.42 nf=1 ad=0.1218 as=0.1218 pd=1.42 ps=1.42 nrd=0.69047619047619  nrs=0.69047619047619 sa=0 sb=0 sd=0 mult=1 m=1
XMRD_op1_0900_s0p5_w5_1 rbl_op1_0900_s0p5_w5 sn_op1_0900_s0p5_w5_1 rwl_des 0 sky130_fd_pr__nfet_01v8 L=0.15 W=0.42 nf=1 ad=0.1218 as=0.1218 pd=1.42 ps=1.42 nrd=0.69047619047619  nrs=0.69047619047619 sa=0 sb=0 sd=0 mult=1 m=1
csn_op1_0900_s0p5_w5_1 sn_op1_0900_s0p5_w5_1 0 {C_SN}
XMWR_op1_0900_s0p5_w5_2 sn_op1_0900_s0p5_w5_2 wwl_des wbl_op1_0900_s0p5_w5 0 sky130_fd_pr__nfet_01v8 L=0.15 W=0.42 nf=1 ad=0.1218 as=0.1218 pd=1.42 ps=1.42 nrd=0.69047619047619  nrs=0.69047619047619 sa=0 sb=0 sd=0 mult=1 m=1
XMRD_op1_0900_s0p5_w5_2 rbl_op1_0900_s0p5_w5 sn_op1_0900_s0p5_w5_2 rwl_des 0 sky130_fd_pr__nfet_01v8 L=0.15 W=0.42 nf=1 ad=0.1218 as=0.1218 pd=1.42 ps=1.42 nrd=0.69047619047619  nrs=0.69047619047619 sa=0 sb=0 sd=0 mult=1 m=1
csn_op1_0900_s0p5_w5_2 sn_op1_0900_s0p5_w5_2 0 {C_SN}
XMWR_op1_0900_s0p5_w5_3 sn_op1_0900_s0p5_w5_3 wwl_des wbl_op1_0900_s0p5_w5 0 sky130_fd_pr__nfet_01v8 L=0.15 W=0.42 nf=1 ad=0.1218 as=0.1218 pd=1.42 ps=1.42 nrd=0.69047619047619  nrs=0.69047619047619 sa=0 sb=0 sd=0 mult=1 m=1
XMRD_op1_0900_s0p5_w5_3 rbl_op1_0900_s0p5_w5 sn_op1_0900_s0p5_w5_3 rwl_des 0 sky130_fd_pr__nfet_01v8 L=0.15 W=0.42 nf=1 ad=0.1218 as=0.1218 pd=1.42 ps=1.42 nrd=0.69047619047619  nrs=0.69047619047619 sa=0 sb=0 sd=0 mult=1 m=1
csn_op1_0900_s0p5_w5_3 sn_op1_0900_s0p5_w5_3 0 {C_SN}
XMN1_op1_0900_s0p5_w5 rbl_op1_0900_s0p5_w5 ref_op1_0900_s0p5_w5 vn_op1_0900_s0p5_w5 0 sky130_fd_pr__nfet_01v8 L=0.15 W=1 nf=1 ad=0.29 as=0.29 pd=2.58 ps=2.58 mult=1 m=1
XMN2_op1_0900_s0p5_w5 ref_op1_0900_s0p5_w5 rbl_op1_0900_s0p5_w5 vn_op1_0900_s0p5_w5 0 sky130_fd_pr__nfet_01v8 L=0.15 W=1 nf=1 ad=0.29 as=0.29 pd=2.58 ps=2.58 mult=1 m=1
XMP1_op1_0900_s0p5_w5 rbl_op1_0900_s0p5_w5 ref_op1_0900_s0p5_w5 vp_op1_0900_s0p5_w5 vdd sky130_fd_pr__pfet_01v8 L=0.15 W=2 nf=1 ad=0.58 as=0.58 pd=4.58 ps=4.58 mult=1 m=1
XMP2_op1_0900_s0p5_w5 ref_op1_0900_s0p5_w5 rbl_op1_0900_s0p5_w5 vp_op1_0900_s0p5_w5 vdd sky130_fd_pr__pfet_01v8 L=0.15 W=2 nf=1 ad=0.58 as=0.58 pd=4.58 ps=4.58 mult=1 m=1
XMNF_op1_0900_s0p5_w5 vn_op1_0900_s0p5_w5 en_op1_0900_s0p5_w5 0 0 sky130_fd_pr__nfet_01v8 L=0.15 W=2 nf=1 ad=0.58 as=0.58 pd=4.58 ps=4.58 mult=1 m=1
XMPH_op1_0900_s0p5_w5 vp_op1_0900_s0p5_w5 enb_op1_0900_s0p5_w5 vdd vdd sky130_fd_pr__pfet_01v8 L=0.15 W=4 nf=1 ad=1.16 as=1.16 pd=8.58 ps=8.58 mult=1 m=1
bd_op1_0900_s0p5_w5 d_op1_0900_s0p5_w5 0 v=v(rbl_op1_0900_s0p5_w5)-v(ref_op1_0900_s0p5_w5)

* ---- instance 6: op1_0900_s0p5_w7p5 (t_en 4.5 ns, WWL 5.5..13 ns, release 15 ns) ----
ven_op1_0900_s0p5_w7p5  en_op1_0900_s0p5_w7p5  0 pwl(0 0 4.5000e-09 0 4.6000e-09 {VDD} 1.5000e-08 {VDD} 1.5100e-08 0)
venb_op1_0900_s0p5_w7p5 enb_op1_0900_s0p5_w7p5 0 pwl(0 {VDD} 4.5000e-09 {VDD} 4.6000e-09 0 1.5000e-08 0 1.5100e-08 {VDD})
vrs_op1_0900_s0p5_w7p5  rwls_op1_0900_s0p5_w7p5 0 pwl(0 {VDD} {T_READ} {VDD} {T_READ+TEDGE} 0 1.5000e-08 0 1.5100e-08 {VDD})
vww_op1_0900_s0p5_w7p5  wwl_op1_0900_s0p5_w7p5 0 pwl(0 0 5.5000e-09 0 5.6000e-09 {VDD} 1.3000e-08 {VDD} 1.3100e-08 0)
vwc_op1_0900_s0p5_w7p5  wbc_op1_0900_s0p5_w7p5 0 pwl(0 0 5.5000e-09 0 5.6000e-09 {VDD} 1.5000e-08 {VDD} 1.5100e-08 0)
swb_op1_0900_s0p5_w7p5 ref_op1_0900_s0p5_w7p5 wbl_op1_0900_s0p5_w7p5 wbc_op1_0900_s0p5_w7p5 0 swwbl
cwbl_op1_0900_s0p5_w7p5 wbl_op1_0900_s0p5_w7p5 0 {C_WBL}
spa_op1_0900_s0p5_w7p5 prea rbl_op1_0900_s0p5_w7p5 ctl 0 swpre
spr_op1_0900_s0p5_w7p5 pref ref_op1_0900_s0p5_w7p5 ctl 0 swpre
crbl_op1_0900_s0p5_w7p5 rbl_op1_0900_s0p5_w7p5 0 {C_RBL}
cref_op1_0900_s0p5_w7p5 ref_op1_0900_s0p5_w7p5 0 {C_RBL}   $ ASSUMPTION: ideal matched dummy load
XMWR_op1_0900_s0p5_w7p5_0 sn_op1_0900_s0p5_w7p5_0 wwl_op1_0900_s0p5_w7p5 wbl_op1_0900_s0p5_w7p5 0 sky130_fd_pr__nfet_01v8 L=0.15 W=0.42 nf=1 ad=0.1218 as=0.1218 pd=1.42 ps=1.42 nrd=0.69047619047619  nrs=0.69047619047619 sa=0 sb=0 sd=0 mult=1 m=1
XMRD_op1_0900_s0p5_w7p5_0 rbl_op1_0900_s0p5_w7p5 sn_op1_0900_s0p5_w7p5_0 rwls_op1_0900_s0p5_w7p5 0 sky130_fd_pr__nfet_01v8 L=0.15 W=0.42 nf=1 ad=0.1218 as=0.1218 pd=1.42 ps=1.42 nrd=0.69047619047619  nrs=0.69047619047619 sa=0 sb=0 sd=0 mult=1 m=1
csn_op1_0900_s0p5_w7p5_0 sn_op1_0900_s0p5_w7p5_0 0 {C_SN}
XMWR_op1_0900_s0p5_w7p5_1 sn_op1_0900_s0p5_w7p5_1 wwl_des wbl_op1_0900_s0p5_w7p5 0 sky130_fd_pr__nfet_01v8 L=0.15 W=0.42 nf=1 ad=0.1218 as=0.1218 pd=1.42 ps=1.42 nrd=0.69047619047619  nrs=0.69047619047619 sa=0 sb=0 sd=0 mult=1 m=1
XMRD_op1_0900_s0p5_w7p5_1 rbl_op1_0900_s0p5_w7p5 sn_op1_0900_s0p5_w7p5_1 rwl_des 0 sky130_fd_pr__nfet_01v8 L=0.15 W=0.42 nf=1 ad=0.1218 as=0.1218 pd=1.42 ps=1.42 nrd=0.69047619047619  nrs=0.69047619047619 sa=0 sb=0 sd=0 mult=1 m=1
csn_op1_0900_s0p5_w7p5_1 sn_op1_0900_s0p5_w7p5_1 0 {C_SN}
XMWR_op1_0900_s0p5_w7p5_2 sn_op1_0900_s0p5_w7p5_2 wwl_des wbl_op1_0900_s0p5_w7p5 0 sky130_fd_pr__nfet_01v8 L=0.15 W=0.42 nf=1 ad=0.1218 as=0.1218 pd=1.42 ps=1.42 nrd=0.69047619047619  nrs=0.69047619047619 sa=0 sb=0 sd=0 mult=1 m=1
XMRD_op1_0900_s0p5_w7p5_2 rbl_op1_0900_s0p5_w7p5 sn_op1_0900_s0p5_w7p5_2 rwl_des 0 sky130_fd_pr__nfet_01v8 L=0.15 W=0.42 nf=1 ad=0.1218 as=0.1218 pd=1.42 ps=1.42 nrd=0.69047619047619  nrs=0.69047619047619 sa=0 sb=0 sd=0 mult=1 m=1
csn_op1_0900_s0p5_w7p5_2 sn_op1_0900_s0p5_w7p5_2 0 {C_SN}
XMWR_op1_0900_s0p5_w7p5_3 sn_op1_0900_s0p5_w7p5_3 wwl_des wbl_op1_0900_s0p5_w7p5 0 sky130_fd_pr__nfet_01v8 L=0.15 W=0.42 nf=1 ad=0.1218 as=0.1218 pd=1.42 ps=1.42 nrd=0.69047619047619  nrs=0.69047619047619 sa=0 sb=0 sd=0 mult=1 m=1
XMRD_op1_0900_s0p5_w7p5_3 rbl_op1_0900_s0p5_w7p5 sn_op1_0900_s0p5_w7p5_3 rwl_des 0 sky130_fd_pr__nfet_01v8 L=0.15 W=0.42 nf=1 ad=0.1218 as=0.1218 pd=1.42 ps=1.42 nrd=0.69047619047619  nrs=0.69047619047619 sa=0 sb=0 sd=0 mult=1 m=1
csn_op1_0900_s0p5_w7p5_3 sn_op1_0900_s0p5_w7p5_3 0 {C_SN}
XMN1_op1_0900_s0p5_w7p5 rbl_op1_0900_s0p5_w7p5 ref_op1_0900_s0p5_w7p5 vn_op1_0900_s0p5_w7p5 0 sky130_fd_pr__nfet_01v8 L=0.15 W=1 nf=1 ad=0.29 as=0.29 pd=2.58 ps=2.58 mult=1 m=1
XMN2_op1_0900_s0p5_w7p5 ref_op1_0900_s0p5_w7p5 rbl_op1_0900_s0p5_w7p5 vn_op1_0900_s0p5_w7p5 0 sky130_fd_pr__nfet_01v8 L=0.15 W=1 nf=1 ad=0.29 as=0.29 pd=2.58 ps=2.58 mult=1 m=1
XMP1_op1_0900_s0p5_w7p5 rbl_op1_0900_s0p5_w7p5 ref_op1_0900_s0p5_w7p5 vp_op1_0900_s0p5_w7p5 vdd sky130_fd_pr__pfet_01v8 L=0.15 W=2 nf=1 ad=0.58 as=0.58 pd=4.58 ps=4.58 mult=1 m=1
XMP2_op1_0900_s0p5_w7p5 ref_op1_0900_s0p5_w7p5 rbl_op1_0900_s0p5_w7p5 vp_op1_0900_s0p5_w7p5 vdd sky130_fd_pr__pfet_01v8 L=0.15 W=2 nf=1 ad=0.58 as=0.58 pd=4.58 ps=4.58 mult=1 m=1
XMNF_op1_0900_s0p5_w7p5 vn_op1_0900_s0p5_w7p5 en_op1_0900_s0p5_w7p5 0 0 sky130_fd_pr__nfet_01v8 L=0.15 W=2 nf=1 ad=0.58 as=0.58 pd=4.58 ps=4.58 mult=1 m=1
XMPH_op1_0900_s0p5_w7p5 vp_op1_0900_s0p5_w7p5 enb_op1_0900_s0p5_w7p5 vdd vdd sky130_fd_pr__pfet_01v8 L=0.15 W=4 nf=1 ad=1.16 as=1.16 pd=8.58 ps=8.58 mult=1 m=1
bd_op1_0900_s0p5_w7p5 d_op1_0900_s0p5_w7p5 0 v=v(rbl_op1_0900_s0p5_w7p5)-v(ref_op1_0900_s0p5_w7p5)

* ---- instance 7: op1_0900_s0p5_w10 (t_en 4.5 ns, WWL 5.5..15.5 ns, release 17.5 ns) ----
ven_op1_0900_s0p5_w10  en_op1_0900_s0p5_w10  0 pwl(0 0 4.5000e-09 0 4.6000e-09 {VDD} 1.7500e-08 {VDD} 1.7600e-08 0)
venb_op1_0900_s0p5_w10 enb_op1_0900_s0p5_w10 0 pwl(0 {VDD} 4.5000e-09 {VDD} 4.6000e-09 0 1.7500e-08 0 1.7600e-08 {VDD})
vrs_op1_0900_s0p5_w10  rwls_op1_0900_s0p5_w10 0 pwl(0 {VDD} {T_READ} {VDD} {T_READ+TEDGE} 0 1.7500e-08 0 1.7600e-08 {VDD})
vww_op1_0900_s0p5_w10  wwl_op1_0900_s0p5_w10 0 pwl(0 0 5.5000e-09 0 5.6000e-09 {VDD} 1.5500e-08 {VDD} 1.5600e-08 0)
vwc_op1_0900_s0p5_w10  wbc_op1_0900_s0p5_w10 0 pwl(0 0 5.5000e-09 0 5.6000e-09 {VDD} 1.7500e-08 {VDD} 1.7600e-08 0)
swb_op1_0900_s0p5_w10 ref_op1_0900_s0p5_w10 wbl_op1_0900_s0p5_w10 wbc_op1_0900_s0p5_w10 0 swwbl
cwbl_op1_0900_s0p5_w10 wbl_op1_0900_s0p5_w10 0 {C_WBL}
spa_op1_0900_s0p5_w10 prea rbl_op1_0900_s0p5_w10 ctl 0 swpre
spr_op1_0900_s0p5_w10 pref ref_op1_0900_s0p5_w10 ctl 0 swpre
crbl_op1_0900_s0p5_w10 rbl_op1_0900_s0p5_w10 0 {C_RBL}
cref_op1_0900_s0p5_w10 ref_op1_0900_s0p5_w10 0 {C_RBL}   $ ASSUMPTION: ideal matched dummy load
XMWR_op1_0900_s0p5_w10_0 sn_op1_0900_s0p5_w10_0 wwl_op1_0900_s0p5_w10 wbl_op1_0900_s0p5_w10 0 sky130_fd_pr__nfet_01v8 L=0.15 W=0.42 nf=1 ad=0.1218 as=0.1218 pd=1.42 ps=1.42 nrd=0.69047619047619  nrs=0.69047619047619 sa=0 sb=0 sd=0 mult=1 m=1
XMRD_op1_0900_s0p5_w10_0 rbl_op1_0900_s0p5_w10 sn_op1_0900_s0p5_w10_0 rwls_op1_0900_s0p5_w10 0 sky130_fd_pr__nfet_01v8 L=0.15 W=0.42 nf=1 ad=0.1218 as=0.1218 pd=1.42 ps=1.42 nrd=0.69047619047619  nrs=0.69047619047619 sa=0 sb=0 sd=0 mult=1 m=1
csn_op1_0900_s0p5_w10_0 sn_op1_0900_s0p5_w10_0 0 {C_SN}
XMWR_op1_0900_s0p5_w10_1 sn_op1_0900_s0p5_w10_1 wwl_des wbl_op1_0900_s0p5_w10 0 sky130_fd_pr__nfet_01v8 L=0.15 W=0.42 nf=1 ad=0.1218 as=0.1218 pd=1.42 ps=1.42 nrd=0.69047619047619  nrs=0.69047619047619 sa=0 sb=0 sd=0 mult=1 m=1
XMRD_op1_0900_s0p5_w10_1 rbl_op1_0900_s0p5_w10 sn_op1_0900_s0p5_w10_1 rwl_des 0 sky130_fd_pr__nfet_01v8 L=0.15 W=0.42 nf=1 ad=0.1218 as=0.1218 pd=1.42 ps=1.42 nrd=0.69047619047619  nrs=0.69047619047619 sa=0 sb=0 sd=0 mult=1 m=1
csn_op1_0900_s0p5_w10_1 sn_op1_0900_s0p5_w10_1 0 {C_SN}
XMWR_op1_0900_s0p5_w10_2 sn_op1_0900_s0p5_w10_2 wwl_des wbl_op1_0900_s0p5_w10 0 sky130_fd_pr__nfet_01v8 L=0.15 W=0.42 nf=1 ad=0.1218 as=0.1218 pd=1.42 ps=1.42 nrd=0.69047619047619  nrs=0.69047619047619 sa=0 sb=0 sd=0 mult=1 m=1
XMRD_op1_0900_s0p5_w10_2 rbl_op1_0900_s0p5_w10 sn_op1_0900_s0p5_w10_2 rwl_des 0 sky130_fd_pr__nfet_01v8 L=0.15 W=0.42 nf=1 ad=0.1218 as=0.1218 pd=1.42 ps=1.42 nrd=0.69047619047619  nrs=0.69047619047619 sa=0 sb=0 sd=0 mult=1 m=1
csn_op1_0900_s0p5_w10_2 sn_op1_0900_s0p5_w10_2 0 {C_SN}
XMWR_op1_0900_s0p5_w10_3 sn_op1_0900_s0p5_w10_3 wwl_des wbl_op1_0900_s0p5_w10 0 sky130_fd_pr__nfet_01v8 L=0.15 W=0.42 nf=1 ad=0.1218 as=0.1218 pd=1.42 ps=1.42 nrd=0.69047619047619  nrs=0.69047619047619 sa=0 sb=0 sd=0 mult=1 m=1
XMRD_op1_0900_s0p5_w10_3 rbl_op1_0900_s0p5_w10 sn_op1_0900_s0p5_w10_3 rwl_des 0 sky130_fd_pr__nfet_01v8 L=0.15 W=0.42 nf=1 ad=0.1218 as=0.1218 pd=1.42 ps=1.42 nrd=0.69047619047619  nrs=0.69047619047619 sa=0 sb=0 sd=0 mult=1 m=1
csn_op1_0900_s0p5_w10_3 sn_op1_0900_s0p5_w10_3 0 {C_SN}
XMN1_op1_0900_s0p5_w10 rbl_op1_0900_s0p5_w10 ref_op1_0900_s0p5_w10 vn_op1_0900_s0p5_w10 0 sky130_fd_pr__nfet_01v8 L=0.15 W=1 nf=1 ad=0.29 as=0.29 pd=2.58 ps=2.58 mult=1 m=1
XMN2_op1_0900_s0p5_w10 ref_op1_0900_s0p5_w10 rbl_op1_0900_s0p5_w10 vn_op1_0900_s0p5_w10 0 sky130_fd_pr__nfet_01v8 L=0.15 W=1 nf=1 ad=0.29 as=0.29 pd=2.58 ps=2.58 mult=1 m=1
XMP1_op1_0900_s0p5_w10 rbl_op1_0900_s0p5_w10 ref_op1_0900_s0p5_w10 vp_op1_0900_s0p5_w10 vdd sky130_fd_pr__pfet_01v8 L=0.15 W=2 nf=1 ad=0.58 as=0.58 pd=4.58 ps=4.58 mult=1 m=1
XMP2_op1_0900_s0p5_w10 ref_op1_0900_s0p5_w10 rbl_op1_0900_s0p5_w10 vp_op1_0900_s0p5_w10 vdd sky130_fd_pr__pfet_01v8 L=0.15 W=2 nf=1 ad=0.58 as=0.58 pd=4.58 ps=4.58 mult=1 m=1
XMNF_op1_0900_s0p5_w10 vn_op1_0900_s0p5_w10 en_op1_0900_s0p5_w10 0 0 sky130_fd_pr__nfet_01v8 L=0.15 W=2 nf=1 ad=0.58 as=0.58 pd=4.58 ps=4.58 mult=1 m=1
XMPH_op1_0900_s0p5_w10 vp_op1_0900_s0p5_w10 enb_op1_0900_s0p5_w10 vdd vdd sky130_fd_pr__pfet_01v8 L=0.15 W=4 nf=1 ad=1.16 as=1.16 pd=8.58 ps=8.58 mult=1 m=1
bd_op1_0900_s0p5_w10 d_op1_0900_s0p5_w10 0 v=v(rbl_op1_0900_s0p5_w10)-v(ref_op1_0900_s0p5_w10)

* ---- instance 8: op1_0900_s0p5_w15 (t_en 4.5 ns, WWL 5.5..20.5 ns, release 22.5 ns) ----
ven_op1_0900_s0p5_w15  en_op1_0900_s0p5_w15  0 pwl(0 0 4.5000e-09 0 4.6000e-09 {VDD} 2.2500e-08 {VDD} 2.2600e-08 0)
venb_op1_0900_s0p5_w15 enb_op1_0900_s0p5_w15 0 pwl(0 {VDD} 4.5000e-09 {VDD} 4.6000e-09 0 2.2500e-08 0 2.2600e-08 {VDD})
vrs_op1_0900_s0p5_w15  rwls_op1_0900_s0p5_w15 0 pwl(0 {VDD} {T_READ} {VDD} {T_READ+TEDGE} 0 2.2500e-08 0 2.2600e-08 {VDD})
vww_op1_0900_s0p5_w15  wwl_op1_0900_s0p5_w15 0 pwl(0 0 5.5000e-09 0 5.6000e-09 {VDD} 2.0500e-08 {VDD} 2.0600e-08 0)
vwc_op1_0900_s0p5_w15  wbc_op1_0900_s0p5_w15 0 pwl(0 0 5.5000e-09 0 5.6000e-09 {VDD} 2.2500e-08 {VDD} 2.2600e-08 0)
swb_op1_0900_s0p5_w15 ref_op1_0900_s0p5_w15 wbl_op1_0900_s0p5_w15 wbc_op1_0900_s0p5_w15 0 swwbl
cwbl_op1_0900_s0p5_w15 wbl_op1_0900_s0p5_w15 0 {C_WBL}
spa_op1_0900_s0p5_w15 prea rbl_op1_0900_s0p5_w15 ctl 0 swpre
spr_op1_0900_s0p5_w15 pref ref_op1_0900_s0p5_w15 ctl 0 swpre
crbl_op1_0900_s0p5_w15 rbl_op1_0900_s0p5_w15 0 {C_RBL}
cref_op1_0900_s0p5_w15 ref_op1_0900_s0p5_w15 0 {C_RBL}   $ ASSUMPTION: ideal matched dummy load
XMWR_op1_0900_s0p5_w15_0 sn_op1_0900_s0p5_w15_0 wwl_op1_0900_s0p5_w15 wbl_op1_0900_s0p5_w15 0 sky130_fd_pr__nfet_01v8 L=0.15 W=0.42 nf=1 ad=0.1218 as=0.1218 pd=1.42 ps=1.42 nrd=0.69047619047619  nrs=0.69047619047619 sa=0 sb=0 sd=0 mult=1 m=1
XMRD_op1_0900_s0p5_w15_0 rbl_op1_0900_s0p5_w15 sn_op1_0900_s0p5_w15_0 rwls_op1_0900_s0p5_w15 0 sky130_fd_pr__nfet_01v8 L=0.15 W=0.42 nf=1 ad=0.1218 as=0.1218 pd=1.42 ps=1.42 nrd=0.69047619047619  nrs=0.69047619047619 sa=0 sb=0 sd=0 mult=1 m=1
csn_op1_0900_s0p5_w15_0 sn_op1_0900_s0p5_w15_0 0 {C_SN}
XMWR_op1_0900_s0p5_w15_1 sn_op1_0900_s0p5_w15_1 wwl_des wbl_op1_0900_s0p5_w15 0 sky130_fd_pr__nfet_01v8 L=0.15 W=0.42 nf=1 ad=0.1218 as=0.1218 pd=1.42 ps=1.42 nrd=0.69047619047619  nrs=0.69047619047619 sa=0 sb=0 sd=0 mult=1 m=1
XMRD_op1_0900_s0p5_w15_1 rbl_op1_0900_s0p5_w15 sn_op1_0900_s0p5_w15_1 rwl_des 0 sky130_fd_pr__nfet_01v8 L=0.15 W=0.42 nf=1 ad=0.1218 as=0.1218 pd=1.42 ps=1.42 nrd=0.69047619047619  nrs=0.69047619047619 sa=0 sb=0 sd=0 mult=1 m=1
csn_op1_0900_s0p5_w15_1 sn_op1_0900_s0p5_w15_1 0 {C_SN}
XMWR_op1_0900_s0p5_w15_2 sn_op1_0900_s0p5_w15_2 wwl_des wbl_op1_0900_s0p5_w15 0 sky130_fd_pr__nfet_01v8 L=0.15 W=0.42 nf=1 ad=0.1218 as=0.1218 pd=1.42 ps=1.42 nrd=0.69047619047619  nrs=0.69047619047619 sa=0 sb=0 sd=0 mult=1 m=1
XMRD_op1_0900_s0p5_w15_2 rbl_op1_0900_s0p5_w15 sn_op1_0900_s0p5_w15_2 rwl_des 0 sky130_fd_pr__nfet_01v8 L=0.15 W=0.42 nf=1 ad=0.1218 as=0.1218 pd=1.42 ps=1.42 nrd=0.69047619047619  nrs=0.69047619047619 sa=0 sb=0 sd=0 mult=1 m=1
csn_op1_0900_s0p5_w15_2 sn_op1_0900_s0p5_w15_2 0 {C_SN}
XMWR_op1_0900_s0p5_w15_3 sn_op1_0900_s0p5_w15_3 wwl_des wbl_op1_0900_s0p5_w15 0 sky130_fd_pr__nfet_01v8 L=0.15 W=0.42 nf=1 ad=0.1218 as=0.1218 pd=1.42 ps=1.42 nrd=0.69047619047619  nrs=0.69047619047619 sa=0 sb=0 sd=0 mult=1 m=1
XMRD_op1_0900_s0p5_w15_3 rbl_op1_0900_s0p5_w15 sn_op1_0900_s0p5_w15_3 rwl_des 0 sky130_fd_pr__nfet_01v8 L=0.15 W=0.42 nf=1 ad=0.1218 as=0.1218 pd=1.42 ps=1.42 nrd=0.69047619047619  nrs=0.69047619047619 sa=0 sb=0 sd=0 mult=1 m=1
csn_op1_0900_s0p5_w15_3 sn_op1_0900_s0p5_w15_3 0 {C_SN}
XMN1_op1_0900_s0p5_w15 rbl_op1_0900_s0p5_w15 ref_op1_0900_s0p5_w15 vn_op1_0900_s0p5_w15 0 sky130_fd_pr__nfet_01v8 L=0.15 W=1 nf=1 ad=0.29 as=0.29 pd=2.58 ps=2.58 mult=1 m=1
XMN2_op1_0900_s0p5_w15 ref_op1_0900_s0p5_w15 rbl_op1_0900_s0p5_w15 vn_op1_0900_s0p5_w15 0 sky130_fd_pr__nfet_01v8 L=0.15 W=1 nf=1 ad=0.29 as=0.29 pd=2.58 ps=2.58 mult=1 m=1
XMP1_op1_0900_s0p5_w15 rbl_op1_0900_s0p5_w15 ref_op1_0900_s0p5_w15 vp_op1_0900_s0p5_w15 vdd sky130_fd_pr__pfet_01v8 L=0.15 W=2 nf=1 ad=0.58 as=0.58 pd=4.58 ps=4.58 mult=1 m=1
XMP2_op1_0900_s0p5_w15 ref_op1_0900_s0p5_w15 rbl_op1_0900_s0p5_w15 vp_op1_0900_s0p5_w15 vdd sky130_fd_pr__pfet_01v8 L=0.15 W=2 nf=1 ad=0.58 as=0.58 pd=4.58 ps=4.58 mult=1 m=1
XMNF_op1_0900_s0p5_w15 vn_op1_0900_s0p5_w15 en_op1_0900_s0p5_w15 0 0 sky130_fd_pr__nfet_01v8 L=0.15 W=2 nf=1 ad=0.58 as=0.58 pd=4.58 ps=4.58 mult=1 m=1
XMPH_op1_0900_s0p5_w15 vp_op1_0900_s0p5_w15 enb_op1_0900_s0p5_w15 vdd vdd sky130_fd_pr__pfet_01v8 L=0.15 W=4 nf=1 ad=1.16 as=1.16 pd=8.58 ps=8.58 mult=1 m=1
bd_op1_0900_s0p5_w15 d_op1_0900_s0p5_w15 0 v=v(rbl_op1_0900_s0p5_w15)-v(ref_op1_0900_s0p5_w15)

* ---- instance 9: op1_0900_s0p5_w20 (t_en 4.5 ns, WWL 5.5..25.5 ns, release 27.5 ns) ----
ven_op1_0900_s0p5_w20  en_op1_0900_s0p5_w20  0 pwl(0 0 4.5000e-09 0 4.6000e-09 {VDD} 2.7500e-08 {VDD} 2.7600e-08 0)
venb_op1_0900_s0p5_w20 enb_op1_0900_s0p5_w20 0 pwl(0 {VDD} 4.5000e-09 {VDD} 4.6000e-09 0 2.7500e-08 0 2.7600e-08 {VDD})
vrs_op1_0900_s0p5_w20  rwls_op1_0900_s0p5_w20 0 pwl(0 {VDD} {T_READ} {VDD} {T_READ+TEDGE} 0 2.7500e-08 0 2.7600e-08 {VDD})
vww_op1_0900_s0p5_w20  wwl_op1_0900_s0p5_w20 0 pwl(0 0 5.5000e-09 0 5.6000e-09 {VDD} 2.5500e-08 {VDD} 2.5600e-08 0)
vwc_op1_0900_s0p5_w20  wbc_op1_0900_s0p5_w20 0 pwl(0 0 5.5000e-09 0 5.6000e-09 {VDD} 2.7500e-08 {VDD} 2.7600e-08 0)
swb_op1_0900_s0p5_w20 ref_op1_0900_s0p5_w20 wbl_op1_0900_s0p5_w20 wbc_op1_0900_s0p5_w20 0 swwbl
cwbl_op1_0900_s0p5_w20 wbl_op1_0900_s0p5_w20 0 {C_WBL}
spa_op1_0900_s0p5_w20 prea rbl_op1_0900_s0p5_w20 ctl 0 swpre
spr_op1_0900_s0p5_w20 pref ref_op1_0900_s0p5_w20 ctl 0 swpre
crbl_op1_0900_s0p5_w20 rbl_op1_0900_s0p5_w20 0 {C_RBL}
cref_op1_0900_s0p5_w20 ref_op1_0900_s0p5_w20 0 {C_RBL}   $ ASSUMPTION: ideal matched dummy load
XMWR_op1_0900_s0p5_w20_0 sn_op1_0900_s0p5_w20_0 wwl_op1_0900_s0p5_w20 wbl_op1_0900_s0p5_w20 0 sky130_fd_pr__nfet_01v8 L=0.15 W=0.42 nf=1 ad=0.1218 as=0.1218 pd=1.42 ps=1.42 nrd=0.69047619047619  nrs=0.69047619047619 sa=0 sb=0 sd=0 mult=1 m=1
XMRD_op1_0900_s0p5_w20_0 rbl_op1_0900_s0p5_w20 sn_op1_0900_s0p5_w20_0 rwls_op1_0900_s0p5_w20 0 sky130_fd_pr__nfet_01v8 L=0.15 W=0.42 nf=1 ad=0.1218 as=0.1218 pd=1.42 ps=1.42 nrd=0.69047619047619  nrs=0.69047619047619 sa=0 sb=0 sd=0 mult=1 m=1
csn_op1_0900_s0p5_w20_0 sn_op1_0900_s0p5_w20_0 0 {C_SN}
XMWR_op1_0900_s0p5_w20_1 sn_op1_0900_s0p5_w20_1 wwl_des wbl_op1_0900_s0p5_w20 0 sky130_fd_pr__nfet_01v8 L=0.15 W=0.42 nf=1 ad=0.1218 as=0.1218 pd=1.42 ps=1.42 nrd=0.69047619047619  nrs=0.69047619047619 sa=0 sb=0 sd=0 mult=1 m=1
XMRD_op1_0900_s0p5_w20_1 rbl_op1_0900_s0p5_w20 sn_op1_0900_s0p5_w20_1 rwl_des 0 sky130_fd_pr__nfet_01v8 L=0.15 W=0.42 nf=1 ad=0.1218 as=0.1218 pd=1.42 ps=1.42 nrd=0.69047619047619  nrs=0.69047619047619 sa=0 sb=0 sd=0 mult=1 m=1
csn_op1_0900_s0p5_w20_1 sn_op1_0900_s0p5_w20_1 0 {C_SN}
XMWR_op1_0900_s0p5_w20_2 sn_op1_0900_s0p5_w20_2 wwl_des wbl_op1_0900_s0p5_w20 0 sky130_fd_pr__nfet_01v8 L=0.15 W=0.42 nf=1 ad=0.1218 as=0.1218 pd=1.42 ps=1.42 nrd=0.69047619047619  nrs=0.69047619047619 sa=0 sb=0 sd=0 mult=1 m=1
XMRD_op1_0900_s0p5_w20_2 rbl_op1_0900_s0p5_w20 sn_op1_0900_s0p5_w20_2 rwl_des 0 sky130_fd_pr__nfet_01v8 L=0.15 W=0.42 nf=1 ad=0.1218 as=0.1218 pd=1.42 ps=1.42 nrd=0.69047619047619  nrs=0.69047619047619 sa=0 sb=0 sd=0 mult=1 m=1
csn_op1_0900_s0p5_w20_2 sn_op1_0900_s0p5_w20_2 0 {C_SN}
XMWR_op1_0900_s0p5_w20_3 sn_op1_0900_s0p5_w20_3 wwl_des wbl_op1_0900_s0p5_w20 0 sky130_fd_pr__nfet_01v8 L=0.15 W=0.42 nf=1 ad=0.1218 as=0.1218 pd=1.42 ps=1.42 nrd=0.69047619047619  nrs=0.69047619047619 sa=0 sb=0 sd=0 mult=1 m=1
XMRD_op1_0900_s0p5_w20_3 rbl_op1_0900_s0p5_w20 sn_op1_0900_s0p5_w20_3 rwl_des 0 sky130_fd_pr__nfet_01v8 L=0.15 W=0.42 nf=1 ad=0.1218 as=0.1218 pd=1.42 ps=1.42 nrd=0.69047619047619  nrs=0.69047619047619 sa=0 sb=0 sd=0 mult=1 m=1
csn_op1_0900_s0p5_w20_3 sn_op1_0900_s0p5_w20_3 0 {C_SN}
XMN1_op1_0900_s0p5_w20 rbl_op1_0900_s0p5_w20 ref_op1_0900_s0p5_w20 vn_op1_0900_s0p5_w20 0 sky130_fd_pr__nfet_01v8 L=0.15 W=1 nf=1 ad=0.29 as=0.29 pd=2.58 ps=2.58 mult=1 m=1
XMN2_op1_0900_s0p5_w20 ref_op1_0900_s0p5_w20 rbl_op1_0900_s0p5_w20 vn_op1_0900_s0p5_w20 0 sky130_fd_pr__nfet_01v8 L=0.15 W=1 nf=1 ad=0.29 as=0.29 pd=2.58 ps=2.58 mult=1 m=1
XMP1_op1_0900_s0p5_w20 rbl_op1_0900_s0p5_w20 ref_op1_0900_s0p5_w20 vp_op1_0900_s0p5_w20 vdd sky130_fd_pr__pfet_01v8 L=0.15 W=2 nf=1 ad=0.58 as=0.58 pd=4.58 ps=4.58 mult=1 m=1
XMP2_op1_0900_s0p5_w20 ref_op1_0900_s0p5_w20 rbl_op1_0900_s0p5_w20 vp_op1_0900_s0p5_w20 vdd sky130_fd_pr__pfet_01v8 L=0.15 W=2 nf=1 ad=0.58 as=0.58 pd=4.58 ps=4.58 mult=1 m=1
XMNF_op1_0900_s0p5_w20 vn_op1_0900_s0p5_w20 en_op1_0900_s0p5_w20 0 0 sky130_fd_pr__nfet_01v8 L=0.15 W=2 nf=1 ad=0.58 as=0.58 pd=4.58 ps=4.58 mult=1 m=1
XMPH_op1_0900_s0p5_w20 vp_op1_0900_s0p5_w20 enb_op1_0900_s0p5_w20 vdd vdd sky130_fd_pr__pfet_01v8 L=0.15 W=4 nf=1 ad=1.16 as=1.16 pd=8.58 ps=8.58 mult=1 m=1
bd_op1_0900_s0p5_w20 d_op1_0900_s0p5_w20 0 v=v(rbl_op1_0900_s0p5_w20)-v(ref_op1_0900_s0p5_w20)

* ---- instance 10: op1_0900_s0p5_w30 (t_en 4.5 ns, WWL 5.5..35.5 ns, release 37.5 ns) ----
ven_op1_0900_s0p5_w30  en_op1_0900_s0p5_w30  0 pwl(0 0 4.5000e-09 0 4.6000e-09 {VDD} 3.7500e-08 {VDD} 3.7600e-08 0)
venb_op1_0900_s0p5_w30 enb_op1_0900_s0p5_w30 0 pwl(0 {VDD} 4.5000e-09 {VDD} 4.6000e-09 0 3.7500e-08 0 3.7600e-08 {VDD})
vrs_op1_0900_s0p5_w30  rwls_op1_0900_s0p5_w30 0 pwl(0 {VDD} {T_READ} {VDD} {T_READ+TEDGE} 0 3.7500e-08 0 3.7600e-08 {VDD})
vww_op1_0900_s0p5_w30  wwl_op1_0900_s0p5_w30 0 pwl(0 0 5.5000e-09 0 5.6000e-09 {VDD} 3.5500e-08 {VDD} 3.5600e-08 0)
vwc_op1_0900_s0p5_w30  wbc_op1_0900_s0p5_w30 0 pwl(0 0 5.5000e-09 0 5.6000e-09 {VDD} 3.7500e-08 {VDD} 3.7600e-08 0)
swb_op1_0900_s0p5_w30 ref_op1_0900_s0p5_w30 wbl_op1_0900_s0p5_w30 wbc_op1_0900_s0p5_w30 0 swwbl
cwbl_op1_0900_s0p5_w30 wbl_op1_0900_s0p5_w30 0 {C_WBL}
spa_op1_0900_s0p5_w30 prea rbl_op1_0900_s0p5_w30 ctl 0 swpre
spr_op1_0900_s0p5_w30 pref ref_op1_0900_s0p5_w30 ctl 0 swpre
crbl_op1_0900_s0p5_w30 rbl_op1_0900_s0p5_w30 0 {C_RBL}
cref_op1_0900_s0p5_w30 ref_op1_0900_s0p5_w30 0 {C_RBL}   $ ASSUMPTION: ideal matched dummy load
XMWR_op1_0900_s0p5_w30_0 sn_op1_0900_s0p5_w30_0 wwl_op1_0900_s0p5_w30 wbl_op1_0900_s0p5_w30 0 sky130_fd_pr__nfet_01v8 L=0.15 W=0.42 nf=1 ad=0.1218 as=0.1218 pd=1.42 ps=1.42 nrd=0.69047619047619  nrs=0.69047619047619 sa=0 sb=0 sd=0 mult=1 m=1
XMRD_op1_0900_s0p5_w30_0 rbl_op1_0900_s0p5_w30 sn_op1_0900_s0p5_w30_0 rwls_op1_0900_s0p5_w30 0 sky130_fd_pr__nfet_01v8 L=0.15 W=0.42 nf=1 ad=0.1218 as=0.1218 pd=1.42 ps=1.42 nrd=0.69047619047619  nrs=0.69047619047619 sa=0 sb=0 sd=0 mult=1 m=1
csn_op1_0900_s0p5_w30_0 sn_op1_0900_s0p5_w30_0 0 {C_SN}
XMWR_op1_0900_s0p5_w30_1 sn_op1_0900_s0p5_w30_1 wwl_des wbl_op1_0900_s0p5_w30 0 sky130_fd_pr__nfet_01v8 L=0.15 W=0.42 nf=1 ad=0.1218 as=0.1218 pd=1.42 ps=1.42 nrd=0.69047619047619  nrs=0.69047619047619 sa=0 sb=0 sd=0 mult=1 m=1
XMRD_op1_0900_s0p5_w30_1 rbl_op1_0900_s0p5_w30 sn_op1_0900_s0p5_w30_1 rwl_des 0 sky130_fd_pr__nfet_01v8 L=0.15 W=0.42 nf=1 ad=0.1218 as=0.1218 pd=1.42 ps=1.42 nrd=0.69047619047619  nrs=0.69047619047619 sa=0 sb=0 sd=0 mult=1 m=1
csn_op1_0900_s0p5_w30_1 sn_op1_0900_s0p5_w30_1 0 {C_SN}
XMWR_op1_0900_s0p5_w30_2 sn_op1_0900_s0p5_w30_2 wwl_des wbl_op1_0900_s0p5_w30 0 sky130_fd_pr__nfet_01v8 L=0.15 W=0.42 nf=1 ad=0.1218 as=0.1218 pd=1.42 ps=1.42 nrd=0.69047619047619  nrs=0.69047619047619 sa=0 sb=0 sd=0 mult=1 m=1
XMRD_op1_0900_s0p5_w30_2 rbl_op1_0900_s0p5_w30 sn_op1_0900_s0p5_w30_2 rwl_des 0 sky130_fd_pr__nfet_01v8 L=0.15 W=0.42 nf=1 ad=0.1218 as=0.1218 pd=1.42 ps=1.42 nrd=0.69047619047619  nrs=0.69047619047619 sa=0 sb=0 sd=0 mult=1 m=1
csn_op1_0900_s0p5_w30_2 sn_op1_0900_s0p5_w30_2 0 {C_SN}
XMWR_op1_0900_s0p5_w30_3 sn_op1_0900_s0p5_w30_3 wwl_des wbl_op1_0900_s0p5_w30 0 sky130_fd_pr__nfet_01v8 L=0.15 W=0.42 nf=1 ad=0.1218 as=0.1218 pd=1.42 ps=1.42 nrd=0.69047619047619  nrs=0.69047619047619 sa=0 sb=0 sd=0 mult=1 m=1
XMRD_op1_0900_s0p5_w30_3 rbl_op1_0900_s0p5_w30 sn_op1_0900_s0p5_w30_3 rwl_des 0 sky130_fd_pr__nfet_01v8 L=0.15 W=0.42 nf=1 ad=0.1218 as=0.1218 pd=1.42 ps=1.42 nrd=0.69047619047619  nrs=0.69047619047619 sa=0 sb=0 sd=0 mult=1 m=1
csn_op1_0900_s0p5_w30_3 sn_op1_0900_s0p5_w30_3 0 {C_SN}
XMN1_op1_0900_s0p5_w30 rbl_op1_0900_s0p5_w30 ref_op1_0900_s0p5_w30 vn_op1_0900_s0p5_w30 0 sky130_fd_pr__nfet_01v8 L=0.15 W=1 nf=1 ad=0.29 as=0.29 pd=2.58 ps=2.58 mult=1 m=1
XMN2_op1_0900_s0p5_w30 ref_op1_0900_s0p5_w30 rbl_op1_0900_s0p5_w30 vn_op1_0900_s0p5_w30 0 sky130_fd_pr__nfet_01v8 L=0.15 W=1 nf=1 ad=0.29 as=0.29 pd=2.58 ps=2.58 mult=1 m=1
XMP1_op1_0900_s0p5_w30 rbl_op1_0900_s0p5_w30 ref_op1_0900_s0p5_w30 vp_op1_0900_s0p5_w30 vdd sky130_fd_pr__pfet_01v8 L=0.15 W=2 nf=1 ad=0.58 as=0.58 pd=4.58 ps=4.58 mult=1 m=1
XMP2_op1_0900_s0p5_w30 ref_op1_0900_s0p5_w30 rbl_op1_0900_s0p5_w30 vp_op1_0900_s0p5_w30 vdd sky130_fd_pr__pfet_01v8 L=0.15 W=2 nf=1 ad=0.58 as=0.58 pd=4.58 ps=4.58 mult=1 m=1
XMNF_op1_0900_s0p5_w30 vn_op1_0900_s0p5_w30 en_op1_0900_s0p5_w30 0 0 sky130_fd_pr__nfet_01v8 L=0.15 W=2 nf=1 ad=0.58 as=0.58 pd=4.58 ps=4.58 mult=1 m=1
XMPH_op1_0900_s0p5_w30 vp_op1_0900_s0p5_w30 enb_op1_0900_s0p5_w30 vdd vdd sky130_fd_pr__pfet_01v8 L=0.15 W=4 nf=1 ad=1.16 as=1.16 pd=8.58 ps=8.58 mult=1 m=1
bd_op1_0900_s0p5_w30 d_op1_0900_s0p5_w30 0 v=v(rbl_op1_0900_s0p5_w30)-v(ref_op1_0900_s0p5_w30)

* ---- instance 11: op1_0900_s0p5_w50 (t_en 4.5 ns, WWL 5.5..55.5 ns, release 57.5 ns) ----
ven_op1_0900_s0p5_w50  en_op1_0900_s0p5_w50  0 pwl(0 0 4.5000e-09 0 4.6000e-09 {VDD} 5.7500e-08 {VDD} 5.7600e-08 0)
venb_op1_0900_s0p5_w50 enb_op1_0900_s0p5_w50 0 pwl(0 {VDD} 4.5000e-09 {VDD} 4.6000e-09 0 5.7500e-08 0 5.7600e-08 {VDD})
vrs_op1_0900_s0p5_w50  rwls_op1_0900_s0p5_w50 0 pwl(0 {VDD} {T_READ} {VDD} {T_READ+TEDGE} 0 5.7500e-08 0 5.7600e-08 {VDD})
vww_op1_0900_s0p5_w50  wwl_op1_0900_s0p5_w50 0 pwl(0 0 5.5000e-09 0 5.6000e-09 {VDD} 5.5500e-08 {VDD} 5.5600e-08 0)
vwc_op1_0900_s0p5_w50  wbc_op1_0900_s0p5_w50 0 pwl(0 0 5.5000e-09 0 5.6000e-09 {VDD} 5.7500e-08 {VDD} 5.7600e-08 0)
swb_op1_0900_s0p5_w50 ref_op1_0900_s0p5_w50 wbl_op1_0900_s0p5_w50 wbc_op1_0900_s0p5_w50 0 swwbl
cwbl_op1_0900_s0p5_w50 wbl_op1_0900_s0p5_w50 0 {C_WBL}
spa_op1_0900_s0p5_w50 prea rbl_op1_0900_s0p5_w50 ctl 0 swpre
spr_op1_0900_s0p5_w50 pref ref_op1_0900_s0p5_w50 ctl 0 swpre
crbl_op1_0900_s0p5_w50 rbl_op1_0900_s0p5_w50 0 {C_RBL}
cref_op1_0900_s0p5_w50 ref_op1_0900_s0p5_w50 0 {C_RBL}   $ ASSUMPTION: ideal matched dummy load
XMWR_op1_0900_s0p5_w50_0 sn_op1_0900_s0p5_w50_0 wwl_op1_0900_s0p5_w50 wbl_op1_0900_s0p5_w50 0 sky130_fd_pr__nfet_01v8 L=0.15 W=0.42 nf=1 ad=0.1218 as=0.1218 pd=1.42 ps=1.42 nrd=0.69047619047619  nrs=0.69047619047619 sa=0 sb=0 sd=0 mult=1 m=1
XMRD_op1_0900_s0p5_w50_0 rbl_op1_0900_s0p5_w50 sn_op1_0900_s0p5_w50_0 rwls_op1_0900_s0p5_w50 0 sky130_fd_pr__nfet_01v8 L=0.15 W=0.42 nf=1 ad=0.1218 as=0.1218 pd=1.42 ps=1.42 nrd=0.69047619047619  nrs=0.69047619047619 sa=0 sb=0 sd=0 mult=1 m=1
csn_op1_0900_s0p5_w50_0 sn_op1_0900_s0p5_w50_0 0 {C_SN}
XMWR_op1_0900_s0p5_w50_1 sn_op1_0900_s0p5_w50_1 wwl_des wbl_op1_0900_s0p5_w50 0 sky130_fd_pr__nfet_01v8 L=0.15 W=0.42 nf=1 ad=0.1218 as=0.1218 pd=1.42 ps=1.42 nrd=0.69047619047619  nrs=0.69047619047619 sa=0 sb=0 sd=0 mult=1 m=1
XMRD_op1_0900_s0p5_w50_1 rbl_op1_0900_s0p5_w50 sn_op1_0900_s0p5_w50_1 rwl_des 0 sky130_fd_pr__nfet_01v8 L=0.15 W=0.42 nf=1 ad=0.1218 as=0.1218 pd=1.42 ps=1.42 nrd=0.69047619047619  nrs=0.69047619047619 sa=0 sb=0 sd=0 mult=1 m=1
csn_op1_0900_s0p5_w50_1 sn_op1_0900_s0p5_w50_1 0 {C_SN}
XMWR_op1_0900_s0p5_w50_2 sn_op1_0900_s0p5_w50_2 wwl_des wbl_op1_0900_s0p5_w50 0 sky130_fd_pr__nfet_01v8 L=0.15 W=0.42 nf=1 ad=0.1218 as=0.1218 pd=1.42 ps=1.42 nrd=0.69047619047619  nrs=0.69047619047619 sa=0 sb=0 sd=0 mult=1 m=1
XMRD_op1_0900_s0p5_w50_2 rbl_op1_0900_s0p5_w50 sn_op1_0900_s0p5_w50_2 rwl_des 0 sky130_fd_pr__nfet_01v8 L=0.15 W=0.42 nf=1 ad=0.1218 as=0.1218 pd=1.42 ps=1.42 nrd=0.69047619047619  nrs=0.69047619047619 sa=0 sb=0 sd=0 mult=1 m=1
csn_op1_0900_s0p5_w50_2 sn_op1_0900_s0p5_w50_2 0 {C_SN}
XMWR_op1_0900_s0p5_w50_3 sn_op1_0900_s0p5_w50_3 wwl_des wbl_op1_0900_s0p5_w50 0 sky130_fd_pr__nfet_01v8 L=0.15 W=0.42 nf=1 ad=0.1218 as=0.1218 pd=1.42 ps=1.42 nrd=0.69047619047619  nrs=0.69047619047619 sa=0 sb=0 sd=0 mult=1 m=1
XMRD_op1_0900_s0p5_w50_3 rbl_op1_0900_s0p5_w50 sn_op1_0900_s0p5_w50_3 rwl_des 0 sky130_fd_pr__nfet_01v8 L=0.15 W=0.42 nf=1 ad=0.1218 as=0.1218 pd=1.42 ps=1.42 nrd=0.69047619047619  nrs=0.69047619047619 sa=0 sb=0 sd=0 mult=1 m=1
csn_op1_0900_s0p5_w50_3 sn_op1_0900_s0p5_w50_3 0 {C_SN}
XMN1_op1_0900_s0p5_w50 rbl_op1_0900_s0p5_w50 ref_op1_0900_s0p5_w50 vn_op1_0900_s0p5_w50 0 sky130_fd_pr__nfet_01v8 L=0.15 W=1 nf=1 ad=0.29 as=0.29 pd=2.58 ps=2.58 mult=1 m=1
XMN2_op1_0900_s0p5_w50 ref_op1_0900_s0p5_w50 rbl_op1_0900_s0p5_w50 vn_op1_0900_s0p5_w50 0 sky130_fd_pr__nfet_01v8 L=0.15 W=1 nf=1 ad=0.29 as=0.29 pd=2.58 ps=2.58 mult=1 m=1
XMP1_op1_0900_s0p5_w50 rbl_op1_0900_s0p5_w50 ref_op1_0900_s0p5_w50 vp_op1_0900_s0p5_w50 vdd sky130_fd_pr__pfet_01v8 L=0.15 W=2 nf=1 ad=0.58 as=0.58 pd=4.58 ps=4.58 mult=1 m=1
XMP2_op1_0900_s0p5_w50 ref_op1_0900_s0p5_w50 rbl_op1_0900_s0p5_w50 vp_op1_0900_s0p5_w50 vdd sky130_fd_pr__pfet_01v8 L=0.15 W=2 nf=1 ad=0.58 as=0.58 pd=4.58 ps=4.58 mult=1 m=1
XMNF_op1_0900_s0p5_w50 vn_op1_0900_s0p5_w50 en_op1_0900_s0p5_w50 0 0 sky130_fd_pr__nfet_01v8 L=0.15 W=2 nf=1 ad=0.58 as=0.58 pd=4.58 ps=4.58 mult=1 m=1
XMPH_op1_0900_s0p5_w50 vp_op1_0900_s0p5_w50 enb_op1_0900_s0p5_w50 vdd vdd sky130_fd_pr__pfet_01v8 L=0.15 W=4 nf=1 ad=1.16 as=1.16 pd=8.58 ps=8.58 mult=1 m=1
bd_op1_0900_s0p5_w50 d_op1_0900_s0p5_w50 0 v=v(rbl_op1_0900_s0p5_w50)-v(ref_op1_0900_s0p5_w50)

* ---- instance 12: op1_0900_s1_w0p2 (t_en 5 ns, WWL 6..6.2 ns, release 8.2 ns) ----
ven_op1_0900_s1_w0p2  en_op1_0900_s1_w0p2  0 pwl(0 0 5.0000e-09 0 5.1000e-09 {VDD} 8.2000e-09 {VDD} 8.3000e-09 0)
venb_op1_0900_s1_w0p2 enb_op1_0900_s1_w0p2 0 pwl(0 {VDD} 5.0000e-09 {VDD} 5.1000e-09 0 8.2000e-09 0 8.3000e-09 {VDD})
vrs_op1_0900_s1_w0p2  rwls_op1_0900_s1_w0p2 0 pwl(0 {VDD} {T_READ} {VDD} {T_READ+TEDGE} 0 8.2000e-09 0 8.3000e-09 {VDD})
vww_op1_0900_s1_w0p2  wwl_op1_0900_s1_w0p2 0 pwl(0 0 6.0000e-09 0 6.1000e-09 {VDD} 6.2000e-09 {VDD} 6.3000e-09 0)
vwc_op1_0900_s1_w0p2  wbc_op1_0900_s1_w0p2 0 pwl(0 0 6.0000e-09 0 6.1000e-09 {VDD} 8.2000e-09 {VDD} 8.3000e-09 0)
swb_op1_0900_s1_w0p2 ref_op1_0900_s1_w0p2 wbl_op1_0900_s1_w0p2 wbc_op1_0900_s1_w0p2 0 swwbl
cwbl_op1_0900_s1_w0p2 wbl_op1_0900_s1_w0p2 0 {C_WBL}
spa_op1_0900_s1_w0p2 prea rbl_op1_0900_s1_w0p2 ctl 0 swpre
spr_op1_0900_s1_w0p2 pref ref_op1_0900_s1_w0p2 ctl 0 swpre
crbl_op1_0900_s1_w0p2 rbl_op1_0900_s1_w0p2 0 {C_RBL}
cref_op1_0900_s1_w0p2 ref_op1_0900_s1_w0p2 0 {C_RBL}   $ ASSUMPTION: ideal matched dummy load
XMWR_op1_0900_s1_w0p2_0 sn_op1_0900_s1_w0p2_0 wwl_op1_0900_s1_w0p2 wbl_op1_0900_s1_w0p2 0 sky130_fd_pr__nfet_01v8 L=0.15 W=0.42 nf=1 ad=0.1218 as=0.1218 pd=1.42 ps=1.42 nrd=0.69047619047619  nrs=0.69047619047619 sa=0 sb=0 sd=0 mult=1 m=1
XMRD_op1_0900_s1_w0p2_0 rbl_op1_0900_s1_w0p2 sn_op1_0900_s1_w0p2_0 rwls_op1_0900_s1_w0p2 0 sky130_fd_pr__nfet_01v8 L=0.15 W=0.42 nf=1 ad=0.1218 as=0.1218 pd=1.42 ps=1.42 nrd=0.69047619047619  nrs=0.69047619047619 sa=0 sb=0 sd=0 mult=1 m=1
csn_op1_0900_s1_w0p2_0 sn_op1_0900_s1_w0p2_0 0 {C_SN}
XMWR_op1_0900_s1_w0p2_1 sn_op1_0900_s1_w0p2_1 wwl_des wbl_op1_0900_s1_w0p2 0 sky130_fd_pr__nfet_01v8 L=0.15 W=0.42 nf=1 ad=0.1218 as=0.1218 pd=1.42 ps=1.42 nrd=0.69047619047619  nrs=0.69047619047619 sa=0 sb=0 sd=0 mult=1 m=1
XMRD_op1_0900_s1_w0p2_1 rbl_op1_0900_s1_w0p2 sn_op1_0900_s1_w0p2_1 rwl_des 0 sky130_fd_pr__nfet_01v8 L=0.15 W=0.42 nf=1 ad=0.1218 as=0.1218 pd=1.42 ps=1.42 nrd=0.69047619047619  nrs=0.69047619047619 sa=0 sb=0 sd=0 mult=1 m=1
csn_op1_0900_s1_w0p2_1 sn_op1_0900_s1_w0p2_1 0 {C_SN}
XMWR_op1_0900_s1_w0p2_2 sn_op1_0900_s1_w0p2_2 wwl_des wbl_op1_0900_s1_w0p2 0 sky130_fd_pr__nfet_01v8 L=0.15 W=0.42 nf=1 ad=0.1218 as=0.1218 pd=1.42 ps=1.42 nrd=0.69047619047619  nrs=0.69047619047619 sa=0 sb=0 sd=0 mult=1 m=1
XMRD_op1_0900_s1_w0p2_2 rbl_op1_0900_s1_w0p2 sn_op1_0900_s1_w0p2_2 rwl_des 0 sky130_fd_pr__nfet_01v8 L=0.15 W=0.42 nf=1 ad=0.1218 as=0.1218 pd=1.42 ps=1.42 nrd=0.69047619047619  nrs=0.69047619047619 sa=0 sb=0 sd=0 mult=1 m=1
csn_op1_0900_s1_w0p2_2 sn_op1_0900_s1_w0p2_2 0 {C_SN}
XMWR_op1_0900_s1_w0p2_3 sn_op1_0900_s1_w0p2_3 wwl_des wbl_op1_0900_s1_w0p2 0 sky130_fd_pr__nfet_01v8 L=0.15 W=0.42 nf=1 ad=0.1218 as=0.1218 pd=1.42 ps=1.42 nrd=0.69047619047619  nrs=0.69047619047619 sa=0 sb=0 sd=0 mult=1 m=1
XMRD_op1_0900_s1_w0p2_3 rbl_op1_0900_s1_w0p2 sn_op1_0900_s1_w0p2_3 rwl_des 0 sky130_fd_pr__nfet_01v8 L=0.15 W=0.42 nf=1 ad=0.1218 as=0.1218 pd=1.42 ps=1.42 nrd=0.69047619047619  nrs=0.69047619047619 sa=0 sb=0 sd=0 mult=1 m=1
csn_op1_0900_s1_w0p2_3 sn_op1_0900_s1_w0p2_3 0 {C_SN}
XMN1_op1_0900_s1_w0p2 rbl_op1_0900_s1_w0p2 ref_op1_0900_s1_w0p2 vn_op1_0900_s1_w0p2 0 sky130_fd_pr__nfet_01v8 L=0.15 W=1 nf=1 ad=0.29 as=0.29 pd=2.58 ps=2.58 mult=1 m=1
XMN2_op1_0900_s1_w0p2 ref_op1_0900_s1_w0p2 rbl_op1_0900_s1_w0p2 vn_op1_0900_s1_w0p2 0 sky130_fd_pr__nfet_01v8 L=0.15 W=1 nf=1 ad=0.29 as=0.29 pd=2.58 ps=2.58 mult=1 m=1
XMP1_op1_0900_s1_w0p2 rbl_op1_0900_s1_w0p2 ref_op1_0900_s1_w0p2 vp_op1_0900_s1_w0p2 vdd sky130_fd_pr__pfet_01v8 L=0.15 W=2 nf=1 ad=0.58 as=0.58 pd=4.58 ps=4.58 mult=1 m=1
XMP2_op1_0900_s1_w0p2 ref_op1_0900_s1_w0p2 rbl_op1_0900_s1_w0p2 vp_op1_0900_s1_w0p2 vdd sky130_fd_pr__pfet_01v8 L=0.15 W=2 nf=1 ad=0.58 as=0.58 pd=4.58 ps=4.58 mult=1 m=1
XMNF_op1_0900_s1_w0p2 vn_op1_0900_s1_w0p2 en_op1_0900_s1_w0p2 0 0 sky130_fd_pr__nfet_01v8 L=0.15 W=2 nf=1 ad=0.58 as=0.58 pd=4.58 ps=4.58 mult=1 m=1
XMPH_op1_0900_s1_w0p2 vp_op1_0900_s1_w0p2 enb_op1_0900_s1_w0p2 vdd vdd sky130_fd_pr__pfet_01v8 L=0.15 W=4 nf=1 ad=1.16 as=1.16 pd=8.58 ps=8.58 mult=1 m=1
bd_op1_0900_s1_w0p2 d_op1_0900_s1_w0p2 0 v=v(rbl_op1_0900_s1_w0p2)-v(ref_op1_0900_s1_w0p2)

* ---- instance 13: op1_0900_s1_w0p5 (t_en 5 ns, WWL 6..6.5 ns, release 8.5 ns) ----
ven_op1_0900_s1_w0p5  en_op1_0900_s1_w0p5  0 pwl(0 0 5.0000e-09 0 5.1000e-09 {VDD} 8.5000e-09 {VDD} 8.6000e-09 0)
venb_op1_0900_s1_w0p5 enb_op1_0900_s1_w0p5 0 pwl(0 {VDD} 5.0000e-09 {VDD} 5.1000e-09 0 8.5000e-09 0 8.6000e-09 {VDD})
vrs_op1_0900_s1_w0p5  rwls_op1_0900_s1_w0p5 0 pwl(0 {VDD} {T_READ} {VDD} {T_READ+TEDGE} 0 8.5000e-09 0 8.6000e-09 {VDD})
vww_op1_0900_s1_w0p5  wwl_op1_0900_s1_w0p5 0 pwl(0 0 6.0000e-09 0 6.1000e-09 {VDD} 6.5000e-09 {VDD} 6.6000e-09 0)
vwc_op1_0900_s1_w0p5  wbc_op1_0900_s1_w0p5 0 pwl(0 0 6.0000e-09 0 6.1000e-09 {VDD} 8.5000e-09 {VDD} 8.6000e-09 0)
swb_op1_0900_s1_w0p5 ref_op1_0900_s1_w0p5 wbl_op1_0900_s1_w0p5 wbc_op1_0900_s1_w0p5 0 swwbl
cwbl_op1_0900_s1_w0p5 wbl_op1_0900_s1_w0p5 0 {C_WBL}
spa_op1_0900_s1_w0p5 prea rbl_op1_0900_s1_w0p5 ctl 0 swpre
spr_op1_0900_s1_w0p5 pref ref_op1_0900_s1_w0p5 ctl 0 swpre
crbl_op1_0900_s1_w0p5 rbl_op1_0900_s1_w0p5 0 {C_RBL}
cref_op1_0900_s1_w0p5 ref_op1_0900_s1_w0p5 0 {C_RBL}   $ ASSUMPTION: ideal matched dummy load
XMWR_op1_0900_s1_w0p5_0 sn_op1_0900_s1_w0p5_0 wwl_op1_0900_s1_w0p5 wbl_op1_0900_s1_w0p5 0 sky130_fd_pr__nfet_01v8 L=0.15 W=0.42 nf=1 ad=0.1218 as=0.1218 pd=1.42 ps=1.42 nrd=0.69047619047619  nrs=0.69047619047619 sa=0 sb=0 sd=0 mult=1 m=1
XMRD_op1_0900_s1_w0p5_0 rbl_op1_0900_s1_w0p5 sn_op1_0900_s1_w0p5_0 rwls_op1_0900_s1_w0p5 0 sky130_fd_pr__nfet_01v8 L=0.15 W=0.42 nf=1 ad=0.1218 as=0.1218 pd=1.42 ps=1.42 nrd=0.69047619047619  nrs=0.69047619047619 sa=0 sb=0 sd=0 mult=1 m=1
csn_op1_0900_s1_w0p5_0 sn_op1_0900_s1_w0p5_0 0 {C_SN}
XMWR_op1_0900_s1_w0p5_1 sn_op1_0900_s1_w0p5_1 wwl_des wbl_op1_0900_s1_w0p5 0 sky130_fd_pr__nfet_01v8 L=0.15 W=0.42 nf=1 ad=0.1218 as=0.1218 pd=1.42 ps=1.42 nrd=0.69047619047619  nrs=0.69047619047619 sa=0 sb=0 sd=0 mult=1 m=1
XMRD_op1_0900_s1_w0p5_1 rbl_op1_0900_s1_w0p5 sn_op1_0900_s1_w0p5_1 rwl_des 0 sky130_fd_pr__nfet_01v8 L=0.15 W=0.42 nf=1 ad=0.1218 as=0.1218 pd=1.42 ps=1.42 nrd=0.69047619047619  nrs=0.69047619047619 sa=0 sb=0 sd=0 mult=1 m=1
csn_op1_0900_s1_w0p5_1 sn_op1_0900_s1_w0p5_1 0 {C_SN}
XMWR_op1_0900_s1_w0p5_2 sn_op1_0900_s1_w0p5_2 wwl_des wbl_op1_0900_s1_w0p5 0 sky130_fd_pr__nfet_01v8 L=0.15 W=0.42 nf=1 ad=0.1218 as=0.1218 pd=1.42 ps=1.42 nrd=0.69047619047619  nrs=0.69047619047619 sa=0 sb=0 sd=0 mult=1 m=1
XMRD_op1_0900_s1_w0p5_2 rbl_op1_0900_s1_w0p5 sn_op1_0900_s1_w0p5_2 rwl_des 0 sky130_fd_pr__nfet_01v8 L=0.15 W=0.42 nf=1 ad=0.1218 as=0.1218 pd=1.42 ps=1.42 nrd=0.69047619047619  nrs=0.69047619047619 sa=0 sb=0 sd=0 mult=1 m=1
csn_op1_0900_s1_w0p5_2 sn_op1_0900_s1_w0p5_2 0 {C_SN}
XMWR_op1_0900_s1_w0p5_3 sn_op1_0900_s1_w0p5_3 wwl_des wbl_op1_0900_s1_w0p5 0 sky130_fd_pr__nfet_01v8 L=0.15 W=0.42 nf=1 ad=0.1218 as=0.1218 pd=1.42 ps=1.42 nrd=0.69047619047619  nrs=0.69047619047619 sa=0 sb=0 sd=0 mult=1 m=1
XMRD_op1_0900_s1_w0p5_3 rbl_op1_0900_s1_w0p5 sn_op1_0900_s1_w0p5_3 rwl_des 0 sky130_fd_pr__nfet_01v8 L=0.15 W=0.42 nf=1 ad=0.1218 as=0.1218 pd=1.42 ps=1.42 nrd=0.69047619047619  nrs=0.69047619047619 sa=0 sb=0 sd=0 mult=1 m=1
csn_op1_0900_s1_w0p5_3 sn_op1_0900_s1_w0p5_3 0 {C_SN}
XMN1_op1_0900_s1_w0p5 rbl_op1_0900_s1_w0p5 ref_op1_0900_s1_w0p5 vn_op1_0900_s1_w0p5 0 sky130_fd_pr__nfet_01v8 L=0.15 W=1 nf=1 ad=0.29 as=0.29 pd=2.58 ps=2.58 mult=1 m=1
XMN2_op1_0900_s1_w0p5 ref_op1_0900_s1_w0p5 rbl_op1_0900_s1_w0p5 vn_op1_0900_s1_w0p5 0 sky130_fd_pr__nfet_01v8 L=0.15 W=1 nf=1 ad=0.29 as=0.29 pd=2.58 ps=2.58 mult=1 m=1
XMP1_op1_0900_s1_w0p5 rbl_op1_0900_s1_w0p5 ref_op1_0900_s1_w0p5 vp_op1_0900_s1_w0p5 vdd sky130_fd_pr__pfet_01v8 L=0.15 W=2 nf=1 ad=0.58 as=0.58 pd=4.58 ps=4.58 mult=1 m=1
XMP2_op1_0900_s1_w0p5 ref_op1_0900_s1_w0p5 rbl_op1_0900_s1_w0p5 vp_op1_0900_s1_w0p5 vdd sky130_fd_pr__pfet_01v8 L=0.15 W=2 nf=1 ad=0.58 as=0.58 pd=4.58 ps=4.58 mult=1 m=1
XMNF_op1_0900_s1_w0p5 vn_op1_0900_s1_w0p5 en_op1_0900_s1_w0p5 0 0 sky130_fd_pr__nfet_01v8 L=0.15 W=2 nf=1 ad=0.58 as=0.58 pd=4.58 ps=4.58 mult=1 m=1
XMPH_op1_0900_s1_w0p5 vp_op1_0900_s1_w0p5 enb_op1_0900_s1_w0p5 vdd vdd sky130_fd_pr__pfet_01v8 L=0.15 W=4 nf=1 ad=1.16 as=1.16 pd=8.58 ps=8.58 mult=1 m=1
bd_op1_0900_s1_w0p5 d_op1_0900_s1_w0p5 0 v=v(rbl_op1_0900_s1_w0p5)-v(ref_op1_0900_s1_w0p5)

* ---- instance 14: op1_0900_s1_w1 (t_en 5 ns, WWL 6..7 ns, release 9 ns) ----
ven_op1_0900_s1_w1  en_op1_0900_s1_w1  0 pwl(0 0 5.0000e-09 0 5.1000e-09 {VDD} 9.0000e-09 {VDD} 9.1000e-09 0)
venb_op1_0900_s1_w1 enb_op1_0900_s1_w1 0 pwl(0 {VDD} 5.0000e-09 {VDD} 5.1000e-09 0 9.0000e-09 0 9.1000e-09 {VDD})
vrs_op1_0900_s1_w1  rwls_op1_0900_s1_w1 0 pwl(0 {VDD} {T_READ} {VDD} {T_READ+TEDGE} 0 9.0000e-09 0 9.1000e-09 {VDD})
vww_op1_0900_s1_w1  wwl_op1_0900_s1_w1 0 pwl(0 0 6.0000e-09 0 6.1000e-09 {VDD} 7.0000e-09 {VDD} 7.1000e-09 0)
vwc_op1_0900_s1_w1  wbc_op1_0900_s1_w1 0 pwl(0 0 6.0000e-09 0 6.1000e-09 {VDD} 9.0000e-09 {VDD} 9.1000e-09 0)
swb_op1_0900_s1_w1 ref_op1_0900_s1_w1 wbl_op1_0900_s1_w1 wbc_op1_0900_s1_w1 0 swwbl
cwbl_op1_0900_s1_w1 wbl_op1_0900_s1_w1 0 {C_WBL}
spa_op1_0900_s1_w1 prea rbl_op1_0900_s1_w1 ctl 0 swpre
spr_op1_0900_s1_w1 pref ref_op1_0900_s1_w1 ctl 0 swpre
crbl_op1_0900_s1_w1 rbl_op1_0900_s1_w1 0 {C_RBL}
cref_op1_0900_s1_w1 ref_op1_0900_s1_w1 0 {C_RBL}   $ ASSUMPTION: ideal matched dummy load
XMWR_op1_0900_s1_w1_0 sn_op1_0900_s1_w1_0 wwl_op1_0900_s1_w1 wbl_op1_0900_s1_w1 0 sky130_fd_pr__nfet_01v8 L=0.15 W=0.42 nf=1 ad=0.1218 as=0.1218 pd=1.42 ps=1.42 nrd=0.69047619047619  nrs=0.69047619047619 sa=0 sb=0 sd=0 mult=1 m=1
XMRD_op1_0900_s1_w1_0 rbl_op1_0900_s1_w1 sn_op1_0900_s1_w1_0 rwls_op1_0900_s1_w1 0 sky130_fd_pr__nfet_01v8 L=0.15 W=0.42 nf=1 ad=0.1218 as=0.1218 pd=1.42 ps=1.42 nrd=0.69047619047619  nrs=0.69047619047619 sa=0 sb=0 sd=0 mult=1 m=1
csn_op1_0900_s1_w1_0 sn_op1_0900_s1_w1_0 0 {C_SN}
XMWR_op1_0900_s1_w1_1 sn_op1_0900_s1_w1_1 wwl_des wbl_op1_0900_s1_w1 0 sky130_fd_pr__nfet_01v8 L=0.15 W=0.42 nf=1 ad=0.1218 as=0.1218 pd=1.42 ps=1.42 nrd=0.69047619047619  nrs=0.69047619047619 sa=0 sb=0 sd=0 mult=1 m=1
XMRD_op1_0900_s1_w1_1 rbl_op1_0900_s1_w1 sn_op1_0900_s1_w1_1 rwl_des 0 sky130_fd_pr__nfet_01v8 L=0.15 W=0.42 nf=1 ad=0.1218 as=0.1218 pd=1.42 ps=1.42 nrd=0.69047619047619  nrs=0.69047619047619 sa=0 sb=0 sd=0 mult=1 m=1
csn_op1_0900_s1_w1_1 sn_op1_0900_s1_w1_1 0 {C_SN}
XMWR_op1_0900_s1_w1_2 sn_op1_0900_s1_w1_2 wwl_des wbl_op1_0900_s1_w1 0 sky130_fd_pr__nfet_01v8 L=0.15 W=0.42 nf=1 ad=0.1218 as=0.1218 pd=1.42 ps=1.42 nrd=0.69047619047619  nrs=0.69047619047619 sa=0 sb=0 sd=0 mult=1 m=1
XMRD_op1_0900_s1_w1_2 rbl_op1_0900_s1_w1 sn_op1_0900_s1_w1_2 rwl_des 0 sky130_fd_pr__nfet_01v8 L=0.15 W=0.42 nf=1 ad=0.1218 as=0.1218 pd=1.42 ps=1.42 nrd=0.69047619047619  nrs=0.69047619047619 sa=0 sb=0 sd=0 mult=1 m=1
csn_op1_0900_s1_w1_2 sn_op1_0900_s1_w1_2 0 {C_SN}
XMWR_op1_0900_s1_w1_3 sn_op1_0900_s1_w1_3 wwl_des wbl_op1_0900_s1_w1 0 sky130_fd_pr__nfet_01v8 L=0.15 W=0.42 nf=1 ad=0.1218 as=0.1218 pd=1.42 ps=1.42 nrd=0.69047619047619  nrs=0.69047619047619 sa=0 sb=0 sd=0 mult=1 m=1
XMRD_op1_0900_s1_w1_3 rbl_op1_0900_s1_w1 sn_op1_0900_s1_w1_3 rwl_des 0 sky130_fd_pr__nfet_01v8 L=0.15 W=0.42 nf=1 ad=0.1218 as=0.1218 pd=1.42 ps=1.42 nrd=0.69047619047619  nrs=0.69047619047619 sa=0 sb=0 sd=0 mult=1 m=1
csn_op1_0900_s1_w1_3 sn_op1_0900_s1_w1_3 0 {C_SN}
XMN1_op1_0900_s1_w1 rbl_op1_0900_s1_w1 ref_op1_0900_s1_w1 vn_op1_0900_s1_w1 0 sky130_fd_pr__nfet_01v8 L=0.15 W=1 nf=1 ad=0.29 as=0.29 pd=2.58 ps=2.58 mult=1 m=1
XMN2_op1_0900_s1_w1 ref_op1_0900_s1_w1 rbl_op1_0900_s1_w1 vn_op1_0900_s1_w1 0 sky130_fd_pr__nfet_01v8 L=0.15 W=1 nf=1 ad=0.29 as=0.29 pd=2.58 ps=2.58 mult=1 m=1
XMP1_op1_0900_s1_w1 rbl_op1_0900_s1_w1 ref_op1_0900_s1_w1 vp_op1_0900_s1_w1 vdd sky130_fd_pr__pfet_01v8 L=0.15 W=2 nf=1 ad=0.58 as=0.58 pd=4.58 ps=4.58 mult=1 m=1
XMP2_op1_0900_s1_w1 ref_op1_0900_s1_w1 rbl_op1_0900_s1_w1 vp_op1_0900_s1_w1 vdd sky130_fd_pr__pfet_01v8 L=0.15 W=2 nf=1 ad=0.58 as=0.58 pd=4.58 ps=4.58 mult=1 m=1
XMNF_op1_0900_s1_w1 vn_op1_0900_s1_w1 en_op1_0900_s1_w1 0 0 sky130_fd_pr__nfet_01v8 L=0.15 W=2 nf=1 ad=0.58 as=0.58 pd=4.58 ps=4.58 mult=1 m=1
XMPH_op1_0900_s1_w1 vp_op1_0900_s1_w1 enb_op1_0900_s1_w1 vdd vdd sky130_fd_pr__pfet_01v8 L=0.15 W=4 nf=1 ad=1.16 as=1.16 pd=8.58 ps=8.58 mult=1 m=1
bd_op1_0900_s1_w1 d_op1_0900_s1_w1 0 v=v(rbl_op1_0900_s1_w1)-v(ref_op1_0900_s1_w1)

* ---- instance 15: op1_0900_s1_w2 (t_en 5 ns, WWL 6..8 ns, release 10 ns) ----
ven_op1_0900_s1_w2  en_op1_0900_s1_w2  0 pwl(0 0 5.0000e-09 0 5.1000e-09 {VDD} 1.0000e-08 {VDD} 1.0100e-08 0)
venb_op1_0900_s1_w2 enb_op1_0900_s1_w2 0 pwl(0 {VDD} 5.0000e-09 {VDD} 5.1000e-09 0 1.0000e-08 0 1.0100e-08 {VDD})
vrs_op1_0900_s1_w2  rwls_op1_0900_s1_w2 0 pwl(0 {VDD} {T_READ} {VDD} {T_READ+TEDGE} 0 1.0000e-08 0 1.0100e-08 {VDD})
vww_op1_0900_s1_w2  wwl_op1_0900_s1_w2 0 pwl(0 0 6.0000e-09 0 6.1000e-09 {VDD} 8.0000e-09 {VDD} 8.1000e-09 0)
vwc_op1_0900_s1_w2  wbc_op1_0900_s1_w2 0 pwl(0 0 6.0000e-09 0 6.1000e-09 {VDD} 1.0000e-08 {VDD} 1.0100e-08 0)
swb_op1_0900_s1_w2 ref_op1_0900_s1_w2 wbl_op1_0900_s1_w2 wbc_op1_0900_s1_w2 0 swwbl
cwbl_op1_0900_s1_w2 wbl_op1_0900_s1_w2 0 {C_WBL}
spa_op1_0900_s1_w2 prea rbl_op1_0900_s1_w2 ctl 0 swpre
spr_op1_0900_s1_w2 pref ref_op1_0900_s1_w2 ctl 0 swpre
crbl_op1_0900_s1_w2 rbl_op1_0900_s1_w2 0 {C_RBL}
cref_op1_0900_s1_w2 ref_op1_0900_s1_w2 0 {C_RBL}   $ ASSUMPTION: ideal matched dummy load
XMWR_op1_0900_s1_w2_0 sn_op1_0900_s1_w2_0 wwl_op1_0900_s1_w2 wbl_op1_0900_s1_w2 0 sky130_fd_pr__nfet_01v8 L=0.15 W=0.42 nf=1 ad=0.1218 as=0.1218 pd=1.42 ps=1.42 nrd=0.69047619047619  nrs=0.69047619047619 sa=0 sb=0 sd=0 mult=1 m=1
XMRD_op1_0900_s1_w2_0 rbl_op1_0900_s1_w2 sn_op1_0900_s1_w2_0 rwls_op1_0900_s1_w2 0 sky130_fd_pr__nfet_01v8 L=0.15 W=0.42 nf=1 ad=0.1218 as=0.1218 pd=1.42 ps=1.42 nrd=0.69047619047619  nrs=0.69047619047619 sa=0 sb=0 sd=0 mult=1 m=1
csn_op1_0900_s1_w2_0 sn_op1_0900_s1_w2_0 0 {C_SN}
XMWR_op1_0900_s1_w2_1 sn_op1_0900_s1_w2_1 wwl_des wbl_op1_0900_s1_w2 0 sky130_fd_pr__nfet_01v8 L=0.15 W=0.42 nf=1 ad=0.1218 as=0.1218 pd=1.42 ps=1.42 nrd=0.69047619047619  nrs=0.69047619047619 sa=0 sb=0 sd=0 mult=1 m=1
XMRD_op1_0900_s1_w2_1 rbl_op1_0900_s1_w2 sn_op1_0900_s1_w2_1 rwl_des 0 sky130_fd_pr__nfet_01v8 L=0.15 W=0.42 nf=1 ad=0.1218 as=0.1218 pd=1.42 ps=1.42 nrd=0.69047619047619  nrs=0.69047619047619 sa=0 sb=0 sd=0 mult=1 m=1
csn_op1_0900_s1_w2_1 sn_op1_0900_s1_w2_1 0 {C_SN}
XMWR_op1_0900_s1_w2_2 sn_op1_0900_s1_w2_2 wwl_des wbl_op1_0900_s1_w2 0 sky130_fd_pr__nfet_01v8 L=0.15 W=0.42 nf=1 ad=0.1218 as=0.1218 pd=1.42 ps=1.42 nrd=0.69047619047619  nrs=0.69047619047619 sa=0 sb=0 sd=0 mult=1 m=1
XMRD_op1_0900_s1_w2_2 rbl_op1_0900_s1_w2 sn_op1_0900_s1_w2_2 rwl_des 0 sky130_fd_pr__nfet_01v8 L=0.15 W=0.42 nf=1 ad=0.1218 as=0.1218 pd=1.42 ps=1.42 nrd=0.69047619047619  nrs=0.69047619047619 sa=0 sb=0 sd=0 mult=1 m=1
csn_op1_0900_s1_w2_2 sn_op1_0900_s1_w2_2 0 {C_SN}
XMWR_op1_0900_s1_w2_3 sn_op1_0900_s1_w2_3 wwl_des wbl_op1_0900_s1_w2 0 sky130_fd_pr__nfet_01v8 L=0.15 W=0.42 nf=1 ad=0.1218 as=0.1218 pd=1.42 ps=1.42 nrd=0.69047619047619  nrs=0.69047619047619 sa=0 sb=0 sd=0 mult=1 m=1
XMRD_op1_0900_s1_w2_3 rbl_op1_0900_s1_w2 sn_op1_0900_s1_w2_3 rwl_des 0 sky130_fd_pr__nfet_01v8 L=0.15 W=0.42 nf=1 ad=0.1218 as=0.1218 pd=1.42 ps=1.42 nrd=0.69047619047619  nrs=0.69047619047619 sa=0 sb=0 sd=0 mult=1 m=1
csn_op1_0900_s1_w2_3 sn_op1_0900_s1_w2_3 0 {C_SN}
XMN1_op1_0900_s1_w2 rbl_op1_0900_s1_w2 ref_op1_0900_s1_w2 vn_op1_0900_s1_w2 0 sky130_fd_pr__nfet_01v8 L=0.15 W=1 nf=1 ad=0.29 as=0.29 pd=2.58 ps=2.58 mult=1 m=1
XMN2_op1_0900_s1_w2 ref_op1_0900_s1_w2 rbl_op1_0900_s1_w2 vn_op1_0900_s1_w2 0 sky130_fd_pr__nfet_01v8 L=0.15 W=1 nf=1 ad=0.29 as=0.29 pd=2.58 ps=2.58 mult=1 m=1
XMP1_op1_0900_s1_w2 rbl_op1_0900_s1_w2 ref_op1_0900_s1_w2 vp_op1_0900_s1_w2 vdd sky130_fd_pr__pfet_01v8 L=0.15 W=2 nf=1 ad=0.58 as=0.58 pd=4.58 ps=4.58 mult=1 m=1
XMP2_op1_0900_s1_w2 ref_op1_0900_s1_w2 rbl_op1_0900_s1_w2 vp_op1_0900_s1_w2 vdd sky130_fd_pr__pfet_01v8 L=0.15 W=2 nf=1 ad=0.58 as=0.58 pd=4.58 ps=4.58 mult=1 m=1
XMNF_op1_0900_s1_w2 vn_op1_0900_s1_w2 en_op1_0900_s1_w2 0 0 sky130_fd_pr__nfet_01v8 L=0.15 W=2 nf=1 ad=0.58 as=0.58 pd=4.58 ps=4.58 mult=1 m=1
XMPH_op1_0900_s1_w2 vp_op1_0900_s1_w2 enb_op1_0900_s1_w2 vdd vdd sky130_fd_pr__pfet_01v8 L=0.15 W=4 nf=1 ad=1.16 as=1.16 pd=8.58 ps=8.58 mult=1 m=1
bd_op1_0900_s1_w2 d_op1_0900_s1_w2 0 v=v(rbl_op1_0900_s1_w2)-v(ref_op1_0900_s1_w2)

* ---- instance 16: op1_0900_s1_w3 (t_en 5 ns, WWL 6..9 ns, release 11 ns) ----
ven_op1_0900_s1_w3  en_op1_0900_s1_w3  0 pwl(0 0 5.0000e-09 0 5.1000e-09 {VDD} 1.1000e-08 {VDD} 1.1100e-08 0)
venb_op1_0900_s1_w3 enb_op1_0900_s1_w3 0 pwl(0 {VDD} 5.0000e-09 {VDD} 5.1000e-09 0 1.1000e-08 0 1.1100e-08 {VDD})
vrs_op1_0900_s1_w3  rwls_op1_0900_s1_w3 0 pwl(0 {VDD} {T_READ} {VDD} {T_READ+TEDGE} 0 1.1000e-08 0 1.1100e-08 {VDD})
vww_op1_0900_s1_w3  wwl_op1_0900_s1_w3 0 pwl(0 0 6.0000e-09 0 6.1000e-09 {VDD} 9.0000e-09 {VDD} 9.1000e-09 0)
vwc_op1_0900_s1_w3  wbc_op1_0900_s1_w3 0 pwl(0 0 6.0000e-09 0 6.1000e-09 {VDD} 1.1000e-08 {VDD} 1.1100e-08 0)
swb_op1_0900_s1_w3 ref_op1_0900_s1_w3 wbl_op1_0900_s1_w3 wbc_op1_0900_s1_w3 0 swwbl
cwbl_op1_0900_s1_w3 wbl_op1_0900_s1_w3 0 {C_WBL}
spa_op1_0900_s1_w3 prea rbl_op1_0900_s1_w3 ctl 0 swpre
spr_op1_0900_s1_w3 pref ref_op1_0900_s1_w3 ctl 0 swpre
crbl_op1_0900_s1_w3 rbl_op1_0900_s1_w3 0 {C_RBL}
cref_op1_0900_s1_w3 ref_op1_0900_s1_w3 0 {C_RBL}   $ ASSUMPTION: ideal matched dummy load
XMWR_op1_0900_s1_w3_0 sn_op1_0900_s1_w3_0 wwl_op1_0900_s1_w3 wbl_op1_0900_s1_w3 0 sky130_fd_pr__nfet_01v8 L=0.15 W=0.42 nf=1 ad=0.1218 as=0.1218 pd=1.42 ps=1.42 nrd=0.69047619047619  nrs=0.69047619047619 sa=0 sb=0 sd=0 mult=1 m=1
XMRD_op1_0900_s1_w3_0 rbl_op1_0900_s1_w3 sn_op1_0900_s1_w3_0 rwls_op1_0900_s1_w3 0 sky130_fd_pr__nfet_01v8 L=0.15 W=0.42 nf=1 ad=0.1218 as=0.1218 pd=1.42 ps=1.42 nrd=0.69047619047619  nrs=0.69047619047619 sa=0 sb=0 sd=0 mult=1 m=1
csn_op1_0900_s1_w3_0 sn_op1_0900_s1_w3_0 0 {C_SN}
XMWR_op1_0900_s1_w3_1 sn_op1_0900_s1_w3_1 wwl_des wbl_op1_0900_s1_w3 0 sky130_fd_pr__nfet_01v8 L=0.15 W=0.42 nf=1 ad=0.1218 as=0.1218 pd=1.42 ps=1.42 nrd=0.69047619047619  nrs=0.69047619047619 sa=0 sb=0 sd=0 mult=1 m=1
XMRD_op1_0900_s1_w3_1 rbl_op1_0900_s1_w3 sn_op1_0900_s1_w3_1 rwl_des 0 sky130_fd_pr__nfet_01v8 L=0.15 W=0.42 nf=1 ad=0.1218 as=0.1218 pd=1.42 ps=1.42 nrd=0.69047619047619  nrs=0.69047619047619 sa=0 sb=0 sd=0 mult=1 m=1
csn_op1_0900_s1_w3_1 sn_op1_0900_s1_w3_1 0 {C_SN}
XMWR_op1_0900_s1_w3_2 sn_op1_0900_s1_w3_2 wwl_des wbl_op1_0900_s1_w3 0 sky130_fd_pr__nfet_01v8 L=0.15 W=0.42 nf=1 ad=0.1218 as=0.1218 pd=1.42 ps=1.42 nrd=0.69047619047619  nrs=0.69047619047619 sa=0 sb=0 sd=0 mult=1 m=1
XMRD_op1_0900_s1_w3_2 rbl_op1_0900_s1_w3 sn_op1_0900_s1_w3_2 rwl_des 0 sky130_fd_pr__nfet_01v8 L=0.15 W=0.42 nf=1 ad=0.1218 as=0.1218 pd=1.42 ps=1.42 nrd=0.69047619047619  nrs=0.69047619047619 sa=0 sb=0 sd=0 mult=1 m=1
csn_op1_0900_s1_w3_2 sn_op1_0900_s1_w3_2 0 {C_SN}
XMWR_op1_0900_s1_w3_3 sn_op1_0900_s1_w3_3 wwl_des wbl_op1_0900_s1_w3 0 sky130_fd_pr__nfet_01v8 L=0.15 W=0.42 nf=1 ad=0.1218 as=0.1218 pd=1.42 ps=1.42 nrd=0.69047619047619  nrs=0.69047619047619 sa=0 sb=0 sd=0 mult=1 m=1
XMRD_op1_0900_s1_w3_3 rbl_op1_0900_s1_w3 sn_op1_0900_s1_w3_3 rwl_des 0 sky130_fd_pr__nfet_01v8 L=0.15 W=0.42 nf=1 ad=0.1218 as=0.1218 pd=1.42 ps=1.42 nrd=0.69047619047619  nrs=0.69047619047619 sa=0 sb=0 sd=0 mult=1 m=1
csn_op1_0900_s1_w3_3 sn_op1_0900_s1_w3_3 0 {C_SN}
XMN1_op1_0900_s1_w3 rbl_op1_0900_s1_w3 ref_op1_0900_s1_w3 vn_op1_0900_s1_w3 0 sky130_fd_pr__nfet_01v8 L=0.15 W=1 nf=1 ad=0.29 as=0.29 pd=2.58 ps=2.58 mult=1 m=1
XMN2_op1_0900_s1_w3 ref_op1_0900_s1_w3 rbl_op1_0900_s1_w3 vn_op1_0900_s1_w3 0 sky130_fd_pr__nfet_01v8 L=0.15 W=1 nf=1 ad=0.29 as=0.29 pd=2.58 ps=2.58 mult=1 m=1
XMP1_op1_0900_s1_w3 rbl_op1_0900_s1_w3 ref_op1_0900_s1_w3 vp_op1_0900_s1_w3 vdd sky130_fd_pr__pfet_01v8 L=0.15 W=2 nf=1 ad=0.58 as=0.58 pd=4.58 ps=4.58 mult=1 m=1
XMP2_op1_0900_s1_w3 ref_op1_0900_s1_w3 rbl_op1_0900_s1_w3 vp_op1_0900_s1_w3 vdd sky130_fd_pr__pfet_01v8 L=0.15 W=2 nf=1 ad=0.58 as=0.58 pd=4.58 ps=4.58 mult=1 m=1
XMNF_op1_0900_s1_w3 vn_op1_0900_s1_w3 en_op1_0900_s1_w3 0 0 sky130_fd_pr__nfet_01v8 L=0.15 W=2 nf=1 ad=0.58 as=0.58 pd=4.58 ps=4.58 mult=1 m=1
XMPH_op1_0900_s1_w3 vp_op1_0900_s1_w3 enb_op1_0900_s1_w3 vdd vdd sky130_fd_pr__pfet_01v8 L=0.15 W=4 nf=1 ad=1.16 as=1.16 pd=8.58 ps=8.58 mult=1 m=1
bd_op1_0900_s1_w3 d_op1_0900_s1_w3 0 v=v(rbl_op1_0900_s1_w3)-v(ref_op1_0900_s1_w3)

* ---- instance 17: op1_0900_s1_w5 (t_en 5 ns, WWL 6..11 ns, release 13 ns) ----
ven_op1_0900_s1_w5  en_op1_0900_s1_w5  0 pwl(0 0 5.0000e-09 0 5.1000e-09 {VDD} 1.3000e-08 {VDD} 1.3100e-08 0)
venb_op1_0900_s1_w5 enb_op1_0900_s1_w5 0 pwl(0 {VDD} 5.0000e-09 {VDD} 5.1000e-09 0 1.3000e-08 0 1.3100e-08 {VDD})
vrs_op1_0900_s1_w5  rwls_op1_0900_s1_w5 0 pwl(0 {VDD} {T_READ} {VDD} {T_READ+TEDGE} 0 1.3000e-08 0 1.3100e-08 {VDD})
vww_op1_0900_s1_w5  wwl_op1_0900_s1_w5 0 pwl(0 0 6.0000e-09 0 6.1000e-09 {VDD} 1.1000e-08 {VDD} 1.1100e-08 0)
vwc_op1_0900_s1_w5  wbc_op1_0900_s1_w5 0 pwl(0 0 6.0000e-09 0 6.1000e-09 {VDD} 1.3000e-08 {VDD} 1.3100e-08 0)
swb_op1_0900_s1_w5 ref_op1_0900_s1_w5 wbl_op1_0900_s1_w5 wbc_op1_0900_s1_w5 0 swwbl
cwbl_op1_0900_s1_w5 wbl_op1_0900_s1_w5 0 {C_WBL}
spa_op1_0900_s1_w5 prea rbl_op1_0900_s1_w5 ctl 0 swpre
spr_op1_0900_s1_w5 pref ref_op1_0900_s1_w5 ctl 0 swpre
crbl_op1_0900_s1_w5 rbl_op1_0900_s1_w5 0 {C_RBL}
cref_op1_0900_s1_w5 ref_op1_0900_s1_w5 0 {C_RBL}   $ ASSUMPTION: ideal matched dummy load
XMWR_op1_0900_s1_w5_0 sn_op1_0900_s1_w5_0 wwl_op1_0900_s1_w5 wbl_op1_0900_s1_w5 0 sky130_fd_pr__nfet_01v8 L=0.15 W=0.42 nf=1 ad=0.1218 as=0.1218 pd=1.42 ps=1.42 nrd=0.69047619047619  nrs=0.69047619047619 sa=0 sb=0 sd=0 mult=1 m=1
XMRD_op1_0900_s1_w5_0 rbl_op1_0900_s1_w5 sn_op1_0900_s1_w5_0 rwls_op1_0900_s1_w5 0 sky130_fd_pr__nfet_01v8 L=0.15 W=0.42 nf=1 ad=0.1218 as=0.1218 pd=1.42 ps=1.42 nrd=0.69047619047619  nrs=0.69047619047619 sa=0 sb=0 sd=0 mult=1 m=1
csn_op1_0900_s1_w5_0 sn_op1_0900_s1_w5_0 0 {C_SN}
XMWR_op1_0900_s1_w5_1 sn_op1_0900_s1_w5_1 wwl_des wbl_op1_0900_s1_w5 0 sky130_fd_pr__nfet_01v8 L=0.15 W=0.42 nf=1 ad=0.1218 as=0.1218 pd=1.42 ps=1.42 nrd=0.69047619047619  nrs=0.69047619047619 sa=0 sb=0 sd=0 mult=1 m=1
XMRD_op1_0900_s1_w5_1 rbl_op1_0900_s1_w5 sn_op1_0900_s1_w5_1 rwl_des 0 sky130_fd_pr__nfet_01v8 L=0.15 W=0.42 nf=1 ad=0.1218 as=0.1218 pd=1.42 ps=1.42 nrd=0.69047619047619  nrs=0.69047619047619 sa=0 sb=0 sd=0 mult=1 m=1
csn_op1_0900_s1_w5_1 sn_op1_0900_s1_w5_1 0 {C_SN}
XMWR_op1_0900_s1_w5_2 sn_op1_0900_s1_w5_2 wwl_des wbl_op1_0900_s1_w5 0 sky130_fd_pr__nfet_01v8 L=0.15 W=0.42 nf=1 ad=0.1218 as=0.1218 pd=1.42 ps=1.42 nrd=0.69047619047619  nrs=0.69047619047619 sa=0 sb=0 sd=0 mult=1 m=1
XMRD_op1_0900_s1_w5_2 rbl_op1_0900_s1_w5 sn_op1_0900_s1_w5_2 rwl_des 0 sky130_fd_pr__nfet_01v8 L=0.15 W=0.42 nf=1 ad=0.1218 as=0.1218 pd=1.42 ps=1.42 nrd=0.69047619047619  nrs=0.69047619047619 sa=0 sb=0 sd=0 mult=1 m=1
csn_op1_0900_s1_w5_2 sn_op1_0900_s1_w5_2 0 {C_SN}
XMWR_op1_0900_s1_w5_3 sn_op1_0900_s1_w5_3 wwl_des wbl_op1_0900_s1_w5 0 sky130_fd_pr__nfet_01v8 L=0.15 W=0.42 nf=1 ad=0.1218 as=0.1218 pd=1.42 ps=1.42 nrd=0.69047619047619  nrs=0.69047619047619 sa=0 sb=0 sd=0 mult=1 m=1
XMRD_op1_0900_s1_w5_3 rbl_op1_0900_s1_w5 sn_op1_0900_s1_w5_3 rwl_des 0 sky130_fd_pr__nfet_01v8 L=0.15 W=0.42 nf=1 ad=0.1218 as=0.1218 pd=1.42 ps=1.42 nrd=0.69047619047619  nrs=0.69047619047619 sa=0 sb=0 sd=0 mult=1 m=1
csn_op1_0900_s1_w5_3 sn_op1_0900_s1_w5_3 0 {C_SN}
XMN1_op1_0900_s1_w5 rbl_op1_0900_s1_w5 ref_op1_0900_s1_w5 vn_op1_0900_s1_w5 0 sky130_fd_pr__nfet_01v8 L=0.15 W=1 nf=1 ad=0.29 as=0.29 pd=2.58 ps=2.58 mult=1 m=1
XMN2_op1_0900_s1_w5 ref_op1_0900_s1_w5 rbl_op1_0900_s1_w5 vn_op1_0900_s1_w5 0 sky130_fd_pr__nfet_01v8 L=0.15 W=1 nf=1 ad=0.29 as=0.29 pd=2.58 ps=2.58 mult=1 m=1
XMP1_op1_0900_s1_w5 rbl_op1_0900_s1_w5 ref_op1_0900_s1_w5 vp_op1_0900_s1_w5 vdd sky130_fd_pr__pfet_01v8 L=0.15 W=2 nf=1 ad=0.58 as=0.58 pd=4.58 ps=4.58 mult=1 m=1
XMP2_op1_0900_s1_w5 ref_op1_0900_s1_w5 rbl_op1_0900_s1_w5 vp_op1_0900_s1_w5 vdd sky130_fd_pr__pfet_01v8 L=0.15 W=2 nf=1 ad=0.58 as=0.58 pd=4.58 ps=4.58 mult=1 m=1
XMNF_op1_0900_s1_w5 vn_op1_0900_s1_w5 en_op1_0900_s1_w5 0 0 sky130_fd_pr__nfet_01v8 L=0.15 W=2 nf=1 ad=0.58 as=0.58 pd=4.58 ps=4.58 mult=1 m=1
XMPH_op1_0900_s1_w5 vp_op1_0900_s1_w5 enb_op1_0900_s1_w5 vdd vdd sky130_fd_pr__pfet_01v8 L=0.15 W=4 nf=1 ad=1.16 as=1.16 pd=8.58 ps=8.58 mult=1 m=1
bd_op1_0900_s1_w5 d_op1_0900_s1_w5 0 v=v(rbl_op1_0900_s1_w5)-v(ref_op1_0900_s1_w5)

* ---- instance 18: op1_0900_s1_w7p5 (t_en 5 ns, WWL 6..13.5 ns, release 15.5 ns) ----
ven_op1_0900_s1_w7p5  en_op1_0900_s1_w7p5  0 pwl(0 0 5.0000e-09 0 5.1000e-09 {VDD} 1.5500e-08 {VDD} 1.5600e-08 0)
venb_op1_0900_s1_w7p5 enb_op1_0900_s1_w7p5 0 pwl(0 {VDD} 5.0000e-09 {VDD} 5.1000e-09 0 1.5500e-08 0 1.5600e-08 {VDD})
vrs_op1_0900_s1_w7p5  rwls_op1_0900_s1_w7p5 0 pwl(0 {VDD} {T_READ} {VDD} {T_READ+TEDGE} 0 1.5500e-08 0 1.5600e-08 {VDD})
vww_op1_0900_s1_w7p5  wwl_op1_0900_s1_w7p5 0 pwl(0 0 6.0000e-09 0 6.1000e-09 {VDD} 1.3500e-08 {VDD} 1.3600e-08 0)
vwc_op1_0900_s1_w7p5  wbc_op1_0900_s1_w7p5 0 pwl(0 0 6.0000e-09 0 6.1000e-09 {VDD} 1.5500e-08 {VDD} 1.5600e-08 0)
swb_op1_0900_s1_w7p5 ref_op1_0900_s1_w7p5 wbl_op1_0900_s1_w7p5 wbc_op1_0900_s1_w7p5 0 swwbl
cwbl_op1_0900_s1_w7p5 wbl_op1_0900_s1_w7p5 0 {C_WBL}
spa_op1_0900_s1_w7p5 prea rbl_op1_0900_s1_w7p5 ctl 0 swpre
spr_op1_0900_s1_w7p5 pref ref_op1_0900_s1_w7p5 ctl 0 swpre
crbl_op1_0900_s1_w7p5 rbl_op1_0900_s1_w7p5 0 {C_RBL}
cref_op1_0900_s1_w7p5 ref_op1_0900_s1_w7p5 0 {C_RBL}   $ ASSUMPTION: ideal matched dummy load
XMWR_op1_0900_s1_w7p5_0 sn_op1_0900_s1_w7p5_0 wwl_op1_0900_s1_w7p5 wbl_op1_0900_s1_w7p5 0 sky130_fd_pr__nfet_01v8 L=0.15 W=0.42 nf=1 ad=0.1218 as=0.1218 pd=1.42 ps=1.42 nrd=0.69047619047619  nrs=0.69047619047619 sa=0 sb=0 sd=0 mult=1 m=1
XMRD_op1_0900_s1_w7p5_0 rbl_op1_0900_s1_w7p5 sn_op1_0900_s1_w7p5_0 rwls_op1_0900_s1_w7p5 0 sky130_fd_pr__nfet_01v8 L=0.15 W=0.42 nf=1 ad=0.1218 as=0.1218 pd=1.42 ps=1.42 nrd=0.69047619047619  nrs=0.69047619047619 sa=0 sb=0 sd=0 mult=1 m=1
csn_op1_0900_s1_w7p5_0 sn_op1_0900_s1_w7p5_0 0 {C_SN}
XMWR_op1_0900_s1_w7p5_1 sn_op1_0900_s1_w7p5_1 wwl_des wbl_op1_0900_s1_w7p5 0 sky130_fd_pr__nfet_01v8 L=0.15 W=0.42 nf=1 ad=0.1218 as=0.1218 pd=1.42 ps=1.42 nrd=0.69047619047619  nrs=0.69047619047619 sa=0 sb=0 sd=0 mult=1 m=1
XMRD_op1_0900_s1_w7p5_1 rbl_op1_0900_s1_w7p5 sn_op1_0900_s1_w7p5_1 rwl_des 0 sky130_fd_pr__nfet_01v8 L=0.15 W=0.42 nf=1 ad=0.1218 as=0.1218 pd=1.42 ps=1.42 nrd=0.69047619047619  nrs=0.69047619047619 sa=0 sb=0 sd=0 mult=1 m=1
csn_op1_0900_s1_w7p5_1 sn_op1_0900_s1_w7p5_1 0 {C_SN}
XMWR_op1_0900_s1_w7p5_2 sn_op1_0900_s1_w7p5_2 wwl_des wbl_op1_0900_s1_w7p5 0 sky130_fd_pr__nfet_01v8 L=0.15 W=0.42 nf=1 ad=0.1218 as=0.1218 pd=1.42 ps=1.42 nrd=0.69047619047619  nrs=0.69047619047619 sa=0 sb=0 sd=0 mult=1 m=1
XMRD_op1_0900_s1_w7p5_2 rbl_op1_0900_s1_w7p5 sn_op1_0900_s1_w7p5_2 rwl_des 0 sky130_fd_pr__nfet_01v8 L=0.15 W=0.42 nf=1 ad=0.1218 as=0.1218 pd=1.42 ps=1.42 nrd=0.69047619047619  nrs=0.69047619047619 sa=0 sb=0 sd=0 mult=1 m=1
csn_op1_0900_s1_w7p5_2 sn_op1_0900_s1_w7p5_2 0 {C_SN}
XMWR_op1_0900_s1_w7p5_3 sn_op1_0900_s1_w7p5_3 wwl_des wbl_op1_0900_s1_w7p5 0 sky130_fd_pr__nfet_01v8 L=0.15 W=0.42 nf=1 ad=0.1218 as=0.1218 pd=1.42 ps=1.42 nrd=0.69047619047619  nrs=0.69047619047619 sa=0 sb=0 sd=0 mult=1 m=1
XMRD_op1_0900_s1_w7p5_3 rbl_op1_0900_s1_w7p5 sn_op1_0900_s1_w7p5_3 rwl_des 0 sky130_fd_pr__nfet_01v8 L=0.15 W=0.42 nf=1 ad=0.1218 as=0.1218 pd=1.42 ps=1.42 nrd=0.69047619047619  nrs=0.69047619047619 sa=0 sb=0 sd=0 mult=1 m=1
csn_op1_0900_s1_w7p5_3 sn_op1_0900_s1_w7p5_3 0 {C_SN}
XMN1_op1_0900_s1_w7p5 rbl_op1_0900_s1_w7p5 ref_op1_0900_s1_w7p5 vn_op1_0900_s1_w7p5 0 sky130_fd_pr__nfet_01v8 L=0.15 W=1 nf=1 ad=0.29 as=0.29 pd=2.58 ps=2.58 mult=1 m=1
XMN2_op1_0900_s1_w7p5 ref_op1_0900_s1_w7p5 rbl_op1_0900_s1_w7p5 vn_op1_0900_s1_w7p5 0 sky130_fd_pr__nfet_01v8 L=0.15 W=1 nf=1 ad=0.29 as=0.29 pd=2.58 ps=2.58 mult=1 m=1
XMP1_op1_0900_s1_w7p5 rbl_op1_0900_s1_w7p5 ref_op1_0900_s1_w7p5 vp_op1_0900_s1_w7p5 vdd sky130_fd_pr__pfet_01v8 L=0.15 W=2 nf=1 ad=0.58 as=0.58 pd=4.58 ps=4.58 mult=1 m=1
XMP2_op1_0900_s1_w7p5 ref_op1_0900_s1_w7p5 rbl_op1_0900_s1_w7p5 vp_op1_0900_s1_w7p5 vdd sky130_fd_pr__pfet_01v8 L=0.15 W=2 nf=1 ad=0.58 as=0.58 pd=4.58 ps=4.58 mult=1 m=1
XMNF_op1_0900_s1_w7p5 vn_op1_0900_s1_w7p5 en_op1_0900_s1_w7p5 0 0 sky130_fd_pr__nfet_01v8 L=0.15 W=2 nf=1 ad=0.58 as=0.58 pd=4.58 ps=4.58 mult=1 m=1
XMPH_op1_0900_s1_w7p5 vp_op1_0900_s1_w7p5 enb_op1_0900_s1_w7p5 vdd vdd sky130_fd_pr__pfet_01v8 L=0.15 W=4 nf=1 ad=1.16 as=1.16 pd=8.58 ps=8.58 mult=1 m=1
bd_op1_0900_s1_w7p5 d_op1_0900_s1_w7p5 0 v=v(rbl_op1_0900_s1_w7p5)-v(ref_op1_0900_s1_w7p5)

* ---- instance 19: op1_0900_s1_w10 (t_en 5 ns, WWL 6..16 ns, release 18 ns) ----
ven_op1_0900_s1_w10  en_op1_0900_s1_w10  0 pwl(0 0 5.0000e-09 0 5.1000e-09 {VDD} 1.8000e-08 {VDD} 1.8100e-08 0)
venb_op1_0900_s1_w10 enb_op1_0900_s1_w10 0 pwl(0 {VDD} 5.0000e-09 {VDD} 5.1000e-09 0 1.8000e-08 0 1.8100e-08 {VDD})
vrs_op1_0900_s1_w10  rwls_op1_0900_s1_w10 0 pwl(0 {VDD} {T_READ} {VDD} {T_READ+TEDGE} 0 1.8000e-08 0 1.8100e-08 {VDD})
vww_op1_0900_s1_w10  wwl_op1_0900_s1_w10 0 pwl(0 0 6.0000e-09 0 6.1000e-09 {VDD} 1.6000e-08 {VDD} 1.6100e-08 0)
vwc_op1_0900_s1_w10  wbc_op1_0900_s1_w10 0 pwl(0 0 6.0000e-09 0 6.1000e-09 {VDD} 1.8000e-08 {VDD} 1.8100e-08 0)
swb_op1_0900_s1_w10 ref_op1_0900_s1_w10 wbl_op1_0900_s1_w10 wbc_op1_0900_s1_w10 0 swwbl
cwbl_op1_0900_s1_w10 wbl_op1_0900_s1_w10 0 {C_WBL}
spa_op1_0900_s1_w10 prea rbl_op1_0900_s1_w10 ctl 0 swpre
spr_op1_0900_s1_w10 pref ref_op1_0900_s1_w10 ctl 0 swpre
crbl_op1_0900_s1_w10 rbl_op1_0900_s1_w10 0 {C_RBL}
cref_op1_0900_s1_w10 ref_op1_0900_s1_w10 0 {C_RBL}   $ ASSUMPTION: ideal matched dummy load
XMWR_op1_0900_s1_w10_0 sn_op1_0900_s1_w10_0 wwl_op1_0900_s1_w10 wbl_op1_0900_s1_w10 0 sky130_fd_pr__nfet_01v8 L=0.15 W=0.42 nf=1 ad=0.1218 as=0.1218 pd=1.42 ps=1.42 nrd=0.69047619047619  nrs=0.69047619047619 sa=0 sb=0 sd=0 mult=1 m=1
XMRD_op1_0900_s1_w10_0 rbl_op1_0900_s1_w10 sn_op1_0900_s1_w10_0 rwls_op1_0900_s1_w10 0 sky130_fd_pr__nfet_01v8 L=0.15 W=0.42 nf=1 ad=0.1218 as=0.1218 pd=1.42 ps=1.42 nrd=0.69047619047619  nrs=0.69047619047619 sa=0 sb=0 sd=0 mult=1 m=1
csn_op1_0900_s1_w10_0 sn_op1_0900_s1_w10_0 0 {C_SN}
XMWR_op1_0900_s1_w10_1 sn_op1_0900_s1_w10_1 wwl_des wbl_op1_0900_s1_w10 0 sky130_fd_pr__nfet_01v8 L=0.15 W=0.42 nf=1 ad=0.1218 as=0.1218 pd=1.42 ps=1.42 nrd=0.69047619047619  nrs=0.69047619047619 sa=0 sb=0 sd=0 mult=1 m=1
XMRD_op1_0900_s1_w10_1 rbl_op1_0900_s1_w10 sn_op1_0900_s1_w10_1 rwl_des 0 sky130_fd_pr__nfet_01v8 L=0.15 W=0.42 nf=1 ad=0.1218 as=0.1218 pd=1.42 ps=1.42 nrd=0.69047619047619  nrs=0.69047619047619 sa=0 sb=0 sd=0 mult=1 m=1
csn_op1_0900_s1_w10_1 sn_op1_0900_s1_w10_1 0 {C_SN}
XMWR_op1_0900_s1_w10_2 sn_op1_0900_s1_w10_2 wwl_des wbl_op1_0900_s1_w10 0 sky130_fd_pr__nfet_01v8 L=0.15 W=0.42 nf=1 ad=0.1218 as=0.1218 pd=1.42 ps=1.42 nrd=0.69047619047619  nrs=0.69047619047619 sa=0 sb=0 sd=0 mult=1 m=1
XMRD_op1_0900_s1_w10_2 rbl_op1_0900_s1_w10 sn_op1_0900_s1_w10_2 rwl_des 0 sky130_fd_pr__nfet_01v8 L=0.15 W=0.42 nf=1 ad=0.1218 as=0.1218 pd=1.42 ps=1.42 nrd=0.69047619047619  nrs=0.69047619047619 sa=0 sb=0 sd=0 mult=1 m=1
csn_op1_0900_s1_w10_2 sn_op1_0900_s1_w10_2 0 {C_SN}
XMWR_op1_0900_s1_w10_3 sn_op1_0900_s1_w10_3 wwl_des wbl_op1_0900_s1_w10 0 sky130_fd_pr__nfet_01v8 L=0.15 W=0.42 nf=1 ad=0.1218 as=0.1218 pd=1.42 ps=1.42 nrd=0.69047619047619  nrs=0.69047619047619 sa=0 sb=0 sd=0 mult=1 m=1
XMRD_op1_0900_s1_w10_3 rbl_op1_0900_s1_w10 sn_op1_0900_s1_w10_3 rwl_des 0 sky130_fd_pr__nfet_01v8 L=0.15 W=0.42 nf=1 ad=0.1218 as=0.1218 pd=1.42 ps=1.42 nrd=0.69047619047619  nrs=0.69047619047619 sa=0 sb=0 sd=0 mult=1 m=1
csn_op1_0900_s1_w10_3 sn_op1_0900_s1_w10_3 0 {C_SN}
XMN1_op1_0900_s1_w10 rbl_op1_0900_s1_w10 ref_op1_0900_s1_w10 vn_op1_0900_s1_w10 0 sky130_fd_pr__nfet_01v8 L=0.15 W=1 nf=1 ad=0.29 as=0.29 pd=2.58 ps=2.58 mult=1 m=1
XMN2_op1_0900_s1_w10 ref_op1_0900_s1_w10 rbl_op1_0900_s1_w10 vn_op1_0900_s1_w10 0 sky130_fd_pr__nfet_01v8 L=0.15 W=1 nf=1 ad=0.29 as=0.29 pd=2.58 ps=2.58 mult=1 m=1
XMP1_op1_0900_s1_w10 rbl_op1_0900_s1_w10 ref_op1_0900_s1_w10 vp_op1_0900_s1_w10 vdd sky130_fd_pr__pfet_01v8 L=0.15 W=2 nf=1 ad=0.58 as=0.58 pd=4.58 ps=4.58 mult=1 m=1
XMP2_op1_0900_s1_w10 ref_op1_0900_s1_w10 rbl_op1_0900_s1_w10 vp_op1_0900_s1_w10 vdd sky130_fd_pr__pfet_01v8 L=0.15 W=2 nf=1 ad=0.58 as=0.58 pd=4.58 ps=4.58 mult=1 m=1
XMNF_op1_0900_s1_w10 vn_op1_0900_s1_w10 en_op1_0900_s1_w10 0 0 sky130_fd_pr__nfet_01v8 L=0.15 W=2 nf=1 ad=0.58 as=0.58 pd=4.58 ps=4.58 mult=1 m=1
XMPH_op1_0900_s1_w10 vp_op1_0900_s1_w10 enb_op1_0900_s1_w10 vdd vdd sky130_fd_pr__pfet_01v8 L=0.15 W=4 nf=1 ad=1.16 as=1.16 pd=8.58 ps=8.58 mult=1 m=1
bd_op1_0900_s1_w10 d_op1_0900_s1_w10 0 v=v(rbl_op1_0900_s1_w10)-v(ref_op1_0900_s1_w10)

* ---- instance 20: op1_0900_s1_w15 (t_en 5 ns, WWL 6..21 ns, release 23 ns) ----
ven_op1_0900_s1_w15  en_op1_0900_s1_w15  0 pwl(0 0 5.0000e-09 0 5.1000e-09 {VDD} 2.3000e-08 {VDD} 2.3100e-08 0)
venb_op1_0900_s1_w15 enb_op1_0900_s1_w15 0 pwl(0 {VDD} 5.0000e-09 {VDD} 5.1000e-09 0 2.3000e-08 0 2.3100e-08 {VDD})
vrs_op1_0900_s1_w15  rwls_op1_0900_s1_w15 0 pwl(0 {VDD} {T_READ} {VDD} {T_READ+TEDGE} 0 2.3000e-08 0 2.3100e-08 {VDD})
vww_op1_0900_s1_w15  wwl_op1_0900_s1_w15 0 pwl(0 0 6.0000e-09 0 6.1000e-09 {VDD} 2.1000e-08 {VDD} 2.1100e-08 0)
vwc_op1_0900_s1_w15  wbc_op1_0900_s1_w15 0 pwl(0 0 6.0000e-09 0 6.1000e-09 {VDD} 2.3000e-08 {VDD} 2.3100e-08 0)
swb_op1_0900_s1_w15 ref_op1_0900_s1_w15 wbl_op1_0900_s1_w15 wbc_op1_0900_s1_w15 0 swwbl
cwbl_op1_0900_s1_w15 wbl_op1_0900_s1_w15 0 {C_WBL}
spa_op1_0900_s1_w15 prea rbl_op1_0900_s1_w15 ctl 0 swpre
spr_op1_0900_s1_w15 pref ref_op1_0900_s1_w15 ctl 0 swpre
crbl_op1_0900_s1_w15 rbl_op1_0900_s1_w15 0 {C_RBL}
cref_op1_0900_s1_w15 ref_op1_0900_s1_w15 0 {C_RBL}   $ ASSUMPTION: ideal matched dummy load
XMWR_op1_0900_s1_w15_0 sn_op1_0900_s1_w15_0 wwl_op1_0900_s1_w15 wbl_op1_0900_s1_w15 0 sky130_fd_pr__nfet_01v8 L=0.15 W=0.42 nf=1 ad=0.1218 as=0.1218 pd=1.42 ps=1.42 nrd=0.69047619047619  nrs=0.69047619047619 sa=0 sb=0 sd=0 mult=1 m=1
XMRD_op1_0900_s1_w15_0 rbl_op1_0900_s1_w15 sn_op1_0900_s1_w15_0 rwls_op1_0900_s1_w15 0 sky130_fd_pr__nfet_01v8 L=0.15 W=0.42 nf=1 ad=0.1218 as=0.1218 pd=1.42 ps=1.42 nrd=0.69047619047619  nrs=0.69047619047619 sa=0 sb=0 sd=0 mult=1 m=1
csn_op1_0900_s1_w15_0 sn_op1_0900_s1_w15_0 0 {C_SN}
XMWR_op1_0900_s1_w15_1 sn_op1_0900_s1_w15_1 wwl_des wbl_op1_0900_s1_w15 0 sky130_fd_pr__nfet_01v8 L=0.15 W=0.42 nf=1 ad=0.1218 as=0.1218 pd=1.42 ps=1.42 nrd=0.69047619047619  nrs=0.69047619047619 sa=0 sb=0 sd=0 mult=1 m=1
XMRD_op1_0900_s1_w15_1 rbl_op1_0900_s1_w15 sn_op1_0900_s1_w15_1 rwl_des 0 sky130_fd_pr__nfet_01v8 L=0.15 W=0.42 nf=1 ad=0.1218 as=0.1218 pd=1.42 ps=1.42 nrd=0.69047619047619  nrs=0.69047619047619 sa=0 sb=0 sd=0 mult=1 m=1
csn_op1_0900_s1_w15_1 sn_op1_0900_s1_w15_1 0 {C_SN}
XMWR_op1_0900_s1_w15_2 sn_op1_0900_s1_w15_2 wwl_des wbl_op1_0900_s1_w15 0 sky130_fd_pr__nfet_01v8 L=0.15 W=0.42 nf=1 ad=0.1218 as=0.1218 pd=1.42 ps=1.42 nrd=0.69047619047619  nrs=0.69047619047619 sa=0 sb=0 sd=0 mult=1 m=1
XMRD_op1_0900_s1_w15_2 rbl_op1_0900_s1_w15 sn_op1_0900_s1_w15_2 rwl_des 0 sky130_fd_pr__nfet_01v8 L=0.15 W=0.42 nf=1 ad=0.1218 as=0.1218 pd=1.42 ps=1.42 nrd=0.69047619047619  nrs=0.69047619047619 sa=0 sb=0 sd=0 mult=1 m=1
csn_op1_0900_s1_w15_2 sn_op1_0900_s1_w15_2 0 {C_SN}
XMWR_op1_0900_s1_w15_3 sn_op1_0900_s1_w15_3 wwl_des wbl_op1_0900_s1_w15 0 sky130_fd_pr__nfet_01v8 L=0.15 W=0.42 nf=1 ad=0.1218 as=0.1218 pd=1.42 ps=1.42 nrd=0.69047619047619  nrs=0.69047619047619 sa=0 sb=0 sd=0 mult=1 m=1
XMRD_op1_0900_s1_w15_3 rbl_op1_0900_s1_w15 sn_op1_0900_s1_w15_3 rwl_des 0 sky130_fd_pr__nfet_01v8 L=0.15 W=0.42 nf=1 ad=0.1218 as=0.1218 pd=1.42 ps=1.42 nrd=0.69047619047619  nrs=0.69047619047619 sa=0 sb=0 sd=0 mult=1 m=1
csn_op1_0900_s1_w15_3 sn_op1_0900_s1_w15_3 0 {C_SN}
XMN1_op1_0900_s1_w15 rbl_op1_0900_s1_w15 ref_op1_0900_s1_w15 vn_op1_0900_s1_w15 0 sky130_fd_pr__nfet_01v8 L=0.15 W=1 nf=1 ad=0.29 as=0.29 pd=2.58 ps=2.58 mult=1 m=1
XMN2_op1_0900_s1_w15 ref_op1_0900_s1_w15 rbl_op1_0900_s1_w15 vn_op1_0900_s1_w15 0 sky130_fd_pr__nfet_01v8 L=0.15 W=1 nf=1 ad=0.29 as=0.29 pd=2.58 ps=2.58 mult=1 m=1
XMP1_op1_0900_s1_w15 rbl_op1_0900_s1_w15 ref_op1_0900_s1_w15 vp_op1_0900_s1_w15 vdd sky130_fd_pr__pfet_01v8 L=0.15 W=2 nf=1 ad=0.58 as=0.58 pd=4.58 ps=4.58 mult=1 m=1
XMP2_op1_0900_s1_w15 ref_op1_0900_s1_w15 rbl_op1_0900_s1_w15 vp_op1_0900_s1_w15 vdd sky130_fd_pr__pfet_01v8 L=0.15 W=2 nf=1 ad=0.58 as=0.58 pd=4.58 ps=4.58 mult=1 m=1
XMNF_op1_0900_s1_w15 vn_op1_0900_s1_w15 en_op1_0900_s1_w15 0 0 sky130_fd_pr__nfet_01v8 L=0.15 W=2 nf=1 ad=0.58 as=0.58 pd=4.58 ps=4.58 mult=1 m=1
XMPH_op1_0900_s1_w15 vp_op1_0900_s1_w15 enb_op1_0900_s1_w15 vdd vdd sky130_fd_pr__pfet_01v8 L=0.15 W=4 nf=1 ad=1.16 as=1.16 pd=8.58 ps=8.58 mult=1 m=1
bd_op1_0900_s1_w15 d_op1_0900_s1_w15 0 v=v(rbl_op1_0900_s1_w15)-v(ref_op1_0900_s1_w15)

* ---- instance 21: op1_0900_s1_w20 (t_en 5 ns, WWL 6..26 ns, release 28 ns) ----
ven_op1_0900_s1_w20  en_op1_0900_s1_w20  0 pwl(0 0 5.0000e-09 0 5.1000e-09 {VDD} 2.8000e-08 {VDD} 2.8100e-08 0)
venb_op1_0900_s1_w20 enb_op1_0900_s1_w20 0 pwl(0 {VDD} 5.0000e-09 {VDD} 5.1000e-09 0 2.8000e-08 0 2.8100e-08 {VDD})
vrs_op1_0900_s1_w20  rwls_op1_0900_s1_w20 0 pwl(0 {VDD} {T_READ} {VDD} {T_READ+TEDGE} 0 2.8000e-08 0 2.8100e-08 {VDD})
vww_op1_0900_s1_w20  wwl_op1_0900_s1_w20 0 pwl(0 0 6.0000e-09 0 6.1000e-09 {VDD} 2.6000e-08 {VDD} 2.6100e-08 0)
vwc_op1_0900_s1_w20  wbc_op1_0900_s1_w20 0 pwl(0 0 6.0000e-09 0 6.1000e-09 {VDD} 2.8000e-08 {VDD} 2.8100e-08 0)
swb_op1_0900_s1_w20 ref_op1_0900_s1_w20 wbl_op1_0900_s1_w20 wbc_op1_0900_s1_w20 0 swwbl
cwbl_op1_0900_s1_w20 wbl_op1_0900_s1_w20 0 {C_WBL}
spa_op1_0900_s1_w20 prea rbl_op1_0900_s1_w20 ctl 0 swpre
spr_op1_0900_s1_w20 pref ref_op1_0900_s1_w20 ctl 0 swpre
crbl_op1_0900_s1_w20 rbl_op1_0900_s1_w20 0 {C_RBL}
cref_op1_0900_s1_w20 ref_op1_0900_s1_w20 0 {C_RBL}   $ ASSUMPTION: ideal matched dummy load
XMWR_op1_0900_s1_w20_0 sn_op1_0900_s1_w20_0 wwl_op1_0900_s1_w20 wbl_op1_0900_s1_w20 0 sky130_fd_pr__nfet_01v8 L=0.15 W=0.42 nf=1 ad=0.1218 as=0.1218 pd=1.42 ps=1.42 nrd=0.69047619047619  nrs=0.69047619047619 sa=0 sb=0 sd=0 mult=1 m=1
XMRD_op1_0900_s1_w20_0 rbl_op1_0900_s1_w20 sn_op1_0900_s1_w20_0 rwls_op1_0900_s1_w20 0 sky130_fd_pr__nfet_01v8 L=0.15 W=0.42 nf=1 ad=0.1218 as=0.1218 pd=1.42 ps=1.42 nrd=0.69047619047619  nrs=0.69047619047619 sa=0 sb=0 sd=0 mult=1 m=1
csn_op1_0900_s1_w20_0 sn_op1_0900_s1_w20_0 0 {C_SN}
XMWR_op1_0900_s1_w20_1 sn_op1_0900_s1_w20_1 wwl_des wbl_op1_0900_s1_w20 0 sky130_fd_pr__nfet_01v8 L=0.15 W=0.42 nf=1 ad=0.1218 as=0.1218 pd=1.42 ps=1.42 nrd=0.69047619047619  nrs=0.69047619047619 sa=0 sb=0 sd=0 mult=1 m=1
XMRD_op1_0900_s1_w20_1 rbl_op1_0900_s1_w20 sn_op1_0900_s1_w20_1 rwl_des 0 sky130_fd_pr__nfet_01v8 L=0.15 W=0.42 nf=1 ad=0.1218 as=0.1218 pd=1.42 ps=1.42 nrd=0.69047619047619  nrs=0.69047619047619 sa=0 sb=0 sd=0 mult=1 m=1
csn_op1_0900_s1_w20_1 sn_op1_0900_s1_w20_1 0 {C_SN}
XMWR_op1_0900_s1_w20_2 sn_op1_0900_s1_w20_2 wwl_des wbl_op1_0900_s1_w20 0 sky130_fd_pr__nfet_01v8 L=0.15 W=0.42 nf=1 ad=0.1218 as=0.1218 pd=1.42 ps=1.42 nrd=0.69047619047619  nrs=0.69047619047619 sa=0 sb=0 sd=0 mult=1 m=1
XMRD_op1_0900_s1_w20_2 rbl_op1_0900_s1_w20 sn_op1_0900_s1_w20_2 rwl_des 0 sky130_fd_pr__nfet_01v8 L=0.15 W=0.42 nf=1 ad=0.1218 as=0.1218 pd=1.42 ps=1.42 nrd=0.69047619047619  nrs=0.69047619047619 sa=0 sb=0 sd=0 mult=1 m=1
csn_op1_0900_s1_w20_2 sn_op1_0900_s1_w20_2 0 {C_SN}
XMWR_op1_0900_s1_w20_3 sn_op1_0900_s1_w20_3 wwl_des wbl_op1_0900_s1_w20 0 sky130_fd_pr__nfet_01v8 L=0.15 W=0.42 nf=1 ad=0.1218 as=0.1218 pd=1.42 ps=1.42 nrd=0.69047619047619  nrs=0.69047619047619 sa=0 sb=0 sd=0 mult=1 m=1
XMRD_op1_0900_s1_w20_3 rbl_op1_0900_s1_w20 sn_op1_0900_s1_w20_3 rwl_des 0 sky130_fd_pr__nfet_01v8 L=0.15 W=0.42 nf=1 ad=0.1218 as=0.1218 pd=1.42 ps=1.42 nrd=0.69047619047619  nrs=0.69047619047619 sa=0 sb=0 sd=0 mult=1 m=1
csn_op1_0900_s1_w20_3 sn_op1_0900_s1_w20_3 0 {C_SN}
XMN1_op1_0900_s1_w20 rbl_op1_0900_s1_w20 ref_op1_0900_s1_w20 vn_op1_0900_s1_w20 0 sky130_fd_pr__nfet_01v8 L=0.15 W=1 nf=1 ad=0.29 as=0.29 pd=2.58 ps=2.58 mult=1 m=1
XMN2_op1_0900_s1_w20 ref_op1_0900_s1_w20 rbl_op1_0900_s1_w20 vn_op1_0900_s1_w20 0 sky130_fd_pr__nfet_01v8 L=0.15 W=1 nf=1 ad=0.29 as=0.29 pd=2.58 ps=2.58 mult=1 m=1
XMP1_op1_0900_s1_w20 rbl_op1_0900_s1_w20 ref_op1_0900_s1_w20 vp_op1_0900_s1_w20 vdd sky130_fd_pr__pfet_01v8 L=0.15 W=2 nf=1 ad=0.58 as=0.58 pd=4.58 ps=4.58 mult=1 m=1
XMP2_op1_0900_s1_w20 ref_op1_0900_s1_w20 rbl_op1_0900_s1_w20 vp_op1_0900_s1_w20 vdd sky130_fd_pr__pfet_01v8 L=0.15 W=2 nf=1 ad=0.58 as=0.58 pd=4.58 ps=4.58 mult=1 m=1
XMNF_op1_0900_s1_w20 vn_op1_0900_s1_w20 en_op1_0900_s1_w20 0 0 sky130_fd_pr__nfet_01v8 L=0.15 W=2 nf=1 ad=0.58 as=0.58 pd=4.58 ps=4.58 mult=1 m=1
XMPH_op1_0900_s1_w20 vp_op1_0900_s1_w20 enb_op1_0900_s1_w20 vdd vdd sky130_fd_pr__pfet_01v8 L=0.15 W=4 nf=1 ad=1.16 as=1.16 pd=8.58 ps=8.58 mult=1 m=1
bd_op1_0900_s1_w20 d_op1_0900_s1_w20 0 v=v(rbl_op1_0900_s1_w20)-v(ref_op1_0900_s1_w20)

* ---- instance 22: op1_0900_s1_w30 (t_en 5 ns, WWL 6..36 ns, release 38 ns) ----
ven_op1_0900_s1_w30  en_op1_0900_s1_w30  0 pwl(0 0 5.0000e-09 0 5.1000e-09 {VDD} 3.8000e-08 {VDD} 3.8100e-08 0)
venb_op1_0900_s1_w30 enb_op1_0900_s1_w30 0 pwl(0 {VDD} 5.0000e-09 {VDD} 5.1000e-09 0 3.8000e-08 0 3.8100e-08 {VDD})
vrs_op1_0900_s1_w30  rwls_op1_0900_s1_w30 0 pwl(0 {VDD} {T_READ} {VDD} {T_READ+TEDGE} 0 3.8000e-08 0 3.8100e-08 {VDD})
vww_op1_0900_s1_w30  wwl_op1_0900_s1_w30 0 pwl(0 0 6.0000e-09 0 6.1000e-09 {VDD} 3.6000e-08 {VDD} 3.6100e-08 0)
vwc_op1_0900_s1_w30  wbc_op1_0900_s1_w30 0 pwl(0 0 6.0000e-09 0 6.1000e-09 {VDD} 3.8000e-08 {VDD} 3.8100e-08 0)
swb_op1_0900_s1_w30 ref_op1_0900_s1_w30 wbl_op1_0900_s1_w30 wbc_op1_0900_s1_w30 0 swwbl
cwbl_op1_0900_s1_w30 wbl_op1_0900_s1_w30 0 {C_WBL}
spa_op1_0900_s1_w30 prea rbl_op1_0900_s1_w30 ctl 0 swpre
spr_op1_0900_s1_w30 pref ref_op1_0900_s1_w30 ctl 0 swpre
crbl_op1_0900_s1_w30 rbl_op1_0900_s1_w30 0 {C_RBL}
cref_op1_0900_s1_w30 ref_op1_0900_s1_w30 0 {C_RBL}   $ ASSUMPTION: ideal matched dummy load
XMWR_op1_0900_s1_w30_0 sn_op1_0900_s1_w30_0 wwl_op1_0900_s1_w30 wbl_op1_0900_s1_w30 0 sky130_fd_pr__nfet_01v8 L=0.15 W=0.42 nf=1 ad=0.1218 as=0.1218 pd=1.42 ps=1.42 nrd=0.69047619047619  nrs=0.69047619047619 sa=0 sb=0 sd=0 mult=1 m=1
XMRD_op1_0900_s1_w30_0 rbl_op1_0900_s1_w30 sn_op1_0900_s1_w30_0 rwls_op1_0900_s1_w30 0 sky130_fd_pr__nfet_01v8 L=0.15 W=0.42 nf=1 ad=0.1218 as=0.1218 pd=1.42 ps=1.42 nrd=0.69047619047619  nrs=0.69047619047619 sa=0 sb=0 sd=0 mult=1 m=1
csn_op1_0900_s1_w30_0 sn_op1_0900_s1_w30_0 0 {C_SN}
XMWR_op1_0900_s1_w30_1 sn_op1_0900_s1_w30_1 wwl_des wbl_op1_0900_s1_w30 0 sky130_fd_pr__nfet_01v8 L=0.15 W=0.42 nf=1 ad=0.1218 as=0.1218 pd=1.42 ps=1.42 nrd=0.69047619047619  nrs=0.69047619047619 sa=0 sb=0 sd=0 mult=1 m=1
XMRD_op1_0900_s1_w30_1 rbl_op1_0900_s1_w30 sn_op1_0900_s1_w30_1 rwl_des 0 sky130_fd_pr__nfet_01v8 L=0.15 W=0.42 nf=1 ad=0.1218 as=0.1218 pd=1.42 ps=1.42 nrd=0.69047619047619  nrs=0.69047619047619 sa=0 sb=0 sd=0 mult=1 m=1
csn_op1_0900_s1_w30_1 sn_op1_0900_s1_w30_1 0 {C_SN}
XMWR_op1_0900_s1_w30_2 sn_op1_0900_s1_w30_2 wwl_des wbl_op1_0900_s1_w30 0 sky130_fd_pr__nfet_01v8 L=0.15 W=0.42 nf=1 ad=0.1218 as=0.1218 pd=1.42 ps=1.42 nrd=0.69047619047619  nrs=0.69047619047619 sa=0 sb=0 sd=0 mult=1 m=1
XMRD_op1_0900_s1_w30_2 rbl_op1_0900_s1_w30 sn_op1_0900_s1_w30_2 rwl_des 0 sky130_fd_pr__nfet_01v8 L=0.15 W=0.42 nf=1 ad=0.1218 as=0.1218 pd=1.42 ps=1.42 nrd=0.69047619047619  nrs=0.69047619047619 sa=0 sb=0 sd=0 mult=1 m=1
csn_op1_0900_s1_w30_2 sn_op1_0900_s1_w30_2 0 {C_SN}
XMWR_op1_0900_s1_w30_3 sn_op1_0900_s1_w30_3 wwl_des wbl_op1_0900_s1_w30 0 sky130_fd_pr__nfet_01v8 L=0.15 W=0.42 nf=1 ad=0.1218 as=0.1218 pd=1.42 ps=1.42 nrd=0.69047619047619  nrs=0.69047619047619 sa=0 sb=0 sd=0 mult=1 m=1
XMRD_op1_0900_s1_w30_3 rbl_op1_0900_s1_w30 sn_op1_0900_s1_w30_3 rwl_des 0 sky130_fd_pr__nfet_01v8 L=0.15 W=0.42 nf=1 ad=0.1218 as=0.1218 pd=1.42 ps=1.42 nrd=0.69047619047619  nrs=0.69047619047619 sa=0 sb=0 sd=0 mult=1 m=1
csn_op1_0900_s1_w30_3 sn_op1_0900_s1_w30_3 0 {C_SN}
XMN1_op1_0900_s1_w30 rbl_op1_0900_s1_w30 ref_op1_0900_s1_w30 vn_op1_0900_s1_w30 0 sky130_fd_pr__nfet_01v8 L=0.15 W=1 nf=1 ad=0.29 as=0.29 pd=2.58 ps=2.58 mult=1 m=1
XMN2_op1_0900_s1_w30 ref_op1_0900_s1_w30 rbl_op1_0900_s1_w30 vn_op1_0900_s1_w30 0 sky130_fd_pr__nfet_01v8 L=0.15 W=1 nf=1 ad=0.29 as=0.29 pd=2.58 ps=2.58 mult=1 m=1
XMP1_op1_0900_s1_w30 rbl_op1_0900_s1_w30 ref_op1_0900_s1_w30 vp_op1_0900_s1_w30 vdd sky130_fd_pr__pfet_01v8 L=0.15 W=2 nf=1 ad=0.58 as=0.58 pd=4.58 ps=4.58 mult=1 m=1
XMP2_op1_0900_s1_w30 ref_op1_0900_s1_w30 rbl_op1_0900_s1_w30 vp_op1_0900_s1_w30 vdd sky130_fd_pr__pfet_01v8 L=0.15 W=2 nf=1 ad=0.58 as=0.58 pd=4.58 ps=4.58 mult=1 m=1
XMNF_op1_0900_s1_w30 vn_op1_0900_s1_w30 en_op1_0900_s1_w30 0 0 sky130_fd_pr__nfet_01v8 L=0.15 W=2 nf=1 ad=0.58 as=0.58 pd=4.58 ps=4.58 mult=1 m=1
XMPH_op1_0900_s1_w30 vp_op1_0900_s1_w30 enb_op1_0900_s1_w30 vdd vdd sky130_fd_pr__pfet_01v8 L=0.15 W=4 nf=1 ad=1.16 as=1.16 pd=8.58 ps=8.58 mult=1 m=1
bd_op1_0900_s1_w30 d_op1_0900_s1_w30 0 v=v(rbl_op1_0900_s1_w30)-v(ref_op1_0900_s1_w30)

* ---- instance 23: op1_0900_s1_w50 (t_en 5 ns, WWL 6..56 ns, release 58 ns) ----
ven_op1_0900_s1_w50  en_op1_0900_s1_w50  0 pwl(0 0 5.0000e-09 0 5.1000e-09 {VDD} 5.8000e-08 {VDD} 5.8100e-08 0)
venb_op1_0900_s1_w50 enb_op1_0900_s1_w50 0 pwl(0 {VDD} 5.0000e-09 {VDD} 5.1000e-09 0 5.8000e-08 0 5.8100e-08 {VDD})
vrs_op1_0900_s1_w50  rwls_op1_0900_s1_w50 0 pwl(0 {VDD} {T_READ} {VDD} {T_READ+TEDGE} 0 5.8000e-08 0 5.8100e-08 {VDD})
vww_op1_0900_s1_w50  wwl_op1_0900_s1_w50 0 pwl(0 0 6.0000e-09 0 6.1000e-09 {VDD} 5.6000e-08 {VDD} 5.6100e-08 0)
vwc_op1_0900_s1_w50  wbc_op1_0900_s1_w50 0 pwl(0 0 6.0000e-09 0 6.1000e-09 {VDD} 5.8000e-08 {VDD} 5.8100e-08 0)
swb_op1_0900_s1_w50 ref_op1_0900_s1_w50 wbl_op1_0900_s1_w50 wbc_op1_0900_s1_w50 0 swwbl
cwbl_op1_0900_s1_w50 wbl_op1_0900_s1_w50 0 {C_WBL}
spa_op1_0900_s1_w50 prea rbl_op1_0900_s1_w50 ctl 0 swpre
spr_op1_0900_s1_w50 pref ref_op1_0900_s1_w50 ctl 0 swpre
crbl_op1_0900_s1_w50 rbl_op1_0900_s1_w50 0 {C_RBL}
cref_op1_0900_s1_w50 ref_op1_0900_s1_w50 0 {C_RBL}   $ ASSUMPTION: ideal matched dummy load
XMWR_op1_0900_s1_w50_0 sn_op1_0900_s1_w50_0 wwl_op1_0900_s1_w50 wbl_op1_0900_s1_w50 0 sky130_fd_pr__nfet_01v8 L=0.15 W=0.42 nf=1 ad=0.1218 as=0.1218 pd=1.42 ps=1.42 nrd=0.69047619047619  nrs=0.69047619047619 sa=0 sb=0 sd=0 mult=1 m=1
XMRD_op1_0900_s1_w50_0 rbl_op1_0900_s1_w50 sn_op1_0900_s1_w50_0 rwls_op1_0900_s1_w50 0 sky130_fd_pr__nfet_01v8 L=0.15 W=0.42 nf=1 ad=0.1218 as=0.1218 pd=1.42 ps=1.42 nrd=0.69047619047619  nrs=0.69047619047619 sa=0 sb=0 sd=0 mult=1 m=1
csn_op1_0900_s1_w50_0 sn_op1_0900_s1_w50_0 0 {C_SN}
XMWR_op1_0900_s1_w50_1 sn_op1_0900_s1_w50_1 wwl_des wbl_op1_0900_s1_w50 0 sky130_fd_pr__nfet_01v8 L=0.15 W=0.42 nf=1 ad=0.1218 as=0.1218 pd=1.42 ps=1.42 nrd=0.69047619047619  nrs=0.69047619047619 sa=0 sb=0 sd=0 mult=1 m=1
XMRD_op1_0900_s1_w50_1 rbl_op1_0900_s1_w50 sn_op1_0900_s1_w50_1 rwl_des 0 sky130_fd_pr__nfet_01v8 L=0.15 W=0.42 nf=1 ad=0.1218 as=0.1218 pd=1.42 ps=1.42 nrd=0.69047619047619  nrs=0.69047619047619 sa=0 sb=0 sd=0 mult=1 m=1
csn_op1_0900_s1_w50_1 sn_op1_0900_s1_w50_1 0 {C_SN}
XMWR_op1_0900_s1_w50_2 sn_op1_0900_s1_w50_2 wwl_des wbl_op1_0900_s1_w50 0 sky130_fd_pr__nfet_01v8 L=0.15 W=0.42 nf=1 ad=0.1218 as=0.1218 pd=1.42 ps=1.42 nrd=0.69047619047619  nrs=0.69047619047619 sa=0 sb=0 sd=0 mult=1 m=1
XMRD_op1_0900_s1_w50_2 rbl_op1_0900_s1_w50 sn_op1_0900_s1_w50_2 rwl_des 0 sky130_fd_pr__nfet_01v8 L=0.15 W=0.42 nf=1 ad=0.1218 as=0.1218 pd=1.42 ps=1.42 nrd=0.69047619047619  nrs=0.69047619047619 sa=0 sb=0 sd=0 mult=1 m=1
csn_op1_0900_s1_w50_2 sn_op1_0900_s1_w50_2 0 {C_SN}
XMWR_op1_0900_s1_w50_3 sn_op1_0900_s1_w50_3 wwl_des wbl_op1_0900_s1_w50 0 sky130_fd_pr__nfet_01v8 L=0.15 W=0.42 nf=1 ad=0.1218 as=0.1218 pd=1.42 ps=1.42 nrd=0.69047619047619  nrs=0.69047619047619 sa=0 sb=0 sd=0 mult=1 m=1
XMRD_op1_0900_s1_w50_3 rbl_op1_0900_s1_w50 sn_op1_0900_s1_w50_3 rwl_des 0 sky130_fd_pr__nfet_01v8 L=0.15 W=0.42 nf=1 ad=0.1218 as=0.1218 pd=1.42 ps=1.42 nrd=0.69047619047619  nrs=0.69047619047619 sa=0 sb=0 sd=0 mult=1 m=1
csn_op1_0900_s1_w50_3 sn_op1_0900_s1_w50_3 0 {C_SN}
XMN1_op1_0900_s1_w50 rbl_op1_0900_s1_w50 ref_op1_0900_s1_w50 vn_op1_0900_s1_w50 0 sky130_fd_pr__nfet_01v8 L=0.15 W=1 nf=1 ad=0.29 as=0.29 pd=2.58 ps=2.58 mult=1 m=1
XMN2_op1_0900_s1_w50 ref_op1_0900_s1_w50 rbl_op1_0900_s1_w50 vn_op1_0900_s1_w50 0 sky130_fd_pr__nfet_01v8 L=0.15 W=1 nf=1 ad=0.29 as=0.29 pd=2.58 ps=2.58 mult=1 m=1
XMP1_op1_0900_s1_w50 rbl_op1_0900_s1_w50 ref_op1_0900_s1_w50 vp_op1_0900_s1_w50 vdd sky130_fd_pr__pfet_01v8 L=0.15 W=2 nf=1 ad=0.58 as=0.58 pd=4.58 ps=4.58 mult=1 m=1
XMP2_op1_0900_s1_w50 ref_op1_0900_s1_w50 rbl_op1_0900_s1_w50 vp_op1_0900_s1_w50 vdd sky130_fd_pr__pfet_01v8 L=0.15 W=2 nf=1 ad=0.58 as=0.58 pd=4.58 ps=4.58 mult=1 m=1
XMNF_op1_0900_s1_w50 vn_op1_0900_s1_w50 en_op1_0900_s1_w50 0 0 sky130_fd_pr__nfet_01v8 L=0.15 W=2 nf=1 ad=0.58 as=0.58 pd=4.58 ps=4.58 mult=1 m=1
XMPH_op1_0900_s1_w50 vp_op1_0900_s1_w50 enb_op1_0900_s1_w50 vdd vdd sky130_fd_pr__pfet_01v8 L=0.15 W=4 nf=1 ad=1.16 as=1.16 pd=8.58 ps=8.58 mult=1 m=1
bd_op1_0900_s1_w50 d_op1_0900_s1_w50 0 v=v(rbl_op1_0900_s1_w50)-v(ref_op1_0900_s1_w50)

* ---- instance 24: op1_0900_s2_w0p2 (t_en 6 ns, WWL 7..7.2 ns, release 9.2 ns) ----
ven_op1_0900_s2_w0p2  en_op1_0900_s2_w0p2  0 pwl(0 0 6.0000e-09 0 6.1000e-09 {VDD} 9.2000e-09 {VDD} 9.3000e-09 0)
venb_op1_0900_s2_w0p2 enb_op1_0900_s2_w0p2 0 pwl(0 {VDD} 6.0000e-09 {VDD} 6.1000e-09 0 9.2000e-09 0 9.3000e-09 {VDD})
vrs_op1_0900_s2_w0p2  rwls_op1_0900_s2_w0p2 0 pwl(0 {VDD} {T_READ} {VDD} {T_READ+TEDGE} 0 9.2000e-09 0 9.3000e-09 {VDD})
vww_op1_0900_s2_w0p2  wwl_op1_0900_s2_w0p2 0 pwl(0 0 7.0000e-09 0 7.1000e-09 {VDD} 7.2000e-09 {VDD} 7.3000e-09 0)
vwc_op1_0900_s2_w0p2  wbc_op1_0900_s2_w0p2 0 pwl(0 0 7.0000e-09 0 7.1000e-09 {VDD} 9.2000e-09 {VDD} 9.3000e-09 0)
swb_op1_0900_s2_w0p2 ref_op1_0900_s2_w0p2 wbl_op1_0900_s2_w0p2 wbc_op1_0900_s2_w0p2 0 swwbl
cwbl_op1_0900_s2_w0p2 wbl_op1_0900_s2_w0p2 0 {C_WBL}
spa_op1_0900_s2_w0p2 prea rbl_op1_0900_s2_w0p2 ctl 0 swpre
spr_op1_0900_s2_w0p2 pref ref_op1_0900_s2_w0p2 ctl 0 swpre
crbl_op1_0900_s2_w0p2 rbl_op1_0900_s2_w0p2 0 {C_RBL}
cref_op1_0900_s2_w0p2 ref_op1_0900_s2_w0p2 0 {C_RBL}   $ ASSUMPTION: ideal matched dummy load
XMWR_op1_0900_s2_w0p2_0 sn_op1_0900_s2_w0p2_0 wwl_op1_0900_s2_w0p2 wbl_op1_0900_s2_w0p2 0 sky130_fd_pr__nfet_01v8 L=0.15 W=0.42 nf=1 ad=0.1218 as=0.1218 pd=1.42 ps=1.42 nrd=0.69047619047619  nrs=0.69047619047619 sa=0 sb=0 sd=0 mult=1 m=1
XMRD_op1_0900_s2_w0p2_0 rbl_op1_0900_s2_w0p2 sn_op1_0900_s2_w0p2_0 rwls_op1_0900_s2_w0p2 0 sky130_fd_pr__nfet_01v8 L=0.15 W=0.42 nf=1 ad=0.1218 as=0.1218 pd=1.42 ps=1.42 nrd=0.69047619047619  nrs=0.69047619047619 sa=0 sb=0 sd=0 mult=1 m=1
csn_op1_0900_s2_w0p2_0 sn_op1_0900_s2_w0p2_0 0 {C_SN}
XMWR_op1_0900_s2_w0p2_1 sn_op1_0900_s2_w0p2_1 wwl_des wbl_op1_0900_s2_w0p2 0 sky130_fd_pr__nfet_01v8 L=0.15 W=0.42 nf=1 ad=0.1218 as=0.1218 pd=1.42 ps=1.42 nrd=0.69047619047619  nrs=0.69047619047619 sa=0 sb=0 sd=0 mult=1 m=1
XMRD_op1_0900_s2_w0p2_1 rbl_op1_0900_s2_w0p2 sn_op1_0900_s2_w0p2_1 rwl_des 0 sky130_fd_pr__nfet_01v8 L=0.15 W=0.42 nf=1 ad=0.1218 as=0.1218 pd=1.42 ps=1.42 nrd=0.69047619047619  nrs=0.69047619047619 sa=0 sb=0 sd=0 mult=1 m=1
csn_op1_0900_s2_w0p2_1 sn_op1_0900_s2_w0p2_1 0 {C_SN}
XMWR_op1_0900_s2_w0p2_2 sn_op1_0900_s2_w0p2_2 wwl_des wbl_op1_0900_s2_w0p2 0 sky130_fd_pr__nfet_01v8 L=0.15 W=0.42 nf=1 ad=0.1218 as=0.1218 pd=1.42 ps=1.42 nrd=0.69047619047619  nrs=0.69047619047619 sa=0 sb=0 sd=0 mult=1 m=1
XMRD_op1_0900_s2_w0p2_2 rbl_op1_0900_s2_w0p2 sn_op1_0900_s2_w0p2_2 rwl_des 0 sky130_fd_pr__nfet_01v8 L=0.15 W=0.42 nf=1 ad=0.1218 as=0.1218 pd=1.42 ps=1.42 nrd=0.69047619047619  nrs=0.69047619047619 sa=0 sb=0 sd=0 mult=1 m=1
csn_op1_0900_s2_w0p2_2 sn_op1_0900_s2_w0p2_2 0 {C_SN}
XMWR_op1_0900_s2_w0p2_3 sn_op1_0900_s2_w0p2_3 wwl_des wbl_op1_0900_s2_w0p2 0 sky130_fd_pr__nfet_01v8 L=0.15 W=0.42 nf=1 ad=0.1218 as=0.1218 pd=1.42 ps=1.42 nrd=0.69047619047619  nrs=0.69047619047619 sa=0 sb=0 sd=0 mult=1 m=1
XMRD_op1_0900_s2_w0p2_3 rbl_op1_0900_s2_w0p2 sn_op1_0900_s2_w0p2_3 rwl_des 0 sky130_fd_pr__nfet_01v8 L=0.15 W=0.42 nf=1 ad=0.1218 as=0.1218 pd=1.42 ps=1.42 nrd=0.69047619047619  nrs=0.69047619047619 sa=0 sb=0 sd=0 mult=1 m=1
csn_op1_0900_s2_w0p2_3 sn_op1_0900_s2_w0p2_3 0 {C_SN}
XMN1_op1_0900_s2_w0p2 rbl_op1_0900_s2_w0p2 ref_op1_0900_s2_w0p2 vn_op1_0900_s2_w0p2 0 sky130_fd_pr__nfet_01v8 L=0.15 W=1 nf=1 ad=0.29 as=0.29 pd=2.58 ps=2.58 mult=1 m=1
XMN2_op1_0900_s2_w0p2 ref_op1_0900_s2_w0p2 rbl_op1_0900_s2_w0p2 vn_op1_0900_s2_w0p2 0 sky130_fd_pr__nfet_01v8 L=0.15 W=1 nf=1 ad=0.29 as=0.29 pd=2.58 ps=2.58 mult=1 m=1
XMP1_op1_0900_s2_w0p2 rbl_op1_0900_s2_w0p2 ref_op1_0900_s2_w0p2 vp_op1_0900_s2_w0p2 vdd sky130_fd_pr__pfet_01v8 L=0.15 W=2 nf=1 ad=0.58 as=0.58 pd=4.58 ps=4.58 mult=1 m=1
XMP2_op1_0900_s2_w0p2 ref_op1_0900_s2_w0p2 rbl_op1_0900_s2_w0p2 vp_op1_0900_s2_w0p2 vdd sky130_fd_pr__pfet_01v8 L=0.15 W=2 nf=1 ad=0.58 as=0.58 pd=4.58 ps=4.58 mult=1 m=1
XMNF_op1_0900_s2_w0p2 vn_op1_0900_s2_w0p2 en_op1_0900_s2_w0p2 0 0 sky130_fd_pr__nfet_01v8 L=0.15 W=2 nf=1 ad=0.58 as=0.58 pd=4.58 ps=4.58 mult=1 m=1
XMPH_op1_0900_s2_w0p2 vp_op1_0900_s2_w0p2 enb_op1_0900_s2_w0p2 vdd vdd sky130_fd_pr__pfet_01v8 L=0.15 W=4 nf=1 ad=1.16 as=1.16 pd=8.58 ps=8.58 mult=1 m=1
bd_op1_0900_s2_w0p2 d_op1_0900_s2_w0p2 0 v=v(rbl_op1_0900_s2_w0p2)-v(ref_op1_0900_s2_w0p2)

* ---- instance 25: op1_0900_s2_w0p5 (t_en 6 ns, WWL 7..7.5 ns, release 9.5 ns) ----
ven_op1_0900_s2_w0p5  en_op1_0900_s2_w0p5  0 pwl(0 0 6.0000e-09 0 6.1000e-09 {VDD} 9.5000e-09 {VDD} 9.6000e-09 0)
venb_op1_0900_s2_w0p5 enb_op1_0900_s2_w0p5 0 pwl(0 {VDD} 6.0000e-09 {VDD} 6.1000e-09 0 9.5000e-09 0 9.6000e-09 {VDD})
vrs_op1_0900_s2_w0p5  rwls_op1_0900_s2_w0p5 0 pwl(0 {VDD} {T_READ} {VDD} {T_READ+TEDGE} 0 9.5000e-09 0 9.6000e-09 {VDD})
vww_op1_0900_s2_w0p5  wwl_op1_0900_s2_w0p5 0 pwl(0 0 7.0000e-09 0 7.1000e-09 {VDD} 7.5000e-09 {VDD} 7.6000e-09 0)
vwc_op1_0900_s2_w0p5  wbc_op1_0900_s2_w0p5 0 pwl(0 0 7.0000e-09 0 7.1000e-09 {VDD} 9.5000e-09 {VDD} 9.6000e-09 0)
swb_op1_0900_s2_w0p5 ref_op1_0900_s2_w0p5 wbl_op1_0900_s2_w0p5 wbc_op1_0900_s2_w0p5 0 swwbl
cwbl_op1_0900_s2_w0p5 wbl_op1_0900_s2_w0p5 0 {C_WBL}
spa_op1_0900_s2_w0p5 prea rbl_op1_0900_s2_w0p5 ctl 0 swpre
spr_op1_0900_s2_w0p5 pref ref_op1_0900_s2_w0p5 ctl 0 swpre
crbl_op1_0900_s2_w0p5 rbl_op1_0900_s2_w0p5 0 {C_RBL}
cref_op1_0900_s2_w0p5 ref_op1_0900_s2_w0p5 0 {C_RBL}   $ ASSUMPTION: ideal matched dummy load
XMWR_op1_0900_s2_w0p5_0 sn_op1_0900_s2_w0p5_0 wwl_op1_0900_s2_w0p5 wbl_op1_0900_s2_w0p5 0 sky130_fd_pr__nfet_01v8 L=0.15 W=0.42 nf=1 ad=0.1218 as=0.1218 pd=1.42 ps=1.42 nrd=0.69047619047619  nrs=0.69047619047619 sa=0 sb=0 sd=0 mult=1 m=1
XMRD_op1_0900_s2_w0p5_0 rbl_op1_0900_s2_w0p5 sn_op1_0900_s2_w0p5_0 rwls_op1_0900_s2_w0p5 0 sky130_fd_pr__nfet_01v8 L=0.15 W=0.42 nf=1 ad=0.1218 as=0.1218 pd=1.42 ps=1.42 nrd=0.69047619047619  nrs=0.69047619047619 sa=0 sb=0 sd=0 mult=1 m=1
csn_op1_0900_s2_w0p5_0 sn_op1_0900_s2_w0p5_0 0 {C_SN}
XMWR_op1_0900_s2_w0p5_1 sn_op1_0900_s2_w0p5_1 wwl_des wbl_op1_0900_s2_w0p5 0 sky130_fd_pr__nfet_01v8 L=0.15 W=0.42 nf=1 ad=0.1218 as=0.1218 pd=1.42 ps=1.42 nrd=0.69047619047619  nrs=0.69047619047619 sa=0 sb=0 sd=0 mult=1 m=1
XMRD_op1_0900_s2_w0p5_1 rbl_op1_0900_s2_w0p5 sn_op1_0900_s2_w0p5_1 rwl_des 0 sky130_fd_pr__nfet_01v8 L=0.15 W=0.42 nf=1 ad=0.1218 as=0.1218 pd=1.42 ps=1.42 nrd=0.69047619047619  nrs=0.69047619047619 sa=0 sb=0 sd=0 mult=1 m=1
csn_op1_0900_s2_w0p5_1 sn_op1_0900_s2_w0p5_1 0 {C_SN}
XMWR_op1_0900_s2_w0p5_2 sn_op1_0900_s2_w0p5_2 wwl_des wbl_op1_0900_s2_w0p5 0 sky130_fd_pr__nfet_01v8 L=0.15 W=0.42 nf=1 ad=0.1218 as=0.1218 pd=1.42 ps=1.42 nrd=0.69047619047619  nrs=0.69047619047619 sa=0 sb=0 sd=0 mult=1 m=1
XMRD_op1_0900_s2_w0p5_2 rbl_op1_0900_s2_w0p5 sn_op1_0900_s2_w0p5_2 rwl_des 0 sky130_fd_pr__nfet_01v8 L=0.15 W=0.42 nf=1 ad=0.1218 as=0.1218 pd=1.42 ps=1.42 nrd=0.69047619047619  nrs=0.69047619047619 sa=0 sb=0 sd=0 mult=1 m=1
csn_op1_0900_s2_w0p5_2 sn_op1_0900_s2_w0p5_2 0 {C_SN}
XMWR_op1_0900_s2_w0p5_3 sn_op1_0900_s2_w0p5_3 wwl_des wbl_op1_0900_s2_w0p5 0 sky130_fd_pr__nfet_01v8 L=0.15 W=0.42 nf=1 ad=0.1218 as=0.1218 pd=1.42 ps=1.42 nrd=0.69047619047619  nrs=0.69047619047619 sa=0 sb=0 sd=0 mult=1 m=1
XMRD_op1_0900_s2_w0p5_3 rbl_op1_0900_s2_w0p5 sn_op1_0900_s2_w0p5_3 rwl_des 0 sky130_fd_pr__nfet_01v8 L=0.15 W=0.42 nf=1 ad=0.1218 as=0.1218 pd=1.42 ps=1.42 nrd=0.69047619047619  nrs=0.69047619047619 sa=0 sb=0 sd=0 mult=1 m=1
csn_op1_0900_s2_w0p5_3 sn_op1_0900_s2_w0p5_3 0 {C_SN}
XMN1_op1_0900_s2_w0p5 rbl_op1_0900_s2_w0p5 ref_op1_0900_s2_w0p5 vn_op1_0900_s2_w0p5 0 sky130_fd_pr__nfet_01v8 L=0.15 W=1 nf=1 ad=0.29 as=0.29 pd=2.58 ps=2.58 mult=1 m=1
XMN2_op1_0900_s2_w0p5 ref_op1_0900_s2_w0p5 rbl_op1_0900_s2_w0p5 vn_op1_0900_s2_w0p5 0 sky130_fd_pr__nfet_01v8 L=0.15 W=1 nf=1 ad=0.29 as=0.29 pd=2.58 ps=2.58 mult=1 m=1
XMP1_op1_0900_s2_w0p5 rbl_op1_0900_s2_w0p5 ref_op1_0900_s2_w0p5 vp_op1_0900_s2_w0p5 vdd sky130_fd_pr__pfet_01v8 L=0.15 W=2 nf=1 ad=0.58 as=0.58 pd=4.58 ps=4.58 mult=1 m=1
XMP2_op1_0900_s2_w0p5 ref_op1_0900_s2_w0p5 rbl_op1_0900_s2_w0p5 vp_op1_0900_s2_w0p5 vdd sky130_fd_pr__pfet_01v8 L=0.15 W=2 nf=1 ad=0.58 as=0.58 pd=4.58 ps=4.58 mult=1 m=1
XMNF_op1_0900_s2_w0p5 vn_op1_0900_s2_w0p5 en_op1_0900_s2_w0p5 0 0 sky130_fd_pr__nfet_01v8 L=0.15 W=2 nf=1 ad=0.58 as=0.58 pd=4.58 ps=4.58 mult=1 m=1
XMPH_op1_0900_s2_w0p5 vp_op1_0900_s2_w0p5 enb_op1_0900_s2_w0p5 vdd vdd sky130_fd_pr__pfet_01v8 L=0.15 W=4 nf=1 ad=1.16 as=1.16 pd=8.58 ps=8.58 mult=1 m=1
bd_op1_0900_s2_w0p5 d_op1_0900_s2_w0p5 0 v=v(rbl_op1_0900_s2_w0p5)-v(ref_op1_0900_s2_w0p5)

* ---- instance 26: op1_0900_s2_w1 (t_en 6 ns, WWL 7..8 ns, release 10 ns) ----
ven_op1_0900_s2_w1  en_op1_0900_s2_w1  0 pwl(0 0 6.0000e-09 0 6.1000e-09 {VDD} 1.0000e-08 {VDD} 1.0100e-08 0)
venb_op1_0900_s2_w1 enb_op1_0900_s2_w1 0 pwl(0 {VDD} 6.0000e-09 {VDD} 6.1000e-09 0 1.0000e-08 0 1.0100e-08 {VDD})
vrs_op1_0900_s2_w1  rwls_op1_0900_s2_w1 0 pwl(0 {VDD} {T_READ} {VDD} {T_READ+TEDGE} 0 1.0000e-08 0 1.0100e-08 {VDD})
vww_op1_0900_s2_w1  wwl_op1_0900_s2_w1 0 pwl(0 0 7.0000e-09 0 7.1000e-09 {VDD} 8.0000e-09 {VDD} 8.1000e-09 0)
vwc_op1_0900_s2_w1  wbc_op1_0900_s2_w1 0 pwl(0 0 7.0000e-09 0 7.1000e-09 {VDD} 1.0000e-08 {VDD} 1.0100e-08 0)
swb_op1_0900_s2_w1 ref_op1_0900_s2_w1 wbl_op1_0900_s2_w1 wbc_op1_0900_s2_w1 0 swwbl
cwbl_op1_0900_s2_w1 wbl_op1_0900_s2_w1 0 {C_WBL}
spa_op1_0900_s2_w1 prea rbl_op1_0900_s2_w1 ctl 0 swpre
spr_op1_0900_s2_w1 pref ref_op1_0900_s2_w1 ctl 0 swpre
crbl_op1_0900_s2_w1 rbl_op1_0900_s2_w1 0 {C_RBL}
cref_op1_0900_s2_w1 ref_op1_0900_s2_w1 0 {C_RBL}   $ ASSUMPTION: ideal matched dummy load
XMWR_op1_0900_s2_w1_0 sn_op1_0900_s2_w1_0 wwl_op1_0900_s2_w1 wbl_op1_0900_s2_w1 0 sky130_fd_pr__nfet_01v8 L=0.15 W=0.42 nf=1 ad=0.1218 as=0.1218 pd=1.42 ps=1.42 nrd=0.69047619047619  nrs=0.69047619047619 sa=0 sb=0 sd=0 mult=1 m=1
XMRD_op1_0900_s2_w1_0 rbl_op1_0900_s2_w1 sn_op1_0900_s2_w1_0 rwls_op1_0900_s2_w1 0 sky130_fd_pr__nfet_01v8 L=0.15 W=0.42 nf=1 ad=0.1218 as=0.1218 pd=1.42 ps=1.42 nrd=0.69047619047619  nrs=0.69047619047619 sa=0 sb=0 sd=0 mult=1 m=1
csn_op1_0900_s2_w1_0 sn_op1_0900_s2_w1_0 0 {C_SN}
XMWR_op1_0900_s2_w1_1 sn_op1_0900_s2_w1_1 wwl_des wbl_op1_0900_s2_w1 0 sky130_fd_pr__nfet_01v8 L=0.15 W=0.42 nf=1 ad=0.1218 as=0.1218 pd=1.42 ps=1.42 nrd=0.69047619047619  nrs=0.69047619047619 sa=0 sb=0 sd=0 mult=1 m=1
XMRD_op1_0900_s2_w1_1 rbl_op1_0900_s2_w1 sn_op1_0900_s2_w1_1 rwl_des 0 sky130_fd_pr__nfet_01v8 L=0.15 W=0.42 nf=1 ad=0.1218 as=0.1218 pd=1.42 ps=1.42 nrd=0.69047619047619  nrs=0.69047619047619 sa=0 sb=0 sd=0 mult=1 m=1
csn_op1_0900_s2_w1_1 sn_op1_0900_s2_w1_1 0 {C_SN}
XMWR_op1_0900_s2_w1_2 sn_op1_0900_s2_w1_2 wwl_des wbl_op1_0900_s2_w1 0 sky130_fd_pr__nfet_01v8 L=0.15 W=0.42 nf=1 ad=0.1218 as=0.1218 pd=1.42 ps=1.42 nrd=0.69047619047619  nrs=0.69047619047619 sa=0 sb=0 sd=0 mult=1 m=1
XMRD_op1_0900_s2_w1_2 rbl_op1_0900_s2_w1 sn_op1_0900_s2_w1_2 rwl_des 0 sky130_fd_pr__nfet_01v8 L=0.15 W=0.42 nf=1 ad=0.1218 as=0.1218 pd=1.42 ps=1.42 nrd=0.69047619047619  nrs=0.69047619047619 sa=0 sb=0 sd=0 mult=1 m=1
csn_op1_0900_s2_w1_2 sn_op1_0900_s2_w1_2 0 {C_SN}
XMWR_op1_0900_s2_w1_3 sn_op1_0900_s2_w1_3 wwl_des wbl_op1_0900_s2_w1 0 sky130_fd_pr__nfet_01v8 L=0.15 W=0.42 nf=1 ad=0.1218 as=0.1218 pd=1.42 ps=1.42 nrd=0.69047619047619  nrs=0.69047619047619 sa=0 sb=0 sd=0 mult=1 m=1
XMRD_op1_0900_s2_w1_3 rbl_op1_0900_s2_w1 sn_op1_0900_s2_w1_3 rwl_des 0 sky130_fd_pr__nfet_01v8 L=0.15 W=0.42 nf=1 ad=0.1218 as=0.1218 pd=1.42 ps=1.42 nrd=0.69047619047619  nrs=0.69047619047619 sa=0 sb=0 sd=0 mult=1 m=1
csn_op1_0900_s2_w1_3 sn_op1_0900_s2_w1_3 0 {C_SN}
XMN1_op1_0900_s2_w1 rbl_op1_0900_s2_w1 ref_op1_0900_s2_w1 vn_op1_0900_s2_w1 0 sky130_fd_pr__nfet_01v8 L=0.15 W=1 nf=1 ad=0.29 as=0.29 pd=2.58 ps=2.58 mult=1 m=1
XMN2_op1_0900_s2_w1 ref_op1_0900_s2_w1 rbl_op1_0900_s2_w1 vn_op1_0900_s2_w1 0 sky130_fd_pr__nfet_01v8 L=0.15 W=1 nf=1 ad=0.29 as=0.29 pd=2.58 ps=2.58 mult=1 m=1
XMP1_op1_0900_s2_w1 rbl_op1_0900_s2_w1 ref_op1_0900_s2_w1 vp_op1_0900_s2_w1 vdd sky130_fd_pr__pfet_01v8 L=0.15 W=2 nf=1 ad=0.58 as=0.58 pd=4.58 ps=4.58 mult=1 m=1
XMP2_op1_0900_s2_w1 ref_op1_0900_s2_w1 rbl_op1_0900_s2_w1 vp_op1_0900_s2_w1 vdd sky130_fd_pr__pfet_01v8 L=0.15 W=2 nf=1 ad=0.58 as=0.58 pd=4.58 ps=4.58 mult=1 m=1
XMNF_op1_0900_s2_w1 vn_op1_0900_s2_w1 en_op1_0900_s2_w1 0 0 sky130_fd_pr__nfet_01v8 L=0.15 W=2 nf=1 ad=0.58 as=0.58 pd=4.58 ps=4.58 mult=1 m=1
XMPH_op1_0900_s2_w1 vp_op1_0900_s2_w1 enb_op1_0900_s2_w1 vdd vdd sky130_fd_pr__pfet_01v8 L=0.15 W=4 nf=1 ad=1.16 as=1.16 pd=8.58 ps=8.58 mult=1 m=1
bd_op1_0900_s2_w1 d_op1_0900_s2_w1 0 v=v(rbl_op1_0900_s2_w1)-v(ref_op1_0900_s2_w1)

* ---- instance 27: op1_0900_s2_w2 (t_en 6 ns, WWL 7..9 ns, release 11 ns) ----
ven_op1_0900_s2_w2  en_op1_0900_s2_w2  0 pwl(0 0 6.0000e-09 0 6.1000e-09 {VDD} 1.1000e-08 {VDD} 1.1100e-08 0)
venb_op1_0900_s2_w2 enb_op1_0900_s2_w2 0 pwl(0 {VDD} 6.0000e-09 {VDD} 6.1000e-09 0 1.1000e-08 0 1.1100e-08 {VDD})
vrs_op1_0900_s2_w2  rwls_op1_0900_s2_w2 0 pwl(0 {VDD} {T_READ} {VDD} {T_READ+TEDGE} 0 1.1000e-08 0 1.1100e-08 {VDD})
vww_op1_0900_s2_w2  wwl_op1_0900_s2_w2 0 pwl(0 0 7.0000e-09 0 7.1000e-09 {VDD} 9.0000e-09 {VDD} 9.1000e-09 0)
vwc_op1_0900_s2_w2  wbc_op1_0900_s2_w2 0 pwl(0 0 7.0000e-09 0 7.1000e-09 {VDD} 1.1000e-08 {VDD} 1.1100e-08 0)
swb_op1_0900_s2_w2 ref_op1_0900_s2_w2 wbl_op1_0900_s2_w2 wbc_op1_0900_s2_w2 0 swwbl
cwbl_op1_0900_s2_w2 wbl_op1_0900_s2_w2 0 {C_WBL}
spa_op1_0900_s2_w2 prea rbl_op1_0900_s2_w2 ctl 0 swpre
spr_op1_0900_s2_w2 pref ref_op1_0900_s2_w2 ctl 0 swpre
crbl_op1_0900_s2_w2 rbl_op1_0900_s2_w2 0 {C_RBL}
cref_op1_0900_s2_w2 ref_op1_0900_s2_w2 0 {C_RBL}   $ ASSUMPTION: ideal matched dummy load
XMWR_op1_0900_s2_w2_0 sn_op1_0900_s2_w2_0 wwl_op1_0900_s2_w2 wbl_op1_0900_s2_w2 0 sky130_fd_pr__nfet_01v8 L=0.15 W=0.42 nf=1 ad=0.1218 as=0.1218 pd=1.42 ps=1.42 nrd=0.69047619047619  nrs=0.69047619047619 sa=0 sb=0 sd=0 mult=1 m=1
XMRD_op1_0900_s2_w2_0 rbl_op1_0900_s2_w2 sn_op1_0900_s2_w2_0 rwls_op1_0900_s2_w2 0 sky130_fd_pr__nfet_01v8 L=0.15 W=0.42 nf=1 ad=0.1218 as=0.1218 pd=1.42 ps=1.42 nrd=0.69047619047619  nrs=0.69047619047619 sa=0 sb=0 sd=0 mult=1 m=1
csn_op1_0900_s2_w2_0 sn_op1_0900_s2_w2_0 0 {C_SN}
XMWR_op1_0900_s2_w2_1 sn_op1_0900_s2_w2_1 wwl_des wbl_op1_0900_s2_w2 0 sky130_fd_pr__nfet_01v8 L=0.15 W=0.42 nf=1 ad=0.1218 as=0.1218 pd=1.42 ps=1.42 nrd=0.69047619047619  nrs=0.69047619047619 sa=0 sb=0 sd=0 mult=1 m=1
XMRD_op1_0900_s2_w2_1 rbl_op1_0900_s2_w2 sn_op1_0900_s2_w2_1 rwl_des 0 sky130_fd_pr__nfet_01v8 L=0.15 W=0.42 nf=1 ad=0.1218 as=0.1218 pd=1.42 ps=1.42 nrd=0.69047619047619  nrs=0.69047619047619 sa=0 sb=0 sd=0 mult=1 m=1
csn_op1_0900_s2_w2_1 sn_op1_0900_s2_w2_1 0 {C_SN}
XMWR_op1_0900_s2_w2_2 sn_op1_0900_s2_w2_2 wwl_des wbl_op1_0900_s2_w2 0 sky130_fd_pr__nfet_01v8 L=0.15 W=0.42 nf=1 ad=0.1218 as=0.1218 pd=1.42 ps=1.42 nrd=0.69047619047619  nrs=0.69047619047619 sa=0 sb=0 sd=0 mult=1 m=1
XMRD_op1_0900_s2_w2_2 rbl_op1_0900_s2_w2 sn_op1_0900_s2_w2_2 rwl_des 0 sky130_fd_pr__nfet_01v8 L=0.15 W=0.42 nf=1 ad=0.1218 as=0.1218 pd=1.42 ps=1.42 nrd=0.69047619047619  nrs=0.69047619047619 sa=0 sb=0 sd=0 mult=1 m=1
csn_op1_0900_s2_w2_2 sn_op1_0900_s2_w2_2 0 {C_SN}
XMWR_op1_0900_s2_w2_3 sn_op1_0900_s2_w2_3 wwl_des wbl_op1_0900_s2_w2 0 sky130_fd_pr__nfet_01v8 L=0.15 W=0.42 nf=1 ad=0.1218 as=0.1218 pd=1.42 ps=1.42 nrd=0.69047619047619  nrs=0.69047619047619 sa=0 sb=0 sd=0 mult=1 m=1
XMRD_op1_0900_s2_w2_3 rbl_op1_0900_s2_w2 sn_op1_0900_s2_w2_3 rwl_des 0 sky130_fd_pr__nfet_01v8 L=0.15 W=0.42 nf=1 ad=0.1218 as=0.1218 pd=1.42 ps=1.42 nrd=0.69047619047619  nrs=0.69047619047619 sa=0 sb=0 sd=0 mult=1 m=1
csn_op1_0900_s2_w2_3 sn_op1_0900_s2_w2_3 0 {C_SN}
XMN1_op1_0900_s2_w2 rbl_op1_0900_s2_w2 ref_op1_0900_s2_w2 vn_op1_0900_s2_w2 0 sky130_fd_pr__nfet_01v8 L=0.15 W=1 nf=1 ad=0.29 as=0.29 pd=2.58 ps=2.58 mult=1 m=1
XMN2_op1_0900_s2_w2 ref_op1_0900_s2_w2 rbl_op1_0900_s2_w2 vn_op1_0900_s2_w2 0 sky130_fd_pr__nfet_01v8 L=0.15 W=1 nf=1 ad=0.29 as=0.29 pd=2.58 ps=2.58 mult=1 m=1
XMP1_op1_0900_s2_w2 rbl_op1_0900_s2_w2 ref_op1_0900_s2_w2 vp_op1_0900_s2_w2 vdd sky130_fd_pr__pfet_01v8 L=0.15 W=2 nf=1 ad=0.58 as=0.58 pd=4.58 ps=4.58 mult=1 m=1
XMP2_op1_0900_s2_w2 ref_op1_0900_s2_w2 rbl_op1_0900_s2_w2 vp_op1_0900_s2_w2 vdd sky130_fd_pr__pfet_01v8 L=0.15 W=2 nf=1 ad=0.58 as=0.58 pd=4.58 ps=4.58 mult=1 m=1
XMNF_op1_0900_s2_w2 vn_op1_0900_s2_w2 en_op1_0900_s2_w2 0 0 sky130_fd_pr__nfet_01v8 L=0.15 W=2 nf=1 ad=0.58 as=0.58 pd=4.58 ps=4.58 mult=1 m=1
XMPH_op1_0900_s2_w2 vp_op1_0900_s2_w2 enb_op1_0900_s2_w2 vdd vdd sky130_fd_pr__pfet_01v8 L=0.15 W=4 nf=1 ad=1.16 as=1.16 pd=8.58 ps=8.58 mult=1 m=1
bd_op1_0900_s2_w2 d_op1_0900_s2_w2 0 v=v(rbl_op1_0900_s2_w2)-v(ref_op1_0900_s2_w2)

* ---- instance 28: op1_0900_s2_w3 (t_en 6 ns, WWL 7..10 ns, release 12 ns) ----
ven_op1_0900_s2_w3  en_op1_0900_s2_w3  0 pwl(0 0 6.0000e-09 0 6.1000e-09 {VDD} 1.2000e-08 {VDD} 1.2100e-08 0)
venb_op1_0900_s2_w3 enb_op1_0900_s2_w3 0 pwl(0 {VDD} 6.0000e-09 {VDD} 6.1000e-09 0 1.2000e-08 0 1.2100e-08 {VDD})
vrs_op1_0900_s2_w3  rwls_op1_0900_s2_w3 0 pwl(0 {VDD} {T_READ} {VDD} {T_READ+TEDGE} 0 1.2000e-08 0 1.2100e-08 {VDD})
vww_op1_0900_s2_w3  wwl_op1_0900_s2_w3 0 pwl(0 0 7.0000e-09 0 7.1000e-09 {VDD} 1.0000e-08 {VDD} 1.0100e-08 0)
vwc_op1_0900_s2_w3  wbc_op1_0900_s2_w3 0 pwl(0 0 7.0000e-09 0 7.1000e-09 {VDD} 1.2000e-08 {VDD} 1.2100e-08 0)
swb_op1_0900_s2_w3 ref_op1_0900_s2_w3 wbl_op1_0900_s2_w3 wbc_op1_0900_s2_w3 0 swwbl
cwbl_op1_0900_s2_w3 wbl_op1_0900_s2_w3 0 {C_WBL}
spa_op1_0900_s2_w3 prea rbl_op1_0900_s2_w3 ctl 0 swpre
spr_op1_0900_s2_w3 pref ref_op1_0900_s2_w3 ctl 0 swpre
crbl_op1_0900_s2_w3 rbl_op1_0900_s2_w3 0 {C_RBL}
cref_op1_0900_s2_w3 ref_op1_0900_s2_w3 0 {C_RBL}   $ ASSUMPTION: ideal matched dummy load
XMWR_op1_0900_s2_w3_0 sn_op1_0900_s2_w3_0 wwl_op1_0900_s2_w3 wbl_op1_0900_s2_w3 0 sky130_fd_pr__nfet_01v8 L=0.15 W=0.42 nf=1 ad=0.1218 as=0.1218 pd=1.42 ps=1.42 nrd=0.69047619047619  nrs=0.69047619047619 sa=0 sb=0 sd=0 mult=1 m=1
XMRD_op1_0900_s2_w3_0 rbl_op1_0900_s2_w3 sn_op1_0900_s2_w3_0 rwls_op1_0900_s2_w3 0 sky130_fd_pr__nfet_01v8 L=0.15 W=0.42 nf=1 ad=0.1218 as=0.1218 pd=1.42 ps=1.42 nrd=0.69047619047619  nrs=0.69047619047619 sa=0 sb=0 sd=0 mult=1 m=1
csn_op1_0900_s2_w3_0 sn_op1_0900_s2_w3_0 0 {C_SN}
XMWR_op1_0900_s2_w3_1 sn_op1_0900_s2_w3_1 wwl_des wbl_op1_0900_s2_w3 0 sky130_fd_pr__nfet_01v8 L=0.15 W=0.42 nf=1 ad=0.1218 as=0.1218 pd=1.42 ps=1.42 nrd=0.69047619047619  nrs=0.69047619047619 sa=0 sb=0 sd=0 mult=1 m=1
XMRD_op1_0900_s2_w3_1 rbl_op1_0900_s2_w3 sn_op1_0900_s2_w3_1 rwl_des 0 sky130_fd_pr__nfet_01v8 L=0.15 W=0.42 nf=1 ad=0.1218 as=0.1218 pd=1.42 ps=1.42 nrd=0.69047619047619  nrs=0.69047619047619 sa=0 sb=0 sd=0 mult=1 m=1
csn_op1_0900_s2_w3_1 sn_op1_0900_s2_w3_1 0 {C_SN}
XMWR_op1_0900_s2_w3_2 sn_op1_0900_s2_w3_2 wwl_des wbl_op1_0900_s2_w3 0 sky130_fd_pr__nfet_01v8 L=0.15 W=0.42 nf=1 ad=0.1218 as=0.1218 pd=1.42 ps=1.42 nrd=0.69047619047619  nrs=0.69047619047619 sa=0 sb=0 sd=0 mult=1 m=1
XMRD_op1_0900_s2_w3_2 rbl_op1_0900_s2_w3 sn_op1_0900_s2_w3_2 rwl_des 0 sky130_fd_pr__nfet_01v8 L=0.15 W=0.42 nf=1 ad=0.1218 as=0.1218 pd=1.42 ps=1.42 nrd=0.69047619047619  nrs=0.69047619047619 sa=0 sb=0 sd=0 mult=1 m=1
csn_op1_0900_s2_w3_2 sn_op1_0900_s2_w3_2 0 {C_SN}
XMWR_op1_0900_s2_w3_3 sn_op1_0900_s2_w3_3 wwl_des wbl_op1_0900_s2_w3 0 sky130_fd_pr__nfet_01v8 L=0.15 W=0.42 nf=1 ad=0.1218 as=0.1218 pd=1.42 ps=1.42 nrd=0.69047619047619  nrs=0.69047619047619 sa=0 sb=0 sd=0 mult=1 m=1
XMRD_op1_0900_s2_w3_3 rbl_op1_0900_s2_w3 sn_op1_0900_s2_w3_3 rwl_des 0 sky130_fd_pr__nfet_01v8 L=0.15 W=0.42 nf=1 ad=0.1218 as=0.1218 pd=1.42 ps=1.42 nrd=0.69047619047619  nrs=0.69047619047619 sa=0 sb=0 sd=0 mult=1 m=1
csn_op1_0900_s2_w3_3 sn_op1_0900_s2_w3_3 0 {C_SN}
XMN1_op1_0900_s2_w3 rbl_op1_0900_s2_w3 ref_op1_0900_s2_w3 vn_op1_0900_s2_w3 0 sky130_fd_pr__nfet_01v8 L=0.15 W=1 nf=1 ad=0.29 as=0.29 pd=2.58 ps=2.58 mult=1 m=1
XMN2_op1_0900_s2_w3 ref_op1_0900_s2_w3 rbl_op1_0900_s2_w3 vn_op1_0900_s2_w3 0 sky130_fd_pr__nfet_01v8 L=0.15 W=1 nf=1 ad=0.29 as=0.29 pd=2.58 ps=2.58 mult=1 m=1
XMP1_op1_0900_s2_w3 rbl_op1_0900_s2_w3 ref_op1_0900_s2_w3 vp_op1_0900_s2_w3 vdd sky130_fd_pr__pfet_01v8 L=0.15 W=2 nf=1 ad=0.58 as=0.58 pd=4.58 ps=4.58 mult=1 m=1
XMP2_op1_0900_s2_w3 ref_op1_0900_s2_w3 rbl_op1_0900_s2_w3 vp_op1_0900_s2_w3 vdd sky130_fd_pr__pfet_01v8 L=0.15 W=2 nf=1 ad=0.58 as=0.58 pd=4.58 ps=4.58 mult=1 m=1
XMNF_op1_0900_s2_w3 vn_op1_0900_s2_w3 en_op1_0900_s2_w3 0 0 sky130_fd_pr__nfet_01v8 L=0.15 W=2 nf=1 ad=0.58 as=0.58 pd=4.58 ps=4.58 mult=1 m=1
XMPH_op1_0900_s2_w3 vp_op1_0900_s2_w3 enb_op1_0900_s2_w3 vdd vdd sky130_fd_pr__pfet_01v8 L=0.15 W=4 nf=1 ad=1.16 as=1.16 pd=8.58 ps=8.58 mult=1 m=1
bd_op1_0900_s2_w3 d_op1_0900_s2_w3 0 v=v(rbl_op1_0900_s2_w3)-v(ref_op1_0900_s2_w3)

* ---- instance 29: op1_0900_s2_w5 (t_en 6 ns, WWL 7..12 ns, release 14 ns) ----
ven_op1_0900_s2_w5  en_op1_0900_s2_w5  0 pwl(0 0 6.0000e-09 0 6.1000e-09 {VDD} 1.4000e-08 {VDD} 1.4100e-08 0)
venb_op1_0900_s2_w5 enb_op1_0900_s2_w5 0 pwl(0 {VDD} 6.0000e-09 {VDD} 6.1000e-09 0 1.4000e-08 0 1.4100e-08 {VDD})
vrs_op1_0900_s2_w5  rwls_op1_0900_s2_w5 0 pwl(0 {VDD} {T_READ} {VDD} {T_READ+TEDGE} 0 1.4000e-08 0 1.4100e-08 {VDD})
vww_op1_0900_s2_w5  wwl_op1_0900_s2_w5 0 pwl(0 0 7.0000e-09 0 7.1000e-09 {VDD} 1.2000e-08 {VDD} 1.2100e-08 0)
vwc_op1_0900_s2_w5  wbc_op1_0900_s2_w5 0 pwl(0 0 7.0000e-09 0 7.1000e-09 {VDD} 1.4000e-08 {VDD} 1.4100e-08 0)
swb_op1_0900_s2_w5 ref_op1_0900_s2_w5 wbl_op1_0900_s2_w5 wbc_op1_0900_s2_w5 0 swwbl
cwbl_op1_0900_s2_w5 wbl_op1_0900_s2_w5 0 {C_WBL}
spa_op1_0900_s2_w5 prea rbl_op1_0900_s2_w5 ctl 0 swpre
spr_op1_0900_s2_w5 pref ref_op1_0900_s2_w5 ctl 0 swpre
crbl_op1_0900_s2_w5 rbl_op1_0900_s2_w5 0 {C_RBL}
cref_op1_0900_s2_w5 ref_op1_0900_s2_w5 0 {C_RBL}   $ ASSUMPTION: ideal matched dummy load
XMWR_op1_0900_s2_w5_0 sn_op1_0900_s2_w5_0 wwl_op1_0900_s2_w5 wbl_op1_0900_s2_w5 0 sky130_fd_pr__nfet_01v8 L=0.15 W=0.42 nf=1 ad=0.1218 as=0.1218 pd=1.42 ps=1.42 nrd=0.69047619047619  nrs=0.69047619047619 sa=0 sb=0 sd=0 mult=1 m=1
XMRD_op1_0900_s2_w5_0 rbl_op1_0900_s2_w5 sn_op1_0900_s2_w5_0 rwls_op1_0900_s2_w5 0 sky130_fd_pr__nfet_01v8 L=0.15 W=0.42 nf=1 ad=0.1218 as=0.1218 pd=1.42 ps=1.42 nrd=0.69047619047619  nrs=0.69047619047619 sa=0 sb=0 sd=0 mult=1 m=1
csn_op1_0900_s2_w5_0 sn_op1_0900_s2_w5_0 0 {C_SN}
XMWR_op1_0900_s2_w5_1 sn_op1_0900_s2_w5_1 wwl_des wbl_op1_0900_s2_w5 0 sky130_fd_pr__nfet_01v8 L=0.15 W=0.42 nf=1 ad=0.1218 as=0.1218 pd=1.42 ps=1.42 nrd=0.69047619047619  nrs=0.69047619047619 sa=0 sb=0 sd=0 mult=1 m=1
XMRD_op1_0900_s2_w5_1 rbl_op1_0900_s2_w5 sn_op1_0900_s2_w5_1 rwl_des 0 sky130_fd_pr__nfet_01v8 L=0.15 W=0.42 nf=1 ad=0.1218 as=0.1218 pd=1.42 ps=1.42 nrd=0.69047619047619  nrs=0.69047619047619 sa=0 sb=0 sd=0 mult=1 m=1
csn_op1_0900_s2_w5_1 sn_op1_0900_s2_w5_1 0 {C_SN}
XMWR_op1_0900_s2_w5_2 sn_op1_0900_s2_w5_2 wwl_des wbl_op1_0900_s2_w5 0 sky130_fd_pr__nfet_01v8 L=0.15 W=0.42 nf=1 ad=0.1218 as=0.1218 pd=1.42 ps=1.42 nrd=0.69047619047619  nrs=0.69047619047619 sa=0 sb=0 sd=0 mult=1 m=1
XMRD_op1_0900_s2_w5_2 rbl_op1_0900_s2_w5 sn_op1_0900_s2_w5_2 rwl_des 0 sky130_fd_pr__nfet_01v8 L=0.15 W=0.42 nf=1 ad=0.1218 as=0.1218 pd=1.42 ps=1.42 nrd=0.69047619047619  nrs=0.69047619047619 sa=0 sb=0 sd=0 mult=1 m=1
csn_op1_0900_s2_w5_2 sn_op1_0900_s2_w5_2 0 {C_SN}
XMWR_op1_0900_s2_w5_3 sn_op1_0900_s2_w5_3 wwl_des wbl_op1_0900_s2_w5 0 sky130_fd_pr__nfet_01v8 L=0.15 W=0.42 nf=1 ad=0.1218 as=0.1218 pd=1.42 ps=1.42 nrd=0.69047619047619  nrs=0.69047619047619 sa=0 sb=0 sd=0 mult=1 m=1
XMRD_op1_0900_s2_w5_3 rbl_op1_0900_s2_w5 sn_op1_0900_s2_w5_3 rwl_des 0 sky130_fd_pr__nfet_01v8 L=0.15 W=0.42 nf=1 ad=0.1218 as=0.1218 pd=1.42 ps=1.42 nrd=0.69047619047619  nrs=0.69047619047619 sa=0 sb=0 sd=0 mult=1 m=1
csn_op1_0900_s2_w5_3 sn_op1_0900_s2_w5_3 0 {C_SN}
XMN1_op1_0900_s2_w5 rbl_op1_0900_s2_w5 ref_op1_0900_s2_w5 vn_op1_0900_s2_w5 0 sky130_fd_pr__nfet_01v8 L=0.15 W=1 nf=1 ad=0.29 as=0.29 pd=2.58 ps=2.58 mult=1 m=1
XMN2_op1_0900_s2_w5 ref_op1_0900_s2_w5 rbl_op1_0900_s2_w5 vn_op1_0900_s2_w5 0 sky130_fd_pr__nfet_01v8 L=0.15 W=1 nf=1 ad=0.29 as=0.29 pd=2.58 ps=2.58 mult=1 m=1
XMP1_op1_0900_s2_w5 rbl_op1_0900_s2_w5 ref_op1_0900_s2_w5 vp_op1_0900_s2_w5 vdd sky130_fd_pr__pfet_01v8 L=0.15 W=2 nf=1 ad=0.58 as=0.58 pd=4.58 ps=4.58 mult=1 m=1
XMP2_op1_0900_s2_w5 ref_op1_0900_s2_w5 rbl_op1_0900_s2_w5 vp_op1_0900_s2_w5 vdd sky130_fd_pr__pfet_01v8 L=0.15 W=2 nf=1 ad=0.58 as=0.58 pd=4.58 ps=4.58 mult=1 m=1
XMNF_op1_0900_s2_w5 vn_op1_0900_s2_w5 en_op1_0900_s2_w5 0 0 sky130_fd_pr__nfet_01v8 L=0.15 W=2 nf=1 ad=0.58 as=0.58 pd=4.58 ps=4.58 mult=1 m=1
XMPH_op1_0900_s2_w5 vp_op1_0900_s2_w5 enb_op1_0900_s2_w5 vdd vdd sky130_fd_pr__pfet_01v8 L=0.15 W=4 nf=1 ad=1.16 as=1.16 pd=8.58 ps=8.58 mult=1 m=1
bd_op1_0900_s2_w5 d_op1_0900_s2_w5 0 v=v(rbl_op1_0900_s2_w5)-v(ref_op1_0900_s2_w5)

* ---- instance 30: op1_0900_s2_w7p5 (t_en 6 ns, WWL 7..14.5 ns, release 16.5 ns) ----
ven_op1_0900_s2_w7p5  en_op1_0900_s2_w7p5  0 pwl(0 0 6.0000e-09 0 6.1000e-09 {VDD} 1.6500e-08 {VDD} 1.6600e-08 0)
venb_op1_0900_s2_w7p5 enb_op1_0900_s2_w7p5 0 pwl(0 {VDD} 6.0000e-09 {VDD} 6.1000e-09 0 1.6500e-08 0 1.6600e-08 {VDD})
vrs_op1_0900_s2_w7p5  rwls_op1_0900_s2_w7p5 0 pwl(0 {VDD} {T_READ} {VDD} {T_READ+TEDGE} 0 1.6500e-08 0 1.6600e-08 {VDD})
vww_op1_0900_s2_w7p5  wwl_op1_0900_s2_w7p5 0 pwl(0 0 7.0000e-09 0 7.1000e-09 {VDD} 1.4500e-08 {VDD} 1.4600e-08 0)
vwc_op1_0900_s2_w7p5  wbc_op1_0900_s2_w7p5 0 pwl(0 0 7.0000e-09 0 7.1000e-09 {VDD} 1.6500e-08 {VDD} 1.6600e-08 0)
swb_op1_0900_s2_w7p5 ref_op1_0900_s2_w7p5 wbl_op1_0900_s2_w7p5 wbc_op1_0900_s2_w7p5 0 swwbl
cwbl_op1_0900_s2_w7p5 wbl_op1_0900_s2_w7p5 0 {C_WBL}
spa_op1_0900_s2_w7p5 prea rbl_op1_0900_s2_w7p5 ctl 0 swpre
spr_op1_0900_s2_w7p5 pref ref_op1_0900_s2_w7p5 ctl 0 swpre
crbl_op1_0900_s2_w7p5 rbl_op1_0900_s2_w7p5 0 {C_RBL}
cref_op1_0900_s2_w7p5 ref_op1_0900_s2_w7p5 0 {C_RBL}   $ ASSUMPTION: ideal matched dummy load
XMWR_op1_0900_s2_w7p5_0 sn_op1_0900_s2_w7p5_0 wwl_op1_0900_s2_w7p5 wbl_op1_0900_s2_w7p5 0 sky130_fd_pr__nfet_01v8 L=0.15 W=0.42 nf=1 ad=0.1218 as=0.1218 pd=1.42 ps=1.42 nrd=0.69047619047619  nrs=0.69047619047619 sa=0 sb=0 sd=0 mult=1 m=1
XMRD_op1_0900_s2_w7p5_0 rbl_op1_0900_s2_w7p5 sn_op1_0900_s2_w7p5_0 rwls_op1_0900_s2_w7p5 0 sky130_fd_pr__nfet_01v8 L=0.15 W=0.42 nf=1 ad=0.1218 as=0.1218 pd=1.42 ps=1.42 nrd=0.69047619047619  nrs=0.69047619047619 sa=0 sb=0 sd=0 mult=1 m=1
csn_op1_0900_s2_w7p5_0 sn_op1_0900_s2_w7p5_0 0 {C_SN}
XMWR_op1_0900_s2_w7p5_1 sn_op1_0900_s2_w7p5_1 wwl_des wbl_op1_0900_s2_w7p5 0 sky130_fd_pr__nfet_01v8 L=0.15 W=0.42 nf=1 ad=0.1218 as=0.1218 pd=1.42 ps=1.42 nrd=0.69047619047619  nrs=0.69047619047619 sa=0 sb=0 sd=0 mult=1 m=1
XMRD_op1_0900_s2_w7p5_1 rbl_op1_0900_s2_w7p5 sn_op1_0900_s2_w7p5_1 rwl_des 0 sky130_fd_pr__nfet_01v8 L=0.15 W=0.42 nf=1 ad=0.1218 as=0.1218 pd=1.42 ps=1.42 nrd=0.69047619047619  nrs=0.69047619047619 sa=0 sb=0 sd=0 mult=1 m=1
csn_op1_0900_s2_w7p5_1 sn_op1_0900_s2_w7p5_1 0 {C_SN}
XMWR_op1_0900_s2_w7p5_2 sn_op1_0900_s2_w7p5_2 wwl_des wbl_op1_0900_s2_w7p5 0 sky130_fd_pr__nfet_01v8 L=0.15 W=0.42 nf=1 ad=0.1218 as=0.1218 pd=1.42 ps=1.42 nrd=0.69047619047619  nrs=0.69047619047619 sa=0 sb=0 sd=0 mult=1 m=1
XMRD_op1_0900_s2_w7p5_2 rbl_op1_0900_s2_w7p5 sn_op1_0900_s2_w7p5_2 rwl_des 0 sky130_fd_pr__nfet_01v8 L=0.15 W=0.42 nf=1 ad=0.1218 as=0.1218 pd=1.42 ps=1.42 nrd=0.69047619047619  nrs=0.69047619047619 sa=0 sb=0 sd=0 mult=1 m=1
csn_op1_0900_s2_w7p5_2 sn_op1_0900_s2_w7p5_2 0 {C_SN}
XMWR_op1_0900_s2_w7p5_3 sn_op1_0900_s2_w7p5_3 wwl_des wbl_op1_0900_s2_w7p5 0 sky130_fd_pr__nfet_01v8 L=0.15 W=0.42 nf=1 ad=0.1218 as=0.1218 pd=1.42 ps=1.42 nrd=0.69047619047619  nrs=0.69047619047619 sa=0 sb=0 sd=0 mult=1 m=1
XMRD_op1_0900_s2_w7p5_3 rbl_op1_0900_s2_w7p5 sn_op1_0900_s2_w7p5_3 rwl_des 0 sky130_fd_pr__nfet_01v8 L=0.15 W=0.42 nf=1 ad=0.1218 as=0.1218 pd=1.42 ps=1.42 nrd=0.69047619047619  nrs=0.69047619047619 sa=0 sb=0 sd=0 mult=1 m=1
csn_op1_0900_s2_w7p5_3 sn_op1_0900_s2_w7p5_3 0 {C_SN}
XMN1_op1_0900_s2_w7p5 rbl_op1_0900_s2_w7p5 ref_op1_0900_s2_w7p5 vn_op1_0900_s2_w7p5 0 sky130_fd_pr__nfet_01v8 L=0.15 W=1 nf=1 ad=0.29 as=0.29 pd=2.58 ps=2.58 mult=1 m=1
XMN2_op1_0900_s2_w7p5 ref_op1_0900_s2_w7p5 rbl_op1_0900_s2_w7p5 vn_op1_0900_s2_w7p5 0 sky130_fd_pr__nfet_01v8 L=0.15 W=1 nf=1 ad=0.29 as=0.29 pd=2.58 ps=2.58 mult=1 m=1
XMP1_op1_0900_s2_w7p5 rbl_op1_0900_s2_w7p5 ref_op1_0900_s2_w7p5 vp_op1_0900_s2_w7p5 vdd sky130_fd_pr__pfet_01v8 L=0.15 W=2 nf=1 ad=0.58 as=0.58 pd=4.58 ps=4.58 mult=1 m=1
XMP2_op1_0900_s2_w7p5 ref_op1_0900_s2_w7p5 rbl_op1_0900_s2_w7p5 vp_op1_0900_s2_w7p5 vdd sky130_fd_pr__pfet_01v8 L=0.15 W=2 nf=1 ad=0.58 as=0.58 pd=4.58 ps=4.58 mult=1 m=1
XMNF_op1_0900_s2_w7p5 vn_op1_0900_s2_w7p5 en_op1_0900_s2_w7p5 0 0 sky130_fd_pr__nfet_01v8 L=0.15 W=2 nf=1 ad=0.58 as=0.58 pd=4.58 ps=4.58 mult=1 m=1
XMPH_op1_0900_s2_w7p5 vp_op1_0900_s2_w7p5 enb_op1_0900_s2_w7p5 vdd vdd sky130_fd_pr__pfet_01v8 L=0.15 W=4 nf=1 ad=1.16 as=1.16 pd=8.58 ps=8.58 mult=1 m=1
bd_op1_0900_s2_w7p5 d_op1_0900_s2_w7p5 0 v=v(rbl_op1_0900_s2_w7p5)-v(ref_op1_0900_s2_w7p5)

* ---- instance 31: op1_0900_s2_w10 (t_en 6 ns, WWL 7..17 ns, release 19 ns) ----
ven_op1_0900_s2_w10  en_op1_0900_s2_w10  0 pwl(0 0 6.0000e-09 0 6.1000e-09 {VDD} 1.9000e-08 {VDD} 1.9100e-08 0)
venb_op1_0900_s2_w10 enb_op1_0900_s2_w10 0 pwl(0 {VDD} 6.0000e-09 {VDD} 6.1000e-09 0 1.9000e-08 0 1.9100e-08 {VDD})
vrs_op1_0900_s2_w10  rwls_op1_0900_s2_w10 0 pwl(0 {VDD} {T_READ} {VDD} {T_READ+TEDGE} 0 1.9000e-08 0 1.9100e-08 {VDD})
vww_op1_0900_s2_w10  wwl_op1_0900_s2_w10 0 pwl(0 0 7.0000e-09 0 7.1000e-09 {VDD} 1.7000e-08 {VDD} 1.7100e-08 0)
vwc_op1_0900_s2_w10  wbc_op1_0900_s2_w10 0 pwl(0 0 7.0000e-09 0 7.1000e-09 {VDD} 1.9000e-08 {VDD} 1.9100e-08 0)
swb_op1_0900_s2_w10 ref_op1_0900_s2_w10 wbl_op1_0900_s2_w10 wbc_op1_0900_s2_w10 0 swwbl
cwbl_op1_0900_s2_w10 wbl_op1_0900_s2_w10 0 {C_WBL}
spa_op1_0900_s2_w10 prea rbl_op1_0900_s2_w10 ctl 0 swpre
spr_op1_0900_s2_w10 pref ref_op1_0900_s2_w10 ctl 0 swpre
crbl_op1_0900_s2_w10 rbl_op1_0900_s2_w10 0 {C_RBL}
cref_op1_0900_s2_w10 ref_op1_0900_s2_w10 0 {C_RBL}   $ ASSUMPTION: ideal matched dummy load
XMWR_op1_0900_s2_w10_0 sn_op1_0900_s2_w10_0 wwl_op1_0900_s2_w10 wbl_op1_0900_s2_w10 0 sky130_fd_pr__nfet_01v8 L=0.15 W=0.42 nf=1 ad=0.1218 as=0.1218 pd=1.42 ps=1.42 nrd=0.69047619047619  nrs=0.69047619047619 sa=0 sb=0 sd=0 mult=1 m=1
XMRD_op1_0900_s2_w10_0 rbl_op1_0900_s2_w10 sn_op1_0900_s2_w10_0 rwls_op1_0900_s2_w10 0 sky130_fd_pr__nfet_01v8 L=0.15 W=0.42 nf=1 ad=0.1218 as=0.1218 pd=1.42 ps=1.42 nrd=0.69047619047619  nrs=0.69047619047619 sa=0 sb=0 sd=0 mult=1 m=1
csn_op1_0900_s2_w10_0 sn_op1_0900_s2_w10_0 0 {C_SN}
XMWR_op1_0900_s2_w10_1 sn_op1_0900_s2_w10_1 wwl_des wbl_op1_0900_s2_w10 0 sky130_fd_pr__nfet_01v8 L=0.15 W=0.42 nf=1 ad=0.1218 as=0.1218 pd=1.42 ps=1.42 nrd=0.69047619047619  nrs=0.69047619047619 sa=0 sb=0 sd=0 mult=1 m=1
XMRD_op1_0900_s2_w10_1 rbl_op1_0900_s2_w10 sn_op1_0900_s2_w10_1 rwl_des 0 sky130_fd_pr__nfet_01v8 L=0.15 W=0.42 nf=1 ad=0.1218 as=0.1218 pd=1.42 ps=1.42 nrd=0.69047619047619  nrs=0.69047619047619 sa=0 sb=0 sd=0 mult=1 m=1
csn_op1_0900_s2_w10_1 sn_op1_0900_s2_w10_1 0 {C_SN}
XMWR_op1_0900_s2_w10_2 sn_op1_0900_s2_w10_2 wwl_des wbl_op1_0900_s2_w10 0 sky130_fd_pr__nfet_01v8 L=0.15 W=0.42 nf=1 ad=0.1218 as=0.1218 pd=1.42 ps=1.42 nrd=0.69047619047619  nrs=0.69047619047619 sa=0 sb=0 sd=0 mult=1 m=1
XMRD_op1_0900_s2_w10_2 rbl_op1_0900_s2_w10 sn_op1_0900_s2_w10_2 rwl_des 0 sky130_fd_pr__nfet_01v8 L=0.15 W=0.42 nf=1 ad=0.1218 as=0.1218 pd=1.42 ps=1.42 nrd=0.69047619047619  nrs=0.69047619047619 sa=0 sb=0 sd=0 mult=1 m=1
csn_op1_0900_s2_w10_2 sn_op1_0900_s2_w10_2 0 {C_SN}
XMWR_op1_0900_s2_w10_3 sn_op1_0900_s2_w10_3 wwl_des wbl_op1_0900_s2_w10 0 sky130_fd_pr__nfet_01v8 L=0.15 W=0.42 nf=1 ad=0.1218 as=0.1218 pd=1.42 ps=1.42 nrd=0.69047619047619  nrs=0.69047619047619 sa=0 sb=0 sd=0 mult=1 m=1
XMRD_op1_0900_s2_w10_3 rbl_op1_0900_s2_w10 sn_op1_0900_s2_w10_3 rwl_des 0 sky130_fd_pr__nfet_01v8 L=0.15 W=0.42 nf=1 ad=0.1218 as=0.1218 pd=1.42 ps=1.42 nrd=0.69047619047619  nrs=0.69047619047619 sa=0 sb=0 sd=0 mult=1 m=1
csn_op1_0900_s2_w10_3 sn_op1_0900_s2_w10_3 0 {C_SN}
XMN1_op1_0900_s2_w10 rbl_op1_0900_s2_w10 ref_op1_0900_s2_w10 vn_op1_0900_s2_w10 0 sky130_fd_pr__nfet_01v8 L=0.15 W=1 nf=1 ad=0.29 as=0.29 pd=2.58 ps=2.58 mult=1 m=1
XMN2_op1_0900_s2_w10 ref_op1_0900_s2_w10 rbl_op1_0900_s2_w10 vn_op1_0900_s2_w10 0 sky130_fd_pr__nfet_01v8 L=0.15 W=1 nf=1 ad=0.29 as=0.29 pd=2.58 ps=2.58 mult=1 m=1
XMP1_op1_0900_s2_w10 rbl_op1_0900_s2_w10 ref_op1_0900_s2_w10 vp_op1_0900_s2_w10 vdd sky130_fd_pr__pfet_01v8 L=0.15 W=2 nf=1 ad=0.58 as=0.58 pd=4.58 ps=4.58 mult=1 m=1
XMP2_op1_0900_s2_w10 ref_op1_0900_s2_w10 rbl_op1_0900_s2_w10 vp_op1_0900_s2_w10 vdd sky130_fd_pr__pfet_01v8 L=0.15 W=2 nf=1 ad=0.58 as=0.58 pd=4.58 ps=4.58 mult=1 m=1
XMNF_op1_0900_s2_w10 vn_op1_0900_s2_w10 en_op1_0900_s2_w10 0 0 sky130_fd_pr__nfet_01v8 L=0.15 W=2 nf=1 ad=0.58 as=0.58 pd=4.58 ps=4.58 mult=1 m=1
XMPH_op1_0900_s2_w10 vp_op1_0900_s2_w10 enb_op1_0900_s2_w10 vdd vdd sky130_fd_pr__pfet_01v8 L=0.15 W=4 nf=1 ad=1.16 as=1.16 pd=8.58 ps=8.58 mult=1 m=1
bd_op1_0900_s2_w10 d_op1_0900_s2_w10 0 v=v(rbl_op1_0900_s2_w10)-v(ref_op1_0900_s2_w10)

* ---- instance 32: op1_0900_s2_w15 (t_en 6 ns, WWL 7..22 ns, release 24 ns) ----
ven_op1_0900_s2_w15  en_op1_0900_s2_w15  0 pwl(0 0 6.0000e-09 0 6.1000e-09 {VDD} 2.4000e-08 {VDD} 2.4100e-08 0)
venb_op1_0900_s2_w15 enb_op1_0900_s2_w15 0 pwl(0 {VDD} 6.0000e-09 {VDD} 6.1000e-09 0 2.4000e-08 0 2.4100e-08 {VDD})
vrs_op1_0900_s2_w15  rwls_op1_0900_s2_w15 0 pwl(0 {VDD} {T_READ} {VDD} {T_READ+TEDGE} 0 2.4000e-08 0 2.4100e-08 {VDD})
vww_op1_0900_s2_w15  wwl_op1_0900_s2_w15 0 pwl(0 0 7.0000e-09 0 7.1000e-09 {VDD} 2.2000e-08 {VDD} 2.2100e-08 0)
vwc_op1_0900_s2_w15  wbc_op1_0900_s2_w15 0 pwl(0 0 7.0000e-09 0 7.1000e-09 {VDD} 2.4000e-08 {VDD} 2.4100e-08 0)
swb_op1_0900_s2_w15 ref_op1_0900_s2_w15 wbl_op1_0900_s2_w15 wbc_op1_0900_s2_w15 0 swwbl
cwbl_op1_0900_s2_w15 wbl_op1_0900_s2_w15 0 {C_WBL}
spa_op1_0900_s2_w15 prea rbl_op1_0900_s2_w15 ctl 0 swpre
spr_op1_0900_s2_w15 pref ref_op1_0900_s2_w15 ctl 0 swpre
crbl_op1_0900_s2_w15 rbl_op1_0900_s2_w15 0 {C_RBL}
cref_op1_0900_s2_w15 ref_op1_0900_s2_w15 0 {C_RBL}   $ ASSUMPTION: ideal matched dummy load
XMWR_op1_0900_s2_w15_0 sn_op1_0900_s2_w15_0 wwl_op1_0900_s2_w15 wbl_op1_0900_s2_w15 0 sky130_fd_pr__nfet_01v8 L=0.15 W=0.42 nf=1 ad=0.1218 as=0.1218 pd=1.42 ps=1.42 nrd=0.69047619047619  nrs=0.69047619047619 sa=0 sb=0 sd=0 mult=1 m=1
XMRD_op1_0900_s2_w15_0 rbl_op1_0900_s2_w15 sn_op1_0900_s2_w15_0 rwls_op1_0900_s2_w15 0 sky130_fd_pr__nfet_01v8 L=0.15 W=0.42 nf=1 ad=0.1218 as=0.1218 pd=1.42 ps=1.42 nrd=0.69047619047619  nrs=0.69047619047619 sa=0 sb=0 sd=0 mult=1 m=1
csn_op1_0900_s2_w15_0 sn_op1_0900_s2_w15_0 0 {C_SN}
XMWR_op1_0900_s2_w15_1 sn_op1_0900_s2_w15_1 wwl_des wbl_op1_0900_s2_w15 0 sky130_fd_pr__nfet_01v8 L=0.15 W=0.42 nf=1 ad=0.1218 as=0.1218 pd=1.42 ps=1.42 nrd=0.69047619047619  nrs=0.69047619047619 sa=0 sb=0 sd=0 mult=1 m=1
XMRD_op1_0900_s2_w15_1 rbl_op1_0900_s2_w15 sn_op1_0900_s2_w15_1 rwl_des 0 sky130_fd_pr__nfet_01v8 L=0.15 W=0.42 nf=1 ad=0.1218 as=0.1218 pd=1.42 ps=1.42 nrd=0.69047619047619  nrs=0.69047619047619 sa=0 sb=0 sd=0 mult=1 m=1
csn_op1_0900_s2_w15_1 sn_op1_0900_s2_w15_1 0 {C_SN}
XMWR_op1_0900_s2_w15_2 sn_op1_0900_s2_w15_2 wwl_des wbl_op1_0900_s2_w15 0 sky130_fd_pr__nfet_01v8 L=0.15 W=0.42 nf=1 ad=0.1218 as=0.1218 pd=1.42 ps=1.42 nrd=0.69047619047619  nrs=0.69047619047619 sa=0 sb=0 sd=0 mult=1 m=1
XMRD_op1_0900_s2_w15_2 rbl_op1_0900_s2_w15 sn_op1_0900_s2_w15_2 rwl_des 0 sky130_fd_pr__nfet_01v8 L=0.15 W=0.42 nf=1 ad=0.1218 as=0.1218 pd=1.42 ps=1.42 nrd=0.69047619047619  nrs=0.69047619047619 sa=0 sb=0 sd=0 mult=1 m=1
csn_op1_0900_s2_w15_2 sn_op1_0900_s2_w15_2 0 {C_SN}
XMWR_op1_0900_s2_w15_3 sn_op1_0900_s2_w15_3 wwl_des wbl_op1_0900_s2_w15 0 sky130_fd_pr__nfet_01v8 L=0.15 W=0.42 nf=1 ad=0.1218 as=0.1218 pd=1.42 ps=1.42 nrd=0.69047619047619  nrs=0.69047619047619 sa=0 sb=0 sd=0 mult=1 m=1
XMRD_op1_0900_s2_w15_3 rbl_op1_0900_s2_w15 sn_op1_0900_s2_w15_3 rwl_des 0 sky130_fd_pr__nfet_01v8 L=0.15 W=0.42 nf=1 ad=0.1218 as=0.1218 pd=1.42 ps=1.42 nrd=0.69047619047619  nrs=0.69047619047619 sa=0 sb=0 sd=0 mult=1 m=1
csn_op1_0900_s2_w15_3 sn_op1_0900_s2_w15_3 0 {C_SN}
XMN1_op1_0900_s2_w15 rbl_op1_0900_s2_w15 ref_op1_0900_s2_w15 vn_op1_0900_s2_w15 0 sky130_fd_pr__nfet_01v8 L=0.15 W=1 nf=1 ad=0.29 as=0.29 pd=2.58 ps=2.58 mult=1 m=1
XMN2_op1_0900_s2_w15 ref_op1_0900_s2_w15 rbl_op1_0900_s2_w15 vn_op1_0900_s2_w15 0 sky130_fd_pr__nfet_01v8 L=0.15 W=1 nf=1 ad=0.29 as=0.29 pd=2.58 ps=2.58 mult=1 m=1
XMP1_op1_0900_s2_w15 rbl_op1_0900_s2_w15 ref_op1_0900_s2_w15 vp_op1_0900_s2_w15 vdd sky130_fd_pr__pfet_01v8 L=0.15 W=2 nf=1 ad=0.58 as=0.58 pd=4.58 ps=4.58 mult=1 m=1
XMP2_op1_0900_s2_w15 ref_op1_0900_s2_w15 rbl_op1_0900_s2_w15 vp_op1_0900_s2_w15 vdd sky130_fd_pr__pfet_01v8 L=0.15 W=2 nf=1 ad=0.58 as=0.58 pd=4.58 ps=4.58 mult=1 m=1
XMNF_op1_0900_s2_w15 vn_op1_0900_s2_w15 en_op1_0900_s2_w15 0 0 sky130_fd_pr__nfet_01v8 L=0.15 W=2 nf=1 ad=0.58 as=0.58 pd=4.58 ps=4.58 mult=1 m=1
XMPH_op1_0900_s2_w15 vp_op1_0900_s2_w15 enb_op1_0900_s2_w15 vdd vdd sky130_fd_pr__pfet_01v8 L=0.15 W=4 nf=1 ad=1.16 as=1.16 pd=8.58 ps=8.58 mult=1 m=1
bd_op1_0900_s2_w15 d_op1_0900_s2_w15 0 v=v(rbl_op1_0900_s2_w15)-v(ref_op1_0900_s2_w15)

* ---- instance 33: op1_0900_s2_w20 (t_en 6 ns, WWL 7..27 ns, release 29 ns) ----
ven_op1_0900_s2_w20  en_op1_0900_s2_w20  0 pwl(0 0 6.0000e-09 0 6.1000e-09 {VDD} 2.9000e-08 {VDD} 2.9100e-08 0)
venb_op1_0900_s2_w20 enb_op1_0900_s2_w20 0 pwl(0 {VDD} 6.0000e-09 {VDD} 6.1000e-09 0 2.9000e-08 0 2.9100e-08 {VDD})
vrs_op1_0900_s2_w20  rwls_op1_0900_s2_w20 0 pwl(0 {VDD} {T_READ} {VDD} {T_READ+TEDGE} 0 2.9000e-08 0 2.9100e-08 {VDD})
vww_op1_0900_s2_w20  wwl_op1_0900_s2_w20 0 pwl(0 0 7.0000e-09 0 7.1000e-09 {VDD} 2.7000e-08 {VDD} 2.7100e-08 0)
vwc_op1_0900_s2_w20  wbc_op1_0900_s2_w20 0 pwl(0 0 7.0000e-09 0 7.1000e-09 {VDD} 2.9000e-08 {VDD} 2.9100e-08 0)
swb_op1_0900_s2_w20 ref_op1_0900_s2_w20 wbl_op1_0900_s2_w20 wbc_op1_0900_s2_w20 0 swwbl
cwbl_op1_0900_s2_w20 wbl_op1_0900_s2_w20 0 {C_WBL}
spa_op1_0900_s2_w20 prea rbl_op1_0900_s2_w20 ctl 0 swpre
spr_op1_0900_s2_w20 pref ref_op1_0900_s2_w20 ctl 0 swpre
crbl_op1_0900_s2_w20 rbl_op1_0900_s2_w20 0 {C_RBL}
cref_op1_0900_s2_w20 ref_op1_0900_s2_w20 0 {C_RBL}   $ ASSUMPTION: ideal matched dummy load
XMWR_op1_0900_s2_w20_0 sn_op1_0900_s2_w20_0 wwl_op1_0900_s2_w20 wbl_op1_0900_s2_w20 0 sky130_fd_pr__nfet_01v8 L=0.15 W=0.42 nf=1 ad=0.1218 as=0.1218 pd=1.42 ps=1.42 nrd=0.69047619047619  nrs=0.69047619047619 sa=0 sb=0 sd=0 mult=1 m=1
XMRD_op1_0900_s2_w20_0 rbl_op1_0900_s2_w20 sn_op1_0900_s2_w20_0 rwls_op1_0900_s2_w20 0 sky130_fd_pr__nfet_01v8 L=0.15 W=0.42 nf=1 ad=0.1218 as=0.1218 pd=1.42 ps=1.42 nrd=0.69047619047619  nrs=0.69047619047619 sa=0 sb=0 sd=0 mult=1 m=1
csn_op1_0900_s2_w20_0 sn_op1_0900_s2_w20_0 0 {C_SN}
XMWR_op1_0900_s2_w20_1 sn_op1_0900_s2_w20_1 wwl_des wbl_op1_0900_s2_w20 0 sky130_fd_pr__nfet_01v8 L=0.15 W=0.42 nf=1 ad=0.1218 as=0.1218 pd=1.42 ps=1.42 nrd=0.69047619047619  nrs=0.69047619047619 sa=0 sb=0 sd=0 mult=1 m=1
XMRD_op1_0900_s2_w20_1 rbl_op1_0900_s2_w20 sn_op1_0900_s2_w20_1 rwl_des 0 sky130_fd_pr__nfet_01v8 L=0.15 W=0.42 nf=1 ad=0.1218 as=0.1218 pd=1.42 ps=1.42 nrd=0.69047619047619  nrs=0.69047619047619 sa=0 sb=0 sd=0 mult=1 m=1
csn_op1_0900_s2_w20_1 sn_op1_0900_s2_w20_1 0 {C_SN}
XMWR_op1_0900_s2_w20_2 sn_op1_0900_s2_w20_2 wwl_des wbl_op1_0900_s2_w20 0 sky130_fd_pr__nfet_01v8 L=0.15 W=0.42 nf=1 ad=0.1218 as=0.1218 pd=1.42 ps=1.42 nrd=0.69047619047619  nrs=0.69047619047619 sa=0 sb=0 sd=0 mult=1 m=1
XMRD_op1_0900_s2_w20_2 rbl_op1_0900_s2_w20 sn_op1_0900_s2_w20_2 rwl_des 0 sky130_fd_pr__nfet_01v8 L=0.15 W=0.42 nf=1 ad=0.1218 as=0.1218 pd=1.42 ps=1.42 nrd=0.69047619047619  nrs=0.69047619047619 sa=0 sb=0 sd=0 mult=1 m=1
csn_op1_0900_s2_w20_2 sn_op1_0900_s2_w20_2 0 {C_SN}
XMWR_op1_0900_s2_w20_3 sn_op1_0900_s2_w20_3 wwl_des wbl_op1_0900_s2_w20 0 sky130_fd_pr__nfet_01v8 L=0.15 W=0.42 nf=1 ad=0.1218 as=0.1218 pd=1.42 ps=1.42 nrd=0.69047619047619  nrs=0.69047619047619 sa=0 sb=0 sd=0 mult=1 m=1
XMRD_op1_0900_s2_w20_3 rbl_op1_0900_s2_w20 sn_op1_0900_s2_w20_3 rwl_des 0 sky130_fd_pr__nfet_01v8 L=0.15 W=0.42 nf=1 ad=0.1218 as=0.1218 pd=1.42 ps=1.42 nrd=0.69047619047619  nrs=0.69047619047619 sa=0 sb=0 sd=0 mult=1 m=1
csn_op1_0900_s2_w20_3 sn_op1_0900_s2_w20_3 0 {C_SN}
XMN1_op1_0900_s2_w20 rbl_op1_0900_s2_w20 ref_op1_0900_s2_w20 vn_op1_0900_s2_w20 0 sky130_fd_pr__nfet_01v8 L=0.15 W=1 nf=1 ad=0.29 as=0.29 pd=2.58 ps=2.58 mult=1 m=1
XMN2_op1_0900_s2_w20 ref_op1_0900_s2_w20 rbl_op1_0900_s2_w20 vn_op1_0900_s2_w20 0 sky130_fd_pr__nfet_01v8 L=0.15 W=1 nf=1 ad=0.29 as=0.29 pd=2.58 ps=2.58 mult=1 m=1
XMP1_op1_0900_s2_w20 rbl_op1_0900_s2_w20 ref_op1_0900_s2_w20 vp_op1_0900_s2_w20 vdd sky130_fd_pr__pfet_01v8 L=0.15 W=2 nf=1 ad=0.58 as=0.58 pd=4.58 ps=4.58 mult=1 m=1
XMP2_op1_0900_s2_w20 ref_op1_0900_s2_w20 rbl_op1_0900_s2_w20 vp_op1_0900_s2_w20 vdd sky130_fd_pr__pfet_01v8 L=0.15 W=2 nf=1 ad=0.58 as=0.58 pd=4.58 ps=4.58 mult=1 m=1
XMNF_op1_0900_s2_w20 vn_op1_0900_s2_w20 en_op1_0900_s2_w20 0 0 sky130_fd_pr__nfet_01v8 L=0.15 W=2 nf=1 ad=0.58 as=0.58 pd=4.58 ps=4.58 mult=1 m=1
XMPH_op1_0900_s2_w20 vp_op1_0900_s2_w20 enb_op1_0900_s2_w20 vdd vdd sky130_fd_pr__pfet_01v8 L=0.15 W=4 nf=1 ad=1.16 as=1.16 pd=8.58 ps=8.58 mult=1 m=1
bd_op1_0900_s2_w20 d_op1_0900_s2_w20 0 v=v(rbl_op1_0900_s2_w20)-v(ref_op1_0900_s2_w20)

* ---- instance 34: op1_0900_s2_w30 (t_en 6 ns, WWL 7..37 ns, release 39 ns) ----
ven_op1_0900_s2_w30  en_op1_0900_s2_w30  0 pwl(0 0 6.0000e-09 0 6.1000e-09 {VDD} 3.9000e-08 {VDD} 3.9100e-08 0)
venb_op1_0900_s2_w30 enb_op1_0900_s2_w30 0 pwl(0 {VDD} 6.0000e-09 {VDD} 6.1000e-09 0 3.9000e-08 0 3.9100e-08 {VDD})
vrs_op1_0900_s2_w30  rwls_op1_0900_s2_w30 0 pwl(0 {VDD} {T_READ} {VDD} {T_READ+TEDGE} 0 3.9000e-08 0 3.9100e-08 {VDD})
vww_op1_0900_s2_w30  wwl_op1_0900_s2_w30 0 pwl(0 0 7.0000e-09 0 7.1000e-09 {VDD} 3.7000e-08 {VDD} 3.7100e-08 0)
vwc_op1_0900_s2_w30  wbc_op1_0900_s2_w30 0 pwl(0 0 7.0000e-09 0 7.1000e-09 {VDD} 3.9000e-08 {VDD} 3.9100e-08 0)
swb_op1_0900_s2_w30 ref_op1_0900_s2_w30 wbl_op1_0900_s2_w30 wbc_op1_0900_s2_w30 0 swwbl
cwbl_op1_0900_s2_w30 wbl_op1_0900_s2_w30 0 {C_WBL}
spa_op1_0900_s2_w30 prea rbl_op1_0900_s2_w30 ctl 0 swpre
spr_op1_0900_s2_w30 pref ref_op1_0900_s2_w30 ctl 0 swpre
crbl_op1_0900_s2_w30 rbl_op1_0900_s2_w30 0 {C_RBL}
cref_op1_0900_s2_w30 ref_op1_0900_s2_w30 0 {C_RBL}   $ ASSUMPTION: ideal matched dummy load
XMWR_op1_0900_s2_w30_0 sn_op1_0900_s2_w30_0 wwl_op1_0900_s2_w30 wbl_op1_0900_s2_w30 0 sky130_fd_pr__nfet_01v8 L=0.15 W=0.42 nf=1 ad=0.1218 as=0.1218 pd=1.42 ps=1.42 nrd=0.69047619047619  nrs=0.69047619047619 sa=0 sb=0 sd=0 mult=1 m=1
XMRD_op1_0900_s2_w30_0 rbl_op1_0900_s2_w30 sn_op1_0900_s2_w30_0 rwls_op1_0900_s2_w30 0 sky130_fd_pr__nfet_01v8 L=0.15 W=0.42 nf=1 ad=0.1218 as=0.1218 pd=1.42 ps=1.42 nrd=0.69047619047619  nrs=0.69047619047619 sa=0 sb=0 sd=0 mult=1 m=1
csn_op1_0900_s2_w30_0 sn_op1_0900_s2_w30_0 0 {C_SN}
XMWR_op1_0900_s2_w30_1 sn_op1_0900_s2_w30_1 wwl_des wbl_op1_0900_s2_w30 0 sky130_fd_pr__nfet_01v8 L=0.15 W=0.42 nf=1 ad=0.1218 as=0.1218 pd=1.42 ps=1.42 nrd=0.69047619047619  nrs=0.69047619047619 sa=0 sb=0 sd=0 mult=1 m=1
XMRD_op1_0900_s2_w30_1 rbl_op1_0900_s2_w30 sn_op1_0900_s2_w30_1 rwl_des 0 sky130_fd_pr__nfet_01v8 L=0.15 W=0.42 nf=1 ad=0.1218 as=0.1218 pd=1.42 ps=1.42 nrd=0.69047619047619  nrs=0.69047619047619 sa=0 sb=0 sd=0 mult=1 m=1
csn_op1_0900_s2_w30_1 sn_op1_0900_s2_w30_1 0 {C_SN}
XMWR_op1_0900_s2_w30_2 sn_op1_0900_s2_w30_2 wwl_des wbl_op1_0900_s2_w30 0 sky130_fd_pr__nfet_01v8 L=0.15 W=0.42 nf=1 ad=0.1218 as=0.1218 pd=1.42 ps=1.42 nrd=0.69047619047619  nrs=0.69047619047619 sa=0 sb=0 sd=0 mult=1 m=1
XMRD_op1_0900_s2_w30_2 rbl_op1_0900_s2_w30 sn_op1_0900_s2_w30_2 rwl_des 0 sky130_fd_pr__nfet_01v8 L=0.15 W=0.42 nf=1 ad=0.1218 as=0.1218 pd=1.42 ps=1.42 nrd=0.69047619047619  nrs=0.69047619047619 sa=0 sb=0 sd=0 mult=1 m=1
csn_op1_0900_s2_w30_2 sn_op1_0900_s2_w30_2 0 {C_SN}
XMWR_op1_0900_s2_w30_3 sn_op1_0900_s2_w30_3 wwl_des wbl_op1_0900_s2_w30 0 sky130_fd_pr__nfet_01v8 L=0.15 W=0.42 nf=1 ad=0.1218 as=0.1218 pd=1.42 ps=1.42 nrd=0.69047619047619  nrs=0.69047619047619 sa=0 sb=0 sd=0 mult=1 m=1
XMRD_op1_0900_s2_w30_3 rbl_op1_0900_s2_w30 sn_op1_0900_s2_w30_3 rwl_des 0 sky130_fd_pr__nfet_01v8 L=0.15 W=0.42 nf=1 ad=0.1218 as=0.1218 pd=1.42 ps=1.42 nrd=0.69047619047619  nrs=0.69047619047619 sa=0 sb=0 sd=0 mult=1 m=1
csn_op1_0900_s2_w30_3 sn_op1_0900_s2_w30_3 0 {C_SN}
XMN1_op1_0900_s2_w30 rbl_op1_0900_s2_w30 ref_op1_0900_s2_w30 vn_op1_0900_s2_w30 0 sky130_fd_pr__nfet_01v8 L=0.15 W=1 nf=1 ad=0.29 as=0.29 pd=2.58 ps=2.58 mult=1 m=1
XMN2_op1_0900_s2_w30 ref_op1_0900_s2_w30 rbl_op1_0900_s2_w30 vn_op1_0900_s2_w30 0 sky130_fd_pr__nfet_01v8 L=0.15 W=1 nf=1 ad=0.29 as=0.29 pd=2.58 ps=2.58 mult=1 m=1
XMP1_op1_0900_s2_w30 rbl_op1_0900_s2_w30 ref_op1_0900_s2_w30 vp_op1_0900_s2_w30 vdd sky130_fd_pr__pfet_01v8 L=0.15 W=2 nf=1 ad=0.58 as=0.58 pd=4.58 ps=4.58 mult=1 m=1
XMP2_op1_0900_s2_w30 ref_op1_0900_s2_w30 rbl_op1_0900_s2_w30 vp_op1_0900_s2_w30 vdd sky130_fd_pr__pfet_01v8 L=0.15 W=2 nf=1 ad=0.58 as=0.58 pd=4.58 ps=4.58 mult=1 m=1
XMNF_op1_0900_s2_w30 vn_op1_0900_s2_w30 en_op1_0900_s2_w30 0 0 sky130_fd_pr__nfet_01v8 L=0.15 W=2 nf=1 ad=0.58 as=0.58 pd=4.58 ps=4.58 mult=1 m=1
XMPH_op1_0900_s2_w30 vp_op1_0900_s2_w30 enb_op1_0900_s2_w30 vdd vdd sky130_fd_pr__pfet_01v8 L=0.15 W=4 nf=1 ad=1.16 as=1.16 pd=8.58 ps=8.58 mult=1 m=1
bd_op1_0900_s2_w30 d_op1_0900_s2_w30 0 v=v(rbl_op1_0900_s2_w30)-v(ref_op1_0900_s2_w30)

* ---- instance 35: op1_0900_s2_w50 (t_en 6 ns, WWL 7..57 ns, release 59 ns) ----
ven_op1_0900_s2_w50  en_op1_0900_s2_w50  0 pwl(0 0 6.0000e-09 0 6.1000e-09 {VDD} 5.9000e-08 {VDD} 5.9100e-08 0)
venb_op1_0900_s2_w50 enb_op1_0900_s2_w50 0 pwl(0 {VDD} 6.0000e-09 {VDD} 6.1000e-09 0 5.9000e-08 0 5.9100e-08 {VDD})
vrs_op1_0900_s2_w50  rwls_op1_0900_s2_w50 0 pwl(0 {VDD} {T_READ} {VDD} {T_READ+TEDGE} 0 5.9000e-08 0 5.9100e-08 {VDD})
vww_op1_0900_s2_w50  wwl_op1_0900_s2_w50 0 pwl(0 0 7.0000e-09 0 7.1000e-09 {VDD} 5.7000e-08 {VDD} 5.7100e-08 0)
vwc_op1_0900_s2_w50  wbc_op1_0900_s2_w50 0 pwl(0 0 7.0000e-09 0 7.1000e-09 {VDD} 5.9000e-08 {VDD} 5.9100e-08 0)
swb_op1_0900_s2_w50 ref_op1_0900_s2_w50 wbl_op1_0900_s2_w50 wbc_op1_0900_s2_w50 0 swwbl
cwbl_op1_0900_s2_w50 wbl_op1_0900_s2_w50 0 {C_WBL}
spa_op1_0900_s2_w50 prea rbl_op1_0900_s2_w50 ctl 0 swpre
spr_op1_0900_s2_w50 pref ref_op1_0900_s2_w50 ctl 0 swpre
crbl_op1_0900_s2_w50 rbl_op1_0900_s2_w50 0 {C_RBL}
cref_op1_0900_s2_w50 ref_op1_0900_s2_w50 0 {C_RBL}   $ ASSUMPTION: ideal matched dummy load
XMWR_op1_0900_s2_w50_0 sn_op1_0900_s2_w50_0 wwl_op1_0900_s2_w50 wbl_op1_0900_s2_w50 0 sky130_fd_pr__nfet_01v8 L=0.15 W=0.42 nf=1 ad=0.1218 as=0.1218 pd=1.42 ps=1.42 nrd=0.69047619047619  nrs=0.69047619047619 sa=0 sb=0 sd=0 mult=1 m=1
XMRD_op1_0900_s2_w50_0 rbl_op1_0900_s2_w50 sn_op1_0900_s2_w50_0 rwls_op1_0900_s2_w50 0 sky130_fd_pr__nfet_01v8 L=0.15 W=0.42 nf=1 ad=0.1218 as=0.1218 pd=1.42 ps=1.42 nrd=0.69047619047619  nrs=0.69047619047619 sa=0 sb=0 sd=0 mult=1 m=1
csn_op1_0900_s2_w50_0 sn_op1_0900_s2_w50_0 0 {C_SN}
XMWR_op1_0900_s2_w50_1 sn_op1_0900_s2_w50_1 wwl_des wbl_op1_0900_s2_w50 0 sky130_fd_pr__nfet_01v8 L=0.15 W=0.42 nf=1 ad=0.1218 as=0.1218 pd=1.42 ps=1.42 nrd=0.69047619047619  nrs=0.69047619047619 sa=0 sb=0 sd=0 mult=1 m=1
XMRD_op1_0900_s2_w50_1 rbl_op1_0900_s2_w50 sn_op1_0900_s2_w50_1 rwl_des 0 sky130_fd_pr__nfet_01v8 L=0.15 W=0.42 nf=1 ad=0.1218 as=0.1218 pd=1.42 ps=1.42 nrd=0.69047619047619  nrs=0.69047619047619 sa=0 sb=0 sd=0 mult=1 m=1
csn_op1_0900_s2_w50_1 sn_op1_0900_s2_w50_1 0 {C_SN}
XMWR_op1_0900_s2_w50_2 sn_op1_0900_s2_w50_2 wwl_des wbl_op1_0900_s2_w50 0 sky130_fd_pr__nfet_01v8 L=0.15 W=0.42 nf=1 ad=0.1218 as=0.1218 pd=1.42 ps=1.42 nrd=0.69047619047619  nrs=0.69047619047619 sa=0 sb=0 sd=0 mult=1 m=1
XMRD_op1_0900_s2_w50_2 rbl_op1_0900_s2_w50 sn_op1_0900_s2_w50_2 rwl_des 0 sky130_fd_pr__nfet_01v8 L=0.15 W=0.42 nf=1 ad=0.1218 as=0.1218 pd=1.42 ps=1.42 nrd=0.69047619047619  nrs=0.69047619047619 sa=0 sb=0 sd=0 mult=1 m=1
csn_op1_0900_s2_w50_2 sn_op1_0900_s2_w50_2 0 {C_SN}
XMWR_op1_0900_s2_w50_3 sn_op1_0900_s2_w50_3 wwl_des wbl_op1_0900_s2_w50 0 sky130_fd_pr__nfet_01v8 L=0.15 W=0.42 nf=1 ad=0.1218 as=0.1218 pd=1.42 ps=1.42 nrd=0.69047619047619  nrs=0.69047619047619 sa=0 sb=0 sd=0 mult=1 m=1
XMRD_op1_0900_s2_w50_3 rbl_op1_0900_s2_w50 sn_op1_0900_s2_w50_3 rwl_des 0 sky130_fd_pr__nfet_01v8 L=0.15 W=0.42 nf=1 ad=0.1218 as=0.1218 pd=1.42 ps=1.42 nrd=0.69047619047619  nrs=0.69047619047619 sa=0 sb=0 sd=0 mult=1 m=1
csn_op1_0900_s2_w50_3 sn_op1_0900_s2_w50_3 0 {C_SN}
XMN1_op1_0900_s2_w50 rbl_op1_0900_s2_w50 ref_op1_0900_s2_w50 vn_op1_0900_s2_w50 0 sky130_fd_pr__nfet_01v8 L=0.15 W=1 nf=1 ad=0.29 as=0.29 pd=2.58 ps=2.58 mult=1 m=1
XMN2_op1_0900_s2_w50 ref_op1_0900_s2_w50 rbl_op1_0900_s2_w50 vn_op1_0900_s2_w50 0 sky130_fd_pr__nfet_01v8 L=0.15 W=1 nf=1 ad=0.29 as=0.29 pd=2.58 ps=2.58 mult=1 m=1
XMP1_op1_0900_s2_w50 rbl_op1_0900_s2_w50 ref_op1_0900_s2_w50 vp_op1_0900_s2_w50 vdd sky130_fd_pr__pfet_01v8 L=0.15 W=2 nf=1 ad=0.58 as=0.58 pd=4.58 ps=4.58 mult=1 m=1
XMP2_op1_0900_s2_w50 ref_op1_0900_s2_w50 rbl_op1_0900_s2_w50 vp_op1_0900_s2_w50 vdd sky130_fd_pr__pfet_01v8 L=0.15 W=2 nf=1 ad=0.58 as=0.58 pd=4.58 ps=4.58 mult=1 m=1
XMNF_op1_0900_s2_w50 vn_op1_0900_s2_w50 en_op1_0900_s2_w50 0 0 sky130_fd_pr__nfet_01v8 L=0.15 W=2 nf=1 ad=0.58 as=0.58 pd=4.58 ps=4.58 mult=1 m=1
XMPH_op1_0900_s2_w50 vp_op1_0900_s2_w50 enb_op1_0900_s2_w50 vdd vdd sky130_fd_pr__pfet_01v8 L=0.15 W=4 nf=1 ad=1.16 as=1.16 pd=8.58 ps=8.58 mult=1 m=1
bd_op1_0900_s2_w50 d_op1_0900_s2_w50 0 v=v(rbl_op1_0900_s2_w50)-v(ref_op1_0900_s2_w50)

* ---- instance 36: op1_0900_s5_w0p2 (t_en 9 ns, WWL 10..10.2 ns, release 12.2 ns) ----
ven_op1_0900_s5_w0p2  en_op1_0900_s5_w0p2  0 pwl(0 0 9.0000e-09 0 9.1000e-09 {VDD} 1.2200e-08 {VDD} 1.2300e-08 0)
venb_op1_0900_s5_w0p2 enb_op1_0900_s5_w0p2 0 pwl(0 {VDD} 9.0000e-09 {VDD} 9.1000e-09 0 1.2200e-08 0 1.2300e-08 {VDD})
vrs_op1_0900_s5_w0p2  rwls_op1_0900_s5_w0p2 0 pwl(0 {VDD} {T_READ} {VDD} {T_READ+TEDGE} 0 1.2200e-08 0 1.2300e-08 {VDD})
vww_op1_0900_s5_w0p2  wwl_op1_0900_s5_w0p2 0 pwl(0 0 1.0000e-08 0 1.0100e-08 {VDD} 1.0200e-08 {VDD} 1.0300e-08 0)
vwc_op1_0900_s5_w0p2  wbc_op1_0900_s5_w0p2 0 pwl(0 0 1.0000e-08 0 1.0100e-08 {VDD} 1.2200e-08 {VDD} 1.2300e-08 0)
swb_op1_0900_s5_w0p2 ref_op1_0900_s5_w0p2 wbl_op1_0900_s5_w0p2 wbc_op1_0900_s5_w0p2 0 swwbl
cwbl_op1_0900_s5_w0p2 wbl_op1_0900_s5_w0p2 0 {C_WBL}
spa_op1_0900_s5_w0p2 prea rbl_op1_0900_s5_w0p2 ctl 0 swpre
spr_op1_0900_s5_w0p2 pref ref_op1_0900_s5_w0p2 ctl 0 swpre
crbl_op1_0900_s5_w0p2 rbl_op1_0900_s5_w0p2 0 {C_RBL}
cref_op1_0900_s5_w0p2 ref_op1_0900_s5_w0p2 0 {C_RBL}   $ ASSUMPTION: ideal matched dummy load
XMWR_op1_0900_s5_w0p2_0 sn_op1_0900_s5_w0p2_0 wwl_op1_0900_s5_w0p2 wbl_op1_0900_s5_w0p2 0 sky130_fd_pr__nfet_01v8 L=0.15 W=0.42 nf=1 ad=0.1218 as=0.1218 pd=1.42 ps=1.42 nrd=0.69047619047619  nrs=0.69047619047619 sa=0 sb=0 sd=0 mult=1 m=1
XMRD_op1_0900_s5_w0p2_0 rbl_op1_0900_s5_w0p2 sn_op1_0900_s5_w0p2_0 rwls_op1_0900_s5_w0p2 0 sky130_fd_pr__nfet_01v8 L=0.15 W=0.42 nf=1 ad=0.1218 as=0.1218 pd=1.42 ps=1.42 nrd=0.69047619047619  nrs=0.69047619047619 sa=0 sb=0 sd=0 mult=1 m=1
csn_op1_0900_s5_w0p2_0 sn_op1_0900_s5_w0p2_0 0 {C_SN}
XMWR_op1_0900_s5_w0p2_1 sn_op1_0900_s5_w0p2_1 wwl_des wbl_op1_0900_s5_w0p2 0 sky130_fd_pr__nfet_01v8 L=0.15 W=0.42 nf=1 ad=0.1218 as=0.1218 pd=1.42 ps=1.42 nrd=0.69047619047619  nrs=0.69047619047619 sa=0 sb=0 sd=0 mult=1 m=1
XMRD_op1_0900_s5_w0p2_1 rbl_op1_0900_s5_w0p2 sn_op1_0900_s5_w0p2_1 rwl_des 0 sky130_fd_pr__nfet_01v8 L=0.15 W=0.42 nf=1 ad=0.1218 as=0.1218 pd=1.42 ps=1.42 nrd=0.69047619047619  nrs=0.69047619047619 sa=0 sb=0 sd=0 mult=1 m=1
csn_op1_0900_s5_w0p2_1 sn_op1_0900_s5_w0p2_1 0 {C_SN}
XMWR_op1_0900_s5_w0p2_2 sn_op1_0900_s5_w0p2_2 wwl_des wbl_op1_0900_s5_w0p2 0 sky130_fd_pr__nfet_01v8 L=0.15 W=0.42 nf=1 ad=0.1218 as=0.1218 pd=1.42 ps=1.42 nrd=0.69047619047619  nrs=0.69047619047619 sa=0 sb=0 sd=0 mult=1 m=1
XMRD_op1_0900_s5_w0p2_2 rbl_op1_0900_s5_w0p2 sn_op1_0900_s5_w0p2_2 rwl_des 0 sky130_fd_pr__nfet_01v8 L=0.15 W=0.42 nf=1 ad=0.1218 as=0.1218 pd=1.42 ps=1.42 nrd=0.69047619047619  nrs=0.69047619047619 sa=0 sb=0 sd=0 mult=1 m=1
csn_op1_0900_s5_w0p2_2 sn_op1_0900_s5_w0p2_2 0 {C_SN}
XMWR_op1_0900_s5_w0p2_3 sn_op1_0900_s5_w0p2_3 wwl_des wbl_op1_0900_s5_w0p2 0 sky130_fd_pr__nfet_01v8 L=0.15 W=0.42 nf=1 ad=0.1218 as=0.1218 pd=1.42 ps=1.42 nrd=0.69047619047619  nrs=0.69047619047619 sa=0 sb=0 sd=0 mult=1 m=1
XMRD_op1_0900_s5_w0p2_3 rbl_op1_0900_s5_w0p2 sn_op1_0900_s5_w0p2_3 rwl_des 0 sky130_fd_pr__nfet_01v8 L=0.15 W=0.42 nf=1 ad=0.1218 as=0.1218 pd=1.42 ps=1.42 nrd=0.69047619047619  nrs=0.69047619047619 sa=0 sb=0 sd=0 mult=1 m=1
csn_op1_0900_s5_w0p2_3 sn_op1_0900_s5_w0p2_3 0 {C_SN}
XMN1_op1_0900_s5_w0p2 rbl_op1_0900_s5_w0p2 ref_op1_0900_s5_w0p2 vn_op1_0900_s5_w0p2 0 sky130_fd_pr__nfet_01v8 L=0.15 W=1 nf=1 ad=0.29 as=0.29 pd=2.58 ps=2.58 mult=1 m=1
XMN2_op1_0900_s5_w0p2 ref_op1_0900_s5_w0p2 rbl_op1_0900_s5_w0p2 vn_op1_0900_s5_w0p2 0 sky130_fd_pr__nfet_01v8 L=0.15 W=1 nf=1 ad=0.29 as=0.29 pd=2.58 ps=2.58 mult=1 m=1
XMP1_op1_0900_s5_w0p2 rbl_op1_0900_s5_w0p2 ref_op1_0900_s5_w0p2 vp_op1_0900_s5_w0p2 vdd sky130_fd_pr__pfet_01v8 L=0.15 W=2 nf=1 ad=0.58 as=0.58 pd=4.58 ps=4.58 mult=1 m=1
XMP2_op1_0900_s5_w0p2 ref_op1_0900_s5_w0p2 rbl_op1_0900_s5_w0p2 vp_op1_0900_s5_w0p2 vdd sky130_fd_pr__pfet_01v8 L=0.15 W=2 nf=1 ad=0.58 as=0.58 pd=4.58 ps=4.58 mult=1 m=1
XMNF_op1_0900_s5_w0p2 vn_op1_0900_s5_w0p2 en_op1_0900_s5_w0p2 0 0 sky130_fd_pr__nfet_01v8 L=0.15 W=2 nf=1 ad=0.58 as=0.58 pd=4.58 ps=4.58 mult=1 m=1
XMPH_op1_0900_s5_w0p2 vp_op1_0900_s5_w0p2 enb_op1_0900_s5_w0p2 vdd vdd sky130_fd_pr__pfet_01v8 L=0.15 W=4 nf=1 ad=1.16 as=1.16 pd=8.58 ps=8.58 mult=1 m=1
bd_op1_0900_s5_w0p2 d_op1_0900_s5_w0p2 0 v=v(rbl_op1_0900_s5_w0p2)-v(ref_op1_0900_s5_w0p2)

* ---- instance 37: op1_0900_s5_w0p5 (t_en 9 ns, WWL 10..10.5 ns, release 12.5 ns) ----
ven_op1_0900_s5_w0p5  en_op1_0900_s5_w0p5  0 pwl(0 0 9.0000e-09 0 9.1000e-09 {VDD} 1.2500e-08 {VDD} 1.2600e-08 0)
venb_op1_0900_s5_w0p5 enb_op1_0900_s5_w0p5 0 pwl(0 {VDD} 9.0000e-09 {VDD} 9.1000e-09 0 1.2500e-08 0 1.2600e-08 {VDD})
vrs_op1_0900_s5_w0p5  rwls_op1_0900_s5_w0p5 0 pwl(0 {VDD} {T_READ} {VDD} {T_READ+TEDGE} 0 1.2500e-08 0 1.2600e-08 {VDD})
vww_op1_0900_s5_w0p5  wwl_op1_0900_s5_w0p5 0 pwl(0 0 1.0000e-08 0 1.0100e-08 {VDD} 1.0500e-08 {VDD} 1.0600e-08 0)
vwc_op1_0900_s5_w0p5  wbc_op1_0900_s5_w0p5 0 pwl(0 0 1.0000e-08 0 1.0100e-08 {VDD} 1.2500e-08 {VDD} 1.2600e-08 0)
swb_op1_0900_s5_w0p5 ref_op1_0900_s5_w0p5 wbl_op1_0900_s5_w0p5 wbc_op1_0900_s5_w0p5 0 swwbl
cwbl_op1_0900_s5_w0p5 wbl_op1_0900_s5_w0p5 0 {C_WBL}
spa_op1_0900_s5_w0p5 prea rbl_op1_0900_s5_w0p5 ctl 0 swpre
spr_op1_0900_s5_w0p5 pref ref_op1_0900_s5_w0p5 ctl 0 swpre
crbl_op1_0900_s5_w0p5 rbl_op1_0900_s5_w0p5 0 {C_RBL}
cref_op1_0900_s5_w0p5 ref_op1_0900_s5_w0p5 0 {C_RBL}   $ ASSUMPTION: ideal matched dummy load
XMWR_op1_0900_s5_w0p5_0 sn_op1_0900_s5_w0p5_0 wwl_op1_0900_s5_w0p5 wbl_op1_0900_s5_w0p5 0 sky130_fd_pr__nfet_01v8 L=0.15 W=0.42 nf=1 ad=0.1218 as=0.1218 pd=1.42 ps=1.42 nrd=0.69047619047619  nrs=0.69047619047619 sa=0 sb=0 sd=0 mult=1 m=1
XMRD_op1_0900_s5_w0p5_0 rbl_op1_0900_s5_w0p5 sn_op1_0900_s5_w0p5_0 rwls_op1_0900_s5_w0p5 0 sky130_fd_pr__nfet_01v8 L=0.15 W=0.42 nf=1 ad=0.1218 as=0.1218 pd=1.42 ps=1.42 nrd=0.69047619047619  nrs=0.69047619047619 sa=0 sb=0 sd=0 mult=1 m=1
csn_op1_0900_s5_w0p5_0 sn_op1_0900_s5_w0p5_0 0 {C_SN}
XMWR_op1_0900_s5_w0p5_1 sn_op1_0900_s5_w0p5_1 wwl_des wbl_op1_0900_s5_w0p5 0 sky130_fd_pr__nfet_01v8 L=0.15 W=0.42 nf=1 ad=0.1218 as=0.1218 pd=1.42 ps=1.42 nrd=0.69047619047619  nrs=0.69047619047619 sa=0 sb=0 sd=0 mult=1 m=1
XMRD_op1_0900_s5_w0p5_1 rbl_op1_0900_s5_w0p5 sn_op1_0900_s5_w0p5_1 rwl_des 0 sky130_fd_pr__nfet_01v8 L=0.15 W=0.42 nf=1 ad=0.1218 as=0.1218 pd=1.42 ps=1.42 nrd=0.69047619047619  nrs=0.69047619047619 sa=0 sb=0 sd=0 mult=1 m=1
csn_op1_0900_s5_w0p5_1 sn_op1_0900_s5_w0p5_1 0 {C_SN}
XMWR_op1_0900_s5_w0p5_2 sn_op1_0900_s5_w0p5_2 wwl_des wbl_op1_0900_s5_w0p5 0 sky130_fd_pr__nfet_01v8 L=0.15 W=0.42 nf=1 ad=0.1218 as=0.1218 pd=1.42 ps=1.42 nrd=0.69047619047619  nrs=0.69047619047619 sa=0 sb=0 sd=0 mult=1 m=1
XMRD_op1_0900_s5_w0p5_2 rbl_op1_0900_s5_w0p5 sn_op1_0900_s5_w0p5_2 rwl_des 0 sky130_fd_pr__nfet_01v8 L=0.15 W=0.42 nf=1 ad=0.1218 as=0.1218 pd=1.42 ps=1.42 nrd=0.69047619047619  nrs=0.69047619047619 sa=0 sb=0 sd=0 mult=1 m=1
csn_op1_0900_s5_w0p5_2 sn_op1_0900_s5_w0p5_2 0 {C_SN}
XMWR_op1_0900_s5_w0p5_3 sn_op1_0900_s5_w0p5_3 wwl_des wbl_op1_0900_s5_w0p5 0 sky130_fd_pr__nfet_01v8 L=0.15 W=0.42 nf=1 ad=0.1218 as=0.1218 pd=1.42 ps=1.42 nrd=0.69047619047619  nrs=0.69047619047619 sa=0 sb=0 sd=0 mult=1 m=1
XMRD_op1_0900_s5_w0p5_3 rbl_op1_0900_s5_w0p5 sn_op1_0900_s5_w0p5_3 rwl_des 0 sky130_fd_pr__nfet_01v8 L=0.15 W=0.42 nf=1 ad=0.1218 as=0.1218 pd=1.42 ps=1.42 nrd=0.69047619047619  nrs=0.69047619047619 sa=0 sb=0 sd=0 mult=1 m=1
csn_op1_0900_s5_w0p5_3 sn_op1_0900_s5_w0p5_3 0 {C_SN}
XMN1_op1_0900_s5_w0p5 rbl_op1_0900_s5_w0p5 ref_op1_0900_s5_w0p5 vn_op1_0900_s5_w0p5 0 sky130_fd_pr__nfet_01v8 L=0.15 W=1 nf=1 ad=0.29 as=0.29 pd=2.58 ps=2.58 mult=1 m=1
XMN2_op1_0900_s5_w0p5 ref_op1_0900_s5_w0p5 rbl_op1_0900_s5_w0p5 vn_op1_0900_s5_w0p5 0 sky130_fd_pr__nfet_01v8 L=0.15 W=1 nf=1 ad=0.29 as=0.29 pd=2.58 ps=2.58 mult=1 m=1
XMP1_op1_0900_s5_w0p5 rbl_op1_0900_s5_w0p5 ref_op1_0900_s5_w0p5 vp_op1_0900_s5_w0p5 vdd sky130_fd_pr__pfet_01v8 L=0.15 W=2 nf=1 ad=0.58 as=0.58 pd=4.58 ps=4.58 mult=1 m=1
XMP2_op1_0900_s5_w0p5 ref_op1_0900_s5_w0p5 rbl_op1_0900_s5_w0p5 vp_op1_0900_s5_w0p5 vdd sky130_fd_pr__pfet_01v8 L=0.15 W=2 nf=1 ad=0.58 as=0.58 pd=4.58 ps=4.58 mult=1 m=1
XMNF_op1_0900_s5_w0p5 vn_op1_0900_s5_w0p5 en_op1_0900_s5_w0p5 0 0 sky130_fd_pr__nfet_01v8 L=0.15 W=2 nf=1 ad=0.58 as=0.58 pd=4.58 ps=4.58 mult=1 m=1
XMPH_op1_0900_s5_w0p5 vp_op1_0900_s5_w0p5 enb_op1_0900_s5_w0p5 vdd vdd sky130_fd_pr__pfet_01v8 L=0.15 W=4 nf=1 ad=1.16 as=1.16 pd=8.58 ps=8.58 mult=1 m=1
bd_op1_0900_s5_w0p5 d_op1_0900_s5_w0p5 0 v=v(rbl_op1_0900_s5_w0p5)-v(ref_op1_0900_s5_w0p5)

* ---- instance 38: op1_0900_s5_w1 (t_en 9 ns, WWL 10..11 ns, release 13 ns) ----
ven_op1_0900_s5_w1  en_op1_0900_s5_w1  0 pwl(0 0 9.0000e-09 0 9.1000e-09 {VDD} 1.3000e-08 {VDD} 1.3100e-08 0)
venb_op1_0900_s5_w1 enb_op1_0900_s5_w1 0 pwl(0 {VDD} 9.0000e-09 {VDD} 9.1000e-09 0 1.3000e-08 0 1.3100e-08 {VDD})
vrs_op1_0900_s5_w1  rwls_op1_0900_s5_w1 0 pwl(0 {VDD} {T_READ} {VDD} {T_READ+TEDGE} 0 1.3000e-08 0 1.3100e-08 {VDD})
vww_op1_0900_s5_w1  wwl_op1_0900_s5_w1 0 pwl(0 0 1.0000e-08 0 1.0100e-08 {VDD} 1.1000e-08 {VDD} 1.1100e-08 0)
vwc_op1_0900_s5_w1  wbc_op1_0900_s5_w1 0 pwl(0 0 1.0000e-08 0 1.0100e-08 {VDD} 1.3000e-08 {VDD} 1.3100e-08 0)
swb_op1_0900_s5_w1 ref_op1_0900_s5_w1 wbl_op1_0900_s5_w1 wbc_op1_0900_s5_w1 0 swwbl
cwbl_op1_0900_s5_w1 wbl_op1_0900_s5_w1 0 {C_WBL}
spa_op1_0900_s5_w1 prea rbl_op1_0900_s5_w1 ctl 0 swpre
spr_op1_0900_s5_w1 pref ref_op1_0900_s5_w1 ctl 0 swpre
crbl_op1_0900_s5_w1 rbl_op1_0900_s5_w1 0 {C_RBL}
cref_op1_0900_s5_w1 ref_op1_0900_s5_w1 0 {C_RBL}   $ ASSUMPTION: ideal matched dummy load
XMWR_op1_0900_s5_w1_0 sn_op1_0900_s5_w1_0 wwl_op1_0900_s5_w1 wbl_op1_0900_s5_w1 0 sky130_fd_pr__nfet_01v8 L=0.15 W=0.42 nf=1 ad=0.1218 as=0.1218 pd=1.42 ps=1.42 nrd=0.69047619047619  nrs=0.69047619047619 sa=0 sb=0 sd=0 mult=1 m=1
XMRD_op1_0900_s5_w1_0 rbl_op1_0900_s5_w1 sn_op1_0900_s5_w1_0 rwls_op1_0900_s5_w1 0 sky130_fd_pr__nfet_01v8 L=0.15 W=0.42 nf=1 ad=0.1218 as=0.1218 pd=1.42 ps=1.42 nrd=0.69047619047619  nrs=0.69047619047619 sa=0 sb=0 sd=0 mult=1 m=1
csn_op1_0900_s5_w1_0 sn_op1_0900_s5_w1_0 0 {C_SN}
XMWR_op1_0900_s5_w1_1 sn_op1_0900_s5_w1_1 wwl_des wbl_op1_0900_s5_w1 0 sky130_fd_pr__nfet_01v8 L=0.15 W=0.42 nf=1 ad=0.1218 as=0.1218 pd=1.42 ps=1.42 nrd=0.69047619047619  nrs=0.69047619047619 sa=0 sb=0 sd=0 mult=1 m=1
XMRD_op1_0900_s5_w1_1 rbl_op1_0900_s5_w1 sn_op1_0900_s5_w1_1 rwl_des 0 sky130_fd_pr__nfet_01v8 L=0.15 W=0.42 nf=1 ad=0.1218 as=0.1218 pd=1.42 ps=1.42 nrd=0.69047619047619  nrs=0.69047619047619 sa=0 sb=0 sd=0 mult=1 m=1
csn_op1_0900_s5_w1_1 sn_op1_0900_s5_w1_1 0 {C_SN}
XMWR_op1_0900_s5_w1_2 sn_op1_0900_s5_w1_2 wwl_des wbl_op1_0900_s5_w1 0 sky130_fd_pr__nfet_01v8 L=0.15 W=0.42 nf=1 ad=0.1218 as=0.1218 pd=1.42 ps=1.42 nrd=0.69047619047619  nrs=0.69047619047619 sa=0 sb=0 sd=0 mult=1 m=1
XMRD_op1_0900_s5_w1_2 rbl_op1_0900_s5_w1 sn_op1_0900_s5_w1_2 rwl_des 0 sky130_fd_pr__nfet_01v8 L=0.15 W=0.42 nf=1 ad=0.1218 as=0.1218 pd=1.42 ps=1.42 nrd=0.69047619047619  nrs=0.69047619047619 sa=0 sb=0 sd=0 mult=1 m=1
csn_op1_0900_s5_w1_2 sn_op1_0900_s5_w1_2 0 {C_SN}
XMWR_op1_0900_s5_w1_3 sn_op1_0900_s5_w1_3 wwl_des wbl_op1_0900_s5_w1 0 sky130_fd_pr__nfet_01v8 L=0.15 W=0.42 nf=1 ad=0.1218 as=0.1218 pd=1.42 ps=1.42 nrd=0.69047619047619  nrs=0.69047619047619 sa=0 sb=0 sd=0 mult=1 m=1
XMRD_op1_0900_s5_w1_3 rbl_op1_0900_s5_w1 sn_op1_0900_s5_w1_3 rwl_des 0 sky130_fd_pr__nfet_01v8 L=0.15 W=0.42 nf=1 ad=0.1218 as=0.1218 pd=1.42 ps=1.42 nrd=0.69047619047619  nrs=0.69047619047619 sa=0 sb=0 sd=0 mult=1 m=1
csn_op1_0900_s5_w1_3 sn_op1_0900_s5_w1_3 0 {C_SN}
XMN1_op1_0900_s5_w1 rbl_op1_0900_s5_w1 ref_op1_0900_s5_w1 vn_op1_0900_s5_w1 0 sky130_fd_pr__nfet_01v8 L=0.15 W=1 nf=1 ad=0.29 as=0.29 pd=2.58 ps=2.58 mult=1 m=1
XMN2_op1_0900_s5_w1 ref_op1_0900_s5_w1 rbl_op1_0900_s5_w1 vn_op1_0900_s5_w1 0 sky130_fd_pr__nfet_01v8 L=0.15 W=1 nf=1 ad=0.29 as=0.29 pd=2.58 ps=2.58 mult=1 m=1
XMP1_op1_0900_s5_w1 rbl_op1_0900_s5_w1 ref_op1_0900_s5_w1 vp_op1_0900_s5_w1 vdd sky130_fd_pr__pfet_01v8 L=0.15 W=2 nf=1 ad=0.58 as=0.58 pd=4.58 ps=4.58 mult=1 m=1
XMP2_op1_0900_s5_w1 ref_op1_0900_s5_w1 rbl_op1_0900_s5_w1 vp_op1_0900_s5_w1 vdd sky130_fd_pr__pfet_01v8 L=0.15 W=2 nf=1 ad=0.58 as=0.58 pd=4.58 ps=4.58 mult=1 m=1
XMNF_op1_0900_s5_w1 vn_op1_0900_s5_w1 en_op1_0900_s5_w1 0 0 sky130_fd_pr__nfet_01v8 L=0.15 W=2 nf=1 ad=0.58 as=0.58 pd=4.58 ps=4.58 mult=1 m=1
XMPH_op1_0900_s5_w1 vp_op1_0900_s5_w1 enb_op1_0900_s5_w1 vdd vdd sky130_fd_pr__pfet_01v8 L=0.15 W=4 nf=1 ad=1.16 as=1.16 pd=8.58 ps=8.58 mult=1 m=1
bd_op1_0900_s5_w1 d_op1_0900_s5_w1 0 v=v(rbl_op1_0900_s5_w1)-v(ref_op1_0900_s5_w1)

* ---- instance 39: op1_0900_s5_w2 (t_en 9 ns, WWL 10..12 ns, release 14 ns) ----
ven_op1_0900_s5_w2  en_op1_0900_s5_w2  0 pwl(0 0 9.0000e-09 0 9.1000e-09 {VDD} 1.4000e-08 {VDD} 1.4100e-08 0)
venb_op1_0900_s5_w2 enb_op1_0900_s5_w2 0 pwl(0 {VDD} 9.0000e-09 {VDD} 9.1000e-09 0 1.4000e-08 0 1.4100e-08 {VDD})
vrs_op1_0900_s5_w2  rwls_op1_0900_s5_w2 0 pwl(0 {VDD} {T_READ} {VDD} {T_READ+TEDGE} 0 1.4000e-08 0 1.4100e-08 {VDD})
vww_op1_0900_s5_w2  wwl_op1_0900_s5_w2 0 pwl(0 0 1.0000e-08 0 1.0100e-08 {VDD} 1.2000e-08 {VDD} 1.2100e-08 0)
vwc_op1_0900_s5_w2  wbc_op1_0900_s5_w2 0 pwl(0 0 1.0000e-08 0 1.0100e-08 {VDD} 1.4000e-08 {VDD} 1.4100e-08 0)
swb_op1_0900_s5_w2 ref_op1_0900_s5_w2 wbl_op1_0900_s5_w2 wbc_op1_0900_s5_w2 0 swwbl
cwbl_op1_0900_s5_w2 wbl_op1_0900_s5_w2 0 {C_WBL}
spa_op1_0900_s5_w2 prea rbl_op1_0900_s5_w2 ctl 0 swpre
spr_op1_0900_s5_w2 pref ref_op1_0900_s5_w2 ctl 0 swpre
crbl_op1_0900_s5_w2 rbl_op1_0900_s5_w2 0 {C_RBL}
cref_op1_0900_s5_w2 ref_op1_0900_s5_w2 0 {C_RBL}   $ ASSUMPTION: ideal matched dummy load
XMWR_op1_0900_s5_w2_0 sn_op1_0900_s5_w2_0 wwl_op1_0900_s5_w2 wbl_op1_0900_s5_w2 0 sky130_fd_pr__nfet_01v8 L=0.15 W=0.42 nf=1 ad=0.1218 as=0.1218 pd=1.42 ps=1.42 nrd=0.69047619047619  nrs=0.69047619047619 sa=0 sb=0 sd=0 mult=1 m=1
XMRD_op1_0900_s5_w2_0 rbl_op1_0900_s5_w2 sn_op1_0900_s5_w2_0 rwls_op1_0900_s5_w2 0 sky130_fd_pr__nfet_01v8 L=0.15 W=0.42 nf=1 ad=0.1218 as=0.1218 pd=1.42 ps=1.42 nrd=0.69047619047619  nrs=0.69047619047619 sa=0 sb=0 sd=0 mult=1 m=1
csn_op1_0900_s5_w2_0 sn_op1_0900_s5_w2_0 0 {C_SN}
XMWR_op1_0900_s5_w2_1 sn_op1_0900_s5_w2_1 wwl_des wbl_op1_0900_s5_w2 0 sky130_fd_pr__nfet_01v8 L=0.15 W=0.42 nf=1 ad=0.1218 as=0.1218 pd=1.42 ps=1.42 nrd=0.69047619047619  nrs=0.69047619047619 sa=0 sb=0 sd=0 mult=1 m=1
XMRD_op1_0900_s5_w2_1 rbl_op1_0900_s5_w2 sn_op1_0900_s5_w2_1 rwl_des 0 sky130_fd_pr__nfet_01v8 L=0.15 W=0.42 nf=1 ad=0.1218 as=0.1218 pd=1.42 ps=1.42 nrd=0.69047619047619  nrs=0.69047619047619 sa=0 sb=0 sd=0 mult=1 m=1
csn_op1_0900_s5_w2_1 sn_op1_0900_s5_w2_1 0 {C_SN}
XMWR_op1_0900_s5_w2_2 sn_op1_0900_s5_w2_2 wwl_des wbl_op1_0900_s5_w2 0 sky130_fd_pr__nfet_01v8 L=0.15 W=0.42 nf=1 ad=0.1218 as=0.1218 pd=1.42 ps=1.42 nrd=0.69047619047619  nrs=0.69047619047619 sa=0 sb=0 sd=0 mult=1 m=1
XMRD_op1_0900_s5_w2_2 rbl_op1_0900_s5_w2 sn_op1_0900_s5_w2_2 rwl_des 0 sky130_fd_pr__nfet_01v8 L=0.15 W=0.42 nf=1 ad=0.1218 as=0.1218 pd=1.42 ps=1.42 nrd=0.69047619047619  nrs=0.69047619047619 sa=0 sb=0 sd=0 mult=1 m=1
csn_op1_0900_s5_w2_2 sn_op1_0900_s5_w2_2 0 {C_SN}
XMWR_op1_0900_s5_w2_3 sn_op1_0900_s5_w2_3 wwl_des wbl_op1_0900_s5_w2 0 sky130_fd_pr__nfet_01v8 L=0.15 W=0.42 nf=1 ad=0.1218 as=0.1218 pd=1.42 ps=1.42 nrd=0.69047619047619  nrs=0.69047619047619 sa=0 sb=0 sd=0 mult=1 m=1
XMRD_op1_0900_s5_w2_3 rbl_op1_0900_s5_w2 sn_op1_0900_s5_w2_3 rwl_des 0 sky130_fd_pr__nfet_01v8 L=0.15 W=0.42 nf=1 ad=0.1218 as=0.1218 pd=1.42 ps=1.42 nrd=0.69047619047619  nrs=0.69047619047619 sa=0 sb=0 sd=0 mult=1 m=1
csn_op1_0900_s5_w2_3 sn_op1_0900_s5_w2_3 0 {C_SN}
XMN1_op1_0900_s5_w2 rbl_op1_0900_s5_w2 ref_op1_0900_s5_w2 vn_op1_0900_s5_w2 0 sky130_fd_pr__nfet_01v8 L=0.15 W=1 nf=1 ad=0.29 as=0.29 pd=2.58 ps=2.58 mult=1 m=1
XMN2_op1_0900_s5_w2 ref_op1_0900_s5_w2 rbl_op1_0900_s5_w2 vn_op1_0900_s5_w2 0 sky130_fd_pr__nfet_01v8 L=0.15 W=1 nf=1 ad=0.29 as=0.29 pd=2.58 ps=2.58 mult=1 m=1
XMP1_op1_0900_s5_w2 rbl_op1_0900_s5_w2 ref_op1_0900_s5_w2 vp_op1_0900_s5_w2 vdd sky130_fd_pr__pfet_01v8 L=0.15 W=2 nf=1 ad=0.58 as=0.58 pd=4.58 ps=4.58 mult=1 m=1
XMP2_op1_0900_s5_w2 ref_op1_0900_s5_w2 rbl_op1_0900_s5_w2 vp_op1_0900_s5_w2 vdd sky130_fd_pr__pfet_01v8 L=0.15 W=2 nf=1 ad=0.58 as=0.58 pd=4.58 ps=4.58 mult=1 m=1
XMNF_op1_0900_s5_w2 vn_op1_0900_s5_w2 en_op1_0900_s5_w2 0 0 sky130_fd_pr__nfet_01v8 L=0.15 W=2 nf=1 ad=0.58 as=0.58 pd=4.58 ps=4.58 mult=1 m=1
XMPH_op1_0900_s5_w2 vp_op1_0900_s5_w2 enb_op1_0900_s5_w2 vdd vdd sky130_fd_pr__pfet_01v8 L=0.15 W=4 nf=1 ad=1.16 as=1.16 pd=8.58 ps=8.58 mult=1 m=1
bd_op1_0900_s5_w2 d_op1_0900_s5_w2 0 v=v(rbl_op1_0900_s5_w2)-v(ref_op1_0900_s5_w2)

* ---- instance 40: op1_0900_s5_w3 (t_en 9 ns, WWL 10..13 ns, release 15 ns) ----
ven_op1_0900_s5_w3  en_op1_0900_s5_w3  0 pwl(0 0 9.0000e-09 0 9.1000e-09 {VDD} 1.5000e-08 {VDD} 1.5100e-08 0)
venb_op1_0900_s5_w3 enb_op1_0900_s5_w3 0 pwl(0 {VDD} 9.0000e-09 {VDD} 9.1000e-09 0 1.5000e-08 0 1.5100e-08 {VDD})
vrs_op1_0900_s5_w3  rwls_op1_0900_s5_w3 0 pwl(0 {VDD} {T_READ} {VDD} {T_READ+TEDGE} 0 1.5000e-08 0 1.5100e-08 {VDD})
vww_op1_0900_s5_w3  wwl_op1_0900_s5_w3 0 pwl(0 0 1.0000e-08 0 1.0100e-08 {VDD} 1.3000e-08 {VDD} 1.3100e-08 0)
vwc_op1_0900_s5_w3  wbc_op1_0900_s5_w3 0 pwl(0 0 1.0000e-08 0 1.0100e-08 {VDD} 1.5000e-08 {VDD} 1.5100e-08 0)
swb_op1_0900_s5_w3 ref_op1_0900_s5_w3 wbl_op1_0900_s5_w3 wbc_op1_0900_s5_w3 0 swwbl
cwbl_op1_0900_s5_w3 wbl_op1_0900_s5_w3 0 {C_WBL}
spa_op1_0900_s5_w3 prea rbl_op1_0900_s5_w3 ctl 0 swpre
spr_op1_0900_s5_w3 pref ref_op1_0900_s5_w3 ctl 0 swpre
crbl_op1_0900_s5_w3 rbl_op1_0900_s5_w3 0 {C_RBL}
cref_op1_0900_s5_w3 ref_op1_0900_s5_w3 0 {C_RBL}   $ ASSUMPTION: ideal matched dummy load
XMWR_op1_0900_s5_w3_0 sn_op1_0900_s5_w3_0 wwl_op1_0900_s5_w3 wbl_op1_0900_s5_w3 0 sky130_fd_pr__nfet_01v8 L=0.15 W=0.42 nf=1 ad=0.1218 as=0.1218 pd=1.42 ps=1.42 nrd=0.69047619047619  nrs=0.69047619047619 sa=0 sb=0 sd=0 mult=1 m=1
XMRD_op1_0900_s5_w3_0 rbl_op1_0900_s5_w3 sn_op1_0900_s5_w3_0 rwls_op1_0900_s5_w3 0 sky130_fd_pr__nfet_01v8 L=0.15 W=0.42 nf=1 ad=0.1218 as=0.1218 pd=1.42 ps=1.42 nrd=0.69047619047619  nrs=0.69047619047619 sa=0 sb=0 sd=0 mult=1 m=1
csn_op1_0900_s5_w3_0 sn_op1_0900_s5_w3_0 0 {C_SN}
XMWR_op1_0900_s5_w3_1 sn_op1_0900_s5_w3_1 wwl_des wbl_op1_0900_s5_w3 0 sky130_fd_pr__nfet_01v8 L=0.15 W=0.42 nf=1 ad=0.1218 as=0.1218 pd=1.42 ps=1.42 nrd=0.69047619047619  nrs=0.69047619047619 sa=0 sb=0 sd=0 mult=1 m=1
XMRD_op1_0900_s5_w3_1 rbl_op1_0900_s5_w3 sn_op1_0900_s5_w3_1 rwl_des 0 sky130_fd_pr__nfet_01v8 L=0.15 W=0.42 nf=1 ad=0.1218 as=0.1218 pd=1.42 ps=1.42 nrd=0.69047619047619  nrs=0.69047619047619 sa=0 sb=0 sd=0 mult=1 m=1
csn_op1_0900_s5_w3_1 sn_op1_0900_s5_w3_1 0 {C_SN}
XMWR_op1_0900_s5_w3_2 sn_op1_0900_s5_w3_2 wwl_des wbl_op1_0900_s5_w3 0 sky130_fd_pr__nfet_01v8 L=0.15 W=0.42 nf=1 ad=0.1218 as=0.1218 pd=1.42 ps=1.42 nrd=0.69047619047619  nrs=0.69047619047619 sa=0 sb=0 sd=0 mult=1 m=1
XMRD_op1_0900_s5_w3_2 rbl_op1_0900_s5_w3 sn_op1_0900_s5_w3_2 rwl_des 0 sky130_fd_pr__nfet_01v8 L=0.15 W=0.42 nf=1 ad=0.1218 as=0.1218 pd=1.42 ps=1.42 nrd=0.69047619047619  nrs=0.69047619047619 sa=0 sb=0 sd=0 mult=1 m=1
csn_op1_0900_s5_w3_2 sn_op1_0900_s5_w3_2 0 {C_SN}
XMWR_op1_0900_s5_w3_3 sn_op1_0900_s5_w3_3 wwl_des wbl_op1_0900_s5_w3 0 sky130_fd_pr__nfet_01v8 L=0.15 W=0.42 nf=1 ad=0.1218 as=0.1218 pd=1.42 ps=1.42 nrd=0.69047619047619  nrs=0.69047619047619 sa=0 sb=0 sd=0 mult=1 m=1
XMRD_op1_0900_s5_w3_3 rbl_op1_0900_s5_w3 sn_op1_0900_s5_w3_3 rwl_des 0 sky130_fd_pr__nfet_01v8 L=0.15 W=0.42 nf=1 ad=0.1218 as=0.1218 pd=1.42 ps=1.42 nrd=0.69047619047619  nrs=0.69047619047619 sa=0 sb=0 sd=0 mult=1 m=1
csn_op1_0900_s5_w3_3 sn_op1_0900_s5_w3_3 0 {C_SN}
XMN1_op1_0900_s5_w3 rbl_op1_0900_s5_w3 ref_op1_0900_s5_w3 vn_op1_0900_s5_w3 0 sky130_fd_pr__nfet_01v8 L=0.15 W=1 nf=1 ad=0.29 as=0.29 pd=2.58 ps=2.58 mult=1 m=1
XMN2_op1_0900_s5_w3 ref_op1_0900_s5_w3 rbl_op1_0900_s5_w3 vn_op1_0900_s5_w3 0 sky130_fd_pr__nfet_01v8 L=0.15 W=1 nf=1 ad=0.29 as=0.29 pd=2.58 ps=2.58 mult=1 m=1
XMP1_op1_0900_s5_w3 rbl_op1_0900_s5_w3 ref_op1_0900_s5_w3 vp_op1_0900_s5_w3 vdd sky130_fd_pr__pfet_01v8 L=0.15 W=2 nf=1 ad=0.58 as=0.58 pd=4.58 ps=4.58 mult=1 m=1
XMP2_op1_0900_s5_w3 ref_op1_0900_s5_w3 rbl_op1_0900_s5_w3 vp_op1_0900_s5_w3 vdd sky130_fd_pr__pfet_01v8 L=0.15 W=2 nf=1 ad=0.58 as=0.58 pd=4.58 ps=4.58 mult=1 m=1
XMNF_op1_0900_s5_w3 vn_op1_0900_s5_w3 en_op1_0900_s5_w3 0 0 sky130_fd_pr__nfet_01v8 L=0.15 W=2 nf=1 ad=0.58 as=0.58 pd=4.58 ps=4.58 mult=1 m=1
XMPH_op1_0900_s5_w3 vp_op1_0900_s5_w3 enb_op1_0900_s5_w3 vdd vdd sky130_fd_pr__pfet_01v8 L=0.15 W=4 nf=1 ad=1.16 as=1.16 pd=8.58 ps=8.58 mult=1 m=1
bd_op1_0900_s5_w3 d_op1_0900_s5_w3 0 v=v(rbl_op1_0900_s5_w3)-v(ref_op1_0900_s5_w3)

* ---- instance 41: op1_0900_s5_w5 (t_en 9 ns, WWL 10..15 ns, release 17 ns) ----
ven_op1_0900_s5_w5  en_op1_0900_s5_w5  0 pwl(0 0 9.0000e-09 0 9.1000e-09 {VDD} 1.7000e-08 {VDD} 1.7100e-08 0)
venb_op1_0900_s5_w5 enb_op1_0900_s5_w5 0 pwl(0 {VDD} 9.0000e-09 {VDD} 9.1000e-09 0 1.7000e-08 0 1.7100e-08 {VDD})
vrs_op1_0900_s5_w5  rwls_op1_0900_s5_w5 0 pwl(0 {VDD} {T_READ} {VDD} {T_READ+TEDGE} 0 1.7000e-08 0 1.7100e-08 {VDD})
vww_op1_0900_s5_w5  wwl_op1_0900_s5_w5 0 pwl(0 0 1.0000e-08 0 1.0100e-08 {VDD} 1.5000e-08 {VDD} 1.5100e-08 0)
vwc_op1_0900_s5_w5  wbc_op1_0900_s5_w5 0 pwl(0 0 1.0000e-08 0 1.0100e-08 {VDD} 1.7000e-08 {VDD} 1.7100e-08 0)
swb_op1_0900_s5_w5 ref_op1_0900_s5_w5 wbl_op1_0900_s5_w5 wbc_op1_0900_s5_w5 0 swwbl
cwbl_op1_0900_s5_w5 wbl_op1_0900_s5_w5 0 {C_WBL}
spa_op1_0900_s5_w5 prea rbl_op1_0900_s5_w5 ctl 0 swpre
spr_op1_0900_s5_w5 pref ref_op1_0900_s5_w5 ctl 0 swpre
crbl_op1_0900_s5_w5 rbl_op1_0900_s5_w5 0 {C_RBL}
cref_op1_0900_s5_w5 ref_op1_0900_s5_w5 0 {C_RBL}   $ ASSUMPTION: ideal matched dummy load
XMWR_op1_0900_s5_w5_0 sn_op1_0900_s5_w5_0 wwl_op1_0900_s5_w5 wbl_op1_0900_s5_w5 0 sky130_fd_pr__nfet_01v8 L=0.15 W=0.42 nf=1 ad=0.1218 as=0.1218 pd=1.42 ps=1.42 nrd=0.69047619047619  nrs=0.69047619047619 sa=0 sb=0 sd=0 mult=1 m=1
XMRD_op1_0900_s5_w5_0 rbl_op1_0900_s5_w5 sn_op1_0900_s5_w5_0 rwls_op1_0900_s5_w5 0 sky130_fd_pr__nfet_01v8 L=0.15 W=0.42 nf=1 ad=0.1218 as=0.1218 pd=1.42 ps=1.42 nrd=0.69047619047619  nrs=0.69047619047619 sa=0 sb=0 sd=0 mult=1 m=1
csn_op1_0900_s5_w5_0 sn_op1_0900_s5_w5_0 0 {C_SN}
XMWR_op1_0900_s5_w5_1 sn_op1_0900_s5_w5_1 wwl_des wbl_op1_0900_s5_w5 0 sky130_fd_pr__nfet_01v8 L=0.15 W=0.42 nf=1 ad=0.1218 as=0.1218 pd=1.42 ps=1.42 nrd=0.69047619047619  nrs=0.69047619047619 sa=0 sb=0 sd=0 mult=1 m=1
XMRD_op1_0900_s5_w5_1 rbl_op1_0900_s5_w5 sn_op1_0900_s5_w5_1 rwl_des 0 sky130_fd_pr__nfet_01v8 L=0.15 W=0.42 nf=1 ad=0.1218 as=0.1218 pd=1.42 ps=1.42 nrd=0.69047619047619  nrs=0.69047619047619 sa=0 sb=0 sd=0 mult=1 m=1
csn_op1_0900_s5_w5_1 sn_op1_0900_s5_w5_1 0 {C_SN}
XMWR_op1_0900_s5_w5_2 sn_op1_0900_s5_w5_2 wwl_des wbl_op1_0900_s5_w5 0 sky130_fd_pr__nfet_01v8 L=0.15 W=0.42 nf=1 ad=0.1218 as=0.1218 pd=1.42 ps=1.42 nrd=0.69047619047619  nrs=0.69047619047619 sa=0 sb=0 sd=0 mult=1 m=1
XMRD_op1_0900_s5_w5_2 rbl_op1_0900_s5_w5 sn_op1_0900_s5_w5_2 rwl_des 0 sky130_fd_pr__nfet_01v8 L=0.15 W=0.42 nf=1 ad=0.1218 as=0.1218 pd=1.42 ps=1.42 nrd=0.69047619047619  nrs=0.69047619047619 sa=0 sb=0 sd=0 mult=1 m=1
csn_op1_0900_s5_w5_2 sn_op1_0900_s5_w5_2 0 {C_SN}
XMWR_op1_0900_s5_w5_3 sn_op1_0900_s5_w5_3 wwl_des wbl_op1_0900_s5_w5 0 sky130_fd_pr__nfet_01v8 L=0.15 W=0.42 nf=1 ad=0.1218 as=0.1218 pd=1.42 ps=1.42 nrd=0.69047619047619  nrs=0.69047619047619 sa=0 sb=0 sd=0 mult=1 m=1
XMRD_op1_0900_s5_w5_3 rbl_op1_0900_s5_w5 sn_op1_0900_s5_w5_3 rwl_des 0 sky130_fd_pr__nfet_01v8 L=0.15 W=0.42 nf=1 ad=0.1218 as=0.1218 pd=1.42 ps=1.42 nrd=0.69047619047619  nrs=0.69047619047619 sa=0 sb=0 sd=0 mult=1 m=1
csn_op1_0900_s5_w5_3 sn_op1_0900_s5_w5_3 0 {C_SN}
XMN1_op1_0900_s5_w5 rbl_op1_0900_s5_w5 ref_op1_0900_s5_w5 vn_op1_0900_s5_w5 0 sky130_fd_pr__nfet_01v8 L=0.15 W=1 nf=1 ad=0.29 as=0.29 pd=2.58 ps=2.58 mult=1 m=1
XMN2_op1_0900_s5_w5 ref_op1_0900_s5_w5 rbl_op1_0900_s5_w5 vn_op1_0900_s5_w5 0 sky130_fd_pr__nfet_01v8 L=0.15 W=1 nf=1 ad=0.29 as=0.29 pd=2.58 ps=2.58 mult=1 m=1
XMP1_op1_0900_s5_w5 rbl_op1_0900_s5_w5 ref_op1_0900_s5_w5 vp_op1_0900_s5_w5 vdd sky130_fd_pr__pfet_01v8 L=0.15 W=2 nf=1 ad=0.58 as=0.58 pd=4.58 ps=4.58 mult=1 m=1
XMP2_op1_0900_s5_w5 ref_op1_0900_s5_w5 rbl_op1_0900_s5_w5 vp_op1_0900_s5_w5 vdd sky130_fd_pr__pfet_01v8 L=0.15 W=2 nf=1 ad=0.58 as=0.58 pd=4.58 ps=4.58 mult=1 m=1
XMNF_op1_0900_s5_w5 vn_op1_0900_s5_w5 en_op1_0900_s5_w5 0 0 sky130_fd_pr__nfet_01v8 L=0.15 W=2 nf=1 ad=0.58 as=0.58 pd=4.58 ps=4.58 mult=1 m=1
XMPH_op1_0900_s5_w5 vp_op1_0900_s5_w5 enb_op1_0900_s5_w5 vdd vdd sky130_fd_pr__pfet_01v8 L=0.15 W=4 nf=1 ad=1.16 as=1.16 pd=8.58 ps=8.58 mult=1 m=1
bd_op1_0900_s5_w5 d_op1_0900_s5_w5 0 v=v(rbl_op1_0900_s5_w5)-v(ref_op1_0900_s5_w5)

* ---- instance 42: op1_0900_s5_w7p5 (t_en 9 ns, WWL 10..17.5 ns, release 19.5 ns) ----
ven_op1_0900_s5_w7p5  en_op1_0900_s5_w7p5  0 pwl(0 0 9.0000e-09 0 9.1000e-09 {VDD} 1.9500e-08 {VDD} 1.9600e-08 0)
venb_op1_0900_s5_w7p5 enb_op1_0900_s5_w7p5 0 pwl(0 {VDD} 9.0000e-09 {VDD} 9.1000e-09 0 1.9500e-08 0 1.9600e-08 {VDD})
vrs_op1_0900_s5_w7p5  rwls_op1_0900_s5_w7p5 0 pwl(0 {VDD} {T_READ} {VDD} {T_READ+TEDGE} 0 1.9500e-08 0 1.9600e-08 {VDD})
vww_op1_0900_s5_w7p5  wwl_op1_0900_s5_w7p5 0 pwl(0 0 1.0000e-08 0 1.0100e-08 {VDD} 1.7500e-08 {VDD} 1.7600e-08 0)
vwc_op1_0900_s5_w7p5  wbc_op1_0900_s5_w7p5 0 pwl(0 0 1.0000e-08 0 1.0100e-08 {VDD} 1.9500e-08 {VDD} 1.9600e-08 0)
swb_op1_0900_s5_w7p5 ref_op1_0900_s5_w7p5 wbl_op1_0900_s5_w7p5 wbc_op1_0900_s5_w7p5 0 swwbl
cwbl_op1_0900_s5_w7p5 wbl_op1_0900_s5_w7p5 0 {C_WBL}
spa_op1_0900_s5_w7p5 prea rbl_op1_0900_s5_w7p5 ctl 0 swpre
spr_op1_0900_s5_w7p5 pref ref_op1_0900_s5_w7p5 ctl 0 swpre
crbl_op1_0900_s5_w7p5 rbl_op1_0900_s5_w7p5 0 {C_RBL}
cref_op1_0900_s5_w7p5 ref_op1_0900_s5_w7p5 0 {C_RBL}   $ ASSUMPTION: ideal matched dummy load
XMWR_op1_0900_s5_w7p5_0 sn_op1_0900_s5_w7p5_0 wwl_op1_0900_s5_w7p5 wbl_op1_0900_s5_w7p5 0 sky130_fd_pr__nfet_01v8 L=0.15 W=0.42 nf=1 ad=0.1218 as=0.1218 pd=1.42 ps=1.42 nrd=0.69047619047619  nrs=0.69047619047619 sa=0 sb=0 sd=0 mult=1 m=1
XMRD_op1_0900_s5_w7p5_0 rbl_op1_0900_s5_w7p5 sn_op1_0900_s5_w7p5_0 rwls_op1_0900_s5_w7p5 0 sky130_fd_pr__nfet_01v8 L=0.15 W=0.42 nf=1 ad=0.1218 as=0.1218 pd=1.42 ps=1.42 nrd=0.69047619047619  nrs=0.69047619047619 sa=0 sb=0 sd=0 mult=1 m=1
csn_op1_0900_s5_w7p5_0 sn_op1_0900_s5_w7p5_0 0 {C_SN}
XMWR_op1_0900_s5_w7p5_1 sn_op1_0900_s5_w7p5_1 wwl_des wbl_op1_0900_s5_w7p5 0 sky130_fd_pr__nfet_01v8 L=0.15 W=0.42 nf=1 ad=0.1218 as=0.1218 pd=1.42 ps=1.42 nrd=0.69047619047619  nrs=0.69047619047619 sa=0 sb=0 sd=0 mult=1 m=1
XMRD_op1_0900_s5_w7p5_1 rbl_op1_0900_s5_w7p5 sn_op1_0900_s5_w7p5_1 rwl_des 0 sky130_fd_pr__nfet_01v8 L=0.15 W=0.42 nf=1 ad=0.1218 as=0.1218 pd=1.42 ps=1.42 nrd=0.69047619047619  nrs=0.69047619047619 sa=0 sb=0 sd=0 mult=1 m=1
csn_op1_0900_s5_w7p5_1 sn_op1_0900_s5_w7p5_1 0 {C_SN}
XMWR_op1_0900_s5_w7p5_2 sn_op1_0900_s5_w7p5_2 wwl_des wbl_op1_0900_s5_w7p5 0 sky130_fd_pr__nfet_01v8 L=0.15 W=0.42 nf=1 ad=0.1218 as=0.1218 pd=1.42 ps=1.42 nrd=0.69047619047619  nrs=0.69047619047619 sa=0 sb=0 sd=0 mult=1 m=1
XMRD_op1_0900_s5_w7p5_2 rbl_op1_0900_s5_w7p5 sn_op1_0900_s5_w7p5_2 rwl_des 0 sky130_fd_pr__nfet_01v8 L=0.15 W=0.42 nf=1 ad=0.1218 as=0.1218 pd=1.42 ps=1.42 nrd=0.69047619047619  nrs=0.69047619047619 sa=0 sb=0 sd=0 mult=1 m=1
csn_op1_0900_s5_w7p5_2 sn_op1_0900_s5_w7p5_2 0 {C_SN}
XMWR_op1_0900_s5_w7p5_3 sn_op1_0900_s5_w7p5_3 wwl_des wbl_op1_0900_s5_w7p5 0 sky130_fd_pr__nfet_01v8 L=0.15 W=0.42 nf=1 ad=0.1218 as=0.1218 pd=1.42 ps=1.42 nrd=0.69047619047619  nrs=0.69047619047619 sa=0 sb=0 sd=0 mult=1 m=1
XMRD_op1_0900_s5_w7p5_3 rbl_op1_0900_s5_w7p5 sn_op1_0900_s5_w7p5_3 rwl_des 0 sky130_fd_pr__nfet_01v8 L=0.15 W=0.42 nf=1 ad=0.1218 as=0.1218 pd=1.42 ps=1.42 nrd=0.69047619047619  nrs=0.69047619047619 sa=0 sb=0 sd=0 mult=1 m=1
csn_op1_0900_s5_w7p5_3 sn_op1_0900_s5_w7p5_3 0 {C_SN}
XMN1_op1_0900_s5_w7p5 rbl_op1_0900_s5_w7p5 ref_op1_0900_s5_w7p5 vn_op1_0900_s5_w7p5 0 sky130_fd_pr__nfet_01v8 L=0.15 W=1 nf=1 ad=0.29 as=0.29 pd=2.58 ps=2.58 mult=1 m=1
XMN2_op1_0900_s5_w7p5 ref_op1_0900_s5_w7p5 rbl_op1_0900_s5_w7p5 vn_op1_0900_s5_w7p5 0 sky130_fd_pr__nfet_01v8 L=0.15 W=1 nf=1 ad=0.29 as=0.29 pd=2.58 ps=2.58 mult=1 m=1
XMP1_op1_0900_s5_w7p5 rbl_op1_0900_s5_w7p5 ref_op1_0900_s5_w7p5 vp_op1_0900_s5_w7p5 vdd sky130_fd_pr__pfet_01v8 L=0.15 W=2 nf=1 ad=0.58 as=0.58 pd=4.58 ps=4.58 mult=1 m=1
XMP2_op1_0900_s5_w7p5 ref_op1_0900_s5_w7p5 rbl_op1_0900_s5_w7p5 vp_op1_0900_s5_w7p5 vdd sky130_fd_pr__pfet_01v8 L=0.15 W=2 nf=1 ad=0.58 as=0.58 pd=4.58 ps=4.58 mult=1 m=1
XMNF_op1_0900_s5_w7p5 vn_op1_0900_s5_w7p5 en_op1_0900_s5_w7p5 0 0 sky130_fd_pr__nfet_01v8 L=0.15 W=2 nf=1 ad=0.58 as=0.58 pd=4.58 ps=4.58 mult=1 m=1
XMPH_op1_0900_s5_w7p5 vp_op1_0900_s5_w7p5 enb_op1_0900_s5_w7p5 vdd vdd sky130_fd_pr__pfet_01v8 L=0.15 W=4 nf=1 ad=1.16 as=1.16 pd=8.58 ps=8.58 mult=1 m=1
bd_op1_0900_s5_w7p5 d_op1_0900_s5_w7p5 0 v=v(rbl_op1_0900_s5_w7p5)-v(ref_op1_0900_s5_w7p5)

* ---- instance 43: op1_0900_s5_w10 (t_en 9 ns, WWL 10..20 ns, release 22 ns) ----
ven_op1_0900_s5_w10  en_op1_0900_s5_w10  0 pwl(0 0 9.0000e-09 0 9.1000e-09 {VDD} 2.2000e-08 {VDD} 2.2100e-08 0)
venb_op1_0900_s5_w10 enb_op1_0900_s5_w10 0 pwl(0 {VDD} 9.0000e-09 {VDD} 9.1000e-09 0 2.2000e-08 0 2.2100e-08 {VDD})
vrs_op1_0900_s5_w10  rwls_op1_0900_s5_w10 0 pwl(0 {VDD} {T_READ} {VDD} {T_READ+TEDGE} 0 2.2000e-08 0 2.2100e-08 {VDD})
vww_op1_0900_s5_w10  wwl_op1_0900_s5_w10 0 pwl(0 0 1.0000e-08 0 1.0100e-08 {VDD} 2.0000e-08 {VDD} 2.0100e-08 0)
vwc_op1_0900_s5_w10  wbc_op1_0900_s5_w10 0 pwl(0 0 1.0000e-08 0 1.0100e-08 {VDD} 2.2000e-08 {VDD} 2.2100e-08 0)
swb_op1_0900_s5_w10 ref_op1_0900_s5_w10 wbl_op1_0900_s5_w10 wbc_op1_0900_s5_w10 0 swwbl
cwbl_op1_0900_s5_w10 wbl_op1_0900_s5_w10 0 {C_WBL}
spa_op1_0900_s5_w10 prea rbl_op1_0900_s5_w10 ctl 0 swpre
spr_op1_0900_s5_w10 pref ref_op1_0900_s5_w10 ctl 0 swpre
crbl_op1_0900_s5_w10 rbl_op1_0900_s5_w10 0 {C_RBL}
cref_op1_0900_s5_w10 ref_op1_0900_s5_w10 0 {C_RBL}   $ ASSUMPTION: ideal matched dummy load
XMWR_op1_0900_s5_w10_0 sn_op1_0900_s5_w10_0 wwl_op1_0900_s5_w10 wbl_op1_0900_s5_w10 0 sky130_fd_pr__nfet_01v8 L=0.15 W=0.42 nf=1 ad=0.1218 as=0.1218 pd=1.42 ps=1.42 nrd=0.69047619047619  nrs=0.69047619047619 sa=0 sb=0 sd=0 mult=1 m=1
XMRD_op1_0900_s5_w10_0 rbl_op1_0900_s5_w10 sn_op1_0900_s5_w10_0 rwls_op1_0900_s5_w10 0 sky130_fd_pr__nfet_01v8 L=0.15 W=0.42 nf=1 ad=0.1218 as=0.1218 pd=1.42 ps=1.42 nrd=0.69047619047619  nrs=0.69047619047619 sa=0 sb=0 sd=0 mult=1 m=1
csn_op1_0900_s5_w10_0 sn_op1_0900_s5_w10_0 0 {C_SN}
XMWR_op1_0900_s5_w10_1 sn_op1_0900_s5_w10_1 wwl_des wbl_op1_0900_s5_w10 0 sky130_fd_pr__nfet_01v8 L=0.15 W=0.42 nf=1 ad=0.1218 as=0.1218 pd=1.42 ps=1.42 nrd=0.69047619047619  nrs=0.69047619047619 sa=0 sb=0 sd=0 mult=1 m=1
XMRD_op1_0900_s5_w10_1 rbl_op1_0900_s5_w10 sn_op1_0900_s5_w10_1 rwl_des 0 sky130_fd_pr__nfet_01v8 L=0.15 W=0.42 nf=1 ad=0.1218 as=0.1218 pd=1.42 ps=1.42 nrd=0.69047619047619  nrs=0.69047619047619 sa=0 sb=0 sd=0 mult=1 m=1
csn_op1_0900_s5_w10_1 sn_op1_0900_s5_w10_1 0 {C_SN}
XMWR_op1_0900_s5_w10_2 sn_op1_0900_s5_w10_2 wwl_des wbl_op1_0900_s5_w10 0 sky130_fd_pr__nfet_01v8 L=0.15 W=0.42 nf=1 ad=0.1218 as=0.1218 pd=1.42 ps=1.42 nrd=0.69047619047619  nrs=0.69047619047619 sa=0 sb=0 sd=0 mult=1 m=1
XMRD_op1_0900_s5_w10_2 rbl_op1_0900_s5_w10 sn_op1_0900_s5_w10_2 rwl_des 0 sky130_fd_pr__nfet_01v8 L=0.15 W=0.42 nf=1 ad=0.1218 as=0.1218 pd=1.42 ps=1.42 nrd=0.69047619047619  nrs=0.69047619047619 sa=0 sb=0 sd=0 mult=1 m=1
csn_op1_0900_s5_w10_2 sn_op1_0900_s5_w10_2 0 {C_SN}
XMWR_op1_0900_s5_w10_3 sn_op1_0900_s5_w10_3 wwl_des wbl_op1_0900_s5_w10 0 sky130_fd_pr__nfet_01v8 L=0.15 W=0.42 nf=1 ad=0.1218 as=0.1218 pd=1.42 ps=1.42 nrd=0.69047619047619  nrs=0.69047619047619 sa=0 sb=0 sd=0 mult=1 m=1
XMRD_op1_0900_s5_w10_3 rbl_op1_0900_s5_w10 sn_op1_0900_s5_w10_3 rwl_des 0 sky130_fd_pr__nfet_01v8 L=0.15 W=0.42 nf=1 ad=0.1218 as=0.1218 pd=1.42 ps=1.42 nrd=0.69047619047619  nrs=0.69047619047619 sa=0 sb=0 sd=0 mult=1 m=1
csn_op1_0900_s5_w10_3 sn_op1_0900_s5_w10_3 0 {C_SN}
XMN1_op1_0900_s5_w10 rbl_op1_0900_s5_w10 ref_op1_0900_s5_w10 vn_op1_0900_s5_w10 0 sky130_fd_pr__nfet_01v8 L=0.15 W=1 nf=1 ad=0.29 as=0.29 pd=2.58 ps=2.58 mult=1 m=1
XMN2_op1_0900_s5_w10 ref_op1_0900_s5_w10 rbl_op1_0900_s5_w10 vn_op1_0900_s5_w10 0 sky130_fd_pr__nfet_01v8 L=0.15 W=1 nf=1 ad=0.29 as=0.29 pd=2.58 ps=2.58 mult=1 m=1
XMP1_op1_0900_s5_w10 rbl_op1_0900_s5_w10 ref_op1_0900_s5_w10 vp_op1_0900_s5_w10 vdd sky130_fd_pr__pfet_01v8 L=0.15 W=2 nf=1 ad=0.58 as=0.58 pd=4.58 ps=4.58 mult=1 m=1
XMP2_op1_0900_s5_w10 ref_op1_0900_s5_w10 rbl_op1_0900_s5_w10 vp_op1_0900_s5_w10 vdd sky130_fd_pr__pfet_01v8 L=0.15 W=2 nf=1 ad=0.58 as=0.58 pd=4.58 ps=4.58 mult=1 m=1
XMNF_op1_0900_s5_w10 vn_op1_0900_s5_w10 en_op1_0900_s5_w10 0 0 sky130_fd_pr__nfet_01v8 L=0.15 W=2 nf=1 ad=0.58 as=0.58 pd=4.58 ps=4.58 mult=1 m=1
XMPH_op1_0900_s5_w10 vp_op1_0900_s5_w10 enb_op1_0900_s5_w10 vdd vdd sky130_fd_pr__pfet_01v8 L=0.15 W=4 nf=1 ad=1.16 as=1.16 pd=8.58 ps=8.58 mult=1 m=1
bd_op1_0900_s5_w10 d_op1_0900_s5_w10 0 v=v(rbl_op1_0900_s5_w10)-v(ref_op1_0900_s5_w10)

* ---- instance 44: op1_0900_s5_w15 (t_en 9 ns, WWL 10..25 ns, release 27 ns) ----
ven_op1_0900_s5_w15  en_op1_0900_s5_w15  0 pwl(0 0 9.0000e-09 0 9.1000e-09 {VDD} 2.7000e-08 {VDD} 2.7100e-08 0)
venb_op1_0900_s5_w15 enb_op1_0900_s5_w15 0 pwl(0 {VDD} 9.0000e-09 {VDD} 9.1000e-09 0 2.7000e-08 0 2.7100e-08 {VDD})
vrs_op1_0900_s5_w15  rwls_op1_0900_s5_w15 0 pwl(0 {VDD} {T_READ} {VDD} {T_READ+TEDGE} 0 2.7000e-08 0 2.7100e-08 {VDD})
vww_op1_0900_s5_w15  wwl_op1_0900_s5_w15 0 pwl(0 0 1.0000e-08 0 1.0100e-08 {VDD} 2.5000e-08 {VDD} 2.5100e-08 0)
vwc_op1_0900_s5_w15  wbc_op1_0900_s5_w15 0 pwl(0 0 1.0000e-08 0 1.0100e-08 {VDD} 2.7000e-08 {VDD} 2.7100e-08 0)
swb_op1_0900_s5_w15 ref_op1_0900_s5_w15 wbl_op1_0900_s5_w15 wbc_op1_0900_s5_w15 0 swwbl
cwbl_op1_0900_s5_w15 wbl_op1_0900_s5_w15 0 {C_WBL}
spa_op1_0900_s5_w15 prea rbl_op1_0900_s5_w15 ctl 0 swpre
spr_op1_0900_s5_w15 pref ref_op1_0900_s5_w15 ctl 0 swpre
crbl_op1_0900_s5_w15 rbl_op1_0900_s5_w15 0 {C_RBL}
cref_op1_0900_s5_w15 ref_op1_0900_s5_w15 0 {C_RBL}   $ ASSUMPTION: ideal matched dummy load
XMWR_op1_0900_s5_w15_0 sn_op1_0900_s5_w15_0 wwl_op1_0900_s5_w15 wbl_op1_0900_s5_w15 0 sky130_fd_pr__nfet_01v8 L=0.15 W=0.42 nf=1 ad=0.1218 as=0.1218 pd=1.42 ps=1.42 nrd=0.69047619047619  nrs=0.69047619047619 sa=0 sb=0 sd=0 mult=1 m=1
XMRD_op1_0900_s5_w15_0 rbl_op1_0900_s5_w15 sn_op1_0900_s5_w15_0 rwls_op1_0900_s5_w15 0 sky130_fd_pr__nfet_01v8 L=0.15 W=0.42 nf=1 ad=0.1218 as=0.1218 pd=1.42 ps=1.42 nrd=0.69047619047619  nrs=0.69047619047619 sa=0 sb=0 sd=0 mult=1 m=1
csn_op1_0900_s5_w15_0 sn_op1_0900_s5_w15_0 0 {C_SN}
XMWR_op1_0900_s5_w15_1 sn_op1_0900_s5_w15_1 wwl_des wbl_op1_0900_s5_w15 0 sky130_fd_pr__nfet_01v8 L=0.15 W=0.42 nf=1 ad=0.1218 as=0.1218 pd=1.42 ps=1.42 nrd=0.69047619047619  nrs=0.69047619047619 sa=0 sb=0 sd=0 mult=1 m=1
XMRD_op1_0900_s5_w15_1 rbl_op1_0900_s5_w15 sn_op1_0900_s5_w15_1 rwl_des 0 sky130_fd_pr__nfet_01v8 L=0.15 W=0.42 nf=1 ad=0.1218 as=0.1218 pd=1.42 ps=1.42 nrd=0.69047619047619  nrs=0.69047619047619 sa=0 sb=0 sd=0 mult=1 m=1
csn_op1_0900_s5_w15_1 sn_op1_0900_s5_w15_1 0 {C_SN}
XMWR_op1_0900_s5_w15_2 sn_op1_0900_s5_w15_2 wwl_des wbl_op1_0900_s5_w15 0 sky130_fd_pr__nfet_01v8 L=0.15 W=0.42 nf=1 ad=0.1218 as=0.1218 pd=1.42 ps=1.42 nrd=0.69047619047619  nrs=0.69047619047619 sa=0 sb=0 sd=0 mult=1 m=1
XMRD_op1_0900_s5_w15_2 rbl_op1_0900_s5_w15 sn_op1_0900_s5_w15_2 rwl_des 0 sky130_fd_pr__nfet_01v8 L=0.15 W=0.42 nf=1 ad=0.1218 as=0.1218 pd=1.42 ps=1.42 nrd=0.69047619047619  nrs=0.69047619047619 sa=0 sb=0 sd=0 mult=1 m=1
csn_op1_0900_s5_w15_2 sn_op1_0900_s5_w15_2 0 {C_SN}
XMWR_op1_0900_s5_w15_3 sn_op1_0900_s5_w15_3 wwl_des wbl_op1_0900_s5_w15 0 sky130_fd_pr__nfet_01v8 L=0.15 W=0.42 nf=1 ad=0.1218 as=0.1218 pd=1.42 ps=1.42 nrd=0.69047619047619  nrs=0.69047619047619 sa=0 sb=0 sd=0 mult=1 m=1
XMRD_op1_0900_s5_w15_3 rbl_op1_0900_s5_w15 sn_op1_0900_s5_w15_3 rwl_des 0 sky130_fd_pr__nfet_01v8 L=0.15 W=0.42 nf=1 ad=0.1218 as=0.1218 pd=1.42 ps=1.42 nrd=0.69047619047619  nrs=0.69047619047619 sa=0 sb=0 sd=0 mult=1 m=1
csn_op1_0900_s5_w15_3 sn_op1_0900_s5_w15_3 0 {C_SN}
XMN1_op1_0900_s5_w15 rbl_op1_0900_s5_w15 ref_op1_0900_s5_w15 vn_op1_0900_s5_w15 0 sky130_fd_pr__nfet_01v8 L=0.15 W=1 nf=1 ad=0.29 as=0.29 pd=2.58 ps=2.58 mult=1 m=1
XMN2_op1_0900_s5_w15 ref_op1_0900_s5_w15 rbl_op1_0900_s5_w15 vn_op1_0900_s5_w15 0 sky130_fd_pr__nfet_01v8 L=0.15 W=1 nf=1 ad=0.29 as=0.29 pd=2.58 ps=2.58 mult=1 m=1
XMP1_op1_0900_s5_w15 rbl_op1_0900_s5_w15 ref_op1_0900_s5_w15 vp_op1_0900_s5_w15 vdd sky130_fd_pr__pfet_01v8 L=0.15 W=2 nf=1 ad=0.58 as=0.58 pd=4.58 ps=4.58 mult=1 m=1
XMP2_op1_0900_s5_w15 ref_op1_0900_s5_w15 rbl_op1_0900_s5_w15 vp_op1_0900_s5_w15 vdd sky130_fd_pr__pfet_01v8 L=0.15 W=2 nf=1 ad=0.58 as=0.58 pd=4.58 ps=4.58 mult=1 m=1
XMNF_op1_0900_s5_w15 vn_op1_0900_s5_w15 en_op1_0900_s5_w15 0 0 sky130_fd_pr__nfet_01v8 L=0.15 W=2 nf=1 ad=0.58 as=0.58 pd=4.58 ps=4.58 mult=1 m=1
XMPH_op1_0900_s5_w15 vp_op1_0900_s5_w15 enb_op1_0900_s5_w15 vdd vdd sky130_fd_pr__pfet_01v8 L=0.15 W=4 nf=1 ad=1.16 as=1.16 pd=8.58 ps=8.58 mult=1 m=1
bd_op1_0900_s5_w15 d_op1_0900_s5_w15 0 v=v(rbl_op1_0900_s5_w15)-v(ref_op1_0900_s5_w15)

* ---- instance 45: op1_0900_s5_w20 (t_en 9 ns, WWL 10..30 ns, release 32 ns) ----
ven_op1_0900_s5_w20  en_op1_0900_s5_w20  0 pwl(0 0 9.0000e-09 0 9.1000e-09 {VDD} 3.2000e-08 {VDD} 3.2100e-08 0)
venb_op1_0900_s5_w20 enb_op1_0900_s5_w20 0 pwl(0 {VDD} 9.0000e-09 {VDD} 9.1000e-09 0 3.2000e-08 0 3.2100e-08 {VDD})
vrs_op1_0900_s5_w20  rwls_op1_0900_s5_w20 0 pwl(0 {VDD} {T_READ} {VDD} {T_READ+TEDGE} 0 3.2000e-08 0 3.2100e-08 {VDD})
vww_op1_0900_s5_w20  wwl_op1_0900_s5_w20 0 pwl(0 0 1.0000e-08 0 1.0100e-08 {VDD} 3.0000e-08 {VDD} 3.0100e-08 0)
vwc_op1_0900_s5_w20  wbc_op1_0900_s5_w20 0 pwl(0 0 1.0000e-08 0 1.0100e-08 {VDD} 3.2000e-08 {VDD} 3.2100e-08 0)
swb_op1_0900_s5_w20 ref_op1_0900_s5_w20 wbl_op1_0900_s5_w20 wbc_op1_0900_s5_w20 0 swwbl
cwbl_op1_0900_s5_w20 wbl_op1_0900_s5_w20 0 {C_WBL}
spa_op1_0900_s5_w20 prea rbl_op1_0900_s5_w20 ctl 0 swpre
spr_op1_0900_s5_w20 pref ref_op1_0900_s5_w20 ctl 0 swpre
crbl_op1_0900_s5_w20 rbl_op1_0900_s5_w20 0 {C_RBL}
cref_op1_0900_s5_w20 ref_op1_0900_s5_w20 0 {C_RBL}   $ ASSUMPTION: ideal matched dummy load
XMWR_op1_0900_s5_w20_0 sn_op1_0900_s5_w20_0 wwl_op1_0900_s5_w20 wbl_op1_0900_s5_w20 0 sky130_fd_pr__nfet_01v8 L=0.15 W=0.42 nf=1 ad=0.1218 as=0.1218 pd=1.42 ps=1.42 nrd=0.69047619047619  nrs=0.69047619047619 sa=0 sb=0 sd=0 mult=1 m=1
XMRD_op1_0900_s5_w20_0 rbl_op1_0900_s5_w20 sn_op1_0900_s5_w20_0 rwls_op1_0900_s5_w20 0 sky130_fd_pr__nfet_01v8 L=0.15 W=0.42 nf=1 ad=0.1218 as=0.1218 pd=1.42 ps=1.42 nrd=0.69047619047619  nrs=0.69047619047619 sa=0 sb=0 sd=0 mult=1 m=1
csn_op1_0900_s5_w20_0 sn_op1_0900_s5_w20_0 0 {C_SN}
XMWR_op1_0900_s5_w20_1 sn_op1_0900_s5_w20_1 wwl_des wbl_op1_0900_s5_w20 0 sky130_fd_pr__nfet_01v8 L=0.15 W=0.42 nf=1 ad=0.1218 as=0.1218 pd=1.42 ps=1.42 nrd=0.69047619047619  nrs=0.69047619047619 sa=0 sb=0 sd=0 mult=1 m=1
XMRD_op1_0900_s5_w20_1 rbl_op1_0900_s5_w20 sn_op1_0900_s5_w20_1 rwl_des 0 sky130_fd_pr__nfet_01v8 L=0.15 W=0.42 nf=1 ad=0.1218 as=0.1218 pd=1.42 ps=1.42 nrd=0.69047619047619  nrs=0.69047619047619 sa=0 sb=0 sd=0 mult=1 m=1
csn_op1_0900_s5_w20_1 sn_op1_0900_s5_w20_1 0 {C_SN}
XMWR_op1_0900_s5_w20_2 sn_op1_0900_s5_w20_2 wwl_des wbl_op1_0900_s5_w20 0 sky130_fd_pr__nfet_01v8 L=0.15 W=0.42 nf=1 ad=0.1218 as=0.1218 pd=1.42 ps=1.42 nrd=0.69047619047619  nrs=0.69047619047619 sa=0 sb=0 sd=0 mult=1 m=1
XMRD_op1_0900_s5_w20_2 rbl_op1_0900_s5_w20 sn_op1_0900_s5_w20_2 rwl_des 0 sky130_fd_pr__nfet_01v8 L=0.15 W=0.42 nf=1 ad=0.1218 as=0.1218 pd=1.42 ps=1.42 nrd=0.69047619047619  nrs=0.69047619047619 sa=0 sb=0 sd=0 mult=1 m=1
csn_op1_0900_s5_w20_2 sn_op1_0900_s5_w20_2 0 {C_SN}
XMWR_op1_0900_s5_w20_3 sn_op1_0900_s5_w20_3 wwl_des wbl_op1_0900_s5_w20 0 sky130_fd_pr__nfet_01v8 L=0.15 W=0.42 nf=1 ad=0.1218 as=0.1218 pd=1.42 ps=1.42 nrd=0.69047619047619  nrs=0.69047619047619 sa=0 sb=0 sd=0 mult=1 m=1
XMRD_op1_0900_s5_w20_3 rbl_op1_0900_s5_w20 sn_op1_0900_s5_w20_3 rwl_des 0 sky130_fd_pr__nfet_01v8 L=0.15 W=0.42 nf=1 ad=0.1218 as=0.1218 pd=1.42 ps=1.42 nrd=0.69047619047619  nrs=0.69047619047619 sa=0 sb=0 sd=0 mult=1 m=1
csn_op1_0900_s5_w20_3 sn_op1_0900_s5_w20_3 0 {C_SN}
XMN1_op1_0900_s5_w20 rbl_op1_0900_s5_w20 ref_op1_0900_s5_w20 vn_op1_0900_s5_w20 0 sky130_fd_pr__nfet_01v8 L=0.15 W=1 nf=1 ad=0.29 as=0.29 pd=2.58 ps=2.58 mult=1 m=1
XMN2_op1_0900_s5_w20 ref_op1_0900_s5_w20 rbl_op1_0900_s5_w20 vn_op1_0900_s5_w20 0 sky130_fd_pr__nfet_01v8 L=0.15 W=1 nf=1 ad=0.29 as=0.29 pd=2.58 ps=2.58 mult=1 m=1
XMP1_op1_0900_s5_w20 rbl_op1_0900_s5_w20 ref_op1_0900_s5_w20 vp_op1_0900_s5_w20 vdd sky130_fd_pr__pfet_01v8 L=0.15 W=2 nf=1 ad=0.58 as=0.58 pd=4.58 ps=4.58 mult=1 m=1
XMP2_op1_0900_s5_w20 ref_op1_0900_s5_w20 rbl_op1_0900_s5_w20 vp_op1_0900_s5_w20 vdd sky130_fd_pr__pfet_01v8 L=0.15 W=2 nf=1 ad=0.58 as=0.58 pd=4.58 ps=4.58 mult=1 m=1
XMNF_op1_0900_s5_w20 vn_op1_0900_s5_w20 en_op1_0900_s5_w20 0 0 sky130_fd_pr__nfet_01v8 L=0.15 W=2 nf=1 ad=0.58 as=0.58 pd=4.58 ps=4.58 mult=1 m=1
XMPH_op1_0900_s5_w20 vp_op1_0900_s5_w20 enb_op1_0900_s5_w20 vdd vdd sky130_fd_pr__pfet_01v8 L=0.15 W=4 nf=1 ad=1.16 as=1.16 pd=8.58 ps=8.58 mult=1 m=1
bd_op1_0900_s5_w20 d_op1_0900_s5_w20 0 v=v(rbl_op1_0900_s5_w20)-v(ref_op1_0900_s5_w20)

* ---- instance 46: op1_0900_s5_w30 (t_en 9 ns, WWL 10..40 ns, release 42 ns) ----
ven_op1_0900_s5_w30  en_op1_0900_s5_w30  0 pwl(0 0 9.0000e-09 0 9.1000e-09 {VDD} 4.2000e-08 {VDD} 4.2100e-08 0)
venb_op1_0900_s5_w30 enb_op1_0900_s5_w30 0 pwl(0 {VDD} 9.0000e-09 {VDD} 9.1000e-09 0 4.2000e-08 0 4.2100e-08 {VDD})
vrs_op1_0900_s5_w30  rwls_op1_0900_s5_w30 0 pwl(0 {VDD} {T_READ} {VDD} {T_READ+TEDGE} 0 4.2000e-08 0 4.2100e-08 {VDD})
vww_op1_0900_s5_w30  wwl_op1_0900_s5_w30 0 pwl(0 0 1.0000e-08 0 1.0100e-08 {VDD} 4.0000e-08 {VDD} 4.0100e-08 0)
vwc_op1_0900_s5_w30  wbc_op1_0900_s5_w30 0 pwl(0 0 1.0000e-08 0 1.0100e-08 {VDD} 4.2000e-08 {VDD} 4.2100e-08 0)
swb_op1_0900_s5_w30 ref_op1_0900_s5_w30 wbl_op1_0900_s5_w30 wbc_op1_0900_s5_w30 0 swwbl
cwbl_op1_0900_s5_w30 wbl_op1_0900_s5_w30 0 {C_WBL}
spa_op1_0900_s5_w30 prea rbl_op1_0900_s5_w30 ctl 0 swpre
spr_op1_0900_s5_w30 pref ref_op1_0900_s5_w30 ctl 0 swpre
crbl_op1_0900_s5_w30 rbl_op1_0900_s5_w30 0 {C_RBL}
cref_op1_0900_s5_w30 ref_op1_0900_s5_w30 0 {C_RBL}   $ ASSUMPTION: ideal matched dummy load
XMWR_op1_0900_s5_w30_0 sn_op1_0900_s5_w30_0 wwl_op1_0900_s5_w30 wbl_op1_0900_s5_w30 0 sky130_fd_pr__nfet_01v8 L=0.15 W=0.42 nf=1 ad=0.1218 as=0.1218 pd=1.42 ps=1.42 nrd=0.69047619047619  nrs=0.69047619047619 sa=0 sb=0 sd=0 mult=1 m=1
XMRD_op1_0900_s5_w30_0 rbl_op1_0900_s5_w30 sn_op1_0900_s5_w30_0 rwls_op1_0900_s5_w30 0 sky130_fd_pr__nfet_01v8 L=0.15 W=0.42 nf=1 ad=0.1218 as=0.1218 pd=1.42 ps=1.42 nrd=0.69047619047619  nrs=0.69047619047619 sa=0 sb=0 sd=0 mult=1 m=1
csn_op1_0900_s5_w30_0 sn_op1_0900_s5_w30_0 0 {C_SN}
XMWR_op1_0900_s5_w30_1 sn_op1_0900_s5_w30_1 wwl_des wbl_op1_0900_s5_w30 0 sky130_fd_pr__nfet_01v8 L=0.15 W=0.42 nf=1 ad=0.1218 as=0.1218 pd=1.42 ps=1.42 nrd=0.69047619047619  nrs=0.69047619047619 sa=0 sb=0 sd=0 mult=1 m=1
XMRD_op1_0900_s5_w30_1 rbl_op1_0900_s5_w30 sn_op1_0900_s5_w30_1 rwl_des 0 sky130_fd_pr__nfet_01v8 L=0.15 W=0.42 nf=1 ad=0.1218 as=0.1218 pd=1.42 ps=1.42 nrd=0.69047619047619  nrs=0.69047619047619 sa=0 sb=0 sd=0 mult=1 m=1
csn_op1_0900_s5_w30_1 sn_op1_0900_s5_w30_1 0 {C_SN}
XMWR_op1_0900_s5_w30_2 sn_op1_0900_s5_w30_2 wwl_des wbl_op1_0900_s5_w30 0 sky130_fd_pr__nfet_01v8 L=0.15 W=0.42 nf=1 ad=0.1218 as=0.1218 pd=1.42 ps=1.42 nrd=0.69047619047619  nrs=0.69047619047619 sa=0 sb=0 sd=0 mult=1 m=1
XMRD_op1_0900_s5_w30_2 rbl_op1_0900_s5_w30 sn_op1_0900_s5_w30_2 rwl_des 0 sky130_fd_pr__nfet_01v8 L=0.15 W=0.42 nf=1 ad=0.1218 as=0.1218 pd=1.42 ps=1.42 nrd=0.69047619047619  nrs=0.69047619047619 sa=0 sb=0 sd=0 mult=1 m=1
csn_op1_0900_s5_w30_2 sn_op1_0900_s5_w30_2 0 {C_SN}
XMWR_op1_0900_s5_w30_3 sn_op1_0900_s5_w30_3 wwl_des wbl_op1_0900_s5_w30 0 sky130_fd_pr__nfet_01v8 L=0.15 W=0.42 nf=1 ad=0.1218 as=0.1218 pd=1.42 ps=1.42 nrd=0.69047619047619  nrs=0.69047619047619 sa=0 sb=0 sd=0 mult=1 m=1
XMRD_op1_0900_s5_w30_3 rbl_op1_0900_s5_w30 sn_op1_0900_s5_w30_3 rwl_des 0 sky130_fd_pr__nfet_01v8 L=0.15 W=0.42 nf=1 ad=0.1218 as=0.1218 pd=1.42 ps=1.42 nrd=0.69047619047619  nrs=0.69047619047619 sa=0 sb=0 sd=0 mult=1 m=1
csn_op1_0900_s5_w30_3 sn_op1_0900_s5_w30_3 0 {C_SN}
XMN1_op1_0900_s5_w30 rbl_op1_0900_s5_w30 ref_op1_0900_s5_w30 vn_op1_0900_s5_w30 0 sky130_fd_pr__nfet_01v8 L=0.15 W=1 nf=1 ad=0.29 as=0.29 pd=2.58 ps=2.58 mult=1 m=1
XMN2_op1_0900_s5_w30 ref_op1_0900_s5_w30 rbl_op1_0900_s5_w30 vn_op1_0900_s5_w30 0 sky130_fd_pr__nfet_01v8 L=0.15 W=1 nf=1 ad=0.29 as=0.29 pd=2.58 ps=2.58 mult=1 m=1
XMP1_op1_0900_s5_w30 rbl_op1_0900_s5_w30 ref_op1_0900_s5_w30 vp_op1_0900_s5_w30 vdd sky130_fd_pr__pfet_01v8 L=0.15 W=2 nf=1 ad=0.58 as=0.58 pd=4.58 ps=4.58 mult=1 m=1
XMP2_op1_0900_s5_w30 ref_op1_0900_s5_w30 rbl_op1_0900_s5_w30 vp_op1_0900_s5_w30 vdd sky130_fd_pr__pfet_01v8 L=0.15 W=2 nf=1 ad=0.58 as=0.58 pd=4.58 ps=4.58 mult=1 m=1
XMNF_op1_0900_s5_w30 vn_op1_0900_s5_w30 en_op1_0900_s5_w30 0 0 sky130_fd_pr__nfet_01v8 L=0.15 W=2 nf=1 ad=0.58 as=0.58 pd=4.58 ps=4.58 mult=1 m=1
XMPH_op1_0900_s5_w30 vp_op1_0900_s5_w30 enb_op1_0900_s5_w30 vdd vdd sky130_fd_pr__pfet_01v8 L=0.15 W=4 nf=1 ad=1.16 as=1.16 pd=8.58 ps=8.58 mult=1 m=1
bd_op1_0900_s5_w30 d_op1_0900_s5_w30 0 v=v(rbl_op1_0900_s5_w30)-v(ref_op1_0900_s5_w30)

* ---- instance 47: op1_0900_s5_w50 (t_en 9 ns, WWL 10..60 ns, release 62 ns) ----
ven_op1_0900_s5_w50  en_op1_0900_s5_w50  0 pwl(0 0 9.0000e-09 0 9.1000e-09 {VDD} 6.2000e-08 {VDD} 6.2100e-08 0)
venb_op1_0900_s5_w50 enb_op1_0900_s5_w50 0 pwl(0 {VDD} 9.0000e-09 {VDD} 9.1000e-09 0 6.2000e-08 0 6.2100e-08 {VDD})
vrs_op1_0900_s5_w50  rwls_op1_0900_s5_w50 0 pwl(0 {VDD} {T_READ} {VDD} {T_READ+TEDGE} 0 6.2000e-08 0 6.2100e-08 {VDD})
vww_op1_0900_s5_w50  wwl_op1_0900_s5_w50 0 pwl(0 0 1.0000e-08 0 1.0100e-08 {VDD} 6.0000e-08 {VDD} 6.0100e-08 0)
vwc_op1_0900_s5_w50  wbc_op1_0900_s5_w50 0 pwl(0 0 1.0000e-08 0 1.0100e-08 {VDD} 6.2000e-08 {VDD} 6.2100e-08 0)
swb_op1_0900_s5_w50 ref_op1_0900_s5_w50 wbl_op1_0900_s5_w50 wbc_op1_0900_s5_w50 0 swwbl
cwbl_op1_0900_s5_w50 wbl_op1_0900_s5_w50 0 {C_WBL}
spa_op1_0900_s5_w50 prea rbl_op1_0900_s5_w50 ctl 0 swpre
spr_op1_0900_s5_w50 pref ref_op1_0900_s5_w50 ctl 0 swpre
crbl_op1_0900_s5_w50 rbl_op1_0900_s5_w50 0 {C_RBL}
cref_op1_0900_s5_w50 ref_op1_0900_s5_w50 0 {C_RBL}   $ ASSUMPTION: ideal matched dummy load
XMWR_op1_0900_s5_w50_0 sn_op1_0900_s5_w50_0 wwl_op1_0900_s5_w50 wbl_op1_0900_s5_w50 0 sky130_fd_pr__nfet_01v8 L=0.15 W=0.42 nf=1 ad=0.1218 as=0.1218 pd=1.42 ps=1.42 nrd=0.69047619047619  nrs=0.69047619047619 sa=0 sb=0 sd=0 mult=1 m=1
XMRD_op1_0900_s5_w50_0 rbl_op1_0900_s5_w50 sn_op1_0900_s5_w50_0 rwls_op1_0900_s5_w50 0 sky130_fd_pr__nfet_01v8 L=0.15 W=0.42 nf=1 ad=0.1218 as=0.1218 pd=1.42 ps=1.42 nrd=0.69047619047619  nrs=0.69047619047619 sa=0 sb=0 sd=0 mult=1 m=1
csn_op1_0900_s5_w50_0 sn_op1_0900_s5_w50_0 0 {C_SN}
XMWR_op1_0900_s5_w50_1 sn_op1_0900_s5_w50_1 wwl_des wbl_op1_0900_s5_w50 0 sky130_fd_pr__nfet_01v8 L=0.15 W=0.42 nf=1 ad=0.1218 as=0.1218 pd=1.42 ps=1.42 nrd=0.69047619047619  nrs=0.69047619047619 sa=0 sb=0 sd=0 mult=1 m=1
XMRD_op1_0900_s5_w50_1 rbl_op1_0900_s5_w50 sn_op1_0900_s5_w50_1 rwl_des 0 sky130_fd_pr__nfet_01v8 L=0.15 W=0.42 nf=1 ad=0.1218 as=0.1218 pd=1.42 ps=1.42 nrd=0.69047619047619  nrs=0.69047619047619 sa=0 sb=0 sd=0 mult=1 m=1
csn_op1_0900_s5_w50_1 sn_op1_0900_s5_w50_1 0 {C_SN}
XMWR_op1_0900_s5_w50_2 sn_op1_0900_s5_w50_2 wwl_des wbl_op1_0900_s5_w50 0 sky130_fd_pr__nfet_01v8 L=0.15 W=0.42 nf=1 ad=0.1218 as=0.1218 pd=1.42 ps=1.42 nrd=0.69047619047619  nrs=0.69047619047619 sa=0 sb=0 sd=0 mult=1 m=1
XMRD_op1_0900_s5_w50_2 rbl_op1_0900_s5_w50 sn_op1_0900_s5_w50_2 rwl_des 0 sky130_fd_pr__nfet_01v8 L=0.15 W=0.42 nf=1 ad=0.1218 as=0.1218 pd=1.42 ps=1.42 nrd=0.69047619047619  nrs=0.69047619047619 sa=0 sb=0 sd=0 mult=1 m=1
csn_op1_0900_s5_w50_2 sn_op1_0900_s5_w50_2 0 {C_SN}
XMWR_op1_0900_s5_w50_3 sn_op1_0900_s5_w50_3 wwl_des wbl_op1_0900_s5_w50 0 sky130_fd_pr__nfet_01v8 L=0.15 W=0.42 nf=1 ad=0.1218 as=0.1218 pd=1.42 ps=1.42 nrd=0.69047619047619  nrs=0.69047619047619 sa=0 sb=0 sd=0 mult=1 m=1
XMRD_op1_0900_s5_w50_3 rbl_op1_0900_s5_w50 sn_op1_0900_s5_w50_3 rwl_des 0 sky130_fd_pr__nfet_01v8 L=0.15 W=0.42 nf=1 ad=0.1218 as=0.1218 pd=1.42 ps=1.42 nrd=0.69047619047619  nrs=0.69047619047619 sa=0 sb=0 sd=0 mult=1 m=1
csn_op1_0900_s5_w50_3 sn_op1_0900_s5_w50_3 0 {C_SN}
XMN1_op1_0900_s5_w50 rbl_op1_0900_s5_w50 ref_op1_0900_s5_w50 vn_op1_0900_s5_w50 0 sky130_fd_pr__nfet_01v8 L=0.15 W=1 nf=1 ad=0.29 as=0.29 pd=2.58 ps=2.58 mult=1 m=1
XMN2_op1_0900_s5_w50 ref_op1_0900_s5_w50 rbl_op1_0900_s5_w50 vn_op1_0900_s5_w50 0 sky130_fd_pr__nfet_01v8 L=0.15 W=1 nf=1 ad=0.29 as=0.29 pd=2.58 ps=2.58 mult=1 m=1
XMP1_op1_0900_s5_w50 rbl_op1_0900_s5_w50 ref_op1_0900_s5_w50 vp_op1_0900_s5_w50 vdd sky130_fd_pr__pfet_01v8 L=0.15 W=2 nf=1 ad=0.58 as=0.58 pd=4.58 ps=4.58 mult=1 m=1
XMP2_op1_0900_s5_w50 ref_op1_0900_s5_w50 rbl_op1_0900_s5_w50 vp_op1_0900_s5_w50 vdd sky130_fd_pr__pfet_01v8 L=0.15 W=2 nf=1 ad=0.58 as=0.58 pd=4.58 ps=4.58 mult=1 m=1
XMNF_op1_0900_s5_w50 vn_op1_0900_s5_w50 en_op1_0900_s5_w50 0 0 sky130_fd_pr__nfet_01v8 L=0.15 W=2 nf=1 ad=0.58 as=0.58 pd=4.58 ps=4.58 mult=1 m=1
XMPH_op1_0900_s5_w50 vp_op1_0900_s5_w50 enb_op1_0900_s5_w50 vdd vdd sky130_fd_pr__pfet_01v8 L=0.15 W=4 nf=1 ad=1.16 as=1.16 pd=8.58 ps=8.58 mult=1 m=1
bd_op1_0900_s5_w50 d_op1_0900_s5_w50 0 v=v(rbl_op1_0900_s5_w50)-v(ref_op1_0900_s5_w50)

* ---- instance 48: op1_0900_s10_w0p2 (t_en 14 ns, WWL 15..15.2 ns, release 17.2 ns) ----
ven_op1_0900_s10_w0p2  en_op1_0900_s10_w0p2  0 pwl(0 0 1.4000e-08 0 1.4100e-08 {VDD} 1.7200e-08 {VDD} 1.7300e-08 0)
venb_op1_0900_s10_w0p2 enb_op1_0900_s10_w0p2 0 pwl(0 {VDD} 1.4000e-08 {VDD} 1.4100e-08 0 1.7200e-08 0 1.7300e-08 {VDD})
vrs_op1_0900_s10_w0p2  rwls_op1_0900_s10_w0p2 0 pwl(0 {VDD} {T_READ} {VDD} {T_READ+TEDGE} 0 1.7200e-08 0 1.7300e-08 {VDD})
vww_op1_0900_s10_w0p2  wwl_op1_0900_s10_w0p2 0 pwl(0 0 1.5000e-08 0 1.5100e-08 {VDD} 1.5200e-08 {VDD} 1.5300e-08 0)
vwc_op1_0900_s10_w0p2  wbc_op1_0900_s10_w0p2 0 pwl(0 0 1.5000e-08 0 1.5100e-08 {VDD} 1.7200e-08 {VDD} 1.7300e-08 0)
swb_op1_0900_s10_w0p2 ref_op1_0900_s10_w0p2 wbl_op1_0900_s10_w0p2 wbc_op1_0900_s10_w0p2 0 swwbl
cwbl_op1_0900_s10_w0p2 wbl_op1_0900_s10_w0p2 0 {C_WBL}
spa_op1_0900_s10_w0p2 prea rbl_op1_0900_s10_w0p2 ctl 0 swpre
spr_op1_0900_s10_w0p2 pref ref_op1_0900_s10_w0p2 ctl 0 swpre
crbl_op1_0900_s10_w0p2 rbl_op1_0900_s10_w0p2 0 {C_RBL}
cref_op1_0900_s10_w0p2 ref_op1_0900_s10_w0p2 0 {C_RBL}   $ ASSUMPTION: ideal matched dummy load
XMWR_op1_0900_s10_w0p2_0 sn_op1_0900_s10_w0p2_0 wwl_op1_0900_s10_w0p2 wbl_op1_0900_s10_w0p2 0 sky130_fd_pr__nfet_01v8 L=0.15 W=0.42 nf=1 ad=0.1218 as=0.1218 pd=1.42 ps=1.42 nrd=0.69047619047619  nrs=0.69047619047619 sa=0 sb=0 sd=0 mult=1 m=1
XMRD_op1_0900_s10_w0p2_0 rbl_op1_0900_s10_w0p2 sn_op1_0900_s10_w0p2_0 rwls_op1_0900_s10_w0p2 0 sky130_fd_pr__nfet_01v8 L=0.15 W=0.42 nf=1 ad=0.1218 as=0.1218 pd=1.42 ps=1.42 nrd=0.69047619047619  nrs=0.69047619047619 sa=0 sb=0 sd=0 mult=1 m=1
csn_op1_0900_s10_w0p2_0 sn_op1_0900_s10_w0p2_0 0 {C_SN}
XMWR_op1_0900_s10_w0p2_1 sn_op1_0900_s10_w0p2_1 wwl_des wbl_op1_0900_s10_w0p2 0 sky130_fd_pr__nfet_01v8 L=0.15 W=0.42 nf=1 ad=0.1218 as=0.1218 pd=1.42 ps=1.42 nrd=0.69047619047619  nrs=0.69047619047619 sa=0 sb=0 sd=0 mult=1 m=1
XMRD_op1_0900_s10_w0p2_1 rbl_op1_0900_s10_w0p2 sn_op1_0900_s10_w0p2_1 rwl_des 0 sky130_fd_pr__nfet_01v8 L=0.15 W=0.42 nf=1 ad=0.1218 as=0.1218 pd=1.42 ps=1.42 nrd=0.69047619047619  nrs=0.69047619047619 sa=0 sb=0 sd=0 mult=1 m=1
csn_op1_0900_s10_w0p2_1 sn_op1_0900_s10_w0p2_1 0 {C_SN}
XMWR_op1_0900_s10_w0p2_2 sn_op1_0900_s10_w0p2_2 wwl_des wbl_op1_0900_s10_w0p2 0 sky130_fd_pr__nfet_01v8 L=0.15 W=0.42 nf=1 ad=0.1218 as=0.1218 pd=1.42 ps=1.42 nrd=0.69047619047619  nrs=0.69047619047619 sa=0 sb=0 sd=0 mult=1 m=1
XMRD_op1_0900_s10_w0p2_2 rbl_op1_0900_s10_w0p2 sn_op1_0900_s10_w0p2_2 rwl_des 0 sky130_fd_pr__nfet_01v8 L=0.15 W=0.42 nf=1 ad=0.1218 as=0.1218 pd=1.42 ps=1.42 nrd=0.69047619047619  nrs=0.69047619047619 sa=0 sb=0 sd=0 mult=1 m=1
csn_op1_0900_s10_w0p2_2 sn_op1_0900_s10_w0p2_2 0 {C_SN}
XMWR_op1_0900_s10_w0p2_3 sn_op1_0900_s10_w0p2_3 wwl_des wbl_op1_0900_s10_w0p2 0 sky130_fd_pr__nfet_01v8 L=0.15 W=0.42 nf=1 ad=0.1218 as=0.1218 pd=1.42 ps=1.42 nrd=0.69047619047619  nrs=0.69047619047619 sa=0 sb=0 sd=0 mult=1 m=1
XMRD_op1_0900_s10_w0p2_3 rbl_op1_0900_s10_w0p2 sn_op1_0900_s10_w0p2_3 rwl_des 0 sky130_fd_pr__nfet_01v8 L=0.15 W=0.42 nf=1 ad=0.1218 as=0.1218 pd=1.42 ps=1.42 nrd=0.69047619047619  nrs=0.69047619047619 sa=0 sb=0 sd=0 mult=1 m=1
csn_op1_0900_s10_w0p2_3 sn_op1_0900_s10_w0p2_3 0 {C_SN}
XMN1_op1_0900_s10_w0p2 rbl_op1_0900_s10_w0p2 ref_op1_0900_s10_w0p2 vn_op1_0900_s10_w0p2 0 sky130_fd_pr__nfet_01v8 L=0.15 W=1 nf=1 ad=0.29 as=0.29 pd=2.58 ps=2.58 mult=1 m=1
XMN2_op1_0900_s10_w0p2 ref_op1_0900_s10_w0p2 rbl_op1_0900_s10_w0p2 vn_op1_0900_s10_w0p2 0 sky130_fd_pr__nfet_01v8 L=0.15 W=1 nf=1 ad=0.29 as=0.29 pd=2.58 ps=2.58 mult=1 m=1
XMP1_op1_0900_s10_w0p2 rbl_op1_0900_s10_w0p2 ref_op1_0900_s10_w0p2 vp_op1_0900_s10_w0p2 vdd sky130_fd_pr__pfet_01v8 L=0.15 W=2 nf=1 ad=0.58 as=0.58 pd=4.58 ps=4.58 mult=1 m=1
XMP2_op1_0900_s10_w0p2 ref_op1_0900_s10_w0p2 rbl_op1_0900_s10_w0p2 vp_op1_0900_s10_w0p2 vdd sky130_fd_pr__pfet_01v8 L=0.15 W=2 nf=1 ad=0.58 as=0.58 pd=4.58 ps=4.58 mult=1 m=1
XMNF_op1_0900_s10_w0p2 vn_op1_0900_s10_w0p2 en_op1_0900_s10_w0p2 0 0 sky130_fd_pr__nfet_01v8 L=0.15 W=2 nf=1 ad=0.58 as=0.58 pd=4.58 ps=4.58 mult=1 m=1
XMPH_op1_0900_s10_w0p2 vp_op1_0900_s10_w0p2 enb_op1_0900_s10_w0p2 vdd vdd sky130_fd_pr__pfet_01v8 L=0.15 W=4 nf=1 ad=1.16 as=1.16 pd=8.58 ps=8.58 mult=1 m=1
bd_op1_0900_s10_w0p2 d_op1_0900_s10_w0p2 0 v=v(rbl_op1_0900_s10_w0p2)-v(ref_op1_0900_s10_w0p2)

* ---- instance 49: op1_0900_s10_w0p5 (t_en 14 ns, WWL 15..15.5 ns, release 17.5 ns) ----
ven_op1_0900_s10_w0p5  en_op1_0900_s10_w0p5  0 pwl(0 0 1.4000e-08 0 1.4100e-08 {VDD} 1.7500e-08 {VDD} 1.7600e-08 0)
venb_op1_0900_s10_w0p5 enb_op1_0900_s10_w0p5 0 pwl(0 {VDD} 1.4000e-08 {VDD} 1.4100e-08 0 1.7500e-08 0 1.7600e-08 {VDD})
vrs_op1_0900_s10_w0p5  rwls_op1_0900_s10_w0p5 0 pwl(0 {VDD} {T_READ} {VDD} {T_READ+TEDGE} 0 1.7500e-08 0 1.7600e-08 {VDD})
vww_op1_0900_s10_w0p5  wwl_op1_0900_s10_w0p5 0 pwl(0 0 1.5000e-08 0 1.5100e-08 {VDD} 1.5500e-08 {VDD} 1.5600e-08 0)
vwc_op1_0900_s10_w0p5  wbc_op1_0900_s10_w0p5 0 pwl(0 0 1.5000e-08 0 1.5100e-08 {VDD} 1.7500e-08 {VDD} 1.7600e-08 0)
swb_op1_0900_s10_w0p5 ref_op1_0900_s10_w0p5 wbl_op1_0900_s10_w0p5 wbc_op1_0900_s10_w0p5 0 swwbl
cwbl_op1_0900_s10_w0p5 wbl_op1_0900_s10_w0p5 0 {C_WBL}
spa_op1_0900_s10_w0p5 prea rbl_op1_0900_s10_w0p5 ctl 0 swpre
spr_op1_0900_s10_w0p5 pref ref_op1_0900_s10_w0p5 ctl 0 swpre
crbl_op1_0900_s10_w0p5 rbl_op1_0900_s10_w0p5 0 {C_RBL}
cref_op1_0900_s10_w0p5 ref_op1_0900_s10_w0p5 0 {C_RBL}   $ ASSUMPTION: ideal matched dummy load
XMWR_op1_0900_s10_w0p5_0 sn_op1_0900_s10_w0p5_0 wwl_op1_0900_s10_w0p5 wbl_op1_0900_s10_w0p5 0 sky130_fd_pr__nfet_01v8 L=0.15 W=0.42 nf=1 ad=0.1218 as=0.1218 pd=1.42 ps=1.42 nrd=0.69047619047619  nrs=0.69047619047619 sa=0 sb=0 sd=0 mult=1 m=1
XMRD_op1_0900_s10_w0p5_0 rbl_op1_0900_s10_w0p5 sn_op1_0900_s10_w0p5_0 rwls_op1_0900_s10_w0p5 0 sky130_fd_pr__nfet_01v8 L=0.15 W=0.42 nf=1 ad=0.1218 as=0.1218 pd=1.42 ps=1.42 nrd=0.69047619047619  nrs=0.69047619047619 sa=0 sb=0 sd=0 mult=1 m=1
csn_op1_0900_s10_w0p5_0 sn_op1_0900_s10_w0p5_0 0 {C_SN}
XMWR_op1_0900_s10_w0p5_1 sn_op1_0900_s10_w0p5_1 wwl_des wbl_op1_0900_s10_w0p5 0 sky130_fd_pr__nfet_01v8 L=0.15 W=0.42 nf=1 ad=0.1218 as=0.1218 pd=1.42 ps=1.42 nrd=0.69047619047619  nrs=0.69047619047619 sa=0 sb=0 sd=0 mult=1 m=1
XMRD_op1_0900_s10_w0p5_1 rbl_op1_0900_s10_w0p5 sn_op1_0900_s10_w0p5_1 rwl_des 0 sky130_fd_pr__nfet_01v8 L=0.15 W=0.42 nf=1 ad=0.1218 as=0.1218 pd=1.42 ps=1.42 nrd=0.69047619047619  nrs=0.69047619047619 sa=0 sb=0 sd=0 mult=1 m=1
csn_op1_0900_s10_w0p5_1 sn_op1_0900_s10_w0p5_1 0 {C_SN}
XMWR_op1_0900_s10_w0p5_2 sn_op1_0900_s10_w0p5_2 wwl_des wbl_op1_0900_s10_w0p5 0 sky130_fd_pr__nfet_01v8 L=0.15 W=0.42 nf=1 ad=0.1218 as=0.1218 pd=1.42 ps=1.42 nrd=0.69047619047619  nrs=0.69047619047619 sa=0 sb=0 sd=0 mult=1 m=1
XMRD_op1_0900_s10_w0p5_2 rbl_op1_0900_s10_w0p5 sn_op1_0900_s10_w0p5_2 rwl_des 0 sky130_fd_pr__nfet_01v8 L=0.15 W=0.42 nf=1 ad=0.1218 as=0.1218 pd=1.42 ps=1.42 nrd=0.69047619047619  nrs=0.69047619047619 sa=0 sb=0 sd=0 mult=1 m=1
csn_op1_0900_s10_w0p5_2 sn_op1_0900_s10_w0p5_2 0 {C_SN}
XMWR_op1_0900_s10_w0p5_3 sn_op1_0900_s10_w0p5_3 wwl_des wbl_op1_0900_s10_w0p5 0 sky130_fd_pr__nfet_01v8 L=0.15 W=0.42 nf=1 ad=0.1218 as=0.1218 pd=1.42 ps=1.42 nrd=0.69047619047619  nrs=0.69047619047619 sa=0 sb=0 sd=0 mult=1 m=1
XMRD_op1_0900_s10_w0p5_3 rbl_op1_0900_s10_w0p5 sn_op1_0900_s10_w0p5_3 rwl_des 0 sky130_fd_pr__nfet_01v8 L=0.15 W=0.42 nf=1 ad=0.1218 as=0.1218 pd=1.42 ps=1.42 nrd=0.69047619047619  nrs=0.69047619047619 sa=0 sb=0 sd=0 mult=1 m=1
csn_op1_0900_s10_w0p5_3 sn_op1_0900_s10_w0p5_3 0 {C_SN}
XMN1_op1_0900_s10_w0p5 rbl_op1_0900_s10_w0p5 ref_op1_0900_s10_w0p5 vn_op1_0900_s10_w0p5 0 sky130_fd_pr__nfet_01v8 L=0.15 W=1 nf=1 ad=0.29 as=0.29 pd=2.58 ps=2.58 mult=1 m=1
XMN2_op1_0900_s10_w0p5 ref_op1_0900_s10_w0p5 rbl_op1_0900_s10_w0p5 vn_op1_0900_s10_w0p5 0 sky130_fd_pr__nfet_01v8 L=0.15 W=1 nf=1 ad=0.29 as=0.29 pd=2.58 ps=2.58 mult=1 m=1
XMP1_op1_0900_s10_w0p5 rbl_op1_0900_s10_w0p5 ref_op1_0900_s10_w0p5 vp_op1_0900_s10_w0p5 vdd sky130_fd_pr__pfet_01v8 L=0.15 W=2 nf=1 ad=0.58 as=0.58 pd=4.58 ps=4.58 mult=1 m=1
XMP2_op1_0900_s10_w0p5 ref_op1_0900_s10_w0p5 rbl_op1_0900_s10_w0p5 vp_op1_0900_s10_w0p5 vdd sky130_fd_pr__pfet_01v8 L=0.15 W=2 nf=1 ad=0.58 as=0.58 pd=4.58 ps=4.58 mult=1 m=1
XMNF_op1_0900_s10_w0p5 vn_op1_0900_s10_w0p5 en_op1_0900_s10_w0p5 0 0 sky130_fd_pr__nfet_01v8 L=0.15 W=2 nf=1 ad=0.58 as=0.58 pd=4.58 ps=4.58 mult=1 m=1
XMPH_op1_0900_s10_w0p5 vp_op1_0900_s10_w0p5 enb_op1_0900_s10_w0p5 vdd vdd sky130_fd_pr__pfet_01v8 L=0.15 W=4 nf=1 ad=1.16 as=1.16 pd=8.58 ps=8.58 mult=1 m=1
bd_op1_0900_s10_w0p5 d_op1_0900_s10_w0p5 0 v=v(rbl_op1_0900_s10_w0p5)-v(ref_op1_0900_s10_w0p5)

* ---- instance 50: op1_0900_s10_w1 (t_en 14 ns, WWL 15..16 ns, release 18 ns) ----
ven_op1_0900_s10_w1  en_op1_0900_s10_w1  0 pwl(0 0 1.4000e-08 0 1.4100e-08 {VDD} 1.8000e-08 {VDD} 1.8100e-08 0)
venb_op1_0900_s10_w1 enb_op1_0900_s10_w1 0 pwl(0 {VDD} 1.4000e-08 {VDD} 1.4100e-08 0 1.8000e-08 0 1.8100e-08 {VDD})
vrs_op1_0900_s10_w1  rwls_op1_0900_s10_w1 0 pwl(0 {VDD} {T_READ} {VDD} {T_READ+TEDGE} 0 1.8000e-08 0 1.8100e-08 {VDD})
vww_op1_0900_s10_w1  wwl_op1_0900_s10_w1 0 pwl(0 0 1.5000e-08 0 1.5100e-08 {VDD} 1.6000e-08 {VDD} 1.6100e-08 0)
vwc_op1_0900_s10_w1  wbc_op1_0900_s10_w1 0 pwl(0 0 1.5000e-08 0 1.5100e-08 {VDD} 1.8000e-08 {VDD} 1.8100e-08 0)
swb_op1_0900_s10_w1 ref_op1_0900_s10_w1 wbl_op1_0900_s10_w1 wbc_op1_0900_s10_w1 0 swwbl
cwbl_op1_0900_s10_w1 wbl_op1_0900_s10_w1 0 {C_WBL}
spa_op1_0900_s10_w1 prea rbl_op1_0900_s10_w1 ctl 0 swpre
spr_op1_0900_s10_w1 pref ref_op1_0900_s10_w1 ctl 0 swpre
crbl_op1_0900_s10_w1 rbl_op1_0900_s10_w1 0 {C_RBL}
cref_op1_0900_s10_w1 ref_op1_0900_s10_w1 0 {C_RBL}   $ ASSUMPTION: ideal matched dummy load
XMWR_op1_0900_s10_w1_0 sn_op1_0900_s10_w1_0 wwl_op1_0900_s10_w1 wbl_op1_0900_s10_w1 0 sky130_fd_pr__nfet_01v8 L=0.15 W=0.42 nf=1 ad=0.1218 as=0.1218 pd=1.42 ps=1.42 nrd=0.69047619047619  nrs=0.69047619047619 sa=0 sb=0 sd=0 mult=1 m=1
XMRD_op1_0900_s10_w1_0 rbl_op1_0900_s10_w1 sn_op1_0900_s10_w1_0 rwls_op1_0900_s10_w1 0 sky130_fd_pr__nfet_01v8 L=0.15 W=0.42 nf=1 ad=0.1218 as=0.1218 pd=1.42 ps=1.42 nrd=0.69047619047619  nrs=0.69047619047619 sa=0 sb=0 sd=0 mult=1 m=1
csn_op1_0900_s10_w1_0 sn_op1_0900_s10_w1_0 0 {C_SN}
XMWR_op1_0900_s10_w1_1 sn_op1_0900_s10_w1_1 wwl_des wbl_op1_0900_s10_w1 0 sky130_fd_pr__nfet_01v8 L=0.15 W=0.42 nf=1 ad=0.1218 as=0.1218 pd=1.42 ps=1.42 nrd=0.69047619047619  nrs=0.69047619047619 sa=0 sb=0 sd=0 mult=1 m=1
XMRD_op1_0900_s10_w1_1 rbl_op1_0900_s10_w1 sn_op1_0900_s10_w1_1 rwl_des 0 sky130_fd_pr__nfet_01v8 L=0.15 W=0.42 nf=1 ad=0.1218 as=0.1218 pd=1.42 ps=1.42 nrd=0.69047619047619  nrs=0.69047619047619 sa=0 sb=0 sd=0 mult=1 m=1
csn_op1_0900_s10_w1_1 sn_op1_0900_s10_w1_1 0 {C_SN}
XMWR_op1_0900_s10_w1_2 sn_op1_0900_s10_w1_2 wwl_des wbl_op1_0900_s10_w1 0 sky130_fd_pr__nfet_01v8 L=0.15 W=0.42 nf=1 ad=0.1218 as=0.1218 pd=1.42 ps=1.42 nrd=0.69047619047619  nrs=0.69047619047619 sa=0 sb=0 sd=0 mult=1 m=1
XMRD_op1_0900_s10_w1_2 rbl_op1_0900_s10_w1 sn_op1_0900_s10_w1_2 rwl_des 0 sky130_fd_pr__nfet_01v8 L=0.15 W=0.42 nf=1 ad=0.1218 as=0.1218 pd=1.42 ps=1.42 nrd=0.69047619047619  nrs=0.69047619047619 sa=0 sb=0 sd=0 mult=1 m=1
csn_op1_0900_s10_w1_2 sn_op1_0900_s10_w1_2 0 {C_SN}
XMWR_op1_0900_s10_w1_3 sn_op1_0900_s10_w1_3 wwl_des wbl_op1_0900_s10_w1 0 sky130_fd_pr__nfet_01v8 L=0.15 W=0.42 nf=1 ad=0.1218 as=0.1218 pd=1.42 ps=1.42 nrd=0.69047619047619  nrs=0.69047619047619 sa=0 sb=0 sd=0 mult=1 m=1
XMRD_op1_0900_s10_w1_3 rbl_op1_0900_s10_w1 sn_op1_0900_s10_w1_3 rwl_des 0 sky130_fd_pr__nfet_01v8 L=0.15 W=0.42 nf=1 ad=0.1218 as=0.1218 pd=1.42 ps=1.42 nrd=0.69047619047619  nrs=0.69047619047619 sa=0 sb=0 sd=0 mult=1 m=1
csn_op1_0900_s10_w1_3 sn_op1_0900_s10_w1_3 0 {C_SN}
XMN1_op1_0900_s10_w1 rbl_op1_0900_s10_w1 ref_op1_0900_s10_w1 vn_op1_0900_s10_w1 0 sky130_fd_pr__nfet_01v8 L=0.15 W=1 nf=1 ad=0.29 as=0.29 pd=2.58 ps=2.58 mult=1 m=1
XMN2_op1_0900_s10_w1 ref_op1_0900_s10_w1 rbl_op1_0900_s10_w1 vn_op1_0900_s10_w1 0 sky130_fd_pr__nfet_01v8 L=0.15 W=1 nf=1 ad=0.29 as=0.29 pd=2.58 ps=2.58 mult=1 m=1
XMP1_op1_0900_s10_w1 rbl_op1_0900_s10_w1 ref_op1_0900_s10_w1 vp_op1_0900_s10_w1 vdd sky130_fd_pr__pfet_01v8 L=0.15 W=2 nf=1 ad=0.58 as=0.58 pd=4.58 ps=4.58 mult=1 m=1
XMP2_op1_0900_s10_w1 ref_op1_0900_s10_w1 rbl_op1_0900_s10_w1 vp_op1_0900_s10_w1 vdd sky130_fd_pr__pfet_01v8 L=0.15 W=2 nf=1 ad=0.58 as=0.58 pd=4.58 ps=4.58 mult=1 m=1
XMNF_op1_0900_s10_w1 vn_op1_0900_s10_w1 en_op1_0900_s10_w1 0 0 sky130_fd_pr__nfet_01v8 L=0.15 W=2 nf=1 ad=0.58 as=0.58 pd=4.58 ps=4.58 mult=1 m=1
XMPH_op1_0900_s10_w1 vp_op1_0900_s10_w1 enb_op1_0900_s10_w1 vdd vdd sky130_fd_pr__pfet_01v8 L=0.15 W=4 nf=1 ad=1.16 as=1.16 pd=8.58 ps=8.58 mult=1 m=1
bd_op1_0900_s10_w1 d_op1_0900_s10_w1 0 v=v(rbl_op1_0900_s10_w1)-v(ref_op1_0900_s10_w1)

* ---- instance 51: op1_0900_s10_w2 (t_en 14 ns, WWL 15..17 ns, release 19 ns) ----
ven_op1_0900_s10_w2  en_op1_0900_s10_w2  0 pwl(0 0 1.4000e-08 0 1.4100e-08 {VDD} 1.9000e-08 {VDD} 1.9100e-08 0)
venb_op1_0900_s10_w2 enb_op1_0900_s10_w2 0 pwl(0 {VDD} 1.4000e-08 {VDD} 1.4100e-08 0 1.9000e-08 0 1.9100e-08 {VDD})
vrs_op1_0900_s10_w2  rwls_op1_0900_s10_w2 0 pwl(0 {VDD} {T_READ} {VDD} {T_READ+TEDGE} 0 1.9000e-08 0 1.9100e-08 {VDD})
vww_op1_0900_s10_w2  wwl_op1_0900_s10_w2 0 pwl(0 0 1.5000e-08 0 1.5100e-08 {VDD} 1.7000e-08 {VDD} 1.7100e-08 0)
vwc_op1_0900_s10_w2  wbc_op1_0900_s10_w2 0 pwl(0 0 1.5000e-08 0 1.5100e-08 {VDD} 1.9000e-08 {VDD} 1.9100e-08 0)
swb_op1_0900_s10_w2 ref_op1_0900_s10_w2 wbl_op1_0900_s10_w2 wbc_op1_0900_s10_w2 0 swwbl
cwbl_op1_0900_s10_w2 wbl_op1_0900_s10_w2 0 {C_WBL}
spa_op1_0900_s10_w2 prea rbl_op1_0900_s10_w2 ctl 0 swpre
spr_op1_0900_s10_w2 pref ref_op1_0900_s10_w2 ctl 0 swpre
crbl_op1_0900_s10_w2 rbl_op1_0900_s10_w2 0 {C_RBL}
cref_op1_0900_s10_w2 ref_op1_0900_s10_w2 0 {C_RBL}   $ ASSUMPTION: ideal matched dummy load
XMWR_op1_0900_s10_w2_0 sn_op1_0900_s10_w2_0 wwl_op1_0900_s10_w2 wbl_op1_0900_s10_w2 0 sky130_fd_pr__nfet_01v8 L=0.15 W=0.42 nf=1 ad=0.1218 as=0.1218 pd=1.42 ps=1.42 nrd=0.69047619047619  nrs=0.69047619047619 sa=0 sb=0 sd=0 mult=1 m=1
XMRD_op1_0900_s10_w2_0 rbl_op1_0900_s10_w2 sn_op1_0900_s10_w2_0 rwls_op1_0900_s10_w2 0 sky130_fd_pr__nfet_01v8 L=0.15 W=0.42 nf=1 ad=0.1218 as=0.1218 pd=1.42 ps=1.42 nrd=0.69047619047619  nrs=0.69047619047619 sa=0 sb=0 sd=0 mult=1 m=1
csn_op1_0900_s10_w2_0 sn_op1_0900_s10_w2_0 0 {C_SN}
XMWR_op1_0900_s10_w2_1 sn_op1_0900_s10_w2_1 wwl_des wbl_op1_0900_s10_w2 0 sky130_fd_pr__nfet_01v8 L=0.15 W=0.42 nf=1 ad=0.1218 as=0.1218 pd=1.42 ps=1.42 nrd=0.69047619047619  nrs=0.69047619047619 sa=0 sb=0 sd=0 mult=1 m=1
XMRD_op1_0900_s10_w2_1 rbl_op1_0900_s10_w2 sn_op1_0900_s10_w2_1 rwl_des 0 sky130_fd_pr__nfet_01v8 L=0.15 W=0.42 nf=1 ad=0.1218 as=0.1218 pd=1.42 ps=1.42 nrd=0.69047619047619  nrs=0.69047619047619 sa=0 sb=0 sd=0 mult=1 m=1
csn_op1_0900_s10_w2_1 sn_op1_0900_s10_w2_1 0 {C_SN}
XMWR_op1_0900_s10_w2_2 sn_op1_0900_s10_w2_2 wwl_des wbl_op1_0900_s10_w2 0 sky130_fd_pr__nfet_01v8 L=0.15 W=0.42 nf=1 ad=0.1218 as=0.1218 pd=1.42 ps=1.42 nrd=0.69047619047619  nrs=0.69047619047619 sa=0 sb=0 sd=0 mult=1 m=1
XMRD_op1_0900_s10_w2_2 rbl_op1_0900_s10_w2 sn_op1_0900_s10_w2_2 rwl_des 0 sky130_fd_pr__nfet_01v8 L=0.15 W=0.42 nf=1 ad=0.1218 as=0.1218 pd=1.42 ps=1.42 nrd=0.69047619047619  nrs=0.69047619047619 sa=0 sb=0 sd=0 mult=1 m=1
csn_op1_0900_s10_w2_2 sn_op1_0900_s10_w2_2 0 {C_SN}
XMWR_op1_0900_s10_w2_3 sn_op1_0900_s10_w2_3 wwl_des wbl_op1_0900_s10_w2 0 sky130_fd_pr__nfet_01v8 L=0.15 W=0.42 nf=1 ad=0.1218 as=0.1218 pd=1.42 ps=1.42 nrd=0.69047619047619  nrs=0.69047619047619 sa=0 sb=0 sd=0 mult=1 m=1
XMRD_op1_0900_s10_w2_3 rbl_op1_0900_s10_w2 sn_op1_0900_s10_w2_3 rwl_des 0 sky130_fd_pr__nfet_01v8 L=0.15 W=0.42 nf=1 ad=0.1218 as=0.1218 pd=1.42 ps=1.42 nrd=0.69047619047619  nrs=0.69047619047619 sa=0 sb=0 sd=0 mult=1 m=1
csn_op1_0900_s10_w2_3 sn_op1_0900_s10_w2_3 0 {C_SN}
XMN1_op1_0900_s10_w2 rbl_op1_0900_s10_w2 ref_op1_0900_s10_w2 vn_op1_0900_s10_w2 0 sky130_fd_pr__nfet_01v8 L=0.15 W=1 nf=1 ad=0.29 as=0.29 pd=2.58 ps=2.58 mult=1 m=1
XMN2_op1_0900_s10_w2 ref_op1_0900_s10_w2 rbl_op1_0900_s10_w2 vn_op1_0900_s10_w2 0 sky130_fd_pr__nfet_01v8 L=0.15 W=1 nf=1 ad=0.29 as=0.29 pd=2.58 ps=2.58 mult=1 m=1
XMP1_op1_0900_s10_w2 rbl_op1_0900_s10_w2 ref_op1_0900_s10_w2 vp_op1_0900_s10_w2 vdd sky130_fd_pr__pfet_01v8 L=0.15 W=2 nf=1 ad=0.58 as=0.58 pd=4.58 ps=4.58 mult=1 m=1
XMP2_op1_0900_s10_w2 ref_op1_0900_s10_w2 rbl_op1_0900_s10_w2 vp_op1_0900_s10_w2 vdd sky130_fd_pr__pfet_01v8 L=0.15 W=2 nf=1 ad=0.58 as=0.58 pd=4.58 ps=4.58 mult=1 m=1
XMNF_op1_0900_s10_w2 vn_op1_0900_s10_w2 en_op1_0900_s10_w2 0 0 sky130_fd_pr__nfet_01v8 L=0.15 W=2 nf=1 ad=0.58 as=0.58 pd=4.58 ps=4.58 mult=1 m=1
XMPH_op1_0900_s10_w2 vp_op1_0900_s10_w2 enb_op1_0900_s10_w2 vdd vdd sky130_fd_pr__pfet_01v8 L=0.15 W=4 nf=1 ad=1.16 as=1.16 pd=8.58 ps=8.58 mult=1 m=1
bd_op1_0900_s10_w2 d_op1_0900_s10_w2 0 v=v(rbl_op1_0900_s10_w2)-v(ref_op1_0900_s10_w2)

* ---- instance 52: op1_0900_s10_w3 (t_en 14 ns, WWL 15..18 ns, release 20 ns) ----
ven_op1_0900_s10_w3  en_op1_0900_s10_w3  0 pwl(0 0 1.4000e-08 0 1.4100e-08 {VDD} 2.0000e-08 {VDD} 2.0100e-08 0)
venb_op1_0900_s10_w3 enb_op1_0900_s10_w3 0 pwl(0 {VDD} 1.4000e-08 {VDD} 1.4100e-08 0 2.0000e-08 0 2.0100e-08 {VDD})
vrs_op1_0900_s10_w3  rwls_op1_0900_s10_w3 0 pwl(0 {VDD} {T_READ} {VDD} {T_READ+TEDGE} 0 2.0000e-08 0 2.0100e-08 {VDD})
vww_op1_0900_s10_w3  wwl_op1_0900_s10_w3 0 pwl(0 0 1.5000e-08 0 1.5100e-08 {VDD} 1.8000e-08 {VDD} 1.8100e-08 0)
vwc_op1_0900_s10_w3  wbc_op1_0900_s10_w3 0 pwl(0 0 1.5000e-08 0 1.5100e-08 {VDD} 2.0000e-08 {VDD} 2.0100e-08 0)
swb_op1_0900_s10_w3 ref_op1_0900_s10_w3 wbl_op1_0900_s10_w3 wbc_op1_0900_s10_w3 0 swwbl
cwbl_op1_0900_s10_w3 wbl_op1_0900_s10_w3 0 {C_WBL}
spa_op1_0900_s10_w3 prea rbl_op1_0900_s10_w3 ctl 0 swpre
spr_op1_0900_s10_w3 pref ref_op1_0900_s10_w3 ctl 0 swpre
crbl_op1_0900_s10_w3 rbl_op1_0900_s10_w3 0 {C_RBL}
cref_op1_0900_s10_w3 ref_op1_0900_s10_w3 0 {C_RBL}   $ ASSUMPTION: ideal matched dummy load
XMWR_op1_0900_s10_w3_0 sn_op1_0900_s10_w3_0 wwl_op1_0900_s10_w3 wbl_op1_0900_s10_w3 0 sky130_fd_pr__nfet_01v8 L=0.15 W=0.42 nf=1 ad=0.1218 as=0.1218 pd=1.42 ps=1.42 nrd=0.69047619047619  nrs=0.69047619047619 sa=0 sb=0 sd=0 mult=1 m=1
XMRD_op1_0900_s10_w3_0 rbl_op1_0900_s10_w3 sn_op1_0900_s10_w3_0 rwls_op1_0900_s10_w3 0 sky130_fd_pr__nfet_01v8 L=0.15 W=0.42 nf=1 ad=0.1218 as=0.1218 pd=1.42 ps=1.42 nrd=0.69047619047619  nrs=0.69047619047619 sa=0 sb=0 sd=0 mult=1 m=1
csn_op1_0900_s10_w3_0 sn_op1_0900_s10_w3_0 0 {C_SN}
XMWR_op1_0900_s10_w3_1 sn_op1_0900_s10_w3_1 wwl_des wbl_op1_0900_s10_w3 0 sky130_fd_pr__nfet_01v8 L=0.15 W=0.42 nf=1 ad=0.1218 as=0.1218 pd=1.42 ps=1.42 nrd=0.69047619047619  nrs=0.69047619047619 sa=0 sb=0 sd=0 mult=1 m=1
XMRD_op1_0900_s10_w3_1 rbl_op1_0900_s10_w3 sn_op1_0900_s10_w3_1 rwl_des 0 sky130_fd_pr__nfet_01v8 L=0.15 W=0.42 nf=1 ad=0.1218 as=0.1218 pd=1.42 ps=1.42 nrd=0.69047619047619  nrs=0.69047619047619 sa=0 sb=0 sd=0 mult=1 m=1
csn_op1_0900_s10_w3_1 sn_op1_0900_s10_w3_1 0 {C_SN}
XMWR_op1_0900_s10_w3_2 sn_op1_0900_s10_w3_2 wwl_des wbl_op1_0900_s10_w3 0 sky130_fd_pr__nfet_01v8 L=0.15 W=0.42 nf=1 ad=0.1218 as=0.1218 pd=1.42 ps=1.42 nrd=0.69047619047619  nrs=0.69047619047619 sa=0 sb=0 sd=0 mult=1 m=1
XMRD_op1_0900_s10_w3_2 rbl_op1_0900_s10_w3 sn_op1_0900_s10_w3_2 rwl_des 0 sky130_fd_pr__nfet_01v8 L=0.15 W=0.42 nf=1 ad=0.1218 as=0.1218 pd=1.42 ps=1.42 nrd=0.69047619047619  nrs=0.69047619047619 sa=0 sb=0 sd=0 mult=1 m=1
csn_op1_0900_s10_w3_2 sn_op1_0900_s10_w3_2 0 {C_SN}
XMWR_op1_0900_s10_w3_3 sn_op1_0900_s10_w3_3 wwl_des wbl_op1_0900_s10_w3 0 sky130_fd_pr__nfet_01v8 L=0.15 W=0.42 nf=1 ad=0.1218 as=0.1218 pd=1.42 ps=1.42 nrd=0.69047619047619  nrs=0.69047619047619 sa=0 sb=0 sd=0 mult=1 m=1
XMRD_op1_0900_s10_w3_3 rbl_op1_0900_s10_w3 sn_op1_0900_s10_w3_3 rwl_des 0 sky130_fd_pr__nfet_01v8 L=0.15 W=0.42 nf=1 ad=0.1218 as=0.1218 pd=1.42 ps=1.42 nrd=0.69047619047619  nrs=0.69047619047619 sa=0 sb=0 sd=0 mult=1 m=1
csn_op1_0900_s10_w3_3 sn_op1_0900_s10_w3_3 0 {C_SN}
XMN1_op1_0900_s10_w3 rbl_op1_0900_s10_w3 ref_op1_0900_s10_w3 vn_op1_0900_s10_w3 0 sky130_fd_pr__nfet_01v8 L=0.15 W=1 nf=1 ad=0.29 as=0.29 pd=2.58 ps=2.58 mult=1 m=1
XMN2_op1_0900_s10_w3 ref_op1_0900_s10_w3 rbl_op1_0900_s10_w3 vn_op1_0900_s10_w3 0 sky130_fd_pr__nfet_01v8 L=0.15 W=1 nf=1 ad=0.29 as=0.29 pd=2.58 ps=2.58 mult=1 m=1
XMP1_op1_0900_s10_w3 rbl_op1_0900_s10_w3 ref_op1_0900_s10_w3 vp_op1_0900_s10_w3 vdd sky130_fd_pr__pfet_01v8 L=0.15 W=2 nf=1 ad=0.58 as=0.58 pd=4.58 ps=4.58 mult=1 m=1
XMP2_op1_0900_s10_w3 ref_op1_0900_s10_w3 rbl_op1_0900_s10_w3 vp_op1_0900_s10_w3 vdd sky130_fd_pr__pfet_01v8 L=0.15 W=2 nf=1 ad=0.58 as=0.58 pd=4.58 ps=4.58 mult=1 m=1
XMNF_op1_0900_s10_w3 vn_op1_0900_s10_w3 en_op1_0900_s10_w3 0 0 sky130_fd_pr__nfet_01v8 L=0.15 W=2 nf=1 ad=0.58 as=0.58 pd=4.58 ps=4.58 mult=1 m=1
XMPH_op1_0900_s10_w3 vp_op1_0900_s10_w3 enb_op1_0900_s10_w3 vdd vdd sky130_fd_pr__pfet_01v8 L=0.15 W=4 nf=1 ad=1.16 as=1.16 pd=8.58 ps=8.58 mult=1 m=1
bd_op1_0900_s10_w3 d_op1_0900_s10_w3 0 v=v(rbl_op1_0900_s10_w3)-v(ref_op1_0900_s10_w3)

* ---- instance 53: op1_0900_s10_w5 (t_en 14 ns, WWL 15..20 ns, release 22 ns) ----
ven_op1_0900_s10_w5  en_op1_0900_s10_w5  0 pwl(0 0 1.4000e-08 0 1.4100e-08 {VDD} 2.2000e-08 {VDD} 2.2100e-08 0)
venb_op1_0900_s10_w5 enb_op1_0900_s10_w5 0 pwl(0 {VDD} 1.4000e-08 {VDD} 1.4100e-08 0 2.2000e-08 0 2.2100e-08 {VDD})
vrs_op1_0900_s10_w5  rwls_op1_0900_s10_w5 0 pwl(0 {VDD} {T_READ} {VDD} {T_READ+TEDGE} 0 2.2000e-08 0 2.2100e-08 {VDD})
vww_op1_0900_s10_w5  wwl_op1_0900_s10_w5 0 pwl(0 0 1.5000e-08 0 1.5100e-08 {VDD} 2.0000e-08 {VDD} 2.0100e-08 0)
vwc_op1_0900_s10_w5  wbc_op1_0900_s10_w5 0 pwl(0 0 1.5000e-08 0 1.5100e-08 {VDD} 2.2000e-08 {VDD} 2.2100e-08 0)
swb_op1_0900_s10_w5 ref_op1_0900_s10_w5 wbl_op1_0900_s10_w5 wbc_op1_0900_s10_w5 0 swwbl
cwbl_op1_0900_s10_w5 wbl_op1_0900_s10_w5 0 {C_WBL}
spa_op1_0900_s10_w5 prea rbl_op1_0900_s10_w5 ctl 0 swpre
spr_op1_0900_s10_w5 pref ref_op1_0900_s10_w5 ctl 0 swpre
crbl_op1_0900_s10_w5 rbl_op1_0900_s10_w5 0 {C_RBL}
cref_op1_0900_s10_w5 ref_op1_0900_s10_w5 0 {C_RBL}   $ ASSUMPTION: ideal matched dummy load
XMWR_op1_0900_s10_w5_0 sn_op1_0900_s10_w5_0 wwl_op1_0900_s10_w5 wbl_op1_0900_s10_w5 0 sky130_fd_pr__nfet_01v8 L=0.15 W=0.42 nf=1 ad=0.1218 as=0.1218 pd=1.42 ps=1.42 nrd=0.69047619047619  nrs=0.69047619047619 sa=0 sb=0 sd=0 mult=1 m=1
XMRD_op1_0900_s10_w5_0 rbl_op1_0900_s10_w5 sn_op1_0900_s10_w5_0 rwls_op1_0900_s10_w5 0 sky130_fd_pr__nfet_01v8 L=0.15 W=0.42 nf=1 ad=0.1218 as=0.1218 pd=1.42 ps=1.42 nrd=0.69047619047619  nrs=0.69047619047619 sa=0 sb=0 sd=0 mult=1 m=1
csn_op1_0900_s10_w5_0 sn_op1_0900_s10_w5_0 0 {C_SN}
XMWR_op1_0900_s10_w5_1 sn_op1_0900_s10_w5_1 wwl_des wbl_op1_0900_s10_w5 0 sky130_fd_pr__nfet_01v8 L=0.15 W=0.42 nf=1 ad=0.1218 as=0.1218 pd=1.42 ps=1.42 nrd=0.69047619047619  nrs=0.69047619047619 sa=0 sb=0 sd=0 mult=1 m=1
XMRD_op1_0900_s10_w5_1 rbl_op1_0900_s10_w5 sn_op1_0900_s10_w5_1 rwl_des 0 sky130_fd_pr__nfet_01v8 L=0.15 W=0.42 nf=1 ad=0.1218 as=0.1218 pd=1.42 ps=1.42 nrd=0.69047619047619  nrs=0.69047619047619 sa=0 sb=0 sd=0 mult=1 m=1
csn_op1_0900_s10_w5_1 sn_op1_0900_s10_w5_1 0 {C_SN}
XMWR_op1_0900_s10_w5_2 sn_op1_0900_s10_w5_2 wwl_des wbl_op1_0900_s10_w5 0 sky130_fd_pr__nfet_01v8 L=0.15 W=0.42 nf=1 ad=0.1218 as=0.1218 pd=1.42 ps=1.42 nrd=0.69047619047619  nrs=0.69047619047619 sa=0 sb=0 sd=0 mult=1 m=1
XMRD_op1_0900_s10_w5_2 rbl_op1_0900_s10_w5 sn_op1_0900_s10_w5_2 rwl_des 0 sky130_fd_pr__nfet_01v8 L=0.15 W=0.42 nf=1 ad=0.1218 as=0.1218 pd=1.42 ps=1.42 nrd=0.69047619047619  nrs=0.69047619047619 sa=0 sb=0 sd=0 mult=1 m=1
csn_op1_0900_s10_w5_2 sn_op1_0900_s10_w5_2 0 {C_SN}
XMWR_op1_0900_s10_w5_3 sn_op1_0900_s10_w5_3 wwl_des wbl_op1_0900_s10_w5 0 sky130_fd_pr__nfet_01v8 L=0.15 W=0.42 nf=1 ad=0.1218 as=0.1218 pd=1.42 ps=1.42 nrd=0.69047619047619  nrs=0.69047619047619 sa=0 sb=0 sd=0 mult=1 m=1
XMRD_op1_0900_s10_w5_3 rbl_op1_0900_s10_w5 sn_op1_0900_s10_w5_3 rwl_des 0 sky130_fd_pr__nfet_01v8 L=0.15 W=0.42 nf=1 ad=0.1218 as=0.1218 pd=1.42 ps=1.42 nrd=0.69047619047619  nrs=0.69047619047619 sa=0 sb=0 sd=0 mult=1 m=1
csn_op1_0900_s10_w5_3 sn_op1_0900_s10_w5_3 0 {C_SN}
XMN1_op1_0900_s10_w5 rbl_op1_0900_s10_w5 ref_op1_0900_s10_w5 vn_op1_0900_s10_w5 0 sky130_fd_pr__nfet_01v8 L=0.15 W=1 nf=1 ad=0.29 as=0.29 pd=2.58 ps=2.58 mult=1 m=1
XMN2_op1_0900_s10_w5 ref_op1_0900_s10_w5 rbl_op1_0900_s10_w5 vn_op1_0900_s10_w5 0 sky130_fd_pr__nfet_01v8 L=0.15 W=1 nf=1 ad=0.29 as=0.29 pd=2.58 ps=2.58 mult=1 m=1
XMP1_op1_0900_s10_w5 rbl_op1_0900_s10_w5 ref_op1_0900_s10_w5 vp_op1_0900_s10_w5 vdd sky130_fd_pr__pfet_01v8 L=0.15 W=2 nf=1 ad=0.58 as=0.58 pd=4.58 ps=4.58 mult=1 m=1
XMP2_op1_0900_s10_w5 ref_op1_0900_s10_w5 rbl_op1_0900_s10_w5 vp_op1_0900_s10_w5 vdd sky130_fd_pr__pfet_01v8 L=0.15 W=2 nf=1 ad=0.58 as=0.58 pd=4.58 ps=4.58 mult=1 m=1
XMNF_op1_0900_s10_w5 vn_op1_0900_s10_w5 en_op1_0900_s10_w5 0 0 sky130_fd_pr__nfet_01v8 L=0.15 W=2 nf=1 ad=0.58 as=0.58 pd=4.58 ps=4.58 mult=1 m=1
XMPH_op1_0900_s10_w5 vp_op1_0900_s10_w5 enb_op1_0900_s10_w5 vdd vdd sky130_fd_pr__pfet_01v8 L=0.15 W=4 nf=1 ad=1.16 as=1.16 pd=8.58 ps=8.58 mult=1 m=1
bd_op1_0900_s10_w5 d_op1_0900_s10_w5 0 v=v(rbl_op1_0900_s10_w5)-v(ref_op1_0900_s10_w5)

* ---- instance 54: op1_0900_s10_w7p5 (t_en 14 ns, WWL 15..22.5 ns, release 24.5 ns) ----
ven_op1_0900_s10_w7p5  en_op1_0900_s10_w7p5  0 pwl(0 0 1.4000e-08 0 1.4100e-08 {VDD} 2.4500e-08 {VDD} 2.4600e-08 0)
venb_op1_0900_s10_w7p5 enb_op1_0900_s10_w7p5 0 pwl(0 {VDD} 1.4000e-08 {VDD} 1.4100e-08 0 2.4500e-08 0 2.4600e-08 {VDD})
vrs_op1_0900_s10_w7p5  rwls_op1_0900_s10_w7p5 0 pwl(0 {VDD} {T_READ} {VDD} {T_READ+TEDGE} 0 2.4500e-08 0 2.4600e-08 {VDD})
vww_op1_0900_s10_w7p5  wwl_op1_0900_s10_w7p5 0 pwl(0 0 1.5000e-08 0 1.5100e-08 {VDD} 2.2500e-08 {VDD} 2.2600e-08 0)
vwc_op1_0900_s10_w7p5  wbc_op1_0900_s10_w7p5 0 pwl(0 0 1.5000e-08 0 1.5100e-08 {VDD} 2.4500e-08 {VDD} 2.4600e-08 0)
swb_op1_0900_s10_w7p5 ref_op1_0900_s10_w7p5 wbl_op1_0900_s10_w7p5 wbc_op1_0900_s10_w7p5 0 swwbl
cwbl_op1_0900_s10_w7p5 wbl_op1_0900_s10_w7p5 0 {C_WBL}
spa_op1_0900_s10_w7p5 prea rbl_op1_0900_s10_w7p5 ctl 0 swpre
spr_op1_0900_s10_w7p5 pref ref_op1_0900_s10_w7p5 ctl 0 swpre
crbl_op1_0900_s10_w7p5 rbl_op1_0900_s10_w7p5 0 {C_RBL}
cref_op1_0900_s10_w7p5 ref_op1_0900_s10_w7p5 0 {C_RBL}   $ ASSUMPTION: ideal matched dummy load
XMWR_op1_0900_s10_w7p5_0 sn_op1_0900_s10_w7p5_0 wwl_op1_0900_s10_w7p5 wbl_op1_0900_s10_w7p5 0 sky130_fd_pr__nfet_01v8 L=0.15 W=0.42 nf=1 ad=0.1218 as=0.1218 pd=1.42 ps=1.42 nrd=0.69047619047619  nrs=0.69047619047619 sa=0 sb=0 sd=0 mult=1 m=1
XMRD_op1_0900_s10_w7p5_0 rbl_op1_0900_s10_w7p5 sn_op1_0900_s10_w7p5_0 rwls_op1_0900_s10_w7p5 0 sky130_fd_pr__nfet_01v8 L=0.15 W=0.42 nf=1 ad=0.1218 as=0.1218 pd=1.42 ps=1.42 nrd=0.69047619047619  nrs=0.69047619047619 sa=0 sb=0 sd=0 mult=1 m=1
csn_op1_0900_s10_w7p5_0 sn_op1_0900_s10_w7p5_0 0 {C_SN}
XMWR_op1_0900_s10_w7p5_1 sn_op1_0900_s10_w7p5_1 wwl_des wbl_op1_0900_s10_w7p5 0 sky130_fd_pr__nfet_01v8 L=0.15 W=0.42 nf=1 ad=0.1218 as=0.1218 pd=1.42 ps=1.42 nrd=0.69047619047619  nrs=0.69047619047619 sa=0 sb=0 sd=0 mult=1 m=1
XMRD_op1_0900_s10_w7p5_1 rbl_op1_0900_s10_w7p5 sn_op1_0900_s10_w7p5_1 rwl_des 0 sky130_fd_pr__nfet_01v8 L=0.15 W=0.42 nf=1 ad=0.1218 as=0.1218 pd=1.42 ps=1.42 nrd=0.69047619047619  nrs=0.69047619047619 sa=0 sb=0 sd=0 mult=1 m=1
csn_op1_0900_s10_w7p5_1 sn_op1_0900_s10_w7p5_1 0 {C_SN}
XMWR_op1_0900_s10_w7p5_2 sn_op1_0900_s10_w7p5_2 wwl_des wbl_op1_0900_s10_w7p5 0 sky130_fd_pr__nfet_01v8 L=0.15 W=0.42 nf=1 ad=0.1218 as=0.1218 pd=1.42 ps=1.42 nrd=0.69047619047619  nrs=0.69047619047619 sa=0 sb=0 sd=0 mult=1 m=1
XMRD_op1_0900_s10_w7p5_2 rbl_op1_0900_s10_w7p5 sn_op1_0900_s10_w7p5_2 rwl_des 0 sky130_fd_pr__nfet_01v8 L=0.15 W=0.42 nf=1 ad=0.1218 as=0.1218 pd=1.42 ps=1.42 nrd=0.69047619047619  nrs=0.69047619047619 sa=0 sb=0 sd=0 mult=1 m=1
csn_op1_0900_s10_w7p5_2 sn_op1_0900_s10_w7p5_2 0 {C_SN}
XMWR_op1_0900_s10_w7p5_3 sn_op1_0900_s10_w7p5_3 wwl_des wbl_op1_0900_s10_w7p5 0 sky130_fd_pr__nfet_01v8 L=0.15 W=0.42 nf=1 ad=0.1218 as=0.1218 pd=1.42 ps=1.42 nrd=0.69047619047619  nrs=0.69047619047619 sa=0 sb=0 sd=0 mult=1 m=1
XMRD_op1_0900_s10_w7p5_3 rbl_op1_0900_s10_w7p5 sn_op1_0900_s10_w7p5_3 rwl_des 0 sky130_fd_pr__nfet_01v8 L=0.15 W=0.42 nf=1 ad=0.1218 as=0.1218 pd=1.42 ps=1.42 nrd=0.69047619047619  nrs=0.69047619047619 sa=0 sb=0 sd=0 mult=1 m=1
csn_op1_0900_s10_w7p5_3 sn_op1_0900_s10_w7p5_3 0 {C_SN}
XMN1_op1_0900_s10_w7p5 rbl_op1_0900_s10_w7p5 ref_op1_0900_s10_w7p5 vn_op1_0900_s10_w7p5 0 sky130_fd_pr__nfet_01v8 L=0.15 W=1 nf=1 ad=0.29 as=0.29 pd=2.58 ps=2.58 mult=1 m=1
XMN2_op1_0900_s10_w7p5 ref_op1_0900_s10_w7p5 rbl_op1_0900_s10_w7p5 vn_op1_0900_s10_w7p5 0 sky130_fd_pr__nfet_01v8 L=0.15 W=1 nf=1 ad=0.29 as=0.29 pd=2.58 ps=2.58 mult=1 m=1
XMP1_op1_0900_s10_w7p5 rbl_op1_0900_s10_w7p5 ref_op1_0900_s10_w7p5 vp_op1_0900_s10_w7p5 vdd sky130_fd_pr__pfet_01v8 L=0.15 W=2 nf=1 ad=0.58 as=0.58 pd=4.58 ps=4.58 mult=1 m=1
XMP2_op1_0900_s10_w7p5 ref_op1_0900_s10_w7p5 rbl_op1_0900_s10_w7p5 vp_op1_0900_s10_w7p5 vdd sky130_fd_pr__pfet_01v8 L=0.15 W=2 nf=1 ad=0.58 as=0.58 pd=4.58 ps=4.58 mult=1 m=1
XMNF_op1_0900_s10_w7p5 vn_op1_0900_s10_w7p5 en_op1_0900_s10_w7p5 0 0 sky130_fd_pr__nfet_01v8 L=0.15 W=2 nf=1 ad=0.58 as=0.58 pd=4.58 ps=4.58 mult=1 m=1
XMPH_op1_0900_s10_w7p5 vp_op1_0900_s10_w7p5 enb_op1_0900_s10_w7p5 vdd vdd sky130_fd_pr__pfet_01v8 L=0.15 W=4 nf=1 ad=1.16 as=1.16 pd=8.58 ps=8.58 mult=1 m=1
bd_op1_0900_s10_w7p5 d_op1_0900_s10_w7p5 0 v=v(rbl_op1_0900_s10_w7p5)-v(ref_op1_0900_s10_w7p5)

* ---- instance 55: op1_0900_s10_w10 (t_en 14 ns, WWL 15..25 ns, release 27 ns) ----
ven_op1_0900_s10_w10  en_op1_0900_s10_w10  0 pwl(0 0 1.4000e-08 0 1.4100e-08 {VDD} 2.7000e-08 {VDD} 2.7100e-08 0)
venb_op1_0900_s10_w10 enb_op1_0900_s10_w10 0 pwl(0 {VDD} 1.4000e-08 {VDD} 1.4100e-08 0 2.7000e-08 0 2.7100e-08 {VDD})
vrs_op1_0900_s10_w10  rwls_op1_0900_s10_w10 0 pwl(0 {VDD} {T_READ} {VDD} {T_READ+TEDGE} 0 2.7000e-08 0 2.7100e-08 {VDD})
vww_op1_0900_s10_w10  wwl_op1_0900_s10_w10 0 pwl(0 0 1.5000e-08 0 1.5100e-08 {VDD} 2.5000e-08 {VDD} 2.5100e-08 0)
vwc_op1_0900_s10_w10  wbc_op1_0900_s10_w10 0 pwl(0 0 1.5000e-08 0 1.5100e-08 {VDD} 2.7000e-08 {VDD} 2.7100e-08 0)
swb_op1_0900_s10_w10 ref_op1_0900_s10_w10 wbl_op1_0900_s10_w10 wbc_op1_0900_s10_w10 0 swwbl
cwbl_op1_0900_s10_w10 wbl_op1_0900_s10_w10 0 {C_WBL}
spa_op1_0900_s10_w10 prea rbl_op1_0900_s10_w10 ctl 0 swpre
spr_op1_0900_s10_w10 pref ref_op1_0900_s10_w10 ctl 0 swpre
crbl_op1_0900_s10_w10 rbl_op1_0900_s10_w10 0 {C_RBL}
cref_op1_0900_s10_w10 ref_op1_0900_s10_w10 0 {C_RBL}   $ ASSUMPTION: ideal matched dummy load
XMWR_op1_0900_s10_w10_0 sn_op1_0900_s10_w10_0 wwl_op1_0900_s10_w10 wbl_op1_0900_s10_w10 0 sky130_fd_pr__nfet_01v8 L=0.15 W=0.42 nf=1 ad=0.1218 as=0.1218 pd=1.42 ps=1.42 nrd=0.69047619047619  nrs=0.69047619047619 sa=0 sb=0 sd=0 mult=1 m=1
XMRD_op1_0900_s10_w10_0 rbl_op1_0900_s10_w10 sn_op1_0900_s10_w10_0 rwls_op1_0900_s10_w10 0 sky130_fd_pr__nfet_01v8 L=0.15 W=0.42 nf=1 ad=0.1218 as=0.1218 pd=1.42 ps=1.42 nrd=0.69047619047619  nrs=0.69047619047619 sa=0 sb=0 sd=0 mult=1 m=1
csn_op1_0900_s10_w10_0 sn_op1_0900_s10_w10_0 0 {C_SN}
XMWR_op1_0900_s10_w10_1 sn_op1_0900_s10_w10_1 wwl_des wbl_op1_0900_s10_w10 0 sky130_fd_pr__nfet_01v8 L=0.15 W=0.42 nf=1 ad=0.1218 as=0.1218 pd=1.42 ps=1.42 nrd=0.69047619047619  nrs=0.69047619047619 sa=0 sb=0 sd=0 mult=1 m=1
XMRD_op1_0900_s10_w10_1 rbl_op1_0900_s10_w10 sn_op1_0900_s10_w10_1 rwl_des 0 sky130_fd_pr__nfet_01v8 L=0.15 W=0.42 nf=1 ad=0.1218 as=0.1218 pd=1.42 ps=1.42 nrd=0.69047619047619  nrs=0.69047619047619 sa=0 sb=0 sd=0 mult=1 m=1
csn_op1_0900_s10_w10_1 sn_op1_0900_s10_w10_1 0 {C_SN}
XMWR_op1_0900_s10_w10_2 sn_op1_0900_s10_w10_2 wwl_des wbl_op1_0900_s10_w10 0 sky130_fd_pr__nfet_01v8 L=0.15 W=0.42 nf=1 ad=0.1218 as=0.1218 pd=1.42 ps=1.42 nrd=0.69047619047619  nrs=0.69047619047619 sa=0 sb=0 sd=0 mult=1 m=1
XMRD_op1_0900_s10_w10_2 rbl_op1_0900_s10_w10 sn_op1_0900_s10_w10_2 rwl_des 0 sky130_fd_pr__nfet_01v8 L=0.15 W=0.42 nf=1 ad=0.1218 as=0.1218 pd=1.42 ps=1.42 nrd=0.69047619047619  nrs=0.69047619047619 sa=0 sb=0 sd=0 mult=1 m=1
csn_op1_0900_s10_w10_2 sn_op1_0900_s10_w10_2 0 {C_SN}
XMWR_op1_0900_s10_w10_3 sn_op1_0900_s10_w10_3 wwl_des wbl_op1_0900_s10_w10 0 sky130_fd_pr__nfet_01v8 L=0.15 W=0.42 nf=1 ad=0.1218 as=0.1218 pd=1.42 ps=1.42 nrd=0.69047619047619  nrs=0.69047619047619 sa=0 sb=0 sd=0 mult=1 m=1
XMRD_op1_0900_s10_w10_3 rbl_op1_0900_s10_w10 sn_op1_0900_s10_w10_3 rwl_des 0 sky130_fd_pr__nfet_01v8 L=0.15 W=0.42 nf=1 ad=0.1218 as=0.1218 pd=1.42 ps=1.42 nrd=0.69047619047619  nrs=0.69047619047619 sa=0 sb=0 sd=0 mult=1 m=1
csn_op1_0900_s10_w10_3 sn_op1_0900_s10_w10_3 0 {C_SN}
XMN1_op1_0900_s10_w10 rbl_op1_0900_s10_w10 ref_op1_0900_s10_w10 vn_op1_0900_s10_w10 0 sky130_fd_pr__nfet_01v8 L=0.15 W=1 nf=1 ad=0.29 as=0.29 pd=2.58 ps=2.58 mult=1 m=1
XMN2_op1_0900_s10_w10 ref_op1_0900_s10_w10 rbl_op1_0900_s10_w10 vn_op1_0900_s10_w10 0 sky130_fd_pr__nfet_01v8 L=0.15 W=1 nf=1 ad=0.29 as=0.29 pd=2.58 ps=2.58 mult=1 m=1
XMP1_op1_0900_s10_w10 rbl_op1_0900_s10_w10 ref_op1_0900_s10_w10 vp_op1_0900_s10_w10 vdd sky130_fd_pr__pfet_01v8 L=0.15 W=2 nf=1 ad=0.58 as=0.58 pd=4.58 ps=4.58 mult=1 m=1
XMP2_op1_0900_s10_w10 ref_op1_0900_s10_w10 rbl_op1_0900_s10_w10 vp_op1_0900_s10_w10 vdd sky130_fd_pr__pfet_01v8 L=0.15 W=2 nf=1 ad=0.58 as=0.58 pd=4.58 ps=4.58 mult=1 m=1
XMNF_op1_0900_s10_w10 vn_op1_0900_s10_w10 en_op1_0900_s10_w10 0 0 sky130_fd_pr__nfet_01v8 L=0.15 W=2 nf=1 ad=0.58 as=0.58 pd=4.58 ps=4.58 mult=1 m=1
XMPH_op1_0900_s10_w10 vp_op1_0900_s10_w10 enb_op1_0900_s10_w10 vdd vdd sky130_fd_pr__pfet_01v8 L=0.15 W=4 nf=1 ad=1.16 as=1.16 pd=8.58 ps=8.58 mult=1 m=1
bd_op1_0900_s10_w10 d_op1_0900_s10_w10 0 v=v(rbl_op1_0900_s10_w10)-v(ref_op1_0900_s10_w10)

* ---- instance 56: op1_0900_s10_w15 (t_en 14 ns, WWL 15..30 ns, release 32 ns) ----
ven_op1_0900_s10_w15  en_op1_0900_s10_w15  0 pwl(0 0 1.4000e-08 0 1.4100e-08 {VDD} 3.2000e-08 {VDD} 3.2100e-08 0)
venb_op1_0900_s10_w15 enb_op1_0900_s10_w15 0 pwl(0 {VDD} 1.4000e-08 {VDD} 1.4100e-08 0 3.2000e-08 0 3.2100e-08 {VDD})
vrs_op1_0900_s10_w15  rwls_op1_0900_s10_w15 0 pwl(0 {VDD} {T_READ} {VDD} {T_READ+TEDGE} 0 3.2000e-08 0 3.2100e-08 {VDD})
vww_op1_0900_s10_w15  wwl_op1_0900_s10_w15 0 pwl(0 0 1.5000e-08 0 1.5100e-08 {VDD} 3.0000e-08 {VDD} 3.0100e-08 0)
vwc_op1_0900_s10_w15  wbc_op1_0900_s10_w15 0 pwl(0 0 1.5000e-08 0 1.5100e-08 {VDD} 3.2000e-08 {VDD} 3.2100e-08 0)
swb_op1_0900_s10_w15 ref_op1_0900_s10_w15 wbl_op1_0900_s10_w15 wbc_op1_0900_s10_w15 0 swwbl
cwbl_op1_0900_s10_w15 wbl_op1_0900_s10_w15 0 {C_WBL}
spa_op1_0900_s10_w15 prea rbl_op1_0900_s10_w15 ctl 0 swpre
spr_op1_0900_s10_w15 pref ref_op1_0900_s10_w15 ctl 0 swpre
crbl_op1_0900_s10_w15 rbl_op1_0900_s10_w15 0 {C_RBL}
cref_op1_0900_s10_w15 ref_op1_0900_s10_w15 0 {C_RBL}   $ ASSUMPTION: ideal matched dummy load
XMWR_op1_0900_s10_w15_0 sn_op1_0900_s10_w15_0 wwl_op1_0900_s10_w15 wbl_op1_0900_s10_w15 0 sky130_fd_pr__nfet_01v8 L=0.15 W=0.42 nf=1 ad=0.1218 as=0.1218 pd=1.42 ps=1.42 nrd=0.69047619047619  nrs=0.69047619047619 sa=0 sb=0 sd=0 mult=1 m=1
XMRD_op1_0900_s10_w15_0 rbl_op1_0900_s10_w15 sn_op1_0900_s10_w15_0 rwls_op1_0900_s10_w15 0 sky130_fd_pr__nfet_01v8 L=0.15 W=0.42 nf=1 ad=0.1218 as=0.1218 pd=1.42 ps=1.42 nrd=0.69047619047619  nrs=0.69047619047619 sa=0 sb=0 sd=0 mult=1 m=1
csn_op1_0900_s10_w15_0 sn_op1_0900_s10_w15_0 0 {C_SN}
XMWR_op1_0900_s10_w15_1 sn_op1_0900_s10_w15_1 wwl_des wbl_op1_0900_s10_w15 0 sky130_fd_pr__nfet_01v8 L=0.15 W=0.42 nf=1 ad=0.1218 as=0.1218 pd=1.42 ps=1.42 nrd=0.69047619047619  nrs=0.69047619047619 sa=0 sb=0 sd=0 mult=1 m=1
XMRD_op1_0900_s10_w15_1 rbl_op1_0900_s10_w15 sn_op1_0900_s10_w15_1 rwl_des 0 sky130_fd_pr__nfet_01v8 L=0.15 W=0.42 nf=1 ad=0.1218 as=0.1218 pd=1.42 ps=1.42 nrd=0.69047619047619  nrs=0.69047619047619 sa=0 sb=0 sd=0 mult=1 m=1
csn_op1_0900_s10_w15_1 sn_op1_0900_s10_w15_1 0 {C_SN}
XMWR_op1_0900_s10_w15_2 sn_op1_0900_s10_w15_2 wwl_des wbl_op1_0900_s10_w15 0 sky130_fd_pr__nfet_01v8 L=0.15 W=0.42 nf=1 ad=0.1218 as=0.1218 pd=1.42 ps=1.42 nrd=0.69047619047619  nrs=0.69047619047619 sa=0 sb=0 sd=0 mult=1 m=1
XMRD_op1_0900_s10_w15_2 rbl_op1_0900_s10_w15 sn_op1_0900_s10_w15_2 rwl_des 0 sky130_fd_pr__nfet_01v8 L=0.15 W=0.42 nf=1 ad=0.1218 as=0.1218 pd=1.42 ps=1.42 nrd=0.69047619047619  nrs=0.69047619047619 sa=0 sb=0 sd=0 mult=1 m=1
csn_op1_0900_s10_w15_2 sn_op1_0900_s10_w15_2 0 {C_SN}
XMWR_op1_0900_s10_w15_3 sn_op1_0900_s10_w15_3 wwl_des wbl_op1_0900_s10_w15 0 sky130_fd_pr__nfet_01v8 L=0.15 W=0.42 nf=1 ad=0.1218 as=0.1218 pd=1.42 ps=1.42 nrd=0.69047619047619  nrs=0.69047619047619 sa=0 sb=0 sd=0 mult=1 m=1
XMRD_op1_0900_s10_w15_3 rbl_op1_0900_s10_w15 sn_op1_0900_s10_w15_3 rwl_des 0 sky130_fd_pr__nfet_01v8 L=0.15 W=0.42 nf=1 ad=0.1218 as=0.1218 pd=1.42 ps=1.42 nrd=0.69047619047619  nrs=0.69047619047619 sa=0 sb=0 sd=0 mult=1 m=1
csn_op1_0900_s10_w15_3 sn_op1_0900_s10_w15_3 0 {C_SN}
XMN1_op1_0900_s10_w15 rbl_op1_0900_s10_w15 ref_op1_0900_s10_w15 vn_op1_0900_s10_w15 0 sky130_fd_pr__nfet_01v8 L=0.15 W=1 nf=1 ad=0.29 as=0.29 pd=2.58 ps=2.58 mult=1 m=1
XMN2_op1_0900_s10_w15 ref_op1_0900_s10_w15 rbl_op1_0900_s10_w15 vn_op1_0900_s10_w15 0 sky130_fd_pr__nfet_01v8 L=0.15 W=1 nf=1 ad=0.29 as=0.29 pd=2.58 ps=2.58 mult=1 m=1
XMP1_op1_0900_s10_w15 rbl_op1_0900_s10_w15 ref_op1_0900_s10_w15 vp_op1_0900_s10_w15 vdd sky130_fd_pr__pfet_01v8 L=0.15 W=2 nf=1 ad=0.58 as=0.58 pd=4.58 ps=4.58 mult=1 m=1
XMP2_op1_0900_s10_w15 ref_op1_0900_s10_w15 rbl_op1_0900_s10_w15 vp_op1_0900_s10_w15 vdd sky130_fd_pr__pfet_01v8 L=0.15 W=2 nf=1 ad=0.58 as=0.58 pd=4.58 ps=4.58 mult=1 m=1
XMNF_op1_0900_s10_w15 vn_op1_0900_s10_w15 en_op1_0900_s10_w15 0 0 sky130_fd_pr__nfet_01v8 L=0.15 W=2 nf=1 ad=0.58 as=0.58 pd=4.58 ps=4.58 mult=1 m=1
XMPH_op1_0900_s10_w15 vp_op1_0900_s10_w15 enb_op1_0900_s10_w15 vdd vdd sky130_fd_pr__pfet_01v8 L=0.15 W=4 nf=1 ad=1.16 as=1.16 pd=8.58 ps=8.58 mult=1 m=1
bd_op1_0900_s10_w15 d_op1_0900_s10_w15 0 v=v(rbl_op1_0900_s10_w15)-v(ref_op1_0900_s10_w15)

* ---- instance 57: op1_0900_s10_w20 (t_en 14 ns, WWL 15..35 ns, release 37 ns) ----
ven_op1_0900_s10_w20  en_op1_0900_s10_w20  0 pwl(0 0 1.4000e-08 0 1.4100e-08 {VDD} 3.7000e-08 {VDD} 3.7100e-08 0)
venb_op1_0900_s10_w20 enb_op1_0900_s10_w20 0 pwl(0 {VDD} 1.4000e-08 {VDD} 1.4100e-08 0 3.7000e-08 0 3.7100e-08 {VDD})
vrs_op1_0900_s10_w20  rwls_op1_0900_s10_w20 0 pwl(0 {VDD} {T_READ} {VDD} {T_READ+TEDGE} 0 3.7000e-08 0 3.7100e-08 {VDD})
vww_op1_0900_s10_w20  wwl_op1_0900_s10_w20 0 pwl(0 0 1.5000e-08 0 1.5100e-08 {VDD} 3.5000e-08 {VDD} 3.5100e-08 0)
vwc_op1_0900_s10_w20  wbc_op1_0900_s10_w20 0 pwl(0 0 1.5000e-08 0 1.5100e-08 {VDD} 3.7000e-08 {VDD} 3.7100e-08 0)
swb_op1_0900_s10_w20 ref_op1_0900_s10_w20 wbl_op1_0900_s10_w20 wbc_op1_0900_s10_w20 0 swwbl
cwbl_op1_0900_s10_w20 wbl_op1_0900_s10_w20 0 {C_WBL}
spa_op1_0900_s10_w20 prea rbl_op1_0900_s10_w20 ctl 0 swpre
spr_op1_0900_s10_w20 pref ref_op1_0900_s10_w20 ctl 0 swpre
crbl_op1_0900_s10_w20 rbl_op1_0900_s10_w20 0 {C_RBL}
cref_op1_0900_s10_w20 ref_op1_0900_s10_w20 0 {C_RBL}   $ ASSUMPTION: ideal matched dummy load
XMWR_op1_0900_s10_w20_0 sn_op1_0900_s10_w20_0 wwl_op1_0900_s10_w20 wbl_op1_0900_s10_w20 0 sky130_fd_pr__nfet_01v8 L=0.15 W=0.42 nf=1 ad=0.1218 as=0.1218 pd=1.42 ps=1.42 nrd=0.69047619047619  nrs=0.69047619047619 sa=0 sb=0 sd=0 mult=1 m=1
XMRD_op1_0900_s10_w20_0 rbl_op1_0900_s10_w20 sn_op1_0900_s10_w20_0 rwls_op1_0900_s10_w20 0 sky130_fd_pr__nfet_01v8 L=0.15 W=0.42 nf=1 ad=0.1218 as=0.1218 pd=1.42 ps=1.42 nrd=0.69047619047619  nrs=0.69047619047619 sa=0 sb=0 sd=0 mult=1 m=1
csn_op1_0900_s10_w20_0 sn_op1_0900_s10_w20_0 0 {C_SN}
XMWR_op1_0900_s10_w20_1 sn_op1_0900_s10_w20_1 wwl_des wbl_op1_0900_s10_w20 0 sky130_fd_pr__nfet_01v8 L=0.15 W=0.42 nf=1 ad=0.1218 as=0.1218 pd=1.42 ps=1.42 nrd=0.69047619047619  nrs=0.69047619047619 sa=0 sb=0 sd=0 mult=1 m=1
XMRD_op1_0900_s10_w20_1 rbl_op1_0900_s10_w20 sn_op1_0900_s10_w20_1 rwl_des 0 sky130_fd_pr__nfet_01v8 L=0.15 W=0.42 nf=1 ad=0.1218 as=0.1218 pd=1.42 ps=1.42 nrd=0.69047619047619  nrs=0.69047619047619 sa=0 sb=0 sd=0 mult=1 m=1
csn_op1_0900_s10_w20_1 sn_op1_0900_s10_w20_1 0 {C_SN}
XMWR_op1_0900_s10_w20_2 sn_op1_0900_s10_w20_2 wwl_des wbl_op1_0900_s10_w20 0 sky130_fd_pr__nfet_01v8 L=0.15 W=0.42 nf=1 ad=0.1218 as=0.1218 pd=1.42 ps=1.42 nrd=0.69047619047619  nrs=0.69047619047619 sa=0 sb=0 sd=0 mult=1 m=1
XMRD_op1_0900_s10_w20_2 rbl_op1_0900_s10_w20 sn_op1_0900_s10_w20_2 rwl_des 0 sky130_fd_pr__nfet_01v8 L=0.15 W=0.42 nf=1 ad=0.1218 as=0.1218 pd=1.42 ps=1.42 nrd=0.69047619047619  nrs=0.69047619047619 sa=0 sb=0 sd=0 mult=1 m=1
csn_op1_0900_s10_w20_2 sn_op1_0900_s10_w20_2 0 {C_SN}
XMWR_op1_0900_s10_w20_3 sn_op1_0900_s10_w20_3 wwl_des wbl_op1_0900_s10_w20 0 sky130_fd_pr__nfet_01v8 L=0.15 W=0.42 nf=1 ad=0.1218 as=0.1218 pd=1.42 ps=1.42 nrd=0.69047619047619  nrs=0.69047619047619 sa=0 sb=0 sd=0 mult=1 m=1
XMRD_op1_0900_s10_w20_3 rbl_op1_0900_s10_w20 sn_op1_0900_s10_w20_3 rwl_des 0 sky130_fd_pr__nfet_01v8 L=0.15 W=0.42 nf=1 ad=0.1218 as=0.1218 pd=1.42 ps=1.42 nrd=0.69047619047619  nrs=0.69047619047619 sa=0 sb=0 sd=0 mult=1 m=1
csn_op1_0900_s10_w20_3 sn_op1_0900_s10_w20_3 0 {C_SN}
XMN1_op1_0900_s10_w20 rbl_op1_0900_s10_w20 ref_op1_0900_s10_w20 vn_op1_0900_s10_w20 0 sky130_fd_pr__nfet_01v8 L=0.15 W=1 nf=1 ad=0.29 as=0.29 pd=2.58 ps=2.58 mult=1 m=1
XMN2_op1_0900_s10_w20 ref_op1_0900_s10_w20 rbl_op1_0900_s10_w20 vn_op1_0900_s10_w20 0 sky130_fd_pr__nfet_01v8 L=0.15 W=1 nf=1 ad=0.29 as=0.29 pd=2.58 ps=2.58 mult=1 m=1
XMP1_op1_0900_s10_w20 rbl_op1_0900_s10_w20 ref_op1_0900_s10_w20 vp_op1_0900_s10_w20 vdd sky130_fd_pr__pfet_01v8 L=0.15 W=2 nf=1 ad=0.58 as=0.58 pd=4.58 ps=4.58 mult=1 m=1
XMP2_op1_0900_s10_w20 ref_op1_0900_s10_w20 rbl_op1_0900_s10_w20 vp_op1_0900_s10_w20 vdd sky130_fd_pr__pfet_01v8 L=0.15 W=2 nf=1 ad=0.58 as=0.58 pd=4.58 ps=4.58 mult=1 m=1
XMNF_op1_0900_s10_w20 vn_op1_0900_s10_w20 en_op1_0900_s10_w20 0 0 sky130_fd_pr__nfet_01v8 L=0.15 W=2 nf=1 ad=0.58 as=0.58 pd=4.58 ps=4.58 mult=1 m=1
XMPH_op1_0900_s10_w20 vp_op1_0900_s10_w20 enb_op1_0900_s10_w20 vdd vdd sky130_fd_pr__pfet_01v8 L=0.15 W=4 nf=1 ad=1.16 as=1.16 pd=8.58 ps=8.58 mult=1 m=1
bd_op1_0900_s10_w20 d_op1_0900_s10_w20 0 v=v(rbl_op1_0900_s10_w20)-v(ref_op1_0900_s10_w20)

* ---- instance 58: op1_0900_s10_w30 (t_en 14 ns, WWL 15..45 ns, release 47 ns) ----
ven_op1_0900_s10_w30  en_op1_0900_s10_w30  0 pwl(0 0 1.4000e-08 0 1.4100e-08 {VDD} 4.7000e-08 {VDD} 4.7100e-08 0)
venb_op1_0900_s10_w30 enb_op1_0900_s10_w30 0 pwl(0 {VDD} 1.4000e-08 {VDD} 1.4100e-08 0 4.7000e-08 0 4.7100e-08 {VDD})
vrs_op1_0900_s10_w30  rwls_op1_0900_s10_w30 0 pwl(0 {VDD} {T_READ} {VDD} {T_READ+TEDGE} 0 4.7000e-08 0 4.7100e-08 {VDD})
vww_op1_0900_s10_w30  wwl_op1_0900_s10_w30 0 pwl(0 0 1.5000e-08 0 1.5100e-08 {VDD} 4.5000e-08 {VDD} 4.5100e-08 0)
vwc_op1_0900_s10_w30  wbc_op1_0900_s10_w30 0 pwl(0 0 1.5000e-08 0 1.5100e-08 {VDD} 4.7000e-08 {VDD} 4.7100e-08 0)
swb_op1_0900_s10_w30 ref_op1_0900_s10_w30 wbl_op1_0900_s10_w30 wbc_op1_0900_s10_w30 0 swwbl
cwbl_op1_0900_s10_w30 wbl_op1_0900_s10_w30 0 {C_WBL}
spa_op1_0900_s10_w30 prea rbl_op1_0900_s10_w30 ctl 0 swpre
spr_op1_0900_s10_w30 pref ref_op1_0900_s10_w30 ctl 0 swpre
crbl_op1_0900_s10_w30 rbl_op1_0900_s10_w30 0 {C_RBL}
cref_op1_0900_s10_w30 ref_op1_0900_s10_w30 0 {C_RBL}   $ ASSUMPTION: ideal matched dummy load
XMWR_op1_0900_s10_w30_0 sn_op1_0900_s10_w30_0 wwl_op1_0900_s10_w30 wbl_op1_0900_s10_w30 0 sky130_fd_pr__nfet_01v8 L=0.15 W=0.42 nf=1 ad=0.1218 as=0.1218 pd=1.42 ps=1.42 nrd=0.69047619047619  nrs=0.69047619047619 sa=0 sb=0 sd=0 mult=1 m=1
XMRD_op1_0900_s10_w30_0 rbl_op1_0900_s10_w30 sn_op1_0900_s10_w30_0 rwls_op1_0900_s10_w30 0 sky130_fd_pr__nfet_01v8 L=0.15 W=0.42 nf=1 ad=0.1218 as=0.1218 pd=1.42 ps=1.42 nrd=0.69047619047619  nrs=0.69047619047619 sa=0 sb=0 sd=0 mult=1 m=1
csn_op1_0900_s10_w30_0 sn_op1_0900_s10_w30_0 0 {C_SN}
XMWR_op1_0900_s10_w30_1 sn_op1_0900_s10_w30_1 wwl_des wbl_op1_0900_s10_w30 0 sky130_fd_pr__nfet_01v8 L=0.15 W=0.42 nf=1 ad=0.1218 as=0.1218 pd=1.42 ps=1.42 nrd=0.69047619047619  nrs=0.69047619047619 sa=0 sb=0 sd=0 mult=1 m=1
XMRD_op1_0900_s10_w30_1 rbl_op1_0900_s10_w30 sn_op1_0900_s10_w30_1 rwl_des 0 sky130_fd_pr__nfet_01v8 L=0.15 W=0.42 nf=1 ad=0.1218 as=0.1218 pd=1.42 ps=1.42 nrd=0.69047619047619  nrs=0.69047619047619 sa=0 sb=0 sd=0 mult=1 m=1
csn_op1_0900_s10_w30_1 sn_op1_0900_s10_w30_1 0 {C_SN}
XMWR_op1_0900_s10_w30_2 sn_op1_0900_s10_w30_2 wwl_des wbl_op1_0900_s10_w30 0 sky130_fd_pr__nfet_01v8 L=0.15 W=0.42 nf=1 ad=0.1218 as=0.1218 pd=1.42 ps=1.42 nrd=0.69047619047619  nrs=0.69047619047619 sa=0 sb=0 sd=0 mult=1 m=1
XMRD_op1_0900_s10_w30_2 rbl_op1_0900_s10_w30 sn_op1_0900_s10_w30_2 rwl_des 0 sky130_fd_pr__nfet_01v8 L=0.15 W=0.42 nf=1 ad=0.1218 as=0.1218 pd=1.42 ps=1.42 nrd=0.69047619047619  nrs=0.69047619047619 sa=0 sb=0 sd=0 mult=1 m=1
csn_op1_0900_s10_w30_2 sn_op1_0900_s10_w30_2 0 {C_SN}
XMWR_op1_0900_s10_w30_3 sn_op1_0900_s10_w30_3 wwl_des wbl_op1_0900_s10_w30 0 sky130_fd_pr__nfet_01v8 L=0.15 W=0.42 nf=1 ad=0.1218 as=0.1218 pd=1.42 ps=1.42 nrd=0.69047619047619  nrs=0.69047619047619 sa=0 sb=0 sd=0 mult=1 m=1
XMRD_op1_0900_s10_w30_3 rbl_op1_0900_s10_w30 sn_op1_0900_s10_w30_3 rwl_des 0 sky130_fd_pr__nfet_01v8 L=0.15 W=0.42 nf=1 ad=0.1218 as=0.1218 pd=1.42 ps=1.42 nrd=0.69047619047619  nrs=0.69047619047619 sa=0 sb=0 sd=0 mult=1 m=1
csn_op1_0900_s10_w30_3 sn_op1_0900_s10_w30_3 0 {C_SN}
XMN1_op1_0900_s10_w30 rbl_op1_0900_s10_w30 ref_op1_0900_s10_w30 vn_op1_0900_s10_w30 0 sky130_fd_pr__nfet_01v8 L=0.15 W=1 nf=1 ad=0.29 as=0.29 pd=2.58 ps=2.58 mult=1 m=1
XMN2_op1_0900_s10_w30 ref_op1_0900_s10_w30 rbl_op1_0900_s10_w30 vn_op1_0900_s10_w30 0 sky130_fd_pr__nfet_01v8 L=0.15 W=1 nf=1 ad=0.29 as=0.29 pd=2.58 ps=2.58 mult=1 m=1
XMP1_op1_0900_s10_w30 rbl_op1_0900_s10_w30 ref_op1_0900_s10_w30 vp_op1_0900_s10_w30 vdd sky130_fd_pr__pfet_01v8 L=0.15 W=2 nf=1 ad=0.58 as=0.58 pd=4.58 ps=4.58 mult=1 m=1
XMP2_op1_0900_s10_w30 ref_op1_0900_s10_w30 rbl_op1_0900_s10_w30 vp_op1_0900_s10_w30 vdd sky130_fd_pr__pfet_01v8 L=0.15 W=2 nf=1 ad=0.58 as=0.58 pd=4.58 ps=4.58 mult=1 m=1
XMNF_op1_0900_s10_w30 vn_op1_0900_s10_w30 en_op1_0900_s10_w30 0 0 sky130_fd_pr__nfet_01v8 L=0.15 W=2 nf=1 ad=0.58 as=0.58 pd=4.58 ps=4.58 mult=1 m=1
XMPH_op1_0900_s10_w30 vp_op1_0900_s10_w30 enb_op1_0900_s10_w30 vdd vdd sky130_fd_pr__pfet_01v8 L=0.15 W=4 nf=1 ad=1.16 as=1.16 pd=8.58 ps=8.58 mult=1 m=1
bd_op1_0900_s10_w30 d_op1_0900_s10_w30 0 v=v(rbl_op1_0900_s10_w30)-v(ref_op1_0900_s10_w30)

* ---- instance 59: op1_0900_s10_w50 (t_en 14 ns, WWL 15..65 ns, release 67 ns) ----
ven_op1_0900_s10_w50  en_op1_0900_s10_w50  0 pwl(0 0 1.4000e-08 0 1.4100e-08 {VDD} 6.7000e-08 {VDD} 6.7100e-08 0)
venb_op1_0900_s10_w50 enb_op1_0900_s10_w50 0 pwl(0 {VDD} 1.4000e-08 {VDD} 1.4100e-08 0 6.7000e-08 0 6.7100e-08 {VDD})
vrs_op1_0900_s10_w50  rwls_op1_0900_s10_w50 0 pwl(0 {VDD} {T_READ} {VDD} {T_READ+TEDGE} 0 6.7000e-08 0 6.7100e-08 {VDD})
vww_op1_0900_s10_w50  wwl_op1_0900_s10_w50 0 pwl(0 0 1.5000e-08 0 1.5100e-08 {VDD} 6.5000e-08 {VDD} 6.5100e-08 0)
vwc_op1_0900_s10_w50  wbc_op1_0900_s10_w50 0 pwl(0 0 1.5000e-08 0 1.5100e-08 {VDD} 6.7000e-08 {VDD} 6.7100e-08 0)
swb_op1_0900_s10_w50 ref_op1_0900_s10_w50 wbl_op1_0900_s10_w50 wbc_op1_0900_s10_w50 0 swwbl
cwbl_op1_0900_s10_w50 wbl_op1_0900_s10_w50 0 {C_WBL}
spa_op1_0900_s10_w50 prea rbl_op1_0900_s10_w50 ctl 0 swpre
spr_op1_0900_s10_w50 pref ref_op1_0900_s10_w50 ctl 0 swpre
crbl_op1_0900_s10_w50 rbl_op1_0900_s10_w50 0 {C_RBL}
cref_op1_0900_s10_w50 ref_op1_0900_s10_w50 0 {C_RBL}   $ ASSUMPTION: ideal matched dummy load
XMWR_op1_0900_s10_w50_0 sn_op1_0900_s10_w50_0 wwl_op1_0900_s10_w50 wbl_op1_0900_s10_w50 0 sky130_fd_pr__nfet_01v8 L=0.15 W=0.42 nf=1 ad=0.1218 as=0.1218 pd=1.42 ps=1.42 nrd=0.69047619047619  nrs=0.69047619047619 sa=0 sb=0 sd=0 mult=1 m=1
XMRD_op1_0900_s10_w50_0 rbl_op1_0900_s10_w50 sn_op1_0900_s10_w50_0 rwls_op1_0900_s10_w50 0 sky130_fd_pr__nfet_01v8 L=0.15 W=0.42 nf=1 ad=0.1218 as=0.1218 pd=1.42 ps=1.42 nrd=0.69047619047619  nrs=0.69047619047619 sa=0 sb=0 sd=0 mult=1 m=1
csn_op1_0900_s10_w50_0 sn_op1_0900_s10_w50_0 0 {C_SN}
XMWR_op1_0900_s10_w50_1 sn_op1_0900_s10_w50_1 wwl_des wbl_op1_0900_s10_w50 0 sky130_fd_pr__nfet_01v8 L=0.15 W=0.42 nf=1 ad=0.1218 as=0.1218 pd=1.42 ps=1.42 nrd=0.69047619047619  nrs=0.69047619047619 sa=0 sb=0 sd=0 mult=1 m=1
XMRD_op1_0900_s10_w50_1 rbl_op1_0900_s10_w50 sn_op1_0900_s10_w50_1 rwl_des 0 sky130_fd_pr__nfet_01v8 L=0.15 W=0.42 nf=1 ad=0.1218 as=0.1218 pd=1.42 ps=1.42 nrd=0.69047619047619  nrs=0.69047619047619 sa=0 sb=0 sd=0 mult=1 m=1
csn_op1_0900_s10_w50_1 sn_op1_0900_s10_w50_1 0 {C_SN}
XMWR_op1_0900_s10_w50_2 sn_op1_0900_s10_w50_2 wwl_des wbl_op1_0900_s10_w50 0 sky130_fd_pr__nfet_01v8 L=0.15 W=0.42 nf=1 ad=0.1218 as=0.1218 pd=1.42 ps=1.42 nrd=0.69047619047619  nrs=0.69047619047619 sa=0 sb=0 sd=0 mult=1 m=1
XMRD_op1_0900_s10_w50_2 rbl_op1_0900_s10_w50 sn_op1_0900_s10_w50_2 rwl_des 0 sky130_fd_pr__nfet_01v8 L=0.15 W=0.42 nf=1 ad=0.1218 as=0.1218 pd=1.42 ps=1.42 nrd=0.69047619047619  nrs=0.69047619047619 sa=0 sb=0 sd=0 mult=1 m=1
csn_op1_0900_s10_w50_2 sn_op1_0900_s10_w50_2 0 {C_SN}
XMWR_op1_0900_s10_w50_3 sn_op1_0900_s10_w50_3 wwl_des wbl_op1_0900_s10_w50 0 sky130_fd_pr__nfet_01v8 L=0.15 W=0.42 nf=1 ad=0.1218 as=0.1218 pd=1.42 ps=1.42 nrd=0.69047619047619  nrs=0.69047619047619 sa=0 sb=0 sd=0 mult=1 m=1
XMRD_op1_0900_s10_w50_3 rbl_op1_0900_s10_w50 sn_op1_0900_s10_w50_3 rwl_des 0 sky130_fd_pr__nfet_01v8 L=0.15 W=0.42 nf=1 ad=0.1218 as=0.1218 pd=1.42 ps=1.42 nrd=0.69047619047619  nrs=0.69047619047619 sa=0 sb=0 sd=0 mult=1 m=1
csn_op1_0900_s10_w50_3 sn_op1_0900_s10_w50_3 0 {C_SN}
XMN1_op1_0900_s10_w50 rbl_op1_0900_s10_w50 ref_op1_0900_s10_w50 vn_op1_0900_s10_w50 0 sky130_fd_pr__nfet_01v8 L=0.15 W=1 nf=1 ad=0.29 as=0.29 pd=2.58 ps=2.58 mult=1 m=1
XMN2_op1_0900_s10_w50 ref_op1_0900_s10_w50 rbl_op1_0900_s10_w50 vn_op1_0900_s10_w50 0 sky130_fd_pr__nfet_01v8 L=0.15 W=1 nf=1 ad=0.29 as=0.29 pd=2.58 ps=2.58 mult=1 m=1
XMP1_op1_0900_s10_w50 rbl_op1_0900_s10_w50 ref_op1_0900_s10_w50 vp_op1_0900_s10_w50 vdd sky130_fd_pr__pfet_01v8 L=0.15 W=2 nf=1 ad=0.58 as=0.58 pd=4.58 ps=4.58 mult=1 m=1
XMP2_op1_0900_s10_w50 ref_op1_0900_s10_w50 rbl_op1_0900_s10_w50 vp_op1_0900_s10_w50 vdd sky130_fd_pr__pfet_01v8 L=0.15 W=2 nf=1 ad=0.58 as=0.58 pd=4.58 ps=4.58 mult=1 m=1
XMNF_op1_0900_s10_w50 vn_op1_0900_s10_w50 en_op1_0900_s10_w50 0 0 sky130_fd_pr__nfet_01v8 L=0.15 W=2 nf=1 ad=0.58 as=0.58 pd=4.58 ps=4.58 mult=1 m=1
XMPH_op1_0900_s10_w50 vp_op1_0900_s10_w50 enb_op1_0900_s10_w50 vdd vdd sky130_fd_pr__pfet_01v8 L=0.15 W=4 nf=1 ad=1.16 as=1.16 pd=8.58 ps=8.58 mult=1 m=1
bd_op1_0900_s10_w50 d_op1_0900_s10_w50 0 v=v(rbl_op1_0900_s10_w50)-v(ref_op1_0900_s10_w50)

* ---- instance 60: op1_1000_s0p5_w0p2 (t_en 4.5 ns, WWL 5.5..5.7 ns, release 7.7 ns) ----
ven_op1_1000_s0p5_w0p2  en_op1_1000_s0p5_w0p2  0 pwl(0 0 4.5000e-09 0 4.6000e-09 {VDD} 7.7000e-09 {VDD} 7.8000e-09 0)
venb_op1_1000_s0p5_w0p2 enb_op1_1000_s0p5_w0p2 0 pwl(0 {VDD} 4.5000e-09 {VDD} 4.6000e-09 0 7.7000e-09 0 7.8000e-09 {VDD})
vrs_op1_1000_s0p5_w0p2  rwls_op1_1000_s0p5_w0p2 0 pwl(0 {VDD} {T_READ} {VDD} {T_READ+TEDGE} 0 7.7000e-09 0 7.8000e-09 {VDD})
vww_op1_1000_s0p5_w0p2  wwl_op1_1000_s0p5_w0p2 0 pwl(0 0 5.5000e-09 0 5.6000e-09 {VDD} 5.7000e-09 {VDD} 5.8000e-09 0)
vwc_op1_1000_s0p5_w0p2  wbc_op1_1000_s0p5_w0p2 0 pwl(0 0 5.5000e-09 0 5.6000e-09 {VDD} 7.7000e-09 {VDD} 7.8000e-09 0)
swb_op1_1000_s0p5_w0p2 ref_op1_1000_s0p5_w0p2 wbl_op1_1000_s0p5_w0p2 wbc_op1_1000_s0p5_w0p2 0 swwbl
cwbl_op1_1000_s0p5_w0p2 wbl_op1_1000_s0p5_w0p2 0 {C_WBL}
spa_op1_1000_s0p5_w0p2 prea rbl_op1_1000_s0p5_w0p2 ctl 0 swpre
spr_op1_1000_s0p5_w0p2 pref ref_op1_1000_s0p5_w0p2 ctl 0 swpre
crbl_op1_1000_s0p5_w0p2 rbl_op1_1000_s0p5_w0p2 0 {C_RBL}
cref_op1_1000_s0p5_w0p2 ref_op1_1000_s0p5_w0p2 0 {C_RBL}   $ ASSUMPTION: ideal matched dummy load
XMWR_op1_1000_s0p5_w0p2_0 sn_op1_1000_s0p5_w0p2_0 wwl_op1_1000_s0p5_w0p2 wbl_op1_1000_s0p5_w0p2 0 sky130_fd_pr__nfet_01v8 L=0.15 W=0.42 nf=1 ad=0.1218 as=0.1218 pd=1.42 ps=1.42 nrd=0.69047619047619  nrs=0.69047619047619 sa=0 sb=0 sd=0 mult=1 m=1
XMRD_op1_1000_s0p5_w0p2_0 rbl_op1_1000_s0p5_w0p2 sn_op1_1000_s0p5_w0p2_0 rwls_op1_1000_s0p5_w0p2 0 sky130_fd_pr__nfet_01v8 L=0.15 W=0.42 nf=1 ad=0.1218 as=0.1218 pd=1.42 ps=1.42 nrd=0.69047619047619  nrs=0.69047619047619 sa=0 sb=0 sd=0 mult=1 m=1
csn_op1_1000_s0p5_w0p2_0 sn_op1_1000_s0p5_w0p2_0 0 {C_SN}
XMWR_op1_1000_s0p5_w0p2_1 sn_op1_1000_s0p5_w0p2_1 wwl_des wbl_op1_1000_s0p5_w0p2 0 sky130_fd_pr__nfet_01v8 L=0.15 W=0.42 nf=1 ad=0.1218 as=0.1218 pd=1.42 ps=1.42 nrd=0.69047619047619  nrs=0.69047619047619 sa=0 sb=0 sd=0 mult=1 m=1
XMRD_op1_1000_s0p5_w0p2_1 rbl_op1_1000_s0p5_w0p2 sn_op1_1000_s0p5_w0p2_1 rwl_des 0 sky130_fd_pr__nfet_01v8 L=0.15 W=0.42 nf=1 ad=0.1218 as=0.1218 pd=1.42 ps=1.42 nrd=0.69047619047619  nrs=0.69047619047619 sa=0 sb=0 sd=0 mult=1 m=1
csn_op1_1000_s0p5_w0p2_1 sn_op1_1000_s0p5_w0p2_1 0 {C_SN}
XMWR_op1_1000_s0p5_w0p2_2 sn_op1_1000_s0p5_w0p2_2 wwl_des wbl_op1_1000_s0p5_w0p2 0 sky130_fd_pr__nfet_01v8 L=0.15 W=0.42 nf=1 ad=0.1218 as=0.1218 pd=1.42 ps=1.42 nrd=0.69047619047619  nrs=0.69047619047619 sa=0 sb=0 sd=0 mult=1 m=1
XMRD_op1_1000_s0p5_w0p2_2 rbl_op1_1000_s0p5_w0p2 sn_op1_1000_s0p5_w0p2_2 rwl_des 0 sky130_fd_pr__nfet_01v8 L=0.15 W=0.42 nf=1 ad=0.1218 as=0.1218 pd=1.42 ps=1.42 nrd=0.69047619047619  nrs=0.69047619047619 sa=0 sb=0 sd=0 mult=1 m=1
csn_op1_1000_s0p5_w0p2_2 sn_op1_1000_s0p5_w0p2_2 0 {C_SN}
XMWR_op1_1000_s0p5_w0p2_3 sn_op1_1000_s0p5_w0p2_3 wwl_des wbl_op1_1000_s0p5_w0p2 0 sky130_fd_pr__nfet_01v8 L=0.15 W=0.42 nf=1 ad=0.1218 as=0.1218 pd=1.42 ps=1.42 nrd=0.69047619047619  nrs=0.69047619047619 sa=0 sb=0 sd=0 mult=1 m=1
XMRD_op1_1000_s0p5_w0p2_3 rbl_op1_1000_s0p5_w0p2 sn_op1_1000_s0p5_w0p2_3 rwl_des 0 sky130_fd_pr__nfet_01v8 L=0.15 W=0.42 nf=1 ad=0.1218 as=0.1218 pd=1.42 ps=1.42 nrd=0.69047619047619  nrs=0.69047619047619 sa=0 sb=0 sd=0 mult=1 m=1
csn_op1_1000_s0p5_w0p2_3 sn_op1_1000_s0p5_w0p2_3 0 {C_SN}
XMN1_op1_1000_s0p5_w0p2 rbl_op1_1000_s0p5_w0p2 ref_op1_1000_s0p5_w0p2 vn_op1_1000_s0p5_w0p2 0 sky130_fd_pr__nfet_01v8 L=0.15 W=1 nf=1 ad=0.29 as=0.29 pd=2.58 ps=2.58 mult=1 m=1
XMN2_op1_1000_s0p5_w0p2 ref_op1_1000_s0p5_w0p2 rbl_op1_1000_s0p5_w0p2 vn_op1_1000_s0p5_w0p2 0 sky130_fd_pr__nfet_01v8 L=0.15 W=1 nf=1 ad=0.29 as=0.29 pd=2.58 ps=2.58 mult=1 m=1
XMP1_op1_1000_s0p5_w0p2 rbl_op1_1000_s0p5_w0p2 ref_op1_1000_s0p5_w0p2 vp_op1_1000_s0p5_w0p2 vdd sky130_fd_pr__pfet_01v8 L=0.15 W=2 nf=1 ad=0.58 as=0.58 pd=4.58 ps=4.58 mult=1 m=1
XMP2_op1_1000_s0p5_w0p2 ref_op1_1000_s0p5_w0p2 rbl_op1_1000_s0p5_w0p2 vp_op1_1000_s0p5_w0p2 vdd sky130_fd_pr__pfet_01v8 L=0.15 W=2 nf=1 ad=0.58 as=0.58 pd=4.58 ps=4.58 mult=1 m=1
XMNF_op1_1000_s0p5_w0p2 vn_op1_1000_s0p5_w0p2 en_op1_1000_s0p5_w0p2 0 0 sky130_fd_pr__nfet_01v8 L=0.15 W=2 nf=1 ad=0.58 as=0.58 pd=4.58 ps=4.58 mult=1 m=1
XMPH_op1_1000_s0p5_w0p2 vp_op1_1000_s0p5_w0p2 enb_op1_1000_s0p5_w0p2 vdd vdd sky130_fd_pr__pfet_01v8 L=0.15 W=4 nf=1 ad=1.16 as=1.16 pd=8.58 ps=8.58 mult=1 m=1
bd_op1_1000_s0p5_w0p2 d_op1_1000_s0p5_w0p2 0 v=v(rbl_op1_1000_s0p5_w0p2)-v(ref_op1_1000_s0p5_w0p2)

* ---- instance 61: op1_1000_s0p5_w0p5 (t_en 4.5 ns, WWL 5.5..6 ns, release 8 ns) ----
ven_op1_1000_s0p5_w0p5  en_op1_1000_s0p5_w0p5  0 pwl(0 0 4.5000e-09 0 4.6000e-09 {VDD} 8.0000e-09 {VDD} 8.1000e-09 0)
venb_op1_1000_s0p5_w0p5 enb_op1_1000_s0p5_w0p5 0 pwl(0 {VDD} 4.5000e-09 {VDD} 4.6000e-09 0 8.0000e-09 0 8.1000e-09 {VDD})
vrs_op1_1000_s0p5_w0p5  rwls_op1_1000_s0p5_w0p5 0 pwl(0 {VDD} {T_READ} {VDD} {T_READ+TEDGE} 0 8.0000e-09 0 8.1000e-09 {VDD})
vww_op1_1000_s0p5_w0p5  wwl_op1_1000_s0p5_w0p5 0 pwl(0 0 5.5000e-09 0 5.6000e-09 {VDD} 6.0000e-09 {VDD} 6.1000e-09 0)
vwc_op1_1000_s0p5_w0p5  wbc_op1_1000_s0p5_w0p5 0 pwl(0 0 5.5000e-09 0 5.6000e-09 {VDD} 8.0000e-09 {VDD} 8.1000e-09 0)
swb_op1_1000_s0p5_w0p5 ref_op1_1000_s0p5_w0p5 wbl_op1_1000_s0p5_w0p5 wbc_op1_1000_s0p5_w0p5 0 swwbl
cwbl_op1_1000_s0p5_w0p5 wbl_op1_1000_s0p5_w0p5 0 {C_WBL}
spa_op1_1000_s0p5_w0p5 prea rbl_op1_1000_s0p5_w0p5 ctl 0 swpre
spr_op1_1000_s0p5_w0p5 pref ref_op1_1000_s0p5_w0p5 ctl 0 swpre
crbl_op1_1000_s0p5_w0p5 rbl_op1_1000_s0p5_w0p5 0 {C_RBL}
cref_op1_1000_s0p5_w0p5 ref_op1_1000_s0p5_w0p5 0 {C_RBL}   $ ASSUMPTION: ideal matched dummy load
XMWR_op1_1000_s0p5_w0p5_0 sn_op1_1000_s0p5_w0p5_0 wwl_op1_1000_s0p5_w0p5 wbl_op1_1000_s0p5_w0p5 0 sky130_fd_pr__nfet_01v8 L=0.15 W=0.42 nf=1 ad=0.1218 as=0.1218 pd=1.42 ps=1.42 nrd=0.69047619047619  nrs=0.69047619047619 sa=0 sb=0 sd=0 mult=1 m=1
XMRD_op1_1000_s0p5_w0p5_0 rbl_op1_1000_s0p5_w0p5 sn_op1_1000_s0p5_w0p5_0 rwls_op1_1000_s0p5_w0p5 0 sky130_fd_pr__nfet_01v8 L=0.15 W=0.42 nf=1 ad=0.1218 as=0.1218 pd=1.42 ps=1.42 nrd=0.69047619047619  nrs=0.69047619047619 sa=0 sb=0 sd=0 mult=1 m=1
csn_op1_1000_s0p5_w0p5_0 sn_op1_1000_s0p5_w0p5_0 0 {C_SN}
XMWR_op1_1000_s0p5_w0p5_1 sn_op1_1000_s0p5_w0p5_1 wwl_des wbl_op1_1000_s0p5_w0p5 0 sky130_fd_pr__nfet_01v8 L=0.15 W=0.42 nf=1 ad=0.1218 as=0.1218 pd=1.42 ps=1.42 nrd=0.69047619047619  nrs=0.69047619047619 sa=0 sb=0 sd=0 mult=1 m=1
XMRD_op1_1000_s0p5_w0p5_1 rbl_op1_1000_s0p5_w0p5 sn_op1_1000_s0p5_w0p5_1 rwl_des 0 sky130_fd_pr__nfet_01v8 L=0.15 W=0.42 nf=1 ad=0.1218 as=0.1218 pd=1.42 ps=1.42 nrd=0.69047619047619  nrs=0.69047619047619 sa=0 sb=0 sd=0 mult=1 m=1
csn_op1_1000_s0p5_w0p5_1 sn_op1_1000_s0p5_w0p5_1 0 {C_SN}
XMWR_op1_1000_s0p5_w0p5_2 sn_op1_1000_s0p5_w0p5_2 wwl_des wbl_op1_1000_s0p5_w0p5 0 sky130_fd_pr__nfet_01v8 L=0.15 W=0.42 nf=1 ad=0.1218 as=0.1218 pd=1.42 ps=1.42 nrd=0.69047619047619  nrs=0.69047619047619 sa=0 sb=0 sd=0 mult=1 m=1
XMRD_op1_1000_s0p5_w0p5_2 rbl_op1_1000_s0p5_w0p5 sn_op1_1000_s0p5_w0p5_2 rwl_des 0 sky130_fd_pr__nfet_01v8 L=0.15 W=0.42 nf=1 ad=0.1218 as=0.1218 pd=1.42 ps=1.42 nrd=0.69047619047619  nrs=0.69047619047619 sa=0 sb=0 sd=0 mult=1 m=1
csn_op1_1000_s0p5_w0p5_2 sn_op1_1000_s0p5_w0p5_2 0 {C_SN}
XMWR_op1_1000_s0p5_w0p5_3 sn_op1_1000_s0p5_w0p5_3 wwl_des wbl_op1_1000_s0p5_w0p5 0 sky130_fd_pr__nfet_01v8 L=0.15 W=0.42 nf=1 ad=0.1218 as=0.1218 pd=1.42 ps=1.42 nrd=0.69047619047619  nrs=0.69047619047619 sa=0 sb=0 sd=0 mult=1 m=1
XMRD_op1_1000_s0p5_w0p5_3 rbl_op1_1000_s0p5_w0p5 sn_op1_1000_s0p5_w0p5_3 rwl_des 0 sky130_fd_pr__nfet_01v8 L=0.15 W=0.42 nf=1 ad=0.1218 as=0.1218 pd=1.42 ps=1.42 nrd=0.69047619047619  nrs=0.69047619047619 sa=0 sb=0 sd=0 mult=1 m=1
csn_op1_1000_s0p5_w0p5_3 sn_op1_1000_s0p5_w0p5_3 0 {C_SN}
XMN1_op1_1000_s0p5_w0p5 rbl_op1_1000_s0p5_w0p5 ref_op1_1000_s0p5_w0p5 vn_op1_1000_s0p5_w0p5 0 sky130_fd_pr__nfet_01v8 L=0.15 W=1 nf=1 ad=0.29 as=0.29 pd=2.58 ps=2.58 mult=1 m=1
XMN2_op1_1000_s0p5_w0p5 ref_op1_1000_s0p5_w0p5 rbl_op1_1000_s0p5_w0p5 vn_op1_1000_s0p5_w0p5 0 sky130_fd_pr__nfet_01v8 L=0.15 W=1 nf=1 ad=0.29 as=0.29 pd=2.58 ps=2.58 mult=1 m=1
XMP1_op1_1000_s0p5_w0p5 rbl_op1_1000_s0p5_w0p5 ref_op1_1000_s0p5_w0p5 vp_op1_1000_s0p5_w0p5 vdd sky130_fd_pr__pfet_01v8 L=0.15 W=2 nf=1 ad=0.58 as=0.58 pd=4.58 ps=4.58 mult=1 m=1
XMP2_op1_1000_s0p5_w0p5 ref_op1_1000_s0p5_w0p5 rbl_op1_1000_s0p5_w0p5 vp_op1_1000_s0p5_w0p5 vdd sky130_fd_pr__pfet_01v8 L=0.15 W=2 nf=1 ad=0.58 as=0.58 pd=4.58 ps=4.58 mult=1 m=1
XMNF_op1_1000_s0p5_w0p5 vn_op1_1000_s0p5_w0p5 en_op1_1000_s0p5_w0p5 0 0 sky130_fd_pr__nfet_01v8 L=0.15 W=2 nf=1 ad=0.58 as=0.58 pd=4.58 ps=4.58 mult=1 m=1
XMPH_op1_1000_s0p5_w0p5 vp_op1_1000_s0p5_w0p5 enb_op1_1000_s0p5_w0p5 vdd vdd sky130_fd_pr__pfet_01v8 L=0.15 W=4 nf=1 ad=1.16 as=1.16 pd=8.58 ps=8.58 mult=1 m=1
bd_op1_1000_s0p5_w0p5 d_op1_1000_s0p5_w0p5 0 v=v(rbl_op1_1000_s0p5_w0p5)-v(ref_op1_1000_s0p5_w0p5)

* ---- instance 62: op1_1000_s0p5_w1 (t_en 4.5 ns, WWL 5.5..6.5 ns, release 8.5 ns) ----
ven_op1_1000_s0p5_w1  en_op1_1000_s0p5_w1  0 pwl(0 0 4.5000e-09 0 4.6000e-09 {VDD} 8.5000e-09 {VDD} 8.6000e-09 0)
venb_op1_1000_s0p5_w1 enb_op1_1000_s0p5_w1 0 pwl(0 {VDD} 4.5000e-09 {VDD} 4.6000e-09 0 8.5000e-09 0 8.6000e-09 {VDD})
vrs_op1_1000_s0p5_w1  rwls_op1_1000_s0p5_w1 0 pwl(0 {VDD} {T_READ} {VDD} {T_READ+TEDGE} 0 8.5000e-09 0 8.6000e-09 {VDD})
vww_op1_1000_s0p5_w1  wwl_op1_1000_s0p5_w1 0 pwl(0 0 5.5000e-09 0 5.6000e-09 {VDD} 6.5000e-09 {VDD} 6.6000e-09 0)
vwc_op1_1000_s0p5_w1  wbc_op1_1000_s0p5_w1 0 pwl(0 0 5.5000e-09 0 5.6000e-09 {VDD} 8.5000e-09 {VDD} 8.6000e-09 0)
swb_op1_1000_s0p5_w1 ref_op1_1000_s0p5_w1 wbl_op1_1000_s0p5_w1 wbc_op1_1000_s0p5_w1 0 swwbl
cwbl_op1_1000_s0p5_w1 wbl_op1_1000_s0p5_w1 0 {C_WBL}
spa_op1_1000_s0p5_w1 prea rbl_op1_1000_s0p5_w1 ctl 0 swpre
spr_op1_1000_s0p5_w1 pref ref_op1_1000_s0p5_w1 ctl 0 swpre
crbl_op1_1000_s0p5_w1 rbl_op1_1000_s0p5_w1 0 {C_RBL}
cref_op1_1000_s0p5_w1 ref_op1_1000_s0p5_w1 0 {C_RBL}   $ ASSUMPTION: ideal matched dummy load
XMWR_op1_1000_s0p5_w1_0 sn_op1_1000_s0p5_w1_0 wwl_op1_1000_s0p5_w1 wbl_op1_1000_s0p5_w1 0 sky130_fd_pr__nfet_01v8 L=0.15 W=0.42 nf=1 ad=0.1218 as=0.1218 pd=1.42 ps=1.42 nrd=0.69047619047619  nrs=0.69047619047619 sa=0 sb=0 sd=0 mult=1 m=1
XMRD_op1_1000_s0p5_w1_0 rbl_op1_1000_s0p5_w1 sn_op1_1000_s0p5_w1_0 rwls_op1_1000_s0p5_w1 0 sky130_fd_pr__nfet_01v8 L=0.15 W=0.42 nf=1 ad=0.1218 as=0.1218 pd=1.42 ps=1.42 nrd=0.69047619047619  nrs=0.69047619047619 sa=0 sb=0 sd=0 mult=1 m=1
csn_op1_1000_s0p5_w1_0 sn_op1_1000_s0p5_w1_0 0 {C_SN}
XMWR_op1_1000_s0p5_w1_1 sn_op1_1000_s0p5_w1_1 wwl_des wbl_op1_1000_s0p5_w1 0 sky130_fd_pr__nfet_01v8 L=0.15 W=0.42 nf=1 ad=0.1218 as=0.1218 pd=1.42 ps=1.42 nrd=0.69047619047619  nrs=0.69047619047619 sa=0 sb=0 sd=0 mult=1 m=1
XMRD_op1_1000_s0p5_w1_1 rbl_op1_1000_s0p5_w1 sn_op1_1000_s0p5_w1_1 rwl_des 0 sky130_fd_pr__nfet_01v8 L=0.15 W=0.42 nf=1 ad=0.1218 as=0.1218 pd=1.42 ps=1.42 nrd=0.69047619047619  nrs=0.69047619047619 sa=0 sb=0 sd=0 mult=1 m=1
csn_op1_1000_s0p5_w1_1 sn_op1_1000_s0p5_w1_1 0 {C_SN}
XMWR_op1_1000_s0p5_w1_2 sn_op1_1000_s0p5_w1_2 wwl_des wbl_op1_1000_s0p5_w1 0 sky130_fd_pr__nfet_01v8 L=0.15 W=0.42 nf=1 ad=0.1218 as=0.1218 pd=1.42 ps=1.42 nrd=0.69047619047619  nrs=0.69047619047619 sa=0 sb=0 sd=0 mult=1 m=1
XMRD_op1_1000_s0p5_w1_2 rbl_op1_1000_s0p5_w1 sn_op1_1000_s0p5_w1_2 rwl_des 0 sky130_fd_pr__nfet_01v8 L=0.15 W=0.42 nf=1 ad=0.1218 as=0.1218 pd=1.42 ps=1.42 nrd=0.69047619047619  nrs=0.69047619047619 sa=0 sb=0 sd=0 mult=1 m=1
csn_op1_1000_s0p5_w1_2 sn_op1_1000_s0p5_w1_2 0 {C_SN}
XMWR_op1_1000_s0p5_w1_3 sn_op1_1000_s0p5_w1_3 wwl_des wbl_op1_1000_s0p5_w1 0 sky130_fd_pr__nfet_01v8 L=0.15 W=0.42 nf=1 ad=0.1218 as=0.1218 pd=1.42 ps=1.42 nrd=0.69047619047619  nrs=0.69047619047619 sa=0 sb=0 sd=0 mult=1 m=1
XMRD_op1_1000_s0p5_w1_3 rbl_op1_1000_s0p5_w1 sn_op1_1000_s0p5_w1_3 rwl_des 0 sky130_fd_pr__nfet_01v8 L=0.15 W=0.42 nf=1 ad=0.1218 as=0.1218 pd=1.42 ps=1.42 nrd=0.69047619047619  nrs=0.69047619047619 sa=0 sb=0 sd=0 mult=1 m=1
csn_op1_1000_s0p5_w1_3 sn_op1_1000_s0p5_w1_3 0 {C_SN}
XMN1_op1_1000_s0p5_w1 rbl_op1_1000_s0p5_w1 ref_op1_1000_s0p5_w1 vn_op1_1000_s0p5_w1 0 sky130_fd_pr__nfet_01v8 L=0.15 W=1 nf=1 ad=0.29 as=0.29 pd=2.58 ps=2.58 mult=1 m=1
XMN2_op1_1000_s0p5_w1 ref_op1_1000_s0p5_w1 rbl_op1_1000_s0p5_w1 vn_op1_1000_s0p5_w1 0 sky130_fd_pr__nfet_01v8 L=0.15 W=1 nf=1 ad=0.29 as=0.29 pd=2.58 ps=2.58 mult=1 m=1
XMP1_op1_1000_s0p5_w1 rbl_op1_1000_s0p5_w1 ref_op1_1000_s0p5_w1 vp_op1_1000_s0p5_w1 vdd sky130_fd_pr__pfet_01v8 L=0.15 W=2 nf=1 ad=0.58 as=0.58 pd=4.58 ps=4.58 mult=1 m=1
XMP2_op1_1000_s0p5_w1 ref_op1_1000_s0p5_w1 rbl_op1_1000_s0p5_w1 vp_op1_1000_s0p5_w1 vdd sky130_fd_pr__pfet_01v8 L=0.15 W=2 nf=1 ad=0.58 as=0.58 pd=4.58 ps=4.58 mult=1 m=1
XMNF_op1_1000_s0p5_w1 vn_op1_1000_s0p5_w1 en_op1_1000_s0p5_w1 0 0 sky130_fd_pr__nfet_01v8 L=0.15 W=2 nf=1 ad=0.58 as=0.58 pd=4.58 ps=4.58 mult=1 m=1
XMPH_op1_1000_s0p5_w1 vp_op1_1000_s0p5_w1 enb_op1_1000_s0p5_w1 vdd vdd sky130_fd_pr__pfet_01v8 L=0.15 W=4 nf=1 ad=1.16 as=1.16 pd=8.58 ps=8.58 mult=1 m=1
bd_op1_1000_s0p5_w1 d_op1_1000_s0p5_w1 0 v=v(rbl_op1_1000_s0p5_w1)-v(ref_op1_1000_s0p5_w1)

* ---- instance 63: op1_1000_s0p5_w2 (t_en 4.5 ns, WWL 5.5..7.5 ns, release 9.5 ns) ----
ven_op1_1000_s0p5_w2  en_op1_1000_s0p5_w2  0 pwl(0 0 4.5000e-09 0 4.6000e-09 {VDD} 9.5000e-09 {VDD} 9.6000e-09 0)
venb_op1_1000_s0p5_w2 enb_op1_1000_s0p5_w2 0 pwl(0 {VDD} 4.5000e-09 {VDD} 4.6000e-09 0 9.5000e-09 0 9.6000e-09 {VDD})
vrs_op1_1000_s0p5_w2  rwls_op1_1000_s0p5_w2 0 pwl(0 {VDD} {T_READ} {VDD} {T_READ+TEDGE} 0 9.5000e-09 0 9.6000e-09 {VDD})
vww_op1_1000_s0p5_w2  wwl_op1_1000_s0p5_w2 0 pwl(0 0 5.5000e-09 0 5.6000e-09 {VDD} 7.5000e-09 {VDD} 7.6000e-09 0)
vwc_op1_1000_s0p5_w2  wbc_op1_1000_s0p5_w2 0 pwl(0 0 5.5000e-09 0 5.6000e-09 {VDD} 9.5000e-09 {VDD} 9.6000e-09 0)
swb_op1_1000_s0p5_w2 ref_op1_1000_s0p5_w2 wbl_op1_1000_s0p5_w2 wbc_op1_1000_s0p5_w2 0 swwbl
cwbl_op1_1000_s0p5_w2 wbl_op1_1000_s0p5_w2 0 {C_WBL}
spa_op1_1000_s0p5_w2 prea rbl_op1_1000_s0p5_w2 ctl 0 swpre
spr_op1_1000_s0p5_w2 pref ref_op1_1000_s0p5_w2 ctl 0 swpre
crbl_op1_1000_s0p5_w2 rbl_op1_1000_s0p5_w2 0 {C_RBL}
cref_op1_1000_s0p5_w2 ref_op1_1000_s0p5_w2 0 {C_RBL}   $ ASSUMPTION: ideal matched dummy load
XMWR_op1_1000_s0p5_w2_0 sn_op1_1000_s0p5_w2_0 wwl_op1_1000_s0p5_w2 wbl_op1_1000_s0p5_w2 0 sky130_fd_pr__nfet_01v8 L=0.15 W=0.42 nf=1 ad=0.1218 as=0.1218 pd=1.42 ps=1.42 nrd=0.69047619047619  nrs=0.69047619047619 sa=0 sb=0 sd=0 mult=1 m=1
XMRD_op1_1000_s0p5_w2_0 rbl_op1_1000_s0p5_w2 sn_op1_1000_s0p5_w2_0 rwls_op1_1000_s0p5_w2 0 sky130_fd_pr__nfet_01v8 L=0.15 W=0.42 nf=1 ad=0.1218 as=0.1218 pd=1.42 ps=1.42 nrd=0.69047619047619  nrs=0.69047619047619 sa=0 sb=0 sd=0 mult=1 m=1
csn_op1_1000_s0p5_w2_0 sn_op1_1000_s0p5_w2_0 0 {C_SN}
XMWR_op1_1000_s0p5_w2_1 sn_op1_1000_s0p5_w2_1 wwl_des wbl_op1_1000_s0p5_w2 0 sky130_fd_pr__nfet_01v8 L=0.15 W=0.42 nf=1 ad=0.1218 as=0.1218 pd=1.42 ps=1.42 nrd=0.69047619047619  nrs=0.69047619047619 sa=0 sb=0 sd=0 mult=1 m=1
XMRD_op1_1000_s0p5_w2_1 rbl_op1_1000_s0p5_w2 sn_op1_1000_s0p5_w2_1 rwl_des 0 sky130_fd_pr__nfet_01v8 L=0.15 W=0.42 nf=1 ad=0.1218 as=0.1218 pd=1.42 ps=1.42 nrd=0.69047619047619  nrs=0.69047619047619 sa=0 sb=0 sd=0 mult=1 m=1
csn_op1_1000_s0p5_w2_1 sn_op1_1000_s0p5_w2_1 0 {C_SN}
XMWR_op1_1000_s0p5_w2_2 sn_op1_1000_s0p5_w2_2 wwl_des wbl_op1_1000_s0p5_w2 0 sky130_fd_pr__nfet_01v8 L=0.15 W=0.42 nf=1 ad=0.1218 as=0.1218 pd=1.42 ps=1.42 nrd=0.69047619047619  nrs=0.69047619047619 sa=0 sb=0 sd=0 mult=1 m=1
XMRD_op1_1000_s0p5_w2_2 rbl_op1_1000_s0p5_w2 sn_op1_1000_s0p5_w2_2 rwl_des 0 sky130_fd_pr__nfet_01v8 L=0.15 W=0.42 nf=1 ad=0.1218 as=0.1218 pd=1.42 ps=1.42 nrd=0.69047619047619  nrs=0.69047619047619 sa=0 sb=0 sd=0 mult=1 m=1
csn_op1_1000_s0p5_w2_2 sn_op1_1000_s0p5_w2_2 0 {C_SN}
XMWR_op1_1000_s0p5_w2_3 sn_op1_1000_s0p5_w2_3 wwl_des wbl_op1_1000_s0p5_w2 0 sky130_fd_pr__nfet_01v8 L=0.15 W=0.42 nf=1 ad=0.1218 as=0.1218 pd=1.42 ps=1.42 nrd=0.69047619047619  nrs=0.69047619047619 sa=0 sb=0 sd=0 mult=1 m=1
XMRD_op1_1000_s0p5_w2_3 rbl_op1_1000_s0p5_w2 sn_op1_1000_s0p5_w2_3 rwl_des 0 sky130_fd_pr__nfet_01v8 L=0.15 W=0.42 nf=1 ad=0.1218 as=0.1218 pd=1.42 ps=1.42 nrd=0.69047619047619  nrs=0.69047619047619 sa=0 sb=0 sd=0 mult=1 m=1
csn_op1_1000_s0p5_w2_3 sn_op1_1000_s0p5_w2_3 0 {C_SN}
XMN1_op1_1000_s0p5_w2 rbl_op1_1000_s0p5_w2 ref_op1_1000_s0p5_w2 vn_op1_1000_s0p5_w2 0 sky130_fd_pr__nfet_01v8 L=0.15 W=1 nf=1 ad=0.29 as=0.29 pd=2.58 ps=2.58 mult=1 m=1
XMN2_op1_1000_s0p5_w2 ref_op1_1000_s0p5_w2 rbl_op1_1000_s0p5_w2 vn_op1_1000_s0p5_w2 0 sky130_fd_pr__nfet_01v8 L=0.15 W=1 nf=1 ad=0.29 as=0.29 pd=2.58 ps=2.58 mult=1 m=1
XMP1_op1_1000_s0p5_w2 rbl_op1_1000_s0p5_w2 ref_op1_1000_s0p5_w2 vp_op1_1000_s0p5_w2 vdd sky130_fd_pr__pfet_01v8 L=0.15 W=2 nf=1 ad=0.58 as=0.58 pd=4.58 ps=4.58 mult=1 m=1
XMP2_op1_1000_s0p5_w2 ref_op1_1000_s0p5_w2 rbl_op1_1000_s0p5_w2 vp_op1_1000_s0p5_w2 vdd sky130_fd_pr__pfet_01v8 L=0.15 W=2 nf=1 ad=0.58 as=0.58 pd=4.58 ps=4.58 mult=1 m=1
XMNF_op1_1000_s0p5_w2 vn_op1_1000_s0p5_w2 en_op1_1000_s0p5_w2 0 0 sky130_fd_pr__nfet_01v8 L=0.15 W=2 nf=1 ad=0.58 as=0.58 pd=4.58 ps=4.58 mult=1 m=1
XMPH_op1_1000_s0p5_w2 vp_op1_1000_s0p5_w2 enb_op1_1000_s0p5_w2 vdd vdd sky130_fd_pr__pfet_01v8 L=0.15 W=4 nf=1 ad=1.16 as=1.16 pd=8.58 ps=8.58 mult=1 m=1
bd_op1_1000_s0p5_w2 d_op1_1000_s0p5_w2 0 v=v(rbl_op1_1000_s0p5_w2)-v(ref_op1_1000_s0p5_w2)

* ---- instance 64: op1_1000_s0p5_w3 (t_en 4.5 ns, WWL 5.5..8.5 ns, release 10.5 ns) ----
ven_op1_1000_s0p5_w3  en_op1_1000_s0p5_w3  0 pwl(0 0 4.5000e-09 0 4.6000e-09 {VDD} 1.0500e-08 {VDD} 1.0600e-08 0)
venb_op1_1000_s0p5_w3 enb_op1_1000_s0p5_w3 0 pwl(0 {VDD} 4.5000e-09 {VDD} 4.6000e-09 0 1.0500e-08 0 1.0600e-08 {VDD})
vrs_op1_1000_s0p5_w3  rwls_op1_1000_s0p5_w3 0 pwl(0 {VDD} {T_READ} {VDD} {T_READ+TEDGE} 0 1.0500e-08 0 1.0600e-08 {VDD})
vww_op1_1000_s0p5_w3  wwl_op1_1000_s0p5_w3 0 pwl(0 0 5.5000e-09 0 5.6000e-09 {VDD} 8.5000e-09 {VDD} 8.6000e-09 0)
vwc_op1_1000_s0p5_w3  wbc_op1_1000_s0p5_w3 0 pwl(0 0 5.5000e-09 0 5.6000e-09 {VDD} 1.0500e-08 {VDD} 1.0600e-08 0)
swb_op1_1000_s0p5_w3 ref_op1_1000_s0p5_w3 wbl_op1_1000_s0p5_w3 wbc_op1_1000_s0p5_w3 0 swwbl
cwbl_op1_1000_s0p5_w3 wbl_op1_1000_s0p5_w3 0 {C_WBL}
spa_op1_1000_s0p5_w3 prea rbl_op1_1000_s0p5_w3 ctl 0 swpre
spr_op1_1000_s0p5_w3 pref ref_op1_1000_s0p5_w3 ctl 0 swpre
crbl_op1_1000_s0p5_w3 rbl_op1_1000_s0p5_w3 0 {C_RBL}
cref_op1_1000_s0p5_w3 ref_op1_1000_s0p5_w3 0 {C_RBL}   $ ASSUMPTION: ideal matched dummy load
XMWR_op1_1000_s0p5_w3_0 sn_op1_1000_s0p5_w3_0 wwl_op1_1000_s0p5_w3 wbl_op1_1000_s0p5_w3 0 sky130_fd_pr__nfet_01v8 L=0.15 W=0.42 nf=1 ad=0.1218 as=0.1218 pd=1.42 ps=1.42 nrd=0.69047619047619  nrs=0.69047619047619 sa=0 sb=0 sd=0 mult=1 m=1
XMRD_op1_1000_s0p5_w3_0 rbl_op1_1000_s0p5_w3 sn_op1_1000_s0p5_w3_0 rwls_op1_1000_s0p5_w3 0 sky130_fd_pr__nfet_01v8 L=0.15 W=0.42 nf=1 ad=0.1218 as=0.1218 pd=1.42 ps=1.42 nrd=0.69047619047619  nrs=0.69047619047619 sa=0 sb=0 sd=0 mult=1 m=1
csn_op1_1000_s0p5_w3_0 sn_op1_1000_s0p5_w3_0 0 {C_SN}
XMWR_op1_1000_s0p5_w3_1 sn_op1_1000_s0p5_w3_1 wwl_des wbl_op1_1000_s0p5_w3 0 sky130_fd_pr__nfet_01v8 L=0.15 W=0.42 nf=1 ad=0.1218 as=0.1218 pd=1.42 ps=1.42 nrd=0.69047619047619  nrs=0.69047619047619 sa=0 sb=0 sd=0 mult=1 m=1
XMRD_op1_1000_s0p5_w3_1 rbl_op1_1000_s0p5_w3 sn_op1_1000_s0p5_w3_1 rwl_des 0 sky130_fd_pr__nfet_01v8 L=0.15 W=0.42 nf=1 ad=0.1218 as=0.1218 pd=1.42 ps=1.42 nrd=0.69047619047619  nrs=0.69047619047619 sa=0 sb=0 sd=0 mult=1 m=1
csn_op1_1000_s0p5_w3_1 sn_op1_1000_s0p5_w3_1 0 {C_SN}
XMWR_op1_1000_s0p5_w3_2 sn_op1_1000_s0p5_w3_2 wwl_des wbl_op1_1000_s0p5_w3 0 sky130_fd_pr__nfet_01v8 L=0.15 W=0.42 nf=1 ad=0.1218 as=0.1218 pd=1.42 ps=1.42 nrd=0.69047619047619  nrs=0.69047619047619 sa=0 sb=0 sd=0 mult=1 m=1
XMRD_op1_1000_s0p5_w3_2 rbl_op1_1000_s0p5_w3 sn_op1_1000_s0p5_w3_2 rwl_des 0 sky130_fd_pr__nfet_01v8 L=0.15 W=0.42 nf=1 ad=0.1218 as=0.1218 pd=1.42 ps=1.42 nrd=0.69047619047619  nrs=0.69047619047619 sa=0 sb=0 sd=0 mult=1 m=1
csn_op1_1000_s0p5_w3_2 sn_op1_1000_s0p5_w3_2 0 {C_SN}
XMWR_op1_1000_s0p5_w3_3 sn_op1_1000_s0p5_w3_3 wwl_des wbl_op1_1000_s0p5_w3 0 sky130_fd_pr__nfet_01v8 L=0.15 W=0.42 nf=1 ad=0.1218 as=0.1218 pd=1.42 ps=1.42 nrd=0.69047619047619  nrs=0.69047619047619 sa=0 sb=0 sd=0 mult=1 m=1
XMRD_op1_1000_s0p5_w3_3 rbl_op1_1000_s0p5_w3 sn_op1_1000_s0p5_w3_3 rwl_des 0 sky130_fd_pr__nfet_01v8 L=0.15 W=0.42 nf=1 ad=0.1218 as=0.1218 pd=1.42 ps=1.42 nrd=0.69047619047619  nrs=0.69047619047619 sa=0 sb=0 sd=0 mult=1 m=1
csn_op1_1000_s0p5_w3_3 sn_op1_1000_s0p5_w3_3 0 {C_SN}
XMN1_op1_1000_s0p5_w3 rbl_op1_1000_s0p5_w3 ref_op1_1000_s0p5_w3 vn_op1_1000_s0p5_w3 0 sky130_fd_pr__nfet_01v8 L=0.15 W=1 nf=1 ad=0.29 as=0.29 pd=2.58 ps=2.58 mult=1 m=1
XMN2_op1_1000_s0p5_w3 ref_op1_1000_s0p5_w3 rbl_op1_1000_s0p5_w3 vn_op1_1000_s0p5_w3 0 sky130_fd_pr__nfet_01v8 L=0.15 W=1 nf=1 ad=0.29 as=0.29 pd=2.58 ps=2.58 mult=1 m=1
XMP1_op1_1000_s0p5_w3 rbl_op1_1000_s0p5_w3 ref_op1_1000_s0p5_w3 vp_op1_1000_s0p5_w3 vdd sky130_fd_pr__pfet_01v8 L=0.15 W=2 nf=1 ad=0.58 as=0.58 pd=4.58 ps=4.58 mult=1 m=1
XMP2_op1_1000_s0p5_w3 ref_op1_1000_s0p5_w3 rbl_op1_1000_s0p5_w3 vp_op1_1000_s0p5_w3 vdd sky130_fd_pr__pfet_01v8 L=0.15 W=2 nf=1 ad=0.58 as=0.58 pd=4.58 ps=4.58 mult=1 m=1
XMNF_op1_1000_s0p5_w3 vn_op1_1000_s0p5_w3 en_op1_1000_s0p5_w3 0 0 sky130_fd_pr__nfet_01v8 L=0.15 W=2 nf=1 ad=0.58 as=0.58 pd=4.58 ps=4.58 mult=1 m=1
XMPH_op1_1000_s0p5_w3 vp_op1_1000_s0p5_w3 enb_op1_1000_s0p5_w3 vdd vdd sky130_fd_pr__pfet_01v8 L=0.15 W=4 nf=1 ad=1.16 as=1.16 pd=8.58 ps=8.58 mult=1 m=1
bd_op1_1000_s0p5_w3 d_op1_1000_s0p5_w3 0 v=v(rbl_op1_1000_s0p5_w3)-v(ref_op1_1000_s0p5_w3)

* ---- instance 65: op1_1000_s0p5_w5 (t_en 4.5 ns, WWL 5.5..10.5 ns, release 12.5 ns) ----
ven_op1_1000_s0p5_w5  en_op1_1000_s0p5_w5  0 pwl(0 0 4.5000e-09 0 4.6000e-09 {VDD} 1.2500e-08 {VDD} 1.2600e-08 0)
venb_op1_1000_s0p5_w5 enb_op1_1000_s0p5_w5 0 pwl(0 {VDD} 4.5000e-09 {VDD} 4.6000e-09 0 1.2500e-08 0 1.2600e-08 {VDD})
vrs_op1_1000_s0p5_w5  rwls_op1_1000_s0p5_w5 0 pwl(0 {VDD} {T_READ} {VDD} {T_READ+TEDGE} 0 1.2500e-08 0 1.2600e-08 {VDD})
vww_op1_1000_s0p5_w5  wwl_op1_1000_s0p5_w5 0 pwl(0 0 5.5000e-09 0 5.6000e-09 {VDD} 1.0500e-08 {VDD} 1.0600e-08 0)
vwc_op1_1000_s0p5_w5  wbc_op1_1000_s0p5_w5 0 pwl(0 0 5.5000e-09 0 5.6000e-09 {VDD} 1.2500e-08 {VDD} 1.2600e-08 0)
swb_op1_1000_s0p5_w5 ref_op1_1000_s0p5_w5 wbl_op1_1000_s0p5_w5 wbc_op1_1000_s0p5_w5 0 swwbl
cwbl_op1_1000_s0p5_w5 wbl_op1_1000_s0p5_w5 0 {C_WBL}
spa_op1_1000_s0p5_w5 prea rbl_op1_1000_s0p5_w5 ctl 0 swpre
spr_op1_1000_s0p5_w5 pref ref_op1_1000_s0p5_w5 ctl 0 swpre
crbl_op1_1000_s0p5_w5 rbl_op1_1000_s0p5_w5 0 {C_RBL}
cref_op1_1000_s0p5_w5 ref_op1_1000_s0p5_w5 0 {C_RBL}   $ ASSUMPTION: ideal matched dummy load
XMWR_op1_1000_s0p5_w5_0 sn_op1_1000_s0p5_w5_0 wwl_op1_1000_s0p5_w5 wbl_op1_1000_s0p5_w5 0 sky130_fd_pr__nfet_01v8 L=0.15 W=0.42 nf=1 ad=0.1218 as=0.1218 pd=1.42 ps=1.42 nrd=0.69047619047619  nrs=0.69047619047619 sa=0 sb=0 sd=0 mult=1 m=1
XMRD_op1_1000_s0p5_w5_0 rbl_op1_1000_s0p5_w5 sn_op1_1000_s0p5_w5_0 rwls_op1_1000_s0p5_w5 0 sky130_fd_pr__nfet_01v8 L=0.15 W=0.42 nf=1 ad=0.1218 as=0.1218 pd=1.42 ps=1.42 nrd=0.69047619047619  nrs=0.69047619047619 sa=0 sb=0 sd=0 mult=1 m=1
csn_op1_1000_s0p5_w5_0 sn_op1_1000_s0p5_w5_0 0 {C_SN}
XMWR_op1_1000_s0p5_w5_1 sn_op1_1000_s0p5_w5_1 wwl_des wbl_op1_1000_s0p5_w5 0 sky130_fd_pr__nfet_01v8 L=0.15 W=0.42 nf=1 ad=0.1218 as=0.1218 pd=1.42 ps=1.42 nrd=0.69047619047619  nrs=0.69047619047619 sa=0 sb=0 sd=0 mult=1 m=1
XMRD_op1_1000_s0p5_w5_1 rbl_op1_1000_s0p5_w5 sn_op1_1000_s0p5_w5_1 rwl_des 0 sky130_fd_pr__nfet_01v8 L=0.15 W=0.42 nf=1 ad=0.1218 as=0.1218 pd=1.42 ps=1.42 nrd=0.69047619047619  nrs=0.69047619047619 sa=0 sb=0 sd=0 mult=1 m=1
csn_op1_1000_s0p5_w5_1 sn_op1_1000_s0p5_w5_1 0 {C_SN}
XMWR_op1_1000_s0p5_w5_2 sn_op1_1000_s0p5_w5_2 wwl_des wbl_op1_1000_s0p5_w5 0 sky130_fd_pr__nfet_01v8 L=0.15 W=0.42 nf=1 ad=0.1218 as=0.1218 pd=1.42 ps=1.42 nrd=0.69047619047619  nrs=0.69047619047619 sa=0 sb=0 sd=0 mult=1 m=1
XMRD_op1_1000_s0p5_w5_2 rbl_op1_1000_s0p5_w5 sn_op1_1000_s0p5_w5_2 rwl_des 0 sky130_fd_pr__nfet_01v8 L=0.15 W=0.42 nf=1 ad=0.1218 as=0.1218 pd=1.42 ps=1.42 nrd=0.69047619047619  nrs=0.69047619047619 sa=0 sb=0 sd=0 mult=1 m=1
csn_op1_1000_s0p5_w5_2 sn_op1_1000_s0p5_w5_2 0 {C_SN}
XMWR_op1_1000_s0p5_w5_3 sn_op1_1000_s0p5_w5_3 wwl_des wbl_op1_1000_s0p5_w5 0 sky130_fd_pr__nfet_01v8 L=0.15 W=0.42 nf=1 ad=0.1218 as=0.1218 pd=1.42 ps=1.42 nrd=0.69047619047619  nrs=0.69047619047619 sa=0 sb=0 sd=0 mult=1 m=1
XMRD_op1_1000_s0p5_w5_3 rbl_op1_1000_s0p5_w5 sn_op1_1000_s0p5_w5_3 rwl_des 0 sky130_fd_pr__nfet_01v8 L=0.15 W=0.42 nf=1 ad=0.1218 as=0.1218 pd=1.42 ps=1.42 nrd=0.69047619047619  nrs=0.69047619047619 sa=0 sb=0 sd=0 mult=1 m=1
csn_op1_1000_s0p5_w5_3 sn_op1_1000_s0p5_w5_3 0 {C_SN}
XMN1_op1_1000_s0p5_w5 rbl_op1_1000_s0p5_w5 ref_op1_1000_s0p5_w5 vn_op1_1000_s0p5_w5 0 sky130_fd_pr__nfet_01v8 L=0.15 W=1 nf=1 ad=0.29 as=0.29 pd=2.58 ps=2.58 mult=1 m=1
XMN2_op1_1000_s0p5_w5 ref_op1_1000_s0p5_w5 rbl_op1_1000_s0p5_w5 vn_op1_1000_s0p5_w5 0 sky130_fd_pr__nfet_01v8 L=0.15 W=1 nf=1 ad=0.29 as=0.29 pd=2.58 ps=2.58 mult=1 m=1
XMP1_op1_1000_s0p5_w5 rbl_op1_1000_s0p5_w5 ref_op1_1000_s0p5_w5 vp_op1_1000_s0p5_w5 vdd sky130_fd_pr__pfet_01v8 L=0.15 W=2 nf=1 ad=0.58 as=0.58 pd=4.58 ps=4.58 mult=1 m=1
XMP2_op1_1000_s0p5_w5 ref_op1_1000_s0p5_w5 rbl_op1_1000_s0p5_w5 vp_op1_1000_s0p5_w5 vdd sky130_fd_pr__pfet_01v8 L=0.15 W=2 nf=1 ad=0.58 as=0.58 pd=4.58 ps=4.58 mult=1 m=1
XMNF_op1_1000_s0p5_w5 vn_op1_1000_s0p5_w5 en_op1_1000_s0p5_w5 0 0 sky130_fd_pr__nfet_01v8 L=0.15 W=2 nf=1 ad=0.58 as=0.58 pd=4.58 ps=4.58 mult=1 m=1
XMPH_op1_1000_s0p5_w5 vp_op1_1000_s0p5_w5 enb_op1_1000_s0p5_w5 vdd vdd sky130_fd_pr__pfet_01v8 L=0.15 W=4 nf=1 ad=1.16 as=1.16 pd=8.58 ps=8.58 mult=1 m=1
bd_op1_1000_s0p5_w5 d_op1_1000_s0p5_w5 0 v=v(rbl_op1_1000_s0p5_w5)-v(ref_op1_1000_s0p5_w5)

* ---- instance 66: op1_1000_s0p5_w7p5 (t_en 4.5 ns, WWL 5.5..13 ns, release 15 ns) ----
ven_op1_1000_s0p5_w7p5  en_op1_1000_s0p5_w7p5  0 pwl(0 0 4.5000e-09 0 4.6000e-09 {VDD} 1.5000e-08 {VDD} 1.5100e-08 0)
venb_op1_1000_s0p5_w7p5 enb_op1_1000_s0p5_w7p5 0 pwl(0 {VDD} 4.5000e-09 {VDD} 4.6000e-09 0 1.5000e-08 0 1.5100e-08 {VDD})
vrs_op1_1000_s0p5_w7p5  rwls_op1_1000_s0p5_w7p5 0 pwl(0 {VDD} {T_READ} {VDD} {T_READ+TEDGE} 0 1.5000e-08 0 1.5100e-08 {VDD})
vww_op1_1000_s0p5_w7p5  wwl_op1_1000_s0p5_w7p5 0 pwl(0 0 5.5000e-09 0 5.6000e-09 {VDD} 1.3000e-08 {VDD} 1.3100e-08 0)
vwc_op1_1000_s0p5_w7p5  wbc_op1_1000_s0p5_w7p5 0 pwl(0 0 5.5000e-09 0 5.6000e-09 {VDD} 1.5000e-08 {VDD} 1.5100e-08 0)
swb_op1_1000_s0p5_w7p5 ref_op1_1000_s0p5_w7p5 wbl_op1_1000_s0p5_w7p5 wbc_op1_1000_s0p5_w7p5 0 swwbl
cwbl_op1_1000_s0p5_w7p5 wbl_op1_1000_s0p5_w7p5 0 {C_WBL}
spa_op1_1000_s0p5_w7p5 prea rbl_op1_1000_s0p5_w7p5 ctl 0 swpre
spr_op1_1000_s0p5_w7p5 pref ref_op1_1000_s0p5_w7p5 ctl 0 swpre
crbl_op1_1000_s0p5_w7p5 rbl_op1_1000_s0p5_w7p5 0 {C_RBL}
cref_op1_1000_s0p5_w7p5 ref_op1_1000_s0p5_w7p5 0 {C_RBL}   $ ASSUMPTION: ideal matched dummy load
XMWR_op1_1000_s0p5_w7p5_0 sn_op1_1000_s0p5_w7p5_0 wwl_op1_1000_s0p5_w7p5 wbl_op1_1000_s0p5_w7p5 0 sky130_fd_pr__nfet_01v8 L=0.15 W=0.42 nf=1 ad=0.1218 as=0.1218 pd=1.42 ps=1.42 nrd=0.69047619047619  nrs=0.69047619047619 sa=0 sb=0 sd=0 mult=1 m=1
XMRD_op1_1000_s0p5_w7p5_0 rbl_op1_1000_s0p5_w7p5 sn_op1_1000_s0p5_w7p5_0 rwls_op1_1000_s0p5_w7p5 0 sky130_fd_pr__nfet_01v8 L=0.15 W=0.42 nf=1 ad=0.1218 as=0.1218 pd=1.42 ps=1.42 nrd=0.69047619047619  nrs=0.69047619047619 sa=0 sb=0 sd=0 mult=1 m=1
csn_op1_1000_s0p5_w7p5_0 sn_op1_1000_s0p5_w7p5_0 0 {C_SN}
XMWR_op1_1000_s0p5_w7p5_1 sn_op1_1000_s0p5_w7p5_1 wwl_des wbl_op1_1000_s0p5_w7p5 0 sky130_fd_pr__nfet_01v8 L=0.15 W=0.42 nf=1 ad=0.1218 as=0.1218 pd=1.42 ps=1.42 nrd=0.69047619047619  nrs=0.69047619047619 sa=0 sb=0 sd=0 mult=1 m=1
XMRD_op1_1000_s0p5_w7p5_1 rbl_op1_1000_s0p5_w7p5 sn_op1_1000_s0p5_w7p5_1 rwl_des 0 sky130_fd_pr__nfet_01v8 L=0.15 W=0.42 nf=1 ad=0.1218 as=0.1218 pd=1.42 ps=1.42 nrd=0.69047619047619  nrs=0.69047619047619 sa=0 sb=0 sd=0 mult=1 m=1
csn_op1_1000_s0p5_w7p5_1 sn_op1_1000_s0p5_w7p5_1 0 {C_SN}
XMWR_op1_1000_s0p5_w7p5_2 sn_op1_1000_s0p5_w7p5_2 wwl_des wbl_op1_1000_s0p5_w7p5 0 sky130_fd_pr__nfet_01v8 L=0.15 W=0.42 nf=1 ad=0.1218 as=0.1218 pd=1.42 ps=1.42 nrd=0.69047619047619  nrs=0.69047619047619 sa=0 sb=0 sd=0 mult=1 m=1
XMRD_op1_1000_s0p5_w7p5_2 rbl_op1_1000_s0p5_w7p5 sn_op1_1000_s0p5_w7p5_2 rwl_des 0 sky130_fd_pr__nfet_01v8 L=0.15 W=0.42 nf=1 ad=0.1218 as=0.1218 pd=1.42 ps=1.42 nrd=0.69047619047619  nrs=0.69047619047619 sa=0 sb=0 sd=0 mult=1 m=1
csn_op1_1000_s0p5_w7p5_2 sn_op1_1000_s0p5_w7p5_2 0 {C_SN}
XMWR_op1_1000_s0p5_w7p5_3 sn_op1_1000_s0p5_w7p5_3 wwl_des wbl_op1_1000_s0p5_w7p5 0 sky130_fd_pr__nfet_01v8 L=0.15 W=0.42 nf=1 ad=0.1218 as=0.1218 pd=1.42 ps=1.42 nrd=0.69047619047619  nrs=0.69047619047619 sa=0 sb=0 sd=0 mult=1 m=1
XMRD_op1_1000_s0p5_w7p5_3 rbl_op1_1000_s0p5_w7p5 sn_op1_1000_s0p5_w7p5_3 rwl_des 0 sky130_fd_pr__nfet_01v8 L=0.15 W=0.42 nf=1 ad=0.1218 as=0.1218 pd=1.42 ps=1.42 nrd=0.69047619047619  nrs=0.69047619047619 sa=0 sb=0 sd=0 mult=1 m=1
csn_op1_1000_s0p5_w7p5_3 sn_op1_1000_s0p5_w7p5_3 0 {C_SN}
XMN1_op1_1000_s0p5_w7p5 rbl_op1_1000_s0p5_w7p5 ref_op1_1000_s0p5_w7p5 vn_op1_1000_s0p5_w7p5 0 sky130_fd_pr__nfet_01v8 L=0.15 W=1 nf=1 ad=0.29 as=0.29 pd=2.58 ps=2.58 mult=1 m=1
XMN2_op1_1000_s0p5_w7p5 ref_op1_1000_s0p5_w7p5 rbl_op1_1000_s0p5_w7p5 vn_op1_1000_s0p5_w7p5 0 sky130_fd_pr__nfet_01v8 L=0.15 W=1 nf=1 ad=0.29 as=0.29 pd=2.58 ps=2.58 mult=1 m=1
XMP1_op1_1000_s0p5_w7p5 rbl_op1_1000_s0p5_w7p5 ref_op1_1000_s0p5_w7p5 vp_op1_1000_s0p5_w7p5 vdd sky130_fd_pr__pfet_01v8 L=0.15 W=2 nf=1 ad=0.58 as=0.58 pd=4.58 ps=4.58 mult=1 m=1
XMP2_op1_1000_s0p5_w7p5 ref_op1_1000_s0p5_w7p5 rbl_op1_1000_s0p5_w7p5 vp_op1_1000_s0p5_w7p5 vdd sky130_fd_pr__pfet_01v8 L=0.15 W=2 nf=1 ad=0.58 as=0.58 pd=4.58 ps=4.58 mult=1 m=1
XMNF_op1_1000_s0p5_w7p5 vn_op1_1000_s0p5_w7p5 en_op1_1000_s0p5_w7p5 0 0 sky130_fd_pr__nfet_01v8 L=0.15 W=2 nf=1 ad=0.58 as=0.58 pd=4.58 ps=4.58 mult=1 m=1
XMPH_op1_1000_s0p5_w7p5 vp_op1_1000_s0p5_w7p5 enb_op1_1000_s0p5_w7p5 vdd vdd sky130_fd_pr__pfet_01v8 L=0.15 W=4 nf=1 ad=1.16 as=1.16 pd=8.58 ps=8.58 mult=1 m=1
bd_op1_1000_s0p5_w7p5 d_op1_1000_s0p5_w7p5 0 v=v(rbl_op1_1000_s0p5_w7p5)-v(ref_op1_1000_s0p5_w7p5)

* ---- instance 67: op1_1000_s0p5_w10 (t_en 4.5 ns, WWL 5.5..15.5 ns, release 17.5 ns) ----
ven_op1_1000_s0p5_w10  en_op1_1000_s0p5_w10  0 pwl(0 0 4.5000e-09 0 4.6000e-09 {VDD} 1.7500e-08 {VDD} 1.7600e-08 0)
venb_op1_1000_s0p5_w10 enb_op1_1000_s0p5_w10 0 pwl(0 {VDD} 4.5000e-09 {VDD} 4.6000e-09 0 1.7500e-08 0 1.7600e-08 {VDD})
vrs_op1_1000_s0p5_w10  rwls_op1_1000_s0p5_w10 0 pwl(0 {VDD} {T_READ} {VDD} {T_READ+TEDGE} 0 1.7500e-08 0 1.7600e-08 {VDD})
vww_op1_1000_s0p5_w10  wwl_op1_1000_s0p5_w10 0 pwl(0 0 5.5000e-09 0 5.6000e-09 {VDD} 1.5500e-08 {VDD} 1.5600e-08 0)
vwc_op1_1000_s0p5_w10  wbc_op1_1000_s0p5_w10 0 pwl(0 0 5.5000e-09 0 5.6000e-09 {VDD} 1.7500e-08 {VDD} 1.7600e-08 0)
swb_op1_1000_s0p5_w10 ref_op1_1000_s0p5_w10 wbl_op1_1000_s0p5_w10 wbc_op1_1000_s0p5_w10 0 swwbl
cwbl_op1_1000_s0p5_w10 wbl_op1_1000_s0p5_w10 0 {C_WBL}
spa_op1_1000_s0p5_w10 prea rbl_op1_1000_s0p5_w10 ctl 0 swpre
spr_op1_1000_s0p5_w10 pref ref_op1_1000_s0p5_w10 ctl 0 swpre
crbl_op1_1000_s0p5_w10 rbl_op1_1000_s0p5_w10 0 {C_RBL}
cref_op1_1000_s0p5_w10 ref_op1_1000_s0p5_w10 0 {C_RBL}   $ ASSUMPTION: ideal matched dummy load
XMWR_op1_1000_s0p5_w10_0 sn_op1_1000_s0p5_w10_0 wwl_op1_1000_s0p5_w10 wbl_op1_1000_s0p5_w10 0 sky130_fd_pr__nfet_01v8 L=0.15 W=0.42 nf=1 ad=0.1218 as=0.1218 pd=1.42 ps=1.42 nrd=0.69047619047619  nrs=0.69047619047619 sa=0 sb=0 sd=0 mult=1 m=1
XMRD_op1_1000_s0p5_w10_0 rbl_op1_1000_s0p5_w10 sn_op1_1000_s0p5_w10_0 rwls_op1_1000_s0p5_w10 0 sky130_fd_pr__nfet_01v8 L=0.15 W=0.42 nf=1 ad=0.1218 as=0.1218 pd=1.42 ps=1.42 nrd=0.69047619047619  nrs=0.69047619047619 sa=0 sb=0 sd=0 mult=1 m=1
csn_op1_1000_s0p5_w10_0 sn_op1_1000_s0p5_w10_0 0 {C_SN}
XMWR_op1_1000_s0p5_w10_1 sn_op1_1000_s0p5_w10_1 wwl_des wbl_op1_1000_s0p5_w10 0 sky130_fd_pr__nfet_01v8 L=0.15 W=0.42 nf=1 ad=0.1218 as=0.1218 pd=1.42 ps=1.42 nrd=0.69047619047619  nrs=0.69047619047619 sa=0 sb=0 sd=0 mult=1 m=1
XMRD_op1_1000_s0p5_w10_1 rbl_op1_1000_s0p5_w10 sn_op1_1000_s0p5_w10_1 rwl_des 0 sky130_fd_pr__nfet_01v8 L=0.15 W=0.42 nf=1 ad=0.1218 as=0.1218 pd=1.42 ps=1.42 nrd=0.69047619047619  nrs=0.69047619047619 sa=0 sb=0 sd=0 mult=1 m=1
csn_op1_1000_s0p5_w10_1 sn_op1_1000_s0p5_w10_1 0 {C_SN}
XMWR_op1_1000_s0p5_w10_2 sn_op1_1000_s0p5_w10_2 wwl_des wbl_op1_1000_s0p5_w10 0 sky130_fd_pr__nfet_01v8 L=0.15 W=0.42 nf=1 ad=0.1218 as=0.1218 pd=1.42 ps=1.42 nrd=0.69047619047619  nrs=0.69047619047619 sa=0 sb=0 sd=0 mult=1 m=1
XMRD_op1_1000_s0p5_w10_2 rbl_op1_1000_s0p5_w10 sn_op1_1000_s0p5_w10_2 rwl_des 0 sky130_fd_pr__nfet_01v8 L=0.15 W=0.42 nf=1 ad=0.1218 as=0.1218 pd=1.42 ps=1.42 nrd=0.69047619047619  nrs=0.69047619047619 sa=0 sb=0 sd=0 mult=1 m=1
csn_op1_1000_s0p5_w10_2 sn_op1_1000_s0p5_w10_2 0 {C_SN}
XMWR_op1_1000_s0p5_w10_3 sn_op1_1000_s0p5_w10_3 wwl_des wbl_op1_1000_s0p5_w10 0 sky130_fd_pr__nfet_01v8 L=0.15 W=0.42 nf=1 ad=0.1218 as=0.1218 pd=1.42 ps=1.42 nrd=0.69047619047619  nrs=0.69047619047619 sa=0 sb=0 sd=0 mult=1 m=1
XMRD_op1_1000_s0p5_w10_3 rbl_op1_1000_s0p5_w10 sn_op1_1000_s0p5_w10_3 rwl_des 0 sky130_fd_pr__nfet_01v8 L=0.15 W=0.42 nf=1 ad=0.1218 as=0.1218 pd=1.42 ps=1.42 nrd=0.69047619047619  nrs=0.69047619047619 sa=0 sb=0 sd=0 mult=1 m=1
csn_op1_1000_s0p5_w10_3 sn_op1_1000_s0p5_w10_3 0 {C_SN}
XMN1_op1_1000_s0p5_w10 rbl_op1_1000_s0p5_w10 ref_op1_1000_s0p5_w10 vn_op1_1000_s0p5_w10 0 sky130_fd_pr__nfet_01v8 L=0.15 W=1 nf=1 ad=0.29 as=0.29 pd=2.58 ps=2.58 mult=1 m=1
XMN2_op1_1000_s0p5_w10 ref_op1_1000_s0p5_w10 rbl_op1_1000_s0p5_w10 vn_op1_1000_s0p5_w10 0 sky130_fd_pr__nfet_01v8 L=0.15 W=1 nf=1 ad=0.29 as=0.29 pd=2.58 ps=2.58 mult=1 m=1
XMP1_op1_1000_s0p5_w10 rbl_op1_1000_s0p5_w10 ref_op1_1000_s0p5_w10 vp_op1_1000_s0p5_w10 vdd sky130_fd_pr__pfet_01v8 L=0.15 W=2 nf=1 ad=0.58 as=0.58 pd=4.58 ps=4.58 mult=1 m=1
XMP2_op1_1000_s0p5_w10 ref_op1_1000_s0p5_w10 rbl_op1_1000_s0p5_w10 vp_op1_1000_s0p5_w10 vdd sky130_fd_pr__pfet_01v8 L=0.15 W=2 nf=1 ad=0.58 as=0.58 pd=4.58 ps=4.58 mult=1 m=1
XMNF_op1_1000_s0p5_w10 vn_op1_1000_s0p5_w10 en_op1_1000_s0p5_w10 0 0 sky130_fd_pr__nfet_01v8 L=0.15 W=2 nf=1 ad=0.58 as=0.58 pd=4.58 ps=4.58 mult=1 m=1
XMPH_op1_1000_s0p5_w10 vp_op1_1000_s0p5_w10 enb_op1_1000_s0p5_w10 vdd vdd sky130_fd_pr__pfet_01v8 L=0.15 W=4 nf=1 ad=1.16 as=1.16 pd=8.58 ps=8.58 mult=1 m=1
bd_op1_1000_s0p5_w10 d_op1_1000_s0p5_w10 0 v=v(rbl_op1_1000_s0p5_w10)-v(ref_op1_1000_s0p5_w10)

* ---- instance 68: op1_1000_s0p5_w15 (t_en 4.5 ns, WWL 5.5..20.5 ns, release 22.5 ns) ----
ven_op1_1000_s0p5_w15  en_op1_1000_s0p5_w15  0 pwl(0 0 4.5000e-09 0 4.6000e-09 {VDD} 2.2500e-08 {VDD} 2.2600e-08 0)
venb_op1_1000_s0p5_w15 enb_op1_1000_s0p5_w15 0 pwl(0 {VDD} 4.5000e-09 {VDD} 4.6000e-09 0 2.2500e-08 0 2.2600e-08 {VDD})
vrs_op1_1000_s0p5_w15  rwls_op1_1000_s0p5_w15 0 pwl(0 {VDD} {T_READ} {VDD} {T_READ+TEDGE} 0 2.2500e-08 0 2.2600e-08 {VDD})
vww_op1_1000_s0p5_w15  wwl_op1_1000_s0p5_w15 0 pwl(0 0 5.5000e-09 0 5.6000e-09 {VDD} 2.0500e-08 {VDD} 2.0600e-08 0)
vwc_op1_1000_s0p5_w15  wbc_op1_1000_s0p5_w15 0 pwl(0 0 5.5000e-09 0 5.6000e-09 {VDD} 2.2500e-08 {VDD} 2.2600e-08 0)
swb_op1_1000_s0p5_w15 ref_op1_1000_s0p5_w15 wbl_op1_1000_s0p5_w15 wbc_op1_1000_s0p5_w15 0 swwbl
cwbl_op1_1000_s0p5_w15 wbl_op1_1000_s0p5_w15 0 {C_WBL}
spa_op1_1000_s0p5_w15 prea rbl_op1_1000_s0p5_w15 ctl 0 swpre
spr_op1_1000_s0p5_w15 pref ref_op1_1000_s0p5_w15 ctl 0 swpre
crbl_op1_1000_s0p5_w15 rbl_op1_1000_s0p5_w15 0 {C_RBL}
cref_op1_1000_s0p5_w15 ref_op1_1000_s0p5_w15 0 {C_RBL}   $ ASSUMPTION: ideal matched dummy load
XMWR_op1_1000_s0p5_w15_0 sn_op1_1000_s0p5_w15_0 wwl_op1_1000_s0p5_w15 wbl_op1_1000_s0p5_w15 0 sky130_fd_pr__nfet_01v8 L=0.15 W=0.42 nf=1 ad=0.1218 as=0.1218 pd=1.42 ps=1.42 nrd=0.69047619047619  nrs=0.69047619047619 sa=0 sb=0 sd=0 mult=1 m=1
XMRD_op1_1000_s0p5_w15_0 rbl_op1_1000_s0p5_w15 sn_op1_1000_s0p5_w15_0 rwls_op1_1000_s0p5_w15 0 sky130_fd_pr__nfet_01v8 L=0.15 W=0.42 nf=1 ad=0.1218 as=0.1218 pd=1.42 ps=1.42 nrd=0.69047619047619  nrs=0.69047619047619 sa=0 sb=0 sd=0 mult=1 m=1
csn_op1_1000_s0p5_w15_0 sn_op1_1000_s0p5_w15_0 0 {C_SN}
XMWR_op1_1000_s0p5_w15_1 sn_op1_1000_s0p5_w15_1 wwl_des wbl_op1_1000_s0p5_w15 0 sky130_fd_pr__nfet_01v8 L=0.15 W=0.42 nf=1 ad=0.1218 as=0.1218 pd=1.42 ps=1.42 nrd=0.69047619047619  nrs=0.69047619047619 sa=0 sb=0 sd=0 mult=1 m=1
XMRD_op1_1000_s0p5_w15_1 rbl_op1_1000_s0p5_w15 sn_op1_1000_s0p5_w15_1 rwl_des 0 sky130_fd_pr__nfet_01v8 L=0.15 W=0.42 nf=1 ad=0.1218 as=0.1218 pd=1.42 ps=1.42 nrd=0.69047619047619  nrs=0.69047619047619 sa=0 sb=0 sd=0 mult=1 m=1
csn_op1_1000_s0p5_w15_1 sn_op1_1000_s0p5_w15_1 0 {C_SN}
XMWR_op1_1000_s0p5_w15_2 sn_op1_1000_s0p5_w15_2 wwl_des wbl_op1_1000_s0p5_w15 0 sky130_fd_pr__nfet_01v8 L=0.15 W=0.42 nf=1 ad=0.1218 as=0.1218 pd=1.42 ps=1.42 nrd=0.69047619047619  nrs=0.69047619047619 sa=0 sb=0 sd=0 mult=1 m=1
XMRD_op1_1000_s0p5_w15_2 rbl_op1_1000_s0p5_w15 sn_op1_1000_s0p5_w15_2 rwl_des 0 sky130_fd_pr__nfet_01v8 L=0.15 W=0.42 nf=1 ad=0.1218 as=0.1218 pd=1.42 ps=1.42 nrd=0.69047619047619  nrs=0.69047619047619 sa=0 sb=0 sd=0 mult=1 m=1
csn_op1_1000_s0p5_w15_2 sn_op1_1000_s0p5_w15_2 0 {C_SN}
XMWR_op1_1000_s0p5_w15_3 sn_op1_1000_s0p5_w15_3 wwl_des wbl_op1_1000_s0p5_w15 0 sky130_fd_pr__nfet_01v8 L=0.15 W=0.42 nf=1 ad=0.1218 as=0.1218 pd=1.42 ps=1.42 nrd=0.69047619047619  nrs=0.69047619047619 sa=0 sb=0 sd=0 mult=1 m=1
XMRD_op1_1000_s0p5_w15_3 rbl_op1_1000_s0p5_w15 sn_op1_1000_s0p5_w15_3 rwl_des 0 sky130_fd_pr__nfet_01v8 L=0.15 W=0.42 nf=1 ad=0.1218 as=0.1218 pd=1.42 ps=1.42 nrd=0.69047619047619  nrs=0.69047619047619 sa=0 sb=0 sd=0 mult=1 m=1
csn_op1_1000_s0p5_w15_3 sn_op1_1000_s0p5_w15_3 0 {C_SN}
XMN1_op1_1000_s0p5_w15 rbl_op1_1000_s0p5_w15 ref_op1_1000_s0p5_w15 vn_op1_1000_s0p5_w15 0 sky130_fd_pr__nfet_01v8 L=0.15 W=1 nf=1 ad=0.29 as=0.29 pd=2.58 ps=2.58 mult=1 m=1
XMN2_op1_1000_s0p5_w15 ref_op1_1000_s0p5_w15 rbl_op1_1000_s0p5_w15 vn_op1_1000_s0p5_w15 0 sky130_fd_pr__nfet_01v8 L=0.15 W=1 nf=1 ad=0.29 as=0.29 pd=2.58 ps=2.58 mult=1 m=1
XMP1_op1_1000_s0p5_w15 rbl_op1_1000_s0p5_w15 ref_op1_1000_s0p5_w15 vp_op1_1000_s0p5_w15 vdd sky130_fd_pr__pfet_01v8 L=0.15 W=2 nf=1 ad=0.58 as=0.58 pd=4.58 ps=4.58 mult=1 m=1
XMP2_op1_1000_s0p5_w15 ref_op1_1000_s0p5_w15 rbl_op1_1000_s0p5_w15 vp_op1_1000_s0p5_w15 vdd sky130_fd_pr__pfet_01v8 L=0.15 W=2 nf=1 ad=0.58 as=0.58 pd=4.58 ps=4.58 mult=1 m=1
XMNF_op1_1000_s0p5_w15 vn_op1_1000_s0p5_w15 en_op1_1000_s0p5_w15 0 0 sky130_fd_pr__nfet_01v8 L=0.15 W=2 nf=1 ad=0.58 as=0.58 pd=4.58 ps=4.58 mult=1 m=1
XMPH_op1_1000_s0p5_w15 vp_op1_1000_s0p5_w15 enb_op1_1000_s0p5_w15 vdd vdd sky130_fd_pr__pfet_01v8 L=0.15 W=4 nf=1 ad=1.16 as=1.16 pd=8.58 ps=8.58 mult=1 m=1
bd_op1_1000_s0p5_w15 d_op1_1000_s0p5_w15 0 v=v(rbl_op1_1000_s0p5_w15)-v(ref_op1_1000_s0p5_w15)

* ---- instance 69: op1_1000_s0p5_w20 (t_en 4.5 ns, WWL 5.5..25.5 ns, release 27.5 ns) ----
ven_op1_1000_s0p5_w20  en_op1_1000_s0p5_w20  0 pwl(0 0 4.5000e-09 0 4.6000e-09 {VDD} 2.7500e-08 {VDD} 2.7600e-08 0)
venb_op1_1000_s0p5_w20 enb_op1_1000_s0p5_w20 0 pwl(0 {VDD} 4.5000e-09 {VDD} 4.6000e-09 0 2.7500e-08 0 2.7600e-08 {VDD})
vrs_op1_1000_s0p5_w20  rwls_op1_1000_s0p5_w20 0 pwl(0 {VDD} {T_READ} {VDD} {T_READ+TEDGE} 0 2.7500e-08 0 2.7600e-08 {VDD})
vww_op1_1000_s0p5_w20  wwl_op1_1000_s0p5_w20 0 pwl(0 0 5.5000e-09 0 5.6000e-09 {VDD} 2.5500e-08 {VDD} 2.5600e-08 0)
vwc_op1_1000_s0p5_w20  wbc_op1_1000_s0p5_w20 0 pwl(0 0 5.5000e-09 0 5.6000e-09 {VDD} 2.7500e-08 {VDD} 2.7600e-08 0)
swb_op1_1000_s0p5_w20 ref_op1_1000_s0p5_w20 wbl_op1_1000_s0p5_w20 wbc_op1_1000_s0p5_w20 0 swwbl
cwbl_op1_1000_s0p5_w20 wbl_op1_1000_s0p5_w20 0 {C_WBL}
spa_op1_1000_s0p5_w20 prea rbl_op1_1000_s0p5_w20 ctl 0 swpre
spr_op1_1000_s0p5_w20 pref ref_op1_1000_s0p5_w20 ctl 0 swpre
crbl_op1_1000_s0p5_w20 rbl_op1_1000_s0p5_w20 0 {C_RBL}
cref_op1_1000_s0p5_w20 ref_op1_1000_s0p5_w20 0 {C_RBL}   $ ASSUMPTION: ideal matched dummy load
XMWR_op1_1000_s0p5_w20_0 sn_op1_1000_s0p5_w20_0 wwl_op1_1000_s0p5_w20 wbl_op1_1000_s0p5_w20 0 sky130_fd_pr__nfet_01v8 L=0.15 W=0.42 nf=1 ad=0.1218 as=0.1218 pd=1.42 ps=1.42 nrd=0.69047619047619  nrs=0.69047619047619 sa=0 sb=0 sd=0 mult=1 m=1
XMRD_op1_1000_s0p5_w20_0 rbl_op1_1000_s0p5_w20 sn_op1_1000_s0p5_w20_0 rwls_op1_1000_s0p5_w20 0 sky130_fd_pr__nfet_01v8 L=0.15 W=0.42 nf=1 ad=0.1218 as=0.1218 pd=1.42 ps=1.42 nrd=0.69047619047619  nrs=0.69047619047619 sa=0 sb=0 sd=0 mult=1 m=1
csn_op1_1000_s0p5_w20_0 sn_op1_1000_s0p5_w20_0 0 {C_SN}
XMWR_op1_1000_s0p5_w20_1 sn_op1_1000_s0p5_w20_1 wwl_des wbl_op1_1000_s0p5_w20 0 sky130_fd_pr__nfet_01v8 L=0.15 W=0.42 nf=1 ad=0.1218 as=0.1218 pd=1.42 ps=1.42 nrd=0.69047619047619  nrs=0.69047619047619 sa=0 sb=0 sd=0 mult=1 m=1
XMRD_op1_1000_s0p5_w20_1 rbl_op1_1000_s0p5_w20 sn_op1_1000_s0p5_w20_1 rwl_des 0 sky130_fd_pr__nfet_01v8 L=0.15 W=0.42 nf=1 ad=0.1218 as=0.1218 pd=1.42 ps=1.42 nrd=0.69047619047619  nrs=0.69047619047619 sa=0 sb=0 sd=0 mult=1 m=1
csn_op1_1000_s0p5_w20_1 sn_op1_1000_s0p5_w20_1 0 {C_SN}
XMWR_op1_1000_s0p5_w20_2 sn_op1_1000_s0p5_w20_2 wwl_des wbl_op1_1000_s0p5_w20 0 sky130_fd_pr__nfet_01v8 L=0.15 W=0.42 nf=1 ad=0.1218 as=0.1218 pd=1.42 ps=1.42 nrd=0.69047619047619  nrs=0.69047619047619 sa=0 sb=0 sd=0 mult=1 m=1
XMRD_op1_1000_s0p5_w20_2 rbl_op1_1000_s0p5_w20 sn_op1_1000_s0p5_w20_2 rwl_des 0 sky130_fd_pr__nfet_01v8 L=0.15 W=0.42 nf=1 ad=0.1218 as=0.1218 pd=1.42 ps=1.42 nrd=0.69047619047619  nrs=0.69047619047619 sa=0 sb=0 sd=0 mult=1 m=1
csn_op1_1000_s0p5_w20_2 sn_op1_1000_s0p5_w20_2 0 {C_SN}
XMWR_op1_1000_s0p5_w20_3 sn_op1_1000_s0p5_w20_3 wwl_des wbl_op1_1000_s0p5_w20 0 sky130_fd_pr__nfet_01v8 L=0.15 W=0.42 nf=1 ad=0.1218 as=0.1218 pd=1.42 ps=1.42 nrd=0.69047619047619  nrs=0.69047619047619 sa=0 sb=0 sd=0 mult=1 m=1
XMRD_op1_1000_s0p5_w20_3 rbl_op1_1000_s0p5_w20 sn_op1_1000_s0p5_w20_3 rwl_des 0 sky130_fd_pr__nfet_01v8 L=0.15 W=0.42 nf=1 ad=0.1218 as=0.1218 pd=1.42 ps=1.42 nrd=0.69047619047619  nrs=0.69047619047619 sa=0 sb=0 sd=0 mult=1 m=1
csn_op1_1000_s0p5_w20_3 sn_op1_1000_s0p5_w20_3 0 {C_SN}
XMN1_op1_1000_s0p5_w20 rbl_op1_1000_s0p5_w20 ref_op1_1000_s0p5_w20 vn_op1_1000_s0p5_w20 0 sky130_fd_pr__nfet_01v8 L=0.15 W=1 nf=1 ad=0.29 as=0.29 pd=2.58 ps=2.58 mult=1 m=1
XMN2_op1_1000_s0p5_w20 ref_op1_1000_s0p5_w20 rbl_op1_1000_s0p5_w20 vn_op1_1000_s0p5_w20 0 sky130_fd_pr__nfet_01v8 L=0.15 W=1 nf=1 ad=0.29 as=0.29 pd=2.58 ps=2.58 mult=1 m=1
XMP1_op1_1000_s0p5_w20 rbl_op1_1000_s0p5_w20 ref_op1_1000_s0p5_w20 vp_op1_1000_s0p5_w20 vdd sky130_fd_pr__pfet_01v8 L=0.15 W=2 nf=1 ad=0.58 as=0.58 pd=4.58 ps=4.58 mult=1 m=1
XMP2_op1_1000_s0p5_w20 ref_op1_1000_s0p5_w20 rbl_op1_1000_s0p5_w20 vp_op1_1000_s0p5_w20 vdd sky130_fd_pr__pfet_01v8 L=0.15 W=2 nf=1 ad=0.58 as=0.58 pd=4.58 ps=4.58 mult=1 m=1
XMNF_op1_1000_s0p5_w20 vn_op1_1000_s0p5_w20 en_op1_1000_s0p5_w20 0 0 sky130_fd_pr__nfet_01v8 L=0.15 W=2 nf=1 ad=0.58 as=0.58 pd=4.58 ps=4.58 mult=1 m=1
XMPH_op1_1000_s0p5_w20 vp_op1_1000_s0p5_w20 enb_op1_1000_s0p5_w20 vdd vdd sky130_fd_pr__pfet_01v8 L=0.15 W=4 nf=1 ad=1.16 as=1.16 pd=8.58 ps=8.58 mult=1 m=1
bd_op1_1000_s0p5_w20 d_op1_1000_s0p5_w20 0 v=v(rbl_op1_1000_s0p5_w20)-v(ref_op1_1000_s0p5_w20)

* ---- instance 70: op1_1000_s0p5_w30 (t_en 4.5 ns, WWL 5.5..35.5 ns, release 37.5 ns) ----
ven_op1_1000_s0p5_w30  en_op1_1000_s0p5_w30  0 pwl(0 0 4.5000e-09 0 4.6000e-09 {VDD} 3.7500e-08 {VDD} 3.7600e-08 0)
venb_op1_1000_s0p5_w30 enb_op1_1000_s0p5_w30 0 pwl(0 {VDD} 4.5000e-09 {VDD} 4.6000e-09 0 3.7500e-08 0 3.7600e-08 {VDD})
vrs_op1_1000_s0p5_w30  rwls_op1_1000_s0p5_w30 0 pwl(0 {VDD} {T_READ} {VDD} {T_READ+TEDGE} 0 3.7500e-08 0 3.7600e-08 {VDD})
vww_op1_1000_s0p5_w30  wwl_op1_1000_s0p5_w30 0 pwl(0 0 5.5000e-09 0 5.6000e-09 {VDD} 3.5500e-08 {VDD} 3.5600e-08 0)
vwc_op1_1000_s0p5_w30  wbc_op1_1000_s0p5_w30 0 pwl(0 0 5.5000e-09 0 5.6000e-09 {VDD} 3.7500e-08 {VDD} 3.7600e-08 0)
swb_op1_1000_s0p5_w30 ref_op1_1000_s0p5_w30 wbl_op1_1000_s0p5_w30 wbc_op1_1000_s0p5_w30 0 swwbl
cwbl_op1_1000_s0p5_w30 wbl_op1_1000_s0p5_w30 0 {C_WBL}
spa_op1_1000_s0p5_w30 prea rbl_op1_1000_s0p5_w30 ctl 0 swpre
spr_op1_1000_s0p5_w30 pref ref_op1_1000_s0p5_w30 ctl 0 swpre
crbl_op1_1000_s0p5_w30 rbl_op1_1000_s0p5_w30 0 {C_RBL}
cref_op1_1000_s0p5_w30 ref_op1_1000_s0p5_w30 0 {C_RBL}   $ ASSUMPTION: ideal matched dummy load
XMWR_op1_1000_s0p5_w30_0 sn_op1_1000_s0p5_w30_0 wwl_op1_1000_s0p5_w30 wbl_op1_1000_s0p5_w30 0 sky130_fd_pr__nfet_01v8 L=0.15 W=0.42 nf=1 ad=0.1218 as=0.1218 pd=1.42 ps=1.42 nrd=0.69047619047619  nrs=0.69047619047619 sa=0 sb=0 sd=0 mult=1 m=1
XMRD_op1_1000_s0p5_w30_0 rbl_op1_1000_s0p5_w30 sn_op1_1000_s0p5_w30_0 rwls_op1_1000_s0p5_w30 0 sky130_fd_pr__nfet_01v8 L=0.15 W=0.42 nf=1 ad=0.1218 as=0.1218 pd=1.42 ps=1.42 nrd=0.69047619047619  nrs=0.69047619047619 sa=0 sb=0 sd=0 mult=1 m=1
csn_op1_1000_s0p5_w30_0 sn_op1_1000_s0p5_w30_0 0 {C_SN}
XMWR_op1_1000_s0p5_w30_1 sn_op1_1000_s0p5_w30_1 wwl_des wbl_op1_1000_s0p5_w30 0 sky130_fd_pr__nfet_01v8 L=0.15 W=0.42 nf=1 ad=0.1218 as=0.1218 pd=1.42 ps=1.42 nrd=0.69047619047619  nrs=0.69047619047619 sa=0 sb=0 sd=0 mult=1 m=1
XMRD_op1_1000_s0p5_w30_1 rbl_op1_1000_s0p5_w30 sn_op1_1000_s0p5_w30_1 rwl_des 0 sky130_fd_pr__nfet_01v8 L=0.15 W=0.42 nf=1 ad=0.1218 as=0.1218 pd=1.42 ps=1.42 nrd=0.69047619047619  nrs=0.69047619047619 sa=0 sb=0 sd=0 mult=1 m=1
csn_op1_1000_s0p5_w30_1 sn_op1_1000_s0p5_w30_1 0 {C_SN}
XMWR_op1_1000_s0p5_w30_2 sn_op1_1000_s0p5_w30_2 wwl_des wbl_op1_1000_s0p5_w30 0 sky130_fd_pr__nfet_01v8 L=0.15 W=0.42 nf=1 ad=0.1218 as=0.1218 pd=1.42 ps=1.42 nrd=0.69047619047619  nrs=0.69047619047619 sa=0 sb=0 sd=0 mult=1 m=1
XMRD_op1_1000_s0p5_w30_2 rbl_op1_1000_s0p5_w30 sn_op1_1000_s0p5_w30_2 rwl_des 0 sky130_fd_pr__nfet_01v8 L=0.15 W=0.42 nf=1 ad=0.1218 as=0.1218 pd=1.42 ps=1.42 nrd=0.69047619047619  nrs=0.69047619047619 sa=0 sb=0 sd=0 mult=1 m=1
csn_op1_1000_s0p5_w30_2 sn_op1_1000_s0p5_w30_2 0 {C_SN}
XMWR_op1_1000_s0p5_w30_3 sn_op1_1000_s0p5_w30_3 wwl_des wbl_op1_1000_s0p5_w30 0 sky130_fd_pr__nfet_01v8 L=0.15 W=0.42 nf=1 ad=0.1218 as=0.1218 pd=1.42 ps=1.42 nrd=0.69047619047619  nrs=0.69047619047619 sa=0 sb=0 sd=0 mult=1 m=1
XMRD_op1_1000_s0p5_w30_3 rbl_op1_1000_s0p5_w30 sn_op1_1000_s0p5_w30_3 rwl_des 0 sky130_fd_pr__nfet_01v8 L=0.15 W=0.42 nf=1 ad=0.1218 as=0.1218 pd=1.42 ps=1.42 nrd=0.69047619047619  nrs=0.69047619047619 sa=0 sb=0 sd=0 mult=1 m=1
csn_op1_1000_s0p5_w30_3 sn_op1_1000_s0p5_w30_3 0 {C_SN}
XMN1_op1_1000_s0p5_w30 rbl_op1_1000_s0p5_w30 ref_op1_1000_s0p5_w30 vn_op1_1000_s0p5_w30 0 sky130_fd_pr__nfet_01v8 L=0.15 W=1 nf=1 ad=0.29 as=0.29 pd=2.58 ps=2.58 mult=1 m=1
XMN2_op1_1000_s0p5_w30 ref_op1_1000_s0p5_w30 rbl_op1_1000_s0p5_w30 vn_op1_1000_s0p5_w30 0 sky130_fd_pr__nfet_01v8 L=0.15 W=1 nf=1 ad=0.29 as=0.29 pd=2.58 ps=2.58 mult=1 m=1
XMP1_op1_1000_s0p5_w30 rbl_op1_1000_s0p5_w30 ref_op1_1000_s0p5_w30 vp_op1_1000_s0p5_w30 vdd sky130_fd_pr__pfet_01v8 L=0.15 W=2 nf=1 ad=0.58 as=0.58 pd=4.58 ps=4.58 mult=1 m=1
XMP2_op1_1000_s0p5_w30 ref_op1_1000_s0p5_w30 rbl_op1_1000_s0p5_w30 vp_op1_1000_s0p5_w30 vdd sky130_fd_pr__pfet_01v8 L=0.15 W=2 nf=1 ad=0.58 as=0.58 pd=4.58 ps=4.58 mult=1 m=1
XMNF_op1_1000_s0p5_w30 vn_op1_1000_s0p5_w30 en_op1_1000_s0p5_w30 0 0 sky130_fd_pr__nfet_01v8 L=0.15 W=2 nf=1 ad=0.58 as=0.58 pd=4.58 ps=4.58 mult=1 m=1
XMPH_op1_1000_s0p5_w30 vp_op1_1000_s0p5_w30 enb_op1_1000_s0p5_w30 vdd vdd sky130_fd_pr__pfet_01v8 L=0.15 W=4 nf=1 ad=1.16 as=1.16 pd=8.58 ps=8.58 mult=1 m=1
bd_op1_1000_s0p5_w30 d_op1_1000_s0p5_w30 0 v=v(rbl_op1_1000_s0p5_w30)-v(ref_op1_1000_s0p5_w30)

* ---- instance 71: op1_1000_s0p5_w50 (t_en 4.5 ns, WWL 5.5..55.5 ns, release 57.5 ns) ----
ven_op1_1000_s0p5_w50  en_op1_1000_s0p5_w50  0 pwl(0 0 4.5000e-09 0 4.6000e-09 {VDD} 5.7500e-08 {VDD} 5.7600e-08 0)
venb_op1_1000_s0p5_w50 enb_op1_1000_s0p5_w50 0 pwl(0 {VDD} 4.5000e-09 {VDD} 4.6000e-09 0 5.7500e-08 0 5.7600e-08 {VDD})
vrs_op1_1000_s0p5_w50  rwls_op1_1000_s0p5_w50 0 pwl(0 {VDD} {T_READ} {VDD} {T_READ+TEDGE} 0 5.7500e-08 0 5.7600e-08 {VDD})
vww_op1_1000_s0p5_w50  wwl_op1_1000_s0p5_w50 0 pwl(0 0 5.5000e-09 0 5.6000e-09 {VDD} 5.5500e-08 {VDD} 5.5600e-08 0)
vwc_op1_1000_s0p5_w50  wbc_op1_1000_s0p5_w50 0 pwl(0 0 5.5000e-09 0 5.6000e-09 {VDD} 5.7500e-08 {VDD} 5.7600e-08 0)
swb_op1_1000_s0p5_w50 ref_op1_1000_s0p5_w50 wbl_op1_1000_s0p5_w50 wbc_op1_1000_s0p5_w50 0 swwbl
cwbl_op1_1000_s0p5_w50 wbl_op1_1000_s0p5_w50 0 {C_WBL}
spa_op1_1000_s0p5_w50 prea rbl_op1_1000_s0p5_w50 ctl 0 swpre
spr_op1_1000_s0p5_w50 pref ref_op1_1000_s0p5_w50 ctl 0 swpre
crbl_op1_1000_s0p5_w50 rbl_op1_1000_s0p5_w50 0 {C_RBL}
cref_op1_1000_s0p5_w50 ref_op1_1000_s0p5_w50 0 {C_RBL}   $ ASSUMPTION: ideal matched dummy load
XMWR_op1_1000_s0p5_w50_0 sn_op1_1000_s0p5_w50_0 wwl_op1_1000_s0p5_w50 wbl_op1_1000_s0p5_w50 0 sky130_fd_pr__nfet_01v8 L=0.15 W=0.42 nf=1 ad=0.1218 as=0.1218 pd=1.42 ps=1.42 nrd=0.69047619047619  nrs=0.69047619047619 sa=0 sb=0 sd=0 mult=1 m=1
XMRD_op1_1000_s0p5_w50_0 rbl_op1_1000_s0p5_w50 sn_op1_1000_s0p5_w50_0 rwls_op1_1000_s0p5_w50 0 sky130_fd_pr__nfet_01v8 L=0.15 W=0.42 nf=1 ad=0.1218 as=0.1218 pd=1.42 ps=1.42 nrd=0.69047619047619  nrs=0.69047619047619 sa=0 sb=0 sd=0 mult=1 m=1
csn_op1_1000_s0p5_w50_0 sn_op1_1000_s0p5_w50_0 0 {C_SN}
XMWR_op1_1000_s0p5_w50_1 sn_op1_1000_s0p5_w50_1 wwl_des wbl_op1_1000_s0p5_w50 0 sky130_fd_pr__nfet_01v8 L=0.15 W=0.42 nf=1 ad=0.1218 as=0.1218 pd=1.42 ps=1.42 nrd=0.69047619047619  nrs=0.69047619047619 sa=0 sb=0 sd=0 mult=1 m=1
XMRD_op1_1000_s0p5_w50_1 rbl_op1_1000_s0p5_w50 sn_op1_1000_s0p5_w50_1 rwl_des 0 sky130_fd_pr__nfet_01v8 L=0.15 W=0.42 nf=1 ad=0.1218 as=0.1218 pd=1.42 ps=1.42 nrd=0.69047619047619  nrs=0.69047619047619 sa=0 sb=0 sd=0 mult=1 m=1
csn_op1_1000_s0p5_w50_1 sn_op1_1000_s0p5_w50_1 0 {C_SN}
XMWR_op1_1000_s0p5_w50_2 sn_op1_1000_s0p5_w50_2 wwl_des wbl_op1_1000_s0p5_w50 0 sky130_fd_pr__nfet_01v8 L=0.15 W=0.42 nf=1 ad=0.1218 as=0.1218 pd=1.42 ps=1.42 nrd=0.69047619047619  nrs=0.69047619047619 sa=0 sb=0 sd=0 mult=1 m=1
XMRD_op1_1000_s0p5_w50_2 rbl_op1_1000_s0p5_w50 sn_op1_1000_s0p5_w50_2 rwl_des 0 sky130_fd_pr__nfet_01v8 L=0.15 W=0.42 nf=1 ad=0.1218 as=0.1218 pd=1.42 ps=1.42 nrd=0.69047619047619  nrs=0.69047619047619 sa=0 sb=0 sd=0 mult=1 m=1
csn_op1_1000_s0p5_w50_2 sn_op1_1000_s0p5_w50_2 0 {C_SN}
XMWR_op1_1000_s0p5_w50_3 sn_op1_1000_s0p5_w50_3 wwl_des wbl_op1_1000_s0p5_w50 0 sky130_fd_pr__nfet_01v8 L=0.15 W=0.42 nf=1 ad=0.1218 as=0.1218 pd=1.42 ps=1.42 nrd=0.69047619047619  nrs=0.69047619047619 sa=0 sb=0 sd=0 mult=1 m=1
XMRD_op1_1000_s0p5_w50_3 rbl_op1_1000_s0p5_w50 sn_op1_1000_s0p5_w50_3 rwl_des 0 sky130_fd_pr__nfet_01v8 L=0.15 W=0.42 nf=1 ad=0.1218 as=0.1218 pd=1.42 ps=1.42 nrd=0.69047619047619  nrs=0.69047619047619 sa=0 sb=0 sd=0 mult=1 m=1
csn_op1_1000_s0p5_w50_3 sn_op1_1000_s0p5_w50_3 0 {C_SN}
XMN1_op1_1000_s0p5_w50 rbl_op1_1000_s0p5_w50 ref_op1_1000_s0p5_w50 vn_op1_1000_s0p5_w50 0 sky130_fd_pr__nfet_01v8 L=0.15 W=1 nf=1 ad=0.29 as=0.29 pd=2.58 ps=2.58 mult=1 m=1
XMN2_op1_1000_s0p5_w50 ref_op1_1000_s0p5_w50 rbl_op1_1000_s0p5_w50 vn_op1_1000_s0p5_w50 0 sky130_fd_pr__nfet_01v8 L=0.15 W=1 nf=1 ad=0.29 as=0.29 pd=2.58 ps=2.58 mult=1 m=1
XMP1_op1_1000_s0p5_w50 rbl_op1_1000_s0p5_w50 ref_op1_1000_s0p5_w50 vp_op1_1000_s0p5_w50 vdd sky130_fd_pr__pfet_01v8 L=0.15 W=2 nf=1 ad=0.58 as=0.58 pd=4.58 ps=4.58 mult=1 m=1
XMP2_op1_1000_s0p5_w50 ref_op1_1000_s0p5_w50 rbl_op1_1000_s0p5_w50 vp_op1_1000_s0p5_w50 vdd sky130_fd_pr__pfet_01v8 L=0.15 W=2 nf=1 ad=0.58 as=0.58 pd=4.58 ps=4.58 mult=1 m=1
XMNF_op1_1000_s0p5_w50 vn_op1_1000_s0p5_w50 en_op1_1000_s0p5_w50 0 0 sky130_fd_pr__nfet_01v8 L=0.15 W=2 nf=1 ad=0.58 as=0.58 pd=4.58 ps=4.58 mult=1 m=1
XMPH_op1_1000_s0p5_w50 vp_op1_1000_s0p5_w50 enb_op1_1000_s0p5_w50 vdd vdd sky130_fd_pr__pfet_01v8 L=0.15 W=4 nf=1 ad=1.16 as=1.16 pd=8.58 ps=8.58 mult=1 m=1
bd_op1_1000_s0p5_w50 d_op1_1000_s0p5_w50 0 v=v(rbl_op1_1000_s0p5_w50)-v(ref_op1_1000_s0p5_w50)

* ---- instance 72: op1_1000_s1_w0p2 (t_en 5 ns, WWL 6..6.2 ns, release 8.2 ns) ----
ven_op1_1000_s1_w0p2  en_op1_1000_s1_w0p2  0 pwl(0 0 5.0000e-09 0 5.1000e-09 {VDD} 8.2000e-09 {VDD} 8.3000e-09 0)
venb_op1_1000_s1_w0p2 enb_op1_1000_s1_w0p2 0 pwl(0 {VDD} 5.0000e-09 {VDD} 5.1000e-09 0 8.2000e-09 0 8.3000e-09 {VDD})
vrs_op1_1000_s1_w0p2  rwls_op1_1000_s1_w0p2 0 pwl(0 {VDD} {T_READ} {VDD} {T_READ+TEDGE} 0 8.2000e-09 0 8.3000e-09 {VDD})
vww_op1_1000_s1_w0p2  wwl_op1_1000_s1_w0p2 0 pwl(0 0 6.0000e-09 0 6.1000e-09 {VDD} 6.2000e-09 {VDD} 6.3000e-09 0)
vwc_op1_1000_s1_w0p2  wbc_op1_1000_s1_w0p2 0 pwl(0 0 6.0000e-09 0 6.1000e-09 {VDD} 8.2000e-09 {VDD} 8.3000e-09 0)
swb_op1_1000_s1_w0p2 ref_op1_1000_s1_w0p2 wbl_op1_1000_s1_w0p2 wbc_op1_1000_s1_w0p2 0 swwbl
cwbl_op1_1000_s1_w0p2 wbl_op1_1000_s1_w0p2 0 {C_WBL}
spa_op1_1000_s1_w0p2 prea rbl_op1_1000_s1_w0p2 ctl 0 swpre
spr_op1_1000_s1_w0p2 pref ref_op1_1000_s1_w0p2 ctl 0 swpre
crbl_op1_1000_s1_w0p2 rbl_op1_1000_s1_w0p2 0 {C_RBL}
cref_op1_1000_s1_w0p2 ref_op1_1000_s1_w0p2 0 {C_RBL}   $ ASSUMPTION: ideal matched dummy load
XMWR_op1_1000_s1_w0p2_0 sn_op1_1000_s1_w0p2_0 wwl_op1_1000_s1_w0p2 wbl_op1_1000_s1_w0p2 0 sky130_fd_pr__nfet_01v8 L=0.15 W=0.42 nf=1 ad=0.1218 as=0.1218 pd=1.42 ps=1.42 nrd=0.69047619047619  nrs=0.69047619047619 sa=0 sb=0 sd=0 mult=1 m=1
XMRD_op1_1000_s1_w0p2_0 rbl_op1_1000_s1_w0p2 sn_op1_1000_s1_w0p2_0 rwls_op1_1000_s1_w0p2 0 sky130_fd_pr__nfet_01v8 L=0.15 W=0.42 nf=1 ad=0.1218 as=0.1218 pd=1.42 ps=1.42 nrd=0.69047619047619  nrs=0.69047619047619 sa=0 sb=0 sd=0 mult=1 m=1
csn_op1_1000_s1_w0p2_0 sn_op1_1000_s1_w0p2_0 0 {C_SN}
XMWR_op1_1000_s1_w0p2_1 sn_op1_1000_s1_w0p2_1 wwl_des wbl_op1_1000_s1_w0p2 0 sky130_fd_pr__nfet_01v8 L=0.15 W=0.42 nf=1 ad=0.1218 as=0.1218 pd=1.42 ps=1.42 nrd=0.69047619047619  nrs=0.69047619047619 sa=0 sb=0 sd=0 mult=1 m=1
XMRD_op1_1000_s1_w0p2_1 rbl_op1_1000_s1_w0p2 sn_op1_1000_s1_w0p2_1 rwl_des 0 sky130_fd_pr__nfet_01v8 L=0.15 W=0.42 nf=1 ad=0.1218 as=0.1218 pd=1.42 ps=1.42 nrd=0.69047619047619  nrs=0.69047619047619 sa=0 sb=0 sd=0 mult=1 m=1
csn_op1_1000_s1_w0p2_1 sn_op1_1000_s1_w0p2_1 0 {C_SN}
XMWR_op1_1000_s1_w0p2_2 sn_op1_1000_s1_w0p2_2 wwl_des wbl_op1_1000_s1_w0p2 0 sky130_fd_pr__nfet_01v8 L=0.15 W=0.42 nf=1 ad=0.1218 as=0.1218 pd=1.42 ps=1.42 nrd=0.69047619047619  nrs=0.69047619047619 sa=0 sb=0 sd=0 mult=1 m=1
XMRD_op1_1000_s1_w0p2_2 rbl_op1_1000_s1_w0p2 sn_op1_1000_s1_w0p2_2 rwl_des 0 sky130_fd_pr__nfet_01v8 L=0.15 W=0.42 nf=1 ad=0.1218 as=0.1218 pd=1.42 ps=1.42 nrd=0.69047619047619  nrs=0.69047619047619 sa=0 sb=0 sd=0 mult=1 m=1
csn_op1_1000_s1_w0p2_2 sn_op1_1000_s1_w0p2_2 0 {C_SN}
XMWR_op1_1000_s1_w0p2_3 sn_op1_1000_s1_w0p2_3 wwl_des wbl_op1_1000_s1_w0p2 0 sky130_fd_pr__nfet_01v8 L=0.15 W=0.42 nf=1 ad=0.1218 as=0.1218 pd=1.42 ps=1.42 nrd=0.69047619047619  nrs=0.69047619047619 sa=0 sb=0 sd=0 mult=1 m=1
XMRD_op1_1000_s1_w0p2_3 rbl_op1_1000_s1_w0p2 sn_op1_1000_s1_w0p2_3 rwl_des 0 sky130_fd_pr__nfet_01v8 L=0.15 W=0.42 nf=1 ad=0.1218 as=0.1218 pd=1.42 ps=1.42 nrd=0.69047619047619  nrs=0.69047619047619 sa=0 sb=0 sd=0 mult=1 m=1
csn_op1_1000_s1_w0p2_3 sn_op1_1000_s1_w0p2_3 0 {C_SN}
XMN1_op1_1000_s1_w0p2 rbl_op1_1000_s1_w0p2 ref_op1_1000_s1_w0p2 vn_op1_1000_s1_w0p2 0 sky130_fd_pr__nfet_01v8 L=0.15 W=1 nf=1 ad=0.29 as=0.29 pd=2.58 ps=2.58 mult=1 m=1
XMN2_op1_1000_s1_w0p2 ref_op1_1000_s1_w0p2 rbl_op1_1000_s1_w0p2 vn_op1_1000_s1_w0p2 0 sky130_fd_pr__nfet_01v8 L=0.15 W=1 nf=1 ad=0.29 as=0.29 pd=2.58 ps=2.58 mult=1 m=1
XMP1_op1_1000_s1_w0p2 rbl_op1_1000_s1_w0p2 ref_op1_1000_s1_w0p2 vp_op1_1000_s1_w0p2 vdd sky130_fd_pr__pfet_01v8 L=0.15 W=2 nf=1 ad=0.58 as=0.58 pd=4.58 ps=4.58 mult=1 m=1
XMP2_op1_1000_s1_w0p2 ref_op1_1000_s1_w0p2 rbl_op1_1000_s1_w0p2 vp_op1_1000_s1_w0p2 vdd sky130_fd_pr__pfet_01v8 L=0.15 W=2 nf=1 ad=0.58 as=0.58 pd=4.58 ps=4.58 mult=1 m=1
XMNF_op1_1000_s1_w0p2 vn_op1_1000_s1_w0p2 en_op1_1000_s1_w0p2 0 0 sky130_fd_pr__nfet_01v8 L=0.15 W=2 nf=1 ad=0.58 as=0.58 pd=4.58 ps=4.58 mult=1 m=1
XMPH_op1_1000_s1_w0p2 vp_op1_1000_s1_w0p2 enb_op1_1000_s1_w0p2 vdd vdd sky130_fd_pr__pfet_01v8 L=0.15 W=4 nf=1 ad=1.16 as=1.16 pd=8.58 ps=8.58 mult=1 m=1
bd_op1_1000_s1_w0p2 d_op1_1000_s1_w0p2 0 v=v(rbl_op1_1000_s1_w0p2)-v(ref_op1_1000_s1_w0p2)

* ---- instance 73: op1_1000_s1_w0p5 (t_en 5 ns, WWL 6..6.5 ns, release 8.5 ns) ----
ven_op1_1000_s1_w0p5  en_op1_1000_s1_w0p5  0 pwl(0 0 5.0000e-09 0 5.1000e-09 {VDD} 8.5000e-09 {VDD} 8.6000e-09 0)
venb_op1_1000_s1_w0p5 enb_op1_1000_s1_w0p5 0 pwl(0 {VDD} 5.0000e-09 {VDD} 5.1000e-09 0 8.5000e-09 0 8.6000e-09 {VDD})
vrs_op1_1000_s1_w0p5  rwls_op1_1000_s1_w0p5 0 pwl(0 {VDD} {T_READ} {VDD} {T_READ+TEDGE} 0 8.5000e-09 0 8.6000e-09 {VDD})
vww_op1_1000_s1_w0p5  wwl_op1_1000_s1_w0p5 0 pwl(0 0 6.0000e-09 0 6.1000e-09 {VDD} 6.5000e-09 {VDD} 6.6000e-09 0)
vwc_op1_1000_s1_w0p5  wbc_op1_1000_s1_w0p5 0 pwl(0 0 6.0000e-09 0 6.1000e-09 {VDD} 8.5000e-09 {VDD} 8.6000e-09 0)
swb_op1_1000_s1_w0p5 ref_op1_1000_s1_w0p5 wbl_op1_1000_s1_w0p5 wbc_op1_1000_s1_w0p5 0 swwbl
cwbl_op1_1000_s1_w0p5 wbl_op1_1000_s1_w0p5 0 {C_WBL}
spa_op1_1000_s1_w0p5 prea rbl_op1_1000_s1_w0p5 ctl 0 swpre
spr_op1_1000_s1_w0p5 pref ref_op1_1000_s1_w0p5 ctl 0 swpre
crbl_op1_1000_s1_w0p5 rbl_op1_1000_s1_w0p5 0 {C_RBL}
cref_op1_1000_s1_w0p5 ref_op1_1000_s1_w0p5 0 {C_RBL}   $ ASSUMPTION: ideal matched dummy load
XMWR_op1_1000_s1_w0p5_0 sn_op1_1000_s1_w0p5_0 wwl_op1_1000_s1_w0p5 wbl_op1_1000_s1_w0p5 0 sky130_fd_pr__nfet_01v8 L=0.15 W=0.42 nf=1 ad=0.1218 as=0.1218 pd=1.42 ps=1.42 nrd=0.69047619047619  nrs=0.69047619047619 sa=0 sb=0 sd=0 mult=1 m=1
XMRD_op1_1000_s1_w0p5_0 rbl_op1_1000_s1_w0p5 sn_op1_1000_s1_w0p5_0 rwls_op1_1000_s1_w0p5 0 sky130_fd_pr__nfet_01v8 L=0.15 W=0.42 nf=1 ad=0.1218 as=0.1218 pd=1.42 ps=1.42 nrd=0.69047619047619  nrs=0.69047619047619 sa=0 sb=0 sd=0 mult=1 m=1
csn_op1_1000_s1_w0p5_0 sn_op1_1000_s1_w0p5_0 0 {C_SN}
XMWR_op1_1000_s1_w0p5_1 sn_op1_1000_s1_w0p5_1 wwl_des wbl_op1_1000_s1_w0p5 0 sky130_fd_pr__nfet_01v8 L=0.15 W=0.42 nf=1 ad=0.1218 as=0.1218 pd=1.42 ps=1.42 nrd=0.69047619047619  nrs=0.69047619047619 sa=0 sb=0 sd=0 mult=1 m=1
XMRD_op1_1000_s1_w0p5_1 rbl_op1_1000_s1_w0p5 sn_op1_1000_s1_w0p5_1 rwl_des 0 sky130_fd_pr__nfet_01v8 L=0.15 W=0.42 nf=1 ad=0.1218 as=0.1218 pd=1.42 ps=1.42 nrd=0.69047619047619  nrs=0.69047619047619 sa=0 sb=0 sd=0 mult=1 m=1
csn_op1_1000_s1_w0p5_1 sn_op1_1000_s1_w0p5_1 0 {C_SN}
XMWR_op1_1000_s1_w0p5_2 sn_op1_1000_s1_w0p5_2 wwl_des wbl_op1_1000_s1_w0p5 0 sky130_fd_pr__nfet_01v8 L=0.15 W=0.42 nf=1 ad=0.1218 as=0.1218 pd=1.42 ps=1.42 nrd=0.69047619047619  nrs=0.69047619047619 sa=0 sb=0 sd=0 mult=1 m=1
XMRD_op1_1000_s1_w0p5_2 rbl_op1_1000_s1_w0p5 sn_op1_1000_s1_w0p5_2 rwl_des 0 sky130_fd_pr__nfet_01v8 L=0.15 W=0.42 nf=1 ad=0.1218 as=0.1218 pd=1.42 ps=1.42 nrd=0.69047619047619  nrs=0.69047619047619 sa=0 sb=0 sd=0 mult=1 m=1
csn_op1_1000_s1_w0p5_2 sn_op1_1000_s1_w0p5_2 0 {C_SN}
XMWR_op1_1000_s1_w0p5_3 sn_op1_1000_s1_w0p5_3 wwl_des wbl_op1_1000_s1_w0p5 0 sky130_fd_pr__nfet_01v8 L=0.15 W=0.42 nf=1 ad=0.1218 as=0.1218 pd=1.42 ps=1.42 nrd=0.69047619047619  nrs=0.69047619047619 sa=0 sb=0 sd=0 mult=1 m=1
XMRD_op1_1000_s1_w0p5_3 rbl_op1_1000_s1_w0p5 sn_op1_1000_s1_w0p5_3 rwl_des 0 sky130_fd_pr__nfet_01v8 L=0.15 W=0.42 nf=1 ad=0.1218 as=0.1218 pd=1.42 ps=1.42 nrd=0.69047619047619  nrs=0.69047619047619 sa=0 sb=0 sd=0 mult=1 m=1
csn_op1_1000_s1_w0p5_3 sn_op1_1000_s1_w0p5_3 0 {C_SN}
XMN1_op1_1000_s1_w0p5 rbl_op1_1000_s1_w0p5 ref_op1_1000_s1_w0p5 vn_op1_1000_s1_w0p5 0 sky130_fd_pr__nfet_01v8 L=0.15 W=1 nf=1 ad=0.29 as=0.29 pd=2.58 ps=2.58 mult=1 m=1
XMN2_op1_1000_s1_w0p5 ref_op1_1000_s1_w0p5 rbl_op1_1000_s1_w0p5 vn_op1_1000_s1_w0p5 0 sky130_fd_pr__nfet_01v8 L=0.15 W=1 nf=1 ad=0.29 as=0.29 pd=2.58 ps=2.58 mult=1 m=1
XMP1_op1_1000_s1_w0p5 rbl_op1_1000_s1_w0p5 ref_op1_1000_s1_w0p5 vp_op1_1000_s1_w0p5 vdd sky130_fd_pr__pfet_01v8 L=0.15 W=2 nf=1 ad=0.58 as=0.58 pd=4.58 ps=4.58 mult=1 m=1
XMP2_op1_1000_s1_w0p5 ref_op1_1000_s1_w0p5 rbl_op1_1000_s1_w0p5 vp_op1_1000_s1_w0p5 vdd sky130_fd_pr__pfet_01v8 L=0.15 W=2 nf=1 ad=0.58 as=0.58 pd=4.58 ps=4.58 mult=1 m=1
XMNF_op1_1000_s1_w0p5 vn_op1_1000_s1_w0p5 en_op1_1000_s1_w0p5 0 0 sky130_fd_pr__nfet_01v8 L=0.15 W=2 nf=1 ad=0.58 as=0.58 pd=4.58 ps=4.58 mult=1 m=1
XMPH_op1_1000_s1_w0p5 vp_op1_1000_s1_w0p5 enb_op1_1000_s1_w0p5 vdd vdd sky130_fd_pr__pfet_01v8 L=0.15 W=4 nf=1 ad=1.16 as=1.16 pd=8.58 ps=8.58 mult=1 m=1
bd_op1_1000_s1_w0p5 d_op1_1000_s1_w0p5 0 v=v(rbl_op1_1000_s1_w0p5)-v(ref_op1_1000_s1_w0p5)

* ---- instance 74: op1_1000_s1_w1 (t_en 5 ns, WWL 6..7 ns, release 9 ns) ----
ven_op1_1000_s1_w1  en_op1_1000_s1_w1  0 pwl(0 0 5.0000e-09 0 5.1000e-09 {VDD} 9.0000e-09 {VDD} 9.1000e-09 0)
venb_op1_1000_s1_w1 enb_op1_1000_s1_w1 0 pwl(0 {VDD} 5.0000e-09 {VDD} 5.1000e-09 0 9.0000e-09 0 9.1000e-09 {VDD})
vrs_op1_1000_s1_w1  rwls_op1_1000_s1_w1 0 pwl(0 {VDD} {T_READ} {VDD} {T_READ+TEDGE} 0 9.0000e-09 0 9.1000e-09 {VDD})
vww_op1_1000_s1_w1  wwl_op1_1000_s1_w1 0 pwl(0 0 6.0000e-09 0 6.1000e-09 {VDD} 7.0000e-09 {VDD} 7.1000e-09 0)
vwc_op1_1000_s1_w1  wbc_op1_1000_s1_w1 0 pwl(0 0 6.0000e-09 0 6.1000e-09 {VDD} 9.0000e-09 {VDD} 9.1000e-09 0)
swb_op1_1000_s1_w1 ref_op1_1000_s1_w1 wbl_op1_1000_s1_w1 wbc_op1_1000_s1_w1 0 swwbl
cwbl_op1_1000_s1_w1 wbl_op1_1000_s1_w1 0 {C_WBL}
spa_op1_1000_s1_w1 prea rbl_op1_1000_s1_w1 ctl 0 swpre
spr_op1_1000_s1_w1 pref ref_op1_1000_s1_w1 ctl 0 swpre
crbl_op1_1000_s1_w1 rbl_op1_1000_s1_w1 0 {C_RBL}
cref_op1_1000_s1_w1 ref_op1_1000_s1_w1 0 {C_RBL}   $ ASSUMPTION: ideal matched dummy load
XMWR_op1_1000_s1_w1_0 sn_op1_1000_s1_w1_0 wwl_op1_1000_s1_w1 wbl_op1_1000_s1_w1 0 sky130_fd_pr__nfet_01v8 L=0.15 W=0.42 nf=1 ad=0.1218 as=0.1218 pd=1.42 ps=1.42 nrd=0.69047619047619  nrs=0.69047619047619 sa=0 sb=0 sd=0 mult=1 m=1
XMRD_op1_1000_s1_w1_0 rbl_op1_1000_s1_w1 sn_op1_1000_s1_w1_0 rwls_op1_1000_s1_w1 0 sky130_fd_pr__nfet_01v8 L=0.15 W=0.42 nf=1 ad=0.1218 as=0.1218 pd=1.42 ps=1.42 nrd=0.69047619047619  nrs=0.69047619047619 sa=0 sb=0 sd=0 mult=1 m=1
csn_op1_1000_s1_w1_0 sn_op1_1000_s1_w1_0 0 {C_SN}
XMWR_op1_1000_s1_w1_1 sn_op1_1000_s1_w1_1 wwl_des wbl_op1_1000_s1_w1 0 sky130_fd_pr__nfet_01v8 L=0.15 W=0.42 nf=1 ad=0.1218 as=0.1218 pd=1.42 ps=1.42 nrd=0.69047619047619  nrs=0.69047619047619 sa=0 sb=0 sd=0 mult=1 m=1
XMRD_op1_1000_s1_w1_1 rbl_op1_1000_s1_w1 sn_op1_1000_s1_w1_1 rwl_des 0 sky130_fd_pr__nfet_01v8 L=0.15 W=0.42 nf=1 ad=0.1218 as=0.1218 pd=1.42 ps=1.42 nrd=0.69047619047619  nrs=0.69047619047619 sa=0 sb=0 sd=0 mult=1 m=1
csn_op1_1000_s1_w1_1 sn_op1_1000_s1_w1_1 0 {C_SN}
XMWR_op1_1000_s1_w1_2 sn_op1_1000_s1_w1_2 wwl_des wbl_op1_1000_s1_w1 0 sky130_fd_pr__nfet_01v8 L=0.15 W=0.42 nf=1 ad=0.1218 as=0.1218 pd=1.42 ps=1.42 nrd=0.69047619047619  nrs=0.69047619047619 sa=0 sb=0 sd=0 mult=1 m=1
XMRD_op1_1000_s1_w1_2 rbl_op1_1000_s1_w1 sn_op1_1000_s1_w1_2 rwl_des 0 sky130_fd_pr__nfet_01v8 L=0.15 W=0.42 nf=1 ad=0.1218 as=0.1218 pd=1.42 ps=1.42 nrd=0.69047619047619  nrs=0.69047619047619 sa=0 sb=0 sd=0 mult=1 m=1
csn_op1_1000_s1_w1_2 sn_op1_1000_s1_w1_2 0 {C_SN}
XMWR_op1_1000_s1_w1_3 sn_op1_1000_s1_w1_3 wwl_des wbl_op1_1000_s1_w1 0 sky130_fd_pr__nfet_01v8 L=0.15 W=0.42 nf=1 ad=0.1218 as=0.1218 pd=1.42 ps=1.42 nrd=0.69047619047619  nrs=0.69047619047619 sa=0 sb=0 sd=0 mult=1 m=1
XMRD_op1_1000_s1_w1_3 rbl_op1_1000_s1_w1 sn_op1_1000_s1_w1_3 rwl_des 0 sky130_fd_pr__nfet_01v8 L=0.15 W=0.42 nf=1 ad=0.1218 as=0.1218 pd=1.42 ps=1.42 nrd=0.69047619047619  nrs=0.69047619047619 sa=0 sb=0 sd=0 mult=1 m=1
csn_op1_1000_s1_w1_3 sn_op1_1000_s1_w1_3 0 {C_SN}
XMN1_op1_1000_s1_w1 rbl_op1_1000_s1_w1 ref_op1_1000_s1_w1 vn_op1_1000_s1_w1 0 sky130_fd_pr__nfet_01v8 L=0.15 W=1 nf=1 ad=0.29 as=0.29 pd=2.58 ps=2.58 mult=1 m=1
XMN2_op1_1000_s1_w1 ref_op1_1000_s1_w1 rbl_op1_1000_s1_w1 vn_op1_1000_s1_w1 0 sky130_fd_pr__nfet_01v8 L=0.15 W=1 nf=1 ad=0.29 as=0.29 pd=2.58 ps=2.58 mult=1 m=1
XMP1_op1_1000_s1_w1 rbl_op1_1000_s1_w1 ref_op1_1000_s1_w1 vp_op1_1000_s1_w1 vdd sky130_fd_pr__pfet_01v8 L=0.15 W=2 nf=1 ad=0.58 as=0.58 pd=4.58 ps=4.58 mult=1 m=1
XMP2_op1_1000_s1_w1 ref_op1_1000_s1_w1 rbl_op1_1000_s1_w1 vp_op1_1000_s1_w1 vdd sky130_fd_pr__pfet_01v8 L=0.15 W=2 nf=1 ad=0.58 as=0.58 pd=4.58 ps=4.58 mult=1 m=1
XMNF_op1_1000_s1_w1 vn_op1_1000_s1_w1 en_op1_1000_s1_w1 0 0 sky130_fd_pr__nfet_01v8 L=0.15 W=2 nf=1 ad=0.58 as=0.58 pd=4.58 ps=4.58 mult=1 m=1
XMPH_op1_1000_s1_w1 vp_op1_1000_s1_w1 enb_op1_1000_s1_w1 vdd vdd sky130_fd_pr__pfet_01v8 L=0.15 W=4 nf=1 ad=1.16 as=1.16 pd=8.58 ps=8.58 mult=1 m=1
bd_op1_1000_s1_w1 d_op1_1000_s1_w1 0 v=v(rbl_op1_1000_s1_w1)-v(ref_op1_1000_s1_w1)

* ---- instance 75: op1_1000_s1_w2 (t_en 5 ns, WWL 6..8 ns, release 10 ns) ----
ven_op1_1000_s1_w2  en_op1_1000_s1_w2  0 pwl(0 0 5.0000e-09 0 5.1000e-09 {VDD} 1.0000e-08 {VDD} 1.0100e-08 0)
venb_op1_1000_s1_w2 enb_op1_1000_s1_w2 0 pwl(0 {VDD} 5.0000e-09 {VDD} 5.1000e-09 0 1.0000e-08 0 1.0100e-08 {VDD})
vrs_op1_1000_s1_w2  rwls_op1_1000_s1_w2 0 pwl(0 {VDD} {T_READ} {VDD} {T_READ+TEDGE} 0 1.0000e-08 0 1.0100e-08 {VDD})
vww_op1_1000_s1_w2  wwl_op1_1000_s1_w2 0 pwl(0 0 6.0000e-09 0 6.1000e-09 {VDD} 8.0000e-09 {VDD} 8.1000e-09 0)
vwc_op1_1000_s1_w2  wbc_op1_1000_s1_w2 0 pwl(0 0 6.0000e-09 0 6.1000e-09 {VDD} 1.0000e-08 {VDD} 1.0100e-08 0)
swb_op1_1000_s1_w2 ref_op1_1000_s1_w2 wbl_op1_1000_s1_w2 wbc_op1_1000_s1_w2 0 swwbl
cwbl_op1_1000_s1_w2 wbl_op1_1000_s1_w2 0 {C_WBL}
spa_op1_1000_s1_w2 prea rbl_op1_1000_s1_w2 ctl 0 swpre
spr_op1_1000_s1_w2 pref ref_op1_1000_s1_w2 ctl 0 swpre
crbl_op1_1000_s1_w2 rbl_op1_1000_s1_w2 0 {C_RBL}
cref_op1_1000_s1_w2 ref_op1_1000_s1_w2 0 {C_RBL}   $ ASSUMPTION: ideal matched dummy load
XMWR_op1_1000_s1_w2_0 sn_op1_1000_s1_w2_0 wwl_op1_1000_s1_w2 wbl_op1_1000_s1_w2 0 sky130_fd_pr__nfet_01v8 L=0.15 W=0.42 nf=1 ad=0.1218 as=0.1218 pd=1.42 ps=1.42 nrd=0.69047619047619  nrs=0.69047619047619 sa=0 sb=0 sd=0 mult=1 m=1
XMRD_op1_1000_s1_w2_0 rbl_op1_1000_s1_w2 sn_op1_1000_s1_w2_0 rwls_op1_1000_s1_w2 0 sky130_fd_pr__nfet_01v8 L=0.15 W=0.42 nf=1 ad=0.1218 as=0.1218 pd=1.42 ps=1.42 nrd=0.69047619047619  nrs=0.69047619047619 sa=0 sb=0 sd=0 mult=1 m=1
csn_op1_1000_s1_w2_0 sn_op1_1000_s1_w2_0 0 {C_SN}
XMWR_op1_1000_s1_w2_1 sn_op1_1000_s1_w2_1 wwl_des wbl_op1_1000_s1_w2 0 sky130_fd_pr__nfet_01v8 L=0.15 W=0.42 nf=1 ad=0.1218 as=0.1218 pd=1.42 ps=1.42 nrd=0.69047619047619  nrs=0.69047619047619 sa=0 sb=0 sd=0 mult=1 m=1
XMRD_op1_1000_s1_w2_1 rbl_op1_1000_s1_w2 sn_op1_1000_s1_w2_1 rwl_des 0 sky130_fd_pr__nfet_01v8 L=0.15 W=0.42 nf=1 ad=0.1218 as=0.1218 pd=1.42 ps=1.42 nrd=0.69047619047619  nrs=0.69047619047619 sa=0 sb=0 sd=0 mult=1 m=1
csn_op1_1000_s1_w2_1 sn_op1_1000_s1_w2_1 0 {C_SN}
XMWR_op1_1000_s1_w2_2 sn_op1_1000_s1_w2_2 wwl_des wbl_op1_1000_s1_w2 0 sky130_fd_pr__nfet_01v8 L=0.15 W=0.42 nf=1 ad=0.1218 as=0.1218 pd=1.42 ps=1.42 nrd=0.69047619047619  nrs=0.69047619047619 sa=0 sb=0 sd=0 mult=1 m=1
XMRD_op1_1000_s1_w2_2 rbl_op1_1000_s1_w2 sn_op1_1000_s1_w2_2 rwl_des 0 sky130_fd_pr__nfet_01v8 L=0.15 W=0.42 nf=1 ad=0.1218 as=0.1218 pd=1.42 ps=1.42 nrd=0.69047619047619  nrs=0.69047619047619 sa=0 sb=0 sd=0 mult=1 m=1
csn_op1_1000_s1_w2_2 sn_op1_1000_s1_w2_2 0 {C_SN}
XMWR_op1_1000_s1_w2_3 sn_op1_1000_s1_w2_3 wwl_des wbl_op1_1000_s1_w2 0 sky130_fd_pr__nfet_01v8 L=0.15 W=0.42 nf=1 ad=0.1218 as=0.1218 pd=1.42 ps=1.42 nrd=0.69047619047619  nrs=0.69047619047619 sa=0 sb=0 sd=0 mult=1 m=1
XMRD_op1_1000_s1_w2_3 rbl_op1_1000_s1_w2 sn_op1_1000_s1_w2_3 rwl_des 0 sky130_fd_pr__nfet_01v8 L=0.15 W=0.42 nf=1 ad=0.1218 as=0.1218 pd=1.42 ps=1.42 nrd=0.69047619047619  nrs=0.69047619047619 sa=0 sb=0 sd=0 mult=1 m=1
csn_op1_1000_s1_w2_3 sn_op1_1000_s1_w2_3 0 {C_SN}
XMN1_op1_1000_s1_w2 rbl_op1_1000_s1_w2 ref_op1_1000_s1_w2 vn_op1_1000_s1_w2 0 sky130_fd_pr__nfet_01v8 L=0.15 W=1 nf=1 ad=0.29 as=0.29 pd=2.58 ps=2.58 mult=1 m=1
XMN2_op1_1000_s1_w2 ref_op1_1000_s1_w2 rbl_op1_1000_s1_w2 vn_op1_1000_s1_w2 0 sky130_fd_pr__nfet_01v8 L=0.15 W=1 nf=1 ad=0.29 as=0.29 pd=2.58 ps=2.58 mult=1 m=1
XMP1_op1_1000_s1_w2 rbl_op1_1000_s1_w2 ref_op1_1000_s1_w2 vp_op1_1000_s1_w2 vdd sky130_fd_pr__pfet_01v8 L=0.15 W=2 nf=1 ad=0.58 as=0.58 pd=4.58 ps=4.58 mult=1 m=1
XMP2_op1_1000_s1_w2 ref_op1_1000_s1_w2 rbl_op1_1000_s1_w2 vp_op1_1000_s1_w2 vdd sky130_fd_pr__pfet_01v8 L=0.15 W=2 nf=1 ad=0.58 as=0.58 pd=4.58 ps=4.58 mult=1 m=1
XMNF_op1_1000_s1_w2 vn_op1_1000_s1_w2 en_op1_1000_s1_w2 0 0 sky130_fd_pr__nfet_01v8 L=0.15 W=2 nf=1 ad=0.58 as=0.58 pd=4.58 ps=4.58 mult=1 m=1
XMPH_op1_1000_s1_w2 vp_op1_1000_s1_w2 enb_op1_1000_s1_w2 vdd vdd sky130_fd_pr__pfet_01v8 L=0.15 W=4 nf=1 ad=1.16 as=1.16 pd=8.58 ps=8.58 mult=1 m=1
bd_op1_1000_s1_w2 d_op1_1000_s1_w2 0 v=v(rbl_op1_1000_s1_w2)-v(ref_op1_1000_s1_w2)

* ---- instance 76: op1_1000_s1_w3 (t_en 5 ns, WWL 6..9 ns, release 11 ns) ----
ven_op1_1000_s1_w3  en_op1_1000_s1_w3  0 pwl(0 0 5.0000e-09 0 5.1000e-09 {VDD} 1.1000e-08 {VDD} 1.1100e-08 0)
venb_op1_1000_s1_w3 enb_op1_1000_s1_w3 0 pwl(0 {VDD} 5.0000e-09 {VDD} 5.1000e-09 0 1.1000e-08 0 1.1100e-08 {VDD})
vrs_op1_1000_s1_w3  rwls_op1_1000_s1_w3 0 pwl(0 {VDD} {T_READ} {VDD} {T_READ+TEDGE} 0 1.1000e-08 0 1.1100e-08 {VDD})
vww_op1_1000_s1_w3  wwl_op1_1000_s1_w3 0 pwl(0 0 6.0000e-09 0 6.1000e-09 {VDD} 9.0000e-09 {VDD} 9.1000e-09 0)
vwc_op1_1000_s1_w3  wbc_op1_1000_s1_w3 0 pwl(0 0 6.0000e-09 0 6.1000e-09 {VDD} 1.1000e-08 {VDD} 1.1100e-08 0)
swb_op1_1000_s1_w3 ref_op1_1000_s1_w3 wbl_op1_1000_s1_w3 wbc_op1_1000_s1_w3 0 swwbl
cwbl_op1_1000_s1_w3 wbl_op1_1000_s1_w3 0 {C_WBL}
spa_op1_1000_s1_w3 prea rbl_op1_1000_s1_w3 ctl 0 swpre
spr_op1_1000_s1_w3 pref ref_op1_1000_s1_w3 ctl 0 swpre
crbl_op1_1000_s1_w3 rbl_op1_1000_s1_w3 0 {C_RBL}
cref_op1_1000_s1_w3 ref_op1_1000_s1_w3 0 {C_RBL}   $ ASSUMPTION: ideal matched dummy load
XMWR_op1_1000_s1_w3_0 sn_op1_1000_s1_w3_0 wwl_op1_1000_s1_w3 wbl_op1_1000_s1_w3 0 sky130_fd_pr__nfet_01v8 L=0.15 W=0.42 nf=1 ad=0.1218 as=0.1218 pd=1.42 ps=1.42 nrd=0.69047619047619  nrs=0.69047619047619 sa=0 sb=0 sd=0 mult=1 m=1
XMRD_op1_1000_s1_w3_0 rbl_op1_1000_s1_w3 sn_op1_1000_s1_w3_0 rwls_op1_1000_s1_w3 0 sky130_fd_pr__nfet_01v8 L=0.15 W=0.42 nf=1 ad=0.1218 as=0.1218 pd=1.42 ps=1.42 nrd=0.69047619047619  nrs=0.69047619047619 sa=0 sb=0 sd=0 mult=1 m=1
csn_op1_1000_s1_w3_0 sn_op1_1000_s1_w3_0 0 {C_SN}
XMWR_op1_1000_s1_w3_1 sn_op1_1000_s1_w3_1 wwl_des wbl_op1_1000_s1_w3 0 sky130_fd_pr__nfet_01v8 L=0.15 W=0.42 nf=1 ad=0.1218 as=0.1218 pd=1.42 ps=1.42 nrd=0.69047619047619  nrs=0.69047619047619 sa=0 sb=0 sd=0 mult=1 m=1
XMRD_op1_1000_s1_w3_1 rbl_op1_1000_s1_w3 sn_op1_1000_s1_w3_1 rwl_des 0 sky130_fd_pr__nfet_01v8 L=0.15 W=0.42 nf=1 ad=0.1218 as=0.1218 pd=1.42 ps=1.42 nrd=0.69047619047619  nrs=0.69047619047619 sa=0 sb=0 sd=0 mult=1 m=1
csn_op1_1000_s1_w3_1 sn_op1_1000_s1_w3_1 0 {C_SN}
XMWR_op1_1000_s1_w3_2 sn_op1_1000_s1_w3_2 wwl_des wbl_op1_1000_s1_w3 0 sky130_fd_pr__nfet_01v8 L=0.15 W=0.42 nf=1 ad=0.1218 as=0.1218 pd=1.42 ps=1.42 nrd=0.69047619047619  nrs=0.69047619047619 sa=0 sb=0 sd=0 mult=1 m=1
XMRD_op1_1000_s1_w3_2 rbl_op1_1000_s1_w3 sn_op1_1000_s1_w3_2 rwl_des 0 sky130_fd_pr__nfet_01v8 L=0.15 W=0.42 nf=1 ad=0.1218 as=0.1218 pd=1.42 ps=1.42 nrd=0.69047619047619  nrs=0.69047619047619 sa=0 sb=0 sd=0 mult=1 m=1
csn_op1_1000_s1_w3_2 sn_op1_1000_s1_w3_2 0 {C_SN}
XMWR_op1_1000_s1_w3_3 sn_op1_1000_s1_w3_3 wwl_des wbl_op1_1000_s1_w3 0 sky130_fd_pr__nfet_01v8 L=0.15 W=0.42 nf=1 ad=0.1218 as=0.1218 pd=1.42 ps=1.42 nrd=0.69047619047619  nrs=0.69047619047619 sa=0 sb=0 sd=0 mult=1 m=1
XMRD_op1_1000_s1_w3_3 rbl_op1_1000_s1_w3 sn_op1_1000_s1_w3_3 rwl_des 0 sky130_fd_pr__nfet_01v8 L=0.15 W=0.42 nf=1 ad=0.1218 as=0.1218 pd=1.42 ps=1.42 nrd=0.69047619047619  nrs=0.69047619047619 sa=0 sb=0 sd=0 mult=1 m=1
csn_op1_1000_s1_w3_3 sn_op1_1000_s1_w3_3 0 {C_SN}
XMN1_op1_1000_s1_w3 rbl_op1_1000_s1_w3 ref_op1_1000_s1_w3 vn_op1_1000_s1_w3 0 sky130_fd_pr__nfet_01v8 L=0.15 W=1 nf=1 ad=0.29 as=0.29 pd=2.58 ps=2.58 mult=1 m=1
XMN2_op1_1000_s1_w3 ref_op1_1000_s1_w3 rbl_op1_1000_s1_w3 vn_op1_1000_s1_w3 0 sky130_fd_pr__nfet_01v8 L=0.15 W=1 nf=1 ad=0.29 as=0.29 pd=2.58 ps=2.58 mult=1 m=1
XMP1_op1_1000_s1_w3 rbl_op1_1000_s1_w3 ref_op1_1000_s1_w3 vp_op1_1000_s1_w3 vdd sky130_fd_pr__pfet_01v8 L=0.15 W=2 nf=1 ad=0.58 as=0.58 pd=4.58 ps=4.58 mult=1 m=1
XMP2_op1_1000_s1_w3 ref_op1_1000_s1_w3 rbl_op1_1000_s1_w3 vp_op1_1000_s1_w3 vdd sky130_fd_pr__pfet_01v8 L=0.15 W=2 nf=1 ad=0.58 as=0.58 pd=4.58 ps=4.58 mult=1 m=1
XMNF_op1_1000_s1_w3 vn_op1_1000_s1_w3 en_op1_1000_s1_w3 0 0 sky130_fd_pr__nfet_01v8 L=0.15 W=2 nf=1 ad=0.58 as=0.58 pd=4.58 ps=4.58 mult=1 m=1
XMPH_op1_1000_s1_w3 vp_op1_1000_s1_w3 enb_op1_1000_s1_w3 vdd vdd sky130_fd_pr__pfet_01v8 L=0.15 W=4 nf=1 ad=1.16 as=1.16 pd=8.58 ps=8.58 mult=1 m=1
bd_op1_1000_s1_w3 d_op1_1000_s1_w3 0 v=v(rbl_op1_1000_s1_w3)-v(ref_op1_1000_s1_w3)

* ---- instance 77: op1_1000_s1_w5 (t_en 5 ns, WWL 6..11 ns, release 13 ns) ----
ven_op1_1000_s1_w5  en_op1_1000_s1_w5  0 pwl(0 0 5.0000e-09 0 5.1000e-09 {VDD} 1.3000e-08 {VDD} 1.3100e-08 0)
venb_op1_1000_s1_w5 enb_op1_1000_s1_w5 0 pwl(0 {VDD} 5.0000e-09 {VDD} 5.1000e-09 0 1.3000e-08 0 1.3100e-08 {VDD})
vrs_op1_1000_s1_w5  rwls_op1_1000_s1_w5 0 pwl(0 {VDD} {T_READ} {VDD} {T_READ+TEDGE} 0 1.3000e-08 0 1.3100e-08 {VDD})
vww_op1_1000_s1_w5  wwl_op1_1000_s1_w5 0 pwl(0 0 6.0000e-09 0 6.1000e-09 {VDD} 1.1000e-08 {VDD} 1.1100e-08 0)
vwc_op1_1000_s1_w5  wbc_op1_1000_s1_w5 0 pwl(0 0 6.0000e-09 0 6.1000e-09 {VDD} 1.3000e-08 {VDD} 1.3100e-08 0)
swb_op1_1000_s1_w5 ref_op1_1000_s1_w5 wbl_op1_1000_s1_w5 wbc_op1_1000_s1_w5 0 swwbl
cwbl_op1_1000_s1_w5 wbl_op1_1000_s1_w5 0 {C_WBL}
spa_op1_1000_s1_w5 prea rbl_op1_1000_s1_w5 ctl 0 swpre
spr_op1_1000_s1_w5 pref ref_op1_1000_s1_w5 ctl 0 swpre
crbl_op1_1000_s1_w5 rbl_op1_1000_s1_w5 0 {C_RBL}
cref_op1_1000_s1_w5 ref_op1_1000_s1_w5 0 {C_RBL}   $ ASSUMPTION: ideal matched dummy load
XMWR_op1_1000_s1_w5_0 sn_op1_1000_s1_w5_0 wwl_op1_1000_s1_w5 wbl_op1_1000_s1_w5 0 sky130_fd_pr__nfet_01v8 L=0.15 W=0.42 nf=1 ad=0.1218 as=0.1218 pd=1.42 ps=1.42 nrd=0.69047619047619  nrs=0.69047619047619 sa=0 sb=0 sd=0 mult=1 m=1
XMRD_op1_1000_s1_w5_0 rbl_op1_1000_s1_w5 sn_op1_1000_s1_w5_0 rwls_op1_1000_s1_w5 0 sky130_fd_pr__nfet_01v8 L=0.15 W=0.42 nf=1 ad=0.1218 as=0.1218 pd=1.42 ps=1.42 nrd=0.69047619047619  nrs=0.69047619047619 sa=0 sb=0 sd=0 mult=1 m=1
csn_op1_1000_s1_w5_0 sn_op1_1000_s1_w5_0 0 {C_SN}
XMWR_op1_1000_s1_w5_1 sn_op1_1000_s1_w5_1 wwl_des wbl_op1_1000_s1_w5 0 sky130_fd_pr__nfet_01v8 L=0.15 W=0.42 nf=1 ad=0.1218 as=0.1218 pd=1.42 ps=1.42 nrd=0.69047619047619  nrs=0.69047619047619 sa=0 sb=0 sd=0 mult=1 m=1
XMRD_op1_1000_s1_w5_1 rbl_op1_1000_s1_w5 sn_op1_1000_s1_w5_1 rwl_des 0 sky130_fd_pr__nfet_01v8 L=0.15 W=0.42 nf=1 ad=0.1218 as=0.1218 pd=1.42 ps=1.42 nrd=0.69047619047619  nrs=0.69047619047619 sa=0 sb=0 sd=0 mult=1 m=1
csn_op1_1000_s1_w5_1 sn_op1_1000_s1_w5_1 0 {C_SN}
XMWR_op1_1000_s1_w5_2 sn_op1_1000_s1_w5_2 wwl_des wbl_op1_1000_s1_w5 0 sky130_fd_pr__nfet_01v8 L=0.15 W=0.42 nf=1 ad=0.1218 as=0.1218 pd=1.42 ps=1.42 nrd=0.69047619047619  nrs=0.69047619047619 sa=0 sb=0 sd=0 mult=1 m=1
XMRD_op1_1000_s1_w5_2 rbl_op1_1000_s1_w5 sn_op1_1000_s1_w5_2 rwl_des 0 sky130_fd_pr__nfet_01v8 L=0.15 W=0.42 nf=1 ad=0.1218 as=0.1218 pd=1.42 ps=1.42 nrd=0.69047619047619  nrs=0.69047619047619 sa=0 sb=0 sd=0 mult=1 m=1
csn_op1_1000_s1_w5_2 sn_op1_1000_s1_w5_2 0 {C_SN}
XMWR_op1_1000_s1_w5_3 sn_op1_1000_s1_w5_3 wwl_des wbl_op1_1000_s1_w5 0 sky130_fd_pr__nfet_01v8 L=0.15 W=0.42 nf=1 ad=0.1218 as=0.1218 pd=1.42 ps=1.42 nrd=0.69047619047619  nrs=0.69047619047619 sa=0 sb=0 sd=0 mult=1 m=1
XMRD_op1_1000_s1_w5_3 rbl_op1_1000_s1_w5 sn_op1_1000_s1_w5_3 rwl_des 0 sky130_fd_pr__nfet_01v8 L=0.15 W=0.42 nf=1 ad=0.1218 as=0.1218 pd=1.42 ps=1.42 nrd=0.69047619047619  nrs=0.69047619047619 sa=0 sb=0 sd=0 mult=1 m=1
csn_op1_1000_s1_w5_3 sn_op1_1000_s1_w5_3 0 {C_SN}
XMN1_op1_1000_s1_w5 rbl_op1_1000_s1_w5 ref_op1_1000_s1_w5 vn_op1_1000_s1_w5 0 sky130_fd_pr__nfet_01v8 L=0.15 W=1 nf=1 ad=0.29 as=0.29 pd=2.58 ps=2.58 mult=1 m=1
XMN2_op1_1000_s1_w5 ref_op1_1000_s1_w5 rbl_op1_1000_s1_w5 vn_op1_1000_s1_w5 0 sky130_fd_pr__nfet_01v8 L=0.15 W=1 nf=1 ad=0.29 as=0.29 pd=2.58 ps=2.58 mult=1 m=1
XMP1_op1_1000_s1_w5 rbl_op1_1000_s1_w5 ref_op1_1000_s1_w5 vp_op1_1000_s1_w5 vdd sky130_fd_pr__pfet_01v8 L=0.15 W=2 nf=1 ad=0.58 as=0.58 pd=4.58 ps=4.58 mult=1 m=1
XMP2_op1_1000_s1_w5 ref_op1_1000_s1_w5 rbl_op1_1000_s1_w5 vp_op1_1000_s1_w5 vdd sky130_fd_pr__pfet_01v8 L=0.15 W=2 nf=1 ad=0.58 as=0.58 pd=4.58 ps=4.58 mult=1 m=1
XMNF_op1_1000_s1_w5 vn_op1_1000_s1_w5 en_op1_1000_s1_w5 0 0 sky130_fd_pr__nfet_01v8 L=0.15 W=2 nf=1 ad=0.58 as=0.58 pd=4.58 ps=4.58 mult=1 m=1
XMPH_op1_1000_s1_w5 vp_op1_1000_s1_w5 enb_op1_1000_s1_w5 vdd vdd sky130_fd_pr__pfet_01v8 L=0.15 W=4 nf=1 ad=1.16 as=1.16 pd=8.58 ps=8.58 mult=1 m=1
bd_op1_1000_s1_w5 d_op1_1000_s1_w5 0 v=v(rbl_op1_1000_s1_w5)-v(ref_op1_1000_s1_w5)

* ---- instance 78: op1_1000_s1_w7p5 (t_en 5 ns, WWL 6..13.5 ns, release 15.5 ns) ----
ven_op1_1000_s1_w7p5  en_op1_1000_s1_w7p5  0 pwl(0 0 5.0000e-09 0 5.1000e-09 {VDD} 1.5500e-08 {VDD} 1.5600e-08 0)
venb_op1_1000_s1_w7p5 enb_op1_1000_s1_w7p5 0 pwl(0 {VDD} 5.0000e-09 {VDD} 5.1000e-09 0 1.5500e-08 0 1.5600e-08 {VDD})
vrs_op1_1000_s1_w7p5  rwls_op1_1000_s1_w7p5 0 pwl(0 {VDD} {T_READ} {VDD} {T_READ+TEDGE} 0 1.5500e-08 0 1.5600e-08 {VDD})
vww_op1_1000_s1_w7p5  wwl_op1_1000_s1_w7p5 0 pwl(0 0 6.0000e-09 0 6.1000e-09 {VDD} 1.3500e-08 {VDD} 1.3600e-08 0)
vwc_op1_1000_s1_w7p5  wbc_op1_1000_s1_w7p5 0 pwl(0 0 6.0000e-09 0 6.1000e-09 {VDD} 1.5500e-08 {VDD} 1.5600e-08 0)
swb_op1_1000_s1_w7p5 ref_op1_1000_s1_w7p5 wbl_op1_1000_s1_w7p5 wbc_op1_1000_s1_w7p5 0 swwbl
cwbl_op1_1000_s1_w7p5 wbl_op1_1000_s1_w7p5 0 {C_WBL}
spa_op1_1000_s1_w7p5 prea rbl_op1_1000_s1_w7p5 ctl 0 swpre
spr_op1_1000_s1_w7p5 pref ref_op1_1000_s1_w7p5 ctl 0 swpre
crbl_op1_1000_s1_w7p5 rbl_op1_1000_s1_w7p5 0 {C_RBL}
cref_op1_1000_s1_w7p5 ref_op1_1000_s1_w7p5 0 {C_RBL}   $ ASSUMPTION: ideal matched dummy load
XMWR_op1_1000_s1_w7p5_0 sn_op1_1000_s1_w7p5_0 wwl_op1_1000_s1_w7p5 wbl_op1_1000_s1_w7p5 0 sky130_fd_pr__nfet_01v8 L=0.15 W=0.42 nf=1 ad=0.1218 as=0.1218 pd=1.42 ps=1.42 nrd=0.69047619047619  nrs=0.69047619047619 sa=0 sb=0 sd=0 mult=1 m=1
XMRD_op1_1000_s1_w7p5_0 rbl_op1_1000_s1_w7p5 sn_op1_1000_s1_w7p5_0 rwls_op1_1000_s1_w7p5 0 sky130_fd_pr__nfet_01v8 L=0.15 W=0.42 nf=1 ad=0.1218 as=0.1218 pd=1.42 ps=1.42 nrd=0.69047619047619  nrs=0.69047619047619 sa=0 sb=0 sd=0 mult=1 m=1
csn_op1_1000_s1_w7p5_0 sn_op1_1000_s1_w7p5_0 0 {C_SN}
XMWR_op1_1000_s1_w7p5_1 sn_op1_1000_s1_w7p5_1 wwl_des wbl_op1_1000_s1_w7p5 0 sky130_fd_pr__nfet_01v8 L=0.15 W=0.42 nf=1 ad=0.1218 as=0.1218 pd=1.42 ps=1.42 nrd=0.69047619047619  nrs=0.69047619047619 sa=0 sb=0 sd=0 mult=1 m=1
XMRD_op1_1000_s1_w7p5_1 rbl_op1_1000_s1_w7p5 sn_op1_1000_s1_w7p5_1 rwl_des 0 sky130_fd_pr__nfet_01v8 L=0.15 W=0.42 nf=1 ad=0.1218 as=0.1218 pd=1.42 ps=1.42 nrd=0.69047619047619  nrs=0.69047619047619 sa=0 sb=0 sd=0 mult=1 m=1
csn_op1_1000_s1_w7p5_1 sn_op1_1000_s1_w7p5_1 0 {C_SN}
XMWR_op1_1000_s1_w7p5_2 sn_op1_1000_s1_w7p5_2 wwl_des wbl_op1_1000_s1_w7p5 0 sky130_fd_pr__nfet_01v8 L=0.15 W=0.42 nf=1 ad=0.1218 as=0.1218 pd=1.42 ps=1.42 nrd=0.69047619047619  nrs=0.69047619047619 sa=0 sb=0 sd=0 mult=1 m=1
XMRD_op1_1000_s1_w7p5_2 rbl_op1_1000_s1_w7p5 sn_op1_1000_s1_w7p5_2 rwl_des 0 sky130_fd_pr__nfet_01v8 L=0.15 W=0.42 nf=1 ad=0.1218 as=0.1218 pd=1.42 ps=1.42 nrd=0.69047619047619  nrs=0.69047619047619 sa=0 sb=0 sd=0 mult=1 m=1
csn_op1_1000_s1_w7p5_2 sn_op1_1000_s1_w7p5_2 0 {C_SN}
XMWR_op1_1000_s1_w7p5_3 sn_op1_1000_s1_w7p5_3 wwl_des wbl_op1_1000_s1_w7p5 0 sky130_fd_pr__nfet_01v8 L=0.15 W=0.42 nf=1 ad=0.1218 as=0.1218 pd=1.42 ps=1.42 nrd=0.69047619047619  nrs=0.69047619047619 sa=0 sb=0 sd=0 mult=1 m=1
XMRD_op1_1000_s1_w7p5_3 rbl_op1_1000_s1_w7p5 sn_op1_1000_s1_w7p5_3 rwl_des 0 sky130_fd_pr__nfet_01v8 L=0.15 W=0.42 nf=1 ad=0.1218 as=0.1218 pd=1.42 ps=1.42 nrd=0.69047619047619  nrs=0.69047619047619 sa=0 sb=0 sd=0 mult=1 m=1
csn_op1_1000_s1_w7p5_3 sn_op1_1000_s1_w7p5_3 0 {C_SN}
XMN1_op1_1000_s1_w7p5 rbl_op1_1000_s1_w7p5 ref_op1_1000_s1_w7p5 vn_op1_1000_s1_w7p5 0 sky130_fd_pr__nfet_01v8 L=0.15 W=1 nf=1 ad=0.29 as=0.29 pd=2.58 ps=2.58 mult=1 m=1
XMN2_op1_1000_s1_w7p5 ref_op1_1000_s1_w7p5 rbl_op1_1000_s1_w7p5 vn_op1_1000_s1_w7p5 0 sky130_fd_pr__nfet_01v8 L=0.15 W=1 nf=1 ad=0.29 as=0.29 pd=2.58 ps=2.58 mult=1 m=1
XMP1_op1_1000_s1_w7p5 rbl_op1_1000_s1_w7p5 ref_op1_1000_s1_w7p5 vp_op1_1000_s1_w7p5 vdd sky130_fd_pr__pfet_01v8 L=0.15 W=2 nf=1 ad=0.58 as=0.58 pd=4.58 ps=4.58 mult=1 m=1
XMP2_op1_1000_s1_w7p5 ref_op1_1000_s1_w7p5 rbl_op1_1000_s1_w7p5 vp_op1_1000_s1_w7p5 vdd sky130_fd_pr__pfet_01v8 L=0.15 W=2 nf=1 ad=0.58 as=0.58 pd=4.58 ps=4.58 mult=1 m=1
XMNF_op1_1000_s1_w7p5 vn_op1_1000_s1_w7p5 en_op1_1000_s1_w7p5 0 0 sky130_fd_pr__nfet_01v8 L=0.15 W=2 nf=1 ad=0.58 as=0.58 pd=4.58 ps=4.58 mult=1 m=1
XMPH_op1_1000_s1_w7p5 vp_op1_1000_s1_w7p5 enb_op1_1000_s1_w7p5 vdd vdd sky130_fd_pr__pfet_01v8 L=0.15 W=4 nf=1 ad=1.16 as=1.16 pd=8.58 ps=8.58 mult=1 m=1
bd_op1_1000_s1_w7p5 d_op1_1000_s1_w7p5 0 v=v(rbl_op1_1000_s1_w7p5)-v(ref_op1_1000_s1_w7p5)

* ---- instance 79: op1_1000_s1_w10 (t_en 5 ns, WWL 6..16 ns, release 18 ns) ----
ven_op1_1000_s1_w10  en_op1_1000_s1_w10  0 pwl(0 0 5.0000e-09 0 5.1000e-09 {VDD} 1.8000e-08 {VDD} 1.8100e-08 0)
venb_op1_1000_s1_w10 enb_op1_1000_s1_w10 0 pwl(0 {VDD} 5.0000e-09 {VDD} 5.1000e-09 0 1.8000e-08 0 1.8100e-08 {VDD})
vrs_op1_1000_s1_w10  rwls_op1_1000_s1_w10 0 pwl(0 {VDD} {T_READ} {VDD} {T_READ+TEDGE} 0 1.8000e-08 0 1.8100e-08 {VDD})
vww_op1_1000_s1_w10  wwl_op1_1000_s1_w10 0 pwl(0 0 6.0000e-09 0 6.1000e-09 {VDD} 1.6000e-08 {VDD} 1.6100e-08 0)
vwc_op1_1000_s1_w10  wbc_op1_1000_s1_w10 0 pwl(0 0 6.0000e-09 0 6.1000e-09 {VDD} 1.8000e-08 {VDD} 1.8100e-08 0)
swb_op1_1000_s1_w10 ref_op1_1000_s1_w10 wbl_op1_1000_s1_w10 wbc_op1_1000_s1_w10 0 swwbl
cwbl_op1_1000_s1_w10 wbl_op1_1000_s1_w10 0 {C_WBL}
spa_op1_1000_s1_w10 prea rbl_op1_1000_s1_w10 ctl 0 swpre
spr_op1_1000_s1_w10 pref ref_op1_1000_s1_w10 ctl 0 swpre
crbl_op1_1000_s1_w10 rbl_op1_1000_s1_w10 0 {C_RBL}
cref_op1_1000_s1_w10 ref_op1_1000_s1_w10 0 {C_RBL}   $ ASSUMPTION: ideal matched dummy load
XMWR_op1_1000_s1_w10_0 sn_op1_1000_s1_w10_0 wwl_op1_1000_s1_w10 wbl_op1_1000_s1_w10 0 sky130_fd_pr__nfet_01v8 L=0.15 W=0.42 nf=1 ad=0.1218 as=0.1218 pd=1.42 ps=1.42 nrd=0.69047619047619  nrs=0.69047619047619 sa=0 sb=0 sd=0 mult=1 m=1
XMRD_op1_1000_s1_w10_0 rbl_op1_1000_s1_w10 sn_op1_1000_s1_w10_0 rwls_op1_1000_s1_w10 0 sky130_fd_pr__nfet_01v8 L=0.15 W=0.42 nf=1 ad=0.1218 as=0.1218 pd=1.42 ps=1.42 nrd=0.69047619047619  nrs=0.69047619047619 sa=0 sb=0 sd=0 mult=1 m=1
csn_op1_1000_s1_w10_0 sn_op1_1000_s1_w10_0 0 {C_SN}
XMWR_op1_1000_s1_w10_1 sn_op1_1000_s1_w10_1 wwl_des wbl_op1_1000_s1_w10 0 sky130_fd_pr__nfet_01v8 L=0.15 W=0.42 nf=1 ad=0.1218 as=0.1218 pd=1.42 ps=1.42 nrd=0.69047619047619  nrs=0.69047619047619 sa=0 sb=0 sd=0 mult=1 m=1
XMRD_op1_1000_s1_w10_1 rbl_op1_1000_s1_w10 sn_op1_1000_s1_w10_1 rwl_des 0 sky130_fd_pr__nfet_01v8 L=0.15 W=0.42 nf=1 ad=0.1218 as=0.1218 pd=1.42 ps=1.42 nrd=0.69047619047619  nrs=0.69047619047619 sa=0 sb=0 sd=0 mult=1 m=1
csn_op1_1000_s1_w10_1 sn_op1_1000_s1_w10_1 0 {C_SN}
XMWR_op1_1000_s1_w10_2 sn_op1_1000_s1_w10_2 wwl_des wbl_op1_1000_s1_w10 0 sky130_fd_pr__nfet_01v8 L=0.15 W=0.42 nf=1 ad=0.1218 as=0.1218 pd=1.42 ps=1.42 nrd=0.69047619047619  nrs=0.69047619047619 sa=0 sb=0 sd=0 mult=1 m=1
XMRD_op1_1000_s1_w10_2 rbl_op1_1000_s1_w10 sn_op1_1000_s1_w10_2 rwl_des 0 sky130_fd_pr__nfet_01v8 L=0.15 W=0.42 nf=1 ad=0.1218 as=0.1218 pd=1.42 ps=1.42 nrd=0.69047619047619  nrs=0.69047619047619 sa=0 sb=0 sd=0 mult=1 m=1
csn_op1_1000_s1_w10_2 sn_op1_1000_s1_w10_2 0 {C_SN}
XMWR_op1_1000_s1_w10_3 sn_op1_1000_s1_w10_3 wwl_des wbl_op1_1000_s1_w10 0 sky130_fd_pr__nfet_01v8 L=0.15 W=0.42 nf=1 ad=0.1218 as=0.1218 pd=1.42 ps=1.42 nrd=0.69047619047619  nrs=0.69047619047619 sa=0 sb=0 sd=0 mult=1 m=1
XMRD_op1_1000_s1_w10_3 rbl_op1_1000_s1_w10 sn_op1_1000_s1_w10_3 rwl_des 0 sky130_fd_pr__nfet_01v8 L=0.15 W=0.42 nf=1 ad=0.1218 as=0.1218 pd=1.42 ps=1.42 nrd=0.69047619047619  nrs=0.69047619047619 sa=0 sb=0 sd=0 mult=1 m=1
csn_op1_1000_s1_w10_3 sn_op1_1000_s1_w10_3 0 {C_SN}
XMN1_op1_1000_s1_w10 rbl_op1_1000_s1_w10 ref_op1_1000_s1_w10 vn_op1_1000_s1_w10 0 sky130_fd_pr__nfet_01v8 L=0.15 W=1 nf=1 ad=0.29 as=0.29 pd=2.58 ps=2.58 mult=1 m=1
XMN2_op1_1000_s1_w10 ref_op1_1000_s1_w10 rbl_op1_1000_s1_w10 vn_op1_1000_s1_w10 0 sky130_fd_pr__nfet_01v8 L=0.15 W=1 nf=1 ad=0.29 as=0.29 pd=2.58 ps=2.58 mult=1 m=1
XMP1_op1_1000_s1_w10 rbl_op1_1000_s1_w10 ref_op1_1000_s1_w10 vp_op1_1000_s1_w10 vdd sky130_fd_pr__pfet_01v8 L=0.15 W=2 nf=1 ad=0.58 as=0.58 pd=4.58 ps=4.58 mult=1 m=1
XMP2_op1_1000_s1_w10 ref_op1_1000_s1_w10 rbl_op1_1000_s1_w10 vp_op1_1000_s1_w10 vdd sky130_fd_pr__pfet_01v8 L=0.15 W=2 nf=1 ad=0.58 as=0.58 pd=4.58 ps=4.58 mult=1 m=1
XMNF_op1_1000_s1_w10 vn_op1_1000_s1_w10 en_op1_1000_s1_w10 0 0 sky130_fd_pr__nfet_01v8 L=0.15 W=2 nf=1 ad=0.58 as=0.58 pd=4.58 ps=4.58 mult=1 m=1
XMPH_op1_1000_s1_w10 vp_op1_1000_s1_w10 enb_op1_1000_s1_w10 vdd vdd sky130_fd_pr__pfet_01v8 L=0.15 W=4 nf=1 ad=1.16 as=1.16 pd=8.58 ps=8.58 mult=1 m=1
bd_op1_1000_s1_w10 d_op1_1000_s1_w10 0 v=v(rbl_op1_1000_s1_w10)-v(ref_op1_1000_s1_w10)

* ---- instance 80: op1_1000_s1_w15 (t_en 5 ns, WWL 6..21 ns, release 23 ns) ----
ven_op1_1000_s1_w15  en_op1_1000_s1_w15  0 pwl(0 0 5.0000e-09 0 5.1000e-09 {VDD} 2.3000e-08 {VDD} 2.3100e-08 0)
venb_op1_1000_s1_w15 enb_op1_1000_s1_w15 0 pwl(0 {VDD} 5.0000e-09 {VDD} 5.1000e-09 0 2.3000e-08 0 2.3100e-08 {VDD})
vrs_op1_1000_s1_w15  rwls_op1_1000_s1_w15 0 pwl(0 {VDD} {T_READ} {VDD} {T_READ+TEDGE} 0 2.3000e-08 0 2.3100e-08 {VDD})
vww_op1_1000_s1_w15  wwl_op1_1000_s1_w15 0 pwl(0 0 6.0000e-09 0 6.1000e-09 {VDD} 2.1000e-08 {VDD} 2.1100e-08 0)
vwc_op1_1000_s1_w15  wbc_op1_1000_s1_w15 0 pwl(0 0 6.0000e-09 0 6.1000e-09 {VDD} 2.3000e-08 {VDD} 2.3100e-08 0)
swb_op1_1000_s1_w15 ref_op1_1000_s1_w15 wbl_op1_1000_s1_w15 wbc_op1_1000_s1_w15 0 swwbl
cwbl_op1_1000_s1_w15 wbl_op1_1000_s1_w15 0 {C_WBL}
spa_op1_1000_s1_w15 prea rbl_op1_1000_s1_w15 ctl 0 swpre
spr_op1_1000_s1_w15 pref ref_op1_1000_s1_w15 ctl 0 swpre
crbl_op1_1000_s1_w15 rbl_op1_1000_s1_w15 0 {C_RBL}
cref_op1_1000_s1_w15 ref_op1_1000_s1_w15 0 {C_RBL}   $ ASSUMPTION: ideal matched dummy load
XMWR_op1_1000_s1_w15_0 sn_op1_1000_s1_w15_0 wwl_op1_1000_s1_w15 wbl_op1_1000_s1_w15 0 sky130_fd_pr__nfet_01v8 L=0.15 W=0.42 nf=1 ad=0.1218 as=0.1218 pd=1.42 ps=1.42 nrd=0.69047619047619  nrs=0.69047619047619 sa=0 sb=0 sd=0 mult=1 m=1
XMRD_op1_1000_s1_w15_0 rbl_op1_1000_s1_w15 sn_op1_1000_s1_w15_0 rwls_op1_1000_s1_w15 0 sky130_fd_pr__nfet_01v8 L=0.15 W=0.42 nf=1 ad=0.1218 as=0.1218 pd=1.42 ps=1.42 nrd=0.69047619047619  nrs=0.69047619047619 sa=0 sb=0 sd=0 mult=1 m=1
csn_op1_1000_s1_w15_0 sn_op1_1000_s1_w15_0 0 {C_SN}
XMWR_op1_1000_s1_w15_1 sn_op1_1000_s1_w15_1 wwl_des wbl_op1_1000_s1_w15 0 sky130_fd_pr__nfet_01v8 L=0.15 W=0.42 nf=1 ad=0.1218 as=0.1218 pd=1.42 ps=1.42 nrd=0.69047619047619  nrs=0.69047619047619 sa=0 sb=0 sd=0 mult=1 m=1
XMRD_op1_1000_s1_w15_1 rbl_op1_1000_s1_w15 sn_op1_1000_s1_w15_1 rwl_des 0 sky130_fd_pr__nfet_01v8 L=0.15 W=0.42 nf=1 ad=0.1218 as=0.1218 pd=1.42 ps=1.42 nrd=0.69047619047619  nrs=0.69047619047619 sa=0 sb=0 sd=0 mult=1 m=1
csn_op1_1000_s1_w15_1 sn_op1_1000_s1_w15_1 0 {C_SN}
XMWR_op1_1000_s1_w15_2 sn_op1_1000_s1_w15_2 wwl_des wbl_op1_1000_s1_w15 0 sky130_fd_pr__nfet_01v8 L=0.15 W=0.42 nf=1 ad=0.1218 as=0.1218 pd=1.42 ps=1.42 nrd=0.69047619047619  nrs=0.69047619047619 sa=0 sb=0 sd=0 mult=1 m=1
XMRD_op1_1000_s1_w15_2 rbl_op1_1000_s1_w15 sn_op1_1000_s1_w15_2 rwl_des 0 sky130_fd_pr__nfet_01v8 L=0.15 W=0.42 nf=1 ad=0.1218 as=0.1218 pd=1.42 ps=1.42 nrd=0.69047619047619  nrs=0.69047619047619 sa=0 sb=0 sd=0 mult=1 m=1
csn_op1_1000_s1_w15_2 sn_op1_1000_s1_w15_2 0 {C_SN}
XMWR_op1_1000_s1_w15_3 sn_op1_1000_s1_w15_3 wwl_des wbl_op1_1000_s1_w15 0 sky130_fd_pr__nfet_01v8 L=0.15 W=0.42 nf=1 ad=0.1218 as=0.1218 pd=1.42 ps=1.42 nrd=0.69047619047619  nrs=0.69047619047619 sa=0 sb=0 sd=0 mult=1 m=1
XMRD_op1_1000_s1_w15_3 rbl_op1_1000_s1_w15 sn_op1_1000_s1_w15_3 rwl_des 0 sky130_fd_pr__nfet_01v8 L=0.15 W=0.42 nf=1 ad=0.1218 as=0.1218 pd=1.42 ps=1.42 nrd=0.69047619047619  nrs=0.69047619047619 sa=0 sb=0 sd=0 mult=1 m=1
csn_op1_1000_s1_w15_3 sn_op1_1000_s1_w15_3 0 {C_SN}
XMN1_op1_1000_s1_w15 rbl_op1_1000_s1_w15 ref_op1_1000_s1_w15 vn_op1_1000_s1_w15 0 sky130_fd_pr__nfet_01v8 L=0.15 W=1 nf=1 ad=0.29 as=0.29 pd=2.58 ps=2.58 mult=1 m=1
XMN2_op1_1000_s1_w15 ref_op1_1000_s1_w15 rbl_op1_1000_s1_w15 vn_op1_1000_s1_w15 0 sky130_fd_pr__nfet_01v8 L=0.15 W=1 nf=1 ad=0.29 as=0.29 pd=2.58 ps=2.58 mult=1 m=1
XMP1_op1_1000_s1_w15 rbl_op1_1000_s1_w15 ref_op1_1000_s1_w15 vp_op1_1000_s1_w15 vdd sky130_fd_pr__pfet_01v8 L=0.15 W=2 nf=1 ad=0.58 as=0.58 pd=4.58 ps=4.58 mult=1 m=1
XMP2_op1_1000_s1_w15 ref_op1_1000_s1_w15 rbl_op1_1000_s1_w15 vp_op1_1000_s1_w15 vdd sky130_fd_pr__pfet_01v8 L=0.15 W=2 nf=1 ad=0.58 as=0.58 pd=4.58 ps=4.58 mult=1 m=1
XMNF_op1_1000_s1_w15 vn_op1_1000_s1_w15 en_op1_1000_s1_w15 0 0 sky130_fd_pr__nfet_01v8 L=0.15 W=2 nf=1 ad=0.58 as=0.58 pd=4.58 ps=4.58 mult=1 m=1
XMPH_op1_1000_s1_w15 vp_op1_1000_s1_w15 enb_op1_1000_s1_w15 vdd vdd sky130_fd_pr__pfet_01v8 L=0.15 W=4 nf=1 ad=1.16 as=1.16 pd=8.58 ps=8.58 mult=1 m=1
bd_op1_1000_s1_w15 d_op1_1000_s1_w15 0 v=v(rbl_op1_1000_s1_w15)-v(ref_op1_1000_s1_w15)

* ---- instance 81: op1_1000_s1_w20 (t_en 5 ns, WWL 6..26 ns, release 28 ns) ----
ven_op1_1000_s1_w20  en_op1_1000_s1_w20  0 pwl(0 0 5.0000e-09 0 5.1000e-09 {VDD} 2.8000e-08 {VDD} 2.8100e-08 0)
venb_op1_1000_s1_w20 enb_op1_1000_s1_w20 0 pwl(0 {VDD} 5.0000e-09 {VDD} 5.1000e-09 0 2.8000e-08 0 2.8100e-08 {VDD})
vrs_op1_1000_s1_w20  rwls_op1_1000_s1_w20 0 pwl(0 {VDD} {T_READ} {VDD} {T_READ+TEDGE} 0 2.8000e-08 0 2.8100e-08 {VDD})
vww_op1_1000_s1_w20  wwl_op1_1000_s1_w20 0 pwl(0 0 6.0000e-09 0 6.1000e-09 {VDD} 2.6000e-08 {VDD} 2.6100e-08 0)
vwc_op1_1000_s1_w20  wbc_op1_1000_s1_w20 0 pwl(0 0 6.0000e-09 0 6.1000e-09 {VDD} 2.8000e-08 {VDD} 2.8100e-08 0)
swb_op1_1000_s1_w20 ref_op1_1000_s1_w20 wbl_op1_1000_s1_w20 wbc_op1_1000_s1_w20 0 swwbl
cwbl_op1_1000_s1_w20 wbl_op1_1000_s1_w20 0 {C_WBL}
spa_op1_1000_s1_w20 prea rbl_op1_1000_s1_w20 ctl 0 swpre
spr_op1_1000_s1_w20 pref ref_op1_1000_s1_w20 ctl 0 swpre
crbl_op1_1000_s1_w20 rbl_op1_1000_s1_w20 0 {C_RBL}
cref_op1_1000_s1_w20 ref_op1_1000_s1_w20 0 {C_RBL}   $ ASSUMPTION: ideal matched dummy load
XMWR_op1_1000_s1_w20_0 sn_op1_1000_s1_w20_0 wwl_op1_1000_s1_w20 wbl_op1_1000_s1_w20 0 sky130_fd_pr__nfet_01v8 L=0.15 W=0.42 nf=1 ad=0.1218 as=0.1218 pd=1.42 ps=1.42 nrd=0.69047619047619  nrs=0.69047619047619 sa=0 sb=0 sd=0 mult=1 m=1
XMRD_op1_1000_s1_w20_0 rbl_op1_1000_s1_w20 sn_op1_1000_s1_w20_0 rwls_op1_1000_s1_w20 0 sky130_fd_pr__nfet_01v8 L=0.15 W=0.42 nf=1 ad=0.1218 as=0.1218 pd=1.42 ps=1.42 nrd=0.69047619047619  nrs=0.69047619047619 sa=0 sb=0 sd=0 mult=1 m=1
csn_op1_1000_s1_w20_0 sn_op1_1000_s1_w20_0 0 {C_SN}
XMWR_op1_1000_s1_w20_1 sn_op1_1000_s1_w20_1 wwl_des wbl_op1_1000_s1_w20 0 sky130_fd_pr__nfet_01v8 L=0.15 W=0.42 nf=1 ad=0.1218 as=0.1218 pd=1.42 ps=1.42 nrd=0.69047619047619  nrs=0.69047619047619 sa=0 sb=0 sd=0 mult=1 m=1
XMRD_op1_1000_s1_w20_1 rbl_op1_1000_s1_w20 sn_op1_1000_s1_w20_1 rwl_des 0 sky130_fd_pr__nfet_01v8 L=0.15 W=0.42 nf=1 ad=0.1218 as=0.1218 pd=1.42 ps=1.42 nrd=0.69047619047619  nrs=0.69047619047619 sa=0 sb=0 sd=0 mult=1 m=1
csn_op1_1000_s1_w20_1 sn_op1_1000_s1_w20_1 0 {C_SN}
XMWR_op1_1000_s1_w20_2 sn_op1_1000_s1_w20_2 wwl_des wbl_op1_1000_s1_w20 0 sky130_fd_pr__nfet_01v8 L=0.15 W=0.42 nf=1 ad=0.1218 as=0.1218 pd=1.42 ps=1.42 nrd=0.69047619047619  nrs=0.69047619047619 sa=0 sb=0 sd=0 mult=1 m=1
XMRD_op1_1000_s1_w20_2 rbl_op1_1000_s1_w20 sn_op1_1000_s1_w20_2 rwl_des 0 sky130_fd_pr__nfet_01v8 L=0.15 W=0.42 nf=1 ad=0.1218 as=0.1218 pd=1.42 ps=1.42 nrd=0.69047619047619  nrs=0.69047619047619 sa=0 sb=0 sd=0 mult=1 m=1
csn_op1_1000_s1_w20_2 sn_op1_1000_s1_w20_2 0 {C_SN}
XMWR_op1_1000_s1_w20_3 sn_op1_1000_s1_w20_3 wwl_des wbl_op1_1000_s1_w20 0 sky130_fd_pr__nfet_01v8 L=0.15 W=0.42 nf=1 ad=0.1218 as=0.1218 pd=1.42 ps=1.42 nrd=0.69047619047619  nrs=0.69047619047619 sa=0 sb=0 sd=0 mult=1 m=1
XMRD_op1_1000_s1_w20_3 rbl_op1_1000_s1_w20 sn_op1_1000_s1_w20_3 rwl_des 0 sky130_fd_pr__nfet_01v8 L=0.15 W=0.42 nf=1 ad=0.1218 as=0.1218 pd=1.42 ps=1.42 nrd=0.69047619047619  nrs=0.69047619047619 sa=0 sb=0 sd=0 mult=1 m=1
csn_op1_1000_s1_w20_3 sn_op1_1000_s1_w20_3 0 {C_SN}
XMN1_op1_1000_s1_w20 rbl_op1_1000_s1_w20 ref_op1_1000_s1_w20 vn_op1_1000_s1_w20 0 sky130_fd_pr__nfet_01v8 L=0.15 W=1 nf=1 ad=0.29 as=0.29 pd=2.58 ps=2.58 mult=1 m=1
XMN2_op1_1000_s1_w20 ref_op1_1000_s1_w20 rbl_op1_1000_s1_w20 vn_op1_1000_s1_w20 0 sky130_fd_pr__nfet_01v8 L=0.15 W=1 nf=1 ad=0.29 as=0.29 pd=2.58 ps=2.58 mult=1 m=1
XMP1_op1_1000_s1_w20 rbl_op1_1000_s1_w20 ref_op1_1000_s1_w20 vp_op1_1000_s1_w20 vdd sky130_fd_pr__pfet_01v8 L=0.15 W=2 nf=1 ad=0.58 as=0.58 pd=4.58 ps=4.58 mult=1 m=1
XMP2_op1_1000_s1_w20 ref_op1_1000_s1_w20 rbl_op1_1000_s1_w20 vp_op1_1000_s1_w20 vdd sky130_fd_pr__pfet_01v8 L=0.15 W=2 nf=1 ad=0.58 as=0.58 pd=4.58 ps=4.58 mult=1 m=1
XMNF_op1_1000_s1_w20 vn_op1_1000_s1_w20 en_op1_1000_s1_w20 0 0 sky130_fd_pr__nfet_01v8 L=0.15 W=2 nf=1 ad=0.58 as=0.58 pd=4.58 ps=4.58 mult=1 m=1
XMPH_op1_1000_s1_w20 vp_op1_1000_s1_w20 enb_op1_1000_s1_w20 vdd vdd sky130_fd_pr__pfet_01v8 L=0.15 W=4 nf=1 ad=1.16 as=1.16 pd=8.58 ps=8.58 mult=1 m=1
bd_op1_1000_s1_w20 d_op1_1000_s1_w20 0 v=v(rbl_op1_1000_s1_w20)-v(ref_op1_1000_s1_w20)

* ---- instance 82: op1_1000_s1_w30 (t_en 5 ns, WWL 6..36 ns, release 38 ns) ----
ven_op1_1000_s1_w30  en_op1_1000_s1_w30  0 pwl(0 0 5.0000e-09 0 5.1000e-09 {VDD} 3.8000e-08 {VDD} 3.8100e-08 0)
venb_op1_1000_s1_w30 enb_op1_1000_s1_w30 0 pwl(0 {VDD} 5.0000e-09 {VDD} 5.1000e-09 0 3.8000e-08 0 3.8100e-08 {VDD})
vrs_op1_1000_s1_w30  rwls_op1_1000_s1_w30 0 pwl(0 {VDD} {T_READ} {VDD} {T_READ+TEDGE} 0 3.8000e-08 0 3.8100e-08 {VDD})
vww_op1_1000_s1_w30  wwl_op1_1000_s1_w30 0 pwl(0 0 6.0000e-09 0 6.1000e-09 {VDD} 3.6000e-08 {VDD} 3.6100e-08 0)
vwc_op1_1000_s1_w30  wbc_op1_1000_s1_w30 0 pwl(0 0 6.0000e-09 0 6.1000e-09 {VDD} 3.8000e-08 {VDD} 3.8100e-08 0)
swb_op1_1000_s1_w30 ref_op1_1000_s1_w30 wbl_op1_1000_s1_w30 wbc_op1_1000_s1_w30 0 swwbl
cwbl_op1_1000_s1_w30 wbl_op1_1000_s1_w30 0 {C_WBL}
spa_op1_1000_s1_w30 prea rbl_op1_1000_s1_w30 ctl 0 swpre
spr_op1_1000_s1_w30 pref ref_op1_1000_s1_w30 ctl 0 swpre
crbl_op1_1000_s1_w30 rbl_op1_1000_s1_w30 0 {C_RBL}
cref_op1_1000_s1_w30 ref_op1_1000_s1_w30 0 {C_RBL}   $ ASSUMPTION: ideal matched dummy load
XMWR_op1_1000_s1_w30_0 sn_op1_1000_s1_w30_0 wwl_op1_1000_s1_w30 wbl_op1_1000_s1_w30 0 sky130_fd_pr__nfet_01v8 L=0.15 W=0.42 nf=1 ad=0.1218 as=0.1218 pd=1.42 ps=1.42 nrd=0.69047619047619  nrs=0.69047619047619 sa=0 sb=0 sd=0 mult=1 m=1
XMRD_op1_1000_s1_w30_0 rbl_op1_1000_s1_w30 sn_op1_1000_s1_w30_0 rwls_op1_1000_s1_w30 0 sky130_fd_pr__nfet_01v8 L=0.15 W=0.42 nf=1 ad=0.1218 as=0.1218 pd=1.42 ps=1.42 nrd=0.69047619047619  nrs=0.69047619047619 sa=0 sb=0 sd=0 mult=1 m=1
csn_op1_1000_s1_w30_0 sn_op1_1000_s1_w30_0 0 {C_SN}
XMWR_op1_1000_s1_w30_1 sn_op1_1000_s1_w30_1 wwl_des wbl_op1_1000_s1_w30 0 sky130_fd_pr__nfet_01v8 L=0.15 W=0.42 nf=1 ad=0.1218 as=0.1218 pd=1.42 ps=1.42 nrd=0.69047619047619  nrs=0.69047619047619 sa=0 sb=0 sd=0 mult=1 m=1
XMRD_op1_1000_s1_w30_1 rbl_op1_1000_s1_w30 sn_op1_1000_s1_w30_1 rwl_des 0 sky130_fd_pr__nfet_01v8 L=0.15 W=0.42 nf=1 ad=0.1218 as=0.1218 pd=1.42 ps=1.42 nrd=0.69047619047619  nrs=0.69047619047619 sa=0 sb=0 sd=0 mult=1 m=1
csn_op1_1000_s1_w30_1 sn_op1_1000_s1_w30_1 0 {C_SN}
XMWR_op1_1000_s1_w30_2 sn_op1_1000_s1_w30_2 wwl_des wbl_op1_1000_s1_w30 0 sky130_fd_pr__nfet_01v8 L=0.15 W=0.42 nf=1 ad=0.1218 as=0.1218 pd=1.42 ps=1.42 nrd=0.69047619047619  nrs=0.69047619047619 sa=0 sb=0 sd=0 mult=1 m=1
XMRD_op1_1000_s1_w30_2 rbl_op1_1000_s1_w30 sn_op1_1000_s1_w30_2 rwl_des 0 sky130_fd_pr__nfet_01v8 L=0.15 W=0.42 nf=1 ad=0.1218 as=0.1218 pd=1.42 ps=1.42 nrd=0.69047619047619  nrs=0.69047619047619 sa=0 sb=0 sd=0 mult=1 m=1
csn_op1_1000_s1_w30_2 sn_op1_1000_s1_w30_2 0 {C_SN}
XMWR_op1_1000_s1_w30_3 sn_op1_1000_s1_w30_3 wwl_des wbl_op1_1000_s1_w30 0 sky130_fd_pr__nfet_01v8 L=0.15 W=0.42 nf=1 ad=0.1218 as=0.1218 pd=1.42 ps=1.42 nrd=0.69047619047619  nrs=0.69047619047619 sa=0 sb=0 sd=0 mult=1 m=1
XMRD_op1_1000_s1_w30_3 rbl_op1_1000_s1_w30 sn_op1_1000_s1_w30_3 rwl_des 0 sky130_fd_pr__nfet_01v8 L=0.15 W=0.42 nf=1 ad=0.1218 as=0.1218 pd=1.42 ps=1.42 nrd=0.69047619047619  nrs=0.69047619047619 sa=0 sb=0 sd=0 mult=1 m=1
csn_op1_1000_s1_w30_3 sn_op1_1000_s1_w30_3 0 {C_SN}
XMN1_op1_1000_s1_w30 rbl_op1_1000_s1_w30 ref_op1_1000_s1_w30 vn_op1_1000_s1_w30 0 sky130_fd_pr__nfet_01v8 L=0.15 W=1 nf=1 ad=0.29 as=0.29 pd=2.58 ps=2.58 mult=1 m=1
XMN2_op1_1000_s1_w30 ref_op1_1000_s1_w30 rbl_op1_1000_s1_w30 vn_op1_1000_s1_w30 0 sky130_fd_pr__nfet_01v8 L=0.15 W=1 nf=1 ad=0.29 as=0.29 pd=2.58 ps=2.58 mult=1 m=1
XMP1_op1_1000_s1_w30 rbl_op1_1000_s1_w30 ref_op1_1000_s1_w30 vp_op1_1000_s1_w30 vdd sky130_fd_pr__pfet_01v8 L=0.15 W=2 nf=1 ad=0.58 as=0.58 pd=4.58 ps=4.58 mult=1 m=1
XMP2_op1_1000_s1_w30 ref_op1_1000_s1_w30 rbl_op1_1000_s1_w30 vp_op1_1000_s1_w30 vdd sky130_fd_pr__pfet_01v8 L=0.15 W=2 nf=1 ad=0.58 as=0.58 pd=4.58 ps=4.58 mult=1 m=1
XMNF_op1_1000_s1_w30 vn_op1_1000_s1_w30 en_op1_1000_s1_w30 0 0 sky130_fd_pr__nfet_01v8 L=0.15 W=2 nf=1 ad=0.58 as=0.58 pd=4.58 ps=4.58 mult=1 m=1
XMPH_op1_1000_s1_w30 vp_op1_1000_s1_w30 enb_op1_1000_s1_w30 vdd vdd sky130_fd_pr__pfet_01v8 L=0.15 W=4 nf=1 ad=1.16 as=1.16 pd=8.58 ps=8.58 mult=1 m=1
bd_op1_1000_s1_w30 d_op1_1000_s1_w30 0 v=v(rbl_op1_1000_s1_w30)-v(ref_op1_1000_s1_w30)

* ---- instance 83: op1_1000_s1_w50 (t_en 5 ns, WWL 6..56 ns, release 58 ns) ----
ven_op1_1000_s1_w50  en_op1_1000_s1_w50  0 pwl(0 0 5.0000e-09 0 5.1000e-09 {VDD} 5.8000e-08 {VDD} 5.8100e-08 0)
venb_op1_1000_s1_w50 enb_op1_1000_s1_w50 0 pwl(0 {VDD} 5.0000e-09 {VDD} 5.1000e-09 0 5.8000e-08 0 5.8100e-08 {VDD})
vrs_op1_1000_s1_w50  rwls_op1_1000_s1_w50 0 pwl(0 {VDD} {T_READ} {VDD} {T_READ+TEDGE} 0 5.8000e-08 0 5.8100e-08 {VDD})
vww_op1_1000_s1_w50  wwl_op1_1000_s1_w50 0 pwl(0 0 6.0000e-09 0 6.1000e-09 {VDD} 5.6000e-08 {VDD} 5.6100e-08 0)
vwc_op1_1000_s1_w50  wbc_op1_1000_s1_w50 0 pwl(0 0 6.0000e-09 0 6.1000e-09 {VDD} 5.8000e-08 {VDD} 5.8100e-08 0)
swb_op1_1000_s1_w50 ref_op1_1000_s1_w50 wbl_op1_1000_s1_w50 wbc_op1_1000_s1_w50 0 swwbl
cwbl_op1_1000_s1_w50 wbl_op1_1000_s1_w50 0 {C_WBL}
spa_op1_1000_s1_w50 prea rbl_op1_1000_s1_w50 ctl 0 swpre
spr_op1_1000_s1_w50 pref ref_op1_1000_s1_w50 ctl 0 swpre
crbl_op1_1000_s1_w50 rbl_op1_1000_s1_w50 0 {C_RBL}
cref_op1_1000_s1_w50 ref_op1_1000_s1_w50 0 {C_RBL}   $ ASSUMPTION: ideal matched dummy load
XMWR_op1_1000_s1_w50_0 sn_op1_1000_s1_w50_0 wwl_op1_1000_s1_w50 wbl_op1_1000_s1_w50 0 sky130_fd_pr__nfet_01v8 L=0.15 W=0.42 nf=1 ad=0.1218 as=0.1218 pd=1.42 ps=1.42 nrd=0.69047619047619  nrs=0.69047619047619 sa=0 sb=0 sd=0 mult=1 m=1
XMRD_op1_1000_s1_w50_0 rbl_op1_1000_s1_w50 sn_op1_1000_s1_w50_0 rwls_op1_1000_s1_w50 0 sky130_fd_pr__nfet_01v8 L=0.15 W=0.42 nf=1 ad=0.1218 as=0.1218 pd=1.42 ps=1.42 nrd=0.69047619047619  nrs=0.69047619047619 sa=0 sb=0 sd=0 mult=1 m=1
csn_op1_1000_s1_w50_0 sn_op1_1000_s1_w50_0 0 {C_SN}
XMWR_op1_1000_s1_w50_1 sn_op1_1000_s1_w50_1 wwl_des wbl_op1_1000_s1_w50 0 sky130_fd_pr__nfet_01v8 L=0.15 W=0.42 nf=1 ad=0.1218 as=0.1218 pd=1.42 ps=1.42 nrd=0.69047619047619  nrs=0.69047619047619 sa=0 sb=0 sd=0 mult=1 m=1
XMRD_op1_1000_s1_w50_1 rbl_op1_1000_s1_w50 sn_op1_1000_s1_w50_1 rwl_des 0 sky130_fd_pr__nfet_01v8 L=0.15 W=0.42 nf=1 ad=0.1218 as=0.1218 pd=1.42 ps=1.42 nrd=0.69047619047619  nrs=0.69047619047619 sa=0 sb=0 sd=0 mult=1 m=1
csn_op1_1000_s1_w50_1 sn_op1_1000_s1_w50_1 0 {C_SN}
XMWR_op1_1000_s1_w50_2 sn_op1_1000_s1_w50_2 wwl_des wbl_op1_1000_s1_w50 0 sky130_fd_pr__nfet_01v8 L=0.15 W=0.42 nf=1 ad=0.1218 as=0.1218 pd=1.42 ps=1.42 nrd=0.69047619047619  nrs=0.69047619047619 sa=0 sb=0 sd=0 mult=1 m=1
XMRD_op1_1000_s1_w50_2 rbl_op1_1000_s1_w50 sn_op1_1000_s1_w50_2 rwl_des 0 sky130_fd_pr__nfet_01v8 L=0.15 W=0.42 nf=1 ad=0.1218 as=0.1218 pd=1.42 ps=1.42 nrd=0.69047619047619  nrs=0.69047619047619 sa=0 sb=0 sd=0 mult=1 m=1
csn_op1_1000_s1_w50_2 sn_op1_1000_s1_w50_2 0 {C_SN}
XMWR_op1_1000_s1_w50_3 sn_op1_1000_s1_w50_3 wwl_des wbl_op1_1000_s1_w50 0 sky130_fd_pr__nfet_01v8 L=0.15 W=0.42 nf=1 ad=0.1218 as=0.1218 pd=1.42 ps=1.42 nrd=0.69047619047619  nrs=0.69047619047619 sa=0 sb=0 sd=0 mult=1 m=1
XMRD_op1_1000_s1_w50_3 rbl_op1_1000_s1_w50 sn_op1_1000_s1_w50_3 rwl_des 0 sky130_fd_pr__nfet_01v8 L=0.15 W=0.42 nf=1 ad=0.1218 as=0.1218 pd=1.42 ps=1.42 nrd=0.69047619047619  nrs=0.69047619047619 sa=0 sb=0 sd=0 mult=1 m=1
csn_op1_1000_s1_w50_3 sn_op1_1000_s1_w50_3 0 {C_SN}
XMN1_op1_1000_s1_w50 rbl_op1_1000_s1_w50 ref_op1_1000_s1_w50 vn_op1_1000_s1_w50 0 sky130_fd_pr__nfet_01v8 L=0.15 W=1 nf=1 ad=0.29 as=0.29 pd=2.58 ps=2.58 mult=1 m=1
XMN2_op1_1000_s1_w50 ref_op1_1000_s1_w50 rbl_op1_1000_s1_w50 vn_op1_1000_s1_w50 0 sky130_fd_pr__nfet_01v8 L=0.15 W=1 nf=1 ad=0.29 as=0.29 pd=2.58 ps=2.58 mult=1 m=1
XMP1_op1_1000_s1_w50 rbl_op1_1000_s1_w50 ref_op1_1000_s1_w50 vp_op1_1000_s1_w50 vdd sky130_fd_pr__pfet_01v8 L=0.15 W=2 nf=1 ad=0.58 as=0.58 pd=4.58 ps=4.58 mult=1 m=1
XMP2_op1_1000_s1_w50 ref_op1_1000_s1_w50 rbl_op1_1000_s1_w50 vp_op1_1000_s1_w50 vdd sky130_fd_pr__pfet_01v8 L=0.15 W=2 nf=1 ad=0.58 as=0.58 pd=4.58 ps=4.58 mult=1 m=1
XMNF_op1_1000_s1_w50 vn_op1_1000_s1_w50 en_op1_1000_s1_w50 0 0 sky130_fd_pr__nfet_01v8 L=0.15 W=2 nf=1 ad=0.58 as=0.58 pd=4.58 ps=4.58 mult=1 m=1
XMPH_op1_1000_s1_w50 vp_op1_1000_s1_w50 enb_op1_1000_s1_w50 vdd vdd sky130_fd_pr__pfet_01v8 L=0.15 W=4 nf=1 ad=1.16 as=1.16 pd=8.58 ps=8.58 mult=1 m=1
bd_op1_1000_s1_w50 d_op1_1000_s1_w50 0 v=v(rbl_op1_1000_s1_w50)-v(ref_op1_1000_s1_w50)

* ---- instance 84: op1_1000_s2_w0p2 (t_en 6 ns, WWL 7..7.2 ns, release 9.2 ns) ----
ven_op1_1000_s2_w0p2  en_op1_1000_s2_w0p2  0 pwl(0 0 6.0000e-09 0 6.1000e-09 {VDD} 9.2000e-09 {VDD} 9.3000e-09 0)
venb_op1_1000_s2_w0p2 enb_op1_1000_s2_w0p2 0 pwl(0 {VDD} 6.0000e-09 {VDD} 6.1000e-09 0 9.2000e-09 0 9.3000e-09 {VDD})
vrs_op1_1000_s2_w0p2  rwls_op1_1000_s2_w0p2 0 pwl(0 {VDD} {T_READ} {VDD} {T_READ+TEDGE} 0 9.2000e-09 0 9.3000e-09 {VDD})
vww_op1_1000_s2_w0p2  wwl_op1_1000_s2_w0p2 0 pwl(0 0 7.0000e-09 0 7.1000e-09 {VDD} 7.2000e-09 {VDD} 7.3000e-09 0)
vwc_op1_1000_s2_w0p2  wbc_op1_1000_s2_w0p2 0 pwl(0 0 7.0000e-09 0 7.1000e-09 {VDD} 9.2000e-09 {VDD} 9.3000e-09 0)
swb_op1_1000_s2_w0p2 ref_op1_1000_s2_w0p2 wbl_op1_1000_s2_w0p2 wbc_op1_1000_s2_w0p2 0 swwbl
cwbl_op1_1000_s2_w0p2 wbl_op1_1000_s2_w0p2 0 {C_WBL}
spa_op1_1000_s2_w0p2 prea rbl_op1_1000_s2_w0p2 ctl 0 swpre
spr_op1_1000_s2_w0p2 pref ref_op1_1000_s2_w0p2 ctl 0 swpre
crbl_op1_1000_s2_w0p2 rbl_op1_1000_s2_w0p2 0 {C_RBL}
cref_op1_1000_s2_w0p2 ref_op1_1000_s2_w0p2 0 {C_RBL}   $ ASSUMPTION: ideal matched dummy load
XMWR_op1_1000_s2_w0p2_0 sn_op1_1000_s2_w0p2_0 wwl_op1_1000_s2_w0p2 wbl_op1_1000_s2_w0p2 0 sky130_fd_pr__nfet_01v8 L=0.15 W=0.42 nf=1 ad=0.1218 as=0.1218 pd=1.42 ps=1.42 nrd=0.69047619047619  nrs=0.69047619047619 sa=0 sb=0 sd=0 mult=1 m=1
XMRD_op1_1000_s2_w0p2_0 rbl_op1_1000_s2_w0p2 sn_op1_1000_s2_w0p2_0 rwls_op1_1000_s2_w0p2 0 sky130_fd_pr__nfet_01v8 L=0.15 W=0.42 nf=1 ad=0.1218 as=0.1218 pd=1.42 ps=1.42 nrd=0.69047619047619  nrs=0.69047619047619 sa=0 sb=0 sd=0 mult=1 m=1
csn_op1_1000_s2_w0p2_0 sn_op1_1000_s2_w0p2_0 0 {C_SN}
XMWR_op1_1000_s2_w0p2_1 sn_op1_1000_s2_w0p2_1 wwl_des wbl_op1_1000_s2_w0p2 0 sky130_fd_pr__nfet_01v8 L=0.15 W=0.42 nf=1 ad=0.1218 as=0.1218 pd=1.42 ps=1.42 nrd=0.69047619047619  nrs=0.69047619047619 sa=0 sb=0 sd=0 mult=1 m=1
XMRD_op1_1000_s2_w0p2_1 rbl_op1_1000_s2_w0p2 sn_op1_1000_s2_w0p2_1 rwl_des 0 sky130_fd_pr__nfet_01v8 L=0.15 W=0.42 nf=1 ad=0.1218 as=0.1218 pd=1.42 ps=1.42 nrd=0.69047619047619  nrs=0.69047619047619 sa=0 sb=0 sd=0 mult=1 m=1
csn_op1_1000_s2_w0p2_1 sn_op1_1000_s2_w0p2_1 0 {C_SN}
XMWR_op1_1000_s2_w0p2_2 sn_op1_1000_s2_w0p2_2 wwl_des wbl_op1_1000_s2_w0p2 0 sky130_fd_pr__nfet_01v8 L=0.15 W=0.42 nf=1 ad=0.1218 as=0.1218 pd=1.42 ps=1.42 nrd=0.69047619047619  nrs=0.69047619047619 sa=0 sb=0 sd=0 mult=1 m=1
XMRD_op1_1000_s2_w0p2_2 rbl_op1_1000_s2_w0p2 sn_op1_1000_s2_w0p2_2 rwl_des 0 sky130_fd_pr__nfet_01v8 L=0.15 W=0.42 nf=1 ad=0.1218 as=0.1218 pd=1.42 ps=1.42 nrd=0.69047619047619  nrs=0.69047619047619 sa=0 sb=0 sd=0 mult=1 m=1
csn_op1_1000_s2_w0p2_2 sn_op1_1000_s2_w0p2_2 0 {C_SN}
XMWR_op1_1000_s2_w0p2_3 sn_op1_1000_s2_w0p2_3 wwl_des wbl_op1_1000_s2_w0p2 0 sky130_fd_pr__nfet_01v8 L=0.15 W=0.42 nf=1 ad=0.1218 as=0.1218 pd=1.42 ps=1.42 nrd=0.69047619047619  nrs=0.69047619047619 sa=0 sb=0 sd=0 mult=1 m=1
XMRD_op1_1000_s2_w0p2_3 rbl_op1_1000_s2_w0p2 sn_op1_1000_s2_w0p2_3 rwl_des 0 sky130_fd_pr__nfet_01v8 L=0.15 W=0.42 nf=1 ad=0.1218 as=0.1218 pd=1.42 ps=1.42 nrd=0.69047619047619  nrs=0.69047619047619 sa=0 sb=0 sd=0 mult=1 m=1
csn_op1_1000_s2_w0p2_3 sn_op1_1000_s2_w0p2_3 0 {C_SN}
XMN1_op1_1000_s2_w0p2 rbl_op1_1000_s2_w0p2 ref_op1_1000_s2_w0p2 vn_op1_1000_s2_w0p2 0 sky130_fd_pr__nfet_01v8 L=0.15 W=1 nf=1 ad=0.29 as=0.29 pd=2.58 ps=2.58 mult=1 m=1
XMN2_op1_1000_s2_w0p2 ref_op1_1000_s2_w0p2 rbl_op1_1000_s2_w0p2 vn_op1_1000_s2_w0p2 0 sky130_fd_pr__nfet_01v8 L=0.15 W=1 nf=1 ad=0.29 as=0.29 pd=2.58 ps=2.58 mult=1 m=1
XMP1_op1_1000_s2_w0p2 rbl_op1_1000_s2_w0p2 ref_op1_1000_s2_w0p2 vp_op1_1000_s2_w0p2 vdd sky130_fd_pr__pfet_01v8 L=0.15 W=2 nf=1 ad=0.58 as=0.58 pd=4.58 ps=4.58 mult=1 m=1
XMP2_op1_1000_s2_w0p2 ref_op1_1000_s2_w0p2 rbl_op1_1000_s2_w0p2 vp_op1_1000_s2_w0p2 vdd sky130_fd_pr__pfet_01v8 L=0.15 W=2 nf=1 ad=0.58 as=0.58 pd=4.58 ps=4.58 mult=1 m=1
XMNF_op1_1000_s2_w0p2 vn_op1_1000_s2_w0p2 en_op1_1000_s2_w0p2 0 0 sky130_fd_pr__nfet_01v8 L=0.15 W=2 nf=1 ad=0.58 as=0.58 pd=4.58 ps=4.58 mult=1 m=1
XMPH_op1_1000_s2_w0p2 vp_op1_1000_s2_w0p2 enb_op1_1000_s2_w0p2 vdd vdd sky130_fd_pr__pfet_01v8 L=0.15 W=4 nf=1 ad=1.16 as=1.16 pd=8.58 ps=8.58 mult=1 m=1
bd_op1_1000_s2_w0p2 d_op1_1000_s2_w0p2 0 v=v(rbl_op1_1000_s2_w0p2)-v(ref_op1_1000_s2_w0p2)

* ---- instance 85: op1_1000_s2_w0p5 (t_en 6 ns, WWL 7..7.5 ns, release 9.5 ns) ----
ven_op1_1000_s2_w0p5  en_op1_1000_s2_w0p5  0 pwl(0 0 6.0000e-09 0 6.1000e-09 {VDD} 9.5000e-09 {VDD} 9.6000e-09 0)
venb_op1_1000_s2_w0p5 enb_op1_1000_s2_w0p5 0 pwl(0 {VDD} 6.0000e-09 {VDD} 6.1000e-09 0 9.5000e-09 0 9.6000e-09 {VDD})
vrs_op1_1000_s2_w0p5  rwls_op1_1000_s2_w0p5 0 pwl(0 {VDD} {T_READ} {VDD} {T_READ+TEDGE} 0 9.5000e-09 0 9.6000e-09 {VDD})
vww_op1_1000_s2_w0p5  wwl_op1_1000_s2_w0p5 0 pwl(0 0 7.0000e-09 0 7.1000e-09 {VDD} 7.5000e-09 {VDD} 7.6000e-09 0)
vwc_op1_1000_s2_w0p5  wbc_op1_1000_s2_w0p5 0 pwl(0 0 7.0000e-09 0 7.1000e-09 {VDD} 9.5000e-09 {VDD} 9.6000e-09 0)
swb_op1_1000_s2_w0p5 ref_op1_1000_s2_w0p5 wbl_op1_1000_s2_w0p5 wbc_op1_1000_s2_w0p5 0 swwbl
cwbl_op1_1000_s2_w0p5 wbl_op1_1000_s2_w0p5 0 {C_WBL}
spa_op1_1000_s2_w0p5 prea rbl_op1_1000_s2_w0p5 ctl 0 swpre
spr_op1_1000_s2_w0p5 pref ref_op1_1000_s2_w0p5 ctl 0 swpre
crbl_op1_1000_s2_w0p5 rbl_op1_1000_s2_w0p5 0 {C_RBL}
cref_op1_1000_s2_w0p5 ref_op1_1000_s2_w0p5 0 {C_RBL}   $ ASSUMPTION: ideal matched dummy load
XMWR_op1_1000_s2_w0p5_0 sn_op1_1000_s2_w0p5_0 wwl_op1_1000_s2_w0p5 wbl_op1_1000_s2_w0p5 0 sky130_fd_pr__nfet_01v8 L=0.15 W=0.42 nf=1 ad=0.1218 as=0.1218 pd=1.42 ps=1.42 nrd=0.69047619047619  nrs=0.69047619047619 sa=0 sb=0 sd=0 mult=1 m=1
XMRD_op1_1000_s2_w0p5_0 rbl_op1_1000_s2_w0p5 sn_op1_1000_s2_w0p5_0 rwls_op1_1000_s2_w0p5 0 sky130_fd_pr__nfet_01v8 L=0.15 W=0.42 nf=1 ad=0.1218 as=0.1218 pd=1.42 ps=1.42 nrd=0.69047619047619  nrs=0.69047619047619 sa=0 sb=0 sd=0 mult=1 m=1
csn_op1_1000_s2_w0p5_0 sn_op1_1000_s2_w0p5_0 0 {C_SN}
XMWR_op1_1000_s2_w0p5_1 sn_op1_1000_s2_w0p5_1 wwl_des wbl_op1_1000_s2_w0p5 0 sky130_fd_pr__nfet_01v8 L=0.15 W=0.42 nf=1 ad=0.1218 as=0.1218 pd=1.42 ps=1.42 nrd=0.69047619047619  nrs=0.69047619047619 sa=0 sb=0 sd=0 mult=1 m=1
XMRD_op1_1000_s2_w0p5_1 rbl_op1_1000_s2_w0p5 sn_op1_1000_s2_w0p5_1 rwl_des 0 sky130_fd_pr__nfet_01v8 L=0.15 W=0.42 nf=1 ad=0.1218 as=0.1218 pd=1.42 ps=1.42 nrd=0.69047619047619  nrs=0.69047619047619 sa=0 sb=0 sd=0 mult=1 m=1
csn_op1_1000_s2_w0p5_1 sn_op1_1000_s2_w0p5_1 0 {C_SN}
XMWR_op1_1000_s2_w0p5_2 sn_op1_1000_s2_w0p5_2 wwl_des wbl_op1_1000_s2_w0p5 0 sky130_fd_pr__nfet_01v8 L=0.15 W=0.42 nf=1 ad=0.1218 as=0.1218 pd=1.42 ps=1.42 nrd=0.69047619047619  nrs=0.69047619047619 sa=0 sb=0 sd=0 mult=1 m=1
XMRD_op1_1000_s2_w0p5_2 rbl_op1_1000_s2_w0p5 sn_op1_1000_s2_w0p5_2 rwl_des 0 sky130_fd_pr__nfet_01v8 L=0.15 W=0.42 nf=1 ad=0.1218 as=0.1218 pd=1.42 ps=1.42 nrd=0.69047619047619  nrs=0.69047619047619 sa=0 sb=0 sd=0 mult=1 m=1
csn_op1_1000_s2_w0p5_2 sn_op1_1000_s2_w0p5_2 0 {C_SN}
XMWR_op1_1000_s2_w0p5_3 sn_op1_1000_s2_w0p5_3 wwl_des wbl_op1_1000_s2_w0p5 0 sky130_fd_pr__nfet_01v8 L=0.15 W=0.42 nf=1 ad=0.1218 as=0.1218 pd=1.42 ps=1.42 nrd=0.69047619047619  nrs=0.69047619047619 sa=0 sb=0 sd=0 mult=1 m=1
XMRD_op1_1000_s2_w0p5_3 rbl_op1_1000_s2_w0p5 sn_op1_1000_s2_w0p5_3 rwl_des 0 sky130_fd_pr__nfet_01v8 L=0.15 W=0.42 nf=1 ad=0.1218 as=0.1218 pd=1.42 ps=1.42 nrd=0.69047619047619  nrs=0.69047619047619 sa=0 sb=0 sd=0 mult=1 m=1
csn_op1_1000_s2_w0p5_3 sn_op1_1000_s2_w0p5_3 0 {C_SN}
XMN1_op1_1000_s2_w0p5 rbl_op1_1000_s2_w0p5 ref_op1_1000_s2_w0p5 vn_op1_1000_s2_w0p5 0 sky130_fd_pr__nfet_01v8 L=0.15 W=1 nf=1 ad=0.29 as=0.29 pd=2.58 ps=2.58 mult=1 m=1
XMN2_op1_1000_s2_w0p5 ref_op1_1000_s2_w0p5 rbl_op1_1000_s2_w0p5 vn_op1_1000_s2_w0p5 0 sky130_fd_pr__nfet_01v8 L=0.15 W=1 nf=1 ad=0.29 as=0.29 pd=2.58 ps=2.58 mult=1 m=1
XMP1_op1_1000_s2_w0p5 rbl_op1_1000_s2_w0p5 ref_op1_1000_s2_w0p5 vp_op1_1000_s2_w0p5 vdd sky130_fd_pr__pfet_01v8 L=0.15 W=2 nf=1 ad=0.58 as=0.58 pd=4.58 ps=4.58 mult=1 m=1
XMP2_op1_1000_s2_w0p5 ref_op1_1000_s2_w0p5 rbl_op1_1000_s2_w0p5 vp_op1_1000_s2_w0p5 vdd sky130_fd_pr__pfet_01v8 L=0.15 W=2 nf=1 ad=0.58 as=0.58 pd=4.58 ps=4.58 mult=1 m=1
XMNF_op1_1000_s2_w0p5 vn_op1_1000_s2_w0p5 en_op1_1000_s2_w0p5 0 0 sky130_fd_pr__nfet_01v8 L=0.15 W=2 nf=1 ad=0.58 as=0.58 pd=4.58 ps=4.58 mult=1 m=1
XMPH_op1_1000_s2_w0p5 vp_op1_1000_s2_w0p5 enb_op1_1000_s2_w0p5 vdd vdd sky130_fd_pr__pfet_01v8 L=0.15 W=4 nf=1 ad=1.16 as=1.16 pd=8.58 ps=8.58 mult=1 m=1
bd_op1_1000_s2_w0p5 d_op1_1000_s2_w0p5 0 v=v(rbl_op1_1000_s2_w0p5)-v(ref_op1_1000_s2_w0p5)

* ---- instance 86: op1_1000_s2_w1 (t_en 6 ns, WWL 7..8 ns, release 10 ns) ----
ven_op1_1000_s2_w1  en_op1_1000_s2_w1  0 pwl(0 0 6.0000e-09 0 6.1000e-09 {VDD} 1.0000e-08 {VDD} 1.0100e-08 0)
venb_op1_1000_s2_w1 enb_op1_1000_s2_w1 0 pwl(0 {VDD} 6.0000e-09 {VDD} 6.1000e-09 0 1.0000e-08 0 1.0100e-08 {VDD})
vrs_op1_1000_s2_w1  rwls_op1_1000_s2_w1 0 pwl(0 {VDD} {T_READ} {VDD} {T_READ+TEDGE} 0 1.0000e-08 0 1.0100e-08 {VDD})
vww_op1_1000_s2_w1  wwl_op1_1000_s2_w1 0 pwl(0 0 7.0000e-09 0 7.1000e-09 {VDD} 8.0000e-09 {VDD} 8.1000e-09 0)
vwc_op1_1000_s2_w1  wbc_op1_1000_s2_w1 0 pwl(0 0 7.0000e-09 0 7.1000e-09 {VDD} 1.0000e-08 {VDD} 1.0100e-08 0)
swb_op1_1000_s2_w1 ref_op1_1000_s2_w1 wbl_op1_1000_s2_w1 wbc_op1_1000_s2_w1 0 swwbl
cwbl_op1_1000_s2_w1 wbl_op1_1000_s2_w1 0 {C_WBL}
spa_op1_1000_s2_w1 prea rbl_op1_1000_s2_w1 ctl 0 swpre
spr_op1_1000_s2_w1 pref ref_op1_1000_s2_w1 ctl 0 swpre
crbl_op1_1000_s2_w1 rbl_op1_1000_s2_w1 0 {C_RBL}
cref_op1_1000_s2_w1 ref_op1_1000_s2_w1 0 {C_RBL}   $ ASSUMPTION: ideal matched dummy load
XMWR_op1_1000_s2_w1_0 sn_op1_1000_s2_w1_0 wwl_op1_1000_s2_w1 wbl_op1_1000_s2_w1 0 sky130_fd_pr__nfet_01v8 L=0.15 W=0.42 nf=1 ad=0.1218 as=0.1218 pd=1.42 ps=1.42 nrd=0.69047619047619  nrs=0.69047619047619 sa=0 sb=0 sd=0 mult=1 m=1
XMRD_op1_1000_s2_w1_0 rbl_op1_1000_s2_w1 sn_op1_1000_s2_w1_0 rwls_op1_1000_s2_w1 0 sky130_fd_pr__nfet_01v8 L=0.15 W=0.42 nf=1 ad=0.1218 as=0.1218 pd=1.42 ps=1.42 nrd=0.69047619047619  nrs=0.69047619047619 sa=0 sb=0 sd=0 mult=1 m=1
csn_op1_1000_s2_w1_0 sn_op1_1000_s2_w1_0 0 {C_SN}
XMWR_op1_1000_s2_w1_1 sn_op1_1000_s2_w1_1 wwl_des wbl_op1_1000_s2_w1 0 sky130_fd_pr__nfet_01v8 L=0.15 W=0.42 nf=1 ad=0.1218 as=0.1218 pd=1.42 ps=1.42 nrd=0.69047619047619  nrs=0.69047619047619 sa=0 sb=0 sd=0 mult=1 m=1
XMRD_op1_1000_s2_w1_1 rbl_op1_1000_s2_w1 sn_op1_1000_s2_w1_1 rwl_des 0 sky130_fd_pr__nfet_01v8 L=0.15 W=0.42 nf=1 ad=0.1218 as=0.1218 pd=1.42 ps=1.42 nrd=0.69047619047619  nrs=0.69047619047619 sa=0 sb=0 sd=0 mult=1 m=1
csn_op1_1000_s2_w1_1 sn_op1_1000_s2_w1_1 0 {C_SN}
XMWR_op1_1000_s2_w1_2 sn_op1_1000_s2_w1_2 wwl_des wbl_op1_1000_s2_w1 0 sky130_fd_pr__nfet_01v8 L=0.15 W=0.42 nf=1 ad=0.1218 as=0.1218 pd=1.42 ps=1.42 nrd=0.69047619047619  nrs=0.69047619047619 sa=0 sb=0 sd=0 mult=1 m=1
XMRD_op1_1000_s2_w1_2 rbl_op1_1000_s2_w1 sn_op1_1000_s2_w1_2 rwl_des 0 sky130_fd_pr__nfet_01v8 L=0.15 W=0.42 nf=1 ad=0.1218 as=0.1218 pd=1.42 ps=1.42 nrd=0.69047619047619  nrs=0.69047619047619 sa=0 sb=0 sd=0 mult=1 m=1
csn_op1_1000_s2_w1_2 sn_op1_1000_s2_w1_2 0 {C_SN}
XMWR_op1_1000_s2_w1_3 sn_op1_1000_s2_w1_3 wwl_des wbl_op1_1000_s2_w1 0 sky130_fd_pr__nfet_01v8 L=0.15 W=0.42 nf=1 ad=0.1218 as=0.1218 pd=1.42 ps=1.42 nrd=0.69047619047619  nrs=0.69047619047619 sa=0 sb=0 sd=0 mult=1 m=1
XMRD_op1_1000_s2_w1_3 rbl_op1_1000_s2_w1 sn_op1_1000_s2_w1_3 rwl_des 0 sky130_fd_pr__nfet_01v8 L=0.15 W=0.42 nf=1 ad=0.1218 as=0.1218 pd=1.42 ps=1.42 nrd=0.69047619047619  nrs=0.69047619047619 sa=0 sb=0 sd=0 mult=1 m=1
csn_op1_1000_s2_w1_3 sn_op1_1000_s2_w1_3 0 {C_SN}
XMN1_op1_1000_s2_w1 rbl_op1_1000_s2_w1 ref_op1_1000_s2_w1 vn_op1_1000_s2_w1 0 sky130_fd_pr__nfet_01v8 L=0.15 W=1 nf=1 ad=0.29 as=0.29 pd=2.58 ps=2.58 mult=1 m=1
XMN2_op1_1000_s2_w1 ref_op1_1000_s2_w1 rbl_op1_1000_s2_w1 vn_op1_1000_s2_w1 0 sky130_fd_pr__nfet_01v8 L=0.15 W=1 nf=1 ad=0.29 as=0.29 pd=2.58 ps=2.58 mult=1 m=1
XMP1_op1_1000_s2_w1 rbl_op1_1000_s2_w1 ref_op1_1000_s2_w1 vp_op1_1000_s2_w1 vdd sky130_fd_pr__pfet_01v8 L=0.15 W=2 nf=1 ad=0.58 as=0.58 pd=4.58 ps=4.58 mult=1 m=1
XMP2_op1_1000_s2_w1 ref_op1_1000_s2_w1 rbl_op1_1000_s2_w1 vp_op1_1000_s2_w1 vdd sky130_fd_pr__pfet_01v8 L=0.15 W=2 nf=1 ad=0.58 as=0.58 pd=4.58 ps=4.58 mult=1 m=1
XMNF_op1_1000_s2_w1 vn_op1_1000_s2_w1 en_op1_1000_s2_w1 0 0 sky130_fd_pr__nfet_01v8 L=0.15 W=2 nf=1 ad=0.58 as=0.58 pd=4.58 ps=4.58 mult=1 m=1
XMPH_op1_1000_s2_w1 vp_op1_1000_s2_w1 enb_op1_1000_s2_w1 vdd vdd sky130_fd_pr__pfet_01v8 L=0.15 W=4 nf=1 ad=1.16 as=1.16 pd=8.58 ps=8.58 mult=1 m=1
bd_op1_1000_s2_w1 d_op1_1000_s2_w1 0 v=v(rbl_op1_1000_s2_w1)-v(ref_op1_1000_s2_w1)

* ---- instance 87: op1_1000_s2_w2 (t_en 6 ns, WWL 7..9 ns, release 11 ns) ----
ven_op1_1000_s2_w2  en_op1_1000_s2_w2  0 pwl(0 0 6.0000e-09 0 6.1000e-09 {VDD} 1.1000e-08 {VDD} 1.1100e-08 0)
venb_op1_1000_s2_w2 enb_op1_1000_s2_w2 0 pwl(0 {VDD} 6.0000e-09 {VDD} 6.1000e-09 0 1.1000e-08 0 1.1100e-08 {VDD})
vrs_op1_1000_s2_w2  rwls_op1_1000_s2_w2 0 pwl(0 {VDD} {T_READ} {VDD} {T_READ+TEDGE} 0 1.1000e-08 0 1.1100e-08 {VDD})
vww_op1_1000_s2_w2  wwl_op1_1000_s2_w2 0 pwl(0 0 7.0000e-09 0 7.1000e-09 {VDD} 9.0000e-09 {VDD} 9.1000e-09 0)
vwc_op1_1000_s2_w2  wbc_op1_1000_s2_w2 0 pwl(0 0 7.0000e-09 0 7.1000e-09 {VDD} 1.1000e-08 {VDD} 1.1100e-08 0)
swb_op1_1000_s2_w2 ref_op1_1000_s2_w2 wbl_op1_1000_s2_w2 wbc_op1_1000_s2_w2 0 swwbl
cwbl_op1_1000_s2_w2 wbl_op1_1000_s2_w2 0 {C_WBL}
spa_op1_1000_s2_w2 prea rbl_op1_1000_s2_w2 ctl 0 swpre
spr_op1_1000_s2_w2 pref ref_op1_1000_s2_w2 ctl 0 swpre
crbl_op1_1000_s2_w2 rbl_op1_1000_s2_w2 0 {C_RBL}
cref_op1_1000_s2_w2 ref_op1_1000_s2_w2 0 {C_RBL}   $ ASSUMPTION: ideal matched dummy load
XMWR_op1_1000_s2_w2_0 sn_op1_1000_s2_w2_0 wwl_op1_1000_s2_w2 wbl_op1_1000_s2_w2 0 sky130_fd_pr__nfet_01v8 L=0.15 W=0.42 nf=1 ad=0.1218 as=0.1218 pd=1.42 ps=1.42 nrd=0.69047619047619  nrs=0.69047619047619 sa=0 sb=0 sd=0 mult=1 m=1
XMRD_op1_1000_s2_w2_0 rbl_op1_1000_s2_w2 sn_op1_1000_s2_w2_0 rwls_op1_1000_s2_w2 0 sky130_fd_pr__nfet_01v8 L=0.15 W=0.42 nf=1 ad=0.1218 as=0.1218 pd=1.42 ps=1.42 nrd=0.69047619047619  nrs=0.69047619047619 sa=0 sb=0 sd=0 mult=1 m=1
csn_op1_1000_s2_w2_0 sn_op1_1000_s2_w2_0 0 {C_SN}
XMWR_op1_1000_s2_w2_1 sn_op1_1000_s2_w2_1 wwl_des wbl_op1_1000_s2_w2 0 sky130_fd_pr__nfet_01v8 L=0.15 W=0.42 nf=1 ad=0.1218 as=0.1218 pd=1.42 ps=1.42 nrd=0.69047619047619  nrs=0.69047619047619 sa=0 sb=0 sd=0 mult=1 m=1
XMRD_op1_1000_s2_w2_1 rbl_op1_1000_s2_w2 sn_op1_1000_s2_w2_1 rwl_des 0 sky130_fd_pr__nfet_01v8 L=0.15 W=0.42 nf=1 ad=0.1218 as=0.1218 pd=1.42 ps=1.42 nrd=0.69047619047619  nrs=0.69047619047619 sa=0 sb=0 sd=0 mult=1 m=1
csn_op1_1000_s2_w2_1 sn_op1_1000_s2_w2_1 0 {C_SN}
XMWR_op1_1000_s2_w2_2 sn_op1_1000_s2_w2_2 wwl_des wbl_op1_1000_s2_w2 0 sky130_fd_pr__nfet_01v8 L=0.15 W=0.42 nf=1 ad=0.1218 as=0.1218 pd=1.42 ps=1.42 nrd=0.69047619047619  nrs=0.69047619047619 sa=0 sb=0 sd=0 mult=1 m=1
XMRD_op1_1000_s2_w2_2 rbl_op1_1000_s2_w2 sn_op1_1000_s2_w2_2 rwl_des 0 sky130_fd_pr__nfet_01v8 L=0.15 W=0.42 nf=1 ad=0.1218 as=0.1218 pd=1.42 ps=1.42 nrd=0.69047619047619  nrs=0.69047619047619 sa=0 sb=0 sd=0 mult=1 m=1
csn_op1_1000_s2_w2_2 sn_op1_1000_s2_w2_2 0 {C_SN}
XMWR_op1_1000_s2_w2_3 sn_op1_1000_s2_w2_3 wwl_des wbl_op1_1000_s2_w2 0 sky130_fd_pr__nfet_01v8 L=0.15 W=0.42 nf=1 ad=0.1218 as=0.1218 pd=1.42 ps=1.42 nrd=0.69047619047619  nrs=0.69047619047619 sa=0 sb=0 sd=0 mult=1 m=1
XMRD_op1_1000_s2_w2_3 rbl_op1_1000_s2_w2 sn_op1_1000_s2_w2_3 rwl_des 0 sky130_fd_pr__nfet_01v8 L=0.15 W=0.42 nf=1 ad=0.1218 as=0.1218 pd=1.42 ps=1.42 nrd=0.69047619047619  nrs=0.69047619047619 sa=0 sb=0 sd=0 mult=1 m=1
csn_op1_1000_s2_w2_3 sn_op1_1000_s2_w2_3 0 {C_SN}
XMN1_op1_1000_s2_w2 rbl_op1_1000_s2_w2 ref_op1_1000_s2_w2 vn_op1_1000_s2_w2 0 sky130_fd_pr__nfet_01v8 L=0.15 W=1 nf=1 ad=0.29 as=0.29 pd=2.58 ps=2.58 mult=1 m=1
XMN2_op1_1000_s2_w2 ref_op1_1000_s2_w2 rbl_op1_1000_s2_w2 vn_op1_1000_s2_w2 0 sky130_fd_pr__nfet_01v8 L=0.15 W=1 nf=1 ad=0.29 as=0.29 pd=2.58 ps=2.58 mult=1 m=1
XMP1_op1_1000_s2_w2 rbl_op1_1000_s2_w2 ref_op1_1000_s2_w2 vp_op1_1000_s2_w2 vdd sky130_fd_pr__pfet_01v8 L=0.15 W=2 nf=1 ad=0.58 as=0.58 pd=4.58 ps=4.58 mult=1 m=1
XMP2_op1_1000_s2_w2 ref_op1_1000_s2_w2 rbl_op1_1000_s2_w2 vp_op1_1000_s2_w2 vdd sky130_fd_pr__pfet_01v8 L=0.15 W=2 nf=1 ad=0.58 as=0.58 pd=4.58 ps=4.58 mult=1 m=1
XMNF_op1_1000_s2_w2 vn_op1_1000_s2_w2 en_op1_1000_s2_w2 0 0 sky130_fd_pr__nfet_01v8 L=0.15 W=2 nf=1 ad=0.58 as=0.58 pd=4.58 ps=4.58 mult=1 m=1
XMPH_op1_1000_s2_w2 vp_op1_1000_s2_w2 enb_op1_1000_s2_w2 vdd vdd sky130_fd_pr__pfet_01v8 L=0.15 W=4 nf=1 ad=1.16 as=1.16 pd=8.58 ps=8.58 mult=1 m=1
bd_op1_1000_s2_w2 d_op1_1000_s2_w2 0 v=v(rbl_op1_1000_s2_w2)-v(ref_op1_1000_s2_w2)

* ---- instance 88: op1_1000_s2_w3 (t_en 6 ns, WWL 7..10 ns, release 12 ns) ----
ven_op1_1000_s2_w3  en_op1_1000_s2_w3  0 pwl(0 0 6.0000e-09 0 6.1000e-09 {VDD} 1.2000e-08 {VDD} 1.2100e-08 0)
venb_op1_1000_s2_w3 enb_op1_1000_s2_w3 0 pwl(0 {VDD} 6.0000e-09 {VDD} 6.1000e-09 0 1.2000e-08 0 1.2100e-08 {VDD})
vrs_op1_1000_s2_w3  rwls_op1_1000_s2_w3 0 pwl(0 {VDD} {T_READ} {VDD} {T_READ+TEDGE} 0 1.2000e-08 0 1.2100e-08 {VDD})
vww_op1_1000_s2_w3  wwl_op1_1000_s2_w3 0 pwl(0 0 7.0000e-09 0 7.1000e-09 {VDD} 1.0000e-08 {VDD} 1.0100e-08 0)
vwc_op1_1000_s2_w3  wbc_op1_1000_s2_w3 0 pwl(0 0 7.0000e-09 0 7.1000e-09 {VDD} 1.2000e-08 {VDD} 1.2100e-08 0)
swb_op1_1000_s2_w3 ref_op1_1000_s2_w3 wbl_op1_1000_s2_w3 wbc_op1_1000_s2_w3 0 swwbl
cwbl_op1_1000_s2_w3 wbl_op1_1000_s2_w3 0 {C_WBL}
spa_op1_1000_s2_w3 prea rbl_op1_1000_s2_w3 ctl 0 swpre
spr_op1_1000_s2_w3 pref ref_op1_1000_s2_w3 ctl 0 swpre
crbl_op1_1000_s2_w3 rbl_op1_1000_s2_w3 0 {C_RBL}
cref_op1_1000_s2_w3 ref_op1_1000_s2_w3 0 {C_RBL}   $ ASSUMPTION: ideal matched dummy load
XMWR_op1_1000_s2_w3_0 sn_op1_1000_s2_w3_0 wwl_op1_1000_s2_w3 wbl_op1_1000_s2_w3 0 sky130_fd_pr__nfet_01v8 L=0.15 W=0.42 nf=1 ad=0.1218 as=0.1218 pd=1.42 ps=1.42 nrd=0.69047619047619  nrs=0.69047619047619 sa=0 sb=0 sd=0 mult=1 m=1
XMRD_op1_1000_s2_w3_0 rbl_op1_1000_s2_w3 sn_op1_1000_s2_w3_0 rwls_op1_1000_s2_w3 0 sky130_fd_pr__nfet_01v8 L=0.15 W=0.42 nf=1 ad=0.1218 as=0.1218 pd=1.42 ps=1.42 nrd=0.69047619047619  nrs=0.69047619047619 sa=0 sb=0 sd=0 mult=1 m=1
csn_op1_1000_s2_w3_0 sn_op1_1000_s2_w3_0 0 {C_SN}
XMWR_op1_1000_s2_w3_1 sn_op1_1000_s2_w3_1 wwl_des wbl_op1_1000_s2_w3 0 sky130_fd_pr__nfet_01v8 L=0.15 W=0.42 nf=1 ad=0.1218 as=0.1218 pd=1.42 ps=1.42 nrd=0.69047619047619  nrs=0.69047619047619 sa=0 sb=0 sd=0 mult=1 m=1
XMRD_op1_1000_s2_w3_1 rbl_op1_1000_s2_w3 sn_op1_1000_s2_w3_1 rwl_des 0 sky130_fd_pr__nfet_01v8 L=0.15 W=0.42 nf=1 ad=0.1218 as=0.1218 pd=1.42 ps=1.42 nrd=0.69047619047619  nrs=0.69047619047619 sa=0 sb=0 sd=0 mult=1 m=1
csn_op1_1000_s2_w3_1 sn_op1_1000_s2_w3_1 0 {C_SN}
XMWR_op1_1000_s2_w3_2 sn_op1_1000_s2_w3_2 wwl_des wbl_op1_1000_s2_w3 0 sky130_fd_pr__nfet_01v8 L=0.15 W=0.42 nf=1 ad=0.1218 as=0.1218 pd=1.42 ps=1.42 nrd=0.69047619047619  nrs=0.69047619047619 sa=0 sb=0 sd=0 mult=1 m=1
XMRD_op1_1000_s2_w3_2 rbl_op1_1000_s2_w3 sn_op1_1000_s2_w3_2 rwl_des 0 sky130_fd_pr__nfet_01v8 L=0.15 W=0.42 nf=1 ad=0.1218 as=0.1218 pd=1.42 ps=1.42 nrd=0.69047619047619  nrs=0.69047619047619 sa=0 sb=0 sd=0 mult=1 m=1
csn_op1_1000_s2_w3_2 sn_op1_1000_s2_w3_2 0 {C_SN}
XMWR_op1_1000_s2_w3_3 sn_op1_1000_s2_w3_3 wwl_des wbl_op1_1000_s2_w3 0 sky130_fd_pr__nfet_01v8 L=0.15 W=0.42 nf=1 ad=0.1218 as=0.1218 pd=1.42 ps=1.42 nrd=0.69047619047619  nrs=0.69047619047619 sa=0 sb=0 sd=0 mult=1 m=1
XMRD_op1_1000_s2_w3_3 rbl_op1_1000_s2_w3 sn_op1_1000_s2_w3_3 rwl_des 0 sky130_fd_pr__nfet_01v8 L=0.15 W=0.42 nf=1 ad=0.1218 as=0.1218 pd=1.42 ps=1.42 nrd=0.69047619047619  nrs=0.69047619047619 sa=0 sb=0 sd=0 mult=1 m=1
csn_op1_1000_s2_w3_3 sn_op1_1000_s2_w3_3 0 {C_SN}
XMN1_op1_1000_s2_w3 rbl_op1_1000_s2_w3 ref_op1_1000_s2_w3 vn_op1_1000_s2_w3 0 sky130_fd_pr__nfet_01v8 L=0.15 W=1 nf=1 ad=0.29 as=0.29 pd=2.58 ps=2.58 mult=1 m=1
XMN2_op1_1000_s2_w3 ref_op1_1000_s2_w3 rbl_op1_1000_s2_w3 vn_op1_1000_s2_w3 0 sky130_fd_pr__nfet_01v8 L=0.15 W=1 nf=1 ad=0.29 as=0.29 pd=2.58 ps=2.58 mult=1 m=1
XMP1_op1_1000_s2_w3 rbl_op1_1000_s2_w3 ref_op1_1000_s2_w3 vp_op1_1000_s2_w3 vdd sky130_fd_pr__pfet_01v8 L=0.15 W=2 nf=1 ad=0.58 as=0.58 pd=4.58 ps=4.58 mult=1 m=1
XMP2_op1_1000_s2_w3 ref_op1_1000_s2_w3 rbl_op1_1000_s2_w3 vp_op1_1000_s2_w3 vdd sky130_fd_pr__pfet_01v8 L=0.15 W=2 nf=1 ad=0.58 as=0.58 pd=4.58 ps=4.58 mult=1 m=1
XMNF_op1_1000_s2_w3 vn_op1_1000_s2_w3 en_op1_1000_s2_w3 0 0 sky130_fd_pr__nfet_01v8 L=0.15 W=2 nf=1 ad=0.58 as=0.58 pd=4.58 ps=4.58 mult=1 m=1
XMPH_op1_1000_s2_w3 vp_op1_1000_s2_w3 enb_op1_1000_s2_w3 vdd vdd sky130_fd_pr__pfet_01v8 L=0.15 W=4 nf=1 ad=1.16 as=1.16 pd=8.58 ps=8.58 mult=1 m=1
bd_op1_1000_s2_w3 d_op1_1000_s2_w3 0 v=v(rbl_op1_1000_s2_w3)-v(ref_op1_1000_s2_w3)

* ---- instance 89: op1_1000_s2_w5 (t_en 6 ns, WWL 7..12 ns, release 14 ns) ----
ven_op1_1000_s2_w5  en_op1_1000_s2_w5  0 pwl(0 0 6.0000e-09 0 6.1000e-09 {VDD} 1.4000e-08 {VDD} 1.4100e-08 0)
venb_op1_1000_s2_w5 enb_op1_1000_s2_w5 0 pwl(0 {VDD} 6.0000e-09 {VDD} 6.1000e-09 0 1.4000e-08 0 1.4100e-08 {VDD})
vrs_op1_1000_s2_w5  rwls_op1_1000_s2_w5 0 pwl(0 {VDD} {T_READ} {VDD} {T_READ+TEDGE} 0 1.4000e-08 0 1.4100e-08 {VDD})
vww_op1_1000_s2_w5  wwl_op1_1000_s2_w5 0 pwl(0 0 7.0000e-09 0 7.1000e-09 {VDD} 1.2000e-08 {VDD} 1.2100e-08 0)
vwc_op1_1000_s2_w5  wbc_op1_1000_s2_w5 0 pwl(0 0 7.0000e-09 0 7.1000e-09 {VDD} 1.4000e-08 {VDD} 1.4100e-08 0)
swb_op1_1000_s2_w5 ref_op1_1000_s2_w5 wbl_op1_1000_s2_w5 wbc_op1_1000_s2_w5 0 swwbl
cwbl_op1_1000_s2_w5 wbl_op1_1000_s2_w5 0 {C_WBL}
spa_op1_1000_s2_w5 prea rbl_op1_1000_s2_w5 ctl 0 swpre
spr_op1_1000_s2_w5 pref ref_op1_1000_s2_w5 ctl 0 swpre
crbl_op1_1000_s2_w5 rbl_op1_1000_s2_w5 0 {C_RBL}
cref_op1_1000_s2_w5 ref_op1_1000_s2_w5 0 {C_RBL}   $ ASSUMPTION: ideal matched dummy load
XMWR_op1_1000_s2_w5_0 sn_op1_1000_s2_w5_0 wwl_op1_1000_s2_w5 wbl_op1_1000_s2_w5 0 sky130_fd_pr__nfet_01v8 L=0.15 W=0.42 nf=1 ad=0.1218 as=0.1218 pd=1.42 ps=1.42 nrd=0.69047619047619  nrs=0.69047619047619 sa=0 sb=0 sd=0 mult=1 m=1
XMRD_op1_1000_s2_w5_0 rbl_op1_1000_s2_w5 sn_op1_1000_s2_w5_0 rwls_op1_1000_s2_w5 0 sky130_fd_pr__nfet_01v8 L=0.15 W=0.42 nf=1 ad=0.1218 as=0.1218 pd=1.42 ps=1.42 nrd=0.69047619047619  nrs=0.69047619047619 sa=0 sb=0 sd=0 mult=1 m=1
csn_op1_1000_s2_w5_0 sn_op1_1000_s2_w5_0 0 {C_SN}
XMWR_op1_1000_s2_w5_1 sn_op1_1000_s2_w5_1 wwl_des wbl_op1_1000_s2_w5 0 sky130_fd_pr__nfet_01v8 L=0.15 W=0.42 nf=1 ad=0.1218 as=0.1218 pd=1.42 ps=1.42 nrd=0.69047619047619  nrs=0.69047619047619 sa=0 sb=0 sd=0 mult=1 m=1
XMRD_op1_1000_s2_w5_1 rbl_op1_1000_s2_w5 sn_op1_1000_s2_w5_1 rwl_des 0 sky130_fd_pr__nfet_01v8 L=0.15 W=0.42 nf=1 ad=0.1218 as=0.1218 pd=1.42 ps=1.42 nrd=0.69047619047619  nrs=0.69047619047619 sa=0 sb=0 sd=0 mult=1 m=1
csn_op1_1000_s2_w5_1 sn_op1_1000_s2_w5_1 0 {C_SN}
XMWR_op1_1000_s2_w5_2 sn_op1_1000_s2_w5_2 wwl_des wbl_op1_1000_s2_w5 0 sky130_fd_pr__nfet_01v8 L=0.15 W=0.42 nf=1 ad=0.1218 as=0.1218 pd=1.42 ps=1.42 nrd=0.69047619047619  nrs=0.69047619047619 sa=0 sb=0 sd=0 mult=1 m=1
XMRD_op1_1000_s2_w5_2 rbl_op1_1000_s2_w5 sn_op1_1000_s2_w5_2 rwl_des 0 sky130_fd_pr__nfet_01v8 L=0.15 W=0.42 nf=1 ad=0.1218 as=0.1218 pd=1.42 ps=1.42 nrd=0.69047619047619  nrs=0.69047619047619 sa=0 sb=0 sd=0 mult=1 m=1
csn_op1_1000_s2_w5_2 sn_op1_1000_s2_w5_2 0 {C_SN}
XMWR_op1_1000_s2_w5_3 sn_op1_1000_s2_w5_3 wwl_des wbl_op1_1000_s2_w5 0 sky130_fd_pr__nfet_01v8 L=0.15 W=0.42 nf=1 ad=0.1218 as=0.1218 pd=1.42 ps=1.42 nrd=0.69047619047619  nrs=0.69047619047619 sa=0 sb=0 sd=0 mult=1 m=1
XMRD_op1_1000_s2_w5_3 rbl_op1_1000_s2_w5 sn_op1_1000_s2_w5_3 rwl_des 0 sky130_fd_pr__nfet_01v8 L=0.15 W=0.42 nf=1 ad=0.1218 as=0.1218 pd=1.42 ps=1.42 nrd=0.69047619047619  nrs=0.69047619047619 sa=0 sb=0 sd=0 mult=1 m=1
csn_op1_1000_s2_w5_3 sn_op1_1000_s2_w5_3 0 {C_SN}
XMN1_op1_1000_s2_w5 rbl_op1_1000_s2_w5 ref_op1_1000_s2_w5 vn_op1_1000_s2_w5 0 sky130_fd_pr__nfet_01v8 L=0.15 W=1 nf=1 ad=0.29 as=0.29 pd=2.58 ps=2.58 mult=1 m=1
XMN2_op1_1000_s2_w5 ref_op1_1000_s2_w5 rbl_op1_1000_s2_w5 vn_op1_1000_s2_w5 0 sky130_fd_pr__nfet_01v8 L=0.15 W=1 nf=1 ad=0.29 as=0.29 pd=2.58 ps=2.58 mult=1 m=1
XMP1_op1_1000_s2_w5 rbl_op1_1000_s2_w5 ref_op1_1000_s2_w5 vp_op1_1000_s2_w5 vdd sky130_fd_pr__pfet_01v8 L=0.15 W=2 nf=1 ad=0.58 as=0.58 pd=4.58 ps=4.58 mult=1 m=1
XMP2_op1_1000_s2_w5 ref_op1_1000_s2_w5 rbl_op1_1000_s2_w5 vp_op1_1000_s2_w5 vdd sky130_fd_pr__pfet_01v8 L=0.15 W=2 nf=1 ad=0.58 as=0.58 pd=4.58 ps=4.58 mult=1 m=1
XMNF_op1_1000_s2_w5 vn_op1_1000_s2_w5 en_op1_1000_s2_w5 0 0 sky130_fd_pr__nfet_01v8 L=0.15 W=2 nf=1 ad=0.58 as=0.58 pd=4.58 ps=4.58 mult=1 m=1
XMPH_op1_1000_s2_w5 vp_op1_1000_s2_w5 enb_op1_1000_s2_w5 vdd vdd sky130_fd_pr__pfet_01v8 L=0.15 W=4 nf=1 ad=1.16 as=1.16 pd=8.58 ps=8.58 mult=1 m=1
bd_op1_1000_s2_w5 d_op1_1000_s2_w5 0 v=v(rbl_op1_1000_s2_w5)-v(ref_op1_1000_s2_w5)

* ---- instance 90: op1_1000_s2_w7p5 (t_en 6 ns, WWL 7..14.5 ns, release 16.5 ns) ----
ven_op1_1000_s2_w7p5  en_op1_1000_s2_w7p5  0 pwl(0 0 6.0000e-09 0 6.1000e-09 {VDD} 1.6500e-08 {VDD} 1.6600e-08 0)
venb_op1_1000_s2_w7p5 enb_op1_1000_s2_w7p5 0 pwl(0 {VDD} 6.0000e-09 {VDD} 6.1000e-09 0 1.6500e-08 0 1.6600e-08 {VDD})
vrs_op1_1000_s2_w7p5  rwls_op1_1000_s2_w7p5 0 pwl(0 {VDD} {T_READ} {VDD} {T_READ+TEDGE} 0 1.6500e-08 0 1.6600e-08 {VDD})
vww_op1_1000_s2_w7p5  wwl_op1_1000_s2_w7p5 0 pwl(0 0 7.0000e-09 0 7.1000e-09 {VDD} 1.4500e-08 {VDD} 1.4600e-08 0)
vwc_op1_1000_s2_w7p5  wbc_op1_1000_s2_w7p5 0 pwl(0 0 7.0000e-09 0 7.1000e-09 {VDD} 1.6500e-08 {VDD} 1.6600e-08 0)
swb_op1_1000_s2_w7p5 ref_op1_1000_s2_w7p5 wbl_op1_1000_s2_w7p5 wbc_op1_1000_s2_w7p5 0 swwbl
cwbl_op1_1000_s2_w7p5 wbl_op1_1000_s2_w7p5 0 {C_WBL}
spa_op1_1000_s2_w7p5 prea rbl_op1_1000_s2_w7p5 ctl 0 swpre
spr_op1_1000_s2_w7p5 pref ref_op1_1000_s2_w7p5 ctl 0 swpre
crbl_op1_1000_s2_w7p5 rbl_op1_1000_s2_w7p5 0 {C_RBL}
cref_op1_1000_s2_w7p5 ref_op1_1000_s2_w7p5 0 {C_RBL}   $ ASSUMPTION: ideal matched dummy load
XMWR_op1_1000_s2_w7p5_0 sn_op1_1000_s2_w7p5_0 wwl_op1_1000_s2_w7p5 wbl_op1_1000_s2_w7p5 0 sky130_fd_pr__nfet_01v8 L=0.15 W=0.42 nf=1 ad=0.1218 as=0.1218 pd=1.42 ps=1.42 nrd=0.69047619047619  nrs=0.69047619047619 sa=0 sb=0 sd=0 mult=1 m=1
XMRD_op1_1000_s2_w7p5_0 rbl_op1_1000_s2_w7p5 sn_op1_1000_s2_w7p5_0 rwls_op1_1000_s2_w7p5 0 sky130_fd_pr__nfet_01v8 L=0.15 W=0.42 nf=1 ad=0.1218 as=0.1218 pd=1.42 ps=1.42 nrd=0.69047619047619  nrs=0.69047619047619 sa=0 sb=0 sd=0 mult=1 m=1
csn_op1_1000_s2_w7p5_0 sn_op1_1000_s2_w7p5_0 0 {C_SN}
XMWR_op1_1000_s2_w7p5_1 sn_op1_1000_s2_w7p5_1 wwl_des wbl_op1_1000_s2_w7p5 0 sky130_fd_pr__nfet_01v8 L=0.15 W=0.42 nf=1 ad=0.1218 as=0.1218 pd=1.42 ps=1.42 nrd=0.69047619047619  nrs=0.69047619047619 sa=0 sb=0 sd=0 mult=1 m=1
XMRD_op1_1000_s2_w7p5_1 rbl_op1_1000_s2_w7p5 sn_op1_1000_s2_w7p5_1 rwl_des 0 sky130_fd_pr__nfet_01v8 L=0.15 W=0.42 nf=1 ad=0.1218 as=0.1218 pd=1.42 ps=1.42 nrd=0.69047619047619  nrs=0.69047619047619 sa=0 sb=0 sd=0 mult=1 m=1
csn_op1_1000_s2_w7p5_1 sn_op1_1000_s2_w7p5_1 0 {C_SN}
XMWR_op1_1000_s2_w7p5_2 sn_op1_1000_s2_w7p5_2 wwl_des wbl_op1_1000_s2_w7p5 0 sky130_fd_pr__nfet_01v8 L=0.15 W=0.42 nf=1 ad=0.1218 as=0.1218 pd=1.42 ps=1.42 nrd=0.69047619047619  nrs=0.69047619047619 sa=0 sb=0 sd=0 mult=1 m=1
XMRD_op1_1000_s2_w7p5_2 rbl_op1_1000_s2_w7p5 sn_op1_1000_s2_w7p5_2 rwl_des 0 sky130_fd_pr__nfet_01v8 L=0.15 W=0.42 nf=1 ad=0.1218 as=0.1218 pd=1.42 ps=1.42 nrd=0.69047619047619  nrs=0.69047619047619 sa=0 sb=0 sd=0 mult=1 m=1
csn_op1_1000_s2_w7p5_2 sn_op1_1000_s2_w7p5_2 0 {C_SN}
XMWR_op1_1000_s2_w7p5_3 sn_op1_1000_s2_w7p5_3 wwl_des wbl_op1_1000_s2_w7p5 0 sky130_fd_pr__nfet_01v8 L=0.15 W=0.42 nf=1 ad=0.1218 as=0.1218 pd=1.42 ps=1.42 nrd=0.69047619047619  nrs=0.69047619047619 sa=0 sb=0 sd=0 mult=1 m=1
XMRD_op1_1000_s2_w7p5_3 rbl_op1_1000_s2_w7p5 sn_op1_1000_s2_w7p5_3 rwl_des 0 sky130_fd_pr__nfet_01v8 L=0.15 W=0.42 nf=1 ad=0.1218 as=0.1218 pd=1.42 ps=1.42 nrd=0.69047619047619  nrs=0.69047619047619 sa=0 sb=0 sd=0 mult=1 m=1
csn_op1_1000_s2_w7p5_3 sn_op1_1000_s2_w7p5_3 0 {C_SN}
XMN1_op1_1000_s2_w7p5 rbl_op1_1000_s2_w7p5 ref_op1_1000_s2_w7p5 vn_op1_1000_s2_w7p5 0 sky130_fd_pr__nfet_01v8 L=0.15 W=1 nf=1 ad=0.29 as=0.29 pd=2.58 ps=2.58 mult=1 m=1
XMN2_op1_1000_s2_w7p5 ref_op1_1000_s2_w7p5 rbl_op1_1000_s2_w7p5 vn_op1_1000_s2_w7p5 0 sky130_fd_pr__nfet_01v8 L=0.15 W=1 nf=1 ad=0.29 as=0.29 pd=2.58 ps=2.58 mult=1 m=1
XMP1_op1_1000_s2_w7p5 rbl_op1_1000_s2_w7p5 ref_op1_1000_s2_w7p5 vp_op1_1000_s2_w7p5 vdd sky130_fd_pr__pfet_01v8 L=0.15 W=2 nf=1 ad=0.58 as=0.58 pd=4.58 ps=4.58 mult=1 m=1
XMP2_op1_1000_s2_w7p5 ref_op1_1000_s2_w7p5 rbl_op1_1000_s2_w7p5 vp_op1_1000_s2_w7p5 vdd sky130_fd_pr__pfet_01v8 L=0.15 W=2 nf=1 ad=0.58 as=0.58 pd=4.58 ps=4.58 mult=1 m=1
XMNF_op1_1000_s2_w7p5 vn_op1_1000_s2_w7p5 en_op1_1000_s2_w7p5 0 0 sky130_fd_pr__nfet_01v8 L=0.15 W=2 nf=1 ad=0.58 as=0.58 pd=4.58 ps=4.58 mult=1 m=1
XMPH_op1_1000_s2_w7p5 vp_op1_1000_s2_w7p5 enb_op1_1000_s2_w7p5 vdd vdd sky130_fd_pr__pfet_01v8 L=0.15 W=4 nf=1 ad=1.16 as=1.16 pd=8.58 ps=8.58 mult=1 m=1
bd_op1_1000_s2_w7p5 d_op1_1000_s2_w7p5 0 v=v(rbl_op1_1000_s2_w7p5)-v(ref_op1_1000_s2_w7p5)

* ---- instance 91: op1_1000_s2_w10 (t_en 6 ns, WWL 7..17 ns, release 19 ns) ----
ven_op1_1000_s2_w10  en_op1_1000_s2_w10  0 pwl(0 0 6.0000e-09 0 6.1000e-09 {VDD} 1.9000e-08 {VDD} 1.9100e-08 0)
venb_op1_1000_s2_w10 enb_op1_1000_s2_w10 0 pwl(0 {VDD} 6.0000e-09 {VDD} 6.1000e-09 0 1.9000e-08 0 1.9100e-08 {VDD})
vrs_op1_1000_s2_w10  rwls_op1_1000_s2_w10 0 pwl(0 {VDD} {T_READ} {VDD} {T_READ+TEDGE} 0 1.9000e-08 0 1.9100e-08 {VDD})
vww_op1_1000_s2_w10  wwl_op1_1000_s2_w10 0 pwl(0 0 7.0000e-09 0 7.1000e-09 {VDD} 1.7000e-08 {VDD} 1.7100e-08 0)
vwc_op1_1000_s2_w10  wbc_op1_1000_s2_w10 0 pwl(0 0 7.0000e-09 0 7.1000e-09 {VDD} 1.9000e-08 {VDD} 1.9100e-08 0)
swb_op1_1000_s2_w10 ref_op1_1000_s2_w10 wbl_op1_1000_s2_w10 wbc_op1_1000_s2_w10 0 swwbl
cwbl_op1_1000_s2_w10 wbl_op1_1000_s2_w10 0 {C_WBL}
spa_op1_1000_s2_w10 prea rbl_op1_1000_s2_w10 ctl 0 swpre
spr_op1_1000_s2_w10 pref ref_op1_1000_s2_w10 ctl 0 swpre
crbl_op1_1000_s2_w10 rbl_op1_1000_s2_w10 0 {C_RBL}
cref_op1_1000_s2_w10 ref_op1_1000_s2_w10 0 {C_RBL}   $ ASSUMPTION: ideal matched dummy load
XMWR_op1_1000_s2_w10_0 sn_op1_1000_s2_w10_0 wwl_op1_1000_s2_w10 wbl_op1_1000_s2_w10 0 sky130_fd_pr__nfet_01v8 L=0.15 W=0.42 nf=1 ad=0.1218 as=0.1218 pd=1.42 ps=1.42 nrd=0.69047619047619  nrs=0.69047619047619 sa=0 sb=0 sd=0 mult=1 m=1
XMRD_op1_1000_s2_w10_0 rbl_op1_1000_s2_w10 sn_op1_1000_s2_w10_0 rwls_op1_1000_s2_w10 0 sky130_fd_pr__nfet_01v8 L=0.15 W=0.42 nf=1 ad=0.1218 as=0.1218 pd=1.42 ps=1.42 nrd=0.69047619047619  nrs=0.69047619047619 sa=0 sb=0 sd=0 mult=1 m=1
csn_op1_1000_s2_w10_0 sn_op1_1000_s2_w10_0 0 {C_SN}
XMWR_op1_1000_s2_w10_1 sn_op1_1000_s2_w10_1 wwl_des wbl_op1_1000_s2_w10 0 sky130_fd_pr__nfet_01v8 L=0.15 W=0.42 nf=1 ad=0.1218 as=0.1218 pd=1.42 ps=1.42 nrd=0.69047619047619  nrs=0.69047619047619 sa=0 sb=0 sd=0 mult=1 m=1
XMRD_op1_1000_s2_w10_1 rbl_op1_1000_s2_w10 sn_op1_1000_s2_w10_1 rwl_des 0 sky130_fd_pr__nfet_01v8 L=0.15 W=0.42 nf=1 ad=0.1218 as=0.1218 pd=1.42 ps=1.42 nrd=0.69047619047619  nrs=0.69047619047619 sa=0 sb=0 sd=0 mult=1 m=1
csn_op1_1000_s2_w10_1 sn_op1_1000_s2_w10_1 0 {C_SN}
XMWR_op1_1000_s2_w10_2 sn_op1_1000_s2_w10_2 wwl_des wbl_op1_1000_s2_w10 0 sky130_fd_pr__nfet_01v8 L=0.15 W=0.42 nf=1 ad=0.1218 as=0.1218 pd=1.42 ps=1.42 nrd=0.69047619047619  nrs=0.69047619047619 sa=0 sb=0 sd=0 mult=1 m=1
XMRD_op1_1000_s2_w10_2 rbl_op1_1000_s2_w10 sn_op1_1000_s2_w10_2 rwl_des 0 sky130_fd_pr__nfet_01v8 L=0.15 W=0.42 nf=1 ad=0.1218 as=0.1218 pd=1.42 ps=1.42 nrd=0.69047619047619  nrs=0.69047619047619 sa=0 sb=0 sd=0 mult=1 m=1
csn_op1_1000_s2_w10_2 sn_op1_1000_s2_w10_2 0 {C_SN}
XMWR_op1_1000_s2_w10_3 sn_op1_1000_s2_w10_3 wwl_des wbl_op1_1000_s2_w10 0 sky130_fd_pr__nfet_01v8 L=0.15 W=0.42 nf=1 ad=0.1218 as=0.1218 pd=1.42 ps=1.42 nrd=0.69047619047619  nrs=0.69047619047619 sa=0 sb=0 sd=0 mult=1 m=1
XMRD_op1_1000_s2_w10_3 rbl_op1_1000_s2_w10 sn_op1_1000_s2_w10_3 rwl_des 0 sky130_fd_pr__nfet_01v8 L=0.15 W=0.42 nf=1 ad=0.1218 as=0.1218 pd=1.42 ps=1.42 nrd=0.69047619047619  nrs=0.69047619047619 sa=0 sb=0 sd=0 mult=1 m=1
csn_op1_1000_s2_w10_3 sn_op1_1000_s2_w10_3 0 {C_SN}
XMN1_op1_1000_s2_w10 rbl_op1_1000_s2_w10 ref_op1_1000_s2_w10 vn_op1_1000_s2_w10 0 sky130_fd_pr__nfet_01v8 L=0.15 W=1 nf=1 ad=0.29 as=0.29 pd=2.58 ps=2.58 mult=1 m=1
XMN2_op1_1000_s2_w10 ref_op1_1000_s2_w10 rbl_op1_1000_s2_w10 vn_op1_1000_s2_w10 0 sky130_fd_pr__nfet_01v8 L=0.15 W=1 nf=1 ad=0.29 as=0.29 pd=2.58 ps=2.58 mult=1 m=1
XMP1_op1_1000_s2_w10 rbl_op1_1000_s2_w10 ref_op1_1000_s2_w10 vp_op1_1000_s2_w10 vdd sky130_fd_pr__pfet_01v8 L=0.15 W=2 nf=1 ad=0.58 as=0.58 pd=4.58 ps=4.58 mult=1 m=1
XMP2_op1_1000_s2_w10 ref_op1_1000_s2_w10 rbl_op1_1000_s2_w10 vp_op1_1000_s2_w10 vdd sky130_fd_pr__pfet_01v8 L=0.15 W=2 nf=1 ad=0.58 as=0.58 pd=4.58 ps=4.58 mult=1 m=1
XMNF_op1_1000_s2_w10 vn_op1_1000_s2_w10 en_op1_1000_s2_w10 0 0 sky130_fd_pr__nfet_01v8 L=0.15 W=2 nf=1 ad=0.58 as=0.58 pd=4.58 ps=4.58 mult=1 m=1
XMPH_op1_1000_s2_w10 vp_op1_1000_s2_w10 enb_op1_1000_s2_w10 vdd vdd sky130_fd_pr__pfet_01v8 L=0.15 W=4 nf=1 ad=1.16 as=1.16 pd=8.58 ps=8.58 mult=1 m=1
bd_op1_1000_s2_w10 d_op1_1000_s2_w10 0 v=v(rbl_op1_1000_s2_w10)-v(ref_op1_1000_s2_w10)

* ---- instance 92: op1_1000_s2_w15 (t_en 6 ns, WWL 7..22 ns, release 24 ns) ----
ven_op1_1000_s2_w15  en_op1_1000_s2_w15  0 pwl(0 0 6.0000e-09 0 6.1000e-09 {VDD} 2.4000e-08 {VDD} 2.4100e-08 0)
venb_op1_1000_s2_w15 enb_op1_1000_s2_w15 0 pwl(0 {VDD} 6.0000e-09 {VDD} 6.1000e-09 0 2.4000e-08 0 2.4100e-08 {VDD})
vrs_op1_1000_s2_w15  rwls_op1_1000_s2_w15 0 pwl(0 {VDD} {T_READ} {VDD} {T_READ+TEDGE} 0 2.4000e-08 0 2.4100e-08 {VDD})
vww_op1_1000_s2_w15  wwl_op1_1000_s2_w15 0 pwl(0 0 7.0000e-09 0 7.1000e-09 {VDD} 2.2000e-08 {VDD} 2.2100e-08 0)
vwc_op1_1000_s2_w15  wbc_op1_1000_s2_w15 0 pwl(0 0 7.0000e-09 0 7.1000e-09 {VDD} 2.4000e-08 {VDD} 2.4100e-08 0)
swb_op1_1000_s2_w15 ref_op1_1000_s2_w15 wbl_op1_1000_s2_w15 wbc_op1_1000_s2_w15 0 swwbl
cwbl_op1_1000_s2_w15 wbl_op1_1000_s2_w15 0 {C_WBL}
spa_op1_1000_s2_w15 prea rbl_op1_1000_s2_w15 ctl 0 swpre
spr_op1_1000_s2_w15 pref ref_op1_1000_s2_w15 ctl 0 swpre
crbl_op1_1000_s2_w15 rbl_op1_1000_s2_w15 0 {C_RBL}
cref_op1_1000_s2_w15 ref_op1_1000_s2_w15 0 {C_RBL}   $ ASSUMPTION: ideal matched dummy load
XMWR_op1_1000_s2_w15_0 sn_op1_1000_s2_w15_0 wwl_op1_1000_s2_w15 wbl_op1_1000_s2_w15 0 sky130_fd_pr__nfet_01v8 L=0.15 W=0.42 nf=1 ad=0.1218 as=0.1218 pd=1.42 ps=1.42 nrd=0.69047619047619  nrs=0.69047619047619 sa=0 sb=0 sd=0 mult=1 m=1
XMRD_op1_1000_s2_w15_0 rbl_op1_1000_s2_w15 sn_op1_1000_s2_w15_0 rwls_op1_1000_s2_w15 0 sky130_fd_pr__nfet_01v8 L=0.15 W=0.42 nf=1 ad=0.1218 as=0.1218 pd=1.42 ps=1.42 nrd=0.69047619047619  nrs=0.69047619047619 sa=0 sb=0 sd=0 mult=1 m=1
csn_op1_1000_s2_w15_0 sn_op1_1000_s2_w15_0 0 {C_SN}
XMWR_op1_1000_s2_w15_1 sn_op1_1000_s2_w15_1 wwl_des wbl_op1_1000_s2_w15 0 sky130_fd_pr__nfet_01v8 L=0.15 W=0.42 nf=1 ad=0.1218 as=0.1218 pd=1.42 ps=1.42 nrd=0.69047619047619  nrs=0.69047619047619 sa=0 sb=0 sd=0 mult=1 m=1
XMRD_op1_1000_s2_w15_1 rbl_op1_1000_s2_w15 sn_op1_1000_s2_w15_1 rwl_des 0 sky130_fd_pr__nfet_01v8 L=0.15 W=0.42 nf=1 ad=0.1218 as=0.1218 pd=1.42 ps=1.42 nrd=0.69047619047619  nrs=0.69047619047619 sa=0 sb=0 sd=0 mult=1 m=1
csn_op1_1000_s2_w15_1 sn_op1_1000_s2_w15_1 0 {C_SN}
XMWR_op1_1000_s2_w15_2 sn_op1_1000_s2_w15_2 wwl_des wbl_op1_1000_s2_w15 0 sky130_fd_pr__nfet_01v8 L=0.15 W=0.42 nf=1 ad=0.1218 as=0.1218 pd=1.42 ps=1.42 nrd=0.69047619047619  nrs=0.69047619047619 sa=0 sb=0 sd=0 mult=1 m=1
XMRD_op1_1000_s2_w15_2 rbl_op1_1000_s2_w15 sn_op1_1000_s2_w15_2 rwl_des 0 sky130_fd_pr__nfet_01v8 L=0.15 W=0.42 nf=1 ad=0.1218 as=0.1218 pd=1.42 ps=1.42 nrd=0.69047619047619  nrs=0.69047619047619 sa=0 sb=0 sd=0 mult=1 m=1
csn_op1_1000_s2_w15_2 sn_op1_1000_s2_w15_2 0 {C_SN}
XMWR_op1_1000_s2_w15_3 sn_op1_1000_s2_w15_3 wwl_des wbl_op1_1000_s2_w15 0 sky130_fd_pr__nfet_01v8 L=0.15 W=0.42 nf=1 ad=0.1218 as=0.1218 pd=1.42 ps=1.42 nrd=0.69047619047619  nrs=0.69047619047619 sa=0 sb=0 sd=0 mult=1 m=1
XMRD_op1_1000_s2_w15_3 rbl_op1_1000_s2_w15 sn_op1_1000_s2_w15_3 rwl_des 0 sky130_fd_pr__nfet_01v8 L=0.15 W=0.42 nf=1 ad=0.1218 as=0.1218 pd=1.42 ps=1.42 nrd=0.69047619047619  nrs=0.69047619047619 sa=0 sb=0 sd=0 mult=1 m=1
csn_op1_1000_s2_w15_3 sn_op1_1000_s2_w15_3 0 {C_SN}
XMN1_op1_1000_s2_w15 rbl_op1_1000_s2_w15 ref_op1_1000_s2_w15 vn_op1_1000_s2_w15 0 sky130_fd_pr__nfet_01v8 L=0.15 W=1 nf=1 ad=0.29 as=0.29 pd=2.58 ps=2.58 mult=1 m=1
XMN2_op1_1000_s2_w15 ref_op1_1000_s2_w15 rbl_op1_1000_s2_w15 vn_op1_1000_s2_w15 0 sky130_fd_pr__nfet_01v8 L=0.15 W=1 nf=1 ad=0.29 as=0.29 pd=2.58 ps=2.58 mult=1 m=1
XMP1_op1_1000_s2_w15 rbl_op1_1000_s2_w15 ref_op1_1000_s2_w15 vp_op1_1000_s2_w15 vdd sky130_fd_pr__pfet_01v8 L=0.15 W=2 nf=1 ad=0.58 as=0.58 pd=4.58 ps=4.58 mult=1 m=1
XMP2_op1_1000_s2_w15 ref_op1_1000_s2_w15 rbl_op1_1000_s2_w15 vp_op1_1000_s2_w15 vdd sky130_fd_pr__pfet_01v8 L=0.15 W=2 nf=1 ad=0.58 as=0.58 pd=4.58 ps=4.58 mult=1 m=1
XMNF_op1_1000_s2_w15 vn_op1_1000_s2_w15 en_op1_1000_s2_w15 0 0 sky130_fd_pr__nfet_01v8 L=0.15 W=2 nf=1 ad=0.58 as=0.58 pd=4.58 ps=4.58 mult=1 m=1
XMPH_op1_1000_s2_w15 vp_op1_1000_s2_w15 enb_op1_1000_s2_w15 vdd vdd sky130_fd_pr__pfet_01v8 L=0.15 W=4 nf=1 ad=1.16 as=1.16 pd=8.58 ps=8.58 mult=1 m=1
bd_op1_1000_s2_w15 d_op1_1000_s2_w15 0 v=v(rbl_op1_1000_s2_w15)-v(ref_op1_1000_s2_w15)

* ---- instance 93: op1_1000_s2_w20 (t_en 6 ns, WWL 7..27 ns, release 29 ns) ----
ven_op1_1000_s2_w20  en_op1_1000_s2_w20  0 pwl(0 0 6.0000e-09 0 6.1000e-09 {VDD} 2.9000e-08 {VDD} 2.9100e-08 0)
venb_op1_1000_s2_w20 enb_op1_1000_s2_w20 0 pwl(0 {VDD} 6.0000e-09 {VDD} 6.1000e-09 0 2.9000e-08 0 2.9100e-08 {VDD})
vrs_op1_1000_s2_w20  rwls_op1_1000_s2_w20 0 pwl(0 {VDD} {T_READ} {VDD} {T_READ+TEDGE} 0 2.9000e-08 0 2.9100e-08 {VDD})
vww_op1_1000_s2_w20  wwl_op1_1000_s2_w20 0 pwl(0 0 7.0000e-09 0 7.1000e-09 {VDD} 2.7000e-08 {VDD} 2.7100e-08 0)
vwc_op1_1000_s2_w20  wbc_op1_1000_s2_w20 0 pwl(0 0 7.0000e-09 0 7.1000e-09 {VDD} 2.9000e-08 {VDD} 2.9100e-08 0)
swb_op1_1000_s2_w20 ref_op1_1000_s2_w20 wbl_op1_1000_s2_w20 wbc_op1_1000_s2_w20 0 swwbl
cwbl_op1_1000_s2_w20 wbl_op1_1000_s2_w20 0 {C_WBL}
spa_op1_1000_s2_w20 prea rbl_op1_1000_s2_w20 ctl 0 swpre
spr_op1_1000_s2_w20 pref ref_op1_1000_s2_w20 ctl 0 swpre
crbl_op1_1000_s2_w20 rbl_op1_1000_s2_w20 0 {C_RBL}
cref_op1_1000_s2_w20 ref_op1_1000_s2_w20 0 {C_RBL}   $ ASSUMPTION: ideal matched dummy load
XMWR_op1_1000_s2_w20_0 sn_op1_1000_s2_w20_0 wwl_op1_1000_s2_w20 wbl_op1_1000_s2_w20 0 sky130_fd_pr__nfet_01v8 L=0.15 W=0.42 nf=1 ad=0.1218 as=0.1218 pd=1.42 ps=1.42 nrd=0.69047619047619  nrs=0.69047619047619 sa=0 sb=0 sd=0 mult=1 m=1
XMRD_op1_1000_s2_w20_0 rbl_op1_1000_s2_w20 sn_op1_1000_s2_w20_0 rwls_op1_1000_s2_w20 0 sky130_fd_pr__nfet_01v8 L=0.15 W=0.42 nf=1 ad=0.1218 as=0.1218 pd=1.42 ps=1.42 nrd=0.69047619047619  nrs=0.69047619047619 sa=0 sb=0 sd=0 mult=1 m=1
csn_op1_1000_s2_w20_0 sn_op1_1000_s2_w20_0 0 {C_SN}
XMWR_op1_1000_s2_w20_1 sn_op1_1000_s2_w20_1 wwl_des wbl_op1_1000_s2_w20 0 sky130_fd_pr__nfet_01v8 L=0.15 W=0.42 nf=1 ad=0.1218 as=0.1218 pd=1.42 ps=1.42 nrd=0.69047619047619  nrs=0.69047619047619 sa=0 sb=0 sd=0 mult=1 m=1
XMRD_op1_1000_s2_w20_1 rbl_op1_1000_s2_w20 sn_op1_1000_s2_w20_1 rwl_des 0 sky130_fd_pr__nfet_01v8 L=0.15 W=0.42 nf=1 ad=0.1218 as=0.1218 pd=1.42 ps=1.42 nrd=0.69047619047619  nrs=0.69047619047619 sa=0 sb=0 sd=0 mult=1 m=1
csn_op1_1000_s2_w20_1 sn_op1_1000_s2_w20_1 0 {C_SN}
XMWR_op1_1000_s2_w20_2 sn_op1_1000_s2_w20_2 wwl_des wbl_op1_1000_s2_w20 0 sky130_fd_pr__nfet_01v8 L=0.15 W=0.42 nf=1 ad=0.1218 as=0.1218 pd=1.42 ps=1.42 nrd=0.69047619047619  nrs=0.69047619047619 sa=0 sb=0 sd=0 mult=1 m=1
XMRD_op1_1000_s2_w20_2 rbl_op1_1000_s2_w20 sn_op1_1000_s2_w20_2 rwl_des 0 sky130_fd_pr__nfet_01v8 L=0.15 W=0.42 nf=1 ad=0.1218 as=0.1218 pd=1.42 ps=1.42 nrd=0.69047619047619  nrs=0.69047619047619 sa=0 sb=0 sd=0 mult=1 m=1
csn_op1_1000_s2_w20_2 sn_op1_1000_s2_w20_2 0 {C_SN}
XMWR_op1_1000_s2_w20_3 sn_op1_1000_s2_w20_3 wwl_des wbl_op1_1000_s2_w20 0 sky130_fd_pr__nfet_01v8 L=0.15 W=0.42 nf=1 ad=0.1218 as=0.1218 pd=1.42 ps=1.42 nrd=0.69047619047619  nrs=0.69047619047619 sa=0 sb=0 sd=0 mult=1 m=1
XMRD_op1_1000_s2_w20_3 rbl_op1_1000_s2_w20 sn_op1_1000_s2_w20_3 rwl_des 0 sky130_fd_pr__nfet_01v8 L=0.15 W=0.42 nf=1 ad=0.1218 as=0.1218 pd=1.42 ps=1.42 nrd=0.69047619047619  nrs=0.69047619047619 sa=0 sb=0 sd=0 mult=1 m=1
csn_op1_1000_s2_w20_3 sn_op1_1000_s2_w20_3 0 {C_SN}
XMN1_op1_1000_s2_w20 rbl_op1_1000_s2_w20 ref_op1_1000_s2_w20 vn_op1_1000_s2_w20 0 sky130_fd_pr__nfet_01v8 L=0.15 W=1 nf=1 ad=0.29 as=0.29 pd=2.58 ps=2.58 mult=1 m=1
XMN2_op1_1000_s2_w20 ref_op1_1000_s2_w20 rbl_op1_1000_s2_w20 vn_op1_1000_s2_w20 0 sky130_fd_pr__nfet_01v8 L=0.15 W=1 nf=1 ad=0.29 as=0.29 pd=2.58 ps=2.58 mult=1 m=1
XMP1_op1_1000_s2_w20 rbl_op1_1000_s2_w20 ref_op1_1000_s2_w20 vp_op1_1000_s2_w20 vdd sky130_fd_pr__pfet_01v8 L=0.15 W=2 nf=1 ad=0.58 as=0.58 pd=4.58 ps=4.58 mult=1 m=1
XMP2_op1_1000_s2_w20 ref_op1_1000_s2_w20 rbl_op1_1000_s2_w20 vp_op1_1000_s2_w20 vdd sky130_fd_pr__pfet_01v8 L=0.15 W=2 nf=1 ad=0.58 as=0.58 pd=4.58 ps=4.58 mult=1 m=1
XMNF_op1_1000_s2_w20 vn_op1_1000_s2_w20 en_op1_1000_s2_w20 0 0 sky130_fd_pr__nfet_01v8 L=0.15 W=2 nf=1 ad=0.58 as=0.58 pd=4.58 ps=4.58 mult=1 m=1
XMPH_op1_1000_s2_w20 vp_op1_1000_s2_w20 enb_op1_1000_s2_w20 vdd vdd sky130_fd_pr__pfet_01v8 L=0.15 W=4 nf=1 ad=1.16 as=1.16 pd=8.58 ps=8.58 mult=1 m=1
bd_op1_1000_s2_w20 d_op1_1000_s2_w20 0 v=v(rbl_op1_1000_s2_w20)-v(ref_op1_1000_s2_w20)

* ---- instance 94: op1_1000_s2_w30 (t_en 6 ns, WWL 7..37 ns, release 39 ns) ----
ven_op1_1000_s2_w30  en_op1_1000_s2_w30  0 pwl(0 0 6.0000e-09 0 6.1000e-09 {VDD} 3.9000e-08 {VDD} 3.9100e-08 0)
venb_op1_1000_s2_w30 enb_op1_1000_s2_w30 0 pwl(0 {VDD} 6.0000e-09 {VDD} 6.1000e-09 0 3.9000e-08 0 3.9100e-08 {VDD})
vrs_op1_1000_s2_w30  rwls_op1_1000_s2_w30 0 pwl(0 {VDD} {T_READ} {VDD} {T_READ+TEDGE} 0 3.9000e-08 0 3.9100e-08 {VDD})
vww_op1_1000_s2_w30  wwl_op1_1000_s2_w30 0 pwl(0 0 7.0000e-09 0 7.1000e-09 {VDD} 3.7000e-08 {VDD} 3.7100e-08 0)
vwc_op1_1000_s2_w30  wbc_op1_1000_s2_w30 0 pwl(0 0 7.0000e-09 0 7.1000e-09 {VDD} 3.9000e-08 {VDD} 3.9100e-08 0)
swb_op1_1000_s2_w30 ref_op1_1000_s2_w30 wbl_op1_1000_s2_w30 wbc_op1_1000_s2_w30 0 swwbl
cwbl_op1_1000_s2_w30 wbl_op1_1000_s2_w30 0 {C_WBL}
spa_op1_1000_s2_w30 prea rbl_op1_1000_s2_w30 ctl 0 swpre
spr_op1_1000_s2_w30 pref ref_op1_1000_s2_w30 ctl 0 swpre
crbl_op1_1000_s2_w30 rbl_op1_1000_s2_w30 0 {C_RBL}
cref_op1_1000_s2_w30 ref_op1_1000_s2_w30 0 {C_RBL}   $ ASSUMPTION: ideal matched dummy load
XMWR_op1_1000_s2_w30_0 sn_op1_1000_s2_w30_0 wwl_op1_1000_s2_w30 wbl_op1_1000_s2_w30 0 sky130_fd_pr__nfet_01v8 L=0.15 W=0.42 nf=1 ad=0.1218 as=0.1218 pd=1.42 ps=1.42 nrd=0.69047619047619  nrs=0.69047619047619 sa=0 sb=0 sd=0 mult=1 m=1
XMRD_op1_1000_s2_w30_0 rbl_op1_1000_s2_w30 sn_op1_1000_s2_w30_0 rwls_op1_1000_s2_w30 0 sky130_fd_pr__nfet_01v8 L=0.15 W=0.42 nf=1 ad=0.1218 as=0.1218 pd=1.42 ps=1.42 nrd=0.69047619047619  nrs=0.69047619047619 sa=0 sb=0 sd=0 mult=1 m=1
csn_op1_1000_s2_w30_0 sn_op1_1000_s2_w30_0 0 {C_SN}
XMWR_op1_1000_s2_w30_1 sn_op1_1000_s2_w30_1 wwl_des wbl_op1_1000_s2_w30 0 sky130_fd_pr__nfet_01v8 L=0.15 W=0.42 nf=1 ad=0.1218 as=0.1218 pd=1.42 ps=1.42 nrd=0.69047619047619  nrs=0.69047619047619 sa=0 sb=0 sd=0 mult=1 m=1
XMRD_op1_1000_s2_w30_1 rbl_op1_1000_s2_w30 sn_op1_1000_s2_w30_1 rwl_des 0 sky130_fd_pr__nfet_01v8 L=0.15 W=0.42 nf=1 ad=0.1218 as=0.1218 pd=1.42 ps=1.42 nrd=0.69047619047619  nrs=0.69047619047619 sa=0 sb=0 sd=0 mult=1 m=1
csn_op1_1000_s2_w30_1 sn_op1_1000_s2_w30_1 0 {C_SN}
XMWR_op1_1000_s2_w30_2 sn_op1_1000_s2_w30_2 wwl_des wbl_op1_1000_s2_w30 0 sky130_fd_pr__nfet_01v8 L=0.15 W=0.42 nf=1 ad=0.1218 as=0.1218 pd=1.42 ps=1.42 nrd=0.69047619047619  nrs=0.69047619047619 sa=0 sb=0 sd=0 mult=1 m=1
XMRD_op1_1000_s2_w30_2 rbl_op1_1000_s2_w30 sn_op1_1000_s2_w30_2 rwl_des 0 sky130_fd_pr__nfet_01v8 L=0.15 W=0.42 nf=1 ad=0.1218 as=0.1218 pd=1.42 ps=1.42 nrd=0.69047619047619  nrs=0.69047619047619 sa=0 sb=0 sd=0 mult=1 m=1
csn_op1_1000_s2_w30_2 sn_op1_1000_s2_w30_2 0 {C_SN}
XMWR_op1_1000_s2_w30_3 sn_op1_1000_s2_w30_3 wwl_des wbl_op1_1000_s2_w30 0 sky130_fd_pr__nfet_01v8 L=0.15 W=0.42 nf=1 ad=0.1218 as=0.1218 pd=1.42 ps=1.42 nrd=0.69047619047619  nrs=0.69047619047619 sa=0 sb=0 sd=0 mult=1 m=1
XMRD_op1_1000_s2_w30_3 rbl_op1_1000_s2_w30 sn_op1_1000_s2_w30_3 rwl_des 0 sky130_fd_pr__nfet_01v8 L=0.15 W=0.42 nf=1 ad=0.1218 as=0.1218 pd=1.42 ps=1.42 nrd=0.69047619047619  nrs=0.69047619047619 sa=0 sb=0 sd=0 mult=1 m=1
csn_op1_1000_s2_w30_3 sn_op1_1000_s2_w30_3 0 {C_SN}
XMN1_op1_1000_s2_w30 rbl_op1_1000_s2_w30 ref_op1_1000_s2_w30 vn_op1_1000_s2_w30 0 sky130_fd_pr__nfet_01v8 L=0.15 W=1 nf=1 ad=0.29 as=0.29 pd=2.58 ps=2.58 mult=1 m=1
XMN2_op1_1000_s2_w30 ref_op1_1000_s2_w30 rbl_op1_1000_s2_w30 vn_op1_1000_s2_w30 0 sky130_fd_pr__nfet_01v8 L=0.15 W=1 nf=1 ad=0.29 as=0.29 pd=2.58 ps=2.58 mult=1 m=1
XMP1_op1_1000_s2_w30 rbl_op1_1000_s2_w30 ref_op1_1000_s2_w30 vp_op1_1000_s2_w30 vdd sky130_fd_pr__pfet_01v8 L=0.15 W=2 nf=1 ad=0.58 as=0.58 pd=4.58 ps=4.58 mult=1 m=1
XMP2_op1_1000_s2_w30 ref_op1_1000_s2_w30 rbl_op1_1000_s2_w30 vp_op1_1000_s2_w30 vdd sky130_fd_pr__pfet_01v8 L=0.15 W=2 nf=1 ad=0.58 as=0.58 pd=4.58 ps=4.58 mult=1 m=1
XMNF_op1_1000_s2_w30 vn_op1_1000_s2_w30 en_op1_1000_s2_w30 0 0 sky130_fd_pr__nfet_01v8 L=0.15 W=2 nf=1 ad=0.58 as=0.58 pd=4.58 ps=4.58 mult=1 m=1
XMPH_op1_1000_s2_w30 vp_op1_1000_s2_w30 enb_op1_1000_s2_w30 vdd vdd sky130_fd_pr__pfet_01v8 L=0.15 W=4 nf=1 ad=1.16 as=1.16 pd=8.58 ps=8.58 mult=1 m=1
bd_op1_1000_s2_w30 d_op1_1000_s2_w30 0 v=v(rbl_op1_1000_s2_w30)-v(ref_op1_1000_s2_w30)

* ---- instance 95: op1_1000_s2_w50 (t_en 6 ns, WWL 7..57 ns, release 59 ns) ----
ven_op1_1000_s2_w50  en_op1_1000_s2_w50  0 pwl(0 0 6.0000e-09 0 6.1000e-09 {VDD} 5.9000e-08 {VDD} 5.9100e-08 0)
venb_op1_1000_s2_w50 enb_op1_1000_s2_w50 0 pwl(0 {VDD} 6.0000e-09 {VDD} 6.1000e-09 0 5.9000e-08 0 5.9100e-08 {VDD})
vrs_op1_1000_s2_w50  rwls_op1_1000_s2_w50 0 pwl(0 {VDD} {T_READ} {VDD} {T_READ+TEDGE} 0 5.9000e-08 0 5.9100e-08 {VDD})
vww_op1_1000_s2_w50  wwl_op1_1000_s2_w50 0 pwl(0 0 7.0000e-09 0 7.1000e-09 {VDD} 5.7000e-08 {VDD} 5.7100e-08 0)
vwc_op1_1000_s2_w50  wbc_op1_1000_s2_w50 0 pwl(0 0 7.0000e-09 0 7.1000e-09 {VDD} 5.9000e-08 {VDD} 5.9100e-08 0)
swb_op1_1000_s2_w50 ref_op1_1000_s2_w50 wbl_op1_1000_s2_w50 wbc_op1_1000_s2_w50 0 swwbl
cwbl_op1_1000_s2_w50 wbl_op1_1000_s2_w50 0 {C_WBL}
spa_op1_1000_s2_w50 prea rbl_op1_1000_s2_w50 ctl 0 swpre
spr_op1_1000_s2_w50 pref ref_op1_1000_s2_w50 ctl 0 swpre
crbl_op1_1000_s2_w50 rbl_op1_1000_s2_w50 0 {C_RBL}
cref_op1_1000_s2_w50 ref_op1_1000_s2_w50 0 {C_RBL}   $ ASSUMPTION: ideal matched dummy load
XMWR_op1_1000_s2_w50_0 sn_op1_1000_s2_w50_0 wwl_op1_1000_s2_w50 wbl_op1_1000_s2_w50 0 sky130_fd_pr__nfet_01v8 L=0.15 W=0.42 nf=1 ad=0.1218 as=0.1218 pd=1.42 ps=1.42 nrd=0.69047619047619  nrs=0.69047619047619 sa=0 sb=0 sd=0 mult=1 m=1
XMRD_op1_1000_s2_w50_0 rbl_op1_1000_s2_w50 sn_op1_1000_s2_w50_0 rwls_op1_1000_s2_w50 0 sky130_fd_pr__nfet_01v8 L=0.15 W=0.42 nf=1 ad=0.1218 as=0.1218 pd=1.42 ps=1.42 nrd=0.69047619047619  nrs=0.69047619047619 sa=0 sb=0 sd=0 mult=1 m=1
csn_op1_1000_s2_w50_0 sn_op1_1000_s2_w50_0 0 {C_SN}
XMWR_op1_1000_s2_w50_1 sn_op1_1000_s2_w50_1 wwl_des wbl_op1_1000_s2_w50 0 sky130_fd_pr__nfet_01v8 L=0.15 W=0.42 nf=1 ad=0.1218 as=0.1218 pd=1.42 ps=1.42 nrd=0.69047619047619  nrs=0.69047619047619 sa=0 sb=0 sd=0 mult=1 m=1
XMRD_op1_1000_s2_w50_1 rbl_op1_1000_s2_w50 sn_op1_1000_s2_w50_1 rwl_des 0 sky130_fd_pr__nfet_01v8 L=0.15 W=0.42 nf=1 ad=0.1218 as=0.1218 pd=1.42 ps=1.42 nrd=0.69047619047619  nrs=0.69047619047619 sa=0 sb=0 sd=0 mult=1 m=1
csn_op1_1000_s2_w50_1 sn_op1_1000_s2_w50_1 0 {C_SN}
XMWR_op1_1000_s2_w50_2 sn_op1_1000_s2_w50_2 wwl_des wbl_op1_1000_s2_w50 0 sky130_fd_pr__nfet_01v8 L=0.15 W=0.42 nf=1 ad=0.1218 as=0.1218 pd=1.42 ps=1.42 nrd=0.69047619047619  nrs=0.69047619047619 sa=0 sb=0 sd=0 mult=1 m=1
XMRD_op1_1000_s2_w50_2 rbl_op1_1000_s2_w50 sn_op1_1000_s2_w50_2 rwl_des 0 sky130_fd_pr__nfet_01v8 L=0.15 W=0.42 nf=1 ad=0.1218 as=0.1218 pd=1.42 ps=1.42 nrd=0.69047619047619  nrs=0.69047619047619 sa=0 sb=0 sd=0 mult=1 m=1
csn_op1_1000_s2_w50_2 sn_op1_1000_s2_w50_2 0 {C_SN}
XMWR_op1_1000_s2_w50_3 sn_op1_1000_s2_w50_3 wwl_des wbl_op1_1000_s2_w50 0 sky130_fd_pr__nfet_01v8 L=0.15 W=0.42 nf=1 ad=0.1218 as=0.1218 pd=1.42 ps=1.42 nrd=0.69047619047619  nrs=0.69047619047619 sa=0 sb=0 sd=0 mult=1 m=1
XMRD_op1_1000_s2_w50_3 rbl_op1_1000_s2_w50 sn_op1_1000_s2_w50_3 rwl_des 0 sky130_fd_pr__nfet_01v8 L=0.15 W=0.42 nf=1 ad=0.1218 as=0.1218 pd=1.42 ps=1.42 nrd=0.69047619047619  nrs=0.69047619047619 sa=0 sb=0 sd=0 mult=1 m=1
csn_op1_1000_s2_w50_3 sn_op1_1000_s2_w50_3 0 {C_SN}
XMN1_op1_1000_s2_w50 rbl_op1_1000_s2_w50 ref_op1_1000_s2_w50 vn_op1_1000_s2_w50 0 sky130_fd_pr__nfet_01v8 L=0.15 W=1 nf=1 ad=0.29 as=0.29 pd=2.58 ps=2.58 mult=1 m=1
XMN2_op1_1000_s2_w50 ref_op1_1000_s2_w50 rbl_op1_1000_s2_w50 vn_op1_1000_s2_w50 0 sky130_fd_pr__nfet_01v8 L=0.15 W=1 nf=1 ad=0.29 as=0.29 pd=2.58 ps=2.58 mult=1 m=1
XMP1_op1_1000_s2_w50 rbl_op1_1000_s2_w50 ref_op1_1000_s2_w50 vp_op1_1000_s2_w50 vdd sky130_fd_pr__pfet_01v8 L=0.15 W=2 nf=1 ad=0.58 as=0.58 pd=4.58 ps=4.58 mult=1 m=1
XMP2_op1_1000_s2_w50 ref_op1_1000_s2_w50 rbl_op1_1000_s2_w50 vp_op1_1000_s2_w50 vdd sky130_fd_pr__pfet_01v8 L=0.15 W=2 nf=1 ad=0.58 as=0.58 pd=4.58 ps=4.58 mult=1 m=1
XMNF_op1_1000_s2_w50 vn_op1_1000_s2_w50 en_op1_1000_s2_w50 0 0 sky130_fd_pr__nfet_01v8 L=0.15 W=2 nf=1 ad=0.58 as=0.58 pd=4.58 ps=4.58 mult=1 m=1
XMPH_op1_1000_s2_w50 vp_op1_1000_s2_w50 enb_op1_1000_s2_w50 vdd vdd sky130_fd_pr__pfet_01v8 L=0.15 W=4 nf=1 ad=1.16 as=1.16 pd=8.58 ps=8.58 mult=1 m=1
bd_op1_1000_s2_w50 d_op1_1000_s2_w50 0 v=v(rbl_op1_1000_s2_w50)-v(ref_op1_1000_s2_w50)

* ---- instance 96: op1_1000_s5_w0p2 (t_en 9 ns, WWL 10..10.2 ns, release 12.2 ns) ----
ven_op1_1000_s5_w0p2  en_op1_1000_s5_w0p2  0 pwl(0 0 9.0000e-09 0 9.1000e-09 {VDD} 1.2200e-08 {VDD} 1.2300e-08 0)
venb_op1_1000_s5_w0p2 enb_op1_1000_s5_w0p2 0 pwl(0 {VDD} 9.0000e-09 {VDD} 9.1000e-09 0 1.2200e-08 0 1.2300e-08 {VDD})
vrs_op1_1000_s5_w0p2  rwls_op1_1000_s5_w0p2 0 pwl(0 {VDD} {T_READ} {VDD} {T_READ+TEDGE} 0 1.2200e-08 0 1.2300e-08 {VDD})
vww_op1_1000_s5_w0p2  wwl_op1_1000_s5_w0p2 0 pwl(0 0 1.0000e-08 0 1.0100e-08 {VDD} 1.0200e-08 {VDD} 1.0300e-08 0)
vwc_op1_1000_s5_w0p2  wbc_op1_1000_s5_w0p2 0 pwl(0 0 1.0000e-08 0 1.0100e-08 {VDD} 1.2200e-08 {VDD} 1.2300e-08 0)
swb_op1_1000_s5_w0p2 ref_op1_1000_s5_w0p2 wbl_op1_1000_s5_w0p2 wbc_op1_1000_s5_w0p2 0 swwbl
cwbl_op1_1000_s5_w0p2 wbl_op1_1000_s5_w0p2 0 {C_WBL}
spa_op1_1000_s5_w0p2 prea rbl_op1_1000_s5_w0p2 ctl 0 swpre
spr_op1_1000_s5_w0p2 pref ref_op1_1000_s5_w0p2 ctl 0 swpre
crbl_op1_1000_s5_w0p2 rbl_op1_1000_s5_w0p2 0 {C_RBL}
cref_op1_1000_s5_w0p2 ref_op1_1000_s5_w0p2 0 {C_RBL}   $ ASSUMPTION: ideal matched dummy load
XMWR_op1_1000_s5_w0p2_0 sn_op1_1000_s5_w0p2_0 wwl_op1_1000_s5_w0p2 wbl_op1_1000_s5_w0p2 0 sky130_fd_pr__nfet_01v8 L=0.15 W=0.42 nf=1 ad=0.1218 as=0.1218 pd=1.42 ps=1.42 nrd=0.69047619047619  nrs=0.69047619047619 sa=0 sb=0 sd=0 mult=1 m=1
XMRD_op1_1000_s5_w0p2_0 rbl_op1_1000_s5_w0p2 sn_op1_1000_s5_w0p2_0 rwls_op1_1000_s5_w0p2 0 sky130_fd_pr__nfet_01v8 L=0.15 W=0.42 nf=1 ad=0.1218 as=0.1218 pd=1.42 ps=1.42 nrd=0.69047619047619  nrs=0.69047619047619 sa=0 sb=0 sd=0 mult=1 m=1
csn_op1_1000_s5_w0p2_0 sn_op1_1000_s5_w0p2_0 0 {C_SN}
XMWR_op1_1000_s5_w0p2_1 sn_op1_1000_s5_w0p2_1 wwl_des wbl_op1_1000_s5_w0p2 0 sky130_fd_pr__nfet_01v8 L=0.15 W=0.42 nf=1 ad=0.1218 as=0.1218 pd=1.42 ps=1.42 nrd=0.69047619047619  nrs=0.69047619047619 sa=0 sb=0 sd=0 mult=1 m=1
XMRD_op1_1000_s5_w0p2_1 rbl_op1_1000_s5_w0p2 sn_op1_1000_s5_w0p2_1 rwl_des 0 sky130_fd_pr__nfet_01v8 L=0.15 W=0.42 nf=1 ad=0.1218 as=0.1218 pd=1.42 ps=1.42 nrd=0.69047619047619  nrs=0.69047619047619 sa=0 sb=0 sd=0 mult=1 m=1
csn_op1_1000_s5_w0p2_1 sn_op1_1000_s5_w0p2_1 0 {C_SN}
XMWR_op1_1000_s5_w0p2_2 sn_op1_1000_s5_w0p2_2 wwl_des wbl_op1_1000_s5_w0p2 0 sky130_fd_pr__nfet_01v8 L=0.15 W=0.42 nf=1 ad=0.1218 as=0.1218 pd=1.42 ps=1.42 nrd=0.69047619047619  nrs=0.69047619047619 sa=0 sb=0 sd=0 mult=1 m=1
XMRD_op1_1000_s5_w0p2_2 rbl_op1_1000_s5_w0p2 sn_op1_1000_s5_w0p2_2 rwl_des 0 sky130_fd_pr__nfet_01v8 L=0.15 W=0.42 nf=1 ad=0.1218 as=0.1218 pd=1.42 ps=1.42 nrd=0.69047619047619  nrs=0.69047619047619 sa=0 sb=0 sd=0 mult=1 m=1
csn_op1_1000_s5_w0p2_2 sn_op1_1000_s5_w0p2_2 0 {C_SN}
XMWR_op1_1000_s5_w0p2_3 sn_op1_1000_s5_w0p2_3 wwl_des wbl_op1_1000_s5_w0p2 0 sky130_fd_pr__nfet_01v8 L=0.15 W=0.42 nf=1 ad=0.1218 as=0.1218 pd=1.42 ps=1.42 nrd=0.69047619047619  nrs=0.69047619047619 sa=0 sb=0 sd=0 mult=1 m=1
XMRD_op1_1000_s5_w0p2_3 rbl_op1_1000_s5_w0p2 sn_op1_1000_s5_w0p2_3 rwl_des 0 sky130_fd_pr__nfet_01v8 L=0.15 W=0.42 nf=1 ad=0.1218 as=0.1218 pd=1.42 ps=1.42 nrd=0.69047619047619  nrs=0.69047619047619 sa=0 sb=0 sd=0 mult=1 m=1
csn_op1_1000_s5_w0p2_3 sn_op1_1000_s5_w0p2_3 0 {C_SN}
XMN1_op1_1000_s5_w0p2 rbl_op1_1000_s5_w0p2 ref_op1_1000_s5_w0p2 vn_op1_1000_s5_w0p2 0 sky130_fd_pr__nfet_01v8 L=0.15 W=1 nf=1 ad=0.29 as=0.29 pd=2.58 ps=2.58 mult=1 m=1
XMN2_op1_1000_s5_w0p2 ref_op1_1000_s5_w0p2 rbl_op1_1000_s5_w0p2 vn_op1_1000_s5_w0p2 0 sky130_fd_pr__nfet_01v8 L=0.15 W=1 nf=1 ad=0.29 as=0.29 pd=2.58 ps=2.58 mult=1 m=1
XMP1_op1_1000_s5_w0p2 rbl_op1_1000_s5_w0p2 ref_op1_1000_s5_w0p2 vp_op1_1000_s5_w0p2 vdd sky130_fd_pr__pfet_01v8 L=0.15 W=2 nf=1 ad=0.58 as=0.58 pd=4.58 ps=4.58 mult=1 m=1
XMP2_op1_1000_s5_w0p2 ref_op1_1000_s5_w0p2 rbl_op1_1000_s5_w0p2 vp_op1_1000_s5_w0p2 vdd sky130_fd_pr__pfet_01v8 L=0.15 W=2 nf=1 ad=0.58 as=0.58 pd=4.58 ps=4.58 mult=1 m=1
XMNF_op1_1000_s5_w0p2 vn_op1_1000_s5_w0p2 en_op1_1000_s5_w0p2 0 0 sky130_fd_pr__nfet_01v8 L=0.15 W=2 nf=1 ad=0.58 as=0.58 pd=4.58 ps=4.58 mult=1 m=1
XMPH_op1_1000_s5_w0p2 vp_op1_1000_s5_w0p2 enb_op1_1000_s5_w0p2 vdd vdd sky130_fd_pr__pfet_01v8 L=0.15 W=4 nf=1 ad=1.16 as=1.16 pd=8.58 ps=8.58 mult=1 m=1
bd_op1_1000_s5_w0p2 d_op1_1000_s5_w0p2 0 v=v(rbl_op1_1000_s5_w0p2)-v(ref_op1_1000_s5_w0p2)

* ---- instance 97: op1_1000_s5_w0p5 (t_en 9 ns, WWL 10..10.5 ns, release 12.5 ns) ----
ven_op1_1000_s5_w0p5  en_op1_1000_s5_w0p5  0 pwl(0 0 9.0000e-09 0 9.1000e-09 {VDD} 1.2500e-08 {VDD} 1.2600e-08 0)
venb_op1_1000_s5_w0p5 enb_op1_1000_s5_w0p5 0 pwl(0 {VDD} 9.0000e-09 {VDD} 9.1000e-09 0 1.2500e-08 0 1.2600e-08 {VDD})
vrs_op1_1000_s5_w0p5  rwls_op1_1000_s5_w0p5 0 pwl(0 {VDD} {T_READ} {VDD} {T_READ+TEDGE} 0 1.2500e-08 0 1.2600e-08 {VDD})
vww_op1_1000_s5_w0p5  wwl_op1_1000_s5_w0p5 0 pwl(0 0 1.0000e-08 0 1.0100e-08 {VDD} 1.0500e-08 {VDD} 1.0600e-08 0)
vwc_op1_1000_s5_w0p5  wbc_op1_1000_s5_w0p5 0 pwl(0 0 1.0000e-08 0 1.0100e-08 {VDD} 1.2500e-08 {VDD} 1.2600e-08 0)
swb_op1_1000_s5_w0p5 ref_op1_1000_s5_w0p5 wbl_op1_1000_s5_w0p5 wbc_op1_1000_s5_w0p5 0 swwbl
cwbl_op1_1000_s5_w0p5 wbl_op1_1000_s5_w0p5 0 {C_WBL}
spa_op1_1000_s5_w0p5 prea rbl_op1_1000_s5_w0p5 ctl 0 swpre
spr_op1_1000_s5_w0p5 pref ref_op1_1000_s5_w0p5 ctl 0 swpre
crbl_op1_1000_s5_w0p5 rbl_op1_1000_s5_w0p5 0 {C_RBL}
cref_op1_1000_s5_w0p5 ref_op1_1000_s5_w0p5 0 {C_RBL}   $ ASSUMPTION: ideal matched dummy load
XMWR_op1_1000_s5_w0p5_0 sn_op1_1000_s5_w0p5_0 wwl_op1_1000_s5_w0p5 wbl_op1_1000_s5_w0p5 0 sky130_fd_pr__nfet_01v8 L=0.15 W=0.42 nf=1 ad=0.1218 as=0.1218 pd=1.42 ps=1.42 nrd=0.69047619047619  nrs=0.69047619047619 sa=0 sb=0 sd=0 mult=1 m=1
XMRD_op1_1000_s5_w0p5_0 rbl_op1_1000_s5_w0p5 sn_op1_1000_s5_w0p5_0 rwls_op1_1000_s5_w0p5 0 sky130_fd_pr__nfet_01v8 L=0.15 W=0.42 nf=1 ad=0.1218 as=0.1218 pd=1.42 ps=1.42 nrd=0.69047619047619  nrs=0.69047619047619 sa=0 sb=0 sd=0 mult=1 m=1
csn_op1_1000_s5_w0p5_0 sn_op1_1000_s5_w0p5_0 0 {C_SN}
XMWR_op1_1000_s5_w0p5_1 sn_op1_1000_s5_w0p5_1 wwl_des wbl_op1_1000_s5_w0p5 0 sky130_fd_pr__nfet_01v8 L=0.15 W=0.42 nf=1 ad=0.1218 as=0.1218 pd=1.42 ps=1.42 nrd=0.69047619047619  nrs=0.69047619047619 sa=0 sb=0 sd=0 mult=1 m=1
XMRD_op1_1000_s5_w0p5_1 rbl_op1_1000_s5_w0p5 sn_op1_1000_s5_w0p5_1 rwl_des 0 sky130_fd_pr__nfet_01v8 L=0.15 W=0.42 nf=1 ad=0.1218 as=0.1218 pd=1.42 ps=1.42 nrd=0.69047619047619  nrs=0.69047619047619 sa=0 sb=0 sd=0 mult=1 m=1
csn_op1_1000_s5_w0p5_1 sn_op1_1000_s5_w0p5_1 0 {C_SN}
XMWR_op1_1000_s5_w0p5_2 sn_op1_1000_s5_w0p5_2 wwl_des wbl_op1_1000_s5_w0p5 0 sky130_fd_pr__nfet_01v8 L=0.15 W=0.42 nf=1 ad=0.1218 as=0.1218 pd=1.42 ps=1.42 nrd=0.69047619047619  nrs=0.69047619047619 sa=0 sb=0 sd=0 mult=1 m=1
XMRD_op1_1000_s5_w0p5_2 rbl_op1_1000_s5_w0p5 sn_op1_1000_s5_w0p5_2 rwl_des 0 sky130_fd_pr__nfet_01v8 L=0.15 W=0.42 nf=1 ad=0.1218 as=0.1218 pd=1.42 ps=1.42 nrd=0.69047619047619  nrs=0.69047619047619 sa=0 sb=0 sd=0 mult=1 m=1
csn_op1_1000_s5_w0p5_2 sn_op1_1000_s5_w0p5_2 0 {C_SN}
XMWR_op1_1000_s5_w0p5_3 sn_op1_1000_s5_w0p5_3 wwl_des wbl_op1_1000_s5_w0p5 0 sky130_fd_pr__nfet_01v8 L=0.15 W=0.42 nf=1 ad=0.1218 as=0.1218 pd=1.42 ps=1.42 nrd=0.69047619047619  nrs=0.69047619047619 sa=0 sb=0 sd=0 mult=1 m=1
XMRD_op1_1000_s5_w0p5_3 rbl_op1_1000_s5_w0p5 sn_op1_1000_s5_w0p5_3 rwl_des 0 sky130_fd_pr__nfet_01v8 L=0.15 W=0.42 nf=1 ad=0.1218 as=0.1218 pd=1.42 ps=1.42 nrd=0.69047619047619  nrs=0.69047619047619 sa=0 sb=0 sd=0 mult=1 m=1
csn_op1_1000_s5_w0p5_3 sn_op1_1000_s5_w0p5_3 0 {C_SN}
XMN1_op1_1000_s5_w0p5 rbl_op1_1000_s5_w0p5 ref_op1_1000_s5_w0p5 vn_op1_1000_s5_w0p5 0 sky130_fd_pr__nfet_01v8 L=0.15 W=1 nf=1 ad=0.29 as=0.29 pd=2.58 ps=2.58 mult=1 m=1
XMN2_op1_1000_s5_w0p5 ref_op1_1000_s5_w0p5 rbl_op1_1000_s5_w0p5 vn_op1_1000_s5_w0p5 0 sky130_fd_pr__nfet_01v8 L=0.15 W=1 nf=1 ad=0.29 as=0.29 pd=2.58 ps=2.58 mult=1 m=1
XMP1_op1_1000_s5_w0p5 rbl_op1_1000_s5_w0p5 ref_op1_1000_s5_w0p5 vp_op1_1000_s5_w0p5 vdd sky130_fd_pr__pfet_01v8 L=0.15 W=2 nf=1 ad=0.58 as=0.58 pd=4.58 ps=4.58 mult=1 m=1
XMP2_op1_1000_s5_w0p5 ref_op1_1000_s5_w0p5 rbl_op1_1000_s5_w0p5 vp_op1_1000_s5_w0p5 vdd sky130_fd_pr__pfet_01v8 L=0.15 W=2 nf=1 ad=0.58 as=0.58 pd=4.58 ps=4.58 mult=1 m=1
XMNF_op1_1000_s5_w0p5 vn_op1_1000_s5_w0p5 en_op1_1000_s5_w0p5 0 0 sky130_fd_pr__nfet_01v8 L=0.15 W=2 nf=1 ad=0.58 as=0.58 pd=4.58 ps=4.58 mult=1 m=1
XMPH_op1_1000_s5_w0p5 vp_op1_1000_s5_w0p5 enb_op1_1000_s5_w0p5 vdd vdd sky130_fd_pr__pfet_01v8 L=0.15 W=4 nf=1 ad=1.16 as=1.16 pd=8.58 ps=8.58 mult=1 m=1
bd_op1_1000_s5_w0p5 d_op1_1000_s5_w0p5 0 v=v(rbl_op1_1000_s5_w0p5)-v(ref_op1_1000_s5_w0p5)

* ---- instance 98: op1_1000_s5_w1 (t_en 9 ns, WWL 10..11 ns, release 13 ns) ----
ven_op1_1000_s5_w1  en_op1_1000_s5_w1  0 pwl(0 0 9.0000e-09 0 9.1000e-09 {VDD} 1.3000e-08 {VDD} 1.3100e-08 0)
venb_op1_1000_s5_w1 enb_op1_1000_s5_w1 0 pwl(0 {VDD} 9.0000e-09 {VDD} 9.1000e-09 0 1.3000e-08 0 1.3100e-08 {VDD})
vrs_op1_1000_s5_w1  rwls_op1_1000_s5_w1 0 pwl(0 {VDD} {T_READ} {VDD} {T_READ+TEDGE} 0 1.3000e-08 0 1.3100e-08 {VDD})
vww_op1_1000_s5_w1  wwl_op1_1000_s5_w1 0 pwl(0 0 1.0000e-08 0 1.0100e-08 {VDD} 1.1000e-08 {VDD} 1.1100e-08 0)
vwc_op1_1000_s5_w1  wbc_op1_1000_s5_w1 0 pwl(0 0 1.0000e-08 0 1.0100e-08 {VDD} 1.3000e-08 {VDD} 1.3100e-08 0)
swb_op1_1000_s5_w1 ref_op1_1000_s5_w1 wbl_op1_1000_s5_w1 wbc_op1_1000_s5_w1 0 swwbl
cwbl_op1_1000_s5_w1 wbl_op1_1000_s5_w1 0 {C_WBL}
spa_op1_1000_s5_w1 prea rbl_op1_1000_s5_w1 ctl 0 swpre
spr_op1_1000_s5_w1 pref ref_op1_1000_s5_w1 ctl 0 swpre
crbl_op1_1000_s5_w1 rbl_op1_1000_s5_w1 0 {C_RBL}
cref_op1_1000_s5_w1 ref_op1_1000_s5_w1 0 {C_RBL}   $ ASSUMPTION: ideal matched dummy load
XMWR_op1_1000_s5_w1_0 sn_op1_1000_s5_w1_0 wwl_op1_1000_s5_w1 wbl_op1_1000_s5_w1 0 sky130_fd_pr__nfet_01v8 L=0.15 W=0.42 nf=1 ad=0.1218 as=0.1218 pd=1.42 ps=1.42 nrd=0.69047619047619  nrs=0.69047619047619 sa=0 sb=0 sd=0 mult=1 m=1
XMRD_op1_1000_s5_w1_0 rbl_op1_1000_s5_w1 sn_op1_1000_s5_w1_0 rwls_op1_1000_s5_w1 0 sky130_fd_pr__nfet_01v8 L=0.15 W=0.42 nf=1 ad=0.1218 as=0.1218 pd=1.42 ps=1.42 nrd=0.69047619047619  nrs=0.69047619047619 sa=0 sb=0 sd=0 mult=1 m=1
csn_op1_1000_s5_w1_0 sn_op1_1000_s5_w1_0 0 {C_SN}
XMWR_op1_1000_s5_w1_1 sn_op1_1000_s5_w1_1 wwl_des wbl_op1_1000_s5_w1 0 sky130_fd_pr__nfet_01v8 L=0.15 W=0.42 nf=1 ad=0.1218 as=0.1218 pd=1.42 ps=1.42 nrd=0.69047619047619  nrs=0.69047619047619 sa=0 sb=0 sd=0 mult=1 m=1
XMRD_op1_1000_s5_w1_1 rbl_op1_1000_s5_w1 sn_op1_1000_s5_w1_1 rwl_des 0 sky130_fd_pr__nfet_01v8 L=0.15 W=0.42 nf=1 ad=0.1218 as=0.1218 pd=1.42 ps=1.42 nrd=0.69047619047619  nrs=0.69047619047619 sa=0 sb=0 sd=0 mult=1 m=1
csn_op1_1000_s5_w1_1 sn_op1_1000_s5_w1_1 0 {C_SN}
XMWR_op1_1000_s5_w1_2 sn_op1_1000_s5_w1_2 wwl_des wbl_op1_1000_s5_w1 0 sky130_fd_pr__nfet_01v8 L=0.15 W=0.42 nf=1 ad=0.1218 as=0.1218 pd=1.42 ps=1.42 nrd=0.69047619047619  nrs=0.69047619047619 sa=0 sb=0 sd=0 mult=1 m=1
XMRD_op1_1000_s5_w1_2 rbl_op1_1000_s5_w1 sn_op1_1000_s5_w1_2 rwl_des 0 sky130_fd_pr__nfet_01v8 L=0.15 W=0.42 nf=1 ad=0.1218 as=0.1218 pd=1.42 ps=1.42 nrd=0.69047619047619  nrs=0.69047619047619 sa=0 sb=0 sd=0 mult=1 m=1
csn_op1_1000_s5_w1_2 sn_op1_1000_s5_w1_2 0 {C_SN}
XMWR_op1_1000_s5_w1_3 sn_op1_1000_s5_w1_3 wwl_des wbl_op1_1000_s5_w1 0 sky130_fd_pr__nfet_01v8 L=0.15 W=0.42 nf=1 ad=0.1218 as=0.1218 pd=1.42 ps=1.42 nrd=0.69047619047619  nrs=0.69047619047619 sa=0 sb=0 sd=0 mult=1 m=1
XMRD_op1_1000_s5_w1_3 rbl_op1_1000_s5_w1 sn_op1_1000_s5_w1_3 rwl_des 0 sky130_fd_pr__nfet_01v8 L=0.15 W=0.42 nf=1 ad=0.1218 as=0.1218 pd=1.42 ps=1.42 nrd=0.69047619047619  nrs=0.69047619047619 sa=0 sb=0 sd=0 mult=1 m=1
csn_op1_1000_s5_w1_3 sn_op1_1000_s5_w1_3 0 {C_SN}
XMN1_op1_1000_s5_w1 rbl_op1_1000_s5_w1 ref_op1_1000_s5_w1 vn_op1_1000_s5_w1 0 sky130_fd_pr__nfet_01v8 L=0.15 W=1 nf=1 ad=0.29 as=0.29 pd=2.58 ps=2.58 mult=1 m=1
XMN2_op1_1000_s5_w1 ref_op1_1000_s5_w1 rbl_op1_1000_s5_w1 vn_op1_1000_s5_w1 0 sky130_fd_pr__nfet_01v8 L=0.15 W=1 nf=1 ad=0.29 as=0.29 pd=2.58 ps=2.58 mult=1 m=1
XMP1_op1_1000_s5_w1 rbl_op1_1000_s5_w1 ref_op1_1000_s5_w1 vp_op1_1000_s5_w1 vdd sky130_fd_pr__pfet_01v8 L=0.15 W=2 nf=1 ad=0.58 as=0.58 pd=4.58 ps=4.58 mult=1 m=1
XMP2_op1_1000_s5_w1 ref_op1_1000_s5_w1 rbl_op1_1000_s5_w1 vp_op1_1000_s5_w1 vdd sky130_fd_pr__pfet_01v8 L=0.15 W=2 nf=1 ad=0.58 as=0.58 pd=4.58 ps=4.58 mult=1 m=1
XMNF_op1_1000_s5_w1 vn_op1_1000_s5_w1 en_op1_1000_s5_w1 0 0 sky130_fd_pr__nfet_01v8 L=0.15 W=2 nf=1 ad=0.58 as=0.58 pd=4.58 ps=4.58 mult=1 m=1
XMPH_op1_1000_s5_w1 vp_op1_1000_s5_w1 enb_op1_1000_s5_w1 vdd vdd sky130_fd_pr__pfet_01v8 L=0.15 W=4 nf=1 ad=1.16 as=1.16 pd=8.58 ps=8.58 mult=1 m=1
bd_op1_1000_s5_w1 d_op1_1000_s5_w1 0 v=v(rbl_op1_1000_s5_w1)-v(ref_op1_1000_s5_w1)

* ---- instance 99: op1_1000_s5_w2 (t_en 9 ns, WWL 10..12 ns, release 14 ns) ----
ven_op1_1000_s5_w2  en_op1_1000_s5_w2  0 pwl(0 0 9.0000e-09 0 9.1000e-09 {VDD} 1.4000e-08 {VDD} 1.4100e-08 0)
venb_op1_1000_s5_w2 enb_op1_1000_s5_w2 0 pwl(0 {VDD} 9.0000e-09 {VDD} 9.1000e-09 0 1.4000e-08 0 1.4100e-08 {VDD})
vrs_op1_1000_s5_w2  rwls_op1_1000_s5_w2 0 pwl(0 {VDD} {T_READ} {VDD} {T_READ+TEDGE} 0 1.4000e-08 0 1.4100e-08 {VDD})
vww_op1_1000_s5_w2  wwl_op1_1000_s5_w2 0 pwl(0 0 1.0000e-08 0 1.0100e-08 {VDD} 1.2000e-08 {VDD} 1.2100e-08 0)
vwc_op1_1000_s5_w2  wbc_op1_1000_s5_w2 0 pwl(0 0 1.0000e-08 0 1.0100e-08 {VDD} 1.4000e-08 {VDD} 1.4100e-08 0)
swb_op1_1000_s5_w2 ref_op1_1000_s5_w2 wbl_op1_1000_s5_w2 wbc_op1_1000_s5_w2 0 swwbl
cwbl_op1_1000_s5_w2 wbl_op1_1000_s5_w2 0 {C_WBL}
spa_op1_1000_s5_w2 prea rbl_op1_1000_s5_w2 ctl 0 swpre
spr_op1_1000_s5_w2 pref ref_op1_1000_s5_w2 ctl 0 swpre
crbl_op1_1000_s5_w2 rbl_op1_1000_s5_w2 0 {C_RBL}
cref_op1_1000_s5_w2 ref_op1_1000_s5_w2 0 {C_RBL}   $ ASSUMPTION: ideal matched dummy load
XMWR_op1_1000_s5_w2_0 sn_op1_1000_s5_w2_0 wwl_op1_1000_s5_w2 wbl_op1_1000_s5_w2 0 sky130_fd_pr__nfet_01v8 L=0.15 W=0.42 nf=1 ad=0.1218 as=0.1218 pd=1.42 ps=1.42 nrd=0.69047619047619  nrs=0.69047619047619 sa=0 sb=0 sd=0 mult=1 m=1
XMRD_op1_1000_s5_w2_0 rbl_op1_1000_s5_w2 sn_op1_1000_s5_w2_0 rwls_op1_1000_s5_w2 0 sky130_fd_pr__nfet_01v8 L=0.15 W=0.42 nf=1 ad=0.1218 as=0.1218 pd=1.42 ps=1.42 nrd=0.69047619047619  nrs=0.69047619047619 sa=0 sb=0 sd=0 mult=1 m=1
csn_op1_1000_s5_w2_0 sn_op1_1000_s5_w2_0 0 {C_SN}
XMWR_op1_1000_s5_w2_1 sn_op1_1000_s5_w2_1 wwl_des wbl_op1_1000_s5_w2 0 sky130_fd_pr__nfet_01v8 L=0.15 W=0.42 nf=1 ad=0.1218 as=0.1218 pd=1.42 ps=1.42 nrd=0.69047619047619  nrs=0.69047619047619 sa=0 sb=0 sd=0 mult=1 m=1
XMRD_op1_1000_s5_w2_1 rbl_op1_1000_s5_w2 sn_op1_1000_s5_w2_1 rwl_des 0 sky130_fd_pr__nfet_01v8 L=0.15 W=0.42 nf=1 ad=0.1218 as=0.1218 pd=1.42 ps=1.42 nrd=0.69047619047619  nrs=0.69047619047619 sa=0 sb=0 sd=0 mult=1 m=1
csn_op1_1000_s5_w2_1 sn_op1_1000_s5_w2_1 0 {C_SN}
XMWR_op1_1000_s5_w2_2 sn_op1_1000_s5_w2_2 wwl_des wbl_op1_1000_s5_w2 0 sky130_fd_pr__nfet_01v8 L=0.15 W=0.42 nf=1 ad=0.1218 as=0.1218 pd=1.42 ps=1.42 nrd=0.69047619047619  nrs=0.69047619047619 sa=0 sb=0 sd=0 mult=1 m=1
XMRD_op1_1000_s5_w2_2 rbl_op1_1000_s5_w2 sn_op1_1000_s5_w2_2 rwl_des 0 sky130_fd_pr__nfet_01v8 L=0.15 W=0.42 nf=1 ad=0.1218 as=0.1218 pd=1.42 ps=1.42 nrd=0.69047619047619  nrs=0.69047619047619 sa=0 sb=0 sd=0 mult=1 m=1
csn_op1_1000_s5_w2_2 sn_op1_1000_s5_w2_2 0 {C_SN}
XMWR_op1_1000_s5_w2_3 sn_op1_1000_s5_w2_3 wwl_des wbl_op1_1000_s5_w2 0 sky130_fd_pr__nfet_01v8 L=0.15 W=0.42 nf=1 ad=0.1218 as=0.1218 pd=1.42 ps=1.42 nrd=0.69047619047619  nrs=0.69047619047619 sa=0 sb=0 sd=0 mult=1 m=1
XMRD_op1_1000_s5_w2_3 rbl_op1_1000_s5_w2 sn_op1_1000_s5_w2_3 rwl_des 0 sky130_fd_pr__nfet_01v8 L=0.15 W=0.42 nf=1 ad=0.1218 as=0.1218 pd=1.42 ps=1.42 nrd=0.69047619047619  nrs=0.69047619047619 sa=0 sb=0 sd=0 mult=1 m=1
csn_op1_1000_s5_w2_3 sn_op1_1000_s5_w2_3 0 {C_SN}
XMN1_op1_1000_s5_w2 rbl_op1_1000_s5_w2 ref_op1_1000_s5_w2 vn_op1_1000_s5_w2 0 sky130_fd_pr__nfet_01v8 L=0.15 W=1 nf=1 ad=0.29 as=0.29 pd=2.58 ps=2.58 mult=1 m=1
XMN2_op1_1000_s5_w2 ref_op1_1000_s5_w2 rbl_op1_1000_s5_w2 vn_op1_1000_s5_w2 0 sky130_fd_pr__nfet_01v8 L=0.15 W=1 nf=1 ad=0.29 as=0.29 pd=2.58 ps=2.58 mult=1 m=1
XMP1_op1_1000_s5_w2 rbl_op1_1000_s5_w2 ref_op1_1000_s5_w2 vp_op1_1000_s5_w2 vdd sky130_fd_pr__pfet_01v8 L=0.15 W=2 nf=1 ad=0.58 as=0.58 pd=4.58 ps=4.58 mult=1 m=1
XMP2_op1_1000_s5_w2 ref_op1_1000_s5_w2 rbl_op1_1000_s5_w2 vp_op1_1000_s5_w2 vdd sky130_fd_pr__pfet_01v8 L=0.15 W=2 nf=1 ad=0.58 as=0.58 pd=4.58 ps=4.58 mult=1 m=1
XMNF_op1_1000_s5_w2 vn_op1_1000_s5_w2 en_op1_1000_s5_w2 0 0 sky130_fd_pr__nfet_01v8 L=0.15 W=2 nf=1 ad=0.58 as=0.58 pd=4.58 ps=4.58 mult=1 m=1
XMPH_op1_1000_s5_w2 vp_op1_1000_s5_w2 enb_op1_1000_s5_w2 vdd vdd sky130_fd_pr__pfet_01v8 L=0.15 W=4 nf=1 ad=1.16 as=1.16 pd=8.58 ps=8.58 mult=1 m=1
bd_op1_1000_s5_w2 d_op1_1000_s5_w2 0 v=v(rbl_op1_1000_s5_w2)-v(ref_op1_1000_s5_w2)

* ---- instance 100: op1_1000_s5_w3 (t_en 9 ns, WWL 10..13 ns, release 15 ns) ----
ven_op1_1000_s5_w3  en_op1_1000_s5_w3  0 pwl(0 0 9.0000e-09 0 9.1000e-09 {VDD} 1.5000e-08 {VDD} 1.5100e-08 0)
venb_op1_1000_s5_w3 enb_op1_1000_s5_w3 0 pwl(0 {VDD} 9.0000e-09 {VDD} 9.1000e-09 0 1.5000e-08 0 1.5100e-08 {VDD})
vrs_op1_1000_s5_w3  rwls_op1_1000_s5_w3 0 pwl(0 {VDD} {T_READ} {VDD} {T_READ+TEDGE} 0 1.5000e-08 0 1.5100e-08 {VDD})
vww_op1_1000_s5_w3  wwl_op1_1000_s5_w3 0 pwl(0 0 1.0000e-08 0 1.0100e-08 {VDD} 1.3000e-08 {VDD} 1.3100e-08 0)
vwc_op1_1000_s5_w3  wbc_op1_1000_s5_w3 0 pwl(0 0 1.0000e-08 0 1.0100e-08 {VDD} 1.5000e-08 {VDD} 1.5100e-08 0)
swb_op1_1000_s5_w3 ref_op1_1000_s5_w3 wbl_op1_1000_s5_w3 wbc_op1_1000_s5_w3 0 swwbl
cwbl_op1_1000_s5_w3 wbl_op1_1000_s5_w3 0 {C_WBL}
spa_op1_1000_s5_w3 prea rbl_op1_1000_s5_w3 ctl 0 swpre
spr_op1_1000_s5_w3 pref ref_op1_1000_s5_w3 ctl 0 swpre
crbl_op1_1000_s5_w3 rbl_op1_1000_s5_w3 0 {C_RBL}
cref_op1_1000_s5_w3 ref_op1_1000_s5_w3 0 {C_RBL}   $ ASSUMPTION: ideal matched dummy load
XMWR_op1_1000_s5_w3_0 sn_op1_1000_s5_w3_0 wwl_op1_1000_s5_w3 wbl_op1_1000_s5_w3 0 sky130_fd_pr__nfet_01v8 L=0.15 W=0.42 nf=1 ad=0.1218 as=0.1218 pd=1.42 ps=1.42 nrd=0.69047619047619  nrs=0.69047619047619 sa=0 sb=0 sd=0 mult=1 m=1
XMRD_op1_1000_s5_w3_0 rbl_op1_1000_s5_w3 sn_op1_1000_s5_w3_0 rwls_op1_1000_s5_w3 0 sky130_fd_pr__nfet_01v8 L=0.15 W=0.42 nf=1 ad=0.1218 as=0.1218 pd=1.42 ps=1.42 nrd=0.69047619047619  nrs=0.69047619047619 sa=0 sb=0 sd=0 mult=1 m=1
csn_op1_1000_s5_w3_0 sn_op1_1000_s5_w3_0 0 {C_SN}
XMWR_op1_1000_s5_w3_1 sn_op1_1000_s5_w3_1 wwl_des wbl_op1_1000_s5_w3 0 sky130_fd_pr__nfet_01v8 L=0.15 W=0.42 nf=1 ad=0.1218 as=0.1218 pd=1.42 ps=1.42 nrd=0.69047619047619  nrs=0.69047619047619 sa=0 sb=0 sd=0 mult=1 m=1
XMRD_op1_1000_s5_w3_1 rbl_op1_1000_s5_w3 sn_op1_1000_s5_w3_1 rwl_des 0 sky130_fd_pr__nfet_01v8 L=0.15 W=0.42 nf=1 ad=0.1218 as=0.1218 pd=1.42 ps=1.42 nrd=0.69047619047619  nrs=0.69047619047619 sa=0 sb=0 sd=0 mult=1 m=1
csn_op1_1000_s5_w3_1 sn_op1_1000_s5_w3_1 0 {C_SN}
XMWR_op1_1000_s5_w3_2 sn_op1_1000_s5_w3_2 wwl_des wbl_op1_1000_s5_w3 0 sky130_fd_pr__nfet_01v8 L=0.15 W=0.42 nf=1 ad=0.1218 as=0.1218 pd=1.42 ps=1.42 nrd=0.69047619047619  nrs=0.69047619047619 sa=0 sb=0 sd=0 mult=1 m=1
XMRD_op1_1000_s5_w3_2 rbl_op1_1000_s5_w3 sn_op1_1000_s5_w3_2 rwl_des 0 sky130_fd_pr__nfet_01v8 L=0.15 W=0.42 nf=1 ad=0.1218 as=0.1218 pd=1.42 ps=1.42 nrd=0.69047619047619  nrs=0.69047619047619 sa=0 sb=0 sd=0 mult=1 m=1
csn_op1_1000_s5_w3_2 sn_op1_1000_s5_w3_2 0 {C_SN}
XMWR_op1_1000_s5_w3_3 sn_op1_1000_s5_w3_3 wwl_des wbl_op1_1000_s5_w3 0 sky130_fd_pr__nfet_01v8 L=0.15 W=0.42 nf=1 ad=0.1218 as=0.1218 pd=1.42 ps=1.42 nrd=0.69047619047619  nrs=0.69047619047619 sa=0 sb=0 sd=0 mult=1 m=1
XMRD_op1_1000_s5_w3_3 rbl_op1_1000_s5_w3 sn_op1_1000_s5_w3_3 rwl_des 0 sky130_fd_pr__nfet_01v8 L=0.15 W=0.42 nf=1 ad=0.1218 as=0.1218 pd=1.42 ps=1.42 nrd=0.69047619047619  nrs=0.69047619047619 sa=0 sb=0 sd=0 mult=1 m=1
csn_op1_1000_s5_w3_3 sn_op1_1000_s5_w3_3 0 {C_SN}
XMN1_op1_1000_s5_w3 rbl_op1_1000_s5_w3 ref_op1_1000_s5_w3 vn_op1_1000_s5_w3 0 sky130_fd_pr__nfet_01v8 L=0.15 W=1 nf=1 ad=0.29 as=0.29 pd=2.58 ps=2.58 mult=1 m=1
XMN2_op1_1000_s5_w3 ref_op1_1000_s5_w3 rbl_op1_1000_s5_w3 vn_op1_1000_s5_w3 0 sky130_fd_pr__nfet_01v8 L=0.15 W=1 nf=1 ad=0.29 as=0.29 pd=2.58 ps=2.58 mult=1 m=1
XMP1_op1_1000_s5_w3 rbl_op1_1000_s5_w3 ref_op1_1000_s5_w3 vp_op1_1000_s5_w3 vdd sky130_fd_pr__pfet_01v8 L=0.15 W=2 nf=1 ad=0.58 as=0.58 pd=4.58 ps=4.58 mult=1 m=1
XMP2_op1_1000_s5_w3 ref_op1_1000_s5_w3 rbl_op1_1000_s5_w3 vp_op1_1000_s5_w3 vdd sky130_fd_pr__pfet_01v8 L=0.15 W=2 nf=1 ad=0.58 as=0.58 pd=4.58 ps=4.58 mult=1 m=1
XMNF_op1_1000_s5_w3 vn_op1_1000_s5_w3 en_op1_1000_s5_w3 0 0 sky130_fd_pr__nfet_01v8 L=0.15 W=2 nf=1 ad=0.58 as=0.58 pd=4.58 ps=4.58 mult=1 m=1
XMPH_op1_1000_s5_w3 vp_op1_1000_s5_w3 enb_op1_1000_s5_w3 vdd vdd sky130_fd_pr__pfet_01v8 L=0.15 W=4 nf=1 ad=1.16 as=1.16 pd=8.58 ps=8.58 mult=1 m=1
bd_op1_1000_s5_w3 d_op1_1000_s5_w3 0 v=v(rbl_op1_1000_s5_w3)-v(ref_op1_1000_s5_w3)

* ---- instance 101: op1_1000_s5_w5 (t_en 9 ns, WWL 10..15 ns, release 17 ns) ----
ven_op1_1000_s5_w5  en_op1_1000_s5_w5  0 pwl(0 0 9.0000e-09 0 9.1000e-09 {VDD} 1.7000e-08 {VDD} 1.7100e-08 0)
venb_op1_1000_s5_w5 enb_op1_1000_s5_w5 0 pwl(0 {VDD} 9.0000e-09 {VDD} 9.1000e-09 0 1.7000e-08 0 1.7100e-08 {VDD})
vrs_op1_1000_s5_w5  rwls_op1_1000_s5_w5 0 pwl(0 {VDD} {T_READ} {VDD} {T_READ+TEDGE} 0 1.7000e-08 0 1.7100e-08 {VDD})
vww_op1_1000_s5_w5  wwl_op1_1000_s5_w5 0 pwl(0 0 1.0000e-08 0 1.0100e-08 {VDD} 1.5000e-08 {VDD} 1.5100e-08 0)
vwc_op1_1000_s5_w5  wbc_op1_1000_s5_w5 0 pwl(0 0 1.0000e-08 0 1.0100e-08 {VDD} 1.7000e-08 {VDD} 1.7100e-08 0)
swb_op1_1000_s5_w5 ref_op1_1000_s5_w5 wbl_op1_1000_s5_w5 wbc_op1_1000_s5_w5 0 swwbl
cwbl_op1_1000_s5_w5 wbl_op1_1000_s5_w5 0 {C_WBL}
spa_op1_1000_s5_w5 prea rbl_op1_1000_s5_w5 ctl 0 swpre
spr_op1_1000_s5_w5 pref ref_op1_1000_s5_w5 ctl 0 swpre
crbl_op1_1000_s5_w5 rbl_op1_1000_s5_w5 0 {C_RBL}
cref_op1_1000_s5_w5 ref_op1_1000_s5_w5 0 {C_RBL}   $ ASSUMPTION: ideal matched dummy load
XMWR_op1_1000_s5_w5_0 sn_op1_1000_s5_w5_0 wwl_op1_1000_s5_w5 wbl_op1_1000_s5_w5 0 sky130_fd_pr__nfet_01v8 L=0.15 W=0.42 nf=1 ad=0.1218 as=0.1218 pd=1.42 ps=1.42 nrd=0.69047619047619  nrs=0.69047619047619 sa=0 sb=0 sd=0 mult=1 m=1
XMRD_op1_1000_s5_w5_0 rbl_op1_1000_s5_w5 sn_op1_1000_s5_w5_0 rwls_op1_1000_s5_w5 0 sky130_fd_pr__nfet_01v8 L=0.15 W=0.42 nf=1 ad=0.1218 as=0.1218 pd=1.42 ps=1.42 nrd=0.69047619047619  nrs=0.69047619047619 sa=0 sb=0 sd=0 mult=1 m=1
csn_op1_1000_s5_w5_0 sn_op1_1000_s5_w5_0 0 {C_SN}
XMWR_op1_1000_s5_w5_1 sn_op1_1000_s5_w5_1 wwl_des wbl_op1_1000_s5_w5 0 sky130_fd_pr__nfet_01v8 L=0.15 W=0.42 nf=1 ad=0.1218 as=0.1218 pd=1.42 ps=1.42 nrd=0.69047619047619  nrs=0.69047619047619 sa=0 sb=0 sd=0 mult=1 m=1
XMRD_op1_1000_s5_w5_1 rbl_op1_1000_s5_w5 sn_op1_1000_s5_w5_1 rwl_des 0 sky130_fd_pr__nfet_01v8 L=0.15 W=0.42 nf=1 ad=0.1218 as=0.1218 pd=1.42 ps=1.42 nrd=0.69047619047619  nrs=0.69047619047619 sa=0 sb=0 sd=0 mult=1 m=1
csn_op1_1000_s5_w5_1 sn_op1_1000_s5_w5_1 0 {C_SN}
XMWR_op1_1000_s5_w5_2 sn_op1_1000_s5_w5_2 wwl_des wbl_op1_1000_s5_w5 0 sky130_fd_pr__nfet_01v8 L=0.15 W=0.42 nf=1 ad=0.1218 as=0.1218 pd=1.42 ps=1.42 nrd=0.69047619047619  nrs=0.69047619047619 sa=0 sb=0 sd=0 mult=1 m=1
XMRD_op1_1000_s5_w5_2 rbl_op1_1000_s5_w5 sn_op1_1000_s5_w5_2 rwl_des 0 sky130_fd_pr__nfet_01v8 L=0.15 W=0.42 nf=1 ad=0.1218 as=0.1218 pd=1.42 ps=1.42 nrd=0.69047619047619  nrs=0.69047619047619 sa=0 sb=0 sd=0 mult=1 m=1
csn_op1_1000_s5_w5_2 sn_op1_1000_s5_w5_2 0 {C_SN}
XMWR_op1_1000_s5_w5_3 sn_op1_1000_s5_w5_3 wwl_des wbl_op1_1000_s5_w5 0 sky130_fd_pr__nfet_01v8 L=0.15 W=0.42 nf=1 ad=0.1218 as=0.1218 pd=1.42 ps=1.42 nrd=0.69047619047619  nrs=0.69047619047619 sa=0 sb=0 sd=0 mult=1 m=1
XMRD_op1_1000_s5_w5_3 rbl_op1_1000_s5_w5 sn_op1_1000_s5_w5_3 rwl_des 0 sky130_fd_pr__nfet_01v8 L=0.15 W=0.42 nf=1 ad=0.1218 as=0.1218 pd=1.42 ps=1.42 nrd=0.69047619047619  nrs=0.69047619047619 sa=0 sb=0 sd=0 mult=1 m=1
csn_op1_1000_s5_w5_3 sn_op1_1000_s5_w5_3 0 {C_SN}
XMN1_op1_1000_s5_w5 rbl_op1_1000_s5_w5 ref_op1_1000_s5_w5 vn_op1_1000_s5_w5 0 sky130_fd_pr__nfet_01v8 L=0.15 W=1 nf=1 ad=0.29 as=0.29 pd=2.58 ps=2.58 mult=1 m=1
XMN2_op1_1000_s5_w5 ref_op1_1000_s5_w5 rbl_op1_1000_s5_w5 vn_op1_1000_s5_w5 0 sky130_fd_pr__nfet_01v8 L=0.15 W=1 nf=1 ad=0.29 as=0.29 pd=2.58 ps=2.58 mult=1 m=1
XMP1_op1_1000_s5_w5 rbl_op1_1000_s5_w5 ref_op1_1000_s5_w5 vp_op1_1000_s5_w5 vdd sky130_fd_pr__pfet_01v8 L=0.15 W=2 nf=1 ad=0.58 as=0.58 pd=4.58 ps=4.58 mult=1 m=1
XMP2_op1_1000_s5_w5 ref_op1_1000_s5_w5 rbl_op1_1000_s5_w5 vp_op1_1000_s5_w5 vdd sky130_fd_pr__pfet_01v8 L=0.15 W=2 nf=1 ad=0.58 as=0.58 pd=4.58 ps=4.58 mult=1 m=1
XMNF_op1_1000_s5_w5 vn_op1_1000_s5_w5 en_op1_1000_s5_w5 0 0 sky130_fd_pr__nfet_01v8 L=0.15 W=2 nf=1 ad=0.58 as=0.58 pd=4.58 ps=4.58 mult=1 m=1
XMPH_op1_1000_s5_w5 vp_op1_1000_s5_w5 enb_op1_1000_s5_w5 vdd vdd sky130_fd_pr__pfet_01v8 L=0.15 W=4 nf=1 ad=1.16 as=1.16 pd=8.58 ps=8.58 mult=1 m=1
bd_op1_1000_s5_w5 d_op1_1000_s5_w5 0 v=v(rbl_op1_1000_s5_w5)-v(ref_op1_1000_s5_w5)

* ---- instance 102: op1_1000_s5_w7p5 (t_en 9 ns, WWL 10..17.5 ns, release 19.5 ns) ----
ven_op1_1000_s5_w7p5  en_op1_1000_s5_w7p5  0 pwl(0 0 9.0000e-09 0 9.1000e-09 {VDD} 1.9500e-08 {VDD} 1.9600e-08 0)
venb_op1_1000_s5_w7p5 enb_op1_1000_s5_w7p5 0 pwl(0 {VDD} 9.0000e-09 {VDD} 9.1000e-09 0 1.9500e-08 0 1.9600e-08 {VDD})
vrs_op1_1000_s5_w7p5  rwls_op1_1000_s5_w7p5 0 pwl(0 {VDD} {T_READ} {VDD} {T_READ+TEDGE} 0 1.9500e-08 0 1.9600e-08 {VDD})
vww_op1_1000_s5_w7p5  wwl_op1_1000_s5_w7p5 0 pwl(0 0 1.0000e-08 0 1.0100e-08 {VDD} 1.7500e-08 {VDD} 1.7600e-08 0)
vwc_op1_1000_s5_w7p5  wbc_op1_1000_s5_w7p5 0 pwl(0 0 1.0000e-08 0 1.0100e-08 {VDD} 1.9500e-08 {VDD} 1.9600e-08 0)
swb_op1_1000_s5_w7p5 ref_op1_1000_s5_w7p5 wbl_op1_1000_s5_w7p5 wbc_op1_1000_s5_w7p5 0 swwbl
cwbl_op1_1000_s5_w7p5 wbl_op1_1000_s5_w7p5 0 {C_WBL}
spa_op1_1000_s5_w7p5 prea rbl_op1_1000_s5_w7p5 ctl 0 swpre
spr_op1_1000_s5_w7p5 pref ref_op1_1000_s5_w7p5 ctl 0 swpre
crbl_op1_1000_s5_w7p5 rbl_op1_1000_s5_w7p5 0 {C_RBL}
cref_op1_1000_s5_w7p5 ref_op1_1000_s5_w7p5 0 {C_RBL}   $ ASSUMPTION: ideal matched dummy load
XMWR_op1_1000_s5_w7p5_0 sn_op1_1000_s5_w7p5_0 wwl_op1_1000_s5_w7p5 wbl_op1_1000_s5_w7p5 0 sky130_fd_pr__nfet_01v8 L=0.15 W=0.42 nf=1 ad=0.1218 as=0.1218 pd=1.42 ps=1.42 nrd=0.69047619047619  nrs=0.69047619047619 sa=0 sb=0 sd=0 mult=1 m=1
XMRD_op1_1000_s5_w7p5_0 rbl_op1_1000_s5_w7p5 sn_op1_1000_s5_w7p5_0 rwls_op1_1000_s5_w7p5 0 sky130_fd_pr__nfet_01v8 L=0.15 W=0.42 nf=1 ad=0.1218 as=0.1218 pd=1.42 ps=1.42 nrd=0.69047619047619  nrs=0.69047619047619 sa=0 sb=0 sd=0 mult=1 m=1
csn_op1_1000_s5_w7p5_0 sn_op1_1000_s5_w7p5_0 0 {C_SN}
XMWR_op1_1000_s5_w7p5_1 sn_op1_1000_s5_w7p5_1 wwl_des wbl_op1_1000_s5_w7p5 0 sky130_fd_pr__nfet_01v8 L=0.15 W=0.42 nf=1 ad=0.1218 as=0.1218 pd=1.42 ps=1.42 nrd=0.69047619047619  nrs=0.69047619047619 sa=0 sb=0 sd=0 mult=1 m=1
XMRD_op1_1000_s5_w7p5_1 rbl_op1_1000_s5_w7p5 sn_op1_1000_s5_w7p5_1 rwl_des 0 sky130_fd_pr__nfet_01v8 L=0.15 W=0.42 nf=1 ad=0.1218 as=0.1218 pd=1.42 ps=1.42 nrd=0.69047619047619  nrs=0.69047619047619 sa=0 sb=0 sd=0 mult=1 m=1
csn_op1_1000_s5_w7p5_1 sn_op1_1000_s5_w7p5_1 0 {C_SN}
XMWR_op1_1000_s5_w7p5_2 sn_op1_1000_s5_w7p5_2 wwl_des wbl_op1_1000_s5_w7p5 0 sky130_fd_pr__nfet_01v8 L=0.15 W=0.42 nf=1 ad=0.1218 as=0.1218 pd=1.42 ps=1.42 nrd=0.69047619047619  nrs=0.69047619047619 sa=0 sb=0 sd=0 mult=1 m=1
XMRD_op1_1000_s5_w7p5_2 rbl_op1_1000_s5_w7p5 sn_op1_1000_s5_w7p5_2 rwl_des 0 sky130_fd_pr__nfet_01v8 L=0.15 W=0.42 nf=1 ad=0.1218 as=0.1218 pd=1.42 ps=1.42 nrd=0.69047619047619  nrs=0.69047619047619 sa=0 sb=0 sd=0 mult=1 m=1
csn_op1_1000_s5_w7p5_2 sn_op1_1000_s5_w7p5_2 0 {C_SN}
XMWR_op1_1000_s5_w7p5_3 sn_op1_1000_s5_w7p5_3 wwl_des wbl_op1_1000_s5_w7p5 0 sky130_fd_pr__nfet_01v8 L=0.15 W=0.42 nf=1 ad=0.1218 as=0.1218 pd=1.42 ps=1.42 nrd=0.69047619047619  nrs=0.69047619047619 sa=0 sb=0 sd=0 mult=1 m=1
XMRD_op1_1000_s5_w7p5_3 rbl_op1_1000_s5_w7p5 sn_op1_1000_s5_w7p5_3 rwl_des 0 sky130_fd_pr__nfet_01v8 L=0.15 W=0.42 nf=1 ad=0.1218 as=0.1218 pd=1.42 ps=1.42 nrd=0.69047619047619  nrs=0.69047619047619 sa=0 sb=0 sd=0 mult=1 m=1
csn_op1_1000_s5_w7p5_3 sn_op1_1000_s5_w7p5_3 0 {C_SN}
XMN1_op1_1000_s5_w7p5 rbl_op1_1000_s5_w7p5 ref_op1_1000_s5_w7p5 vn_op1_1000_s5_w7p5 0 sky130_fd_pr__nfet_01v8 L=0.15 W=1 nf=1 ad=0.29 as=0.29 pd=2.58 ps=2.58 mult=1 m=1
XMN2_op1_1000_s5_w7p5 ref_op1_1000_s5_w7p5 rbl_op1_1000_s5_w7p5 vn_op1_1000_s5_w7p5 0 sky130_fd_pr__nfet_01v8 L=0.15 W=1 nf=1 ad=0.29 as=0.29 pd=2.58 ps=2.58 mult=1 m=1
XMP1_op1_1000_s5_w7p5 rbl_op1_1000_s5_w7p5 ref_op1_1000_s5_w7p5 vp_op1_1000_s5_w7p5 vdd sky130_fd_pr__pfet_01v8 L=0.15 W=2 nf=1 ad=0.58 as=0.58 pd=4.58 ps=4.58 mult=1 m=1
XMP2_op1_1000_s5_w7p5 ref_op1_1000_s5_w7p5 rbl_op1_1000_s5_w7p5 vp_op1_1000_s5_w7p5 vdd sky130_fd_pr__pfet_01v8 L=0.15 W=2 nf=1 ad=0.58 as=0.58 pd=4.58 ps=4.58 mult=1 m=1
XMNF_op1_1000_s5_w7p5 vn_op1_1000_s5_w7p5 en_op1_1000_s5_w7p5 0 0 sky130_fd_pr__nfet_01v8 L=0.15 W=2 nf=1 ad=0.58 as=0.58 pd=4.58 ps=4.58 mult=1 m=1
XMPH_op1_1000_s5_w7p5 vp_op1_1000_s5_w7p5 enb_op1_1000_s5_w7p5 vdd vdd sky130_fd_pr__pfet_01v8 L=0.15 W=4 nf=1 ad=1.16 as=1.16 pd=8.58 ps=8.58 mult=1 m=1
bd_op1_1000_s5_w7p5 d_op1_1000_s5_w7p5 0 v=v(rbl_op1_1000_s5_w7p5)-v(ref_op1_1000_s5_w7p5)

* ---- instance 103: op1_1000_s5_w10 (t_en 9 ns, WWL 10..20 ns, release 22 ns) ----
ven_op1_1000_s5_w10  en_op1_1000_s5_w10  0 pwl(0 0 9.0000e-09 0 9.1000e-09 {VDD} 2.2000e-08 {VDD} 2.2100e-08 0)
venb_op1_1000_s5_w10 enb_op1_1000_s5_w10 0 pwl(0 {VDD} 9.0000e-09 {VDD} 9.1000e-09 0 2.2000e-08 0 2.2100e-08 {VDD})
vrs_op1_1000_s5_w10  rwls_op1_1000_s5_w10 0 pwl(0 {VDD} {T_READ} {VDD} {T_READ+TEDGE} 0 2.2000e-08 0 2.2100e-08 {VDD})
vww_op1_1000_s5_w10  wwl_op1_1000_s5_w10 0 pwl(0 0 1.0000e-08 0 1.0100e-08 {VDD} 2.0000e-08 {VDD} 2.0100e-08 0)
vwc_op1_1000_s5_w10  wbc_op1_1000_s5_w10 0 pwl(0 0 1.0000e-08 0 1.0100e-08 {VDD} 2.2000e-08 {VDD} 2.2100e-08 0)
swb_op1_1000_s5_w10 ref_op1_1000_s5_w10 wbl_op1_1000_s5_w10 wbc_op1_1000_s5_w10 0 swwbl
cwbl_op1_1000_s5_w10 wbl_op1_1000_s5_w10 0 {C_WBL}
spa_op1_1000_s5_w10 prea rbl_op1_1000_s5_w10 ctl 0 swpre
spr_op1_1000_s5_w10 pref ref_op1_1000_s5_w10 ctl 0 swpre
crbl_op1_1000_s5_w10 rbl_op1_1000_s5_w10 0 {C_RBL}
cref_op1_1000_s5_w10 ref_op1_1000_s5_w10 0 {C_RBL}   $ ASSUMPTION: ideal matched dummy load
XMWR_op1_1000_s5_w10_0 sn_op1_1000_s5_w10_0 wwl_op1_1000_s5_w10 wbl_op1_1000_s5_w10 0 sky130_fd_pr__nfet_01v8 L=0.15 W=0.42 nf=1 ad=0.1218 as=0.1218 pd=1.42 ps=1.42 nrd=0.69047619047619  nrs=0.69047619047619 sa=0 sb=0 sd=0 mult=1 m=1
XMRD_op1_1000_s5_w10_0 rbl_op1_1000_s5_w10 sn_op1_1000_s5_w10_0 rwls_op1_1000_s5_w10 0 sky130_fd_pr__nfet_01v8 L=0.15 W=0.42 nf=1 ad=0.1218 as=0.1218 pd=1.42 ps=1.42 nrd=0.69047619047619  nrs=0.69047619047619 sa=0 sb=0 sd=0 mult=1 m=1
csn_op1_1000_s5_w10_0 sn_op1_1000_s5_w10_0 0 {C_SN}
XMWR_op1_1000_s5_w10_1 sn_op1_1000_s5_w10_1 wwl_des wbl_op1_1000_s5_w10 0 sky130_fd_pr__nfet_01v8 L=0.15 W=0.42 nf=1 ad=0.1218 as=0.1218 pd=1.42 ps=1.42 nrd=0.69047619047619  nrs=0.69047619047619 sa=0 sb=0 sd=0 mult=1 m=1
XMRD_op1_1000_s5_w10_1 rbl_op1_1000_s5_w10 sn_op1_1000_s5_w10_1 rwl_des 0 sky130_fd_pr__nfet_01v8 L=0.15 W=0.42 nf=1 ad=0.1218 as=0.1218 pd=1.42 ps=1.42 nrd=0.69047619047619  nrs=0.69047619047619 sa=0 sb=0 sd=0 mult=1 m=1
csn_op1_1000_s5_w10_1 sn_op1_1000_s5_w10_1 0 {C_SN}
XMWR_op1_1000_s5_w10_2 sn_op1_1000_s5_w10_2 wwl_des wbl_op1_1000_s5_w10 0 sky130_fd_pr__nfet_01v8 L=0.15 W=0.42 nf=1 ad=0.1218 as=0.1218 pd=1.42 ps=1.42 nrd=0.69047619047619  nrs=0.69047619047619 sa=0 sb=0 sd=0 mult=1 m=1
XMRD_op1_1000_s5_w10_2 rbl_op1_1000_s5_w10 sn_op1_1000_s5_w10_2 rwl_des 0 sky130_fd_pr__nfet_01v8 L=0.15 W=0.42 nf=1 ad=0.1218 as=0.1218 pd=1.42 ps=1.42 nrd=0.69047619047619  nrs=0.69047619047619 sa=0 sb=0 sd=0 mult=1 m=1
csn_op1_1000_s5_w10_2 sn_op1_1000_s5_w10_2 0 {C_SN}
XMWR_op1_1000_s5_w10_3 sn_op1_1000_s5_w10_3 wwl_des wbl_op1_1000_s5_w10 0 sky130_fd_pr__nfet_01v8 L=0.15 W=0.42 nf=1 ad=0.1218 as=0.1218 pd=1.42 ps=1.42 nrd=0.69047619047619  nrs=0.69047619047619 sa=0 sb=0 sd=0 mult=1 m=1
XMRD_op1_1000_s5_w10_3 rbl_op1_1000_s5_w10 sn_op1_1000_s5_w10_3 rwl_des 0 sky130_fd_pr__nfet_01v8 L=0.15 W=0.42 nf=1 ad=0.1218 as=0.1218 pd=1.42 ps=1.42 nrd=0.69047619047619  nrs=0.69047619047619 sa=0 sb=0 sd=0 mult=1 m=1
csn_op1_1000_s5_w10_3 sn_op1_1000_s5_w10_3 0 {C_SN}
XMN1_op1_1000_s5_w10 rbl_op1_1000_s5_w10 ref_op1_1000_s5_w10 vn_op1_1000_s5_w10 0 sky130_fd_pr__nfet_01v8 L=0.15 W=1 nf=1 ad=0.29 as=0.29 pd=2.58 ps=2.58 mult=1 m=1
XMN2_op1_1000_s5_w10 ref_op1_1000_s5_w10 rbl_op1_1000_s5_w10 vn_op1_1000_s5_w10 0 sky130_fd_pr__nfet_01v8 L=0.15 W=1 nf=1 ad=0.29 as=0.29 pd=2.58 ps=2.58 mult=1 m=1
XMP1_op1_1000_s5_w10 rbl_op1_1000_s5_w10 ref_op1_1000_s5_w10 vp_op1_1000_s5_w10 vdd sky130_fd_pr__pfet_01v8 L=0.15 W=2 nf=1 ad=0.58 as=0.58 pd=4.58 ps=4.58 mult=1 m=1
XMP2_op1_1000_s5_w10 ref_op1_1000_s5_w10 rbl_op1_1000_s5_w10 vp_op1_1000_s5_w10 vdd sky130_fd_pr__pfet_01v8 L=0.15 W=2 nf=1 ad=0.58 as=0.58 pd=4.58 ps=4.58 mult=1 m=1
XMNF_op1_1000_s5_w10 vn_op1_1000_s5_w10 en_op1_1000_s5_w10 0 0 sky130_fd_pr__nfet_01v8 L=0.15 W=2 nf=1 ad=0.58 as=0.58 pd=4.58 ps=4.58 mult=1 m=1
XMPH_op1_1000_s5_w10 vp_op1_1000_s5_w10 enb_op1_1000_s5_w10 vdd vdd sky130_fd_pr__pfet_01v8 L=0.15 W=4 nf=1 ad=1.16 as=1.16 pd=8.58 ps=8.58 mult=1 m=1
bd_op1_1000_s5_w10 d_op1_1000_s5_w10 0 v=v(rbl_op1_1000_s5_w10)-v(ref_op1_1000_s5_w10)

* ---- instance 104: op1_1000_s5_w15 (t_en 9 ns, WWL 10..25 ns, release 27 ns) ----
ven_op1_1000_s5_w15  en_op1_1000_s5_w15  0 pwl(0 0 9.0000e-09 0 9.1000e-09 {VDD} 2.7000e-08 {VDD} 2.7100e-08 0)
venb_op1_1000_s5_w15 enb_op1_1000_s5_w15 0 pwl(0 {VDD} 9.0000e-09 {VDD} 9.1000e-09 0 2.7000e-08 0 2.7100e-08 {VDD})
vrs_op1_1000_s5_w15  rwls_op1_1000_s5_w15 0 pwl(0 {VDD} {T_READ} {VDD} {T_READ+TEDGE} 0 2.7000e-08 0 2.7100e-08 {VDD})
vww_op1_1000_s5_w15  wwl_op1_1000_s5_w15 0 pwl(0 0 1.0000e-08 0 1.0100e-08 {VDD} 2.5000e-08 {VDD} 2.5100e-08 0)
vwc_op1_1000_s5_w15  wbc_op1_1000_s5_w15 0 pwl(0 0 1.0000e-08 0 1.0100e-08 {VDD} 2.7000e-08 {VDD} 2.7100e-08 0)
swb_op1_1000_s5_w15 ref_op1_1000_s5_w15 wbl_op1_1000_s5_w15 wbc_op1_1000_s5_w15 0 swwbl
cwbl_op1_1000_s5_w15 wbl_op1_1000_s5_w15 0 {C_WBL}
spa_op1_1000_s5_w15 prea rbl_op1_1000_s5_w15 ctl 0 swpre
spr_op1_1000_s5_w15 pref ref_op1_1000_s5_w15 ctl 0 swpre
crbl_op1_1000_s5_w15 rbl_op1_1000_s5_w15 0 {C_RBL}
cref_op1_1000_s5_w15 ref_op1_1000_s5_w15 0 {C_RBL}   $ ASSUMPTION: ideal matched dummy load
XMWR_op1_1000_s5_w15_0 sn_op1_1000_s5_w15_0 wwl_op1_1000_s5_w15 wbl_op1_1000_s5_w15 0 sky130_fd_pr__nfet_01v8 L=0.15 W=0.42 nf=1 ad=0.1218 as=0.1218 pd=1.42 ps=1.42 nrd=0.69047619047619  nrs=0.69047619047619 sa=0 sb=0 sd=0 mult=1 m=1
XMRD_op1_1000_s5_w15_0 rbl_op1_1000_s5_w15 sn_op1_1000_s5_w15_0 rwls_op1_1000_s5_w15 0 sky130_fd_pr__nfet_01v8 L=0.15 W=0.42 nf=1 ad=0.1218 as=0.1218 pd=1.42 ps=1.42 nrd=0.69047619047619  nrs=0.69047619047619 sa=0 sb=0 sd=0 mult=1 m=1
csn_op1_1000_s5_w15_0 sn_op1_1000_s5_w15_0 0 {C_SN}
XMWR_op1_1000_s5_w15_1 sn_op1_1000_s5_w15_1 wwl_des wbl_op1_1000_s5_w15 0 sky130_fd_pr__nfet_01v8 L=0.15 W=0.42 nf=1 ad=0.1218 as=0.1218 pd=1.42 ps=1.42 nrd=0.69047619047619  nrs=0.69047619047619 sa=0 sb=0 sd=0 mult=1 m=1
XMRD_op1_1000_s5_w15_1 rbl_op1_1000_s5_w15 sn_op1_1000_s5_w15_1 rwl_des 0 sky130_fd_pr__nfet_01v8 L=0.15 W=0.42 nf=1 ad=0.1218 as=0.1218 pd=1.42 ps=1.42 nrd=0.69047619047619  nrs=0.69047619047619 sa=0 sb=0 sd=0 mult=1 m=1
csn_op1_1000_s5_w15_1 sn_op1_1000_s5_w15_1 0 {C_SN}
XMWR_op1_1000_s5_w15_2 sn_op1_1000_s5_w15_2 wwl_des wbl_op1_1000_s5_w15 0 sky130_fd_pr__nfet_01v8 L=0.15 W=0.42 nf=1 ad=0.1218 as=0.1218 pd=1.42 ps=1.42 nrd=0.69047619047619  nrs=0.69047619047619 sa=0 sb=0 sd=0 mult=1 m=1
XMRD_op1_1000_s5_w15_2 rbl_op1_1000_s5_w15 sn_op1_1000_s5_w15_2 rwl_des 0 sky130_fd_pr__nfet_01v8 L=0.15 W=0.42 nf=1 ad=0.1218 as=0.1218 pd=1.42 ps=1.42 nrd=0.69047619047619  nrs=0.69047619047619 sa=0 sb=0 sd=0 mult=1 m=1
csn_op1_1000_s5_w15_2 sn_op1_1000_s5_w15_2 0 {C_SN}
XMWR_op1_1000_s5_w15_3 sn_op1_1000_s5_w15_3 wwl_des wbl_op1_1000_s5_w15 0 sky130_fd_pr__nfet_01v8 L=0.15 W=0.42 nf=1 ad=0.1218 as=0.1218 pd=1.42 ps=1.42 nrd=0.69047619047619  nrs=0.69047619047619 sa=0 sb=0 sd=0 mult=1 m=1
XMRD_op1_1000_s5_w15_3 rbl_op1_1000_s5_w15 sn_op1_1000_s5_w15_3 rwl_des 0 sky130_fd_pr__nfet_01v8 L=0.15 W=0.42 nf=1 ad=0.1218 as=0.1218 pd=1.42 ps=1.42 nrd=0.69047619047619  nrs=0.69047619047619 sa=0 sb=0 sd=0 mult=1 m=1
csn_op1_1000_s5_w15_3 sn_op1_1000_s5_w15_3 0 {C_SN}
XMN1_op1_1000_s5_w15 rbl_op1_1000_s5_w15 ref_op1_1000_s5_w15 vn_op1_1000_s5_w15 0 sky130_fd_pr__nfet_01v8 L=0.15 W=1 nf=1 ad=0.29 as=0.29 pd=2.58 ps=2.58 mult=1 m=1
XMN2_op1_1000_s5_w15 ref_op1_1000_s5_w15 rbl_op1_1000_s5_w15 vn_op1_1000_s5_w15 0 sky130_fd_pr__nfet_01v8 L=0.15 W=1 nf=1 ad=0.29 as=0.29 pd=2.58 ps=2.58 mult=1 m=1
XMP1_op1_1000_s5_w15 rbl_op1_1000_s5_w15 ref_op1_1000_s5_w15 vp_op1_1000_s5_w15 vdd sky130_fd_pr__pfet_01v8 L=0.15 W=2 nf=1 ad=0.58 as=0.58 pd=4.58 ps=4.58 mult=1 m=1
XMP2_op1_1000_s5_w15 ref_op1_1000_s5_w15 rbl_op1_1000_s5_w15 vp_op1_1000_s5_w15 vdd sky130_fd_pr__pfet_01v8 L=0.15 W=2 nf=1 ad=0.58 as=0.58 pd=4.58 ps=4.58 mult=1 m=1
XMNF_op1_1000_s5_w15 vn_op1_1000_s5_w15 en_op1_1000_s5_w15 0 0 sky130_fd_pr__nfet_01v8 L=0.15 W=2 nf=1 ad=0.58 as=0.58 pd=4.58 ps=4.58 mult=1 m=1
XMPH_op1_1000_s5_w15 vp_op1_1000_s5_w15 enb_op1_1000_s5_w15 vdd vdd sky130_fd_pr__pfet_01v8 L=0.15 W=4 nf=1 ad=1.16 as=1.16 pd=8.58 ps=8.58 mult=1 m=1
bd_op1_1000_s5_w15 d_op1_1000_s5_w15 0 v=v(rbl_op1_1000_s5_w15)-v(ref_op1_1000_s5_w15)

* ---- instance 105: op1_1000_s5_w20 (t_en 9 ns, WWL 10..30 ns, release 32 ns) ----
ven_op1_1000_s5_w20  en_op1_1000_s5_w20  0 pwl(0 0 9.0000e-09 0 9.1000e-09 {VDD} 3.2000e-08 {VDD} 3.2100e-08 0)
venb_op1_1000_s5_w20 enb_op1_1000_s5_w20 0 pwl(0 {VDD} 9.0000e-09 {VDD} 9.1000e-09 0 3.2000e-08 0 3.2100e-08 {VDD})
vrs_op1_1000_s5_w20  rwls_op1_1000_s5_w20 0 pwl(0 {VDD} {T_READ} {VDD} {T_READ+TEDGE} 0 3.2000e-08 0 3.2100e-08 {VDD})
vww_op1_1000_s5_w20  wwl_op1_1000_s5_w20 0 pwl(0 0 1.0000e-08 0 1.0100e-08 {VDD} 3.0000e-08 {VDD} 3.0100e-08 0)
vwc_op1_1000_s5_w20  wbc_op1_1000_s5_w20 0 pwl(0 0 1.0000e-08 0 1.0100e-08 {VDD} 3.2000e-08 {VDD} 3.2100e-08 0)
swb_op1_1000_s5_w20 ref_op1_1000_s5_w20 wbl_op1_1000_s5_w20 wbc_op1_1000_s5_w20 0 swwbl
cwbl_op1_1000_s5_w20 wbl_op1_1000_s5_w20 0 {C_WBL}
spa_op1_1000_s5_w20 prea rbl_op1_1000_s5_w20 ctl 0 swpre
spr_op1_1000_s5_w20 pref ref_op1_1000_s5_w20 ctl 0 swpre
crbl_op1_1000_s5_w20 rbl_op1_1000_s5_w20 0 {C_RBL}
cref_op1_1000_s5_w20 ref_op1_1000_s5_w20 0 {C_RBL}   $ ASSUMPTION: ideal matched dummy load
XMWR_op1_1000_s5_w20_0 sn_op1_1000_s5_w20_0 wwl_op1_1000_s5_w20 wbl_op1_1000_s5_w20 0 sky130_fd_pr__nfet_01v8 L=0.15 W=0.42 nf=1 ad=0.1218 as=0.1218 pd=1.42 ps=1.42 nrd=0.69047619047619  nrs=0.69047619047619 sa=0 sb=0 sd=0 mult=1 m=1
XMRD_op1_1000_s5_w20_0 rbl_op1_1000_s5_w20 sn_op1_1000_s5_w20_0 rwls_op1_1000_s5_w20 0 sky130_fd_pr__nfet_01v8 L=0.15 W=0.42 nf=1 ad=0.1218 as=0.1218 pd=1.42 ps=1.42 nrd=0.69047619047619  nrs=0.69047619047619 sa=0 sb=0 sd=0 mult=1 m=1
csn_op1_1000_s5_w20_0 sn_op1_1000_s5_w20_0 0 {C_SN}
XMWR_op1_1000_s5_w20_1 sn_op1_1000_s5_w20_1 wwl_des wbl_op1_1000_s5_w20 0 sky130_fd_pr__nfet_01v8 L=0.15 W=0.42 nf=1 ad=0.1218 as=0.1218 pd=1.42 ps=1.42 nrd=0.69047619047619  nrs=0.69047619047619 sa=0 sb=0 sd=0 mult=1 m=1
XMRD_op1_1000_s5_w20_1 rbl_op1_1000_s5_w20 sn_op1_1000_s5_w20_1 rwl_des 0 sky130_fd_pr__nfet_01v8 L=0.15 W=0.42 nf=1 ad=0.1218 as=0.1218 pd=1.42 ps=1.42 nrd=0.69047619047619  nrs=0.69047619047619 sa=0 sb=0 sd=0 mult=1 m=1
csn_op1_1000_s5_w20_1 sn_op1_1000_s5_w20_1 0 {C_SN}
XMWR_op1_1000_s5_w20_2 sn_op1_1000_s5_w20_2 wwl_des wbl_op1_1000_s5_w20 0 sky130_fd_pr__nfet_01v8 L=0.15 W=0.42 nf=1 ad=0.1218 as=0.1218 pd=1.42 ps=1.42 nrd=0.69047619047619  nrs=0.69047619047619 sa=0 sb=0 sd=0 mult=1 m=1
XMRD_op1_1000_s5_w20_2 rbl_op1_1000_s5_w20 sn_op1_1000_s5_w20_2 rwl_des 0 sky130_fd_pr__nfet_01v8 L=0.15 W=0.42 nf=1 ad=0.1218 as=0.1218 pd=1.42 ps=1.42 nrd=0.69047619047619  nrs=0.69047619047619 sa=0 sb=0 sd=0 mult=1 m=1
csn_op1_1000_s5_w20_2 sn_op1_1000_s5_w20_2 0 {C_SN}
XMWR_op1_1000_s5_w20_3 sn_op1_1000_s5_w20_3 wwl_des wbl_op1_1000_s5_w20 0 sky130_fd_pr__nfet_01v8 L=0.15 W=0.42 nf=1 ad=0.1218 as=0.1218 pd=1.42 ps=1.42 nrd=0.69047619047619  nrs=0.69047619047619 sa=0 sb=0 sd=0 mult=1 m=1
XMRD_op1_1000_s5_w20_3 rbl_op1_1000_s5_w20 sn_op1_1000_s5_w20_3 rwl_des 0 sky130_fd_pr__nfet_01v8 L=0.15 W=0.42 nf=1 ad=0.1218 as=0.1218 pd=1.42 ps=1.42 nrd=0.69047619047619  nrs=0.69047619047619 sa=0 sb=0 sd=0 mult=1 m=1
csn_op1_1000_s5_w20_3 sn_op1_1000_s5_w20_3 0 {C_SN}
XMN1_op1_1000_s5_w20 rbl_op1_1000_s5_w20 ref_op1_1000_s5_w20 vn_op1_1000_s5_w20 0 sky130_fd_pr__nfet_01v8 L=0.15 W=1 nf=1 ad=0.29 as=0.29 pd=2.58 ps=2.58 mult=1 m=1
XMN2_op1_1000_s5_w20 ref_op1_1000_s5_w20 rbl_op1_1000_s5_w20 vn_op1_1000_s5_w20 0 sky130_fd_pr__nfet_01v8 L=0.15 W=1 nf=1 ad=0.29 as=0.29 pd=2.58 ps=2.58 mult=1 m=1
XMP1_op1_1000_s5_w20 rbl_op1_1000_s5_w20 ref_op1_1000_s5_w20 vp_op1_1000_s5_w20 vdd sky130_fd_pr__pfet_01v8 L=0.15 W=2 nf=1 ad=0.58 as=0.58 pd=4.58 ps=4.58 mult=1 m=1
XMP2_op1_1000_s5_w20 ref_op1_1000_s5_w20 rbl_op1_1000_s5_w20 vp_op1_1000_s5_w20 vdd sky130_fd_pr__pfet_01v8 L=0.15 W=2 nf=1 ad=0.58 as=0.58 pd=4.58 ps=4.58 mult=1 m=1
XMNF_op1_1000_s5_w20 vn_op1_1000_s5_w20 en_op1_1000_s5_w20 0 0 sky130_fd_pr__nfet_01v8 L=0.15 W=2 nf=1 ad=0.58 as=0.58 pd=4.58 ps=4.58 mult=1 m=1
XMPH_op1_1000_s5_w20 vp_op1_1000_s5_w20 enb_op1_1000_s5_w20 vdd vdd sky130_fd_pr__pfet_01v8 L=0.15 W=4 nf=1 ad=1.16 as=1.16 pd=8.58 ps=8.58 mult=1 m=1
bd_op1_1000_s5_w20 d_op1_1000_s5_w20 0 v=v(rbl_op1_1000_s5_w20)-v(ref_op1_1000_s5_w20)

* ---- instance 106: op1_1000_s5_w30 (t_en 9 ns, WWL 10..40 ns, release 42 ns) ----
ven_op1_1000_s5_w30  en_op1_1000_s5_w30  0 pwl(0 0 9.0000e-09 0 9.1000e-09 {VDD} 4.2000e-08 {VDD} 4.2100e-08 0)
venb_op1_1000_s5_w30 enb_op1_1000_s5_w30 0 pwl(0 {VDD} 9.0000e-09 {VDD} 9.1000e-09 0 4.2000e-08 0 4.2100e-08 {VDD})
vrs_op1_1000_s5_w30  rwls_op1_1000_s5_w30 0 pwl(0 {VDD} {T_READ} {VDD} {T_READ+TEDGE} 0 4.2000e-08 0 4.2100e-08 {VDD})
vww_op1_1000_s5_w30  wwl_op1_1000_s5_w30 0 pwl(0 0 1.0000e-08 0 1.0100e-08 {VDD} 4.0000e-08 {VDD} 4.0100e-08 0)
vwc_op1_1000_s5_w30  wbc_op1_1000_s5_w30 0 pwl(0 0 1.0000e-08 0 1.0100e-08 {VDD} 4.2000e-08 {VDD} 4.2100e-08 0)
swb_op1_1000_s5_w30 ref_op1_1000_s5_w30 wbl_op1_1000_s5_w30 wbc_op1_1000_s5_w30 0 swwbl
cwbl_op1_1000_s5_w30 wbl_op1_1000_s5_w30 0 {C_WBL}
spa_op1_1000_s5_w30 prea rbl_op1_1000_s5_w30 ctl 0 swpre
spr_op1_1000_s5_w30 pref ref_op1_1000_s5_w30 ctl 0 swpre
crbl_op1_1000_s5_w30 rbl_op1_1000_s5_w30 0 {C_RBL}
cref_op1_1000_s5_w30 ref_op1_1000_s5_w30 0 {C_RBL}   $ ASSUMPTION: ideal matched dummy load
XMWR_op1_1000_s5_w30_0 sn_op1_1000_s5_w30_0 wwl_op1_1000_s5_w30 wbl_op1_1000_s5_w30 0 sky130_fd_pr__nfet_01v8 L=0.15 W=0.42 nf=1 ad=0.1218 as=0.1218 pd=1.42 ps=1.42 nrd=0.69047619047619  nrs=0.69047619047619 sa=0 sb=0 sd=0 mult=1 m=1
XMRD_op1_1000_s5_w30_0 rbl_op1_1000_s5_w30 sn_op1_1000_s5_w30_0 rwls_op1_1000_s5_w30 0 sky130_fd_pr__nfet_01v8 L=0.15 W=0.42 nf=1 ad=0.1218 as=0.1218 pd=1.42 ps=1.42 nrd=0.69047619047619  nrs=0.69047619047619 sa=0 sb=0 sd=0 mult=1 m=1
csn_op1_1000_s5_w30_0 sn_op1_1000_s5_w30_0 0 {C_SN}
XMWR_op1_1000_s5_w30_1 sn_op1_1000_s5_w30_1 wwl_des wbl_op1_1000_s5_w30 0 sky130_fd_pr__nfet_01v8 L=0.15 W=0.42 nf=1 ad=0.1218 as=0.1218 pd=1.42 ps=1.42 nrd=0.69047619047619  nrs=0.69047619047619 sa=0 sb=0 sd=0 mult=1 m=1
XMRD_op1_1000_s5_w30_1 rbl_op1_1000_s5_w30 sn_op1_1000_s5_w30_1 rwl_des 0 sky130_fd_pr__nfet_01v8 L=0.15 W=0.42 nf=1 ad=0.1218 as=0.1218 pd=1.42 ps=1.42 nrd=0.69047619047619  nrs=0.69047619047619 sa=0 sb=0 sd=0 mult=1 m=1
csn_op1_1000_s5_w30_1 sn_op1_1000_s5_w30_1 0 {C_SN}
XMWR_op1_1000_s5_w30_2 sn_op1_1000_s5_w30_2 wwl_des wbl_op1_1000_s5_w30 0 sky130_fd_pr__nfet_01v8 L=0.15 W=0.42 nf=1 ad=0.1218 as=0.1218 pd=1.42 ps=1.42 nrd=0.69047619047619  nrs=0.69047619047619 sa=0 sb=0 sd=0 mult=1 m=1
XMRD_op1_1000_s5_w30_2 rbl_op1_1000_s5_w30 sn_op1_1000_s5_w30_2 rwl_des 0 sky130_fd_pr__nfet_01v8 L=0.15 W=0.42 nf=1 ad=0.1218 as=0.1218 pd=1.42 ps=1.42 nrd=0.69047619047619  nrs=0.69047619047619 sa=0 sb=0 sd=0 mult=1 m=1
csn_op1_1000_s5_w30_2 sn_op1_1000_s5_w30_2 0 {C_SN}
XMWR_op1_1000_s5_w30_3 sn_op1_1000_s5_w30_3 wwl_des wbl_op1_1000_s5_w30 0 sky130_fd_pr__nfet_01v8 L=0.15 W=0.42 nf=1 ad=0.1218 as=0.1218 pd=1.42 ps=1.42 nrd=0.69047619047619  nrs=0.69047619047619 sa=0 sb=0 sd=0 mult=1 m=1
XMRD_op1_1000_s5_w30_3 rbl_op1_1000_s5_w30 sn_op1_1000_s5_w30_3 rwl_des 0 sky130_fd_pr__nfet_01v8 L=0.15 W=0.42 nf=1 ad=0.1218 as=0.1218 pd=1.42 ps=1.42 nrd=0.69047619047619  nrs=0.69047619047619 sa=0 sb=0 sd=0 mult=1 m=1
csn_op1_1000_s5_w30_3 sn_op1_1000_s5_w30_3 0 {C_SN}
XMN1_op1_1000_s5_w30 rbl_op1_1000_s5_w30 ref_op1_1000_s5_w30 vn_op1_1000_s5_w30 0 sky130_fd_pr__nfet_01v8 L=0.15 W=1 nf=1 ad=0.29 as=0.29 pd=2.58 ps=2.58 mult=1 m=1
XMN2_op1_1000_s5_w30 ref_op1_1000_s5_w30 rbl_op1_1000_s5_w30 vn_op1_1000_s5_w30 0 sky130_fd_pr__nfet_01v8 L=0.15 W=1 nf=1 ad=0.29 as=0.29 pd=2.58 ps=2.58 mult=1 m=1
XMP1_op1_1000_s5_w30 rbl_op1_1000_s5_w30 ref_op1_1000_s5_w30 vp_op1_1000_s5_w30 vdd sky130_fd_pr__pfet_01v8 L=0.15 W=2 nf=1 ad=0.58 as=0.58 pd=4.58 ps=4.58 mult=1 m=1
XMP2_op1_1000_s5_w30 ref_op1_1000_s5_w30 rbl_op1_1000_s5_w30 vp_op1_1000_s5_w30 vdd sky130_fd_pr__pfet_01v8 L=0.15 W=2 nf=1 ad=0.58 as=0.58 pd=4.58 ps=4.58 mult=1 m=1
XMNF_op1_1000_s5_w30 vn_op1_1000_s5_w30 en_op1_1000_s5_w30 0 0 sky130_fd_pr__nfet_01v8 L=0.15 W=2 nf=1 ad=0.58 as=0.58 pd=4.58 ps=4.58 mult=1 m=1
XMPH_op1_1000_s5_w30 vp_op1_1000_s5_w30 enb_op1_1000_s5_w30 vdd vdd sky130_fd_pr__pfet_01v8 L=0.15 W=4 nf=1 ad=1.16 as=1.16 pd=8.58 ps=8.58 mult=1 m=1
bd_op1_1000_s5_w30 d_op1_1000_s5_w30 0 v=v(rbl_op1_1000_s5_w30)-v(ref_op1_1000_s5_w30)

* ---- instance 107: op1_1000_s5_w50 (t_en 9 ns, WWL 10..60 ns, release 62 ns) ----
ven_op1_1000_s5_w50  en_op1_1000_s5_w50  0 pwl(0 0 9.0000e-09 0 9.1000e-09 {VDD} 6.2000e-08 {VDD} 6.2100e-08 0)
venb_op1_1000_s5_w50 enb_op1_1000_s5_w50 0 pwl(0 {VDD} 9.0000e-09 {VDD} 9.1000e-09 0 6.2000e-08 0 6.2100e-08 {VDD})
vrs_op1_1000_s5_w50  rwls_op1_1000_s5_w50 0 pwl(0 {VDD} {T_READ} {VDD} {T_READ+TEDGE} 0 6.2000e-08 0 6.2100e-08 {VDD})
vww_op1_1000_s5_w50  wwl_op1_1000_s5_w50 0 pwl(0 0 1.0000e-08 0 1.0100e-08 {VDD} 6.0000e-08 {VDD} 6.0100e-08 0)
vwc_op1_1000_s5_w50  wbc_op1_1000_s5_w50 0 pwl(0 0 1.0000e-08 0 1.0100e-08 {VDD} 6.2000e-08 {VDD} 6.2100e-08 0)
swb_op1_1000_s5_w50 ref_op1_1000_s5_w50 wbl_op1_1000_s5_w50 wbc_op1_1000_s5_w50 0 swwbl
cwbl_op1_1000_s5_w50 wbl_op1_1000_s5_w50 0 {C_WBL}
spa_op1_1000_s5_w50 prea rbl_op1_1000_s5_w50 ctl 0 swpre
spr_op1_1000_s5_w50 pref ref_op1_1000_s5_w50 ctl 0 swpre
crbl_op1_1000_s5_w50 rbl_op1_1000_s5_w50 0 {C_RBL}
cref_op1_1000_s5_w50 ref_op1_1000_s5_w50 0 {C_RBL}   $ ASSUMPTION: ideal matched dummy load
XMWR_op1_1000_s5_w50_0 sn_op1_1000_s5_w50_0 wwl_op1_1000_s5_w50 wbl_op1_1000_s5_w50 0 sky130_fd_pr__nfet_01v8 L=0.15 W=0.42 nf=1 ad=0.1218 as=0.1218 pd=1.42 ps=1.42 nrd=0.69047619047619  nrs=0.69047619047619 sa=0 sb=0 sd=0 mult=1 m=1
XMRD_op1_1000_s5_w50_0 rbl_op1_1000_s5_w50 sn_op1_1000_s5_w50_0 rwls_op1_1000_s5_w50 0 sky130_fd_pr__nfet_01v8 L=0.15 W=0.42 nf=1 ad=0.1218 as=0.1218 pd=1.42 ps=1.42 nrd=0.69047619047619  nrs=0.69047619047619 sa=0 sb=0 sd=0 mult=1 m=1
csn_op1_1000_s5_w50_0 sn_op1_1000_s5_w50_0 0 {C_SN}
XMWR_op1_1000_s5_w50_1 sn_op1_1000_s5_w50_1 wwl_des wbl_op1_1000_s5_w50 0 sky130_fd_pr__nfet_01v8 L=0.15 W=0.42 nf=1 ad=0.1218 as=0.1218 pd=1.42 ps=1.42 nrd=0.69047619047619  nrs=0.69047619047619 sa=0 sb=0 sd=0 mult=1 m=1
XMRD_op1_1000_s5_w50_1 rbl_op1_1000_s5_w50 sn_op1_1000_s5_w50_1 rwl_des 0 sky130_fd_pr__nfet_01v8 L=0.15 W=0.42 nf=1 ad=0.1218 as=0.1218 pd=1.42 ps=1.42 nrd=0.69047619047619  nrs=0.69047619047619 sa=0 sb=0 sd=0 mult=1 m=1
csn_op1_1000_s5_w50_1 sn_op1_1000_s5_w50_1 0 {C_SN}
XMWR_op1_1000_s5_w50_2 sn_op1_1000_s5_w50_2 wwl_des wbl_op1_1000_s5_w50 0 sky130_fd_pr__nfet_01v8 L=0.15 W=0.42 nf=1 ad=0.1218 as=0.1218 pd=1.42 ps=1.42 nrd=0.69047619047619  nrs=0.69047619047619 sa=0 sb=0 sd=0 mult=1 m=1
XMRD_op1_1000_s5_w50_2 rbl_op1_1000_s5_w50 sn_op1_1000_s5_w50_2 rwl_des 0 sky130_fd_pr__nfet_01v8 L=0.15 W=0.42 nf=1 ad=0.1218 as=0.1218 pd=1.42 ps=1.42 nrd=0.69047619047619  nrs=0.69047619047619 sa=0 sb=0 sd=0 mult=1 m=1
csn_op1_1000_s5_w50_2 sn_op1_1000_s5_w50_2 0 {C_SN}
XMWR_op1_1000_s5_w50_3 sn_op1_1000_s5_w50_3 wwl_des wbl_op1_1000_s5_w50 0 sky130_fd_pr__nfet_01v8 L=0.15 W=0.42 nf=1 ad=0.1218 as=0.1218 pd=1.42 ps=1.42 nrd=0.69047619047619  nrs=0.69047619047619 sa=0 sb=0 sd=0 mult=1 m=1
XMRD_op1_1000_s5_w50_3 rbl_op1_1000_s5_w50 sn_op1_1000_s5_w50_3 rwl_des 0 sky130_fd_pr__nfet_01v8 L=0.15 W=0.42 nf=1 ad=0.1218 as=0.1218 pd=1.42 ps=1.42 nrd=0.69047619047619  nrs=0.69047619047619 sa=0 sb=0 sd=0 mult=1 m=1
csn_op1_1000_s5_w50_3 sn_op1_1000_s5_w50_3 0 {C_SN}
XMN1_op1_1000_s5_w50 rbl_op1_1000_s5_w50 ref_op1_1000_s5_w50 vn_op1_1000_s5_w50 0 sky130_fd_pr__nfet_01v8 L=0.15 W=1 nf=1 ad=0.29 as=0.29 pd=2.58 ps=2.58 mult=1 m=1
XMN2_op1_1000_s5_w50 ref_op1_1000_s5_w50 rbl_op1_1000_s5_w50 vn_op1_1000_s5_w50 0 sky130_fd_pr__nfet_01v8 L=0.15 W=1 nf=1 ad=0.29 as=0.29 pd=2.58 ps=2.58 mult=1 m=1
XMP1_op1_1000_s5_w50 rbl_op1_1000_s5_w50 ref_op1_1000_s5_w50 vp_op1_1000_s5_w50 vdd sky130_fd_pr__pfet_01v8 L=0.15 W=2 nf=1 ad=0.58 as=0.58 pd=4.58 ps=4.58 mult=1 m=1
XMP2_op1_1000_s5_w50 ref_op1_1000_s5_w50 rbl_op1_1000_s5_w50 vp_op1_1000_s5_w50 vdd sky130_fd_pr__pfet_01v8 L=0.15 W=2 nf=1 ad=0.58 as=0.58 pd=4.58 ps=4.58 mult=1 m=1
XMNF_op1_1000_s5_w50 vn_op1_1000_s5_w50 en_op1_1000_s5_w50 0 0 sky130_fd_pr__nfet_01v8 L=0.15 W=2 nf=1 ad=0.58 as=0.58 pd=4.58 ps=4.58 mult=1 m=1
XMPH_op1_1000_s5_w50 vp_op1_1000_s5_w50 enb_op1_1000_s5_w50 vdd vdd sky130_fd_pr__pfet_01v8 L=0.15 W=4 nf=1 ad=1.16 as=1.16 pd=8.58 ps=8.58 mult=1 m=1
bd_op1_1000_s5_w50 d_op1_1000_s5_w50 0 v=v(rbl_op1_1000_s5_w50)-v(ref_op1_1000_s5_w50)

* ---- instance 108: op1_1000_s10_w0p2 (t_en 14 ns, WWL 15..15.2 ns, release 17.2 ns) ----
ven_op1_1000_s10_w0p2  en_op1_1000_s10_w0p2  0 pwl(0 0 1.4000e-08 0 1.4100e-08 {VDD} 1.7200e-08 {VDD} 1.7300e-08 0)
venb_op1_1000_s10_w0p2 enb_op1_1000_s10_w0p2 0 pwl(0 {VDD} 1.4000e-08 {VDD} 1.4100e-08 0 1.7200e-08 0 1.7300e-08 {VDD})
vrs_op1_1000_s10_w0p2  rwls_op1_1000_s10_w0p2 0 pwl(0 {VDD} {T_READ} {VDD} {T_READ+TEDGE} 0 1.7200e-08 0 1.7300e-08 {VDD})
vww_op1_1000_s10_w0p2  wwl_op1_1000_s10_w0p2 0 pwl(0 0 1.5000e-08 0 1.5100e-08 {VDD} 1.5200e-08 {VDD} 1.5300e-08 0)
vwc_op1_1000_s10_w0p2  wbc_op1_1000_s10_w0p2 0 pwl(0 0 1.5000e-08 0 1.5100e-08 {VDD} 1.7200e-08 {VDD} 1.7300e-08 0)
swb_op1_1000_s10_w0p2 ref_op1_1000_s10_w0p2 wbl_op1_1000_s10_w0p2 wbc_op1_1000_s10_w0p2 0 swwbl
cwbl_op1_1000_s10_w0p2 wbl_op1_1000_s10_w0p2 0 {C_WBL}
spa_op1_1000_s10_w0p2 prea rbl_op1_1000_s10_w0p2 ctl 0 swpre
spr_op1_1000_s10_w0p2 pref ref_op1_1000_s10_w0p2 ctl 0 swpre
crbl_op1_1000_s10_w0p2 rbl_op1_1000_s10_w0p2 0 {C_RBL}
cref_op1_1000_s10_w0p2 ref_op1_1000_s10_w0p2 0 {C_RBL}   $ ASSUMPTION: ideal matched dummy load
XMWR_op1_1000_s10_w0p2_0 sn_op1_1000_s10_w0p2_0 wwl_op1_1000_s10_w0p2 wbl_op1_1000_s10_w0p2 0 sky130_fd_pr__nfet_01v8 L=0.15 W=0.42 nf=1 ad=0.1218 as=0.1218 pd=1.42 ps=1.42 nrd=0.69047619047619  nrs=0.69047619047619 sa=0 sb=0 sd=0 mult=1 m=1
XMRD_op1_1000_s10_w0p2_0 rbl_op1_1000_s10_w0p2 sn_op1_1000_s10_w0p2_0 rwls_op1_1000_s10_w0p2 0 sky130_fd_pr__nfet_01v8 L=0.15 W=0.42 nf=1 ad=0.1218 as=0.1218 pd=1.42 ps=1.42 nrd=0.69047619047619  nrs=0.69047619047619 sa=0 sb=0 sd=0 mult=1 m=1
csn_op1_1000_s10_w0p2_0 sn_op1_1000_s10_w0p2_0 0 {C_SN}
XMWR_op1_1000_s10_w0p2_1 sn_op1_1000_s10_w0p2_1 wwl_des wbl_op1_1000_s10_w0p2 0 sky130_fd_pr__nfet_01v8 L=0.15 W=0.42 nf=1 ad=0.1218 as=0.1218 pd=1.42 ps=1.42 nrd=0.69047619047619  nrs=0.69047619047619 sa=0 sb=0 sd=0 mult=1 m=1
XMRD_op1_1000_s10_w0p2_1 rbl_op1_1000_s10_w0p2 sn_op1_1000_s10_w0p2_1 rwl_des 0 sky130_fd_pr__nfet_01v8 L=0.15 W=0.42 nf=1 ad=0.1218 as=0.1218 pd=1.42 ps=1.42 nrd=0.69047619047619  nrs=0.69047619047619 sa=0 sb=0 sd=0 mult=1 m=1
csn_op1_1000_s10_w0p2_1 sn_op1_1000_s10_w0p2_1 0 {C_SN}
XMWR_op1_1000_s10_w0p2_2 sn_op1_1000_s10_w0p2_2 wwl_des wbl_op1_1000_s10_w0p2 0 sky130_fd_pr__nfet_01v8 L=0.15 W=0.42 nf=1 ad=0.1218 as=0.1218 pd=1.42 ps=1.42 nrd=0.69047619047619  nrs=0.69047619047619 sa=0 sb=0 sd=0 mult=1 m=1
XMRD_op1_1000_s10_w0p2_2 rbl_op1_1000_s10_w0p2 sn_op1_1000_s10_w0p2_2 rwl_des 0 sky130_fd_pr__nfet_01v8 L=0.15 W=0.42 nf=1 ad=0.1218 as=0.1218 pd=1.42 ps=1.42 nrd=0.69047619047619  nrs=0.69047619047619 sa=0 sb=0 sd=0 mult=1 m=1
csn_op1_1000_s10_w0p2_2 sn_op1_1000_s10_w0p2_2 0 {C_SN}
XMWR_op1_1000_s10_w0p2_3 sn_op1_1000_s10_w0p2_3 wwl_des wbl_op1_1000_s10_w0p2 0 sky130_fd_pr__nfet_01v8 L=0.15 W=0.42 nf=1 ad=0.1218 as=0.1218 pd=1.42 ps=1.42 nrd=0.69047619047619  nrs=0.69047619047619 sa=0 sb=0 sd=0 mult=1 m=1
XMRD_op1_1000_s10_w0p2_3 rbl_op1_1000_s10_w0p2 sn_op1_1000_s10_w0p2_3 rwl_des 0 sky130_fd_pr__nfet_01v8 L=0.15 W=0.42 nf=1 ad=0.1218 as=0.1218 pd=1.42 ps=1.42 nrd=0.69047619047619  nrs=0.69047619047619 sa=0 sb=0 sd=0 mult=1 m=1
csn_op1_1000_s10_w0p2_3 sn_op1_1000_s10_w0p2_3 0 {C_SN}
XMN1_op1_1000_s10_w0p2 rbl_op1_1000_s10_w0p2 ref_op1_1000_s10_w0p2 vn_op1_1000_s10_w0p2 0 sky130_fd_pr__nfet_01v8 L=0.15 W=1 nf=1 ad=0.29 as=0.29 pd=2.58 ps=2.58 mult=1 m=1
XMN2_op1_1000_s10_w0p2 ref_op1_1000_s10_w0p2 rbl_op1_1000_s10_w0p2 vn_op1_1000_s10_w0p2 0 sky130_fd_pr__nfet_01v8 L=0.15 W=1 nf=1 ad=0.29 as=0.29 pd=2.58 ps=2.58 mult=1 m=1
XMP1_op1_1000_s10_w0p2 rbl_op1_1000_s10_w0p2 ref_op1_1000_s10_w0p2 vp_op1_1000_s10_w0p2 vdd sky130_fd_pr__pfet_01v8 L=0.15 W=2 nf=1 ad=0.58 as=0.58 pd=4.58 ps=4.58 mult=1 m=1
XMP2_op1_1000_s10_w0p2 ref_op1_1000_s10_w0p2 rbl_op1_1000_s10_w0p2 vp_op1_1000_s10_w0p2 vdd sky130_fd_pr__pfet_01v8 L=0.15 W=2 nf=1 ad=0.58 as=0.58 pd=4.58 ps=4.58 mult=1 m=1
XMNF_op1_1000_s10_w0p2 vn_op1_1000_s10_w0p2 en_op1_1000_s10_w0p2 0 0 sky130_fd_pr__nfet_01v8 L=0.15 W=2 nf=1 ad=0.58 as=0.58 pd=4.58 ps=4.58 mult=1 m=1
XMPH_op1_1000_s10_w0p2 vp_op1_1000_s10_w0p2 enb_op1_1000_s10_w0p2 vdd vdd sky130_fd_pr__pfet_01v8 L=0.15 W=4 nf=1 ad=1.16 as=1.16 pd=8.58 ps=8.58 mult=1 m=1
bd_op1_1000_s10_w0p2 d_op1_1000_s10_w0p2 0 v=v(rbl_op1_1000_s10_w0p2)-v(ref_op1_1000_s10_w0p2)

* ---- instance 109: op1_1000_s10_w0p5 (t_en 14 ns, WWL 15..15.5 ns, release 17.5 ns) ----
ven_op1_1000_s10_w0p5  en_op1_1000_s10_w0p5  0 pwl(0 0 1.4000e-08 0 1.4100e-08 {VDD} 1.7500e-08 {VDD} 1.7600e-08 0)
venb_op1_1000_s10_w0p5 enb_op1_1000_s10_w0p5 0 pwl(0 {VDD} 1.4000e-08 {VDD} 1.4100e-08 0 1.7500e-08 0 1.7600e-08 {VDD})
vrs_op1_1000_s10_w0p5  rwls_op1_1000_s10_w0p5 0 pwl(0 {VDD} {T_READ} {VDD} {T_READ+TEDGE} 0 1.7500e-08 0 1.7600e-08 {VDD})
vww_op1_1000_s10_w0p5  wwl_op1_1000_s10_w0p5 0 pwl(0 0 1.5000e-08 0 1.5100e-08 {VDD} 1.5500e-08 {VDD} 1.5600e-08 0)
vwc_op1_1000_s10_w0p5  wbc_op1_1000_s10_w0p5 0 pwl(0 0 1.5000e-08 0 1.5100e-08 {VDD} 1.7500e-08 {VDD} 1.7600e-08 0)
swb_op1_1000_s10_w0p5 ref_op1_1000_s10_w0p5 wbl_op1_1000_s10_w0p5 wbc_op1_1000_s10_w0p5 0 swwbl
cwbl_op1_1000_s10_w0p5 wbl_op1_1000_s10_w0p5 0 {C_WBL}
spa_op1_1000_s10_w0p5 prea rbl_op1_1000_s10_w0p5 ctl 0 swpre
spr_op1_1000_s10_w0p5 pref ref_op1_1000_s10_w0p5 ctl 0 swpre
crbl_op1_1000_s10_w0p5 rbl_op1_1000_s10_w0p5 0 {C_RBL}
cref_op1_1000_s10_w0p5 ref_op1_1000_s10_w0p5 0 {C_RBL}   $ ASSUMPTION: ideal matched dummy load
XMWR_op1_1000_s10_w0p5_0 sn_op1_1000_s10_w0p5_0 wwl_op1_1000_s10_w0p5 wbl_op1_1000_s10_w0p5 0 sky130_fd_pr__nfet_01v8 L=0.15 W=0.42 nf=1 ad=0.1218 as=0.1218 pd=1.42 ps=1.42 nrd=0.69047619047619  nrs=0.69047619047619 sa=0 sb=0 sd=0 mult=1 m=1
XMRD_op1_1000_s10_w0p5_0 rbl_op1_1000_s10_w0p5 sn_op1_1000_s10_w0p5_0 rwls_op1_1000_s10_w0p5 0 sky130_fd_pr__nfet_01v8 L=0.15 W=0.42 nf=1 ad=0.1218 as=0.1218 pd=1.42 ps=1.42 nrd=0.69047619047619  nrs=0.69047619047619 sa=0 sb=0 sd=0 mult=1 m=1
csn_op1_1000_s10_w0p5_0 sn_op1_1000_s10_w0p5_0 0 {C_SN}
XMWR_op1_1000_s10_w0p5_1 sn_op1_1000_s10_w0p5_1 wwl_des wbl_op1_1000_s10_w0p5 0 sky130_fd_pr__nfet_01v8 L=0.15 W=0.42 nf=1 ad=0.1218 as=0.1218 pd=1.42 ps=1.42 nrd=0.69047619047619  nrs=0.69047619047619 sa=0 sb=0 sd=0 mult=1 m=1
XMRD_op1_1000_s10_w0p5_1 rbl_op1_1000_s10_w0p5 sn_op1_1000_s10_w0p5_1 rwl_des 0 sky130_fd_pr__nfet_01v8 L=0.15 W=0.42 nf=1 ad=0.1218 as=0.1218 pd=1.42 ps=1.42 nrd=0.69047619047619  nrs=0.69047619047619 sa=0 sb=0 sd=0 mult=1 m=1
csn_op1_1000_s10_w0p5_1 sn_op1_1000_s10_w0p5_1 0 {C_SN}
XMWR_op1_1000_s10_w0p5_2 sn_op1_1000_s10_w0p5_2 wwl_des wbl_op1_1000_s10_w0p5 0 sky130_fd_pr__nfet_01v8 L=0.15 W=0.42 nf=1 ad=0.1218 as=0.1218 pd=1.42 ps=1.42 nrd=0.69047619047619  nrs=0.69047619047619 sa=0 sb=0 sd=0 mult=1 m=1
XMRD_op1_1000_s10_w0p5_2 rbl_op1_1000_s10_w0p5 sn_op1_1000_s10_w0p5_2 rwl_des 0 sky130_fd_pr__nfet_01v8 L=0.15 W=0.42 nf=1 ad=0.1218 as=0.1218 pd=1.42 ps=1.42 nrd=0.69047619047619  nrs=0.69047619047619 sa=0 sb=0 sd=0 mult=1 m=1
csn_op1_1000_s10_w0p5_2 sn_op1_1000_s10_w0p5_2 0 {C_SN}
XMWR_op1_1000_s10_w0p5_3 sn_op1_1000_s10_w0p5_3 wwl_des wbl_op1_1000_s10_w0p5 0 sky130_fd_pr__nfet_01v8 L=0.15 W=0.42 nf=1 ad=0.1218 as=0.1218 pd=1.42 ps=1.42 nrd=0.69047619047619  nrs=0.69047619047619 sa=0 sb=0 sd=0 mult=1 m=1
XMRD_op1_1000_s10_w0p5_3 rbl_op1_1000_s10_w0p5 sn_op1_1000_s10_w0p5_3 rwl_des 0 sky130_fd_pr__nfet_01v8 L=0.15 W=0.42 nf=1 ad=0.1218 as=0.1218 pd=1.42 ps=1.42 nrd=0.69047619047619  nrs=0.69047619047619 sa=0 sb=0 sd=0 mult=1 m=1
csn_op1_1000_s10_w0p5_3 sn_op1_1000_s10_w0p5_3 0 {C_SN}
XMN1_op1_1000_s10_w0p5 rbl_op1_1000_s10_w0p5 ref_op1_1000_s10_w0p5 vn_op1_1000_s10_w0p5 0 sky130_fd_pr__nfet_01v8 L=0.15 W=1 nf=1 ad=0.29 as=0.29 pd=2.58 ps=2.58 mult=1 m=1
XMN2_op1_1000_s10_w0p5 ref_op1_1000_s10_w0p5 rbl_op1_1000_s10_w0p5 vn_op1_1000_s10_w0p5 0 sky130_fd_pr__nfet_01v8 L=0.15 W=1 nf=1 ad=0.29 as=0.29 pd=2.58 ps=2.58 mult=1 m=1
XMP1_op1_1000_s10_w0p5 rbl_op1_1000_s10_w0p5 ref_op1_1000_s10_w0p5 vp_op1_1000_s10_w0p5 vdd sky130_fd_pr__pfet_01v8 L=0.15 W=2 nf=1 ad=0.58 as=0.58 pd=4.58 ps=4.58 mult=1 m=1
XMP2_op1_1000_s10_w0p5 ref_op1_1000_s10_w0p5 rbl_op1_1000_s10_w0p5 vp_op1_1000_s10_w0p5 vdd sky130_fd_pr__pfet_01v8 L=0.15 W=2 nf=1 ad=0.58 as=0.58 pd=4.58 ps=4.58 mult=1 m=1
XMNF_op1_1000_s10_w0p5 vn_op1_1000_s10_w0p5 en_op1_1000_s10_w0p5 0 0 sky130_fd_pr__nfet_01v8 L=0.15 W=2 nf=1 ad=0.58 as=0.58 pd=4.58 ps=4.58 mult=1 m=1
XMPH_op1_1000_s10_w0p5 vp_op1_1000_s10_w0p5 enb_op1_1000_s10_w0p5 vdd vdd sky130_fd_pr__pfet_01v8 L=0.15 W=4 nf=1 ad=1.16 as=1.16 pd=8.58 ps=8.58 mult=1 m=1
bd_op1_1000_s10_w0p5 d_op1_1000_s10_w0p5 0 v=v(rbl_op1_1000_s10_w0p5)-v(ref_op1_1000_s10_w0p5)

* ---- instance 110: op1_1000_s10_w1 (t_en 14 ns, WWL 15..16 ns, release 18 ns) ----
ven_op1_1000_s10_w1  en_op1_1000_s10_w1  0 pwl(0 0 1.4000e-08 0 1.4100e-08 {VDD} 1.8000e-08 {VDD} 1.8100e-08 0)
venb_op1_1000_s10_w1 enb_op1_1000_s10_w1 0 pwl(0 {VDD} 1.4000e-08 {VDD} 1.4100e-08 0 1.8000e-08 0 1.8100e-08 {VDD})
vrs_op1_1000_s10_w1  rwls_op1_1000_s10_w1 0 pwl(0 {VDD} {T_READ} {VDD} {T_READ+TEDGE} 0 1.8000e-08 0 1.8100e-08 {VDD})
vww_op1_1000_s10_w1  wwl_op1_1000_s10_w1 0 pwl(0 0 1.5000e-08 0 1.5100e-08 {VDD} 1.6000e-08 {VDD} 1.6100e-08 0)
vwc_op1_1000_s10_w1  wbc_op1_1000_s10_w1 0 pwl(0 0 1.5000e-08 0 1.5100e-08 {VDD} 1.8000e-08 {VDD} 1.8100e-08 0)
swb_op1_1000_s10_w1 ref_op1_1000_s10_w1 wbl_op1_1000_s10_w1 wbc_op1_1000_s10_w1 0 swwbl
cwbl_op1_1000_s10_w1 wbl_op1_1000_s10_w1 0 {C_WBL}
spa_op1_1000_s10_w1 prea rbl_op1_1000_s10_w1 ctl 0 swpre
spr_op1_1000_s10_w1 pref ref_op1_1000_s10_w1 ctl 0 swpre
crbl_op1_1000_s10_w1 rbl_op1_1000_s10_w1 0 {C_RBL}
cref_op1_1000_s10_w1 ref_op1_1000_s10_w1 0 {C_RBL}   $ ASSUMPTION: ideal matched dummy load
XMWR_op1_1000_s10_w1_0 sn_op1_1000_s10_w1_0 wwl_op1_1000_s10_w1 wbl_op1_1000_s10_w1 0 sky130_fd_pr__nfet_01v8 L=0.15 W=0.42 nf=1 ad=0.1218 as=0.1218 pd=1.42 ps=1.42 nrd=0.69047619047619  nrs=0.69047619047619 sa=0 sb=0 sd=0 mult=1 m=1
XMRD_op1_1000_s10_w1_0 rbl_op1_1000_s10_w1 sn_op1_1000_s10_w1_0 rwls_op1_1000_s10_w1 0 sky130_fd_pr__nfet_01v8 L=0.15 W=0.42 nf=1 ad=0.1218 as=0.1218 pd=1.42 ps=1.42 nrd=0.69047619047619  nrs=0.69047619047619 sa=0 sb=0 sd=0 mult=1 m=1
csn_op1_1000_s10_w1_0 sn_op1_1000_s10_w1_0 0 {C_SN}
XMWR_op1_1000_s10_w1_1 sn_op1_1000_s10_w1_1 wwl_des wbl_op1_1000_s10_w1 0 sky130_fd_pr__nfet_01v8 L=0.15 W=0.42 nf=1 ad=0.1218 as=0.1218 pd=1.42 ps=1.42 nrd=0.69047619047619  nrs=0.69047619047619 sa=0 sb=0 sd=0 mult=1 m=1
XMRD_op1_1000_s10_w1_1 rbl_op1_1000_s10_w1 sn_op1_1000_s10_w1_1 rwl_des 0 sky130_fd_pr__nfet_01v8 L=0.15 W=0.42 nf=1 ad=0.1218 as=0.1218 pd=1.42 ps=1.42 nrd=0.69047619047619  nrs=0.69047619047619 sa=0 sb=0 sd=0 mult=1 m=1
csn_op1_1000_s10_w1_1 sn_op1_1000_s10_w1_1 0 {C_SN}
XMWR_op1_1000_s10_w1_2 sn_op1_1000_s10_w1_2 wwl_des wbl_op1_1000_s10_w1 0 sky130_fd_pr__nfet_01v8 L=0.15 W=0.42 nf=1 ad=0.1218 as=0.1218 pd=1.42 ps=1.42 nrd=0.69047619047619  nrs=0.69047619047619 sa=0 sb=0 sd=0 mult=1 m=1
XMRD_op1_1000_s10_w1_2 rbl_op1_1000_s10_w1 sn_op1_1000_s10_w1_2 rwl_des 0 sky130_fd_pr__nfet_01v8 L=0.15 W=0.42 nf=1 ad=0.1218 as=0.1218 pd=1.42 ps=1.42 nrd=0.69047619047619  nrs=0.69047619047619 sa=0 sb=0 sd=0 mult=1 m=1
csn_op1_1000_s10_w1_2 sn_op1_1000_s10_w1_2 0 {C_SN}
XMWR_op1_1000_s10_w1_3 sn_op1_1000_s10_w1_3 wwl_des wbl_op1_1000_s10_w1 0 sky130_fd_pr__nfet_01v8 L=0.15 W=0.42 nf=1 ad=0.1218 as=0.1218 pd=1.42 ps=1.42 nrd=0.69047619047619  nrs=0.69047619047619 sa=0 sb=0 sd=0 mult=1 m=1
XMRD_op1_1000_s10_w1_3 rbl_op1_1000_s10_w1 sn_op1_1000_s10_w1_3 rwl_des 0 sky130_fd_pr__nfet_01v8 L=0.15 W=0.42 nf=1 ad=0.1218 as=0.1218 pd=1.42 ps=1.42 nrd=0.69047619047619  nrs=0.69047619047619 sa=0 sb=0 sd=0 mult=1 m=1
csn_op1_1000_s10_w1_3 sn_op1_1000_s10_w1_3 0 {C_SN}
XMN1_op1_1000_s10_w1 rbl_op1_1000_s10_w1 ref_op1_1000_s10_w1 vn_op1_1000_s10_w1 0 sky130_fd_pr__nfet_01v8 L=0.15 W=1 nf=1 ad=0.29 as=0.29 pd=2.58 ps=2.58 mult=1 m=1
XMN2_op1_1000_s10_w1 ref_op1_1000_s10_w1 rbl_op1_1000_s10_w1 vn_op1_1000_s10_w1 0 sky130_fd_pr__nfet_01v8 L=0.15 W=1 nf=1 ad=0.29 as=0.29 pd=2.58 ps=2.58 mult=1 m=1
XMP1_op1_1000_s10_w1 rbl_op1_1000_s10_w1 ref_op1_1000_s10_w1 vp_op1_1000_s10_w1 vdd sky130_fd_pr__pfet_01v8 L=0.15 W=2 nf=1 ad=0.58 as=0.58 pd=4.58 ps=4.58 mult=1 m=1
XMP2_op1_1000_s10_w1 ref_op1_1000_s10_w1 rbl_op1_1000_s10_w1 vp_op1_1000_s10_w1 vdd sky130_fd_pr__pfet_01v8 L=0.15 W=2 nf=1 ad=0.58 as=0.58 pd=4.58 ps=4.58 mult=1 m=1
XMNF_op1_1000_s10_w1 vn_op1_1000_s10_w1 en_op1_1000_s10_w1 0 0 sky130_fd_pr__nfet_01v8 L=0.15 W=2 nf=1 ad=0.58 as=0.58 pd=4.58 ps=4.58 mult=1 m=1
XMPH_op1_1000_s10_w1 vp_op1_1000_s10_w1 enb_op1_1000_s10_w1 vdd vdd sky130_fd_pr__pfet_01v8 L=0.15 W=4 nf=1 ad=1.16 as=1.16 pd=8.58 ps=8.58 mult=1 m=1
bd_op1_1000_s10_w1 d_op1_1000_s10_w1 0 v=v(rbl_op1_1000_s10_w1)-v(ref_op1_1000_s10_w1)

* ---- instance 111: op1_1000_s10_w2 (t_en 14 ns, WWL 15..17 ns, release 19 ns) ----
ven_op1_1000_s10_w2  en_op1_1000_s10_w2  0 pwl(0 0 1.4000e-08 0 1.4100e-08 {VDD} 1.9000e-08 {VDD} 1.9100e-08 0)
venb_op1_1000_s10_w2 enb_op1_1000_s10_w2 0 pwl(0 {VDD} 1.4000e-08 {VDD} 1.4100e-08 0 1.9000e-08 0 1.9100e-08 {VDD})
vrs_op1_1000_s10_w2  rwls_op1_1000_s10_w2 0 pwl(0 {VDD} {T_READ} {VDD} {T_READ+TEDGE} 0 1.9000e-08 0 1.9100e-08 {VDD})
vww_op1_1000_s10_w2  wwl_op1_1000_s10_w2 0 pwl(0 0 1.5000e-08 0 1.5100e-08 {VDD} 1.7000e-08 {VDD} 1.7100e-08 0)
vwc_op1_1000_s10_w2  wbc_op1_1000_s10_w2 0 pwl(0 0 1.5000e-08 0 1.5100e-08 {VDD} 1.9000e-08 {VDD} 1.9100e-08 0)
swb_op1_1000_s10_w2 ref_op1_1000_s10_w2 wbl_op1_1000_s10_w2 wbc_op1_1000_s10_w2 0 swwbl
cwbl_op1_1000_s10_w2 wbl_op1_1000_s10_w2 0 {C_WBL}
spa_op1_1000_s10_w2 prea rbl_op1_1000_s10_w2 ctl 0 swpre
spr_op1_1000_s10_w2 pref ref_op1_1000_s10_w2 ctl 0 swpre
crbl_op1_1000_s10_w2 rbl_op1_1000_s10_w2 0 {C_RBL}
cref_op1_1000_s10_w2 ref_op1_1000_s10_w2 0 {C_RBL}   $ ASSUMPTION: ideal matched dummy load
XMWR_op1_1000_s10_w2_0 sn_op1_1000_s10_w2_0 wwl_op1_1000_s10_w2 wbl_op1_1000_s10_w2 0 sky130_fd_pr__nfet_01v8 L=0.15 W=0.42 nf=1 ad=0.1218 as=0.1218 pd=1.42 ps=1.42 nrd=0.69047619047619  nrs=0.69047619047619 sa=0 sb=0 sd=0 mult=1 m=1
XMRD_op1_1000_s10_w2_0 rbl_op1_1000_s10_w2 sn_op1_1000_s10_w2_0 rwls_op1_1000_s10_w2 0 sky130_fd_pr__nfet_01v8 L=0.15 W=0.42 nf=1 ad=0.1218 as=0.1218 pd=1.42 ps=1.42 nrd=0.69047619047619  nrs=0.69047619047619 sa=0 sb=0 sd=0 mult=1 m=1
csn_op1_1000_s10_w2_0 sn_op1_1000_s10_w2_0 0 {C_SN}
XMWR_op1_1000_s10_w2_1 sn_op1_1000_s10_w2_1 wwl_des wbl_op1_1000_s10_w2 0 sky130_fd_pr__nfet_01v8 L=0.15 W=0.42 nf=1 ad=0.1218 as=0.1218 pd=1.42 ps=1.42 nrd=0.69047619047619  nrs=0.69047619047619 sa=0 sb=0 sd=0 mult=1 m=1
XMRD_op1_1000_s10_w2_1 rbl_op1_1000_s10_w2 sn_op1_1000_s10_w2_1 rwl_des 0 sky130_fd_pr__nfet_01v8 L=0.15 W=0.42 nf=1 ad=0.1218 as=0.1218 pd=1.42 ps=1.42 nrd=0.69047619047619  nrs=0.69047619047619 sa=0 sb=0 sd=0 mult=1 m=1
csn_op1_1000_s10_w2_1 sn_op1_1000_s10_w2_1 0 {C_SN}
XMWR_op1_1000_s10_w2_2 sn_op1_1000_s10_w2_2 wwl_des wbl_op1_1000_s10_w2 0 sky130_fd_pr__nfet_01v8 L=0.15 W=0.42 nf=1 ad=0.1218 as=0.1218 pd=1.42 ps=1.42 nrd=0.69047619047619  nrs=0.69047619047619 sa=0 sb=0 sd=0 mult=1 m=1
XMRD_op1_1000_s10_w2_2 rbl_op1_1000_s10_w2 sn_op1_1000_s10_w2_2 rwl_des 0 sky130_fd_pr__nfet_01v8 L=0.15 W=0.42 nf=1 ad=0.1218 as=0.1218 pd=1.42 ps=1.42 nrd=0.69047619047619  nrs=0.69047619047619 sa=0 sb=0 sd=0 mult=1 m=1
csn_op1_1000_s10_w2_2 sn_op1_1000_s10_w2_2 0 {C_SN}
XMWR_op1_1000_s10_w2_3 sn_op1_1000_s10_w2_3 wwl_des wbl_op1_1000_s10_w2 0 sky130_fd_pr__nfet_01v8 L=0.15 W=0.42 nf=1 ad=0.1218 as=0.1218 pd=1.42 ps=1.42 nrd=0.69047619047619  nrs=0.69047619047619 sa=0 sb=0 sd=0 mult=1 m=1
XMRD_op1_1000_s10_w2_3 rbl_op1_1000_s10_w2 sn_op1_1000_s10_w2_3 rwl_des 0 sky130_fd_pr__nfet_01v8 L=0.15 W=0.42 nf=1 ad=0.1218 as=0.1218 pd=1.42 ps=1.42 nrd=0.69047619047619  nrs=0.69047619047619 sa=0 sb=0 sd=0 mult=1 m=1
csn_op1_1000_s10_w2_3 sn_op1_1000_s10_w2_3 0 {C_SN}
XMN1_op1_1000_s10_w2 rbl_op1_1000_s10_w2 ref_op1_1000_s10_w2 vn_op1_1000_s10_w2 0 sky130_fd_pr__nfet_01v8 L=0.15 W=1 nf=1 ad=0.29 as=0.29 pd=2.58 ps=2.58 mult=1 m=1
XMN2_op1_1000_s10_w2 ref_op1_1000_s10_w2 rbl_op1_1000_s10_w2 vn_op1_1000_s10_w2 0 sky130_fd_pr__nfet_01v8 L=0.15 W=1 nf=1 ad=0.29 as=0.29 pd=2.58 ps=2.58 mult=1 m=1
XMP1_op1_1000_s10_w2 rbl_op1_1000_s10_w2 ref_op1_1000_s10_w2 vp_op1_1000_s10_w2 vdd sky130_fd_pr__pfet_01v8 L=0.15 W=2 nf=1 ad=0.58 as=0.58 pd=4.58 ps=4.58 mult=1 m=1
XMP2_op1_1000_s10_w2 ref_op1_1000_s10_w2 rbl_op1_1000_s10_w2 vp_op1_1000_s10_w2 vdd sky130_fd_pr__pfet_01v8 L=0.15 W=2 nf=1 ad=0.58 as=0.58 pd=4.58 ps=4.58 mult=1 m=1
XMNF_op1_1000_s10_w2 vn_op1_1000_s10_w2 en_op1_1000_s10_w2 0 0 sky130_fd_pr__nfet_01v8 L=0.15 W=2 nf=1 ad=0.58 as=0.58 pd=4.58 ps=4.58 mult=1 m=1
XMPH_op1_1000_s10_w2 vp_op1_1000_s10_w2 enb_op1_1000_s10_w2 vdd vdd sky130_fd_pr__pfet_01v8 L=0.15 W=4 nf=1 ad=1.16 as=1.16 pd=8.58 ps=8.58 mult=1 m=1
bd_op1_1000_s10_w2 d_op1_1000_s10_w2 0 v=v(rbl_op1_1000_s10_w2)-v(ref_op1_1000_s10_w2)

* ---- instance 112: op1_1000_s10_w3 (t_en 14 ns, WWL 15..18 ns, release 20 ns) ----
ven_op1_1000_s10_w3  en_op1_1000_s10_w3  0 pwl(0 0 1.4000e-08 0 1.4100e-08 {VDD} 2.0000e-08 {VDD} 2.0100e-08 0)
venb_op1_1000_s10_w3 enb_op1_1000_s10_w3 0 pwl(0 {VDD} 1.4000e-08 {VDD} 1.4100e-08 0 2.0000e-08 0 2.0100e-08 {VDD})
vrs_op1_1000_s10_w3  rwls_op1_1000_s10_w3 0 pwl(0 {VDD} {T_READ} {VDD} {T_READ+TEDGE} 0 2.0000e-08 0 2.0100e-08 {VDD})
vww_op1_1000_s10_w3  wwl_op1_1000_s10_w3 0 pwl(0 0 1.5000e-08 0 1.5100e-08 {VDD} 1.8000e-08 {VDD} 1.8100e-08 0)
vwc_op1_1000_s10_w3  wbc_op1_1000_s10_w3 0 pwl(0 0 1.5000e-08 0 1.5100e-08 {VDD} 2.0000e-08 {VDD} 2.0100e-08 0)
swb_op1_1000_s10_w3 ref_op1_1000_s10_w3 wbl_op1_1000_s10_w3 wbc_op1_1000_s10_w3 0 swwbl
cwbl_op1_1000_s10_w3 wbl_op1_1000_s10_w3 0 {C_WBL}
spa_op1_1000_s10_w3 prea rbl_op1_1000_s10_w3 ctl 0 swpre
spr_op1_1000_s10_w3 pref ref_op1_1000_s10_w3 ctl 0 swpre
crbl_op1_1000_s10_w3 rbl_op1_1000_s10_w3 0 {C_RBL}
cref_op1_1000_s10_w3 ref_op1_1000_s10_w3 0 {C_RBL}   $ ASSUMPTION: ideal matched dummy load
XMWR_op1_1000_s10_w3_0 sn_op1_1000_s10_w3_0 wwl_op1_1000_s10_w3 wbl_op1_1000_s10_w3 0 sky130_fd_pr__nfet_01v8 L=0.15 W=0.42 nf=1 ad=0.1218 as=0.1218 pd=1.42 ps=1.42 nrd=0.69047619047619  nrs=0.69047619047619 sa=0 sb=0 sd=0 mult=1 m=1
XMRD_op1_1000_s10_w3_0 rbl_op1_1000_s10_w3 sn_op1_1000_s10_w3_0 rwls_op1_1000_s10_w3 0 sky130_fd_pr__nfet_01v8 L=0.15 W=0.42 nf=1 ad=0.1218 as=0.1218 pd=1.42 ps=1.42 nrd=0.69047619047619  nrs=0.69047619047619 sa=0 sb=0 sd=0 mult=1 m=1
csn_op1_1000_s10_w3_0 sn_op1_1000_s10_w3_0 0 {C_SN}
XMWR_op1_1000_s10_w3_1 sn_op1_1000_s10_w3_1 wwl_des wbl_op1_1000_s10_w3 0 sky130_fd_pr__nfet_01v8 L=0.15 W=0.42 nf=1 ad=0.1218 as=0.1218 pd=1.42 ps=1.42 nrd=0.69047619047619  nrs=0.69047619047619 sa=0 sb=0 sd=0 mult=1 m=1
XMRD_op1_1000_s10_w3_1 rbl_op1_1000_s10_w3 sn_op1_1000_s10_w3_1 rwl_des 0 sky130_fd_pr__nfet_01v8 L=0.15 W=0.42 nf=1 ad=0.1218 as=0.1218 pd=1.42 ps=1.42 nrd=0.69047619047619  nrs=0.69047619047619 sa=0 sb=0 sd=0 mult=1 m=1
csn_op1_1000_s10_w3_1 sn_op1_1000_s10_w3_1 0 {C_SN}
XMWR_op1_1000_s10_w3_2 sn_op1_1000_s10_w3_2 wwl_des wbl_op1_1000_s10_w3 0 sky130_fd_pr__nfet_01v8 L=0.15 W=0.42 nf=1 ad=0.1218 as=0.1218 pd=1.42 ps=1.42 nrd=0.69047619047619  nrs=0.69047619047619 sa=0 sb=0 sd=0 mult=1 m=1
XMRD_op1_1000_s10_w3_2 rbl_op1_1000_s10_w3 sn_op1_1000_s10_w3_2 rwl_des 0 sky130_fd_pr__nfet_01v8 L=0.15 W=0.42 nf=1 ad=0.1218 as=0.1218 pd=1.42 ps=1.42 nrd=0.69047619047619  nrs=0.69047619047619 sa=0 sb=0 sd=0 mult=1 m=1
csn_op1_1000_s10_w3_2 sn_op1_1000_s10_w3_2 0 {C_SN}
XMWR_op1_1000_s10_w3_3 sn_op1_1000_s10_w3_3 wwl_des wbl_op1_1000_s10_w3 0 sky130_fd_pr__nfet_01v8 L=0.15 W=0.42 nf=1 ad=0.1218 as=0.1218 pd=1.42 ps=1.42 nrd=0.69047619047619  nrs=0.69047619047619 sa=0 sb=0 sd=0 mult=1 m=1
XMRD_op1_1000_s10_w3_3 rbl_op1_1000_s10_w3 sn_op1_1000_s10_w3_3 rwl_des 0 sky130_fd_pr__nfet_01v8 L=0.15 W=0.42 nf=1 ad=0.1218 as=0.1218 pd=1.42 ps=1.42 nrd=0.69047619047619  nrs=0.69047619047619 sa=0 sb=0 sd=0 mult=1 m=1
csn_op1_1000_s10_w3_3 sn_op1_1000_s10_w3_3 0 {C_SN}
XMN1_op1_1000_s10_w3 rbl_op1_1000_s10_w3 ref_op1_1000_s10_w3 vn_op1_1000_s10_w3 0 sky130_fd_pr__nfet_01v8 L=0.15 W=1 nf=1 ad=0.29 as=0.29 pd=2.58 ps=2.58 mult=1 m=1
XMN2_op1_1000_s10_w3 ref_op1_1000_s10_w3 rbl_op1_1000_s10_w3 vn_op1_1000_s10_w3 0 sky130_fd_pr__nfet_01v8 L=0.15 W=1 nf=1 ad=0.29 as=0.29 pd=2.58 ps=2.58 mult=1 m=1
XMP1_op1_1000_s10_w3 rbl_op1_1000_s10_w3 ref_op1_1000_s10_w3 vp_op1_1000_s10_w3 vdd sky130_fd_pr__pfet_01v8 L=0.15 W=2 nf=1 ad=0.58 as=0.58 pd=4.58 ps=4.58 mult=1 m=1
XMP2_op1_1000_s10_w3 ref_op1_1000_s10_w3 rbl_op1_1000_s10_w3 vp_op1_1000_s10_w3 vdd sky130_fd_pr__pfet_01v8 L=0.15 W=2 nf=1 ad=0.58 as=0.58 pd=4.58 ps=4.58 mult=1 m=1
XMNF_op1_1000_s10_w3 vn_op1_1000_s10_w3 en_op1_1000_s10_w3 0 0 sky130_fd_pr__nfet_01v8 L=0.15 W=2 nf=1 ad=0.58 as=0.58 pd=4.58 ps=4.58 mult=1 m=1
XMPH_op1_1000_s10_w3 vp_op1_1000_s10_w3 enb_op1_1000_s10_w3 vdd vdd sky130_fd_pr__pfet_01v8 L=0.15 W=4 nf=1 ad=1.16 as=1.16 pd=8.58 ps=8.58 mult=1 m=1
bd_op1_1000_s10_w3 d_op1_1000_s10_w3 0 v=v(rbl_op1_1000_s10_w3)-v(ref_op1_1000_s10_w3)

* ---- instance 113: op1_1000_s10_w5 (t_en 14 ns, WWL 15..20 ns, release 22 ns) ----
ven_op1_1000_s10_w5  en_op1_1000_s10_w5  0 pwl(0 0 1.4000e-08 0 1.4100e-08 {VDD} 2.2000e-08 {VDD} 2.2100e-08 0)
venb_op1_1000_s10_w5 enb_op1_1000_s10_w5 0 pwl(0 {VDD} 1.4000e-08 {VDD} 1.4100e-08 0 2.2000e-08 0 2.2100e-08 {VDD})
vrs_op1_1000_s10_w5  rwls_op1_1000_s10_w5 0 pwl(0 {VDD} {T_READ} {VDD} {T_READ+TEDGE} 0 2.2000e-08 0 2.2100e-08 {VDD})
vww_op1_1000_s10_w5  wwl_op1_1000_s10_w5 0 pwl(0 0 1.5000e-08 0 1.5100e-08 {VDD} 2.0000e-08 {VDD} 2.0100e-08 0)
vwc_op1_1000_s10_w5  wbc_op1_1000_s10_w5 0 pwl(0 0 1.5000e-08 0 1.5100e-08 {VDD} 2.2000e-08 {VDD} 2.2100e-08 0)
swb_op1_1000_s10_w5 ref_op1_1000_s10_w5 wbl_op1_1000_s10_w5 wbc_op1_1000_s10_w5 0 swwbl
cwbl_op1_1000_s10_w5 wbl_op1_1000_s10_w5 0 {C_WBL}
spa_op1_1000_s10_w5 prea rbl_op1_1000_s10_w5 ctl 0 swpre
spr_op1_1000_s10_w5 pref ref_op1_1000_s10_w5 ctl 0 swpre
crbl_op1_1000_s10_w5 rbl_op1_1000_s10_w5 0 {C_RBL}
cref_op1_1000_s10_w5 ref_op1_1000_s10_w5 0 {C_RBL}   $ ASSUMPTION: ideal matched dummy load
XMWR_op1_1000_s10_w5_0 sn_op1_1000_s10_w5_0 wwl_op1_1000_s10_w5 wbl_op1_1000_s10_w5 0 sky130_fd_pr__nfet_01v8 L=0.15 W=0.42 nf=1 ad=0.1218 as=0.1218 pd=1.42 ps=1.42 nrd=0.69047619047619  nrs=0.69047619047619 sa=0 sb=0 sd=0 mult=1 m=1
XMRD_op1_1000_s10_w5_0 rbl_op1_1000_s10_w5 sn_op1_1000_s10_w5_0 rwls_op1_1000_s10_w5 0 sky130_fd_pr__nfet_01v8 L=0.15 W=0.42 nf=1 ad=0.1218 as=0.1218 pd=1.42 ps=1.42 nrd=0.69047619047619  nrs=0.69047619047619 sa=0 sb=0 sd=0 mult=1 m=1
csn_op1_1000_s10_w5_0 sn_op1_1000_s10_w5_0 0 {C_SN}
XMWR_op1_1000_s10_w5_1 sn_op1_1000_s10_w5_1 wwl_des wbl_op1_1000_s10_w5 0 sky130_fd_pr__nfet_01v8 L=0.15 W=0.42 nf=1 ad=0.1218 as=0.1218 pd=1.42 ps=1.42 nrd=0.69047619047619  nrs=0.69047619047619 sa=0 sb=0 sd=0 mult=1 m=1
XMRD_op1_1000_s10_w5_1 rbl_op1_1000_s10_w5 sn_op1_1000_s10_w5_1 rwl_des 0 sky130_fd_pr__nfet_01v8 L=0.15 W=0.42 nf=1 ad=0.1218 as=0.1218 pd=1.42 ps=1.42 nrd=0.69047619047619  nrs=0.69047619047619 sa=0 sb=0 sd=0 mult=1 m=1
csn_op1_1000_s10_w5_1 sn_op1_1000_s10_w5_1 0 {C_SN}
XMWR_op1_1000_s10_w5_2 sn_op1_1000_s10_w5_2 wwl_des wbl_op1_1000_s10_w5 0 sky130_fd_pr__nfet_01v8 L=0.15 W=0.42 nf=1 ad=0.1218 as=0.1218 pd=1.42 ps=1.42 nrd=0.69047619047619  nrs=0.69047619047619 sa=0 sb=0 sd=0 mult=1 m=1
XMRD_op1_1000_s10_w5_2 rbl_op1_1000_s10_w5 sn_op1_1000_s10_w5_2 rwl_des 0 sky130_fd_pr__nfet_01v8 L=0.15 W=0.42 nf=1 ad=0.1218 as=0.1218 pd=1.42 ps=1.42 nrd=0.69047619047619  nrs=0.69047619047619 sa=0 sb=0 sd=0 mult=1 m=1
csn_op1_1000_s10_w5_2 sn_op1_1000_s10_w5_2 0 {C_SN}
XMWR_op1_1000_s10_w5_3 sn_op1_1000_s10_w5_3 wwl_des wbl_op1_1000_s10_w5 0 sky130_fd_pr__nfet_01v8 L=0.15 W=0.42 nf=1 ad=0.1218 as=0.1218 pd=1.42 ps=1.42 nrd=0.69047619047619  nrs=0.69047619047619 sa=0 sb=0 sd=0 mult=1 m=1
XMRD_op1_1000_s10_w5_3 rbl_op1_1000_s10_w5 sn_op1_1000_s10_w5_3 rwl_des 0 sky130_fd_pr__nfet_01v8 L=0.15 W=0.42 nf=1 ad=0.1218 as=0.1218 pd=1.42 ps=1.42 nrd=0.69047619047619  nrs=0.69047619047619 sa=0 sb=0 sd=0 mult=1 m=1
csn_op1_1000_s10_w5_3 sn_op1_1000_s10_w5_3 0 {C_SN}
XMN1_op1_1000_s10_w5 rbl_op1_1000_s10_w5 ref_op1_1000_s10_w5 vn_op1_1000_s10_w5 0 sky130_fd_pr__nfet_01v8 L=0.15 W=1 nf=1 ad=0.29 as=0.29 pd=2.58 ps=2.58 mult=1 m=1
XMN2_op1_1000_s10_w5 ref_op1_1000_s10_w5 rbl_op1_1000_s10_w5 vn_op1_1000_s10_w5 0 sky130_fd_pr__nfet_01v8 L=0.15 W=1 nf=1 ad=0.29 as=0.29 pd=2.58 ps=2.58 mult=1 m=1
XMP1_op1_1000_s10_w5 rbl_op1_1000_s10_w5 ref_op1_1000_s10_w5 vp_op1_1000_s10_w5 vdd sky130_fd_pr__pfet_01v8 L=0.15 W=2 nf=1 ad=0.58 as=0.58 pd=4.58 ps=4.58 mult=1 m=1
XMP2_op1_1000_s10_w5 ref_op1_1000_s10_w5 rbl_op1_1000_s10_w5 vp_op1_1000_s10_w5 vdd sky130_fd_pr__pfet_01v8 L=0.15 W=2 nf=1 ad=0.58 as=0.58 pd=4.58 ps=4.58 mult=1 m=1
XMNF_op1_1000_s10_w5 vn_op1_1000_s10_w5 en_op1_1000_s10_w5 0 0 sky130_fd_pr__nfet_01v8 L=0.15 W=2 nf=1 ad=0.58 as=0.58 pd=4.58 ps=4.58 mult=1 m=1
XMPH_op1_1000_s10_w5 vp_op1_1000_s10_w5 enb_op1_1000_s10_w5 vdd vdd sky130_fd_pr__pfet_01v8 L=0.15 W=4 nf=1 ad=1.16 as=1.16 pd=8.58 ps=8.58 mult=1 m=1
bd_op1_1000_s10_w5 d_op1_1000_s10_w5 0 v=v(rbl_op1_1000_s10_w5)-v(ref_op1_1000_s10_w5)

* ---- instance 114: op1_1000_s10_w7p5 (t_en 14 ns, WWL 15..22.5 ns, release 24.5 ns) ----
ven_op1_1000_s10_w7p5  en_op1_1000_s10_w7p5  0 pwl(0 0 1.4000e-08 0 1.4100e-08 {VDD} 2.4500e-08 {VDD} 2.4600e-08 0)
venb_op1_1000_s10_w7p5 enb_op1_1000_s10_w7p5 0 pwl(0 {VDD} 1.4000e-08 {VDD} 1.4100e-08 0 2.4500e-08 0 2.4600e-08 {VDD})
vrs_op1_1000_s10_w7p5  rwls_op1_1000_s10_w7p5 0 pwl(0 {VDD} {T_READ} {VDD} {T_READ+TEDGE} 0 2.4500e-08 0 2.4600e-08 {VDD})
vww_op1_1000_s10_w7p5  wwl_op1_1000_s10_w7p5 0 pwl(0 0 1.5000e-08 0 1.5100e-08 {VDD} 2.2500e-08 {VDD} 2.2600e-08 0)
vwc_op1_1000_s10_w7p5  wbc_op1_1000_s10_w7p5 0 pwl(0 0 1.5000e-08 0 1.5100e-08 {VDD} 2.4500e-08 {VDD} 2.4600e-08 0)
swb_op1_1000_s10_w7p5 ref_op1_1000_s10_w7p5 wbl_op1_1000_s10_w7p5 wbc_op1_1000_s10_w7p5 0 swwbl
cwbl_op1_1000_s10_w7p5 wbl_op1_1000_s10_w7p5 0 {C_WBL}
spa_op1_1000_s10_w7p5 prea rbl_op1_1000_s10_w7p5 ctl 0 swpre
spr_op1_1000_s10_w7p5 pref ref_op1_1000_s10_w7p5 ctl 0 swpre
crbl_op1_1000_s10_w7p5 rbl_op1_1000_s10_w7p5 0 {C_RBL}
cref_op1_1000_s10_w7p5 ref_op1_1000_s10_w7p5 0 {C_RBL}   $ ASSUMPTION: ideal matched dummy load
XMWR_op1_1000_s10_w7p5_0 sn_op1_1000_s10_w7p5_0 wwl_op1_1000_s10_w7p5 wbl_op1_1000_s10_w7p5 0 sky130_fd_pr__nfet_01v8 L=0.15 W=0.42 nf=1 ad=0.1218 as=0.1218 pd=1.42 ps=1.42 nrd=0.69047619047619  nrs=0.69047619047619 sa=0 sb=0 sd=0 mult=1 m=1
XMRD_op1_1000_s10_w7p5_0 rbl_op1_1000_s10_w7p5 sn_op1_1000_s10_w7p5_0 rwls_op1_1000_s10_w7p5 0 sky130_fd_pr__nfet_01v8 L=0.15 W=0.42 nf=1 ad=0.1218 as=0.1218 pd=1.42 ps=1.42 nrd=0.69047619047619  nrs=0.69047619047619 sa=0 sb=0 sd=0 mult=1 m=1
csn_op1_1000_s10_w7p5_0 sn_op1_1000_s10_w7p5_0 0 {C_SN}
XMWR_op1_1000_s10_w7p5_1 sn_op1_1000_s10_w7p5_1 wwl_des wbl_op1_1000_s10_w7p5 0 sky130_fd_pr__nfet_01v8 L=0.15 W=0.42 nf=1 ad=0.1218 as=0.1218 pd=1.42 ps=1.42 nrd=0.69047619047619  nrs=0.69047619047619 sa=0 sb=0 sd=0 mult=1 m=1
XMRD_op1_1000_s10_w7p5_1 rbl_op1_1000_s10_w7p5 sn_op1_1000_s10_w7p5_1 rwl_des 0 sky130_fd_pr__nfet_01v8 L=0.15 W=0.42 nf=1 ad=0.1218 as=0.1218 pd=1.42 ps=1.42 nrd=0.69047619047619  nrs=0.69047619047619 sa=0 sb=0 sd=0 mult=1 m=1
csn_op1_1000_s10_w7p5_1 sn_op1_1000_s10_w7p5_1 0 {C_SN}
XMWR_op1_1000_s10_w7p5_2 sn_op1_1000_s10_w7p5_2 wwl_des wbl_op1_1000_s10_w7p5 0 sky130_fd_pr__nfet_01v8 L=0.15 W=0.42 nf=1 ad=0.1218 as=0.1218 pd=1.42 ps=1.42 nrd=0.69047619047619  nrs=0.69047619047619 sa=0 sb=0 sd=0 mult=1 m=1
XMRD_op1_1000_s10_w7p5_2 rbl_op1_1000_s10_w7p5 sn_op1_1000_s10_w7p5_2 rwl_des 0 sky130_fd_pr__nfet_01v8 L=0.15 W=0.42 nf=1 ad=0.1218 as=0.1218 pd=1.42 ps=1.42 nrd=0.69047619047619  nrs=0.69047619047619 sa=0 sb=0 sd=0 mult=1 m=1
csn_op1_1000_s10_w7p5_2 sn_op1_1000_s10_w7p5_2 0 {C_SN}
XMWR_op1_1000_s10_w7p5_3 sn_op1_1000_s10_w7p5_3 wwl_des wbl_op1_1000_s10_w7p5 0 sky130_fd_pr__nfet_01v8 L=0.15 W=0.42 nf=1 ad=0.1218 as=0.1218 pd=1.42 ps=1.42 nrd=0.69047619047619  nrs=0.69047619047619 sa=0 sb=0 sd=0 mult=1 m=1
XMRD_op1_1000_s10_w7p5_3 rbl_op1_1000_s10_w7p5 sn_op1_1000_s10_w7p5_3 rwl_des 0 sky130_fd_pr__nfet_01v8 L=0.15 W=0.42 nf=1 ad=0.1218 as=0.1218 pd=1.42 ps=1.42 nrd=0.69047619047619  nrs=0.69047619047619 sa=0 sb=0 sd=0 mult=1 m=1
csn_op1_1000_s10_w7p5_3 sn_op1_1000_s10_w7p5_3 0 {C_SN}
XMN1_op1_1000_s10_w7p5 rbl_op1_1000_s10_w7p5 ref_op1_1000_s10_w7p5 vn_op1_1000_s10_w7p5 0 sky130_fd_pr__nfet_01v8 L=0.15 W=1 nf=1 ad=0.29 as=0.29 pd=2.58 ps=2.58 mult=1 m=1
XMN2_op1_1000_s10_w7p5 ref_op1_1000_s10_w7p5 rbl_op1_1000_s10_w7p5 vn_op1_1000_s10_w7p5 0 sky130_fd_pr__nfet_01v8 L=0.15 W=1 nf=1 ad=0.29 as=0.29 pd=2.58 ps=2.58 mult=1 m=1
XMP1_op1_1000_s10_w7p5 rbl_op1_1000_s10_w7p5 ref_op1_1000_s10_w7p5 vp_op1_1000_s10_w7p5 vdd sky130_fd_pr__pfet_01v8 L=0.15 W=2 nf=1 ad=0.58 as=0.58 pd=4.58 ps=4.58 mult=1 m=1
XMP2_op1_1000_s10_w7p5 ref_op1_1000_s10_w7p5 rbl_op1_1000_s10_w7p5 vp_op1_1000_s10_w7p5 vdd sky130_fd_pr__pfet_01v8 L=0.15 W=2 nf=1 ad=0.58 as=0.58 pd=4.58 ps=4.58 mult=1 m=1
XMNF_op1_1000_s10_w7p5 vn_op1_1000_s10_w7p5 en_op1_1000_s10_w7p5 0 0 sky130_fd_pr__nfet_01v8 L=0.15 W=2 nf=1 ad=0.58 as=0.58 pd=4.58 ps=4.58 mult=1 m=1
XMPH_op1_1000_s10_w7p5 vp_op1_1000_s10_w7p5 enb_op1_1000_s10_w7p5 vdd vdd sky130_fd_pr__pfet_01v8 L=0.15 W=4 nf=1 ad=1.16 as=1.16 pd=8.58 ps=8.58 mult=1 m=1
bd_op1_1000_s10_w7p5 d_op1_1000_s10_w7p5 0 v=v(rbl_op1_1000_s10_w7p5)-v(ref_op1_1000_s10_w7p5)

* ---- instance 115: op1_1000_s10_w10 (t_en 14 ns, WWL 15..25 ns, release 27 ns) ----
ven_op1_1000_s10_w10  en_op1_1000_s10_w10  0 pwl(0 0 1.4000e-08 0 1.4100e-08 {VDD} 2.7000e-08 {VDD} 2.7100e-08 0)
venb_op1_1000_s10_w10 enb_op1_1000_s10_w10 0 pwl(0 {VDD} 1.4000e-08 {VDD} 1.4100e-08 0 2.7000e-08 0 2.7100e-08 {VDD})
vrs_op1_1000_s10_w10  rwls_op1_1000_s10_w10 0 pwl(0 {VDD} {T_READ} {VDD} {T_READ+TEDGE} 0 2.7000e-08 0 2.7100e-08 {VDD})
vww_op1_1000_s10_w10  wwl_op1_1000_s10_w10 0 pwl(0 0 1.5000e-08 0 1.5100e-08 {VDD} 2.5000e-08 {VDD} 2.5100e-08 0)
vwc_op1_1000_s10_w10  wbc_op1_1000_s10_w10 0 pwl(0 0 1.5000e-08 0 1.5100e-08 {VDD} 2.7000e-08 {VDD} 2.7100e-08 0)
swb_op1_1000_s10_w10 ref_op1_1000_s10_w10 wbl_op1_1000_s10_w10 wbc_op1_1000_s10_w10 0 swwbl
cwbl_op1_1000_s10_w10 wbl_op1_1000_s10_w10 0 {C_WBL}
spa_op1_1000_s10_w10 prea rbl_op1_1000_s10_w10 ctl 0 swpre
spr_op1_1000_s10_w10 pref ref_op1_1000_s10_w10 ctl 0 swpre
crbl_op1_1000_s10_w10 rbl_op1_1000_s10_w10 0 {C_RBL}
cref_op1_1000_s10_w10 ref_op1_1000_s10_w10 0 {C_RBL}   $ ASSUMPTION: ideal matched dummy load
XMWR_op1_1000_s10_w10_0 sn_op1_1000_s10_w10_0 wwl_op1_1000_s10_w10 wbl_op1_1000_s10_w10 0 sky130_fd_pr__nfet_01v8 L=0.15 W=0.42 nf=1 ad=0.1218 as=0.1218 pd=1.42 ps=1.42 nrd=0.69047619047619  nrs=0.69047619047619 sa=0 sb=0 sd=0 mult=1 m=1
XMRD_op1_1000_s10_w10_0 rbl_op1_1000_s10_w10 sn_op1_1000_s10_w10_0 rwls_op1_1000_s10_w10 0 sky130_fd_pr__nfet_01v8 L=0.15 W=0.42 nf=1 ad=0.1218 as=0.1218 pd=1.42 ps=1.42 nrd=0.69047619047619  nrs=0.69047619047619 sa=0 sb=0 sd=0 mult=1 m=1
csn_op1_1000_s10_w10_0 sn_op1_1000_s10_w10_0 0 {C_SN}
XMWR_op1_1000_s10_w10_1 sn_op1_1000_s10_w10_1 wwl_des wbl_op1_1000_s10_w10 0 sky130_fd_pr__nfet_01v8 L=0.15 W=0.42 nf=1 ad=0.1218 as=0.1218 pd=1.42 ps=1.42 nrd=0.69047619047619  nrs=0.69047619047619 sa=0 sb=0 sd=0 mult=1 m=1
XMRD_op1_1000_s10_w10_1 rbl_op1_1000_s10_w10 sn_op1_1000_s10_w10_1 rwl_des 0 sky130_fd_pr__nfet_01v8 L=0.15 W=0.42 nf=1 ad=0.1218 as=0.1218 pd=1.42 ps=1.42 nrd=0.69047619047619  nrs=0.69047619047619 sa=0 sb=0 sd=0 mult=1 m=1
csn_op1_1000_s10_w10_1 sn_op1_1000_s10_w10_1 0 {C_SN}
XMWR_op1_1000_s10_w10_2 sn_op1_1000_s10_w10_2 wwl_des wbl_op1_1000_s10_w10 0 sky130_fd_pr__nfet_01v8 L=0.15 W=0.42 nf=1 ad=0.1218 as=0.1218 pd=1.42 ps=1.42 nrd=0.69047619047619  nrs=0.69047619047619 sa=0 sb=0 sd=0 mult=1 m=1
XMRD_op1_1000_s10_w10_2 rbl_op1_1000_s10_w10 sn_op1_1000_s10_w10_2 rwl_des 0 sky130_fd_pr__nfet_01v8 L=0.15 W=0.42 nf=1 ad=0.1218 as=0.1218 pd=1.42 ps=1.42 nrd=0.69047619047619  nrs=0.69047619047619 sa=0 sb=0 sd=0 mult=1 m=1
csn_op1_1000_s10_w10_2 sn_op1_1000_s10_w10_2 0 {C_SN}
XMWR_op1_1000_s10_w10_3 sn_op1_1000_s10_w10_3 wwl_des wbl_op1_1000_s10_w10 0 sky130_fd_pr__nfet_01v8 L=0.15 W=0.42 nf=1 ad=0.1218 as=0.1218 pd=1.42 ps=1.42 nrd=0.69047619047619  nrs=0.69047619047619 sa=0 sb=0 sd=0 mult=1 m=1
XMRD_op1_1000_s10_w10_3 rbl_op1_1000_s10_w10 sn_op1_1000_s10_w10_3 rwl_des 0 sky130_fd_pr__nfet_01v8 L=0.15 W=0.42 nf=1 ad=0.1218 as=0.1218 pd=1.42 ps=1.42 nrd=0.69047619047619  nrs=0.69047619047619 sa=0 sb=0 sd=0 mult=1 m=1
csn_op1_1000_s10_w10_3 sn_op1_1000_s10_w10_3 0 {C_SN}
XMN1_op1_1000_s10_w10 rbl_op1_1000_s10_w10 ref_op1_1000_s10_w10 vn_op1_1000_s10_w10 0 sky130_fd_pr__nfet_01v8 L=0.15 W=1 nf=1 ad=0.29 as=0.29 pd=2.58 ps=2.58 mult=1 m=1
XMN2_op1_1000_s10_w10 ref_op1_1000_s10_w10 rbl_op1_1000_s10_w10 vn_op1_1000_s10_w10 0 sky130_fd_pr__nfet_01v8 L=0.15 W=1 nf=1 ad=0.29 as=0.29 pd=2.58 ps=2.58 mult=1 m=1
XMP1_op1_1000_s10_w10 rbl_op1_1000_s10_w10 ref_op1_1000_s10_w10 vp_op1_1000_s10_w10 vdd sky130_fd_pr__pfet_01v8 L=0.15 W=2 nf=1 ad=0.58 as=0.58 pd=4.58 ps=4.58 mult=1 m=1
XMP2_op1_1000_s10_w10 ref_op1_1000_s10_w10 rbl_op1_1000_s10_w10 vp_op1_1000_s10_w10 vdd sky130_fd_pr__pfet_01v8 L=0.15 W=2 nf=1 ad=0.58 as=0.58 pd=4.58 ps=4.58 mult=1 m=1
XMNF_op1_1000_s10_w10 vn_op1_1000_s10_w10 en_op1_1000_s10_w10 0 0 sky130_fd_pr__nfet_01v8 L=0.15 W=2 nf=1 ad=0.58 as=0.58 pd=4.58 ps=4.58 mult=1 m=1
XMPH_op1_1000_s10_w10 vp_op1_1000_s10_w10 enb_op1_1000_s10_w10 vdd vdd sky130_fd_pr__pfet_01v8 L=0.15 W=4 nf=1 ad=1.16 as=1.16 pd=8.58 ps=8.58 mult=1 m=1
bd_op1_1000_s10_w10 d_op1_1000_s10_w10 0 v=v(rbl_op1_1000_s10_w10)-v(ref_op1_1000_s10_w10)

* ---- instance 116: op1_1000_s10_w15 (t_en 14 ns, WWL 15..30 ns, release 32 ns) ----
ven_op1_1000_s10_w15  en_op1_1000_s10_w15  0 pwl(0 0 1.4000e-08 0 1.4100e-08 {VDD} 3.2000e-08 {VDD} 3.2100e-08 0)
venb_op1_1000_s10_w15 enb_op1_1000_s10_w15 0 pwl(0 {VDD} 1.4000e-08 {VDD} 1.4100e-08 0 3.2000e-08 0 3.2100e-08 {VDD})
vrs_op1_1000_s10_w15  rwls_op1_1000_s10_w15 0 pwl(0 {VDD} {T_READ} {VDD} {T_READ+TEDGE} 0 3.2000e-08 0 3.2100e-08 {VDD})
vww_op1_1000_s10_w15  wwl_op1_1000_s10_w15 0 pwl(0 0 1.5000e-08 0 1.5100e-08 {VDD} 3.0000e-08 {VDD} 3.0100e-08 0)
vwc_op1_1000_s10_w15  wbc_op1_1000_s10_w15 0 pwl(0 0 1.5000e-08 0 1.5100e-08 {VDD} 3.2000e-08 {VDD} 3.2100e-08 0)
swb_op1_1000_s10_w15 ref_op1_1000_s10_w15 wbl_op1_1000_s10_w15 wbc_op1_1000_s10_w15 0 swwbl
cwbl_op1_1000_s10_w15 wbl_op1_1000_s10_w15 0 {C_WBL}
spa_op1_1000_s10_w15 prea rbl_op1_1000_s10_w15 ctl 0 swpre
spr_op1_1000_s10_w15 pref ref_op1_1000_s10_w15 ctl 0 swpre
crbl_op1_1000_s10_w15 rbl_op1_1000_s10_w15 0 {C_RBL}
cref_op1_1000_s10_w15 ref_op1_1000_s10_w15 0 {C_RBL}   $ ASSUMPTION: ideal matched dummy load
XMWR_op1_1000_s10_w15_0 sn_op1_1000_s10_w15_0 wwl_op1_1000_s10_w15 wbl_op1_1000_s10_w15 0 sky130_fd_pr__nfet_01v8 L=0.15 W=0.42 nf=1 ad=0.1218 as=0.1218 pd=1.42 ps=1.42 nrd=0.69047619047619  nrs=0.69047619047619 sa=0 sb=0 sd=0 mult=1 m=1
XMRD_op1_1000_s10_w15_0 rbl_op1_1000_s10_w15 sn_op1_1000_s10_w15_0 rwls_op1_1000_s10_w15 0 sky130_fd_pr__nfet_01v8 L=0.15 W=0.42 nf=1 ad=0.1218 as=0.1218 pd=1.42 ps=1.42 nrd=0.69047619047619  nrs=0.69047619047619 sa=0 sb=0 sd=0 mult=1 m=1
csn_op1_1000_s10_w15_0 sn_op1_1000_s10_w15_0 0 {C_SN}
XMWR_op1_1000_s10_w15_1 sn_op1_1000_s10_w15_1 wwl_des wbl_op1_1000_s10_w15 0 sky130_fd_pr__nfet_01v8 L=0.15 W=0.42 nf=1 ad=0.1218 as=0.1218 pd=1.42 ps=1.42 nrd=0.69047619047619  nrs=0.69047619047619 sa=0 sb=0 sd=0 mult=1 m=1
XMRD_op1_1000_s10_w15_1 rbl_op1_1000_s10_w15 sn_op1_1000_s10_w15_1 rwl_des 0 sky130_fd_pr__nfet_01v8 L=0.15 W=0.42 nf=1 ad=0.1218 as=0.1218 pd=1.42 ps=1.42 nrd=0.69047619047619  nrs=0.69047619047619 sa=0 sb=0 sd=0 mult=1 m=1
csn_op1_1000_s10_w15_1 sn_op1_1000_s10_w15_1 0 {C_SN}
XMWR_op1_1000_s10_w15_2 sn_op1_1000_s10_w15_2 wwl_des wbl_op1_1000_s10_w15 0 sky130_fd_pr__nfet_01v8 L=0.15 W=0.42 nf=1 ad=0.1218 as=0.1218 pd=1.42 ps=1.42 nrd=0.69047619047619  nrs=0.69047619047619 sa=0 sb=0 sd=0 mult=1 m=1
XMRD_op1_1000_s10_w15_2 rbl_op1_1000_s10_w15 sn_op1_1000_s10_w15_2 rwl_des 0 sky130_fd_pr__nfet_01v8 L=0.15 W=0.42 nf=1 ad=0.1218 as=0.1218 pd=1.42 ps=1.42 nrd=0.69047619047619  nrs=0.69047619047619 sa=0 sb=0 sd=0 mult=1 m=1
csn_op1_1000_s10_w15_2 sn_op1_1000_s10_w15_2 0 {C_SN}
XMWR_op1_1000_s10_w15_3 sn_op1_1000_s10_w15_3 wwl_des wbl_op1_1000_s10_w15 0 sky130_fd_pr__nfet_01v8 L=0.15 W=0.42 nf=1 ad=0.1218 as=0.1218 pd=1.42 ps=1.42 nrd=0.69047619047619  nrs=0.69047619047619 sa=0 sb=0 sd=0 mult=1 m=1
XMRD_op1_1000_s10_w15_3 rbl_op1_1000_s10_w15 sn_op1_1000_s10_w15_3 rwl_des 0 sky130_fd_pr__nfet_01v8 L=0.15 W=0.42 nf=1 ad=0.1218 as=0.1218 pd=1.42 ps=1.42 nrd=0.69047619047619  nrs=0.69047619047619 sa=0 sb=0 sd=0 mult=1 m=1
csn_op1_1000_s10_w15_3 sn_op1_1000_s10_w15_3 0 {C_SN}
XMN1_op1_1000_s10_w15 rbl_op1_1000_s10_w15 ref_op1_1000_s10_w15 vn_op1_1000_s10_w15 0 sky130_fd_pr__nfet_01v8 L=0.15 W=1 nf=1 ad=0.29 as=0.29 pd=2.58 ps=2.58 mult=1 m=1
XMN2_op1_1000_s10_w15 ref_op1_1000_s10_w15 rbl_op1_1000_s10_w15 vn_op1_1000_s10_w15 0 sky130_fd_pr__nfet_01v8 L=0.15 W=1 nf=1 ad=0.29 as=0.29 pd=2.58 ps=2.58 mult=1 m=1
XMP1_op1_1000_s10_w15 rbl_op1_1000_s10_w15 ref_op1_1000_s10_w15 vp_op1_1000_s10_w15 vdd sky130_fd_pr__pfet_01v8 L=0.15 W=2 nf=1 ad=0.58 as=0.58 pd=4.58 ps=4.58 mult=1 m=1
XMP2_op1_1000_s10_w15 ref_op1_1000_s10_w15 rbl_op1_1000_s10_w15 vp_op1_1000_s10_w15 vdd sky130_fd_pr__pfet_01v8 L=0.15 W=2 nf=1 ad=0.58 as=0.58 pd=4.58 ps=4.58 mult=1 m=1
XMNF_op1_1000_s10_w15 vn_op1_1000_s10_w15 en_op1_1000_s10_w15 0 0 sky130_fd_pr__nfet_01v8 L=0.15 W=2 nf=1 ad=0.58 as=0.58 pd=4.58 ps=4.58 mult=1 m=1
XMPH_op1_1000_s10_w15 vp_op1_1000_s10_w15 enb_op1_1000_s10_w15 vdd vdd sky130_fd_pr__pfet_01v8 L=0.15 W=4 nf=1 ad=1.16 as=1.16 pd=8.58 ps=8.58 mult=1 m=1
bd_op1_1000_s10_w15 d_op1_1000_s10_w15 0 v=v(rbl_op1_1000_s10_w15)-v(ref_op1_1000_s10_w15)

* ---- instance 117: op1_1000_s10_w20 (t_en 14 ns, WWL 15..35 ns, release 37 ns) ----
ven_op1_1000_s10_w20  en_op1_1000_s10_w20  0 pwl(0 0 1.4000e-08 0 1.4100e-08 {VDD} 3.7000e-08 {VDD} 3.7100e-08 0)
venb_op1_1000_s10_w20 enb_op1_1000_s10_w20 0 pwl(0 {VDD} 1.4000e-08 {VDD} 1.4100e-08 0 3.7000e-08 0 3.7100e-08 {VDD})
vrs_op1_1000_s10_w20  rwls_op1_1000_s10_w20 0 pwl(0 {VDD} {T_READ} {VDD} {T_READ+TEDGE} 0 3.7000e-08 0 3.7100e-08 {VDD})
vww_op1_1000_s10_w20  wwl_op1_1000_s10_w20 0 pwl(0 0 1.5000e-08 0 1.5100e-08 {VDD} 3.5000e-08 {VDD} 3.5100e-08 0)
vwc_op1_1000_s10_w20  wbc_op1_1000_s10_w20 0 pwl(0 0 1.5000e-08 0 1.5100e-08 {VDD} 3.7000e-08 {VDD} 3.7100e-08 0)
swb_op1_1000_s10_w20 ref_op1_1000_s10_w20 wbl_op1_1000_s10_w20 wbc_op1_1000_s10_w20 0 swwbl
cwbl_op1_1000_s10_w20 wbl_op1_1000_s10_w20 0 {C_WBL}
spa_op1_1000_s10_w20 prea rbl_op1_1000_s10_w20 ctl 0 swpre
spr_op1_1000_s10_w20 pref ref_op1_1000_s10_w20 ctl 0 swpre
crbl_op1_1000_s10_w20 rbl_op1_1000_s10_w20 0 {C_RBL}
cref_op1_1000_s10_w20 ref_op1_1000_s10_w20 0 {C_RBL}   $ ASSUMPTION: ideal matched dummy load
XMWR_op1_1000_s10_w20_0 sn_op1_1000_s10_w20_0 wwl_op1_1000_s10_w20 wbl_op1_1000_s10_w20 0 sky130_fd_pr__nfet_01v8 L=0.15 W=0.42 nf=1 ad=0.1218 as=0.1218 pd=1.42 ps=1.42 nrd=0.69047619047619  nrs=0.69047619047619 sa=0 sb=0 sd=0 mult=1 m=1
XMRD_op1_1000_s10_w20_0 rbl_op1_1000_s10_w20 sn_op1_1000_s10_w20_0 rwls_op1_1000_s10_w20 0 sky130_fd_pr__nfet_01v8 L=0.15 W=0.42 nf=1 ad=0.1218 as=0.1218 pd=1.42 ps=1.42 nrd=0.69047619047619  nrs=0.69047619047619 sa=0 sb=0 sd=0 mult=1 m=1
csn_op1_1000_s10_w20_0 sn_op1_1000_s10_w20_0 0 {C_SN}
XMWR_op1_1000_s10_w20_1 sn_op1_1000_s10_w20_1 wwl_des wbl_op1_1000_s10_w20 0 sky130_fd_pr__nfet_01v8 L=0.15 W=0.42 nf=1 ad=0.1218 as=0.1218 pd=1.42 ps=1.42 nrd=0.69047619047619  nrs=0.69047619047619 sa=0 sb=0 sd=0 mult=1 m=1
XMRD_op1_1000_s10_w20_1 rbl_op1_1000_s10_w20 sn_op1_1000_s10_w20_1 rwl_des 0 sky130_fd_pr__nfet_01v8 L=0.15 W=0.42 nf=1 ad=0.1218 as=0.1218 pd=1.42 ps=1.42 nrd=0.69047619047619  nrs=0.69047619047619 sa=0 sb=0 sd=0 mult=1 m=1
csn_op1_1000_s10_w20_1 sn_op1_1000_s10_w20_1 0 {C_SN}
XMWR_op1_1000_s10_w20_2 sn_op1_1000_s10_w20_2 wwl_des wbl_op1_1000_s10_w20 0 sky130_fd_pr__nfet_01v8 L=0.15 W=0.42 nf=1 ad=0.1218 as=0.1218 pd=1.42 ps=1.42 nrd=0.69047619047619  nrs=0.69047619047619 sa=0 sb=0 sd=0 mult=1 m=1
XMRD_op1_1000_s10_w20_2 rbl_op1_1000_s10_w20 sn_op1_1000_s10_w20_2 rwl_des 0 sky130_fd_pr__nfet_01v8 L=0.15 W=0.42 nf=1 ad=0.1218 as=0.1218 pd=1.42 ps=1.42 nrd=0.69047619047619  nrs=0.69047619047619 sa=0 sb=0 sd=0 mult=1 m=1
csn_op1_1000_s10_w20_2 sn_op1_1000_s10_w20_2 0 {C_SN}
XMWR_op1_1000_s10_w20_3 sn_op1_1000_s10_w20_3 wwl_des wbl_op1_1000_s10_w20 0 sky130_fd_pr__nfet_01v8 L=0.15 W=0.42 nf=1 ad=0.1218 as=0.1218 pd=1.42 ps=1.42 nrd=0.69047619047619  nrs=0.69047619047619 sa=0 sb=0 sd=0 mult=1 m=1
XMRD_op1_1000_s10_w20_3 rbl_op1_1000_s10_w20 sn_op1_1000_s10_w20_3 rwl_des 0 sky130_fd_pr__nfet_01v8 L=0.15 W=0.42 nf=1 ad=0.1218 as=0.1218 pd=1.42 ps=1.42 nrd=0.69047619047619  nrs=0.69047619047619 sa=0 sb=0 sd=0 mult=1 m=1
csn_op1_1000_s10_w20_3 sn_op1_1000_s10_w20_3 0 {C_SN}
XMN1_op1_1000_s10_w20 rbl_op1_1000_s10_w20 ref_op1_1000_s10_w20 vn_op1_1000_s10_w20 0 sky130_fd_pr__nfet_01v8 L=0.15 W=1 nf=1 ad=0.29 as=0.29 pd=2.58 ps=2.58 mult=1 m=1
XMN2_op1_1000_s10_w20 ref_op1_1000_s10_w20 rbl_op1_1000_s10_w20 vn_op1_1000_s10_w20 0 sky130_fd_pr__nfet_01v8 L=0.15 W=1 nf=1 ad=0.29 as=0.29 pd=2.58 ps=2.58 mult=1 m=1
XMP1_op1_1000_s10_w20 rbl_op1_1000_s10_w20 ref_op1_1000_s10_w20 vp_op1_1000_s10_w20 vdd sky130_fd_pr__pfet_01v8 L=0.15 W=2 nf=1 ad=0.58 as=0.58 pd=4.58 ps=4.58 mult=1 m=1
XMP2_op1_1000_s10_w20 ref_op1_1000_s10_w20 rbl_op1_1000_s10_w20 vp_op1_1000_s10_w20 vdd sky130_fd_pr__pfet_01v8 L=0.15 W=2 nf=1 ad=0.58 as=0.58 pd=4.58 ps=4.58 mult=1 m=1
XMNF_op1_1000_s10_w20 vn_op1_1000_s10_w20 en_op1_1000_s10_w20 0 0 sky130_fd_pr__nfet_01v8 L=0.15 W=2 nf=1 ad=0.58 as=0.58 pd=4.58 ps=4.58 mult=1 m=1
XMPH_op1_1000_s10_w20 vp_op1_1000_s10_w20 enb_op1_1000_s10_w20 vdd vdd sky130_fd_pr__pfet_01v8 L=0.15 W=4 nf=1 ad=1.16 as=1.16 pd=8.58 ps=8.58 mult=1 m=1
bd_op1_1000_s10_w20 d_op1_1000_s10_w20 0 v=v(rbl_op1_1000_s10_w20)-v(ref_op1_1000_s10_w20)

* ---- instance 118: op1_1000_s10_w30 (t_en 14 ns, WWL 15..45 ns, release 47 ns) ----
ven_op1_1000_s10_w30  en_op1_1000_s10_w30  0 pwl(0 0 1.4000e-08 0 1.4100e-08 {VDD} 4.7000e-08 {VDD} 4.7100e-08 0)
venb_op1_1000_s10_w30 enb_op1_1000_s10_w30 0 pwl(0 {VDD} 1.4000e-08 {VDD} 1.4100e-08 0 4.7000e-08 0 4.7100e-08 {VDD})
vrs_op1_1000_s10_w30  rwls_op1_1000_s10_w30 0 pwl(0 {VDD} {T_READ} {VDD} {T_READ+TEDGE} 0 4.7000e-08 0 4.7100e-08 {VDD})
vww_op1_1000_s10_w30  wwl_op1_1000_s10_w30 0 pwl(0 0 1.5000e-08 0 1.5100e-08 {VDD} 4.5000e-08 {VDD} 4.5100e-08 0)
vwc_op1_1000_s10_w30  wbc_op1_1000_s10_w30 0 pwl(0 0 1.5000e-08 0 1.5100e-08 {VDD} 4.7000e-08 {VDD} 4.7100e-08 0)
swb_op1_1000_s10_w30 ref_op1_1000_s10_w30 wbl_op1_1000_s10_w30 wbc_op1_1000_s10_w30 0 swwbl
cwbl_op1_1000_s10_w30 wbl_op1_1000_s10_w30 0 {C_WBL}
spa_op1_1000_s10_w30 prea rbl_op1_1000_s10_w30 ctl 0 swpre
spr_op1_1000_s10_w30 pref ref_op1_1000_s10_w30 ctl 0 swpre
crbl_op1_1000_s10_w30 rbl_op1_1000_s10_w30 0 {C_RBL}
cref_op1_1000_s10_w30 ref_op1_1000_s10_w30 0 {C_RBL}   $ ASSUMPTION: ideal matched dummy load
XMWR_op1_1000_s10_w30_0 sn_op1_1000_s10_w30_0 wwl_op1_1000_s10_w30 wbl_op1_1000_s10_w30 0 sky130_fd_pr__nfet_01v8 L=0.15 W=0.42 nf=1 ad=0.1218 as=0.1218 pd=1.42 ps=1.42 nrd=0.69047619047619  nrs=0.69047619047619 sa=0 sb=0 sd=0 mult=1 m=1
XMRD_op1_1000_s10_w30_0 rbl_op1_1000_s10_w30 sn_op1_1000_s10_w30_0 rwls_op1_1000_s10_w30 0 sky130_fd_pr__nfet_01v8 L=0.15 W=0.42 nf=1 ad=0.1218 as=0.1218 pd=1.42 ps=1.42 nrd=0.69047619047619  nrs=0.69047619047619 sa=0 sb=0 sd=0 mult=1 m=1
csn_op1_1000_s10_w30_0 sn_op1_1000_s10_w30_0 0 {C_SN}
XMWR_op1_1000_s10_w30_1 sn_op1_1000_s10_w30_1 wwl_des wbl_op1_1000_s10_w30 0 sky130_fd_pr__nfet_01v8 L=0.15 W=0.42 nf=1 ad=0.1218 as=0.1218 pd=1.42 ps=1.42 nrd=0.69047619047619  nrs=0.69047619047619 sa=0 sb=0 sd=0 mult=1 m=1
XMRD_op1_1000_s10_w30_1 rbl_op1_1000_s10_w30 sn_op1_1000_s10_w30_1 rwl_des 0 sky130_fd_pr__nfet_01v8 L=0.15 W=0.42 nf=1 ad=0.1218 as=0.1218 pd=1.42 ps=1.42 nrd=0.69047619047619  nrs=0.69047619047619 sa=0 sb=0 sd=0 mult=1 m=1
csn_op1_1000_s10_w30_1 sn_op1_1000_s10_w30_1 0 {C_SN}
XMWR_op1_1000_s10_w30_2 sn_op1_1000_s10_w30_2 wwl_des wbl_op1_1000_s10_w30 0 sky130_fd_pr__nfet_01v8 L=0.15 W=0.42 nf=1 ad=0.1218 as=0.1218 pd=1.42 ps=1.42 nrd=0.69047619047619  nrs=0.69047619047619 sa=0 sb=0 sd=0 mult=1 m=1
XMRD_op1_1000_s10_w30_2 rbl_op1_1000_s10_w30 sn_op1_1000_s10_w30_2 rwl_des 0 sky130_fd_pr__nfet_01v8 L=0.15 W=0.42 nf=1 ad=0.1218 as=0.1218 pd=1.42 ps=1.42 nrd=0.69047619047619  nrs=0.69047619047619 sa=0 sb=0 sd=0 mult=1 m=1
csn_op1_1000_s10_w30_2 sn_op1_1000_s10_w30_2 0 {C_SN}
XMWR_op1_1000_s10_w30_3 sn_op1_1000_s10_w30_3 wwl_des wbl_op1_1000_s10_w30 0 sky130_fd_pr__nfet_01v8 L=0.15 W=0.42 nf=1 ad=0.1218 as=0.1218 pd=1.42 ps=1.42 nrd=0.69047619047619  nrs=0.69047619047619 sa=0 sb=0 sd=0 mult=1 m=1
XMRD_op1_1000_s10_w30_3 rbl_op1_1000_s10_w30 sn_op1_1000_s10_w30_3 rwl_des 0 sky130_fd_pr__nfet_01v8 L=0.15 W=0.42 nf=1 ad=0.1218 as=0.1218 pd=1.42 ps=1.42 nrd=0.69047619047619  nrs=0.69047619047619 sa=0 sb=0 sd=0 mult=1 m=1
csn_op1_1000_s10_w30_3 sn_op1_1000_s10_w30_3 0 {C_SN}
XMN1_op1_1000_s10_w30 rbl_op1_1000_s10_w30 ref_op1_1000_s10_w30 vn_op1_1000_s10_w30 0 sky130_fd_pr__nfet_01v8 L=0.15 W=1 nf=1 ad=0.29 as=0.29 pd=2.58 ps=2.58 mult=1 m=1
XMN2_op1_1000_s10_w30 ref_op1_1000_s10_w30 rbl_op1_1000_s10_w30 vn_op1_1000_s10_w30 0 sky130_fd_pr__nfet_01v8 L=0.15 W=1 nf=1 ad=0.29 as=0.29 pd=2.58 ps=2.58 mult=1 m=1
XMP1_op1_1000_s10_w30 rbl_op1_1000_s10_w30 ref_op1_1000_s10_w30 vp_op1_1000_s10_w30 vdd sky130_fd_pr__pfet_01v8 L=0.15 W=2 nf=1 ad=0.58 as=0.58 pd=4.58 ps=4.58 mult=1 m=1
XMP2_op1_1000_s10_w30 ref_op1_1000_s10_w30 rbl_op1_1000_s10_w30 vp_op1_1000_s10_w30 vdd sky130_fd_pr__pfet_01v8 L=0.15 W=2 nf=1 ad=0.58 as=0.58 pd=4.58 ps=4.58 mult=1 m=1
XMNF_op1_1000_s10_w30 vn_op1_1000_s10_w30 en_op1_1000_s10_w30 0 0 sky130_fd_pr__nfet_01v8 L=0.15 W=2 nf=1 ad=0.58 as=0.58 pd=4.58 ps=4.58 mult=1 m=1
XMPH_op1_1000_s10_w30 vp_op1_1000_s10_w30 enb_op1_1000_s10_w30 vdd vdd sky130_fd_pr__pfet_01v8 L=0.15 W=4 nf=1 ad=1.16 as=1.16 pd=8.58 ps=8.58 mult=1 m=1
bd_op1_1000_s10_w30 d_op1_1000_s10_w30 0 v=v(rbl_op1_1000_s10_w30)-v(ref_op1_1000_s10_w30)

* ---- instance 119: op1_1000_s10_w50 (t_en 14 ns, WWL 15..65 ns, release 67 ns) ----
ven_op1_1000_s10_w50  en_op1_1000_s10_w50  0 pwl(0 0 1.4000e-08 0 1.4100e-08 {VDD} 6.7000e-08 {VDD} 6.7100e-08 0)
venb_op1_1000_s10_w50 enb_op1_1000_s10_w50 0 pwl(0 {VDD} 1.4000e-08 {VDD} 1.4100e-08 0 6.7000e-08 0 6.7100e-08 {VDD})
vrs_op1_1000_s10_w50  rwls_op1_1000_s10_w50 0 pwl(0 {VDD} {T_READ} {VDD} {T_READ+TEDGE} 0 6.7000e-08 0 6.7100e-08 {VDD})
vww_op1_1000_s10_w50  wwl_op1_1000_s10_w50 0 pwl(0 0 1.5000e-08 0 1.5100e-08 {VDD} 6.5000e-08 {VDD} 6.5100e-08 0)
vwc_op1_1000_s10_w50  wbc_op1_1000_s10_w50 0 pwl(0 0 1.5000e-08 0 1.5100e-08 {VDD} 6.7000e-08 {VDD} 6.7100e-08 0)
swb_op1_1000_s10_w50 ref_op1_1000_s10_w50 wbl_op1_1000_s10_w50 wbc_op1_1000_s10_w50 0 swwbl
cwbl_op1_1000_s10_w50 wbl_op1_1000_s10_w50 0 {C_WBL}
spa_op1_1000_s10_w50 prea rbl_op1_1000_s10_w50 ctl 0 swpre
spr_op1_1000_s10_w50 pref ref_op1_1000_s10_w50 ctl 0 swpre
crbl_op1_1000_s10_w50 rbl_op1_1000_s10_w50 0 {C_RBL}
cref_op1_1000_s10_w50 ref_op1_1000_s10_w50 0 {C_RBL}   $ ASSUMPTION: ideal matched dummy load
XMWR_op1_1000_s10_w50_0 sn_op1_1000_s10_w50_0 wwl_op1_1000_s10_w50 wbl_op1_1000_s10_w50 0 sky130_fd_pr__nfet_01v8 L=0.15 W=0.42 nf=1 ad=0.1218 as=0.1218 pd=1.42 ps=1.42 nrd=0.69047619047619  nrs=0.69047619047619 sa=0 sb=0 sd=0 mult=1 m=1
XMRD_op1_1000_s10_w50_0 rbl_op1_1000_s10_w50 sn_op1_1000_s10_w50_0 rwls_op1_1000_s10_w50 0 sky130_fd_pr__nfet_01v8 L=0.15 W=0.42 nf=1 ad=0.1218 as=0.1218 pd=1.42 ps=1.42 nrd=0.69047619047619  nrs=0.69047619047619 sa=0 sb=0 sd=0 mult=1 m=1
csn_op1_1000_s10_w50_0 sn_op1_1000_s10_w50_0 0 {C_SN}
XMWR_op1_1000_s10_w50_1 sn_op1_1000_s10_w50_1 wwl_des wbl_op1_1000_s10_w50 0 sky130_fd_pr__nfet_01v8 L=0.15 W=0.42 nf=1 ad=0.1218 as=0.1218 pd=1.42 ps=1.42 nrd=0.69047619047619  nrs=0.69047619047619 sa=0 sb=0 sd=0 mult=1 m=1
XMRD_op1_1000_s10_w50_1 rbl_op1_1000_s10_w50 sn_op1_1000_s10_w50_1 rwl_des 0 sky130_fd_pr__nfet_01v8 L=0.15 W=0.42 nf=1 ad=0.1218 as=0.1218 pd=1.42 ps=1.42 nrd=0.69047619047619  nrs=0.69047619047619 sa=0 sb=0 sd=0 mult=1 m=1
csn_op1_1000_s10_w50_1 sn_op1_1000_s10_w50_1 0 {C_SN}
XMWR_op1_1000_s10_w50_2 sn_op1_1000_s10_w50_2 wwl_des wbl_op1_1000_s10_w50 0 sky130_fd_pr__nfet_01v8 L=0.15 W=0.42 nf=1 ad=0.1218 as=0.1218 pd=1.42 ps=1.42 nrd=0.69047619047619  nrs=0.69047619047619 sa=0 sb=0 sd=0 mult=1 m=1
XMRD_op1_1000_s10_w50_2 rbl_op1_1000_s10_w50 sn_op1_1000_s10_w50_2 rwl_des 0 sky130_fd_pr__nfet_01v8 L=0.15 W=0.42 nf=1 ad=0.1218 as=0.1218 pd=1.42 ps=1.42 nrd=0.69047619047619  nrs=0.69047619047619 sa=0 sb=0 sd=0 mult=1 m=1
csn_op1_1000_s10_w50_2 sn_op1_1000_s10_w50_2 0 {C_SN}
XMWR_op1_1000_s10_w50_3 sn_op1_1000_s10_w50_3 wwl_des wbl_op1_1000_s10_w50 0 sky130_fd_pr__nfet_01v8 L=0.15 W=0.42 nf=1 ad=0.1218 as=0.1218 pd=1.42 ps=1.42 nrd=0.69047619047619  nrs=0.69047619047619 sa=0 sb=0 sd=0 mult=1 m=1
XMRD_op1_1000_s10_w50_3 rbl_op1_1000_s10_w50 sn_op1_1000_s10_w50_3 rwl_des 0 sky130_fd_pr__nfet_01v8 L=0.15 W=0.42 nf=1 ad=0.1218 as=0.1218 pd=1.42 ps=1.42 nrd=0.69047619047619  nrs=0.69047619047619 sa=0 sb=0 sd=0 mult=1 m=1
csn_op1_1000_s10_w50_3 sn_op1_1000_s10_w50_3 0 {C_SN}
XMN1_op1_1000_s10_w50 rbl_op1_1000_s10_w50 ref_op1_1000_s10_w50 vn_op1_1000_s10_w50 0 sky130_fd_pr__nfet_01v8 L=0.15 W=1 nf=1 ad=0.29 as=0.29 pd=2.58 ps=2.58 mult=1 m=1
XMN2_op1_1000_s10_w50 ref_op1_1000_s10_w50 rbl_op1_1000_s10_w50 vn_op1_1000_s10_w50 0 sky130_fd_pr__nfet_01v8 L=0.15 W=1 nf=1 ad=0.29 as=0.29 pd=2.58 ps=2.58 mult=1 m=1
XMP1_op1_1000_s10_w50 rbl_op1_1000_s10_w50 ref_op1_1000_s10_w50 vp_op1_1000_s10_w50 vdd sky130_fd_pr__pfet_01v8 L=0.15 W=2 nf=1 ad=0.58 as=0.58 pd=4.58 ps=4.58 mult=1 m=1
XMP2_op1_1000_s10_w50 ref_op1_1000_s10_w50 rbl_op1_1000_s10_w50 vp_op1_1000_s10_w50 vdd sky130_fd_pr__pfet_01v8 L=0.15 W=2 nf=1 ad=0.58 as=0.58 pd=4.58 ps=4.58 mult=1 m=1
XMNF_op1_1000_s10_w50 vn_op1_1000_s10_w50 en_op1_1000_s10_w50 0 0 sky130_fd_pr__nfet_01v8 L=0.15 W=2 nf=1 ad=0.58 as=0.58 pd=4.58 ps=4.58 mult=1 m=1
XMPH_op1_1000_s10_w50 vp_op1_1000_s10_w50 enb_op1_1000_s10_w50 vdd vdd sky130_fd_pr__pfet_01v8 L=0.15 W=4 nf=1 ad=1.16 as=1.16 pd=8.58 ps=8.58 mult=1 m=1
bd_op1_1000_s10_w50 d_op1_1000_s10_w50 0 v=v(rbl_op1_1000_s10_w50)-v(ref_op1_1000_s10_w50)

* ---- instance 120: op0_n100_s0p5_w0p2 (t_en 4.5 ns, WWL 5.5..5.7 ns, release 7.7 ns) ----
ven_op0_n100_s0p5_w0p2  en_op0_n100_s0p5_w0p2  0 pwl(0 0 4.5000e-09 0 4.6000e-09 {VDD} 7.7000e-09 {VDD} 7.8000e-09 0)
venb_op0_n100_s0p5_w0p2 enb_op0_n100_s0p5_w0p2 0 pwl(0 {VDD} 4.5000e-09 {VDD} 4.6000e-09 0 7.7000e-09 0 7.8000e-09 {VDD})
vrs_op0_n100_s0p5_w0p2  rwls_op0_n100_s0p5_w0p2 0 pwl(0 {VDD} {T_READ} {VDD} {T_READ+TEDGE} 0 7.7000e-09 0 7.8000e-09 {VDD})
vww_op0_n100_s0p5_w0p2  wwl_op0_n100_s0p5_w0p2 0 pwl(0 0 5.5000e-09 0 5.6000e-09 {VDD} 5.7000e-09 {VDD} 5.8000e-09 0)
vwc_op0_n100_s0p5_w0p2  wbc_op0_n100_s0p5_w0p2 0 pwl(0 0 5.5000e-09 0 5.6000e-09 {VDD} 7.7000e-09 {VDD} 7.8000e-09 0)
swb_op0_n100_s0p5_w0p2 ref_op0_n100_s0p5_w0p2 wbl_op0_n100_s0p5_w0p2 wbc_op0_n100_s0p5_w0p2 0 swwbl
cwbl_op0_n100_s0p5_w0p2 wbl_op0_n100_s0p5_w0p2 0 {C_WBL}
spa_op0_n100_s0p5_w0p2 prea rbl_op0_n100_s0p5_w0p2 ctl 0 swpre
spr_op0_n100_s0p5_w0p2 pref ref_op0_n100_s0p5_w0p2 ctl 0 swpre
crbl_op0_n100_s0p5_w0p2 rbl_op0_n100_s0p5_w0p2 0 {C_RBL}
cref_op0_n100_s0p5_w0p2 ref_op0_n100_s0p5_w0p2 0 {C_RBL}   $ ASSUMPTION: ideal matched dummy load
XMWR_op0_n100_s0p5_w0p2_0 sn_op0_n100_s0p5_w0p2_0 wwl_op0_n100_s0p5_w0p2 wbl_op0_n100_s0p5_w0p2 0 sky130_fd_pr__nfet_01v8 L=0.15 W=0.42 nf=1 ad=0.1218 as=0.1218 pd=1.42 ps=1.42 nrd=0.69047619047619  nrs=0.69047619047619 sa=0 sb=0 sd=0 mult=1 m=1
XMRD_op0_n100_s0p5_w0p2_0 rbl_op0_n100_s0p5_w0p2 sn_op0_n100_s0p5_w0p2_0 rwls_op0_n100_s0p5_w0p2 0 sky130_fd_pr__nfet_01v8 L=0.15 W=0.42 nf=1 ad=0.1218 as=0.1218 pd=1.42 ps=1.42 nrd=0.69047619047619  nrs=0.69047619047619 sa=0 sb=0 sd=0 mult=1 m=1
csn_op0_n100_s0p5_w0p2_0 sn_op0_n100_s0p5_w0p2_0 0 {C_SN}
XMWR_op0_n100_s0p5_w0p2_1 sn_op0_n100_s0p5_w0p2_1 wwl_des wbl_op0_n100_s0p5_w0p2 0 sky130_fd_pr__nfet_01v8 L=0.15 W=0.42 nf=1 ad=0.1218 as=0.1218 pd=1.42 ps=1.42 nrd=0.69047619047619  nrs=0.69047619047619 sa=0 sb=0 sd=0 mult=1 m=1
XMRD_op0_n100_s0p5_w0p2_1 rbl_op0_n100_s0p5_w0p2 sn_op0_n100_s0p5_w0p2_1 rwl_des 0 sky130_fd_pr__nfet_01v8 L=0.15 W=0.42 nf=1 ad=0.1218 as=0.1218 pd=1.42 ps=1.42 nrd=0.69047619047619  nrs=0.69047619047619 sa=0 sb=0 sd=0 mult=1 m=1
csn_op0_n100_s0p5_w0p2_1 sn_op0_n100_s0p5_w0p2_1 0 {C_SN}
XMWR_op0_n100_s0p5_w0p2_2 sn_op0_n100_s0p5_w0p2_2 wwl_des wbl_op0_n100_s0p5_w0p2 0 sky130_fd_pr__nfet_01v8 L=0.15 W=0.42 nf=1 ad=0.1218 as=0.1218 pd=1.42 ps=1.42 nrd=0.69047619047619  nrs=0.69047619047619 sa=0 sb=0 sd=0 mult=1 m=1
XMRD_op0_n100_s0p5_w0p2_2 rbl_op0_n100_s0p5_w0p2 sn_op0_n100_s0p5_w0p2_2 rwl_des 0 sky130_fd_pr__nfet_01v8 L=0.15 W=0.42 nf=1 ad=0.1218 as=0.1218 pd=1.42 ps=1.42 nrd=0.69047619047619  nrs=0.69047619047619 sa=0 sb=0 sd=0 mult=1 m=1
csn_op0_n100_s0p5_w0p2_2 sn_op0_n100_s0p5_w0p2_2 0 {C_SN}
XMWR_op0_n100_s0p5_w0p2_3 sn_op0_n100_s0p5_w0p2_3 wwl_des wbl_op0_n100_s0p5_w0p2 0 sky130_fd_pr__nfet_01v8 L=0.15 W=0.42 nf=1 ad=0.1218 as=0.1218 pd=1.42 ps=1.42 nrd=0.69047619047619  nrs=0.69047619047619 sa=0 sb=0 sd=0 mult=1 m=1
XMRD_op0_n100_s0p5_w0p2_3 rbl_op0_n100_s0p5_w0p2 sn_op0_n100_s0p5_w0p2_3 rwl_des 0 sky130_fd_pr__nfet_01v8 L=0.15 W=0.42 nf=1 ad=0.1218 as=0.1218 pd=1.42 ps=1.42 nrd=0.69047619047619  nrs=0.69047619047619 sa=0 sb=0 sd=0 mult=1 m=1
csn_op0_n100_s0p5_w0p2_3 sn_op0_n100_s0p5_w0p2_3 0 {C_SN}
XMN1_op0_n100_s0p5_w0p2 rbl_op0_n100_s0p5_w0p2 ref_op0_n100_s0p5_w0p2 vn_op0_n100_s0p5_w0p2 0 sky130_fd_pr__nfet_01v8 L=0.15 W=1 nf=1 ad=0.29 as=0.29 pd=2.58 ps=2.58 mult=1 m=1
XMN2_op0_n100_s0p5_w0p2 ref_op0_n100_s0p5_w0p2 rbl_op0_n100_s0p5_w0p2 vn_op0_n100_s0p5_w0p2 0 sky130_fd_pr__nfet_01v8 L=0.15 W=1 nf=1 ad=0.29 as=0.29 pd=2.58 ps=2.58 mult=1 m=1
XMP1_op0_n100_s0p5_w0p2 rbl_op0_n100_s0p5_w0p2 ref_op0_n100_s0p5_w0p2 vp_op0_n100_s0p5_w0p2 vdd sky130_fd_pr__pfet_01v8 L=0.15 W=2 nf=1 ad=0.58 as=0.58 pd=4.58 ps=4.58 mult=1 m=1
XMP2_op0_n100_s0p5_w0p2 ref_op0_n100_s0p5_w0p2 rbl_op0_n100_s0p5_w0p2 vp_op0_n100_s0p5_w0p2 vdd sky130_fd_pr__pfet_01v8 L=0.15 W=2 nf=1 ad=0.58 as=0.58 pd=4.58 ps=4.58 mult=1 m=1
XMNF_op0_n100_s0p5_w0p2 vn_op0_n100_s0p5_w0p2 en_op0_n100_s0p5_w0p2 0 0 sky130_fd_pr__nfet_01v8 L=0.15 W=2 nf=1 ad=0.58 as=0.58 pd=4.58 ps=4.58 mult=1 m=1
XMPH_op0_n100_s0p5_w0p2 vp_op0_n100_s0p5_w0p2 enb_op0_n100_s0p5_w0p2 vdd vdd sky130_fd_pr__pfet_01v8 L=0.15 W=4 nf=1 ad=1.16 as=1.16 pd=8.58 ps=8.58 mult=1 m=1
bd_op0_n100_s0p5_w0p2 d_op0_n100_s0p5_w0p2 0 v=v(rbl_op0_n100_s0p5_w0p2)-v(ref_op0_n100_s0p5_w0p2)

* ---- instance 121: op0_n100_s0p5_w0p5 (t_en 4.5 ns, WWL 5.5..6 ns, release 8 ns) ----
ven_op0_n100_s0p5_w0p5  en_op0_n100_s0p5_w0p5  0 pwl(0 0 4.5000e-09 0 4.6000e-09 {VDD} 8.0000e-09 {VDD} 8.1000e-09 0)
venb_op0_n100_s0p5_w0p5 enb_op0_n100_s0p5_w0p5 0 pwl(0 {VDD} 4.5000e-09 {VDD} 4.6000e-09 0 8.0000e-09 0 8.1000e-09 {VDD})
vrs_op0_n100_s0p5_w0p5  rwls_op0_n100_s0p5_w0p5 0 pwl(0 {VDD} {T_READ} {VDD} {T_READ+TEDGE} 0 8.0000e-09 0 8.1000e-09 {VDD})
vww_op0_n100_s0p5_w0p5  wwl_op0_n100_s0p5_w0p5 0 pwl(0 0 5.5000e-09 0 5.6000e-09 {VDD} 6.0000e-09 {VDD} 6.1000e-09 0)
vwc_op0_n100_s0p5_w0p5  wbc_op0_n100_s0p5_w0p5 0 pwl(0 0 5.5000e-09 0 5.6000e-09 {VDD} 8.0000e-09 {VDD} 8.1000e-09 0)
swb_op0_n100_s0p5_w0p5 ref_op0_n100_s0p5_w0p5 wbl_op0_n100_s0p5_w0p5 wbc_op0_n100_s0p5_w0p5 0 swwbl
cwbl_op0_n100_s0p5_w0p5 wbl_op0_n100_s0p5_w0p5 0 {C_WBL}
spa_op0_n100_s0p5_w0p5 prea rbl_op0_n100_s0p5_w0p5 ctl 0 swpre
spr_op0_n100_s0p5_w0p5 pref ref_op0_n100_s0p5_w0p5 ctl 0 swpre
crbl_op0_n100_s0p5_w0p5 rbl_op0_n100_s0p5_w0p5 0 {C_RBL}
cref_op0_n100_s0p5_w0p5 ref_op0_n100_s0p5_w0p5 0 {C_RBL}   $ ASSUMPTION: ideal matched dummy load
XMWR_op0_n100_s0p5_w0p5_0 sn_op0_n100_s0p5_w0p5_0 wwl_op0_n100_s0p5_w0p5 wbl_op0_n100_s0p5_w0p5 0 sky130_fd_pr__nfet_01v8 L=0.15 W=0.42 nf=1 ad=0.1218 as=0.1218 pd=1.42 ps=1.42 nrd=0.69047619047619  nrs=0.69047619047619 sa=0 sb=0 sd=0 mult=1 m=1
XMRD_op0_n100_s0p5_w0p5_0 rbl_op0_n100_s0p5_w0p5 sn_op0_n100_s0p5_w0p5_0 rwls_op0_n100_s0p5_w0p5 0 sky130_fd_pr__nfet_01v8 L=0.15 W=0.42 nf=1 ad=0.1218 as=0.1218 pd=1.42 ps=1.42 nrd=0.69047619047619  nrs=0.69047619047619 sa=0 sb=0 sd=0 mult=1 m=1
csn_op0_n100_s0p5_w0p5_0 sn_op0_n100_s0p5_w0p5_0 0 {C_SN}
XMWR_op0_n100_s0p5_w0p5_1 sn_op0_n100_s0p5_w0p5_1 wwl_des wbl_op0_n100_s0p5_w0p5 0 sky130_fd_pr__nfet_01v8 L=0.15 W=0.42 nf=1 ad=0.1218 as=0.1218 pd=1.42 ps=1.42 nrd=0.69047619047619  nrs=0.69047619047619 sa=0 sb=0 sd=0 mult=1 m=1
XMRD_op0_n100_s0p5_w0p5_1 rbl_op0_n100_s0p5_w0p5 sn_op0_n100_s0p5_w0p5_1 rwl_des 0 sky130_fd_pr__nfet_01v8 L=0.15 W=0.42 nf=1 ad=0.1218 as=0.1218 pd=1.42 ps=1.42 nrd=0.69047619047619  nrs=0.69047619047619 sa=0 sb=0 sd=0 mult=1 m=1
csn_op0_n100_s0p5_w0p5_1 sn_op0_n100_s0p5_w0p5_1 0 {C_SN}
XMWR_op0_n100_s0p5_w0p5_2 sn_op0_n100_s0p5_w0p5_2 wwl_des wbl_op0_n100_s0p5_w0p5 0 sky130_fd_pr__nfet_01v8 L=0.15 W=0.42 nf=1 ad=0.1218 as=0.1218 pd=1.42 ps=1.42 nrd=0.69047619047619  nrs=0.69047619047619 sa=0 sb=0 sd=0 mult=1 m=1
XMRD_op0_n100_s0p5_w0p5_2 rbl_op0_n100_s0p5_w0p5 sn_op0_n100_s0p5_w0p5_2 rwl_des 0 sky130_fd_pr__nfet_01v8 L=0.15 W=0.42 nf=1 ad=0.1218 as=0.1218 pd=1.42 ps=1.42 nrd=0.69047619047619  nrs=0.69047619047619 sa=0 sb=0 sd=0 mult=1 m=1
csn_op0_n100_s0p5_w0p5_2 sn_op0_n100_s0p5_w0p5_2 0 {C_SN}
XMWR_op0_n100_s0p5_w0p5_3 sn_op0_n100_s0p5_w0p5_3 wwl_des wbl_op0_n100_s0p5_w0p5 0 sky130_fd_pr__nfet_01v8 L=0.15 W=0.42 nf=1 ad=0.1218 as=0.1218 pd=1.42 ps=1.42 nrd=0.69047619047619  nrs=0.69047619047619 sa=0 sb=0 sd=0 mult=1 m=1
XMRD_op0_n100_s0p5_w0p5_3 rbl_op0_n100_s0p5_w0p5 sn_op0_n100_s0p5_w0p5_3 rwl_des 0 sky130_fd_pr__nfet_01v8 L=0.15 W=0.42 nf=1 ad=0.1218 as=0.1218 pd=1.42 ps=1.42 nrd=0.69047619047619  nrs=0.69047619047619 sa=0 sb=0 sd=0 mult=1 m=1
csn_op0_n100_s0p5_w0p5_3 sn_op0_n100_s0p5_w0p5_3 0 {C_SN}
XMN1_op0_n100_s0p5_w0p5 rbl_op0_n100_s0p5_w0p5 ref_op0_n100_s0p5_w0p5 vn_op0_n100_s0p5_w0p5 0 sky130_fd_pr__nfet_01v8 L=0.15 W=1 nf=1 ad=0.29 as=0.29 pd=2.58 ps=2.58 mult=1 m=1
XMN2_op0_n100_s0p5_w0p5 ref_op0_n100_s0p5_w0p5 rbl_op0_n100_s0p5_w0p5 vn_op0_n100_s0p5_w0p5 0 sky130_fd_pr__nfet_01v8 L=0.15 W=1 nf=1 ad=0.29 as=0.29 pd=2.58 ps=2.58 mult=1 m=1
XMP1_op0_n100_s0p5_w0p5 rbl_op0_n100_s0p5_w0p5 ref_op0_n100_s0p5_w0p5 vp_op0_n100_s0p5_w0p5 vdd sky130_fd_pr__pfet_01v8 L=0.15 W=2 nf=1 ad=0.58 as=0.58 pd=4.58 ps=4.58 mult=1 m=1
XMP2_op0_n100_s0p5_w0p5 ref_op0_n100_s0p5_w0p5 rbl_op0_n100_s0p5_w0p5 vp_op0_n100_s0p5_w0p5 vdd sky130_fd_pr__pfet_01v8 L=0.15 W=2 nf=1 ad=0.58 as=0.58 pd=4.58 ps=4.58 mult=1 m=1
XMNF_op0_n100_s0p5_w0p5 vn_op0_n100_s0p5_w0p5 en_op0_n100_s0p5_w0p5 0 0 sky130_fd_pr__nfet_01v8 L=0.15 W=2 nf=1 ad=0.58 as=0.58 pd=4.58 ps=4.58 mult=1 m=1
XMPH_op0_n100_s0p5_w0p5 vp_op0_n100_s0p5_w0p5 enb_op0_n100_s0p5_w0p5 vdd vdd sky130_fd_pr__pfet_01v8 L=0.15 W=4 nf=1 ad=1.16 as=1.16 pd=8.58 ps=8.58 mult=1 m=1
bd_op0_n100_s0p5_w0p5 d_op0_n100_s0p5_w0p5 0 v=v(rbl_op0_n100_s0p5_w0p5)-v(ref_op0_n100_s0p5_w0p5)

* ---- instance 122: op0_n100_s0p5_w1 (t_en 4.5 ns, WWL 5.5..6.5 ns, release 8.5 ns) ----
ven_op0_n100_s0p5_w1  en_op0_n100_s0p5_w1  0 pwl(0 0 4.5000e-09 0 4.6000e-09 {VDD} 8.5000e-09 {VDD} 8.6000e-09 0)
venb_op0_n100_s0p5_w1 enb_op0_n100_s0p5_w1 0 pwl(0 {VDD} 4.5000e-09 {VDD} 4.6000e-09 0 8.5000e-09 0 8.6000e-09 {VDD})
vrs_op0_n100_s0p5_w1  rwls_op0_n100_s0p5_w1 0 pwl(0 {VDD} {T_READ} {VDD} {T_READ+TEDGE} 0 8.5000e-09 0 8.6000e-09 {VDD})
vww_op0_n100_s0p5_w1  wwl_op0_n100_s0p5_w1 0 pwl(0 0 5.5000e-09 0 5.6000e-09 {VDD} 6.5000e-09 {VDD} 6.6000e-09 0)
vwc_op0_n100_s0p5_w1  wbc_op0_n100_s0p5_w1 0 pwl(0 0 5.5000e-09 0 5.6000e-09 {VDD} 8.5000e-09 {VDD} 8.6000e-09 0)
swb_op0_n100_s0p5_w1 ref_op0_n100_s0p5_w1 wbl_op0_n100_s0p5_w1 wbc_op0_n100_s0p5_w1 0 swwbl
cwbl_op0_n100_s0p5_w1 wbl_op0_n100_s0p5_w1 0 {C_WBL}
spa_op0_n100_s0p5_w1 prea rbl_op0_n100_s0p5_w1 ctl 0 swpre
spr_op0_n100_s0p5_w1 pref ref_op0_n100_s0p5_w1 ctl 0 swpre
crbl_op0_n100_s0p5_w1 rbl_op0_n100_s0p5_w1 0 {C_RBL}
cref_op0_n100_s0p5_w1 ref_op0_n100_s0p5_w1 0 {C_RBL}   $ ASSUMPTION: ideal matched dummy load
XMWR_op0_n100_s0p5_w1_0 sn_op0_n100_s0p5_w1_0 wwl_op0_n100_s0p5_w1 wbl_op0_n100_s0p5_w1 0 sky130_fd_pr__nfet_01v8 L=0.15 W=0.42 nf=1 ad=0.1218 as=0.1218 pd=1.42 ps=1.42 nrd=0.69047619047619  nrs=0.69047619047619 sa=0 sb=0 sd=0 mult=1 m=1
XMRD_op0_n100_s0p5_w1_0 rbl_op0_n100_s0p5_w1 sn_op0_n100_s0p5_w1_0 rwls_op0_n100_s0p5_w1 0 sky130_fd_pr__nfet_01v8 L=0.15 W=0.42 nf=1 ad=0.1218 as=0.1218 pd=1.42 ps=1.42 nrd=0.69047619047619  nrs=0.69047619047619 sa=0 sb=0 sd=0 mult=1 m=1
csn_op0_n100_s0p5_w1_0 sn_op0_n100_s0p5_w1_0 0 {C_SN}
XMWR_op0_n100_s0p5_w1_1 sn_op0_n100_s0p5_w1_1 wwl_des wbl_op0_n100_s0p5_w1 0 sky130_fd_pr__nfet_01v8 L=0.15 W=0.42 nf=1 ad=0.1218 as=0.1218 pd=1.42 ps=1.42 nrd=0.69047619047619  nrs=0.69047619047619 sa=0 sb=0 sd=0 mult=1 m=1
XMRD_op0_n100_s0p5_w1_1 rbl_op0_n100_s0p5_w1 sn_op0_n100_s0p5_w1_1 rwl_des 0 sky130_fd_pr__nfet_01v8 L=0.15 W=0.42 nf=1 ad=0.1218 as=0.1218 pd=1.42 ps=1.42 nrd=0.69047619047619  nrs=0.69047619047619 sa=0 sb=0 sd=0 mult=1 m=1
csn_op0_n100_s0p5_w1_1 sn_op0_n100_s0p5_w1_1 0 {C_SN}
XMWR_op0_n100_s0p5_w1_2 sn_op0_n100_s0p5_w1_2 wwl_des wbl_op0_n100_s0p5_w1 0 sky130_fd_pr__nfet_01v8 L=0.15 W=0.42 nf=1 ad=0.1218 as=0.1218 pd=1.42 ps=1.42 nrd=0.69047619047619  nrs=0.69047619047619 sa=0 sb=0 sd=0 mult=1 m=1
XMRD_op0_n100_s0p5_w1_2 rbl_op0_n100_s0p5_w1 sn_op0_n100_s0p5_w1_2 rwl_des 0 sky130_fd_pr__nfet_01v8 L=0.15 W=0.42 nf=1 ad=0.1218 as=0.1218 pd=1.42 ps=1.42 nrd=0.69047619047619  nrs=0.69047619047619 sa=0 sb=0 sd=0 mult=1 m=1
csn_op0_n100_s0p5_w1_2 sn_op0_n100_s0p5_w1_2 0 {C_SN}
XMWR_op0_n100_s0p5_w1_3 sn_op0_n100_s0p5_w1_3 wwl_des wbl_op0_n100_s0p5_w1 0 sky130_fd_pr__nfet_01v8 L=0.15 W=0.42 nf=1 ad=0.1218 as=0.1218 pd=1.42 ps=1.42 nrd=0.69047619047619  nrs=0.69047619047619 sa=0 sb=0 sd=0 mult=1 m=1
XMRD_op0_n100_s0p5_w1_3 rbl_op0_n100_s0p5_w1 sn_op0_n100_s0p5_w1_3 rwl_des 0 sky130_fd_pr__nfet_01v8 L=0.15 W=0.42 nf=1 ad=0.1218 as=0.1218 pd=1.42 ps=1.42 nrd=0.69047619047619  nrs=0.69047619047619 sa=0 sb=0 sd=0 mult=1 m=1
csn_op0_n100_s0p5_w1_3 sn_op0_n100_s0p5_w1_3 0 {C_SN}
XMN1_op0_n100_s0p5_w1 rbl_op0_n100_s0p5_w1 ref_op0_n100_s0p5_w1 vn_op0_n100_s0p5_w1 0 sky130_fd_pr__nfet_01v8 L=0.15 W=1 nf=1 ad=0.29 as=0.29 pd=2.58 ps=2.58 mult=1 m=1
XMN2_op0_n100_s0p5_w1 ref_op0_n100_s0p5_w1 rbl_op0_n100_s0p5_w1 vn_op0_n100_s0p5_w1 0 sky130_fd_pr__nfet_01v8 L=0.15 W=1 nf=1 ad=0.29 as=0.29 pd=2.58 ps=2.58 mult=1 m=1
XMP1_op0_n100_s0p5_w1 rbl_op0_n100_s0p5_w1 ref_op0_n100_s0p5_w1 vp_op0_n100_s0p5_w1 vdd sky130_fd_pr__pfet_01v8 L=0.15 W=2 nf=1 ad=0.58 as=0.58 pd=4.58 ps=4.58 mult=1 m=1
XMP2_op0_n100_s0p5_w1 ref_op0_n100_s0p5_w1 rbl_op0_n100_s0p5_w1 vp_op0_n100_s0p5_w1 vdd sky130_fd_pr__pfet_01v8 L=0.15 W=2 nf=1 ad=0.58 as=0.58 pd=4.58 ps=4.58 mult=1 m=1
XMNF_op0_n100_s0p5_w1 vn_op0_n100_s0p5_w1 en_op0_n100_s0p5_w1 0 0 sky130_fd_pr__nfet_01v8 L=0.15 W=2 nf=1 ad=0.58 as=0.58 pd=4.58 ps=4.58 mult=1 m=1
XMPH_op0_n100_s0p5_w1 vp_op0_n100_s0p5_w1 enb_op0_n100_s0p5_w1 vdd vdd sky130_fd_pr__pfet_01v8 L=0.15 W=4 nf=1 ad=1.16 as=1.16 pd=8.58 ps=8.58 mult=1 m=1
bd_op0_n100_s0p5_w1 d_op0_n100_s0p5_w1 0 v=v(rbl_op0_n100_s0p5_w1)-v(ref_op0_n100_s0p5_w1)

* ---- instance 123: op0_n100_s0p5_w2 (t_en 4.5 ns, WWL 5.5..7.5 ns, release 9.5 ns) ----
ven_op0_n100_s0p5_w2  en_op0_n100_s0p5_w2  0 pwl(0 0 4.5000e-09 0 4.6000e-09 {VDD} 9.5000e-09 {VDD} 9.6000e-09 0)
venb_op0_n100_s0p5_w2 enb_op0_n100_s0p5_w2 0 pwl(0 {VDD} 4.5000e-09 {VDD} 4.6000e-09 0 9.5000e-09 0 9.6000e-09 {VDD})
vrs_op0_n100_s0p5_w2  rwls_op0_n100_s0p5_w2 0 pwl(0 {VDD} {T_READ} {VDD} {T_READ+TEDGE} 0 9.5000e-09 0 9.6000e-09 {VDD})
vww_op0_n100_s0p5_w2  wwl_op0_n100_s0p5_w2 0 pwl(0 0 5.5000e-09 0 5.6000e-09 {VDD} 7.5000e-09 {VDD} 7.6000e-09 0)
vwc_op0_n100_s0p5_w2  wbc_op0_n100_s0p5_w2 0 pwl(0 0 5.5000e-09 0 5.6000e-09 {VDD} 9.5000e-09 {VDD} 9.6000e-09 0)
swb_op0_n100_s0p5_w2 ref_op0_n100_s0p5_w2 wbl_op0_n100_s0p5_w2 wbc_op0_n100_s0p5_w2 0 swwbl
cwbl_op0_n100_s0p5_w2 wbl_op0_n100_s0p5_w2 0 {C_WBL}
spa_op0_n100_s0p5_w2 prea rbl_op0_n100_s0p5_w2 ctl 0 swpre
spr_op0_n100_s0p5_w2 pref ref_op0_n100_s0p5_w2 ctl 0 swpre
crbl_op0_n100_s0p5_w2 rbl_op0_n100_s0p5_w2 0 {C_RBL}
cref_op0_n100_s0p5_w2 ref_op0_n100_s0p5_w2 0 {C_RBL}   $ ASSUMPTION: ideal matched dummy load
XMWR_op0_n100_s0p5_w2_0 sn_op0_n100_s0p5_w2_0 wwl_op0_n100_s0p5_w2 wbl_op0_n100_s0p5_w2 0 sky130_fd_pr__nfet_01v8 L=0.15 W=0.42 nf=1 ad=0.1218 as=0.1218 pd=1.42 ps=1.42 nrd=0.69047619047619  nrs=0.69047619047619 sa=0 sb=0 sd=0 mult=1 m=1
XMRD_op0_n100_s0p5_w2_0 rbl_op0_n100_s0p5_w2 sn_op0_n100_s0p5_w2_0 rwls_op0_n100_s0p5_w2 0 sky130_fd_pr__nfet_01v8 L=0.15 W=0.42 nf=1 ad=0.1218 as=0.1218 pd=1.42 ps=1.42 nrd=0.69047619047619  nrs=0.69047619047619 sa=0 sb=0 sd=0 mult=1 m=1
csn_op0_n100_s0p5_w2_0 sn_op0_n100_s0p5_w2_0 0 {C_SN}
XMWR_op0_n100_s0p5_w2_1 sn_op0_n100_s0p5_w2_1 wwl_des wbl_op0_n100_s0p5_w2 0 sky130_fd_pr__nfet_01v8 L=0.15 W=0.42 nf=1 ad=0.1218 as=0.1218 pd=1.42 ps=1.42 nrd=0.69047619047619  nrs=0.69047619047619 sa=0 sb=0 sd=0 mult=1 m=1
XMRD_op0_n100_s0p5_w2_1 rbl_op0_n100_s0p5_w2 sn_op0_n100_s0p5_w2_1 rwl_des 0 sky130_fd_pr__nfet_01v8 L=0.15 W=0.42 nf=1 ad=0.1218 as=0.1218 pd=1.42 ps=1.42 nrd=0.69047619047619  nrs=0.69047619047619 sa=0 sb=0 sd=0 mult=1 m=1
csn_op0_n100_s0p5_w2_1 sn_op0_n100_s0p5_w2_1 0 {C_SN}
XMWR_op0_n100_s0p5_w2_2 sn_op0_n100_s0p5_w2_2 wwl_des wbl_op0_n100_s0p5_w2 0 sky130_fd_pr__nfet_01v8 L=0.15 W=0.42 nf=1 ad=0.1218 as=0.1218 pd=1.42 ps=1.42 nrd=0.69047619047619  nrs=0.69047619047619 sa=0 sb=0 sd=0 mult=1 m=1
XMRD_op0_n100_s0p5_w2_2 rbl_op0_n100_s0p5_w2 sn_op0_n100_s0p5_w2_2 rwl_des 0 sky130_fd_pr__nfet_01v8 L=0.15 W=0.42 nf=1 ad=0.1218 as=0.1218 pd=1.42 ps=1.42 nrd=0.69047619047619  nrs=0.69047619047619 sa=0 sb=0 sd=0 mult=1 m=1
csn_op0_n100_s0p5_w2_2 sn_op0_n100_s0p5_w2_2 0 {C_SN}
XMWR_op0_n100_s0p5_w2_3 sn_op0_n100_s0p5_w2_3 wwl_des wbl_op0_n100_s0p5_w2 0 sky130_fd_pr__nfet_01v8 L=0.15 W=0.42 nf=1 ad=0.1218 as=0.1218 pd=1.42 ps=1.42 nrd=0.69047619047619  nrs=0.69047619047619 sa=0 sb=0 sd=0 mult=1 m=1
XMRD_op0_n100_s0p5_w2_3 rbl_op0_n100_s0p5_w2 sn_op0_n100_s0p5_w2_3 rwl_des 0 sky130_fd_pr__nfet_01v8 L=0.15 W=0.42 nf=1 ad=0.1218 as=0.1218 pd=1.42 ps=1.42 nrd=0.69047619047619  nrs=0.69047619047619 sa=0 sb=0 sd=0 mult=1 m=1
csn_op0_n100_s0p5_w2_3 sn_op0_n100_s0p5_w2_3 0 {C_SN}
XMN1_op0_n100_s0p5_w2 rbl_op0_n100_s0p5_w2 ref_op0_n100_s0p5_w2 vn_op0_n100_s0p5_w2 0 sky130_fd_pr__nfet_01v8 L=0.15 W=1 nf=1 ad=0.29 as=0.29 pd=2.58 ps=2.58 mult=1 m=1
XMN2_op0_n100_s0p5_w2 ref_op0_n100_s0p5_w2 rbl_op0_n100_s0p5_w2 vn_op0_n100_s0p5_w2 0 sky130_fd_pr__nfet_01v8 L=0.15 W=1 nf=1 ad=0.29 as=0.29 pd=2.58 ps=2.58 mult=1 m=1
XMP1_op0_n100_s0p5_w2 rbl_op0_n100_s0p5_w2 ref_op0_n100_s0p5_w2 vp_op0_n100_s0p5_w2 vdd sky130_fd_pr__pfet_01v8 L=0.15 W=2 nf=1 ad=0.58 as=0.58 pd=4.58 ps=4.58 mult=1 m=1
XMP2_op0_n100_s0p5_w2 ref_op0_n100_s0p5_w2 rbl_op0_n100_s0p5_w2 vp_op0_n100_s0p5_w2 vdd sky130_fd_pr__pfet_01v8 L=0.15 W=2 nf=1 ad=0.58 as=0.58 pd=4.58 ps=4.58 mult=1 m=1
XMNF_op0_n100_s0p5_w2 vn_op0_n100_s0p5_w2 en_op0_n100_s0p5_w2 0 0 sky130_fd_pr__nfet_01v8 L=0.15 W=2 nf=1 ad=0.58 as=0.58 pd=4.58 ps=4.58 mult=1 m=1
XMPH_op0_n100_s0p5_w2 vp_op0_n100_s0p5_w2 enb_op0_n100_s0p5_w2 vdd vdd sky130_fd_pr__pfet_01v8 L=0.15 W=4 nf=1 ad=1.16 as=1.16 pd=8.58 ps=8.58 mult=1 m=1
bd_op0_n100_s0p5_w2 d_op0_n100_s0p5_w2 0 v=v(rbl_op0_n100_s0p5_w2)-v(ref_op0_n100_s0p5_w2)

* ---- instance 124: op0_n100_s0p5_w3 (t_en 4.5 ns, WWL 5.5..8.5 ns, release 10.5 ns) ----
ven_op0_n100_s0p5_w3  en_op0_n100_s0p5_w3  0 pwl(0 0 4.5000e-09 0 4.6000e-09 {VDD} 1.0500e-08 {VDD} 1.0600e-08 0)
venb_op0_n100_s0p5_w3 enb_op0_n100_s0p5_w3 0 pwl(0 {VDD} 4.5000e-09 {VDD} 4.6000e-09 0 1.0500e-08 0 1.0600e-08 {VDD})
vrs_op0_n100_s0p5_w3  rwls_op0_n100_s0p5_w3 0 pwl(0 {VDD} {T_READ} {VDD} {T_READ+TEDGE} 0 1.0500e-08 0 1.0600e-08 {VDD})
vww_op0_n100_s0p5_w3  wwl_op0_n100_s0p5_w3 0 pwl(0 0 5.5000e-09 0 5.6000e-09 {VDD} 8.5000e-09 {VDD} 8.6000e-09 0)
vwc_op0_n100_s0p5_w3  wbc_op0_n100_s0p5_w3 0 pwl(0 0 5.5000e-09 0 5.6000e-09 {VDD} 1.0500e-08 {VDD} 1.0600e-08 0)
swb_op0_n100_s0p5_w3 ref_op0_n100_s0p5_w3 wbl_op0_n100_s0p5_w3 wbc_op0_n100_s0p5_w3 0 swwbl
cwbl_op0_n100_s0p5_w3 wbl_op0_n100_s0p5_w3 0 {C_WBL}
spa_op0_n100_s0p5_w3 prea rbl_op0_n100_s0p5_w3 ctl 0 swpre
spr_op0_n100_s0p5_w3 pref ref_op0_n100_s0p5_w3 ctl 0 swpre
crbl_op0_n100_s0p5_w3 rbl_op0_n100_s0p5_w3 0 {C_RBL}
cref_op0_n100_s0p5_w3 ref_op0_n100_s0p5_w3 0 {C_RBL}   $ ASSUMPTION: ideal matched dummy load
XMWR_op0_n100_s0p5_w3_0 sn_op0_n100_s0p5_w3_0 wwl_op0_n100_s0p5_w3 wbl_op0_n100_s0p5_w3 0 sky130_fd_pr__nfet_01v8 L=0.15 W=0.42 nf=1 ad=0.1218 as=0.1218 pd=1.42 ps=1.42 nrd=0.69047619047619  nrs=0.69047619047619 sa=0 sb=0 sd=0 mult=1 m=1
XMRD_op0_n100_s0p5_w3_0 rbl_op0_n100_s0p5_w3 sn_op0_n100_s0p5_w3_0 rwls_op0_n100_s0p5_w3 0 sky130_fd_pr__nfet_01v8 L=0.15 W=0.42 nf=1 ad=0.1218 as=0.1218 pd=1.42 ps=1.42 nrd=0.69047619047619  nrs=0.69047619047619 sa=0 sb=0 sd=0 mult=1 m=1
csn_op0_n100_s0p5_w3_0 sn_op0_n100_s0p5_w3_0 0 {C_SN}
XMWR_op0_n100_s0p5_w3_1 sn_op0_n100_s0p5_w3_1 wwl_des wbl_op0_n100_s0p5_w3 0 sky130_fd_pr__nfet_01v8 L=0.15 W=0.42 nf=1 ad=0.1218 as=0.1218 pd=1.42 ps=1.42 nrd=0.69047619047619  nrs=0.69047619047619 sa=0 sb=0 sd=0 mult=1 m=1
XMRD_op0_n100_s0p5_w3_1 rbl_op0_n100_s0p5_w3 sn_op0_n100_s0p5_w3_1 rwl_des 0 sky130_fd_pr__nfet_01v8 L=0.15 W=0.42 nf=1 ad=0.1218 as=0.1218 pd=1.42 ps=1.42 nrd=0.69047619047619  nrs=0.69047619047619 sa=0 sb=0 sd=0 mult=1 m=1
csn_op0_n100_s0p5_w3_1 sn_op0_n100_s0p5_w3_1 0 {C_SN}
XMWR_op0_n100_s0p5_w3_2 sn_op0_n100_s0p5_w3_2 wwl_des wbl_op0_n100_s0p5_w3 0 sky130_fd_pr__nfet_01v8 L=0.15 W=0.42 nf=1 ad=0.1218 as=0.1218 pd=1.42 ps=1.42 nrd=0.69047619047619  nrs=0.69047619047619 sa=0 sb=0 sd=0 mult=1 m=1
XMRD_op0_n100_s0p5_w3_2 rbl_op0_n100_s0p5_w3 sn_op0_n100_s0p5_w3_2 rwl_des 0 sky130_fd_pr__nfet_01v8 L=0.15 W=0.42 nf=1 ad=0.1218 as=0.1218 pd=1.42 ps=1.42 nrd=0.69047619047619  nrs=0.69047619047619 sa=0 sb=0 sd=0 mult=1 m=1
csn_op0_n100_s0p5_w3_2 sn_op0_n100_s0p5_w3_2 0 {C_SN}
XMWR_op0_n100_s0p5_w3_3 sn_op0_n100_s0p5_w3_3 wwl_des wbl_op0_n100_s0p5_w3 0 sky130_fd_pr__nfet_01v8 L=0.15 W=0.42 nf=1 ad=0.1218 as=0.1218 pd=1.42 ps=1.42 nrd=0.69047619047619  nrs=0.69047619047619 sa=0 sb=0 sd=0 mult=1 m=1
XMRD_op0_n100_s0p5_w3_3 rbl_op0_n100_s0p5_w3 sn_op0_n100_s0p5_w3_3 rwl_des 0 sky130_fd_pr__nfet_01v8 L=0.15 W=0.42 nf=1 ad=0.1218 as=0.1218 pd=1.42 ps=1.42 nrd=0.69047619047619  nrs=0.69047619047619 sa=0 sb=0 sd=0 mult=1 m=1
csn_op0_n100_s0p5_w3_3 sn_op0_n100_s0p5_w3_3 0 {C_SN}
XMN1_op0_n100_s0p5_w3 rbl_op0_n100_s0p5_w3 ref_op0_n100_s0p5_w3 vn_op0_n100_s0p5_w3 0 sky130_fd_pr__nfet_01v8 L=0.15 W=1 nf=1 ad=0.29 as=0.29 pd=2.58 ps=2.58 mult=1 m=1
XMN2_op0_n100_s0p5_w3 ref_op0_n100_s0p5_w3 rbl_op0_n100_s0p5_w3 vn_op0_n100_s0p5_w3 0 sky130_fd_pr__nfet_01v8 L=0.15 W=1 nf=1 ad=0.29 as=0.29 pd=2.58 ps=2.58 mult=1 m=1
XMP1_op0_n100_s0p5_w3 rbl_op0_n100_s0p5_w3 ref_op0_n100_s0p5_w3 vp_op0_n100_s0p5_w3 vdd sky130_fd_pr__pfet_01v8 L=0.15 W=2 nf=1 ad=0.58 as=0.58 pd=4.58 ps=4.58 mult=1 m=1
XMP2_op0_n100_s0p5_w3 ref_op0_n100_s0p5_w3 rbl_op0_n100_s0p5_w3 vp_op0_n100_s0p5_w3 vdd sky130_fd_pr__pfet_01v8 L=0.15 W=2 nf=1 ad=0.58 as=0.58 pd=4.58 ps=4.58 mult=1 m=1
XMNF_op0_n100_s0p5_w3 vn_op0_n100_s0p5_w3 en_op0_n100_s0p5_w3 0 0 sky130_fd_pr__nfet_01v8 L=0.15 W=2 nf=1 ad=0.58 as=0.58 pd=4.58 ps=4.58 mult=1 m=1
XMPH_op0_n100_s0p5_w3 vp_op0_n100_s0p5_w3 enb_op0_n100_s0p5_w3 vdd vdd sky130_fd_pr__pfet_01v8 L=0.15 W=4 nf=1 ad=1.16 as=1.16 pd=8.58 ps=8.58 mult=1 m=1
bd_op0_n100_s0p5_w3 d_op0_n100_s0p5_w3 0 v=v(rbl_op0_n100_s0p5_w3)-v(ref_op0_n100_s0p5_w3)

* ---- instance 125: op0_n100_s0p5_w5 (t_en 4.5 ns, WWL 5.5..10.5 ns, release 12.5 ns) ----
ven_op0_n100_s0p5_w5  en_op0_n100_s0p5_w5  0 pwl(0 0 4.5000e-09 0 4.6000e-09 {VDD} 1.2500e-08 {VDD} 1.2600e-08 0)
venb_op0_n100_s0p5_w5 enb_op0_n100_s0p5_w5 0 pwl(0 {VDD} 4.5000e-09 {VDD} 4.6000e-09 0 1.2500e-08 0 1.2600e-08 {VDD})
vrs_op0_n100_s0p5_w5  rwls_op0_n100_s0p5_w5 0 pwl(0 {VDD} {T_READ} {VDD} {T_READ+TEDGE} 0 1.2500e-08 0 1.2600e-08 {VDD})
vww_op0_n100_s0p5_w5  wwl_op0_n100_s0p5_w5 0 pwl(0 0 5.5000e-09 0 5.6000e-09 {VDD} 1.0500e-08 {VDD} 1.0600e-08 0)
vwc_op0_n100_s0p5_w5  wbc_op0_n100_s0p5_w5 0 pwl(0 0 5.5000e-09 0 5.6000e-09 {VDD} 1.2500e-08 {VDD} 1.2600e-08 0)
swb_op0_n100_s0p5_w5 ref_op0_n100_s0p5_w5 wbl_op0_n100_s0p5_w5 wbc_op0_n100_s0p5_w5 0 swwbl
cwbl_op0_n100_s0p5_w5 wbl_op0_n100_s0p5_w5 0 {C_WBL}
spa_op0_n100_s0p5_w5 prea rbl_op0_n100_s0p5_w5 ctl 0 swpre
spr_op0_n100_s0p5_w5 pref ref_op0_n100_s0p5_w5 ctl 0 swpre
crbl_op0_n100_s0p5_w5 rbl_op0_n100_s0p5_w5 0 {C_RBL}
cref_op0_n100_s0p5_w5 ref_op0_n100_s0p5_w5 0 {C_RBL}   $ ASSUMPTION: ideal matched dummy load
XMWR_op0_n100_s0p5_w5_0 sn_op0_n100_s0p5_w5_0 wwl_op0_n100_s0p5_w5 wbl_op0_n100_s0p5_w5 0 sky130_fd_pr__nfet_01v8 L=0.15 W=0.42 nf=1 ad=0.1218 as=0.1218 pd=1.42 ps=1.42 nrd=0.69047619047619  nrs=0.69047619047619 sa=0 sb=0 sd=0 mult=1 m=1
XMRD_op0_n100_s0p5_w5_0 rbl_op0_n100_s0p5_w5 sn_op0_n100_s0p5_w5_0 rwls_op0_n100_s0p5_w5 0 sky130_fd_pr__nfet_01v8 L=0.15 W=0.42 nf=1 ad=0.1218 as=0.1218 pd=1.42 ps=1.42 nrd=0.69047619047619  nrs=0.69047619047619 sa=0 sb=0 sd=0 mult=1 m=1
csn_op0_n100_s0p5_w5_0 sn_op0_n100_s0p5_w5_0 0 {C_SN}
XMWR_op0_n100_s0p5_w5_1 sn_op0_n100_s0p5_w5_1 wwl_des wbl_op0_n100_s0p5_w5 0 sky130_fd_pr__nfet_01v8 L=0.15 W=0.42 nf=1 ad=0.1218 as=0.1218 pd=1.42 ps=1.42 nrd=0.69047619047619  nrs=0.69047619047619 sa=0 sb=0 sd=0 mult=1 m=1
XMRD_op0_n100_s0p5_w5_1 rbl_op0_n100_s0p5_w5 sn_op0_n100_s0p5_w5_1 rwl_des 0 sky130_fd_pr__nfet_01v8 L=0.15 W=0.42 nf=1 ad=0.1218 as=0.1218 pd=1.42 ps=1.42 nrd=0.69047619047619  nrs=0.69047619047619 sa=0 sb=0 sd=0 mult=1 m=1
csn_op0_n100_s0p5_w5_1 sn_op0_n100_s0p5_w5_1 0 {C_SN}
XMWR_op0_n100_s0p5_w5_2 sn_op0_n100_s0p5_w5_2 wwl_des wbl_op0_n100_s0p5_w5 0 sky130_fd_pr__nfet_01v8 L=0.15 W=0.42 nf=1 ad=0.1218 as=0.1218 pd=1.42 ps=1.42 nrd=0.69047619047619  nrs=0.69047619047619 sa=0 sb=0 sd=0 mult=1 m=1
XMRD_op0_n100_s0p5_w5_2 rbl_op0_n100_s0p5_w5 sn_op0_n100_s0p5_w5_2 rwl_des 0 sky130_fd_pr__nfet_01v8 L=0.15 W=0.42 nf=1 ad=0.1218 as=0.1218 pd=1.42 ps=1.42 nrd=0.69047619047619  nrs=0.69047619047619 sa=0 sb=0 sd=0 mult=1 m=1
csn_op0_n100_s0p5_w5_2 sn_op0_n100_s0p5_w5_2 0 {C_SN}
XMWR_op0_n100_s0p5_w5_3 sn_op0_n100_s0p5_w5_3 wwl_des wbl_op0_n100_s0p5_w5 0 sky130_fd_pr__nfet_01v8 L=0.15 W=0.42 nf=1 ad=0.1218 as=0.1218 pd=1.42 ps=1.42 nrd=0.69047619047619  nrs=0.69047619047619 sa=0 sb=0 sd=0 mult=1 m=1
XMRD_op0_n100_s0p5_w5_3 rbl_op0_n100_s0p5_w5 sn_op0_n100_s0p5_w5_3 rwl_des 0 sky130_fd_pr__nfet_01v8 L=0.15 W=0.42 nf=1 ad=0.1218 as=0.1218 pd=1.42 ps=1.42 nrd=0.69047619047619  nrs=0.69047619047619 sa=0 sb=0 sd=0 mult=1 m=1
csn_op0_n100_s0p5_w5_3 sn_op0_n100_s0p5_w5_3 0 {C_SN}
XMN1_op0_n100_s0p5_w5 rbl_op0_n100_s0p5_w5 ref_op0_n100_s0p5_w5 vn_op0_n100_s0p5_w5 0 sky130_fd_pr__nfet_01v8 L=0.15 W=1 nf=1 ad=0.29 as=0.29 pd=2.58 ps=2.58 mult=1 m=1
XMN2_op0_n100_s0p5_w5 ref_op0_n100_s0p5_w5 rbl_op0_n100_s0p5_w5 vn_op0_n100_s0p5_w5 0 sky130_fd_pr__nfet_01v8 L=0.15 W=1 nf=1 ad=0.29 as=0.29 pd=2.58 ps=2.58 mult=1 m=1
XMP1_op0_n100_s0p5_w5 rbl_op0_n100_s0p5_w5 ref_op0_n100_s0p5_w5 vp_op0_n100_s0p5_w5 vdd sky130_fd_pr__pfet_01v8 L=0.15 W=2 nf=1 ad=0.58 as=0.58 pd=4.58 ps=4.58 mult=1 m=1
XMP2_op0_n100_s0p5_w5 ref_op0_n100_s0p5_w5 rbl_op0_n100_s0p5_w5 vp_op0_n100_s0p5_w5 vdd sky130_fd_pr__pfet_01v8 L=0.15 W=2 nf=1 ad=0.58 as=0.58 pd=4.58 ps=4.58 mult=1 m=1
XMNF_op0_n100_s0p5_w5 vn_op0_n100_s0p5_w5 en_op0_n100_s0p5_w5 0 0 sky130_fd_pr__nfet_01v8 L=0.15 W=2 nf=1 ad=0.58 as=0.58 pd=4.58 ps=4.58 mult=1 m=1
XMPH_op0_n100_s0p5_w5 vp_op0_n100_s0p5_w5 enb_op0_n100_s0p5_w5 vdd vdd sky130_fd_pr__pfet_01v8 L=0.15 W=4 nf=1 ad=1.16 as=1.16 pd=8.58 ps=8.58 mult=1 m=1
bd_op0_n100_s0p5_w5 d_op0_n100_s0p5_w5 0 v=v(rbl_op0_n100_s0p5_w5)-v(ref_op0_n100_s0p5_w5)

* ---- instance 126: op0_n100_s0p5_w7p5 (t_en 4.5 ns, WWL 5.5..13 ns, release 15 ns) ----
ven_op0_n100_s0p5_w7p5  en_op0_n100_s0p5_w7p5  0 pwl(0 0 4.5000e-09 0 4.6000e-09 {VDD} 1.5000e-08 {VDD} 1.5100e-08 0)
venb_op0_n100_s0p5_w7p5 enb_op0_n100_s0p5_w7p5 0 pwl(0 {VDD} 4.5000e-09 {VDD} 4.6000e-09 0 1.5000e-08 0 1.5100e-08 {VDD})
vrs_op0_n100_s0p5_w7p5  rwls_op0_n100_s0p5_w7p5 0 pwl(0 {VDD} {T_READ} {VDD} {T_READ+TEDGE} 0 1.5000e-08 0 1.5100e-08 {VDD})
vww_op0_n100_s0p5_w7p5  wwl_op0_n100_s0p5_w7p5 0 pwl(0 0 5.5000e-09 0 5.6000e-09 {VDD} 1.3000e-08 {VDD} 1.3100e-08 0)
vwc_op0_n100_s0p5_w7p5  wbc_op0_n100_s0p5_w7p5 0 pwl(0 0 5.5000e-09 0 5.6000e-09 {VDD} 1.5000e-08 {VDD} 1.5100e-08 0)
swb_op0_n100_s0p5_w7p5 ref_op0_n100_s0p5_w7p5 wbl_op0_n100_s0p5_w7p5 wbc_op0_n100_s0p5_w7p5 0 swwbl
cwbl_op0_n100_s0p5_w7p5 wbl_op0_n100_s0p5_w7p5 0 {C_WBL}
spa_op0_n100_s0p5_w7p5 prea rbl_op0_n100_s0p5_w7p5 ctl 0 swpre
spr_op0_n100_s0p5_w7p5 pref ref_op0_n100_s0p5_w7p5 ctl 0 swpre
crbl_op0_n100_s0p5_w7p5 rbl_op0_n100_s0p5_w7p5 0 {C_RBL}
cref_op0_n100_s0p5_w7p5 ref_op0_n100_s0p5_w7p5 0 {C_RBL}   $ ASSUMPTION: ideal matched dummy load
XMWR_op0_n100_s0p5_w7p5_0 sn_op0_n100_s0p5_w7p5_0 wwl_op0_n100_s0p5_w7p5 wbl_op0_n100_s0p5_w7p5 0 sky130_fd_pr__nfet_01v8 L=0.15 W=0.42 nf=1 ad=0.1218 as=0.1218 pd=1.42 ps=1.42 nrd=0.69047619047619  nrs=0.69047619047619 sa=0 sb=0 sd=0 mult=1 m=1
XMRD_op0_n100_s0p5_w7p5_0 rbl_op0_n100_s0p5_w7p5 sn_op0_n100_s0p5_w7p5_0 rwls_op0_n100_s0p5_w7p5 0 sky130_fd_pr__nfet_01v8 L=0.15 W=0.42 nf=1 ad=0.1218 as=0.1218 pd=1.42 ps=1.42 nrd=0.69047619047619  nrs=0.69047619047619 sa=0 sb=0 sd=0 mult=1 m=1
csn_op0_n100_s0p5_w7p5_0 sn_op0_n100_s0p5_w7p5_0 0 {C_SN}
XMWR_op0_n100_s0p5_w7p5_1 sn_op0_n100_s0p5_w7p5_1 wwl_des wbl_op0_n100_s0p5_w7p5 0 sky130_fd_pr__nfet_01v8 L=0.15 W=0.42 nf=1 ad=0.1218 as=0.1218 pd=1.42 ps=1.42 nrd=0.69047619047619  nrs=0.69047619047619 sa=0 sb=0 sd=0 mult=1 m=1
XMRD_op0_n100_s0p5_w7p5_1 rbl_op0_n100_s0p5_w7p5 sn_op0_n100_s0p5_w7p5_1 rwl_des 0 sky130_fd_pr__nfet_01v8 L=0.15 W=0.42 nf=1 ad=0.1218 as=0.1218 pd=1.42 ps=1.42 nrd=0.69047619047619  nrs=0.69047619047619 sa=0 sb=0 sd=0 mult=1 m=1
csn_op0_n100_s0p5_w7p5_1 sn_op0_n100_s0p5_w7p5_1 0 {C_SN}
XMWR_op0_n100_s0p5_w7p5_2 sn_op0_n100_s0p5_w7p5_2 wwl_des wbl_op0_n100_s0p5_w7p5 0 sky130_fd_pr__nfet_01v8 L=0.15 W=0.42 nf=1 ad=0.1218 as=0.1218 pd=1.42 ps=1.42 nrd=0.69047619047619  nrs=0.69047619047619 sa=0 sb=0 sd=0 mult=1 m=1
XMRD_op0_n100_s0p5_w7p5_2 rbl_op0_n100_s0p5_w7p5 sn_op0_n100_s0p5_w7p5_2 rwl_des 0 sky130_fd_pr__nfet_01v8 L=0.15 W=0.42 nf=1 ad=0.1218 as=0.1218 pd=1.42 ps=1.42 nrd=0.69047619047619  nrs=0.69047619047619 sa=0 sb=0 sd=0 mult=1 m=1
csn_op0_n100_s0p5_w7p5_2 sn_op0_n100_s0p5_w7p5_2 0 {C_SN}
XMWR_op0_n100_s0p5_w7p5_3 sn_op0_n100_s0p5_w7p5_3 wwl_des wbl_op0_n100_s0p5_w7p5 0 sky130_fd_pr__nfet_01v8 L=0.15 W=0.42 nf=1 ad=0.1218 as=0.1218 pd=1.42 ps=1.42 nrd=0.69047619047619  nrs=0.69047619047619 sa=0 sb=0 sd=0 mult=1 m=1
XMRD_op0_n100_s0p5_w7p5_3 rbl_op0_n100_s0p5_w7p5 sn_op0_n100_s0p5_w7p5_3 rwl_des 0 sky130_fd_pr__nfet_01v8 L=0.15 W=0.42 nf=1 ad=0.1218 as=0.1218 pd=1.42 ps=1.42 nrd=0.69047619047619  nrs=0.69047619047619 sa=0 sb=0 sd=0 mult=1 m=1
csn_op0_n100_s0p5_w7p5_3 sn_op0_n100_s0p5_w7p5_3 0 {C_SN}
XMN1_op0_n100_s0p5_w7p5 rbl_op0_n100_s0p5_w7p5 ref_op0_n100_s0p5_w7p5 vn_op0_n100_s0p5_w7p5 0 sky130_fd_pr__nfet_01v8 L=0.15 W=1 nf=1 ad=0.29 as=0.29 pd=2.58 ps=2.58 mult=1 m=1
XMN2_op0_n100_s0p5_w7p5 ref_op0_n100_s0p5_w7p5 rbl_op0_n100_s0p5_w7p5 vn_op0_n100_s0p5_w7p5 0 sky130_fd_pr__nfet_01v8 L=0.15 W=1 nf=1 ad=0.29 as=0.29 pd=2.58 ps=2.58 mult=1 m=1
XMP1_op0_n100_s0p5_w7p5 rbl_op0_n100_s0p5_w7p5 ref_op0_n100_s0p5_w7p5 vp_op0_n100_s0p5_w7p5 vdd sky130_fd_pr__pfet_01v8 L=0.15 W=2 nf=1 ad=0.58 as=0.58 pd=4.58 ps=4.58 mult=1 m=1
XMP2_op0_n100_s0p5_w7p5 ref_op0_n100_s0p5_w7p5 rbl_op0_n100_s0p5_w7p5 vp_op0_n100_s0p5_w7p5 vdd sky130_fd_pr__pfet_01v8 L=0.15 W=2 nf=1 ad=0.58 as=0.58 pd=4.58 ps=4.58 mult=1 m=1
XMNF_op0_n100_s0p5_w7p5 vn_op0_n100_s0p5_w7p5 en_op0_n100_s0p5_w7p5 0 0 sky130_fd_pr__nfet_01v8 L=0.15 W=2 nf=1 ad=0.58 as=0.58 pd=4.58 ps=4.58 mult=1 m=1
XMPH_op0_n100_s0p5_w7p5 vp_op0_n100_s0p5_w7p5 enb_op0_n100_s0p5_w7p5 vdd vdd sky130_fd_pr__pfet_01v8 L=0.15 W=4 nf=1 ad=1.16 as=1.16 pd=8.58 ps=8.58 mult=1 m=1
bd_op0_n100_s0p5_w7p5 d_op0_n100_s0p5_w7p5 0 v=v(rbl_op0_n100_s0p5_w7p5)-v(ref_op0_n100_s0p5_w7p5)

* ---- instance 127: op0_n100_s0p5_w10 (t_en 4.5 ns, WWL 5.5..15.5 ns, release 17.5 ns) ----
ven_op0_n100_s0p5_w10  en_op0_n100_s0p5_w10  0 pwl(0 0 4.5000e-09 0 4.6000e-09 {VDD} 1.7500e-08 {VDD} 1.7600e-08 0)
venb_op0_n100_s0p5_w10 enb_op0_n100_s0p5_w10 0 pwl(0 {VDD} 4.5000e-09 {VDD} 4.6000e-09 0 1.7500e-08 0 1.7600e-08 {VDD})
vrs_op0_n100_s0p5_w10  rwls_op0_n100_s0p5_w10 0 pwl(0 {VDD} {T_READ} {VDD} {T_READ+TEDGE} 0 1.7500e-08 0 1.7600e-08 {VDD})
vww_op0_n100_s0p5_w10  wwl_op0_n100_s0p5_w10 0 pwl(0 0 5.5000e-09 0 5.6000e-09 {VDD} 1.5500e-08 {VDD} 1.5600e-08 0)
vwc_op0_n100_s0p5_w10  wbc_op0_n100_s0p5_w10 0 pwl(0 0 5.5000e-09 0 5.6000e-09 {VDD} 1.7500e-08 {VDD} 1.7600e-08 0)
swb_op0_n100_s0p5_w10 ref_op0_n100_s0p5_w10 wbl_op0_n100_s0p5_w10 wbc_op0_n100_s0p5_w10 0 swwbl
cwbl_op0_n100_s0p5_w10 wbl_op0_n100_s0p5_w10 0 {C_WBL}
spa_op0_n100_s0p5_w10 prea rbl_op0_n100_s0p5_w10 ctl 0 swpre
spr_op0_n100_s0p5_w10 pref ref_op0_n100_s0p5_w10 ctl 0 swpre
crbl_op0_n100_s0p5_w10 rbl_op0_n100_s0p5_w10 0 {C_RBL}
cref_op0_n100_s0p5_w10 ref_op0_n100_s0p5_w10 0 {C_RBL}   $ ASSUMPTION: ideal matched dummy load
XMWR_op0_n100_s0p5_w10_0 sn_op0_n100_s0p5_w10_0 wwl_op0_n100_s0p5_w10 wbl_op0_n100_s0p5_w10 0 sky130_fd_pr__nfet_01v8 L=0.15 W=0.42 nf=1 ad=0.1218 as=0.1218 pd=1.42 ps=1.42 nrd=0.69047619047619  nrs=0.69047619047619 sa=0 sb=0 sd=0 mult=1 m=1
XMRD_op0_n100_s0p5_w10_0 rbl_op0_n100_s0p5_w10 sn_op0_n100_s0p5_w10_0 rwls_op0_n100_s0p5_w10 0 sky130_fd_pr__nfet_01v8 L=0.15 W=0.42 nf=1 ad=0.1218 as=0.1218 pd=1.42 ps=1.42 nrd=0.69047619047619  nrs=0.69047619047619 sa=0 sb=0 sd=0 mult=1 m=1
csn_op0_n100_s0p5_w10_0 sn_op0_n100_s0p5_w10_0 0 {C_SN}
XMWR_op0_n100_s0p5_w10_1 sn_op0_n100_s0p5_w10_1 wwl_des wbl_op0_n100_s0p5_w10 0 sky130_fd_pr__nfet_01v8 L=0.15 W=0.42 nf=1 ad=0.1218 as=0.1218 pd=1.42 ps=1.42 nrd=0.69047619047619  nrs=0.69047619047619 sa=0 sb=0 sd=0 mult=1 m=1
XMRD_op0_n100_s0p5_w10_1 rbl_op0_n100_s0p5_w10 sn_op0_n100_s0p5_w10_1 rwl_des 0 sky130_fd_pr__nfet_01v8 L=0.15 W=0.42 nf=1 ad=0.1218 as=0.1218 pd=1.42 ps=1.42 nrd=0.69047619047619  nrs=0.69047619047619 sa=0 sb=0 sd=0 mult=1 m=1
csn_op0_n100_s0p5_w10_1 sn_op0_n100_s0p5_w10_1 0 {C_SN}
XMWR_op0_n100_s0p5_w10_2 sn_op0_n100_s0p5_w10_2 wwl_des wbl_op0_n100_s0p5_w10 0 sky130_fd_pr__nfet_01v8 L=0.15 W=0.42 nf=1 ad=0.1218 as=0.1218 pd=1.42 ps=1.42 nrd=0.69047619047619  nrs=0.69047619047619 sa=0 sb=0 sd=0 mult=1 m=1
XMRD_op0_n100_s0p5_w10_2 rbl_op0_n100_s0p5_w10 sn_op0_n100_s0p5_w10_2 rwl_des 0 sky130_fd_pr__nfet_01v8 L=0.15 W=0.42 nf=1 ad=0.1218 as=0.1218 pd=1.42 ps=1.42 nrd=0.69047619047619  nrs=0.69047619047619 sa=0 sb=0 sd=0 mult=1 m=1
csn_op0_n100_s0p5_w10_2 sn_op0_n100_s0p5_w10_2 0 {C_SN}
XMWR_op0_n100_s0p5_w10_3 sn_op0_n100_s0p5_w10_3 wwl_des wbl_op0_n100_s0p5_w10 0 sky130_fd_pr__nfet_01v8 L=0.15 W=0.42 nf=1 ad=0.1218 as=0.1218 pd=1.42 ps=1.42 nrd=0.69047619047619  nrs=0.69047619047619 sa=0 sb=0 sd=0 mult=1 m=1
XMRD_op0_n100_s0p5_w10_3 rbl_op0_n100_s0p5_w10 sn_op0_n100_s0p5_w10_3 rwl_des 0 sky130_fd_pr__nfet_01v8 L=0.15 W=0.42 nf=1 ad=0.1218 as=0.1218 pd=1.42 ps=1.42 nrd=0.69047619047619  nrs=0.69047619047619 sa=0 sb=0 sd=0 mult=1 m=1
csn_op0_n100_s0p5_w10_3 sn_op0_n100_s0p5_w10_3 0 {C_SN}
XMN1_op0_n100_s0p5_w10 rbl_op0_n100_s0p5_w10 ref_op0_n100_s0p5_w10 vn_op0_n100_s0p5_w10 0 sky130_fd_pr__nfet_01v8 L=0.15 W=1 nf=1 ad=0.29 as=0.29 pd=2.58 ps=2.58 mult=1 m=1
XMN2_op0_n100_s0p5_w10 ref_op0_n100_s0p5_w10 rbl_op0_n100_s0p5_w10 vn_op0_n100_s0p5_w10 0 sky130_fd_pr__nfet_01v8 L=0.15 W=1 nf=1 ad=0.29 as=0.29 pd=2.58 ps=2.58 mult=1 m=1
XMP1_op0_n100_s0p5_w10 rbl_op0_n100_s0p5_w10 ref_op0_n100_s0p5_w10 vp_op0_n100_s0p5_w10 vdd sky130_fd_pr__pfet_01v8 L=0.15 W=2 nf=1 ad=0.58 as=0.58 pd=4.58 ps=4.58 mult=1 m=1
XMP2_op0_n100_s0p5_w10 ref_op0_n100_s0p5_w10 rbl_op0_n100_s0p5_w10 vp_op0_n100_s0p5_w10 vdd sky130_fd_pr__pfet_01v8 L=0.15 W=2 nf=1 ad=0.58 as=0.58 pd=4.58 ps=4.58 mult=1 m=1
XMNF_op0_n100_s0p5_w10 vn_op0_n100_s0p5_w10 en_op0_n100_s0p5_w10 0 0 sky130_fd_pr__nfet_01v8 L=0.15 W=2 nf=1 ad=0.58 as=0.58 pd=4.58 ps=4.58 mult=1 m=1
XMPH_op0_n100_s0p5_w10 vp_op0_n100_s0p5_w10 enb_op0_n100_s0p5_w10 vdd vdd sky130_fd_pr__pfet_01v8 L=0.15 W=4 nf=1 ad=1.16 as=1.16 pd=8.58 ps=8.58 mult=1 m=1
bd_op0_n100_s0p5_w10 d_op0_n100_s0p5_w10 0 v=v(rbl_op0_n100_s0p5_w10)-v(ref_op0_n100_s0p5_w10)

* ---- instance 128: op0_n100_s0p5_w15 (t_en 4.5 ns, WWL 5.5..20.5 ns, release 22.5 ns) ----
ven_op0_n100_s0p5_w15  en_op0_n100_s0p5_w15  0 pwl(0 0 4.5000e-09 0 4.6000e-09 {VDD} 2.2500e-08 {VDD} 2.2600e-08 0)
venb_op0_n100_s0p5_w15 enb_op0_n100_s0p5_w15 0 pwl(0 {VDD} 4.5000e-09 {VDD} 4.6000e-09 0 2.2500e-08 0 2.2600e-08 {VDD})
vrs_op0_n100_s0p5_w15  rwls_op0_n100_s0p5_w15 0 pwl(0 {VDD} {T_READ} {VDD} {T_READ+TEDGE} 0 2.2500e-08 0 2.2600e-08 {VDD})
vww_op0_n100_s0p5_w15  wwl_op0_n100_s0p5_w15 0 pwl(0 0 5.5000e-09 0 5.6000e-09 {VDD} 2.0500e-08 {VDD} 2.0600e-08 0)
vwc_op0_n100_s0p5_w15  wbc_op0_n100_s0p5_w15 0 pwl(0 0 5.5000e-09 0 5.6000e-09 {VDD} 2.2500e-08 {VDD} 2.2600e-08 0)
swb_op0_n100_s0p5_w15 ref_op0_n100_s0p5_w15 wbl_op0_n100_s0p5_w15 wbc_op0_n100_s0p5_w15 0 swwbl
cwbl_op0_n100_s0p5_w15 wbl_op0_n100_s0p5_w15 0 {C_WBL}
spa_op0_n100_s0p5_w15 prea rbl_op0_n100_s0p5_w15 ctl 0 swpre
spr_op0_n100_s0p5_w15 pref ref_op0_n100_s0p5_w15 ctl 0 swpre
crbl_op0_n100_s0p5_w15 rbl_op0_n100_s0p5_w15 0 {C_RBL}
cref_op0_n100_s0p5_w15 ref_op0_n100_s0p5_w15 0 {C_RBL}   $ ASSUMPTION: ideal matched dummy load
XMWR_op0_n100_s0p5_w15_0 sn_op0_n100_s0p5_w15_0 wwl_op0_n100_s0p5_w15 wbl_op0_n100_s0p5_w15 0 sky130_fd_pr__nfet_01v8 L=0.15 W=0.42 nf=1 ad=0.1218 as=0.1218 pd=1.42 ps=1.42 nrd=0.69047619047619  nrs=0.69047619047619 sa=0 sb=0 sd=0 mult=1 m=1
XMRD_op0_n100_s0p5_w15_0 rbl_op0_n100_s0p5_w15 sn_op0_n100_s0p5_w15_0 rwls_op0_n100_s0p5_w15 0 sky130_fd_pr__nfet_01v8 L=0.15 W=0.42 nf=1 ad=0.1218 as=0.1218 pd=1.42 ps=1.42 nrd=0.69047619047619  nrs=0.69047619047619 sa=0 sb=0 sd=0 mult=1 m=1
csn_op0_n100_s0p5_w15_0 sn_op0_n100_s0p5_w15_0 0 {C_SN}
XMWR_op0_n100_s0p5_w15_1 sn_op0_n100_s0p5_w15_1 wwl_des wbl_op0_n100_s0p5_w15 0 sky130_fd_pr__nfet_01v8 L=0.15 W=0.42 nf=1 ad=0.1218 as=0.1218 pd=1.42 ps=1.42 nrd=0.69047619047619  nrs=0.69047619047619 sa=0 sb=0 sd=0 mult=1 m=1
XMRD_op0_n100_s0p5_w15_1 rbl_op0_n100_s0p5_w15 sn_op0_n100_s0p5_w15_1 rwl_des 0 sky130_fd_pr__nfet_01v8 L=0.15 W=0.42 nf=1 ad=0.1218 as=0.1218 pd=1.42 ps=1.42 nrd=0.69047619047619  nrs=0.69047619047619 sa=0 sb=0 sd=0 mult=1 m=1
csn_op0_n100_s0p5_w15_1 sn_op0_n100_s0p5_w15_1 0 {C_SN}
XMWR_op0_n100_s0p5_w15_2 sn_op0_n100_s0p5_w15_2 wwl_des wbl_op0_n100_s0p5_w15 0 sky130_fd_pr__nfet_01v8 L=0.15 W=0.42 nf=1 ad=0.1218 as=0.1218 pd=1.42 ps=1.42 nrd=0.69047619047619  nrs=0.69047619047619 sa=0 sb=0 sd=0 mult=1 m=1
XMRD_op0_n100_s0p5_w15_2 rbl_op0_n100_s0p5_w15 sn_op0_n100_s0p5_w15_2 rwl_des 0 sky130_fd_pr__nfet_01v8 L=0.15 W=0.42 nf=1 ad=0.1218 as=0.1218 pd=1.42 ps=1.42 nrd=0.69047619047619  nrs=0.69047619047619 sa=0 sb=0 sd=0 mult=1 m=1
csn_op0_n100_s0p5_w15_2 sn_op0_n100_s0p5_w15_2 0 {C_SN}
XMWR_op0_n100_s0p5_w15_3 sn_op0_n100_s0p5_w15_3 wwl_des wbl_op0_n100_s0p5_w15 0 sky130_fd_pr__nfet_01v8 L=0.15 W=0.42 nf=1 ad=0.1218 as=0.1218 pd=1.42 ps=1.42 nrd=0.69047619047619  nrs=0.69047619047619 sa=0 sb=0 sd=0 mult=1 m=1
XMRD_op0_n100_s0p5_w15_3 rbl_op0_n100_s0p5_w15 sn_op0_n100_s0p5_w15_3 rwl_des 0 sky130_fd_pr__nfet_01v8 L=0.15 W=0.42 nf=1 ad=0.1218 as=0.1218 pd=1.42 ps=1.42 nrd=0.69047619047619  nrs=0.69047619047619 sa=0 sb=0 sd=0 mult=1 m=1
csn_op0_n100_s0p5_w15_3 sn_op0_n100_s0p5_w15_3 0 {C_SN}
XMN1_op0_n100_s0p5_w15 rbl_op0_n100_s0p5_w15 ref_op0_n100_s0p5_w15 vn_op0_n100_s0p5_w15 0 sky130_fd_pr__nfet_01v8 L=0.15 W=1 nf=1 ad=0.29 as=0.29 pd=2.58 ps=2.58 mult=1 m=1
XMN2_op0_n100_s0p5_w15 ref_op0_n100_s0p5_w15 rbl_op0_n100_s0p5_w15 vn_op0_n100_s0p5_w15 0 sky130_fd_pr__nfet_01v8 L=0.15 W=1 nf=1 ad=0.29 as=0.29 pd=2.58 ps=2.58 mult=1 m=1
XMP1_op0_n100_s0p5_w15 rbl_op0_n100_s0p5_w15 ref_op0_n100_s0p5_w15 vp_op0_n100_s0p5_w15 vdd sky130_fd_pr__pfet_01v8 L=0.15 W=2 nf=1 ad=0.58 as=0.58 pd=4.58 ps=4.58 mult=1 m=1
XMP2_op0_n100_s0p5_w15 ref_op0_n100_s0p5_w15 rbl_op0_n100_s0p5_w15 vp_op0_n100_s0p5_w15 vdd sky130_fd_pr__pfet_01v8 L=0.15 W=2 nf=1 ad=0.58 as=0.58 pd=4.58 ps=4.58 mult=1 m=1
XMNF_op0_n100_s0p5_w15 vn_op0_n100_s0p5_w15 en_op0_n100_s0p5_w15 0 0 sky130_fd_pr__nfet_01v8 L=0.15 W=2 nf=1 ad=0.58 as=0.58 pd=4.58 ps=4.58 mult=1 m=1
XMPH_op0_n100_s0p5_w15 vp_op0_n100_s0p5_w15 enb_op0_n100_s0p5_w15 vdd vdd sky130_fd_pr__pfet_01v8 L=0.15 W=4 nf=1 ad=1.16 as=1.16 pd=8.58 ps=8.58 mult=1 m=1
bd_op0_n100_s0p5_w15 d_op0_n100_s0p5_w15 0 v=v(rbl_op0_n100_s0p5_w15)-v(ref_op0_n100_s0p5_w15)

* ---- instance 129: op0_n100_s0p5_w20 (t_en 4.5 ns, WWL 5.5..25.5 ns, release 27.5 ns) ----
ven_op0_n100_s0p5_w20  en_op0_n100_s0p5_w20  0 pwl(0 0 4.5000e-09 0 4.6000e-09 {VDD} 2.7500e-08 {VDD} 2.7600e-08 0)
venb_op0_n100_s0p5_w20 enb_op0_n100_s0p5_w20 0 pwl(0 {VDD} 4.5000e-09 {VDD} 4.6000e-09 0 2.7500e-08 0 2.7600e-08 {VDD})
vrs_op0_n100_s0p5_w20  rwls_op0_n100_s0p5_w20 0 pwl(0 {VDD} {T_READ} {VDD} {T_READ+TEDGE} 0 2.7500e-08 0 2.7600e-08 {VDD})
vww_op0_n100_s0p5_w20  wwl_op0_n100_s0p5_w20 0 pwl(0 0 5.5000e-09 0 5.6000e-09 {VDD} 2.5500e-08 {VDD} 2.5600e-08 0)
vwc_op0_n100_s0p5_w20  wbc_op0_n100_s0p5_w20 0 pwl(0 0 5.5000e-09 0 5.6000e-09 {VDD} 2.7500e-08 {VDD} 2.7600e-08 0)
swb_op0_n100_s0p5_w20 ref_op0_n100_s0p5_w20 wbl_op0_n100_s0p5_w20 wbc_op0_n100_s0p5_w20 0 swwbl
cwbl_op0_n100_s0p5_w20 wbl_op0_n100_s0p5_w20 0 {C_WBL}
spa_op0_n100_s0p5_w20 prea rbl_op0_n100_s0p5_w20 ctl 0 swpre
spr_op0_n100_s0p5_w20 pref ref_op0_n100_s0p5_w20 ctl 0 swpre
crbl_op0_n100_s0p5_w20 rbl_op0_n100_s0p5_w20 0 {C_RBL}
cref_op0_n100_s0p5_w20 ref_op0_n100_s0p5_w20 0 {C_RBL}   $ ASSUMPTION: ideal matched dummy load
XMWR_op0_n100_s0p5_w20_0 sn_op0_n100_s0p5_w20_0 wwl_op0_n100_s0p5_w20 wbl_op0_n100_s0p5_w20 0 sky130_fd_pr__nfet_01v8 L=0.15 W=0.42 nf=1 ad=0.1218 as=0.1218 pd=1.42 ps=1.42 nrd=0.69047619047619  nrs=0.69047619047619 sa=0 sb=0 sd=0 mult=1 m=1
XMRD_op0_n100_s0p5_w20_0 rbl_op0_n100_s0p5_w20 sn_op0_n100_s0p5_w20_0 rwls_op0_n100_s0p5_w20 0 sky130_fd_pr__nfet_01v8 L=0.15 W=0.42 nf=1 ad=0.1218 as=0.1218 pd=1.42 ps=1.42 nrd=0.69047619047619  nrs=0.69047619047619 sa=0 sb=0 sd=0 mult=1 m=1
csn_op0_n100_s0p5_w20_0 sn_op0_n100_s0p5_w20_0 0 {C_SN}
XMWR_op0_n100_s0p5_w20_1 sn_op0_n100_s0p5_w20_1 wwl_des wbl_op0_n100_s0p5_w20 0 sky130_fd_pr__nfet_01v8 L=0.15 W=0.42 nf=1 ad=0.1218 as=0.1218 pd=1.42 ps=1.42 nrd=0.69047619047619  nrs=0.69047619047619 sa=0 sb=0 sd=0 mult=1 m=1
XMRD_op0_n100_s0p5_w20_1 rbl_op0_n100_s0p5_w20 sn_op0_n100_s0p5_w20_1 rwl_des 0 sky130_fd_pr__nfet_01v8 L=0.15 W=0.42 nf=1 ad=0.1218 as=0.1218 pd=1.42 ps=1.42 nrd=0.69047619047619  nrs=0.69047619047619 sa=0 sb=0 sd=0 mult=1 m=1
csn_op0_n100_s0p5_w20_1 sn_op0_n100_s0p5_w20_1 0 {C_SN}
XMWR_op0_n100_s0p5_w20_2 sn_op0_n100_s0p5_w20_2 wwl_des wbl_op0_n100_s0p5_w20 0 sky130_fd_pr__nfet_01v8 L=0.15 W=0.42 nf=1 ad=0.1218 as=0.1218 pd=1.42 ps=1.42 nrd=0.69047619047619  nrs=0.69047619047619 sa=0 sb=0 sd=0 mult=1 m=1
XMRD_op0_n100_s0p5_w20_2 rbl_op0_n100_s0p5_w20 sn_op0_n100_s0p5_w20_2 rwl_des 0 sky130_fd_pr__nfet_01v8 L=0.15 W=0.42 nf=1 ad=0.1218 as=0.1218 pd=1.42 ps=1.42 nrd=0.69047619047619  nrs=0.69047619047619 sa=0 sb=0 sd=0 mult=1 m=1
csn_op0_n100_s0p5_w20_2 sn_op0_n100_s0p5_w20_2 0 {C_SN}
XMWR_op0_n100_s0p5_w20_3 sn_op0_n100_s0p5_w20_3 wwl_des wbl_op0_n100_s0p5_w20 0 sky130_fd_pr__nfet_01v8 L=0.15 W=0.42 nf=1 ad=0.1218 as=0.1218 pd=1.42 ps=1.42 nrd=0.69047619047619  nrs=0.69047619047619 sa=0 sb=0 sd=0 mult=1 m=1
XMRD_op0_n100_s0p5_w20_3 rbl_op0_n100_s0p5_w20 sn_op0_n100_s0p5_w20_3 rwl_des 0 sky130_fd_pr__nfet_01v8 L=0.15 W=0.42 nf=1 ad=0.1218 as=0.1218 pd=1.42 ps=1.42 nrd=0.69047619047619  nrs=0.69047619047619 sa=0 sb=0 sd=0 mult=1 m=1
csn_op0_n100_s0p5_w20_3 sn_op0_n100_s0p5_w20_3 0 {C_SN}
XMN1_op0_n100_s0p5_w20 rbl_op0_n100_s0p5_w20 ref_op0_n100_s0p5_w20 vn_op0_n100_s0p5_w20 0 sky130_fd_pr__nfet_01v8 L=0.15 W=1 nf=1 ad=0.29 as=0.29 pd=2.58 ps=2.58 mult=1 m=1
XMN2_op0_n100_s0p5_w20 ref_op0_n100_s0p5_w20 rbl_op0_n100_s0p5_w20 vn_op0_n100_s0p5_w20 0 sky130_fd_pr__nfet_01v8 L=0.15 W=1 nf=1 ad=0.29 as=0.29 pd=2.58 ps=2.58 mult=1 m=1
XMP1_op0_n100_s0p5_w20 rbl_op0_n100_s0p5_w20 ref_op0_n100_s0p5_w20 vp_op0_n100_s0p5_w20 vdd sky130_fd_pr__pfet_01v8 L=0.15 W=2 nf=1 ad=0.58 as=0.58 pd=4.58 ps=4.58 mult=1 m=1
XMP2_op0_n100_s0p5_w20 ref_op0_n100_s0p5_w20 rbl_op0_n100_s0p5_w20 vp_op0_n100_s0p5_w20 vdd sky130_fd_pr__pfet_01v8 L=0.15 W=2 nf=1 ad=0.58 as=0.58 pd=4.58 ps=4.58 mult=1 m=1
XMNF_op0_n100_s0p5_w20 vn_op0_n100_s0p5_w20 en_op0_n100_s0p5_w20 0 0 sky130_fd_pr__nfet_01v8 L=0.15 W=2 nf=1 ad=0.58 as=0.58 pd=4.58 ps=4.58 mult=1 m=1
XMPH_op0_n100_s0p5_w20 vp_op0_n100_s0p5_w20 enb_op0_n100_s0p5_w20 vdd vdd sky130_fd_pr__pfet_01v8 L=0.15 W=4 nf=1 ad=1.16 as=1.16 pd=8.58 ps=8.58 mult=1 m=1
bd_op0_n100_s0p5_w20 d_op0_n100_s0p5_w20 0 v=v(rbl_op0_n100_s0p5_w20)-v(ref_op0_n100_s0p5_w20)

* ---- instance 130: op0_n100_s0p5_w30 (t_en 4.5 ns, WWL 5.5..35.5 ns, release 37.5 ns) ----
ven_op0_n100_s0p5_w30  en_op0_n100_s0p5_w30  0 pwl(0 0 4.5000e-09 0 4.6000e-09 {VDD} 3.7500e-08 {VDD} 3.7600e-08 0)
venb_op0_n100_s0p5_w30 enb_op0_n100_s0p5_w30 0 pwl(0 {VDD} 4.5000e-09 {VDD} 4.6000e-09 0 3.7500e-08 0 3.7600e-08 {VDD})
vrs_op0_n100_s0p5_w30  rwls_op0_n100_s0p5_w30 0 pwl(0 {VDD} {T_READ} {VDD} {T_READ+TEDGE} 0 3.7500e-08 0 3.7600e-08 {VDD})
vww_op0_n100_s0p5_w30  wwl_op0_n100_s0p5_w30 0 pwl(0 0 5.5000e-09 0 5.6000e-09 {VDD} 3.5500e-08 {VDD} 3.5600e-08 0)
vwc_op0_n100_s0p5_w30  wbc_op0_n100_s0p5_w30 0 pwl(0 0 5.5000e-09 0 5.6000e-09 {VDD} 3.7500e-08 {VDD} 3.7600e-08 0)
swb_op0_n100_s0p5_w30 ref_op0_n100_s0p5_w30 wbl_op0_n100_s0p5_w30 wbc_op0_n100_s0p5_w30 0 swwbl
cwbl_op0_n100_s0p5_w30 wbl_op0_n100_s0p5_w30 0 {C_WBL}
spa_op0_n100_s0p5_w30 prea rbl_op0_n100_s0p5_w30 ctl 0 swpre
spr_op0_n100_s0p5_w30 pref ref_op0_n100_s0p5_w30 ctl 0 swpre
crbl_op0_n100_s0p5_w30 rbl_op0_n100_s0p5_w30 0 {C_RBL}
cref_op0_n100_s0p5_w30 ref_op0_n100_s0p5_w30 0 {C_RBL}   $ ASSUMPTION: ideal matched dummy load
XMWR_op0_n100_s0p5_w30_0 sn_op0_n100_s0p5_w30_0 wwl_op0_n100_s0p5_w30 wbl_op0_n100_s0p5_w30 0 sky130_fd_pr__nfet_01v8 L=0.15 W=0.42 nf=1 ad=0.1218 as=0.1218 pd=1.42 ps=1.42 nrd=0.69047619047619  nrs=0.69047619047619 sa=0 sb=0 sd=0 mult=1 m=1
XMRD_op0_n100_s0p5_w30_0 rbl_op0_n100_s0p5_w30 sn_op0_n100_s0p5_w30_0 rwls_op0_n100_s0p5_w30 0 sky130_fd_pr__nfet_01v8 L=0.15 W=0.42 nf=1 ad=0.1218 as=0.1218 pd=1.42 ps=1.42 nrd=0.69047619047619  nrs=0.69047619047619 sa=0 sb=0 sd=0 mult=1 m=1
csn_op0_n100_s0p5_w30_0 sn_op0_n100_s0p5_w30_0 0 {C_SN}
XMWR_op0_n100_s0p5_w30_1 sn_op0_n100_s0p5_w30_1 wwl_des wbl_op0_n100_s0p5_w30 0 sky130_fd_pr__nfet_01v8 L=0.15 W=0.42 nf=1 ad=0.1218 as=0.1218 pd=1.42 ps=1.42 nrd=0.69047619047619  nrs=0.69047619047619 sa=0 sb=0 sd=0 mult=1 m=1
XMRD_op0_n100_s0p5_w30_1 rbl_op0_n100_s0p5_w30 sn_op0_n100_s0p5_w30_1 rwl_des 0 sky130_fd_pr__nfet_01v8 L=0.15 W=0.42 nf=1 ad=0.1218 as=0.1218 pd=1.42 ps=1.42 nrd=0.69047619047619  nrs=0.69047619047619 sa=0 sb=0 sd=0 mult=1 m=1
csn_op0_n100_s0p5_w30_1 sn_op0_n100_s0p5_w30_1 0 {C_SN}
XMWR_op0_n100_s0p5_w30_2 sn_op0_n100_s0p5_w30_2 wwl_des wbl_op0_n100_s0p5_w30 0 sky130_fd_pr__nfet_01v8 L=0.15 W=0.42 nf=1 ad=0.1218 as=0.1218 pd=1.42 ps=1.42 nrd=0.69047619047619  nrs=0.69047619047619 sa=0 sb=0 sd=0 mult=1 m=1
XMRD_op0_n100_s0p5_w30_2 rbl_op0_n100_s0p5_w30 sn_op0_n100_s0p5_w30_2 rwl_des 0 sky130_fd_pr__nfet_01v8 L=0.15 W=0.42 nf=1 ad=0.1218 as=0.1218 pd=1.42 ps=1.42 nrd=0.69047619047619  nrs=0.69047619047619 sa=0 sb=0 sd=0 mult=1 m=1
csn_op0_n100_s0p5_w30_2 sn_op0_n100_s0p5_w30_2 0 {C_SN}
XMWR_op0_n100_s0p5_w30_3 sn_op0_n100_s0p5_w30_3 wwl_des wbl_op0_n100_s0p5_w30 0 sky130_fd_pr__nfet_01v8 L=0.15 W=0.42 nf=1 ad=0.1218 as=0.1218 pd=1.42 ps=1.42 nrd=0.69047619047619  nrs=0.69047619047619 sa=0 sb=0 sd=0 mult=1 m=1
XMRD_op0_n100_s0p5_w30_3 rbl_op0_n100_s0p5_w30 sn_op0_n100_s0p5_w30_3 rwl_des 0 sky130_fd_pr__nfet_01v8 L=0.15 W=0.42 nf=1 ad=0.1218 as=0.1218 pd=1.42 ps=1.42 nrd=0.69047619047619  nrs=0.69047619047619 sa=0 sb=0 sd=0 mult=1 m=1
csn_op0_n100_s0p5_w30_3 sn_op0_n100_s0p5_w30_3 0 {C_SN}
XMN1_op0_n100_s0p5_w30 rbl_op0_n100_s0p5_w30 ref_op0_n100_s0p5_w30 vn_op0_n100_s0p5_w30 0 sky130_fd_pr__nfet_01v8 L=0.15 W=1 nf=1 ad=0.29 as=0.29 pd=2.58 ps=2.58 mult=1 m=1
XMN2_op0_n100_s0p5_w30 ref_op0_n100_s0p5_w30 rbl_op0_n100_s0p5_w30 vn_op0_n100_s0p5_w30 0 sky130_fd_pr__nfet_01v8 L=0.15 W=1 nf=1 ad=0.29 as=0.29 pd=2.58 ps=2.58 mult=1 m=1
XMP1_op0_n100_s0p5_w30 rbl_op0_n100_s0p5_w30 ref_op0_n100_s0p5_w30 vp_op0_n100_s0p5_w30 vdd sky130_fd_pr__pfet_01v8 L=0.15 W=2 nf=1 ad=0.58 as=0.58 pd=4.58 ps=4.58 mult=1 m=1
XMP2_op0_n100_s0p5_w30 ref_op0_n100_s0p5_w30 rbl_op0_n100_s0p5_w30 vp_op0_n100_s0p5_w30 vdd sky130_fd_pr__pfet_01v8 L=0.15 W=2 nf=1 ad=0.58 as=0.58 pd=4.58 ps=4.58 mult=1 m=1
XMNF_op0_n100_s0p5_w30 vn_op0_n100_s0p5_w30 en_op0_n100_s0p5_w30 0 0 sky130_fd_pr__nfet_01v8 L=0.15 W=2 nf=1 ad=0.58 as=0.58 pd=4.58 ps=4.58 mult=1 m=1
XMPH_op0_n100_s0p5_w30 vp_op0_n100_s0p5_w30 enb_op0_n100_s0p5_w30 vdd vdd sky130_fd_pr__pfet_01v8 L=0.15 W=4 nf=1 ad=1.16 as=1.16 pd=8.58 ps=8.58 mult=1 m=1
bd_op0_n100_s0p5_w30 d_op0_n100_s0p5_w30 0 v=v(rbl_op0_n100_s0p5_w30)-v(ref_op0_n100_s0p5_w30)

* ---- instance 131: op0_n100_s0p5_w50 (t_en 4.5 ns, WWL 5.5..55.5 ns, release 57.5 ns) ----
ven_op0_n100_s0p5_w50  en_op0_n100_s0p5_w50  0 pwl(0 0 4.5000e-09 0 4.6000e-09 {VDD} 5.7500e-08 {VDD} 5.7600e-08 0)
venb_op0_n100_s0p5_w50 enb_op0_n100_s0p5_w50 0 pwl(0 {VDD} 4.5000e-09 {VDD} 4.6000e-09 0 5.7500e-08 0 5.7600e-08 {VDD})
vrs_op0_n100_s0p5_w50  rwls_op0_n100_s0p5_w50 0 pwl(0 {VDD} {T_READ} {VDD} {T_READ+TEDGE} 0 5.7500e-08 0 5.7600e-08 {VDD})
vww_op0_n100_s0p5_w50  wwl_op0_n100_s0p5_w50 0 pwl(0 0 5.5000e-09 0 5.6000e-09 {VDD} 5.5500e-08 {VDD} 5.5600e-08 0)
vwc_op0_n100_s0p5_w50  wbc_op0_n100_s0p5_w50 0 pwl(0 0 5.5000e-09 0 5.6000e-09 {VDD} 5.7500e-08 {VDD} 5.7600e-08 0)
swb_op0_n100_s0p5_w50 ref_op0_n100_s0p5_w50 wbl_op0_n100_s0p5_w50 wbc_op0_n100_s0p5_w50 0 swwbl
cwbl_op0_n100_s0p5_w50 wbl_op0_n100_s0p5_w50 0 {C_WBL}
spa_op0_n100_s0p5_w50 prea rbl_op0_n100_s0p5_w50 ctl 0 swpre
spr_op0_n100_s0p5_w50 pref ref_op0_n100_s0p5_w50 ctl 0 swpre
crbl_op0_n100_s0p5_w50 rbl_op0_n100_s0p5_w50 0 {C_RBL}
cref_op0_n100_s0p5_w50 ref_op0_n100_s0p5_w50 0 {C_RBL}   $ ASSUMPTION: ideal matched dummy load
XMWR_op0_n100_s0p5_w50_0 sn_op0_n100_s0p5_w50_0 wwl_op0_n100_s0p5_w50 wbl_op0_n100_s0p5_w50 0 sky130_fd_pr__nfet_01v8 L=0.15 W=0.42 nf=1 ad=0.1218 as=0.1218 pd=1.42 ps=1.42 nrd=0.69047619047619  nrs=0.69047619047619 sa=0 sb=0 sd=0 mult=1 m=1
XMRD_op0_n100_s0p5_w50_0 rbl_op0_n100_s0p5_w50 sn_op0_n100_s0p5_w50_0 rwls_op0_n100_s0p5_w50 0 sky130_fd_pr__nfet_01v8 L=0.15 W=0.42 nf=1 ad=0.1218 as=0.1218 pd=1.42 ps=1.42 nrd=0.69047619047619  nrs=0.69047619047619 sa=0 sb=0 sd=0 mult=1 m=1
csn_op0_n100_s0p5_w50_0 sn_op0_n100_s0p5_w50_0 0 {C_SN}
XMWR_op0_n100_s0p5_w50_1 sn_op0_n100_s0p5_w50_1 wwl_des wbl_op0_n100_s0p5_w50 0 sky130_fd_pr__nfet_01v8 L=0.15 W=0.42 nf=1 ad=0.1218 as=0.1218 pd=1.42 ps=1.42 nrd=0.69047619047619  nrs=0.69047619047619 sa=0 sb=0 sd=0 mult=1 m=1
XMRD_op0_n100_s0p5_w50_1 rbl_op0_n100_s0p5_w50 sn_op0_n100_s0p5_w50_1 rwl_des 0 sky130_fd_pr__nfet_01v8 L=0.15 W=0.42 nf=1 ad=0.1218 as=0.1218 pd=1.42 ps=1.42 nrd=0.69047619047619  nrs=0.69047619047619 sa=0 sb=0 sd=0 mult=1 m=1
csn_op0_n100_s0p5_w50_1 sn_op0_n100_s0p5_w50_1 0 {C_SN}
XMWR_op0_n100_s0p5_w50_2 sn_op0_n100_s0p5_w50_2 wwl_des wbl_op0_n100_s0p5_w50 0 sky130_fd_pr__nfet_01v8 L=0.15 W=0.42 nf=1 ad=0.1218 as=0.1218 pd=1.42 ps=1.42 nrd=0.69047619047619  nrs=0.69047619047619 sa=0 sb=0 sd=0 mult=1 m=1
XMRD_op0_n100_s0p5_w50_2 rbl_op0_n100_s0p5_w50 sn_op0_n100_s0p5_w50_2 rwl_des 0 sky130_fd_pr__nfet_01v8 L=0.15 W=0.42 nf=1 ad=0.1218 as=0.1218 pd=1.42 ps=1.42 nrd=0.69047619047619  nrs=0.69047619047619 sa=0 sb=0 sd=0 mult=1 m=1
csn_op0_n100_s0p5_w50_2 sn_op0_n100_s0p5_w50_2 0 {C_SN}
XMWR_op0_n100_s0p5_w50_3 sn_op0_n100_s0p5_w50_3 wwl_des wbl_op0_n100_s0p5_w50 0 sky130_fd_pr__nfet_01v8 L=0.15 W=0.42 nf=1 ad=0.1218 as=0.1218 pd=1.42 ps=1.42 nrd=0.69047619047619  nrs=0.69047619047619 sa=0 sb=0 sd=0 mult=1 m=1
XMRD_op0_n100_s0p5_w50_3 rbl_op0_n100_s0p5_w50 sn_op0_n100_s0p5_w50_3 rwl_des 0 sky130_fd_pr__nfet_01v8 L=0.15 W=0.42 nf=1 ad=0.1218 as=0.1218 pd=1.42 ps=1.42 nrd=0.69047619047619  nrs=0.69047619047619 sa=0 sb=0 sd=0 mult=1 m=1
csn_op0_n100_s0p5_w50_3 sn_op0_n100_s0p5_w50_3 0 {C_SN}
XMN1_op0_n100_s0p5_w50 rbl_op0_n100_s0p5_w50 ref_op0_n100_s0p5_w50 vn_op0_n100_s0p5_w50 0 sky130_fd_pr__nfet_01v8 L=0.15 W=1 nf=1 ad=0.29 as=0.29 pd=2.58 ps=2.58 mult=1 m=1
XMN2_op0_n100_s0p5_w50 ref_op0_n100_s0p5_w50 rbl_op0_n100_s0p5_w50 vn_op0_n100_s0p5_w50 0 sky130_fd_pr__nfet_01v8 L=0.15 W=1 nf=1 ad=0.29 as=0.29 pd=2.58 ps=2.58 mult=1 m=1
XMP1_op0_n100_s0p5_w50 rbl_op0_n100_s0p5_w50 ref_op0_n100_s0p5_w50 vp_op0_n100_s0p5_w50 vdd sky130_fd_pr__pfet_01v8 L=0.15 W=2 nf=1 ad=0.58 as=0.58 pd=4.58 ps=4.58 mult=1 m=1
XMP2_op0_n100_s0p5_w50 ref_op0_n100_s0p5_w50 rbl_op0_n100_s0p5_w50 vp_op0_n100_s0p5_w50 vdd sky130_fd_pr__pfet_01v8 L=0.15 W=2 nf=1 ad=0.58 as=0.58 pd=4.58 ps=4.58 mult=1 m=1
XMNF_op0_n100_s0p5_w50 vn_op0_n100_s0p5_w50 en_op0_n100_s0p5_w50 0 0 sky130_fd_pr__nfet_01v8 L=0.15 W=2 nf=1 ad=0.58 as=0.58 pd=4.58 ps=4.58 mult=1 m=1
XMPH_op0_n100_s0p5_w50 vp_op0_n100_s0p5_w50 enb_op0_n100_s0p5_w50 vdd vdd sky130_fd_pr__pfet_01v8 L=0.15 W=4 nf=1 ad=1.16 as=1.16 pd=8.58 ps=8.58 mult=1 m=1
bd_op0_n100_s0p5_w50 d_op0_n100_s0p5_w50 0 v=v(rbl_op0_n100_s0p5_w50)-v(ref_op0_n100_s0p5_w50)

* ---- instance 132: op0_n100_s1_w0p2 (t_en 5 ns, WWL 6..6.2 ns, release 8.2 ns) ----
ven_op0_n100_s1_w0p2  en_op0_n100_s1_w0p2  0 pwl(0 0 5.0000e-09 0 5.1000e-09 {VDD} 8.2000e-09 {VDD} 8.3000e-09 0)
venb_op0_n100_s1_w0p2 enb_op0_n100_s1_w0p2 0 pwl(0 {VDD} 5.0000e-09 {VDD} 5.1000e-09 0 8.2000e-09 0 8.3000e-09 {VDD})
vrs_op0_n100_s1_w0p2  rwls_op0_n100_s1_w0p2 0 pwl(0 {VDD} {T_READ} {VDD} {T_READ+TEDGE} 0 8.2000e-09 0 8.3000e-09 {VDD})
vww_op0_n100_s1_w0p2  wwl_op0_n100_s1_w0p2 0 pwl(0 0 6.0000e-09 0 6.1000e-09 {VDD} 6.2000e-09 {VDD} 6.3000e-09 0)
vwc_op0_n100_s1_w0p2  wbc_op0_n100_s1_w0p2 0 pwl(0 0 6.0000e-09 0 6.1000e-09 {VDD} 8.2000e-09 {VDD} 8.3000e-09 0)
swb_op0_n100_s1_w0p2 ref_op0_n100_s1_w0p2 wbl_op0_n100_s1_w0p2 wbc_op0_n100_s1_w0p2 0 swwbl
cwbl_op0_n100_s1_w0p2 wbl_op0_n100_s1_w0p2 0 {C_WBL}
spa_op0_n100_s1_w0p2 prea rbl_op0_n100_s1_w0p2 ctl 0 swpre
spr_op0_n100_s1_w0p2 pref ref_op0_n100_s1_w0p2 ctl 0 swpre
crbl_op0_n100_s1_w0p2 rbl_op0_n100_s1_w0p2 0 {C_RBL}
cref_op0_n100_s1_w0p2 ref_op0_n100_s1_w0p2 0 {C_RBL}   $ ASSUMPTION: ideal matched dummy load
XMWR_op0_n100_s1_w0p2_0 sn_op0_n100_s1_w0p2_0 wwl_op0_n100_s1_w0p2 wbl_op0_n100_s1_w0p2 0 sky130_fd_pr__nfet_01v8 L=0.15 W=0.42 nf=1 ad=0.1218 as=0.1218 pd=1.42 ps=1.42 nrd=0.69047619047619  nrs=0.69047619047619 sa=0 sb=0 sd=0 mult=1 m=1
XMRD_op0_n100_s1_w0p2_0 rbl_op0_n100_s1_w0p2 sn_op0_n100_s1_w0p2_0 rwls_op0_n100_s1_w0p2 0 sky130_fd_pr__nfet_01v8 L=0.15 W=0.42 nf=1 ad=0.1218 as=0.1218 pd=1.42 ps=1.42 nrd=0.69047619047619  nrs=0.69047619047619 sa=0 sb=0 sd=0 mult=1 m=1
csn_op0_n100_s1_w0p2_0 sn_op0_n100_s1_w0p2_0 0 {C_SN}
XMWR_op0_n100_s1_w0p2_1 sn_op0_n100_s1_w0p2_1 wwl_des wbl_op0_n100_s1_w0p2 0 sky130_fd_pr__nfet_01v8 L=0.15 W=0.42 nf=1 ad=0.1218 as=0.1218 pd=1.42 ps=1.42 nrd=0.69047619047619  nrs=0.69047619047619 sa=0 sb=0 sd=0 mult=1 m=1
XMRD_op0_n100_s1_w0p2_1 rbl_op0_n100_s1_w0p2 sn_op0_n100_s1_w0p2_1 rwl_des 0 sky130_fd_pr__nfet_01v8 L=0.15 W=0.42 nf=1 ad=0.1218 as=0.1218 pd=1.42 ps=1.42 nrd=0.69047619047619  nrs=0.69047619047619 sa=0 sb=0 sd=0 mult=1 m=1
csn_op0_n100_s1_w0p2_1 sn_op0_n100_s1_w0p2_1 0 {C_SN}
XMWR_op0_n100_s1_w0p2_2 sn_op0_n100_s1_w0p2_2 wwl_des wbl_op0_n100_s1_w0p2 0 sky130_fd_pr__nfet_01v8 L=0.15 W=0.42 nf=1 ad=0.1218 as=0.1218 pd=1.42 ps=1.42 nrd=0.69047619047619  nrs=0.69047619047619 sa=0 sb=0 sd=0 mult=1 m=1
XMRD_op0_n100_s1_w0p2_2 rbl_op0_n100_s1_w0p2 sn_op0_n100_s1_w0p2_2 rwl_des 0 sky130_fd_pr__nfet_01v8 L=0.15 W=0.42 nf=1 ad=0.1218 as=0.1218 pd=1.42 ps=1.42 nrd=0.69047619047619  nrs=0.69047619047619 sa=0 sb=0 sd=0 mult=1 m=1
csn_op0_n100_s1_w0p2_2 sn_op0_n100_s1_w0p2_2 0 {C_SN}
XMWR_op0_n100_s1_w0p2_3 sn_op0_n100_s1_w0p2_3 wwl_des wbl_op0_n100_s1_w0p2 0 sky130_fd_pr__nfet_01v8 L=0.15 W=0.42 nf=1 ad=0.1218 as=0.1218 pd=1.42 ps=1.42 nrd=0.69047619047619  nrs=0.69047619047619 sa=0 sb=0 sd=0 mult=1 m=1
XMRD_op0_n100_s1_w0p2_3 rbl_op0_n100_s1_w0p2 sn_op0_n100_s1_w0p2_3 rwl_des 0 sky130_fd_pr__nfet_01v8 L=0.15 W=0.42 nf=1 ad=0.1218 as=0.1218 pd=1.42 ps=1.42 nrd=0.69047619047619  nrs=0.69047619047619 sa=0 sb=0 sd=0 mult=1 m=1
csn_op0_n100_s1_w0p2_3 sn_op0_n100_s1_w0p2_3 0 {C_SN}
XMN1_op0_n100_s1_w0p2 rbl_op0_n100_s1_w0p2 ref_op0_n100_s1_w0p2 vn_op0_n100_s1_w0p2 0 sky130_fd_pr__nfet_01v8 L=0.15 W=1 nf=1 ad=0.29 as=0.29 pd=2.58 ps=2.58 mult=1 m=1
XMN2_op0_n100_s1_w0p2 ref_op0_n100_s1_w0p2 rbl_op0_n100_s1_w0p2 vn_op0_n100_s1_w0p2 0 sky130_fd_pr__nfet_01v8 L=0.15 W=1 nf=1 ad=0.29 as=0.29 pd=2.58 ps=2.58 mult=1 m=1
XMP1_op0_n100_s1_w0p2 rbl_op0_n100_s1_w0p2 ref_op0_n100_s1_w0p2 vp_op0_n100_s1_w0p2 vdd sky130_fd_pr__pfet_01v8 L=0.15 W=2 nf=1 ad=0.58 as=0.58 pd=4.58 ps=4.58 mult=1 m=1
XMP2_op0_n100_s1_w0p2 ref_op0_n100_s1_w0p2 rbl_op0_n100_s1_w0p2 vp_op0_n100_s1_w0p2 vdd sky130_fd_pr__pfet_01v8 L=0.15 W=2 nf=1 ad=0.58 as=0.58 pd=4.58 ps=4.58 mult=1 m=1
XMNF_op0_n100_s1_w0p2 vn_op0_n100_s1_w0p2 en_op0_n100_s1_w0p2 0 0 sky130_fd_pr__nfet_01v8 L=0.15 W=2 nf=1 ad=0.58 as=0.58 pd=4.58 ps=4.58 mult=1 m=1
XMPH_op0_n100_s1_w0p2 vp_op0_n100_s1_w0p2 enb_op0_n100_s1_w0p2 vdd vdd sky130_fd_pr__pfet_01v8 L=0.15 W=4 nf=1 ad=1.16 as=1.16 pd=8.58 ps=8.58 mult=1 m=1
bd_op0_n100_s1_w0p2 d_op0_n100_s1_w0p2 0 v=v(rbl_op0_n100_s1_w0p2)-v(ref_op0_n100_s1_w0p2)

* ---- instance 133: op0_n100_s1_w0p5 (t_en 5 ns, WWL 6..6.5 ns, release 8.5 ns) ----
ven_op0_n100_s1_w0p5  en_op0_n100_s1_w0p5  0 pwl(0 0 5.0000e-09 0 5.1000e-09 {VDD} 8.5000e-09 {VDD} 8.6000e-09 0)
venb_op0_n100_s1_w0p5 enb_op0_n100_s1_w0p5 0 pwl(0 {VDD} 5.0000e-09 {VDD} 5.1000e-09 0 8.5000e-09 0 8.6000e-09 {VDD})
vrs_op0_n100_s1_w0p5  rwls_op0_n100_s1_w0p5 0 pwl(0 {VDD} {T_READ} {VDD} {T_READ+TEDGE} 0 8.5000e-09 0 8.6000e-09 {VDD})
vww_op0_n100_s1_w0p5  wwl_op0_n100_s1_w0p5 0 pwl(0 0 6.0000e-09 0 6.1000e-09 {VDD} 6.5000e-09 {VDD} 6.6000e-09 0)
vwc_op0_n100_s1_w0p5  wbc_op0_n100_s1_w0p5 0 pwl(0 0 6.0000e-09 0 6.1000e-09 {VDD} 8.5000e-09 {VDD} 8.6000e-09 0)
swb_op0_n100_s1_w0p5 ref_op0_n100_s1_w0p5 wbl_op0_n100_s1_w0p5 wbc_op0_n100_s1_w0p5 0 swwbl
cwbl_op0_n100_s1_w0p5 wbl_op0_n100_s1_w0p5 0 {C_WBL}
spa_op0_n100_s1_w0p5 prea rbl_op0_n100_s1_w0p5 ctl 0 swpre
spr_op0_n100_s1_w0p5 pref ref_op0_n100_s1_w0p5 ctl 0 swpre
crbl_op0_n100_s1_w0p5 rbl_op0_n100_s1_w0p5 0 {C_RBL}
cref_op0_n100_s1_w0p5 ref_op0_n100_s1_w0p5 0 {C_RBL}   $ ASSUMPTION: ideal matched dummy load
XMWR_op0_n100_s1_w0p5_0 sn_op0_n100_s1_w0p5_0 wwl_op0_n100_s1_w0p5 wbl_op0_n100_s1_w0p5 0 sky130_fd_pr__nfet_01v8 L=0.15 W=0.42 nf=1 ad=0.1218 as=0.1218 pd=1.42 ps=1.42 nrd=0.69047619047619  nrs=0.69047619047619 sa=0 sb=0 sd=0 mult=1 m=1
XMRD_op0_n100_s1_w0p5_0 rbl_op0_n100_s1_w0p5 sn_op0_n100_s1_w0p5_0 rwls_op0_n100_s1_w0p5 0 sky130_fd_pr__nfet_01v8 L=0.15 W=0.42 nf=1 ad=0.1218 as=0.1218 pd=1.42 ps=1.42 nrd=0.69047619047619  nrs=0.69047619047619 sa=0 sb=0 sd=0 mult=1 m=1
csn_op0_n100_s1_w0p5_0 sn_op0_n100_s1_w0p5_0 0 {C_SN}
XMWR_op0_n100_s1_w0p5_1 sn_op0_n100_s1_w0p5_1 wwl_des wbl_op0_n100_s1_w0p5 0 sky130_fd_pr__nfet_01v8 L=0.15 W=0.42 nf=1 ad=0.1218 as=0.1218 pd=1.42 ps=1.42 nrd=0.69047619047619  nrs=0.69047619047619 sa=0 sb=0 sd=0 mult=1 m=1
XMRD_op0_n100_s1_w0p5_1 rbl_op0_n100_s1_w0p5 sn_op0_n100_s1_w0p5_1 rwl_des 0 sky130_fd_pr__nfet_01v8 L=0.15 W=0.42 nf=1 ad=0.1218 as=0.1218 pd=1.42 ps=1.42 nrd=0.69047619047619  nrs=0.69047619047619 sa=0 sb=0 sd=0 mult=1 m=1
csn_op0_n100_s1_w0p5_1 sn_op0_n100_s1_w0p5_1 0 {C_SN}
XMWR_op0_n100_s1_w0p5_2 sn_op0_n100_s1_w0p5_2 wwl_des wbl_op0_n100_s1_w0p5 0 sky130_fd_pr__nfet_01v8 L=0.15 W=0.42 nf=1 ad=0.1218 as=0.1218 pd=1.42 ps=1.42 nrd=0.69047619047619  nrs=0.69047619047619 sa=0 sb=0 sd=0 mult=1 m=1
XMRD_op0_n100_s1_w0p5_2 rbl_op0_n100_s1_w0p5 sn_op0_n100_s1_w0p5_2 rwl_des 0 sky130_fd_pr__nfet_01v8 L=0.15 W=0.42 nf=1 ad=0.1218 as=0.1218 pd=1.42 ps=1.42 nrd=0.69047619047619  nrs=0.69047619047619 sa=0 sb=0 sd=0 mult=1 m=1
csn_op0_n100_s1_w0p5_2 sn_op0_n100_s1_w0p5_2 0 {C_SN}
XMWR_op0_n100_s1_w0p5_3 sn_op0_n100_s1_w0p5_3 wwl_des wbl_op0_n100_s1_w0p5 0 sky130_fd_pr__nfet_01v8 L=0.15 W=0.42 nf=1 ad=0.1218 as=0.1218 pd=1.42 ps=1.42 nrd=0.69047619047619  nrs=0.69047619047619 sa=0 sb=0 sd=0 mult=1 m=1
XMRD_op0_n100_s1_w0p5_3 rbl_op0_n100_s1_w0p5 sn_op0_n100_s1_w0p5_3 rwl_des 0 sky130_fd_pr__nfet_01v8 L=0.15 W=0.42 nf=1 ad=0.1218 as=0.1218 pd=1.42 ps=1.42 nrd=0.69047619047619  nrs=0.69047619047619 sa=0 sb=0 sd=0 mult=1 m=1
csn_op0_n100_s1_w0p5_3 sn_op0_n100_s1_w0p5_3 0 {C_SN}
XMN1_op0_n100_s1_w0p5 rbl_op0_n100_s1_w0p5 ref_op0_n100_s1_w0p5 vn_op0_n100_s1_w0p5 0 sky130_fd_pr__nfet_01v8 L=0.15 W=1 nf=1 ad=0.29 as=0.29 pd=2.58 ps=2.58 mult=1 m=1
XMN2_op0_n100_s1_w0p5 ref_op0_n100_s1_w0p5 rbl_op0_n100_s1_w0p5 vn_op0_n100_s1_w0p5 0 sky130_fd_pr__nfet_01v8 L=0.15 W=1 nf=1 ad=0.29 as=0.29 pd=2.58 ps=2.58 mult=1 m=1
XMP1_op0_n100_s1_w0p5 rbl_op0_n100_s1_w0p5 ref_op0_n100_s1_w0p5 vp_op0_n100_s1_w0p5 vdd sky130_fd_pr__pfet_01v8 L=0.15 W=2 nf=1 ad=0.58 as=0.58 pd=4.58 ps=4.58 mult=1 m=1
XMP2_op0_n100_s1_w0p5 ref_op0_n100_s1_w0p5 rbl_op0_n100_s1_w0p5 vp_op0_n100_s1_w0p5 vdd sky130_fd_pr__pfet_01v8 L=0.15 W=2 nf=1 ad=0.58 as=0.58 pd=4.58 ps=4.58 mult=1 m=1
XMNF_op0_n100_s1_w0p5 vn_op0_n100_s1_w0p5 en_op0_n100_s1_w0p5 0 0 sky130_fd_pr__nfet_01v8 L=0.15 W=2 nf=1 ad=0.58 as=0.58 pd=4.58 ps=4.58 mult=1 m=1
XMPH_op0_n100_s1_w0p5 vp_op0_n100_s1_w0p5 enb_op0_n100_s1_w0p5 vdd vdd sky130_fd_pr__pfet_01v8 L=0.15 W=4 nf=1 ad=1.16 as=1.16 pd=8.58 ps=8.58 mult=1 m=1
bd_op0_n100_s1_w0p5 d_op0_n100_s1_w0p5 0 v=v(rbl_op0_n100_s1_w0p5)-v(ref_op0_n100_s1_w0p5)

* ---- instance 134: op0_n100_s1_w1 (t_en 5 ns, WWL 6..7 ns, release 9 ns) ----
ven_op0_n100_s1_w1  en_op0_n100_s1_w1  0 pwl(0 0 5.0000e-09 0 5.1000e-09 {VDD} 9.0000e-09 {VDD} 9.1000e-09 0)
venb_op0_n100_s1_w1 enb_op0_n100_s1_w1 0 pwl(0 {VDD} 5.0000e-09 {VDD} 5.1000e-09 0 9.0000e-09 0 9.1000e-09 {VDD})
vrs_op0_n100_s1_w1  rwls_op0_n100_s1_w1 0 pwl(0 {VDD} {T_READ} {VDD} {T_READ+TEDGE} 0 9.0000e-09 0 9.1000e-09 {VDD})
vww_op0_n100_s1_w1  wwl_op0_n100_s1_w1 0 pwl(0 0 6.0000e-09 0 6.1000e-09 {VDD} 7.0000e-09 {VDD} 7.1000e-09 0)
vwc_op0_n100_s1_w1  wbc_op0_n100_s1_w1 0 pwl(0 0 6.0000e-09 0 6.1000e-09 {VDD} 9.0000e-09 {VDD} 9.1000e-09 0)
swb_op0_n100_s1_w1 ref_op0_n100_s1_w1 wbl_op0_n100_s1_w1 wbc_op0_n100_s1_w1 0 swwbl
cwbl_op0_n100_s1_w1 wbl_op0_n100_s1_w1 0 {C_WBL}
spa_op0_n100_s1_w1 prea rbl_op0_n100_s1_w1 ctl 0 swpre
spr_op0_n100_s1_w1 pref ref_op0_n100_s1_w1 ctl 0 swpre
crbl_op0_n100_s1_w1 rbl_op0_n100_s1_w1 0 {C_RBL}
cref_op0_n100_s1_w1 ref_op0_n100_s1_w1 0 {C_RBL}   $ ASSUMPTION: ideal matched dummy load
XMWR_op0_n100_s1_w1_0 sn_op0_n100_s1_w1_0 wwl_op0_n100_s1_w1 wbl_op0_n100_s1_w1 0 sky130_fd_pr__nfet_01v8 L=0.15 W=0.42 nf=1 ad=0.1218 as=0.1218 pd=1.42 ps=1.42 nrd=0.69047619047619  nrs=0.69047619047619 sa=0 sb=0 sd=0 mult=1 m=1
XMRD_op0_n100_s1_w1_0 rbl_op0_n100_s1_w1 sn_op0_n100_s1_w1_0 rwls_op0_n100_s1_w1 0 sky130_fd_pr__nfet_01v8 L=0.15 W=0.42 nf=1 ad=0.1218 as=0.1218 pd=1.42 ps=1.42 nrd=0.69047619047619  nrs=0.69047619047619 sa=0 sb=0 sd=0 mult=1 m=1
csn_op0_n100_s1_w1_0 sn_op0_n100_s1_w1_0 0 {C_SN}
XMWR_op0_n100_s1_w1_1 sn_op0_n100_s1_w1_1 wwl_des wbl_op0_n100_s1_w1 0 sky130_fd_pr__nfet_01v8 L=0.15 W=0.42 nf=1 ad=0.1218 as=0.1218 pd=1.42 ps=1.42 nrd=0.69047619047619  nrs=0.69047619047619 sa=0 sb=0 sd=0 mult=1 m=1
XMRD_op0_n100_s1_w1_1 rbl_op0_n100_s1_w1 sn_op0_n100_s1_w1_1 rwl_des 0 sky130_fd_pr__nfet_01v8 L=0.15 W=0.42 nf=1 ad=0.1218 as=0.1218 pd=1.42 ps=1.42 nrd=0.69047619047619  nrs=0.69047619047619 sa=0 sb=0 sd=0 mult=1 m=1
csn_op0_n100_s1_w1_1 sn_op0_n100_s1_w1_1 0 {C_SN}
XMWR_op0_n100_s1_w1_2 sn_op0_n100_s1_w1_2 wwl_des wbl_op0_n100_s1_w1 0 sky130_fd_pr__nfet_01v8 L=0.15 W=0.42 nf=1 ad=0.1218 as=0.1218 pd=1.42 ps=1.42 nrd=0.69047619047619  nrs=0.69047619047619 sa=0 sb=0 sd=0 mult=1 m=1
XMRD_op0_n100_s1_w1_2 rbl_op0_n100_s1_w1 sn_op0_n100_s1_w1_2 rwl_des 0 sky130_fd_pr__nfet_01v8 L=0.15 W=0.42 nf=1 ad=0.1218 as=0.1218 pd=1.42 ps=1.42 nrd=0.69047619047619  nrs=0.69047619047619 sa=0 sb=0 sd=0 mult=1 m=1
csn_op0_n100_s1_w1_2 sn_op0_n100_s1_w1_2 0 {C_SN}
XMWR_op0_n100_s1_w1_3 sn_op0_n100_s1_w1_3 wwl_des wbl_op0_n100_s1_w1 0 sky130_fd_pr__nfet_01v8 L=0.15 W=0.42 nf=1 ad=0.1218 as=0.1218 pd=1.42 ps=1.42 nrd=0.69047619047619  nrs=0.69047619047619 sa=0 sb=0 sd=0 mult=1 m=1
XMRD_op0_n100_s1_w1_3 rbl_op0_n100_s1_w1 sn_op0_n100_s1_w1_3 rwl_des 0 sky130_fd_pr__nfet_01v8 L=0.15 W=0.42 nf=1 ad=0.1218 as=0.1218 pd=1.42 ps=1.42 nrd=0.69047619047619  nrs=0.69047619047619 sa=0 sb=0 sd=0 mult=1 m=1
csn_op0_n100_s1_w1_3 sn_op0_n100_s1_w1_3 0 {C_SN}
XMN1_op0_n100_s1_w1 rbl_op0_n100_s1_w1 ref_op0_n100_s1_w1 vn_op0_n100_s1_w1 0 sky130_fd_pr__nfet_01v8 L=0.15 W=1 nf=1 ad=0.29 as=0.29 pd=2.58 ps=2.58 mult=1 m=1
XMN2_op0_n100_s1_w1 ref_op0_n100_s1_w1 rbl_op0_n100_s1_w1 vn_op0_n100_s1_w1 0 sky130_fd_pr__nfet_01v8 L=0.15 W=1 nf=1 ad=0.29 as=0.29 pd=2.58 ps=2.58 mult=1 m=1
XMP1_op0_n100_s1_w1 rbl_op0_n100_s1_w1 ref_op0_n100_s1_w1 vp_op0_n100_s1_w1 vdd sky130_fd_pr__pfet_01v8 L=0.15 W=2 nf=1 ad=0.58 as=0.58 pd=4.58 ps=4.58 mult=1 m=1
XMP2_op0_n100_s1_w1 ref_op0_n100_s1_w1 rbl_op0_n100_s1_w1 vp_op0_n100_s1_w1 vdd sky130_fd_pr__pfet_01v8 L=0.15 W=2 nf=1 ad=0.58 as=0.58 pd=4.58 ps=4.58 mult=1 m=1
XMNF_op0_n100_s1_w1 vn_op0_n100_s1_w1 en_op0_n100_s1_w1 0 0 sky130_fd_pr__nfet_01v8 L=0.15 W=2 nf=1 ad=0.58 as=0.58 pd=4.58 ps=4.58 mult=1 m=1
XMPH_op0_n100_s1_w1 vp_op0_n100_s1_w1 enb_op0_n100_s1_w1 vdd vdd sky130_fd_pr__pfet_01v8 L=0.15 W=4 nf=1 ad=1.16 as=1.16 pd=8.58 ps=8.58 mult=1 m=1
bd_op0_n100_s1_w1 d_op0_n100_s1_w1 0 v=v(rbl_op0_n100_s1_w1)-v(ref_op0_n100_s1_w1)

* ---- instance 135: op0_n100_s1_w2 (t_en 5 ns, WWL 6..8 ns, release 10 ns) ----
ven_op0_n100_s1_w2  en_op0_n100_s1_w2  0 pwl(0 0 5.0000e-09 0 5.1000e-09 {VDD} 1.0000e-08 {VDD} 1.0100e-08 0)
venb_op0_n100_s1_w2 enb_op0_n100_s1_w2 0 pwl(0 {VDD} 5.0000e-09 {VDD} 5.1000e-09 0 1.0000e-08 0 1.0100e-08 {VDD})
vrs_op0_n100_s1_w2  rwls_op0_n100_s1_w2 0 pwl(0 {VDD} {T_READ} {VDD} {T_READ+TEDGE} 0 1.0000e-08 0 1.0100e-08 {VDD})
vww_op0_n100_s1_w2  wwl_op0_n100_s1_w2 0 pwl(0 0 6.0000e-09 0 6.1000e-09 {VDD} 8.0000e-09 {VDD} 8.1000e-09 0)
vwc_op0_n100_s1_w2  wbc_op0_n100_s1_w2 0 pwl(0 0 6.0000e-09 0 6.1000e-09 {VDD} 1.0000e-08 {VDD} 1.0100e-08 0)
swb_op0_n100_s1_w2 ref_op0_n100_s1_w2 wbl_op0_n100_s1_w2 wbc_op0_n100_s1_w2 0 swwbl
cwbl_op0_n100_s1_w2 wbl_op0_n100_s1_w2 0 {C_WBL}
spa_op0_n100_s1_w2 prea rbl_op0_n100_s1_w2 ctl 0 swpre
spr_op0_n100_s1_w2 pref ref_op0_n100_s1_w2 ctl 0 swpre
crbl_op0_n100_s1_w2 rbl_op0_n100_s1_w2 0 {C_RBL}
cref_op0_n100_s1_w2 ref_op0_n100_s1_w2 0 {C_RBL}   $ ASSUMPTION: ideal matched dummy load
XMWR_op0_n100_s1_w2_0 sn_op0_n100_s1_w2_0 wwl_op0_n100_s1_w2 wbl_op0_n100_s1_w2 0 sky130_fd_pr__nfet_01v8 L=0.15 W=0.42 nf=1 ad=0.1218 as=0.1218 pd=1.42 ps=1.42 nrd=0.69047619047619  nrs=0.69047619047619 sa=0 sb=0 sd=0 mult=1 m=1
XMRD_op0_n100_s1_w2_0 rbl_op0_n100_s1_w2 sn_op0_n100_s1_w2_0 rwls_op0_n100_s1_w2 0 sky130_fd_pr__nfet_01v8 L=0.15 W=0.42 nf=1 ad=0.1218 as=0.1218 pd=1.42 ps=1.42 nrd=0.69047619047619  nrs=0.69047619047619 sa=0 sb=0 sd=0 mult=1 m=1
csn_op0_n100_s1_w2_0 sn_op0_n100_s1_w2_0 0 {C_SN}
XMWR_op0_n100_s1_w2_1 sn_op0_n100_s1_w2_1 wwl_des wbl_op0_n100_s1_w2 0 sky130_fd_pr__nfet_01v8 L=0.15 W=0.42 nf=1 ad=0.1218 as=0.1218 pd=1.42 ps=1.42 nrd=0.69047619047619  nrs=0.69047619047619 sa=0 sb=0 sd=0 mult=1 m=1
XMRD_op0_n100_s1_w2_1 rbl_op0_n100_s1_w2 sn_op0_n100_s1_w2_1 rwl_des 0 sky130_fd_pr__nfet_01v8 L=0.15 W=0.42 nf=1 ad=0.1218 as=0.1218 pd=1.42 ps=1.42 nrd=0.69047619047619  nrs=0.69047619047619 sa=0 sb=0 sd=0 mult=1 m=1
csn_op0_n100_s1_w2_1 sn_op0_n100_s1_w2_1 0 {C_SN}
XMWR_op0_n100_s1_w2_2 sn_op0_n100_s1_w2_2 wwl_des wbl_op0_n100_s1_w2 0 sky130_fd_pr__nfet_01v8 L=0.15 W=0.42 nf=1 ad=0.1218 as=0.1218 pd=1.42 ps=1.42 nrd=0.69047619047619  nrs=0.69047619047619 sa=0 sb=0 sd=0 mult=1 m=1
XMRD_op0_n100_s1_w2_2 rbl_op0_n100_s1_w2 sn_op0_n100_s1_w2_2 rwl_des 0 sky130_fd_pr__nfet_01v8 L=0.15 W=0.42 nf=1 ad=0.1218 as=0.1218 pd=1.42 ps=1.42 nrd=0.69047619047619  nrs=0.69047619047619 sa=0 sb=0 sd=0 mult=1 m=1
csn_op0_n100_s1_w2_2 sn_op0_n100_s1_w2_2 0 {C_SN}
XMWR_op0_n100_s1_w2_3 sn_op0_n100_s1_w2_3 wwl_des wbl_op0_n100_s1_w2 0 sky130_fd_pr__nfet_01v8 L=0.15 W=0.42 nf=1 ad=0.1218 as=0.1218 pd=1.42 ps=1.42 nrd=0.69047619047619  nrs=0.69047619047619 sa=0 sb=0 sd=0 mult=1 m=1
XMRD_op0_n100_s1_w2_3 rbl_op0_n100_s1_w2 sn_op0_n100_s1_w2_3 rwl_des 0 sky130_fd_pr__nfet_01v8 L=0.15 W=0.42 nf=1 ad=0.1218 as=0.1218 pd=1.42 ps=1.42 nrd=0.69047619047619  nrs=0.69047619047619 sa=0 sb=0 sd=0 mult=1 m=1
csn_op0_n100_s1_w2_3 sn_op0_n100_s1_w2_3 0 {C_SN}
XMN1_op0_n100_s1_w2 rbl_op0_n100_s1_w2 ref_op0_n100_s1_w2 vn_op0_n100_s1_w2 0 sky130_fd_pr__nfet_01v8 L=0.15 W=1 nf=1 ad=0.29 as=0.29 pd=2.58 ps=2.58 mult=1 m=1
XMN2_op0_n100_s1_w2 ref_op0_n100_s1_w2 rbl_op0_n100_s1_w2 vn_op0_n100_s1_w2 0 sky130_fd_pr__nfet_01v8 L=0.15 W=1 nf=1 ad=0.29 as=0.29 pd=2.58 ps=2.58 mult=1 m=1
XMP1_op0_n100_s1_w2 rbl_op0_n100_s1_w2 ref_op0_n100_s1_w2 vp_op0_n100_s1_w2 vdd sky130_fd_pr__pfet_01v8 L=0.15 W=2 nf=1 ad=0.58 as=0.58 pd=4.58 ps=4.58 mult=1 m=1
XMP2_op0_n100_s1_w2 ref_op0_n100_s1_w2 rbl_op0_n100_s1_w2 vp_op0_n100_s1_w2 vdd sky130_fd_pr__pfet_01v8 L=0.15 W=2 nf=1 ad=0.58 as=0.58 pd=4.58 ps=4.58 mult=1 m=1
XMNF_op0_n100_s1_w2 vn_op0_n100_s1_w2 en_op0_n100_s1_w2 0 0 sky130_fd_pr__nfet_01v8 L=0.15 W=2 nf=1 ad=0.58 as=0.58 pd=4.58 ps=4.58 mult=1 m=1
XMPH_op0_n100_s1_w2 vp_op0_n100_s1_w2 enb_op0_n100_s1_w2 vdd vdd sky130_fd_pr__pfet_01v8 L=0.15 W=4 nf=1 ad=1.16 as=1.16 pd=8.58 ps=8.58 mult=1 m=1
bd_op0_n100_s1_w2 d_op0_n100_s1_w2 0 v=v(rbl_op0_n100_s1_w2)-v(ref_op0_n100_s1_w2)

* ---- instance 136: op0_n100_s1_w3 (t_en 5 ns, WWL 6..9 ns, release 11 ns) ----
ven_op0_n100_s1_w3  en_op0_n100_s1_w3  0 pwl(0 0 5.0000e-09 0 5.1000e-09 {VDD} 1.1000e-08 {VDD} 1.1100e-08 0)
venb_op0_n100_s1_w3 enb_op0_n100_s1_w3 0 pwl(0 {VDD} 5.0000e-09 {VDD} 5.1000e-09 0 1.1000e-08 0 1.1100e-08 {VDD})
vrs_op0_n100_s1_w3  rwls_op0_n100_s1_w3 0 pwl(0 {VDD} {T_READ} {VDD} {T_READ+TEDGE} 0 1.1000e-08 0 1.1100e-08 {VDD})
vww_op0_n100_s1_w3  wwl_op0_n100_s1_w3 0 pwl(0 0 6.0000e-09 0 6.1000e-09 {VDD} 9.0000e-09 {VDD} 9.1000e-09 0)
vwc_op0_n100_s1_w3  wbc_op0_n100_s1_w3 0 pwl(0 0 6.0000e-09 0 6.1000e-09 {VDD} 1.1000e-08 {VDD} 1.1100e-08 0)
swb_op0_n100_s1_w3 ref_op0_n100_s1_w3 wbl_op0_n100_s1_w3 wbc_op0_n100_s1_w3 0 swwbl
cwbl_op0_n100_s1_w3 wbl_op0_n100_s1_w3 0 {C_WBL}
spa_op0_n100_s1_w3 prea rbl_op0_n100_s1_w3 ctl 0 swpre
spr_op0_n100_s1_w3 pref ref_op0_n100_s1_w3 ctl 0 swpre
crbl_op0_n100_s1_w3 rbl_op0_n100_s1_w3 0 {C_RBL}
cref_op0_n100_s1_w3 ref_op0_n100_s1_w3 0 {C_RBL}   $ ASSUMPTION: ideal matched dummy load
XMWR_op0_n100_s1_w3_0 sn_op0_n100_s1_w3_0 wwl_op0_n100_s1_w3 wbl_op0_n100_s1_w3 0 sky130_fd_pr__nfet_01v8 L=0.15 W=0.42 nf=1 ad=0.1218 as=0.1218 pd=1.42 ps=1.42 nrd=0.69047619047619  nrs=0.69047619047619 sa=0 sb=0 sd=0 mult=1 m=1
XMRD_op0_n100_s1_w3_0 rbl_op0_n100_s1_w3 sn_op0_n100_s1_w3_0 rwls_op0_n100_s1_w3 0 sky130_fd_pr__nfet_01v8 L=0.15 W=0.42 nf=1 ad=0.1218 as=0.1218 pd=1.42 ps=1.42 nrd=0.69047619047619  nrs=0.69047619047619 sa=0 sb=0 sd=0 mult=1 m=1
csn_op0_n100_s1_w3_0 sn_op0_n100_s1_w3_0 0 {C_SN}
XMWR_op0_n100_s1_w3_1 sn_op0_n100_s1_w3_1 wwl_des wbl_op0_n100_s1_w3 0 sky130_fd_pr__nfet_01v8 L=0.15 W=0.42 nf=1 ad=0.1218 as=0.1218 pd=1.42 ps=1.42 nrd=0.69047619047619  nrs=0.69047619047619 sa=0 sb=0 sd=0 mult=1 m=1
XMRD_op0_n100_s1_w3_1 rbl_op0_n100_s1_w3 sn_op0_n100_s1_w3_1 rwl_des 0 sky130_fd_pr__nfet_01v8 L=0.15 W=0.42 nf=1 ad=0.1218 as=0.1218 pd=1.42 ps=1.42 nrd=0.69047619047619  nrs=0.69047619047619 sa=0 sb=0 sd=0 mult=1 m=1
csn_op0_n100_s1_w3_1 sn_op0_n100_s1_w3_1 0 {C_SN}
XMWR_op0_n100_s1_w3_2 sn_op0_n100_s1_w3_2 wwl_des wbl_op0_n100_s1_w3 0 sky130_fd_pr__nfet_01v8 L=0.15 W=0.42 nf=1 ad=0.1218 as=0.1218 pd=1.42 ps=1.42 nrd=0.69047619047619  nrs=0.69047619047619 sa=0 sb=0 sd=0 mult=1 m=1
XMRD_op0_n100_s1_w3_2 rbl_op0_n100_s1_w3 sn_op0_n100_s1_w3_2 rwl_des 0 sky130_fd_pr__nfet_01v8 L=0.15 W=0.42 nf=1 ad=0.1218 as=0.1218 pd=1.42 ps=1.42 nrd=0.69047619047619  nrs=0.69047619047619 sa=0 sb=0 sd=0 mult=1 m=1
csn_op0_n100_s1_w3_2 sn_op0_n100_s1_w3_2 0 {C_SN}
XMWR_op0_n100_s1_w3_3 sn_op0_n100_s1_w3_3 wwl_des wbl_op0_n100_s1_w3 0 sky130_fd_pr__nfet_01v8 L=0.15 W=0.42 nf=1 ad=0.1218 as=0.1218 pd=1.42 ps=1.42 nrd=0.69047619047619  nrs=0.69047619047619 sa=0 sb=0 sd=0 mult=1 m=1
XMRD_op0_n100_s1_w3_3 rbl_op0_n100_s1_w3 sn_op0_n100_s1_w3_3 rwl_des 0 sky130_fd_pr__nfet_01v8 L=0.15 W=0.42 nf=1 ad=0.1218 as=0.1218 pd=1.42 ps=1.42 nrd=0.69047619047619  nrs=0.69047619047619 sa=0 sb=0 sd=0 mult=1 m=1
csn_op0_n100_s1_w3_3 sn_op0_n100_s1_w3_3 0 {C_SN}
XMN1_op0_n100_s1_w3 rbl_op0_n100_s1_w3 ref_op0_n100_s1_w3 vn_op0_n100_s1_w3 0 sky130_fd_pr__nfet_01v8 L=0.15 W=1 nf=1 ad=0.29 as=0.29 pd=2.58 ps=2.58 mult=1 m=1
XMN2_op0_n100_s1_w3 ref_op0_n100_s1_w3 rbl_op0_n100_s1_w3 vn_op0_n100_s1_w3 0 sky130_fd_pr__nfet_01v8 L=0.15 W=1 nf=1 ad=0.29 as=0.29 pd=2.58 ps=2.58 mult=1 m=1
XMP1_op0_n100_s1_w3 rbl_op0_n100_s1_w3 ref_op0_n100_s1_w3 vp_op0_n100_s1_w3 vdd sky130_fd_pr__pfet_01v8 L=0.15 W=2 nf=1 ad=0.58 as=0.58 pd=4.58 ps=4.58 mult=1 m=1
XMP2_op0_n100_s1_w3 ref_op0_n100_s1_w3 rbl_op0_n100_s1_w3 vp_op0_n100_s1_w3 vdd sky130_fd_pr__pfet_01v8 L=0.15 W=2 nf=1 ad=0.58 as=0.58 pd=4.58 ps=4.58 mult=1 m=1
XMNF_op0_n100_s1_w3 vn_op0_n100_s1_w3 en_op0_n100_s1_w3 0 0 sky130_fd_pr__nfet_01v8 L=0.15 W=2 nf=1 ad=0.58 as=0.58 pd=4.58 ps=4.58 mult=1 m=1
XMPH_op0_n100_s1_w3 vp_op0_n100_s1_w3 enb_op0_n100_s1_w3 vdd vdd sky130_fd_pr__pfet_01v8 L=0.15 W=4 nf=1 ad=1.16 as=1.16 pd=8.58 ps=8.58 mult=1 m=1
bd_op0_n100_s1_w3 d_op0_n100_s1_w3 0 v=v(rbl_op0_n100_s1_w3)-v(ref_op0_n100_s1_w3)

* ---- instance 137: op0_n100_s1_w5 (t_en 5 ns, WWL 6..11 ns, release 13 ns) ----
ven_op0_n100_s1_w5  en_op0_n100_s1_w5  0 pwl(0 0 5.0000e-09 0 5.1000e-09 {VDD} 1.3000e-08 {VDD} 1.3100e-08 0)
venb_op0_n100_s1_w5 enb_op0_n100_s1_w5 0 pwl(0 {VDD} 5.0000e-09 {VDD} 5.1000e-09 0 1.3000e-08 0 1.3100e-08 {VDD})
vrs_op0_n100_s1_w5  rwls_op0_n100_s1_w5 0 pwl(0 {VDD} {T_READ} {VDD} {T_READ+TEDGE} 0 1.3000e-08 0 1.3100e-08 {VDD})
vww_op0_n100_s1_w5  wwl_op0_n100_s1_w5 0 pwl(0 0 6.0000e-09 0 6.1000e-09 {VDD} 1.1000e-08 {VDD} 1.1100e-08 0)
vwc_op0_n100_s1_w5  wbc_op0_n100_s1_w5 0 pwl(0 0 6.0000e-09 0 6.1000e-09 {VDD} 1.3000e-08 {VDD} 1.3100e-08 0)
swb_op0_n100_s1_w5 ref_op0_n100_s1_w5 wbl_op0_n100_s1_w5 wbc_op0_n100_s1_w5 0 swwbl
cwbl_op0_n100_s1_w5 wbl_op0_n100_s1_w5 0 {C_WBL}
spa_op0_n100_s1_w5 prea rbl_op0_n100_s1_w5 ctl 0 swpre
spr_op0_n100_s1_w5 pref ref_op0_n100_s1_w5 ctl 0 swpre
crbl_op0_n100_s1_w5 rbl_op0_n100_s1_w5 0 {C_RBL}
cref_op0_n100_s1_w5 ref_op0_n100_s1_w5 0 {C_RBL}   $ ASSUMPTION: ideal matched dummy load
XMWR_op0_n100_s1_w5_0 sn_op0_n100_s1_w5_0 wwl_op0_n100_s1_w5 wbl_op0_n100_s1_w5 0 sky130_fd_pr__nfet_01v8 L=0.15 W=0.42 nf=1 ad=0.1218 as=0.1218 pd=1.42 ps=1.42 nrd=0.69047619047619  nrs=0.69047619047619 sa=0 sb=0 sd=0 mult=1 m=1
XMRD_op0_n100_s1_w5_0 rbl_op0_n100_s1_w5 sn_op0_n100_s1_w5_0 rwls_op0_n100_s1_w5 0 sky130_fd_pr__nfet_01v8 L=0.15 W=0.42 nf=1 ad=0.1218 as=0.1218 pd=1.42 ps=1.42 nrd=0.69047619047619  nrs=0.69047619047619 sa=0 sb=0 sd=0 mult=1 m=1
csn_op0_n100_s1_w5_0 sn_op0_n100_s1_w5_0 0 {C_SN}
XMWR_op0_n100_s1_w5_1 sn_op0_n100_s1_w5_1 wwl_des wbl_op0_n100_s1_w5 0 sky130_fd_pr__nfet_01v8 L=0.15 W=0.42 nf=1 ad=0.1218 as=0.1218 pd=1.42 ps=1.42 nrd=0.69047619047619  nrs=0.69047619047619 sa=0 sb=0 sd=0 mult=1 m=1
XMRD_op0_n100_s1_w5_1 rbl_op0_n100_s1_w5 sn_op0_n100_s1_w5_1 rwl_des 0 sky130_fd_pr__nfet_01v8 L=0.15 W=0.42 nf=1 ad=0.1218 as=0.1218 pd=1.42 ps=1.42 nrd=0.69047619047619  nrs=0.69047619047619 sa=0 sb=0 sd=0 mult=1 m=1
csn_op0_n100_s1_w5_1 sn_op0_n100_s1_w5_1 0 {C_SN}
XMWR_op0_n100_s1_w5_2 sn_op0_n100_s1_w5_2 wwl_des wbl_op0_n100_s1_w5 0 sky130_fd_pr__nfet_01v8 L=0.15 W=0.42 nf=1 ad=0.1218 as=0.1218 pd=1.42 ps=1.42 nrd=0.69047619047619  nrs=0.69047619047619 sa=0 sb=0 sd=0 mult=1 m=1
XMRD_op0_n100_s1_w5_2 rbl_op0_n100_s1_w5 sn_op0_n100_s1_w5_2 rwl_des 0 sky130_fd_pr__nfet_01v8 L=0.15 W=0.42 nf=1 ad=0.1218 as=0.1218 pd=1.42 ps=1.42 nrd=0.69047619047619  nrs=0.69047619047619 sa=0 sb=0 sd=0 mult=1 m=1
csn_op0_n100_s1_w5_2 sn_op0_n100_s1_w5_2 0 {C_SN}
XMWR_op0_n100_s1_w5_3 sn_op0_n100_s1_w5_3 wwl_des wbl_op0_n100_s1_w5 0 sky130_fd_pr__nfet_01v8 L=0.15 W=0.42 nf=1 ad=0.1218 as=0.1218 pd=1.42 ps=1.42 nrd=0.69047619047619  nrs=0.69047619047619 sa=0 sb=0 sd=0 mult=1 m=1
XMRD_op0_n100_s1_w5_3 rbl_op0_n100_s1_w5 sn_op0_n100_s1_w5_3 rwl_des 0 sky130_fd_pr__nfet_01v8 L=0.15 W=0.42 nf=1 ad=0.1218 as=0.1218 pd=1.42 ps=1.42 nrd=0.69047619047619  nrs=0.69047619047619 sa=0 sb=0 sd=0 mult=1 m=1
csn_op0_n100_s1_w5_3 sn_op0_n100_s1_w5_3 0 {C_SN}
XMN1_op0_n100_s1_w5 rbl_op0_n100_s1_w5 ref_op0_n100_s1_w5 vn_op0_n100_s1_w5 0 sky130_fd_pr__nfet_01v8 L=0.15 W=1 nf=1 ad=0.29 as=0.29 pd=2.58 ps=2.58 mult=1 m=1
XMN2_op0_n100_s1_w5 ref_op0_n100_s1_w5 rbl_op0_n100_s1_w5 vn_op0_n100_s1_w5 0 sky130_fd_pr__nfet_01v8 L=0.15 W=1 nf=1 ad=0.29 as=0.29 pd=2.58 ps=2.58 mult=1 m=1
XMP1_op0_n100_s1_w5 rbl_op0_n100_s1_w5 ref_op0_n100_s1_w5 vp_op0_n100_s1_w5 vdd sky130_fd_pr__pfet_01v8 L=0.15 W=2 nf=1 ad=0.58 as=0.58 pd=4.58 ps=4.58 mult=1 m=1
XMP2_op0_n100_s1_w5 ref_op0_n100_s1_w5 rbl_op0_n100_s1_w5 vp_op0_n100_s1_w5 vdd sky130_fd_pr__pfet_01v8 L=0.15 W=2 nf=1 ad=0.58 as=0.58 pd=4.58 ps=4.58 mult=1 m=1
XMNF_op0_n100_s1_w5 vn_op0_n100_s1_w5 en_op0_n100_s1_w5 0 0 sky130_fd_pr__nfet_01v8 L=0.15 W=2 nf=1 ad=0.58 as=0.58 pd=4.58 ps=4.58 mult=1 m=1
XMPH_op0_n100_s1_w5 vp_op0_n100_s1_w5 enb_op0_n100_s1_w5 vdd vdd sky130_fd_pr__pfet_01v8 L=0.15 W=4 nf=1 ad=1.16 as=1.16 pd=8.58 ps=8.58 mult=1 m=1
bd_op0_n100_s1_w5 d_op0_n100_s1_w5 0 v=v(rbl_op0_n100_s1_w5)-v(ref_op0_n100_s1_w5)

* ---- instance 138: op0_n100_s1_w7p5 (t_en 5 ns, WWL 6..13.5 ns, release 15.5 ns) ----
ven_op0_n100_s1_w7p5  en_op0_n100_s1_w7p5  0 pwl(0 0 5.0000e-09 0 5.1000e-09 {VDD} 1.5500e-08 {VDD} 1.5600e-08 0)
venb_op0_n100_s1_w7p5 enb_op0_n100_s1_w7p5 0 pwl(0 {VDD} 5.0000e-09 {VDD} 5.1000e-09 0 1.5500e-08 0 1.5600e-08 {VDD})
vrs_op0_n100_s1_w7p5  rwls_op0_n100_s1_w7p5 0 pwl(0 {VDD} {T_READ} {VDD} {T_READ+TEDGE} 0 1.5500e-08 0 1.5600e-08 {VDD})
vww_op0_n100_s1_w7p5  wwl_op0_n100_s1_w7p5 0 pwl(0 0 6.0000e-09 0 6.1000e-09 {VDD} 1.3500e-08 {VDD} 1.3600e-08 0)
vwc_op0_n100_s1_w7p5  wbc_op0_n100_s1_w7p5 0 pwl(0 0 6.0000e-09 0 6.1000e-09 {VDD} 1.5500e-08 {VDD} 1.5600e-08 0)
swb_op0_n100_s1_w7p5 ref_op0_n100_s1_w7p5 wbl_op0_n100_s1_w7p5 wbc_op0_n100_s1_w7p5 0 swwbl
cwbl_op0_n100_s1_w7p5 wbl_op0_n100_s1_w7p5 0 {C_WBL}
spa_op0_n100_s1_w7p5 prea rbl_op0_n100_s1_w7p5 ctl 0 swpre
spr_op0_n100_s1_w7p5 pref ref_op0_n100_s1_w7p5 ctl 0 swpre
crbl_op0_n100_s1_w7p5 rbl_op0_n100_s1_w7p5 0 {C_RBL}
cref_op0_n100_s1_w7p5 ref_op0_n100_s1_w7p5 0 {C_RBL}   $ ASSUMPTION: ideal matched dummy load
XMWR_op0_n100_s1_w7p5_0 sn_op0_n100_s1_w7p5_0 wwl_op0_n100_s1_w7p5 wbl_op0_n100_s1_w7p5 0 sky130_fd_pr__nfet_01v8 L=0.15 W=0.42 nf=1 ad=0.1218 as=0.1218 pd=1.42 ps=1.42 nrd=0.69047619047619  nrs=0.69047619047619 sa=0 sb=0 sd=0 mult=1 m=1
XMRD_op0_n100_s1_w7p5_0 rbl_op0_n100_s1_w7p5 sn_op0_n100_s1_w7p5_0 rwls_op0_n100_s1_w7p5 0 sky130_fd_pr__nfet_01v8 L=0.15 W=0.42 nf=1 ad=0.1218 as=0.1218 pd=1.42 ps=1.42 nrd=0.69047619047619  nrs=0.69047619047619 sa=0 sb=0 sd=0 mult=1 m=1
csn_op0_n100_s1_w7p5_0 sn_op0_n100_s1_w7p5_0 0 {C_SN}
XMWR_op0_n100_s1_w7p5_1 sn_op0_n100_s1_w7p5_1 wwl_des wbl_op0_n100_s1_w7p5 0 sky130_fd_pr__nfet_01v8 L=0.15 W=0.42 nf=1 ad=0.1218 as=0.1218 pd=1.42 ps=1.42 nrd=0.69047619047619  nrs=0.69047619047619 sa=0 sb=0 sd=0 mult=1 m=1
XMRD_op0_n100_s1_w7p5_1 rbl_op0_n100_s1_w7p5 sn_op0_n100_s1_w7p5_1 rwl_des 0 sky130_fd_pr__nfet_01v8 L=0.15 W=0.42 nf=1 ad=0.1218 as=0.1218 pd=1.42 ps=1.42 nrd=0.69047619047619  nrs=0.69047619047619 sa=0 sb=0 sd=0 mult=1 m=1
csn_op0_n100_s1_w7p5_1 sn_op0_n100_s1_w7p5_1 0 {C_SN}
XMWR_op0_n100_s1_w7p5_2 sn_op0_n100_s1_w7p5_2 wwl_des wbl_op0_n100_s1_w7p5 0 sky130_fd_pr__nfet_01v8 L=0.15 W=0.42 nf=1 ad=0.1218 as=0.1218 pd=1.42 ps=1.42 nrd=0.69047619047619  nrs=0.69047619047619 sa=0 sb=0 sd=0 mult=1 m=1
XMRD_op0_n100_s1_w7p5_2 rbl_op0_n100_s1_w7p5 sn_op0_n100_s1_w7p5_2 rwl_des 0 sky130_fd_pr__nfet_01v8 L=0.15 W=0.42 nf=1 ad=0.1218 as=0.1218 pd=1.42 ps=1.42 nrd=0.69047619047619  nrs=0.69047619047619 sa=0 sb=0 sd=0 mult=1 m=1
csn_op0_n100_s1_w7p5_2 sn_op0_n100_s1_w7p5_2 0 {C_SN}
XMWR_op0_n100_s1_w7p5_3 sn_op0_n100_s1_w7p5_3 wwl_des wbl_op0_n100_s1_w7p5 0 sky130_fd_pr__nfet_01v8 L=0.15 W=0.42 nf=1 ad=0.1218 as=0.1218 pd=1.42 ps=1.42 nrd=0.69047619047619  nrs=0.69047619047619 sa=0 sb=0 sd=0 mult=1 m=1
XMRD_op0_n100_s1_w7p5_3 rbl_op0_n100_s1_w7p5 sn_op0_n100_s1_w7p5_3 rwl_des 0 sky130_fd_pr__nfet_01v8 L=0.15 W=0.42 nf=1 ad=0.1218 as=0.1218 pd=1.42 ps=1.42 nrd=0.69047619047619  nrs=0.69047619047619 sa=0 sb=0 sd=0 mult=1 m=1
csn_op0_n100_s1_w7p5_3 sn_op0_n100_s1_w7p5_3 0 {C_SN}
XMN1_op0_n100_s1_w7p5 rbl_op0_n100_s1_w7p5 ref_op0_n100_s1_w7p5 vn_op0_n100_s1_w7p5 0 sky130_fd_pr__nfet_01v8 L=0.15 W=1 nf=1 ad=0.29 as=0.29 pd=2.58 ps=2.58 mult=1 m=1
XMN2_op0_n100_s1_w7p5 ref_op0_n100_s1_w7p5 rbl_op0_n100_s1_w7p5 vn_op0_n100_s1_w7p5 0 sky130_fd_pr__nfet_01v8 L=0.15 W=1 nf=1 ad=0.29 as=0.29 pd=2.58 ps=2.58 mult=1 m=1
XMP1_op0_n100_s1_w7p5 rbl_op0_n100_s1_w7p5 ref_op0_n100_s1_w7p5 vp_op0_n100_s1_w7p5 vdd sky130_fd_pr__pfet_01v8 L=0.15 W=2 nf=1 ad=0.58 as=0.58 pd=4.58 ps=4.58 mult=1 m=1
XMP2_op0_n100_s1_w7p5 ref_op0_n100_s1_w7p5 rbl_op0_n100_s1_w7p5 vp_op0_n100_s1_w7p5 vdd sky130_fd_pr__pfet_01v8 L=0.15 W=2 nf=1 ad=0.58 as=0.58 pd=4.58 ps=4.58 mult=1 m=1
XMNF_op0_n100_s1_w7p5 vn_op0_n100_s1_w7p5 en_op0_n100_s1_w7p5 0 0 sky130_fd_pr__nfet_01v8 L=0.15 W=2 nf=1 ad=0.58 as=0.58 pd=4.58 ps=4.58 mult=1 m=1
XMPH_op0_n100_s1_w7p5 vp_op0_n100_s1_w7p5 enb_op0_n100_s1_w7p5 vdd vdd sky130_fd_pr__pfet_01v8 L=0.15 W=4 nf=1 ad=1.16 as=1.16 pd=8.58 ps=8.58 mult=1 m=1
bd_op0_n100_s1_w7p5 d_op0_n100_s1_w7p5 0 v=v(rbl_op0_n100_s1_w7p5)-v(ref_op0_n100_s1_w7p5)

* ---- instance 139: op0_n100_s1_w10 (t_en 5 ns, WWL 6..16 ns, release 18 ns) ----
ven_op0_n100_s1_w10  en_op0_n100_s1_w10  0 pwl(0 0 5.0000e-09 0 5.1000e-09 {VDD} 1.8000e-08 {VDD} 1.8100e-08 0)
venb_op0_n100_s1_w10 enb_op0_n100_s1_w10 0 pwl(0 {VDD} 5.0000e-09 {VDD} 5.1000e-09 0 1.8000e-08 0 1.8100e-08 {VDD})
vrs_op0_n100_s1_w10  rwls_op0_n100_s1_w10 0 pwl(0 {VDD} {T_READ} {VDD} {T_READ+TEDGE} 0 1.8000e-08 0 1.8100e-08 {VDD})
vww_op0_n100_s1_w10  wwl_op0_n100_s1_w10 0 pwl(0 0 6.0000e-09 0 6.1000e-09 {VDD} 1.6000e-08 {VDD} 1.6100e-08 0)
vwc_op0_n100_s1_w10  wbc_op0_n100_s1_w10 0 pwl(0 0 6.0000e-09 0 6.1000e-09 {VDD} 1.8000e-08 {VDD} 1.8100e-08 0)
swb_op0_n100_s1_w10 ref_op0_n100_s1_w10 wbl_op0_n100_s1_w10 wbc_op0_n100_s1_w10 0 swwbl
cwbl_op0_n100_s1_w10 wbl_op0_n100_s1_w10 0 {C_WBL}
spa_op0_n100_s1_w10 prea rbl_op0_n100_s1_w10 ctl 0 swpre
spr_op0_n100_s1_w10 pref ref_op0_n100_s1_w10 ctl 0 swpre
crbl_op0_n100_s1_w10 rbl_op0_n100_s1_w10 0 {C_RBL}
cref_op0_n100_s1_w10 ref_op0_n100_s1_w10 0 {C_RBL}   $ ASSUMPTION: ideal matched dummy load
XMWR_op0_n100_s1_w10_0 sn_op0_n100_s1_w10_0 wwl_op0_n100_s1_w10 wbl_op0_n100_s1_w10 0 sky130_fd_pr__nfet_01v8 L=0.15 W=0.42 nf=1 ad=0.1218 as=0.1218 pd=1.42 ps=1.42 nrd=0.69047619047619  nrs=0.69047619047619 sa=0 sb=0 sd=0 mult=1 m=1
XMRD_op0_n100_s1_w10_0 rbl_op0_n100_s1_w10 sn_op0_n100_s1_w10_0 rwls_op0_n100_s1_w10 0 sky130_fd_pr__nfet_01v8 L=0.15 W=0.42 nf=1 ad=0.1218 as=0.1218 pd=1.42 ps=1.42 nrd=0.69047619047619  nrs=0.69047619047619 sa=0 sb=0 sd=0 mult=1 m=1
csn_op0_n100_s1_w10_0 sn_op0_n100_s1_w10_0 0 {C_SN}
XMWR_op0_n100_s1_w10_1 sn_op0_n100_s1_w10_1 wwl_des wbl_op0_n100_s1_w10 0 sky130_fd_pr__nfet_01v8 L=0.15 W=0.42 nf=1 ad=0.1218 as=0.1218 pd=1.42 ps=1.42 nrd=0.69047619047619  nrs=0.69047619047619 sa=0 sb=0 sd=0 mult=1 m=1
XMRD_op0_n100_s1_w10_1 rbl_op0_n100_s1_w10 sn_op0_n100_s1_w10_1 rwl_des 0 sky130_fd_pr__nfet_01v8 L=0.15 W=0.42 nf=1 ad=0.1218 as=0.1218 pd=1.42 ps=1.42 nrd=0.69047619047619  nrs=0.69047619047619 sa=0 sb=0 sd=0 mult=1 m=1
csn_op0_n100_s1_w10_1 sn_op0_n100_s1_w10_1 0 {C_SN}
XMWR_op0_n100_s1_w10_2 sn_op0_n100_s1_w10_2 wwl_des wbl_op0_n100_s1_w10 0 sky130_fd_pr__nfet_01v8 L=0.15 W=0.42 nf=1 ad=0.1218 as=0.1218 pd=1.42 ps=1.42 nrd=0.69047619047619  nrs=0.69047619047619 sa=0 sb=0 sd=0 mult=1 m=1
XMRD_op0_n100_s1_w10_2 rbl_op0_n100_s1_w10 sn_op0_n100_s1_w10_2 rwl_des 0 sky130_fd_pr__nfet_01v8 L=0.15 W=0.42 nf=1 ad=0.1218 as=0.1218 pd=1.42 ps=1.42 nrd=0.69047619047619  nrs=0.69047619047619 sa=0 sb=0 sd=0 mult=1 m=1
csn_op0_n100_s1_w10_2 sn_op0_n100_s1_w10_2 0 {C_SN}
XMWR_op0_n100_s1_w10_3 sn_op0_n100_s1_w10_3 wwl_des wbl_op0_n100_s1_w10 0 sky130_fd_pr__nfet_01v8 L=0.15 W=0.42 nf=1 ad=0.1218 as=0.1218 pd=1.42 ps=1.42 nrd=0.69047619047619  nrs=0.69047619047619 sa=0 sb=0 sd=0 mult=1 m=1
XMRD_op0_n100_s1_w10_3 rbl_op0_n100_s1_w10 sn_op0_n100_s1_w10_3 rwl_des 0 sky130_fd_pr__nfet_01v8 L=0.15 W=0.42 nf=1 ad=0.1218 as=0.1218 pd=1.42 ps=1.42 nrd=0.69047619047619  nrs=0.69047619047619 sa=0 sb=0 sd=0 mult=1 m=1
csn_op0_n100_s1_w10_3 sn_op0_n100_s1_w10_3 0 {C_SN}
XMN1_op0_n100_s1_w10 rbl_op0_n100_s1_w10 ref_op0_n100_s1_w10 vn_op0_n100_s1_w10 0 sky130_fd_pr__nfet_01v8 L=0.15 W=1 nf=1 ad=0.29 as=0.29 pd=2.58 ps=2.58 mult=1 m=1
XMN2_op0_n100_s1_w10 ref_op0_n100_s1_w10 rbl_op0_n100_s1_w10 vn_op0_n100_s1_w10 0 sky130_fd_pr__nfet_01v8 L=0.15 W=1 nf=1 ad=0.29 as=0.29 pd=2.58 ps=2.58 mult=1 m=1
XMP1_op0_n100_s1_w10 rbl_op0_n100_s1_w10 ref_op0_n100_s1_w10 vp_op0_n100_s1_w10 vdd sky130_fd_pr__pfet_01v8 L=0.15 W=2 nf=1 ad=0.58 as=0.58 pd=4.58 ps=4.58 mult=1 m=1
XMP2_op0_n100_s1_w10 ref_op0_n100_s1_w10 rbl_op0_n100_s1_w10 vp_op0_n100_s1_w10 vdd sky130_fd_pr__pfet_01v8 L=0.15 W=2 nf=1 ad=0.58 as=0.58 pd=4.58 ps=4.58 mult=1 m=1
XMNF_op0_n100_s1_w10 vn_op0_n100_s1_w10 en_op0_n100_s1_w10 0 0 sky130_fd_pr__nfet_01v8 L=0.15 W=2 nf=1 ad=0.58 as=0.58 pd=4.58 ps=4.58 mult=1 m=1
XMPH_op0_n100_s1_w10 vp_op0_n100_s1_w10 enb_op0_n100_s1_w10 vdd vdd sky130_fd_pr__pfet_01v8 L=0.15 W=4 nf=1 ad=1.16 as=1.16 pd=8.58 ps=8.58 mult=1 m=1
bd_op0_n100_s1_w10 d_op0_n100_s1_w10 0 v=v(rbl_op0_n100_s1_w10)-v(ref_op0_n100_s1_w10)

* ---- instance 140: op0_n100_s1_w15 (t_en 5 ns, WWL 6..21 ns, release 23 ns) ----
ven_op0_n100_s1_w15  en_op0_n100_s1_w15  0 pwl(0 0 5.0000e-09 0 5.1000e-09 {VDD} 2.3000e-08 {VDD} 2.3100e-08 0)
venb_op0_n100_s1_w15 enb_op0_n100_s1_w15 0 pwl(0 {VDD} 5.0000e-09 {VDD} 5.1000e-09 0 2.3000e-08 0 2.3100e-08 {VDD})
vrs_op0_n100_s1_w15  rwls_op0_n100_s1_w15 0 pwl(0 {VDD} {T_READ} {VDD} {T_READ+TEDGE} 0 2.3000e-08 0 2.3100e-08 {VDD})
vww_op0_n100_s1_w15  wwl_op0_n100_s1_w15 0 pwl(0 0 6.0000e-09 0 6.1000e-09 {VDD} 2.1000e-08 {VDD} 2.1100e-08 0)
vwc_op0_n100_s1_w15  wbc_op0_n100_s1_w15 0 pwl(0 0 6.0000e-09 0 6.1000e-09 {VDD} 2.3000e-08 {VDD} 2.3100e-08 0)
swb_op0_n100_s1_w15 ref_op0_n100_s1_w15 wbl_op0_n100_s1_w15 wbc_op0_n100_s1_w15 0 swwbl
cwbl_op0_n100_s1_w15 wbl_op0_n100_s1_w15 0 {C_WBL}
spa_op0_n100_s1_w15 prea rbl_op0_n100_s1_w15 ctl 0 swpre
spr_op0_n100_s1_w15 pref ref_op0_n100_s1_w15 ctl 0 swpre
crbl_op0_n100_s1_w15 rbl_op0_n100_s1_w15 0 {C_RBL}
cref_op0_n100_s1_w15 ref_op0_n100_s1_w15 0 {C_RBL}   $ ASSUMPTION: ideal matched dummy load
XMWR_op0_n100_s1_w15_0 sn_op0_n100_s1_w15_0 wwl_op0_n100_s1_w15 wbl_op0_n100_s1_w15 0 sky130_fd_pr__nfet_01v8 L=0.15 W=0.42 nf=1 ad=0.1218 as=0.1218 pd=1.42 ps=1.42 nrd=0.69047619047619  nrs=0.69047619047619 sa=0 sb=0 sd=0 mult=1 m=1
XMRD_op0_n100_s1_w15_0 rbl_op0_n100_s1_w15 sn_op0_n100_s1_w15_0 rwls_op0_n100_s1_w15 0 sky130_fd_pr__nfet_01v8 L=0.15 W=0.42 nf=1 ad=0.1218 as=0.1218 pd=1.42 ps=1.42 nrd=0.69047619047619  nrs=0.69047619047619 sa=0 sb=0 sd=0 mult=1 m=1
csn_op0_n100_s1_w15_0 sn_op0_n100_s1_w15_0 0 {C_SN}
XMWR_op0_n100_s1_w15_1 sn_op0_n100_s1_w15_1 wwl_des wbl_op0_n100_s1_w15 0 sky130_fd_pr__nfet_01v8 L=0.15 W=0.42 nf=1 ad=0.1218 as=0.1218 pd=1.42 ps=1.42 nrd=0.69047619047619  nrs=0.69047619047619 sa=0 sb=0 sd=0 mult=1 m=1
XMRD_op0_n100_s1_w15_1 rbl_op0_n100_s1_w15 sn_op0_n100_s1_w15_1 rwl_des 0 sky130_fd_pr__nfet_01v8 L=0.15 W=0.42 nf=1 ad=0.1218 as=0.1218 pd=1.42 ps=1.42 nrd=0.69047619047619  nrs=0.69047619047619 sa=0 sb=0 sd=0 mult=1 m=1
csn_op0_n100_s1_w15_1 sn_op0_n100_s1_w15_1 0 {C_SN}
XMWR_op0_n100_s1_w15_2 sn_op0_n100_s1_w15_2 wwl_des wbl_op0_n100_s1_w15 0 sky130_fd_pr__nfet_01v8 L=0.15 W=0.42 nf=1 ad=0.1218 as=0.1218 pd=1.42 ps=1.42 nrd=0.69047619047619  nrs=0.69047619047619 sa=0 sb=0 sd=0 mult=1 m=1
XMRD_op0_n100_s1_w15_2 rbl_op0_n100_s1_w15 sn_op0_n100_s1_w15_2 rwl_des 0 sky130_fd_pr__nfet_01v8 L=0.15 W=0.42 nf=1 ad=0.1218 as=0.1218 pd=1.42 ps=1.42 nrd=0.69047619047619  nrs=0.69047619047619 sa=0 sb=0 sd=0 mult=1 m=1
csn_op0_n100_s1_w15_2 sn_op0_n100_s1_w15_2 0 {C_SN}
XMWR_op0_n100_s1_w15_3 sn_op0_n100_s1_w15_3 wwl_des wbl_op0_n100_s1_w15 0 sky130_fd_pr__nfet_01v8 L=0.15 W=0.42 nf=1 ad=0.1218 as=0.1218 pd=1.42 ps=1.42 nrd=0.69047619047619  nrs=0.69047619047619 sa=0 sb=0 sd=0 mult=1 m=1
XMRD_op0_n100_s1_w15_3 rbl_op0_n100_s1_w15 sn_op0_n100_s1_w15_3 rwl_des 0 sky130_fd_pr__nfet_01v8 L=0.15 W=0.42 nf=1 ad=0.1218 as=0.1218 pd=1.42 ps=1.42 nrd=0.69047619047619  nrs=0.69047619047619 sa=0 sb=0 sd=0 mult=1 m=1
csn_op0_n100_s1_w15_3 sn_op0_n100_s1_w15_3 0 {C_SN}
XMN1_op0_n100_s1_w15 rbl_op0_n100_s1_w15 ref_op0_n100_s1_w15 vn_op0_n100_s1_w15 0 sky130_fd_pr__nfet_01v8 L=0.15 W=1 nf=1 ad=0.29 as=0.29 pd=2.58 ps=2.58 mult=1 m=1
XMN2_op0_n100_s1_w15 ref_op0_n100_s1_w15 rbl_op0_n100_s1_w15 vn_op0_n100_s1_w15 0 sky130_fd_pr__nfet_01v8 L=0.15 W=1 nf=1 ad=0.29 as=0.29 pd=2.58 ps=2.58 mult=1 m=1
XMP1_op0_n100_s1_w15 rbl_op0_n100_s1_w15 ref_op0_n100_s1_w15 vp_op0_n100_s1_w15 vdd sky130_fd_pr__pfet_01v8 L=0.15 W=2 nf=1 ad=0.58 as=0.58 pd=4.58 ps=4.58 mult=1 m=1
XMP2_op0_n100_s1_w15 ref_op0_n100_s1_w15 rbl_op0_n100_s1_w15 vp_op0_n100_s1_w15 vdd sky130_fd_pr__pfet_01v8 L=0.15 W=2 nf=1 ad=0.58 as=0.58 pd=4.58 ps=4.58 mult=1 m=1
XMNF_op0_n100_s1_w15 vn_op0_n100_s1_w15 en_op0_n100_s1_w15 0 0 sky130_fd_pr__nfet_01v8 L=0.15 W=2 nf=1 ad=0.58 as=0.58 pd=4.58 ps=4.58 mult=1 m=1
XMPH_op0_n100_s1_w15 vp_op0_n100_s1_w15 enb_op0_n100_s1_w15 vdd vdd sky130_fd_pr__pfet_01v8 L=0.15 W=4 nf=1 ad=1.16 as=1.16 pd=8.58 ps=8.58 mult=1 m=1
bd_op0_n100_s1_w15 d_op0_n100_s1_w15 0 v=v(rbl_op0_n100_s1_w15)-v(ref_op0_n100_s1_w15)

* ---- instance 141: op0_n100_s1_w20 (t_en 5 ns, WWL 6..26 ns, release 28 ns) ----
ven_op0_n100_s1_w20  en_op0_n100_s1_w20  0 pwl(0 0 5.0000e-09 0 5.1000e-09 {VDD} 2.8000e-08 {VDD} 2.8100e-08 0)
venb_op0_n100_s1_w20 enb_op0_n100_s1_w20 0 pwl(0 {VDD} 5.0000e-09 {VDD} 5.1000e-09 0 2.8000e-08 0 2.8100e-08 {VDD})
vrs_op0_n100_s1_w20  rwls_op0_n100_s1_w20 0 pwl(0 {VDD} {T_READ} {VDD} {T_READ+TEDGE} 0 2.8000e-08 0 2.8100e-08 {VDD})
vww_op0_n100_s1_w20  wwl_op0_n100_s1_w20 0 pwl(0 0 6.0000e-09 0 6.1000e-09 {VDD} 2.6000e-08 {VDD} 2.6100e-08 0)
vwc_op0_n100_s1_w20  wbc_op0_n100_s1_w20 0 pwl(0 0 6.0000e-09 0 6.1000e-09 {VDD} 2.8000e-08 {VDD} 2.8100e-08 0)
swb_op0_n100_s1_w20 ref_op0_n100_s1_w20 wbl_op0_n100_s1_w20 wbc_op0_n100_s1_w20 0 swwbl
cwbl_op0_n100_s1_w20 wbl_op0_n100_s1_w20 0 {C_WBL}
spa_op0_n100_s1_w20 prea rbl_op0_n100_s1_w20 ctl 0 swpre
spr_op0_n100_s1_w20 pref ref_op0_n100_s1_w20 ctl 0 swpre
crbl_op0_n100_s1_w20 rbl_op0_n100_s1_w20 0 {C_RBL}
cref_op0_n100_s1_w20 ref_op0_n100_s1_w20 0 {C_RBL}   $ ASSUMPTION: ideal matched dummy load
XMWR_op0_n100_s1_w20_0 sn_op0_n100_s1_w20_0 wwl_op0_n100_s1_w20 wbl_op0_n100_s1_w20 0 sky130_fd_pr__nfet_01v8 L=0.15 W=0.42 nf=1 ad=0.1218 as=0.1218 pd=1.42 ps=1.42 nrd=0.69047619047619  nrs=0.69047619047619 sa=0 sb=0 sd=0 mult=1 m=1
XMRD_op0_n100_s1_w20_0 rbl_op0_n100_s1_w20 sn_op0_n100_s1_w20_0 rwls_op0_n100_s1_w20 0 sky130_fd_pr__nfet_01v8 L=0.15 W=0.42 nf=1 ad=0.1218 as=0.1218 pd=1.42 ps=1.42 nrd=0.69047619047619  nrs=0.69047619047619 sa=0 sb=0 sd=0 mult=1 m=1
csn_op0_n100_s1_w20_0 sn_op0_n100_s1_w20_0 0 {C_SN}
XMWR_op0_n100_s1_w20_1 sn_op0_n100_s1_w20_1 wwl_des wbl_op0_n100_s1_w20 0 sky130_fd_pr__nfet_01v8 L=0.15 W=0.42 nf=1 ad=0.1218 as=0.1218 pd=1.42 ps=1.42 nrd=0.69047619047619  nrs=0.69047619047619 sa=0 sb=0 sd=0 mult=1 m=1
XMRD_op0_n100_s1_w20_1 rbl_op0_n100_s1_w20 sn_op0_n100_s1_w20_1 rwl_des 0 sky130_fd_pr__nfet_01v8 L=0.15 W=0.42 nf=1 ad=0.1218 as=0.1218 pd=1.42 ps=1.42 nrd=0.69047619047619  nrs=0.69047619047619 sa=0 sb=0 sd=0 mult=1 m=1
csn_op0_n100_s1_w20_1 sn_op0_n100_s1_w20_1 0 {C_SN}
XMWR_op0_n100_s1_w20_2 sn_op0_n100_s1_w20_2 wwl_des wbl_op0_n100_s1_w20 0 sky130_fd_pr__nfet_01v8 L=0.15 W=0.42 nf=1 ad=0.1218 as=0.1218 pd=1.42 ps=1.42 nrd=0.69047619047619  nrs=0.69047619047619 sa=0 sb=0 sd=0 mult=1 m=1
XMRD_op0_n100_s1_w20_2 rbl_op0_n100_s1_w20 sn_op0_n100_s1_w20_2 rwl_des 0 sky130_fd_pr__nfet_01v8 L=0.15 W=0.42 nf=1 ad=0.1218 as=0.1218 pd=1.42 ps=1.42 nrd=0.69047619047619  nrs=0.69047619047619 sa=0 sb=0 sd=0 mult=1 m=1
csn_op0_n100_s1_w20_2 sn_op0_n100_s1_w20_2 0 {C_SN}
XMWR_op0_n100_s1_w20_3 sn_op0_n100_s1_w20_3 wwl_des wbl_op0_n100_s1_w20 0 sky130_fd_pr__nfet_01v8 L=0.15 W=0.42 nf=1 ad=0.1218 as=0.1218 pd=1.42 ps=1.42 nrd=0.69047619047619  nrs=0.69047619047619 sa=0 sb=0 sd=0 mult=1 m=1
XMRD_op0_n100_s1_w20_3 rbl_op0_n100_s1_w20 sn_op0_n100_s1_w20_3 rwl_des 0 sky130_fd_pr__nfet_01v8 L=0.15 W=0.42 nf=1 ad=0.1218 as=0.1218 pd=1.42 ps=1.42 nrd=0.69047619047619  nrs=0.69047619047619 sa=0 sb=0 sd=0 mult=1 m=1
csn_op0_n100_s1_w20_3 sn_op0_n100_s1_w20_3 0 {C_SN}
XMN1_op0_n100_s1_w20 rbl_op0_n100_s1_w20 ref_op0_n100_s1_w20 vn_op0_n100_s1_w20 0 sky130_fd_pr__nfet_01v8 L=0.15 W=1 nf=1 ad=0.29 as=0.29 pd=2.58 ps=2.58 mult=1 m=1
XMN2_op0_n100_s1_w20 ref_op0_n100_s1_w20 rbl_op0_n100_s1_w20 vn_op0_n100_s1_w20 0 sky130_fd_pr__nfet_01v8 L=0.15 W=1 nf=1 ad=0.29 as=0.29 pd=2.58 ps=2.58 mult=1 m=1
XMP1_op0_n100_s1_w20 rbl_op0_n100_s1_w20 ref_op0_n100_s1_w20 vp_op0_n100_s1_w20 vdd sky130_fd_pr__pfet_01v8 L=0.15 W=2 nf=1 ad=0.58 as=0.58 pd=4.58 ps=4.58 mult=1 m=1
XMP2_op0_n100_s1_w20 ref_op0_n100_s1_w20 rbl_op0_n100_s1_w20 vp_op0_n100_s1_w20 vdd sky130_fd_pr__pfet_01v8 L=0.15 W=2 nf=1 ad=0.58 as=0.58 pd=4.58 ps=4.58 mult=1 m=1
XMNF_op0_n100_s1_w20 vn_op0_n100_s1_w20 en_op0_n100_s1_w20 0 0 sky130_fd_pr__nfet_01v8 L=0.15 W=2 nf=1 ad=0.58 as=0.58 pd=4.58 ps=4.58 mult=1 m=1
XMPH_op0_n100_s1_w20 vp_op0_n100_s1_w20 enb_op0_n100_s1_w20 vdd vdd sky130_fd_pr__pfet_01v8 L=0.15 W=4 nf=1 ad=1.16 as=1.16 pd=8.58 ps=8.58 mult=1 m=1
bd_op0_n100_s1_w20 d_op0_n100_s1_w20 0 v=v(rbl_op0_n100_s1_w20)-v(ref_op0_n100_s1_w20)

* ---- instance 142: op0_n100_s1_w30 (t_en 5 ns, WWL 6..36 ns, release 38 ns) ----
ven_op0_n100_s1_w30  en_op0_n100_s1_w30  0 pwl(0 0 5.0000e-09 0 5.1000e-09 {VDD} 3.8000e-08 {VDD} 3.8100e-08 0)
venb_op0_n100_s1_w30 enb_op0_n100_s1_w30 0 pwl(0 {VDD} 5.0000e-09 {VDD} 5.1000e-09 0 3.8000e-08 0 3.8100e-08 {VDD})
vrs_op0_n100_s1_w30  rwls_op0_n100_s1_w30 0 pwl(0 {VDD} {T_READ} {VDD} {T_READ+TEDGE} 0 3.8000e-08 0 3.8100e-08 {VDD})
vww_op0_n100_s1_w30  wwl_op0_n100_s1_w30 0 pwl(0 0 6.0000e-09 0 6.1000e-09 {VDD} 3.6000e-08 {VDD} 3.6100e-08 0)
vwc_op0_n100_s1_w30  wbc_op0_n100_s1_w30 0 pwl(0 0 6.0000e-09 0 6.1000e-09 {VDD} 3.8000e-08 {VDD} 3.8100e-08 0)
swb_op0_n100_s1_w30 ref_op0_n100_s1_w30 wbl_op0_n100_s1_w30 wbc_op0_n100_s1_w30 0 swwbl
cwbl_op0_n100_s1_w30 wbl_op0_n100_s1_w30 0 {C_WBL}
spa_op0_n100_s1_w30 prea rbl_op0_n100_s1_w30 ctl 0 swpre
spr_op0_n100_s1_w30 pref ref_op0_n100_s1_w30 ctl 0 swpre
crbl_op0_n100_s1_w30 rbl_op0_n100_s1_w30 0 {C_RBL}
cref_op0_n100_s1_w30 ref_op0_n100_s1_w30 0 {C_RBL}   $ ASSUMPTION: ideal matched dummy load
XMWR_op0_n100_s1_w30_0 sn_op0_n100_s1_w30_0 wwl_op0_n100_s1_w30 wbl_op0_n100_s1_w30 0 sky130_fd_pr__nfet_01v8 L=0.15 W=0.42 nf=1 ad=0.1218 as=0.1218 pd=1.42 ps=1.42 nrd=0.69047619047619  nrs=0.69047619047619 sa=0 sb=0 sd=0 mult=1 m=1
XMRD_op0_n100_s1_w30_0 rbl_op0_n100_s1_w30 sn_op0_n100_s1_w30_0 rwls_op0_n100_s1_w30 0 sky130_fd_pr__nfet_01v8 L=0.15 W=0.42 nf=1 ad=0.1218 as=0.1218 pd=1.42 ps=1.42 nrd=0.69047619047619  nrs=0.69047619047619 sa=0 sb=0 sd=0 mult=1 m=1
csn_op0_n100_s1_w30_0 sn_op0_n100_s1_w30_0 0 {C_SN}
XMWR_op0_n100_s1_w30_1 sn_op0_n100_s1_w30_1 wwl_des wbl_op0_n100_s1_w30 0 sky130_fd_pr__nfet_01v8 L=0.15 W=0.42 nf=1 ad=0.1218 as=0.1218 pd=1.42 ps=1.42 nrd=0.69047619047619  nrs=0.69047619047619 sa=0 sb=0 sd=0 mult=1 m=1
XMRD_op0_n100_s1_w30_1 rbl_op0_n100_s1_w30 sn_op0_n100_s1_w30_1 rwl_des 0 sky130_fd_pr__nfet_01v8 L=0.15 W=0.42 nf=1 ad=0.1218 as=0.1218 pd=1.42 ps=1.42 nrd=0.69047619047619  nrs=0.69047619047619 sa=0 sb=0 sd=0 mult=1 m=1
csn_op0_n100_s1_w30_1 sn_op0_n100_s1_w30_1 0 {C_SN}
XMWR_op0_n100_s1_w30_2 sn_op0_n100_s1_w30_2 wwl_des wbl_op0_n100_s1_w30 0 sky130_fd_pr__nfet_01v8 L=0.15 W=0.42 nf=1 ad=0.1218 as=0.1218 pd=1.42 ps=1.42 nrd=0.69047619047619  nrs=0.69047619047619 sa=0 sb=0 sd=0 mult=1 m=1
XMRD_op0_n100_s1_w30_2 rbl_op0_n100_s1_w30 sn_op0_n100_s1_w30_2 rwl_des 0 sky130_fd_pr__nfet_01v8 L=0.15 W=0.42 nf=1 ad=0.1218 as=0.1218 pd=1.42 ps=1.42 nrd=0.69047619047619  nrs=0.69047619047619 sa=0 sb=0 sd=0 mult=1 m=1
csn_op0_n100_s1_w30_2 sn_op0_n100_s1_w30_2 0 {C_SN}
XMWR_op0_n100_s1_w30_3 sn_op0_n100_s1_w30_3 wwl_des wbl_op0_n100_s1_w30 0 sky130_fd_pr__nfet_01v8 L=0.15 W=0.42 nf=1 ad=0.1218 as=0.1218 pd=1.42 ps=1.42 nrd=0.69047619047619  nrs=0.69047619047619 sa=0 sb=0 sd=0 mult=1 m=1
XMRD_op0_n100_s1_w30_3 rbl_op0_n100_s1_w30 sn_op0_n100_s1_w30_3 rwl_des 0 sky130_fd_pr__nfet_01v8 L=0.15 W=0.42 nf=1 ad=0.1218 as=0.1218 pd=1.42 ps=1.42 nrd=0.69047619047619  nrs=0.69047619047619 sa=0 sb=0 sd=0 mult=1 m=1
csn_op0_n100_s1_w30_3 sn_op0_n100_s1_w30_3 0 {C_SN}
XMN1_op0_n100_s1_w30 rbl_op0_n100_s1_w30 ref_op0_n100_s1_w30 vn_op0_n100_s1_w30 0 sky130_fd_pr__nfet_01v8 L=0.15 W=1 nf=1 ad=0.29 as=0.29 pd=2.58 ps=2.58 mult=1 m=1
XMN2_op0_n100_s1_w30 ref_op0_n100_s1_w30 rbl_op0_n100_s1_w30 vn_op0_n100_s1_w30 0 sky130_fd_pr__nfet_01v8 L=0.15 W=1 nf=1 ad=0.29 as=0.29 pd=2.58 ps=2.58 mult=1 m=1
XMP1_op0_n100_s1_w30 rbl_op0_n100_s1_w30 ref_op0_n100_s1_w30 vp_op0_n100_s1_w30 vdd sky130_fd_pr__pfet_01v8 L=0.15 W=2 nf=1 ad=0.58 as=0.58 pd=4.58 ps=4.58 mult=1 m=1
XMP2_op0_n100_s1_w30 ref_op0_n100_s1_w30 rbl_op0_n100_s1_w30 vp_op0_n100_s1_w30 vdd sky130_fd_pr__pfet_01v8 L=0.15 W=2 nf=1 ad=0.58 as=0.58 pd=4.58 ps=4.58 mult=1 m=1
XMNF_op0_n100_s1_w30 vn_op0_n100_s1_w30 en_op0_n100_s1_w30 0 0 sky130_fd_pr__nfet_01v8 L=0.15 W=2 nf=1 ad=0.58 as=0.58 pd=4.58 ps=4.58 mult=1 m=1
XMPH_op0_n100_s1_w30 vp_op0_n100_s1_w30 enb_op0_n100_s1_w30 vdd vdd sky130_fd_pr__pfet_01v8 L=0.15 W=4 nf=1 ad=1.16 as=1.16 pd=8.58 ps=8.58 mult=1 m=1
bd_op0_n100_s1_w30 d_op0_n100_s1_w30 0 v=v(rbl_op0_n100_s1_w30)-v(ref_op0_n100_s1_w30)

* ---- instance 143: op0_n100_s1_w50 (t_en 5 ns, WWL 6..56 ns, release 58 ns) ----
ven_op0_n100_s1_w50  en_op0_n100_s1_w50  0 pwl(0 0 5.0000e-09 0 5.1000e-09 {VDD} 5.8000e-08 {VDD} 5.8100e-08 0)
venb_op0_n100_s1_w50 enb_op0_n100_s1_w50 0 pwl(0 {VDD} 5.0000e-09 {VDD} 5.1000e-09 0 5.8000e-08 0 5.8100e-08 {VDD})
vrs_op0_n100_s1_w50  rwls_op0_n100_s1_w50 0 pwl(0 {VDD} {T_READ} {VDD} {T_READ+TEDGE} 0 5.8000e-08 0 5.8100e-08 {VDD})
vww_op0_n100_s1_w50  wwl_op0_n100_s1_w50 0 pwl(0 0 6.0000e-09 0 6.1000e-09 {VDD} 5.6000e-08 {VDD} 5.6100e-08 0)
vwc_op0_n100_s1_w50  wbc_op0_n100_s1_w50 0 pwl(0 0 6.0000e-09 0 6.1000e-09 {VDD} 5.8000e-08 {VDD} 5.8100e-08 0)
swb_op0_n100_s1_w50 ref_op0_n100_s1_w50 wbl_op0_n100_s1_w50 wbc_op0_n100_s1_w50 0 swwbl
cwbl_op0_n100_s1_w50 wbl_op0_n100_s1_w50 0 {C_WBL}
spa_op0_n100_s1_w50 prea rbl_op0_n100_s1_w50 ctl 0 swpre
spr_op0_n100_s1_w50 pref ref_op0_n100_s1_w50 ctl 0 swpre
crbl_op0_n100_s1_w50 rbl_op0_n100_s1_w50 0 {C_RBL}
cref_op0_n100_s1_w50 ref_op0_n100_s1_w50 0 {C_RBL}   $ ASSUMPTION: ideal matched dummy load
XMWR_op0_n100_s1_w50_0 sn_op0_n100_s1_w50_0 wwl_op0_n100_s1_w50 wbl_op0_n100_s1_w50 0 sky130_fd_pr__nfet_01v8 L=0.15 W=0.42 nf=1 ad=0.1218 as=0.1218 pd=1.42 ps=1.42 nrd=0.69047619047619  nrs=0.69047619047619 sa=0 sb=0 sd=0 mult=1 m=1
XMRD_op0_n100_s1_w50_0 rbl_op0_n100_s1_w50 sn_op0_n100_s1_w50_0 rwls_op0_n100_s1_w50 0 sky130_fd_pr__nfet_01v8 L=0.15 W=0.42 nf=1 ad=0.1218 as=0.1218 pd=1.42 ps=1.42 nrd=0.69047619047619  nrs=0.69047619047619 sa=0 sb=0 sd=0 mult=1 m=1
csn_op0_n100_s1_w50_0 sn_op0_n100_s1_w50_0 0 {C_SN}
XMWR_op0_n100_s1_w50_1 sn_op0_n100_s1_w50_1 wwl_des wbl_op0_n100_s1_w50 0 sky130_fd_pr__nfet_01v8 L=0.15 W=0.42 nf=1 ad=0.1218 as=0.1218 pd=1.42 ps=1.42 nrd=0.69047619047619  nrs=0.69047619047619 sa=0 sb=0 sd=0 mult=1 m=1
XMRD_op0_n100_s1_w50_1 rbl_op0_n100_s1_w50 sn_op0_n100_s1_w50_1 rwl_des 0 sky130_fd_pr__nfet_01v8 L=0.15 W=0.42 nf=1 ad=0.1218 as=0.1218 pd=1.42 ps=1.42 nrd=0.69047619047619  nrs=0.69047619047619 sa=0 sb=0 sd=0 mult=1 m=1
csn_op0_n100_s1_w50_1 sn_op0_n100_s1_w50_1 0 {C_SN}
XMWR_op0_n100_s1_w50_2 sn_op0_n100_s1_w50_2 wwl_des wbl_op0_n100_s1_w50 0 sky130_fd_pr__nfet_01v8 L=0.15 W=0.42 nf=1 ad=0.1218 as=0.1218 pd=1.42 ps=1.42 nrd=0.69047619047619  nrs=0.69047619047619 sa=0 sb=0 sd=0 mult=1 m=1
XMRD_op0_n100_s1_w50_2 rbl_op0_n100_s1_w50 sn_op0_n100_s1_w50_2 rwl_des 0 sky130_fd_pr__nfet_01v8 L=0.15 W=0.42 nf=1 ad=0.1218 as=0.1218 pd=1.42 ps=1.42 nrd=0.69047619047619  nrs=0.69047619047619 sa=0 sb=0 sd=0 mult=1 m=1
csn_op0_n100_s1_w50_2 sn_op0_n100_s1_w50_2 0 {C_SN}
XMWR_op0_n100_s1_w50_3 sn_op0_n100_s1_w50_3 wwl_des wbl_op0_n100_s1_w50 0 sky130_fd_pr__nfet_01v8 L=0.15 W=0.42 nf=1 ad=0.1218 as=0.1218 pd=1.42 ps=1.42 nrd=0.69047619047619  nrs=0.69047619047619 sa=0 sb=0 sd=0 mult=1 m=1
XMRD_op0_n100_s1_w50_3 rbl_op0_n100_s1_w50 sn_op0_n100_s1_w50_3 rwl_des 0 sky130_fd_pr__nfet_01v8 L=0.15 W=0.42 nf=1 ad=0.1218 as=0.1218 pd=1.42 ps=1.42 nrd=0.69047619047619  nrs=0.69047619047619 sa=0 sb=0 sd=0 mult=1 m=1
csn_op0_n100_s1_w50_3 sn_op0_n100_s1_w50_3 0 {C_SN}
XMN1_op0_n100_s1_w50 rbl_op0_n100_s1_w50 ref_op0_n100_s1_w50 vn_op0_n100_s1_w50 0 sky130_fd_pr__nfet_01v8 L=0.15 W=1 nf=1 ad=0.29 as=0.29 pd=2.58 ps=2.58 mult=1 m=1
XMN2_op0_n100_s1_w50 ref_op0_n100_s1_w50 rbl_op0_n100_s1_w50 vn_op0_n100_s1_w50 0 sky130_fd_pr__nfet_01v8 L=0.15 W=1 nf=1 ad=0.29 as=0.29 pd=2.58 ps=2.58 mult=1 m=1
XMP1_op0_n100_s1_w50 rbl_op0_n100_s1_w50 ref_op0_n100_s1_w50 vp_op0_n100_s1_w50 vdd sky130_fd_pr__pfet_01v8 L=0.15 W=2 nf=1 ad=0.58 as=0.58 pd=4.58 ps=4.58 mult=1 m=1
XMP2_op0_n100_s1_w50 ref_op0_n100_s1_w50 rbl_op0_n100_s1_w50 vp_op0_n100_s1_w50 vdd sky130_fd_pr__pfet_01v8 L=0.15 W=2 nf=1 ad=0.58 as=0.58 pd=4.58 ps=4.58 mult=1 m=1
XMNF_op0_n100_s1_w50 vn_op0_n100_s1_w50 en_op0_n100_s1_w50 0 0 sky130_fd_pr__nfet_01v8 L=0.15 W=2 nf=1 ad=0.58 as=0.58 pd=4.58 ps=4.58 mult=1 m=1
XMPH_op0_n100_s1_w50 vp_op0_n100_s1_w50 enb_op0_n100_s1_w50 vdd vdd sky130_fd_pr__pfet_01v8 L=0.15 W=4 nf=1 ad=1.16 as=1.16 pd=8.58 ps=8.58 mult=1 m=1
bd_op0_n100_s1_w50 d_op0_n100_s1_w50 0 v=v(rbl_op0_n100_s1_w50)-v(ref_op0_n100_s1_w50)

* ---- instance 144: op0_n100_s2_w0p2 (t_en 6 ns, WWL 7..7.2 ns, release 9.2 ns) ----
ven_op0_n100_s2_w0p2  en_op0_n100_s2_w0p2  0 pwl(0 0 6.0000e-09 0 6.1000e-09 {VDD} 9.2000e-09 {VDD} 9.3000e-09 0)
venb_op0_n100_s2_w0p2 enb_op0_n100_s2_w0p2 0 pwl(0 {VDD} 6.0000e-09 {VDD} 6.1000e-09 0 9.2000e-09 0 9.3000e-09 {VDD})
vrs_op0_n100_s2_w0p2  rwls_op0_n100_s2_w0p2 0 pwl(0 {VDD} {T_READ} {VDD} {T_READ+TEDGE} 0 9.2000e-09 0 9.3000e-09 {VDD})
vww_op0_n100_s2_w0p2  wwl_op0_n100_s2_w0p2 0 pwl(0 0 7.0000e-09 0 7.1000e-09 {VDD} 7.2000e-09 {VDD} 7.3000e-09 0)
vwc_op0_n100_s2_w0p2  wbc_op0_n100_s2_w0p2 0 pwl(0 0 7.0000e-09 0 7.1000e-09 {VDD} 9.2000e-09 {VDD} 9.3000e-09 0)
swb_op0_n100_s2_w0p2 ref_op0_n100_s2_w0p2 wbl_op0_n100_s2_w0p2 wbc_op0_n100_s2_w0p2 0 swwbl
cwbl_op0_n100_s2_w0p2 wbl_op0_n100_s2_w0p2 0 {C_WBL}
spa_op0_n100_s2_w0p2 prea rbl_op0_n100_s2_w0p2 ctl 0 swpre
spr_op0_n100_s2_w0p2 pref ref_op0_n100_s2_w0p2 ctl 0 swpre
crbl_op0_n100_s2_w0p2 rbl_op0_n100_s2_w0p2 0 {C_RBL}
cref_op0_n100_s2_w0p2 ref_op0_n100_s2_w0p2 0 {C_RBL}   $ ASSUMPTION: ideal matched dummy load
XMWR_op0_n100_s2_w0p2_0 sn_op0_n100_s2_w0p2_0 wwl_op0_n100_s2_w0p2 wbl_op0_n100_s2_w0p2 0 sky130_fd_pr__nfet_01v8 L=0.15 W=0.42 nf=1 ad=0.1218 as=0.1218 pd=1.42 ps=1.42 nrd=0.69047619047619  nrs=0.69047619047619 sa=0 sb=0 sd=0 mult=1 m=1
XMRD_op0_n100_s2_w0p2_0 rbl_op0_n100_s2_w0p2 sn_op0_n100_s2_w0p2_0 rwls_op0_n100_s2_w0p2 0 sky130_fd_pr__nfet_01v8 L=0.15 W=0.42 nf=1 ad=0.1218 as=0.1218 pd=1.42 ps=1.42 nrd=0.69047619047619  nrs=0.69047619047619 sa=0 sb=0 sd=0 mult=1 m=1
csn_op0_n100_s2_w0p2_0 sn_op0_n100_s2_w0p2_0 0 {C_SN}
XMWR_op0_n100_s2_w0p2_1 sn_op0_n100_s2_w0p2_1 wwl_des wbl_op0_n100_s2_w0p2 0 sky130_fd_pr__nfet_01v8 L=0.15 W=0.42 nf=1 ad=0.1218 as=0.1218 pd=1.42 ps=1.42 nrd=0.69047619047619  nrs=0.69047619047619 sa=0 sb=0 sd=0 mult=1 m=1
XMRD_op0_n100_s2_w0p2_1 rbl_op0_n100_s2_w0p2 sn_op0_n100_s2_w0p2_1 rwl_des 0 sky130_fd_pr__nfet_01v8 L=0.15 W=0.42 nf=1 ad=0.1218 as=0.1218 pd=1.42 ps=1.42 nrd=0.69047619047619  nrs=0.69047619047619 sa=0 sb=0 sd=0 mult=1 m=1
csn_op0_n100_s2_w0p2_1 sn_op0_n100_s2_w0p2_1 0 {C_SN}
XMWR_op0_n100_s2_w0p2_2 sn_op0_n100_s2_w0p2_2 wwl_des wbl_op0_n100_s2_w0p2 0 sky130_fd_pr__nfet_01v8 L=0.15 W=0.42 nf=1 ad=0.1218 as=0.1218 pd=1.42 ps=1.42 nrd=0.69047619047619  nrs=0.69047619047619 sa=0 sb=0 sd=0 mult=1 m=1
XMRD_op0_n100_s2_w0p2_2 rbl_op0_n100_s2_w0p2 sn_op0_n100_s2_w0p2_2 rwl_des 0 sky130_fd_pr__nfet_01v8 L=0.15 W=0.42 nf=1 ad=0.1218 as=0.1218 pd=1.42 ps=1.42 nrd=0.69047619047619  nrs=0.69047619047619 sa=0 sb=0 sd=0 mult=1 m=1
csn_op0_n100_s2_w0p2_2 sn_op0_n100_s2_w0p2_2 0 {C_SN}
XMWR_op0_n100_s2_w0p2_3 sn_op0_n100_s2_w0p2_3 wwl_des wbl_op0_n100_s2_w0p2 0 sky130_fd_pr__nfet_01v8 L=0.15 W=0.42 nf=1 ad=0.1218 as=0.1218 pd=1.42 ps=1.42 nrd=0.69047619047619  nrs=0.69047619047619 sa=0 sb=0 sd=0 mult=1 m=1
XMRD_op0_n100_s2_w0p2_3 rbl_op0_n100_s2_w0p2 sn_op0_n100_s2_w0p2_3 rwl_des 0 sky130_fd_pr__nfet_01v8 L=0.15 W=0.42 nf=1 ad=0.1218 as=0.1218 pd=1.42 ps=1.42 nrd=0.69047619047619  nrs=0.69047619047619 sa=0 sb=0 sd=0 mult=1 m=1
csn_op0_n100_s2_w0p2_3 sn_op0_n100_s2_w0p2_3 0 {C_SN}
XMN1_op0_n100_s2_w0p2 rbl_op0_n100_s2_w0p2 ref_op0_n100_s2_w0p2 vn_op0_n100_s2_w0p2 0 sky130_fd_pr__nfet_01v8 L=0.15 W=1 nf=1 ad=0.29 as=0.29 pd=2.58 ps=2.58 mult=1 m=1
XMN2_op0_n100_s2_w0p2 ref_op0_n100_s2_w0p2 rbl_op0_n100_s2_w0p2 vn_op0_n100_s2_w0p2 0 sky130_fd_pr__nfet_01v8 L=0.15 W=1 nf=1 ad=0.29 as=0.29 pd=2.58 ps=2.58 mult=1 m=1
XMP1_op0_n100_s2_w0p2 rbl_op0_n100_s2_w0p2 ref_op0_n100_s2_w0p2 vp_op0_n100_s2_w0p2 vdd sky130_fd_pr__pfet_01v8 L=0.15 W=2 nf=1 ad=0.58 as=0.58 pd=4.58 ps=4.58 mult=1 m=1
XMP2_op0_n100_s2_w0p2 ref_op0_n100_s2_w0p2 rbl_op0_n100_s2_w0p2 vp_op0_n100_s2_w0p2 vdd sky130_fd_pr__pfet_01v8 L=0.15 W=2 nf=1 ad=0.58 as=0.58 pd=4.58 ps=4.58 mult=1 m=1
XMNF_op0_n100_s2_w0p2 vn_op0_n100_s2_w0p2 en_op0_n100_s2_w0p2 0 0 sky130_fd_pr__nfet_01v8 L=0.15 W=2 nf=1 ad=0.58 as=0.58 pd=4.58 ps=4.58 mult=1 m=1
XMPH_op0_n100_s2_w0p2 vp_op0_n100_s2_w0p2 enb_op0_n100_s2_w0p2 vdd vdd sky130_fd_pr__pfet_01v8 L=0.15 W=4 nf=1 ad=1.16 as=1.16 pd=8.58 ps=8.58 mult=1 m=1
bd_op0_n100_s2_w0p2 d_op0_n100_s2_w0p2 0 v=v(rbl_op0_n100_s2_w0p2)-v(ref_op0_n100_s2_w0p2)

* ---- instance 145: op0_n100_s2_w0p5 (t_en 6 ns, WWL 7..7.5 ns, release 9.5 ns) ----
ven_op0_n100_s2_w0p5  en_op0_n100_s2_w0p5  0 pwl(0 0 6.0000e-09 0 6.1000e-09 {VDD} 9.5000e-09 {VDD} 9.6000e-09 0)
venb_op0_n100_s2_w0p5 enb_op0_n100_s2_w0p5 0 pwl(0 {VDD} 6.0000e-09 {VDD} 6.1000e-09 0 9.5000e-09 0 9.6000e-09 {VDD})
vrs_op0_n100_s2_w0p5  rwls_op0_n100_s2_w0p5 0 pwl(0 {VDD} {T_READ} {VDD} {T_READ+TEDGE} 0 9.5000e-09 0 9.6000e-09 {VDD})
vww_op0_n100_s2_w0p5  wwl_op0_n100_s2_w0p5 0 pwl(0 0 7.0000e-09 0 7.1000e-09 {VDD} 7.5000e-09 {VDD} 7.6000e-09 0)
vwc_op0_n100_s2_w0p5  wbc_op0_n100_s2_w0p5 0 pwl(0 0 7.0000e-09 0 7.1000e-09 {VDD} 9.5000e-09 {VDD} 9.6000e-09 0)
swb_op0_n100_s2_w0p5 ref_op0_n100_s2_w0p5 wbl_op0_n100_s2_w0p5 wbc_op0_n100_s2_w0p5 0 swwbl
cwbl_op0_n100_s2_w0p5 wbl_op0_n100_s2_w0p5 0 {C_WBL}
spa_op0_n100_s2_w0p5 prea rbl_op0_n100_s2_w0p5 ctl 0 swpre
spr_op0_n100_s2_w0p5 pref ref_op0_n100_s2_w0p5 ctl 0 swpre
crbl_op0_n100_s2_w0p5 rbl_op0_n100_s2_w0p5 0 {C_RBL}
cref_op0_n100_s2_w0p5 ref_op0_n100_s2_w0p5 0 {C_RBL}   $ ASSUMPTION: ideal matched dummy load
XMWR_op0_n100_s2_w0p5_0 sn_op0_n100_s2_w0p5_0 wwl_op0_n100_s2_w0p5 wbl_op0_n100_s2_w0p5 0 sky130_fd_pr__nfet_01v8 L=0.15 W=0.42 nf=1 ad=0.1218 as=0.1218 pd=1.42 ps=1.42 nrd=0.69047619047619  nrs=0.69047619047619 sa=0 sb=0 sd=0 mult=1 m=1
XMRD_op0_n100_s2_w0p5_0 rbl_op0_n100_s2_w0p5 sn_op0_n100_s2_w0p5_0 rwls_op0_n100_s2_w0p5 0 sky130_fd_pr__nfet_01v8 L=0.15 W=0.42 nf=1 ad=0.1218 as=0.1218 pd=1.42 ps=1.42 nrd=0.69047619047619  nrs=0.69047619047619 sa=0 sb=0 sd=0 mult=1 m=1
csn_op0_n100_s2_w0p5_0 sn_op0_n100_s2_w0p5_0 0 {C_SN}
XMWR_op0_n100_s2_w0p5_1 sn_op0_n100_s2_w0p5_1 wwl_des wbl_op0_n100_s2_w0p5 0 sky130_fd_pr__nfet_01v8 L=0.15 W=0.42 nf=1 ad=0.1218 as=0.1218 pd=1.42 ps=1.42 nrd=0.69047619047619  nrs=0.69047619047619 sa=0 sb=0 sd=0 mult=1 m=1
XMRD_op0_n100_s2_w0p5_1 rbl_op0_n100_s2_w0p5 sn_op0_n100_s2_w0p5_1 rwl_des 0 sky130_fd_pr__nfet_01v8 L=0.15 W=0.42 nf=1 ad=0.1218 as=0.1218 pd=1.42 ps=1.42 nrd=0.69047619047619  nrs=0.69047619047619 sa=0 sb=0 sd=0 mult=1 m=1
csn_op0_n100_s2_w0p5_1 sn_op0_n100_s2_w0p5_1 0 {C_SN}
XMWR_op0_n100_s2_w0p5_2 sn_op0_n100_s2_w0p5_2 wwl_des wbl_op0_n100_s2_w0p5 0 sky130_fd_pr__nfet_01v8 L=0.15 W=0.42 nf=1 ad=0.1218 as=0.1218 pd=1.42 ps=1.42 nrd=0.69047619047619  nrs=0.69047619047619 sa=0 sb=0 sd=0 mult=1 m=1
XMRD_op0_n100_s2_w0p5_2 rbl_op0_n100_s2_w0p5 sn_op0_n100_s2_w0p5_2 rwl_des 0 sky130_fd_pr__nfet_01v8 L=0.15 W=0.42 nf=1 ad=0.1218 as=0.1218 pd=1.42 ps=1.42 nrd=0.69047619047619  nrs=0.69047619047619 sa=0 sb=0 sd=0 mult=1 m=1
csn_op0_n100_s2_w0p5_2 sn_op0_n100_s2_w0p5_2 0 {C_SN}
XMWR_op0_n100_s2_w0p5_3 sn_op0_n100_s2_w0p5_3 wwl_des wbl_op0_n100_s2_w0p5 0 sky130_fd_pr__nfet_01v8 L=0.15 W=0.42 nf=1 ad=0.1218 as=0.1218 pd=1.42 ps=1.42 nrd=0.69047619047619  nrs=0.69047619047619 sa=0 sb=0 sd=0 mult=1 m=1
XMRD_op0_n100_s2_w0p5_3 rbl_op0_n100_s2_w0p5 sn_op0_n100_s2_w0p5_3 rwl_des 0 sky130_fd_pr__nfet_01v8 L=0.15 W=0.42 nf=1 ad=0.1218 as=0.1218 pd=1.42 ps=1.42 nrd=0.69047619047619  nrs=0.69047619047619 sa=0 sb=0 sd=0 mult=1 m=1
csn_op0_n100_s2_w0p5_3 sn_op0_n100_s2_w0p5_3 0 {C_SN}
XMN1_op0_n100_s2_w0p5 rbl_op0_n100_s2_w0p5 ref_op0_n100_s2_w0p5 vn_op0_n100_s2_w0p5 0 sky130_fd_pr__nfet_01v8 L=0.15 W=1 nf=1 ad=0.29 as=0.29 pd=2.58 ps=2.58 mult=1 m=1
XMN2_op0_n100_s2_w0p5 ref_op0_n100_s2_w0p5 rbl_op0_n100_s2_w0p5 vn_op0_n100_s2_w0p5 0 sky130_fd_pr__nfet_01v8 L=0.15 W=1 nf=1 ad=0.29 as=0.29 pd=2.58 ps=2.58 mult=1 m=1
XMP1_op0_n100_s2_w0p5 rbl_op0_n100_s2_w0p5 ref_op0_n100_s2_w0p5 vp_op0_n100_s2_w0p5 vdd sky130_fd_pr__pfet_01v8 L=0.15 W=2 nf=1 ad=0.58 as=0.58 pd=4.58 ps=4.58 mult=1 m=1
XMP2_op0_n100_s2_w0p5 ref_op0_n100_s2_w0p5 rbl_op0_n100_s2_w0p5 vp_op0_n100_s2_w0p5 vdd sky130_fd_pr__pfet_01v8 L=0.15 W=2 nf=1 ad=0.58 as=0.58 pd=4.58 ps=4.58 mult=1 m=1
XMNF_op0_n100_s2_w0p5 vn_op0_n100_s2_w0p5 en_op0_n100_s2_w0p5 0 0 sky130_fd_pr__nfet_01v8 L=0.15 W=2 nf=1 ad=0.58 as=0.58 pd=4.58 ps=4.58 mult=1 m=1
XMPH_op0_n100_s2_w0p5 vp_op0_n100_s2_w0p5 enb_op0_n100_s2_w0p5 vdd vdd sky130_fd_pr__pfet_01v8 L=0.15 W=4 nf=1 ad=1.16 as=1.16 pd=8.58 ps=8.58 mult=1 m=1
bd_op0_n100_s2_w0p5 d_op0_n100_s2_w0p5 0 v=v(rbl_op0_n100_s2_w0p5)-v(ref_op0_n100_s2_w0p5)

* ---- instance 146: op0_n100_s2_w1 (t_en 6 ns, WWL 7..8 ns, release 10 ns) ----
ven_op0_n100_s2_w1  en_op0_n100_s2_w1  0 pwl(0 0 6.0000e-09 0 6.1000e-09 {VDD} 1.0000e-08 {VDD} 1.0100e-08 0)
venb_op0_n100_s2_w1 enb_op0_n100_s2_w1 0 pwl(0 {VDD} 6.0000e-09 {VDD} 6.1000e-09 0 1.0000e-08 0 1.0100e-08 {VDD})
vrs_op0_n100_s2_w1  rwls_op0_n100_s2_w1 0 pwl(0 {VDD} {T_READ} {VDD} {T_READ+TEDGE} 0 1.0000e-08 0 1.0100e-08 {VDD})
vww_op0_n100_s2_w1  wwl_op0_n100_s2_w1 0 pwl(0 0 7.0000e-09 0 7.1000e-09 {VDD} 8.0000e-09 {VDD} 8.1000e-09 0)
vwc_op0_n100_s2_w1  wbc_op0_n100_s2_w1 0 pwl(0 0 7.0000e-09 0 7.1000e-09 {VDD} 1.0000e-08 {VDD} 1.0100e-08 0)
swb_op0_n100_s2_w1 ref_op0_n100_s2_w1 wbl_op0_n100_s2_w1 wbc_op0_n100_s2_w1 0 swwbl
cwbl_op0_n100_s2_w1 wbl_op0_n100_s2_w1 0 {C_WBL}
spa_op0_n100_s2_w1 prea rbl_op0_n100_s2_w1 ctl 0 swpre
spr_op0_n100_s2_w1 pref ref_op0_n100_s2_w1 ctl 0 swpre
crbl_op0_n100_s2_w1 rbl_op0_n100_s2_w1 0 {C_RBL}
cref_op0_n100_s2_w1 ref_op0_n100_s2_w1 0 {C_RBL}   $ ASSUMPTION: ideal matched dummy load
XMWR_op0_n100_s2_w1_0 sn_op0_n100_s2_w1_0 wwl_op0_n100_s2_w1 wbl_op0_n100_s2_w1 0 sky130_fd_pr__nfet_01v8 L=0.15 W=0.42 nf=1 ad=0.1218 as=0.1218 pd=1.42 ps=1.42 nrd=0.69047619047619  nrs=0.69047619047619 sa=0 sb=0 sd=0 mult=1 m=1
XMRD_op0_n100_s2_w1_0 rbl_op0_n100_s2_w1 sn_op0_n100_s2_w1_0 rwls_op0_n100_s2_w1 0 sky130_fd_pr__nfet_01v8 L=0.15 W=0.42 nf=1 ad=0.1218 as=0.1218 pd=1.42 ps=1.42 nrd=0.69047619047619  nrs=0.69047619047619 sa=0 sb=0 sd=0 mult=1 m=1
csn_op0_n100_s2_w1_0 sn_op0_n100_s2_w1_0 0 {C_SN}
XMWR_op0_n100_s2_w1_1 sn_op0_n100_s2_w1_1 wwl_des wbl_op0_n100_s2_w1 0 sky130_fd_pr__nfet_01v8 L=0.15 W=0.42 nf=1 ad=0.1218 as=0.1218 pd=1.42 ps=1.42 nrd=0.69047619047619  nrs=0.69047619047619 sa=0 sb=0 sd=0 mult=1 m=1
XMRD_op0_n100_s2_w1_1 rbl_op0_n100_s2_w1 sn_op0_n100_s2_w1_1 rwl_des 0 sky130_fd_pr__nfet_01v8 L=0.15 W=0.42 nf=1 ad=0.1218 as=0.1218 pd=1.42 ps=1.42 nrd=0.69047619047619  nrs=0.69047619047619 sa=0 sb=0 sd=0 mult=1 m=1
csn_op0_n100_s2_w1_1 sn_op0_n100_s2_w1_1 0 {C_SN}
XMWR_op0_n100_s2_w1_2 sn_op0_n100_s2_w1_2 wwl_des wbl_op0_n100_s2_w1 0 sky130_fd_pr__nfet_01v8 L=0.15 W=0.42 nf=1 ad=0.1218 as=0.1218 pd=1.42 ps=1.42 nrd=0.69047619047619  nrs=0.69047619047619 sa=0 sb=0 sd=0 mult=1 m=1
XMRD_op0_n100_s2_w1_2 rbl_op0_n100_s2_w1 sn_op0_n100_s2_w1_2 rwl_des 0 sky130_fd_pr__nfet_01v8 L=0.15 W=0.42 nf=1 ad=0.1218 as=0.1218 pd=1.42 ps=1.42 nrd=0.69047619047619  nrs=0.69047619047619 sa=0 sb=0 sd=0 mult=1 m=1
csn_op0_n100_s2_w1_2 sn_op0_n100_s2_w1_2 0 {C_SN}
XMWR_op0_n100_s2_w1_3 sn_op0_n100_s2_w1_3 wwl_des wbl_op0_n100_s2_w1 0 sky130_fd_pr__nfet_01v8 L=0.15 W=0.42 nf=1 ad=0.1218 as=0.1218 pd=1.42 ps=1.42 nrd=0.69047619047619  nrs=0.69047619047619 sa=0 sb=0 sd=0 mult=1 m=1
XMRD_op0_n100_s2_w1_3 rbl_op0_n100_s2_w1 sn_op0_n100_s2_w1_3 rwl_des 0 sky130_fd_pr__nfet_01v8 L=0.15 W=0.42 nf=1 ad=0.1218 as=0.1218 pd=1.42 ps=1.42 nrd=0.69047619047619  nrs=0.69047619047619 sa=0 sb=0 sd=0 mult=1 m=1
csn_op0_n100_s2_w1_3 sn_op0_n100_s2_w1_3 0 {C_SN}
XMN1_op0_n100_s2_w1 rbl_op0_n100_s2_w1 ref_op0_n100_s2_w1 vn_op0_n100_s2_w1 0 sky130_fd_pr__nfet_01v8 L=0.15 W=1 nf=1 ad=0.29 as=0.29 pd=2.58 ps=2.58 mult=1 m=1
XMN2_op0_n100_s2_w1 ref_op0_n100_s2_w1 rbl_op0_n100_s2_w1 vn_op0_n100_s2_w1 0 sky130_fd_pr__nfet_01v8 L=0.15 W=1 nf=1 ad=0.29 as=0.29 pd=2.58 ps=2.58 mult=1 m=1
XMP1_op0_n100_s2_w1 rbl_op0_n100_s2_w1 ref_op0_n100_s2_w1 vp_op0_n100_s2_w1 vdd sky130_fd_pr__pfet_01v8 L=0.15 W=2 nf=1 ad=0.58 as=0.58 pd=4.58 ps=4.58 mult=1 m=1
XMP2_op0_n100_s2_w1 ref_op0_n100_s2_w1 rbl_op0_n100_s2_w1 vp_op0_n100_s2_w1 vdd sky130_fd_pr__pfet_01v8 L=0.15 W=2 nf=1 ad=0.58 as=0.58 pd=4.58 ps=4.58 mult=1 m=1
XMNF_op0_n100_s2_w1 vn_op0_n100_s2_w1 en_op0_n100_s2_w1 0 0 sky130_fd_pr__nfet_01v8 L=0.15 W=2 nf=1 ad=0.58 as=0.58 pd=4.58 ps=4.58 mult=1 m=1
XMPH_op0_n100_s2_w1 vp_op0_n100_s2_w1 enb_op0_n100_s2_w1 vdd vdd sky130_fd_pr__pfet_01v8 L=0.15 W=4 nf=1 ad=1.16 as=1.16 pd=8.58 ps=8.58 mult=1 m=1
bd_op0_n100_s2_w1 d_op0_n100_s2_w1 0 v=v(rbl_op0_n100_s2_w1)-v(ref_op0_n100_s2_w1)

* ---- instance 147: op0_n100_s2_w2 (t_en 6 ns, WWL 7..9 ns, release 11 ns) ----
ven_op0_n100_s2_w2  en_op0_n100_s2_w2  0 pwl(0 0 6.0000e-09 0 6.1000e-09 {VDD} 1.1000e-08 {VDD} 1.1100e-08 0)
venb_op0_n100_s2_w2 enb_op0_n100_s2_w2 0 pwl(0 {VDD} 6.0000e-09 {VDD} 6.1000e-09 0 1.1000e-08 0 1.1100e-08 {VDD})
vrs_op0_n100_s2_w2  rwls_op0_n100_s2_w2 0 pwl(0 {VDD} {T_READ} {VDD} {T_READ+TEDGE} 0 1.1000e-08 0 1.1100e-08 {VDD})
vww_op0_n100_s2_w2  wwl_op0_n100_s2_w2 0 pwl(0 0 7.0000e-09 0 7.1000e-09 {VDD} 9.0000e-09 {VDD} 9.1000e-09 0)
vwc_op0_n100_s2_w2  wbc_op0_n100_s2_w2 0 pwl(0 0 7.0000e-09 0 7.1000e-09 {VDD} 1.1000e-08 {VDD} 1.1100e-08 0)
swb_op0_n100_s2_w2 ref_op0_n100_s2_w2 wbl_op0_n100_s2_w2 wbc_op0_n100_s2_w2 0 swwbl
cwbl_op0_n100_s2_w2 wbl_op0_n100_s2_w2 0 {C_WBL}
spa_op0_n100_s2_w2 prea rbl_op0_n100_s2_w2 ctl 0 swpre
spr_op0_n100_s2_w2 pref ref_op0_n100_s2_w2 ctl 0 swpre
crbl_op0_n100_s2_w2 rbl_op0_n100_s2_w2 0 {C_RBL}
cref_op0_n100_s2_w2 ref_op0_n100_s2_w2 0 {C_RBL}   $ ASSUMPTION: ideal matched dummy load
XMWR_op0_n100_s2_w2_0 sn_op0_n100_s2_w2_0 wwl_op0_n100_s2_w2 wbl_op0_n100_s2_w2 0 sky130_fd_pr__nfet_01v8 L=0.15 W=0.42 nf=1 ad=0.1218 as=0.1218 pd=1.42 ps=1.42 nrd=0.69047619047619  nrs=0.69047619047619 sa=0 sb=0 sd=0 mult=1 m=1
XMRD_op0_n100_s2_w2_0 rbl_op0_n100_s2_w2 sn_op0_n100_s2_w2_0 rwls_op0_n100_s2_w2 0 sky130_fd_pr__nfet_01v8 L=0.15 W=0.42 nf=1 ad=0.1218 as=0.1218 pd=1.42 ps=1.42 nrd=0.69047619047619  nrs=0.69047619047619 sa=0 sb=0 sd=0 mult=1 m=1
csn_op0_n100_s2_w2_0 sn_op0_n100_s2_w2_0 0 {C_SN}
XMWR_op0_n100_s2_w2_1 sn_op0_n100_s2_w2_1 wwl_des wbl_op0_n100_s2_w2 0 sky130_fd_pr__nfet_01v8 L=0.15 W=0.42 nf=1 ad=0.1218 as=0.1218 pd=1.42 ps=1.42 nrd=0.69047619047619  nrs=0.69047619047619 sa=0 sb=0 sd=0 mult=1 m=1
XMRD_op0_n100_s2_w2_1 rbl_op0_n100_s2_w2 sn_op0_n100_s2_w2_1 rwl_des 0 sky130_fd_pr__nfet_01v8 L=0.15 W=0.42 nf=1 ad=0.1218 as=0.1218 pd=1.42 ps=1.42 nrd=0.69047619047619  nrs=0.69047619047619 sa=0 sb=0 sd=0 mult=1 m=1
csn_op0_n100_s2_w2_1 sn_op0_n100_s2_w2_1 0 {C_SN}
XMWR_op0_n100_s2_w2_2 sn_op0_n100_s2_w2_2 wwl_des wbl_op0_n100_s2_w2 0 sky130_fd_pr__nfet_01v8 L=0.15 W=0.42 nf=1 ad=0.1218 as=0.1218 pd=1.42 ps=1.42 nrd=0.69047619047619  nrs=0.69047619047619 sa=0 sb=0 sd=0 mult=1 m=1
XMRD_op0_n100_s2_w2_2 rbl_op0_n100_s2_w2 sn_op0_n100_s2_w2_2 rwl_des 0 sky130_fd_pr__nfet_01v8 L=0.15 W=0.42 nf=1 ad=0.1218 as=0.1218 pd=1.42 ps=1.42 nrd=0.69047619047619  nrs=0.69047619047619 sa=0 sb=0 sd=0 mult=1 m=1
csn_op0_n100_s2_w2_2 sn_op0_n100_s2_w2_2 0 {C_SN}
XMWR_op0_n100_s2_w2_3 sn_op0_n100_s2_w2_3 wwl_des wbl_op0_n100_s2_w2 0 sky130_fd_pr__nfet_01v8 L=0.15 W=0.42 nf=1 ad=0.1218 as=0.1218 pd=1.42 ps=1.42 nrd=0.69047619047619  nrs=0.69047619047619 sa=0 sb=0 sd=0 mult=1 m=1
XMRD_op0_n100_s2_w2_3 rbl_op0_n100_s2_w2 sn_op0_n100_s2_w2_3 rwl_des 0 sky130_fd_pr__nfet_01v8 L=0.15 W=0.42 nf=1 ad=0.1218 as=0.1218 pd=1.42 ps=1.42 nrd=0.69047619047619  nrs=0.69047619047619 sa=0 sb=0 sd=0 mult=1 m=1
csn_op0_n100_s2_w2_3 sn_op0_n100_s2_w2_3 0 {C_SN}
XMN1_op0_n100_s2_w2 rbl_op0_n100_s2_w2 ref_op0_n100_s2_w2 vn_op0_n100_s2_w2 0 sky130_fd_pr__nfet_01v8 L=0.15 W=1 nf=1 ad=0.29 as=0.29 pd=2.58 ps=2.58 mult=1 m=1
XMN2_op0_n100_s2_w2 ref_op0_n100_s2_w2 rbl_op0_n100_s2_w2 vn_op0_n100_s2_w2 0 sky130_fd_pr__nfet_01v8 L=0.15 W=1 nf=1 ad=0.29 as=0.29 pd=2.58 ps=2.58 mult=1 m=1
XMP1_op0_n100_s2_w2 rbl_op0_n100_s2_w2 ref_op0_n100_s2_w2 vp_op0_n100_s2_w2 vdd sky130_fd_pr__pfet_01v8 L=0.15 W=2 nf=1 ad=0.58 as=0.58 pd=4.58 ps=4.58 mult=1 m=1
XMP2_op0_n100_s2_w2 ref_op0_n100_s2_w2 rbl_op0_n100_s2_w2 vp_op0_n100_s2_w2 vdd sky130_fd_pr__pfet_01v8 L=0.15 W=2 nf=1 ad=0.58 as=0.58 pd=4.58 ps=4.58 mult=1 m=1
XMNF_op0_n100_s2_w2 vn_op0_n100_s2_w2 en_op0_n100_s2_w2 0 0 sky130_fd_pr__nfet_01v8 L=0.15 W=2 nf=1 ad=0.58 as=0.58 pd=4.58 ps=4.58 mult=1 m=1
XMPH_op0_n100_s2_w2 vp_op0_n100_s2_w2 enb_op0_n100_s2_w2 vdd vdd sky130_fd_pr__pfet_01v8 L=0.15 W=4 nf=1 ad=1.16 as=1.16 pd=8.58 ps=8.58 mult=1 m=1
bd_op0_n100_s2_w2 d_op0_n100_s2_w2 0 v=v(rbl_op0_n100_s2_w2)-v(ref_op0_n100_s2_w2)

* ---- instance 148: op0_n100_s2_w3 (t_en 6 ns, WWL 7..10 ns, release 12 ns) ----
ven_op0_n100_s2_w3  en_op0_n100_s2_w3  0 pwl(0 0 6.0000e-09 0 6.1000e-09 {VDD} 1.2000e-08 {VDD} 1.2100e-08 0)
venb_op0_n100_s2_w3 enb_op0_n100_s2_w3 0 pwl(0 {VDD} 6.0000e-09 {VDD} 6.1000e-09 0 1.2000e-08 0 1.2100e-08 {VDD})
vrs_op0_n100_s2_w3  rwls_op0_n100_s2_w3 0 pwl(0 {VDD} {T_READ} {VDD} {T_READ+TEDGE} 0 1.2000e-08 0 1.2100e-08 {VDD})
vww_op0_n100_s2_w3  wwl_op0_n100_s2_w3 0 pwl(0 0 7.0000e-09 0 7.1000e-09 {VDD} 1.0000e-08 {VDD} 1.0100e-08 0)
vwc_op0_n100_s2_w3  wbc_op0_n100_s2_w3 0 pwl(0 0 7.0000e-09 0 7.1000e-09 {VDD} 1.2000e-08 {VDD} 1.2100e-08 0)
swb_op0_n100_s2_w3 ref_op0_n100_s2_w3 wbl_op0_n100_s2_w3 wbc_op0_n100_s2_w3 0 swwbl
cwbl_op0_n100_s2_w3 wbl_op0_n100_s2_w3 0 {C_WBL}
spa_op0_n100_s2_w3 prea rbl_op0_n100_s2_w3 ctl 0 swpre
spr_op0_n100_s2_w3 pref ref_op0_n100_s2_w3 ctl 0 swpre
crbl_op0_n100_s2_w3 rbl_op0_n100_s2_w3 0 {C_RBL}
cref_op0_n100_s2_w3 ref_op0_n100_s2_w3 0 {C_RBL}   $ ASSUMPTION: ideal matched dummy load
XMWR_op0_n100_s2_w3_0 sn_op0_n100_s2_w3_0 wwl_op0_n100_s2_w3 wbl_op0_n100_s2_w3 0 sky130_fd_pr__nfet_01v8 L=0.15 W=0.42 nf=1 ad=0.1218 as=0.1218 pd=1.42 ps=1.42 nrd=0.69047619047619  nrs=0.69047619047619 sa=0 sb=0 sd=0 mult=1 m=1
XMRD_op0_n100_s2_w3_0 rbl_op0_n100_s2_w3 sn_op0_n100_s2_w3_0 rwls_op0_n100_s2_w3 0 sky130_fd_pr__nfet_01v8 L=0.15 W=0.42 nf=1 ad=0.1218 as=0.1218 pd=1.42 ps=1.42 nrd=0.69047619047619  nrs=0.69047619047619 sa=0 sb=0 sd=0 mult=1 m=1
csn_op0_n100_s2_w3_0 sn_op0_n100_s2_w3_0 0 {C_SN}
XMWR_op0_n100_s2_w3_1 sn_op0_n100_s2_w3_1 wwl_des wbl_op0_n100_s2_w3 0 sky130_fd_pr__nfet_01v8 L=0.15 W=0.42 nf=1 ad=0.1218 as=0.1218 pd=1.42 ps=1.42 nrd=0.69047619047619  nrs=0.69047619047619 sa=0 sb=0 sd=0 mult=1 m=1
XMRD_op0_n100_s2_w3_1 rbl_op0_n100_s2_w3 sn_op0_n100_s2_w3_1 rwl_des 0 sky130_fd_pr__nfet_01v8 L=0.15 W=0.42 nf=1 ad=0.1218 as=0.1218 pd=1.42 ps=1.42 nrd=0.69047619047619  nrs=0.69047619047619 sa=0 sb=0 sd=0 mult=1 m=1
csn_op0_n100_s2_w3_1 sn_op0_n100_s2_w3_1 0 {C_SN}
XMWR_op0_n100_s2_w3_2 sn_op0_n100_s2_w3_2 wwl_des wbl_op0_n100_s2_w3 0 sky130_fd_pr__nfet_01v8 L=0.15 W=0.42 nf=1 ad=0.1218 as=0.1218 pd=1.42 ps=1.42 nrd=0.69047619047619  nrs=0.69047619047619 sa=0 sb=0 sd=0 mult=1 m=1
XMRD_op0_n100_s2_w3_2 rbl_op0_n100_s2_w3 sn_op0_n100_s2_w3_2 rwl_des 0 sky130_fd_pr__nfet_01v8 L=0.15 W=0.42 nf=1 ad=0.1218 as=0.1218 pd=1.42 ps=1.42 nrd=0.69047619047619  nrs=0.69047619047619 sa=0 sb=0 sd=0 mult=1 m=1
csn_op0_n100_s2_w3_2 sn_op0_n100_s2_w3_2 0 {C_SN}
XMWR_op0_n100_s2_w3_3 sn_op0_n100_s2_w3_3 wwl_des wbl_op0_n100_s2_w3 0 sky130_fd_pr__nfet_01v8 L=0.15 W=0.42 nf=1 ad=0.1218 as=0.1218 pd=1.42 ps=1.42 nrd=0.69047619047619  nrs=0.69047619047619 sa=0 sb=0 sd=0 mult=1 m=1
XMRD_op0_n100_s2_w3_3 rbl_op0_n100_s2_w3 sn_op0_n100_s2_w3_3 rwl_des 0 sky130_fd_pr__nfet_01v8 L=0.15 W=0.42 nf=1 ad=0.1218 as=0.1218 pd=1.42 ps=1.42 nrd=0.69047619047619  nrs=0.69047619047619 sa=0 sb=0 sd=0 mult=1 m=1
csn_op0_n100_s2_w3_3 sn_op0_n100_s2_w3_3 0 {C_SN}
XMN1_op0_n100_s2_w3 rbl_op0_n100_s2_w3 ref_op0_n100_s2_w3 vn_op0_n100_s2_w3 0 sky130_fd_pr__nfet_01v8 L=0.15 W=1 nf=1 ad=0.29 as=0.29 pd=2.58 ps=2.58 mult=1 m=1
XMN2_op0_n100_s2_w3 ref_op0_n100_s2_w3 rbl_op0_n100_s2_w3 vn_op0_n100_s2_w3 0 sky130_fd_pr__nfet_01v8 L=0.15 W=1 nf=1 ad=0.29 as=0.29 pd=2.58 ps=2.58 mult=1 m=1
XMP1_op0_n100_s2_w3 rbl_op0_n100_s2_w3 ref_op0_n100_s2_w3 vp_op0_n100_s2_w3 vdd sky130_fd_pr__pfet_01v8 L=0.15 W=2 nf=1 ad=0.58 as=0.58 pd=4.58 ps=4.58 mult=1 m=1
XMP2_op0_n100_s2_w3 ref_op0_n100_s2_w3 rbl_op0_n100_s2_w3 vp_op0_n100_s2_w3 vdd sky130_fd_pr__pfet_01v8 L=0.15 W=2 nf=1 ad=0.58 as=0.58 pd=4.58 ps=4.58 mult=1 m=1
XMNF_op0_n100_s2_w3 vn_op0_n100_s2_w3 en_op0_n100_s2_w3 0 0 sky130_fd_pr__nfet_01v8 L=0.15 W=2 nf=1 ad=0.58 as=0.58 pd=4.58 ps=4.58 mult=1 m=1
XMPH_op0_n100_s2_w3 vp_op0_n100_s2_w3 enb_op0_n100_s2_w3 vdd vdd sky130_fd_pr__pfet_01v8 L=0.15 W=4 nf=1 ad=1.16 as=1.16 pd=8.58 ps=8.58 mult=1 m=1
bd_op0_n100_s2_w3 d_op0_n100_s2_w3 0 v=v(rbl_op0_n100_s2_w3)-v(ref_op0_n100_s2_w3)

* ---- instance 149: op0_n100_s2_w5 (t_en 6 ns, WWL 7..12 ns, release 14 ns) ----
ven_op0_n100_s2_w5  en_op0_n100_s2_w5  0 pwl(0 0 6.0000e-09 0 6.1000e-09 {VDD} 1.4000e-08 {VDD} 1.4100e-08 0)
venb_op0_n100_s2_w5 enb_op0_n100_s2_w5 0 pwl(0 {VDD} 6.0000e-09 {VDD} 6.1000e-09 0 1.4000e-08 0 1.4100e-08 {VDD})
vrs_op0_n100_s2_w5  rwls_op0_n100_s2_w5 0 pwl(0 {VDD} {T_READ} {VDD} {T_READ+TEDGE} 0 1.4000e-08 0 1.4100e-08 {VDD})
vww_op0_n100_s2_w5  wwl_op0_n100_s2_w5 0 pwl(0 0 7.0000e-09 0 7.1000e-09 {VDD} 1.2000e-08 {VDD} 1.2100e-08 0)
vwc_op0_n100_s2_w5  wbc_op0_n100_s2_w5 0 pwl(0 0 7.0000e-09 0 7.1000e-09 {VDD} 1.4000e-08 {VDD} 1.4100e-08 0)
swb_op0_n100_s2_w5 ref_op0_n100_s2_w5 wbl_op0_n100_s2_w5 wbc_op0_n100_s2_w5 0 swwbl
cwbl_op0_n100_s2_w5 wbl_op0_n100_s2_w5 0 {C_WBL}
spa_op0_n100_s2_w5 prea rbl_op0_n100_s2_w5 ctl 0 swpre
spr_op0_n100_s2_w5 pref ref_op0_n100_s2_w5 ctl 0 swpre
crbl_op0_n100_s2_w5 rbl_op0_n100_s2_w5 0 {C_RBL}
cref_op0_n100_s2_w5 ref_op0_n100_s2_w5 0 {C_RBL}   $ ASSUMPTION: ideal matched dummy load
XMWR_op0_n100_s2_w5_0 sn_op0_n100_s2_w5_0 wwl_op0_n100_s2_w5 wbl_op0_n100_s2_w5 0 sky130_fd_pr__nfet_01v8 L=0.15 W=0.42 nf=1 ad=0.1218 as=0.1218 pd=1.42 ps=1.42 nrd=0.69047619047619  nrs=0.69047619047619 sa=0 sb=0 sd=0 mult=1 m=1
XMRD_op0_n100_s2_w5_0 rbl_op0_n100_s2_w5 sn_op0_n100_s2_w5_0 rwls_op0_n100_s2_w5 0 sky130_fd_pr__nfet_01v8 L=0.15 W=0.42 nf=1 ad=0.1218 as=0.1218 pd=1.42 ps=1.42 nrd=0.69047619047619  nrs=0.69047619047619 sa=0 sb=0 sd=0 mult=1 m=1
csn_op0_n100_s2_w5_0 sn_op0_n100_s2_w5_0 0 {C_SN}
XMWR_op0_n100_s2_w5_1 sn_op0_n100_s2_w5_1 wwl_des wbl_op0_n100_s2_w5 0 sky130_fd_pr__nfet_01v8 L=0.15 W=0.42 nf=1 ad=0.1218 as=0.1218 pd=1.42 ps=1.42 nrd=0.69047619047619  nrs=0.69047619047619 sa=0 sb=0 sd=0 mult=1 m=1
XMRD_op0_n100_s2_w5_1 rbl_op0_n100_s2_w5 sn_op0_n100_s2_w5_1 rwl_des 0 sky130_fd_pr__nfet_01v8 L=0.15 W=0.42 nf=1 ad=0.1218 as=0.1218 pd=1.42 ps=1.42 nrd=0.69047619047619  nrs=0.69047619047619 sa=0 sb=0 sd=0 mult=1 m=1
csn_op0_n100_s2_w5_1 sn_op0_n100_s2_w5_1 0 {C_SN}
XMWR_op0_n100_s2_w5_2 sn_op0_n100_s2_w5_2 wwl_des wbl_op0_n100_s2_w5 0 sky130_fd_pr__nfet_01v8 L=0.15 W=0.42 nf=1 ad=0.1218 as=0.1218 pd=1.42 ps=1.42 nrd=0.69047619047619  nrs=0.69047619047619 sa=0 sb=0 sd=0 mult=1 m=1
XMRD_op0_n100_s2_w5_2 rbl_op0_n100_s2_w5 sn_op0_n100_s2_w5_2 rwl_des 0 sky130_fd_pr__nfet_01v8 L=0.15 W=0.42 nf=1 ad=0.1218 as=0.1218 pd=1.42 ps=1.42 nrd=0.69047619047619  nrs=0.69047619047619 sa=0 sb=0 sd=0 mult=1 m=1
csn_op0_n100_s2_w5_2 sn_op0_n100_s2_w5_2 0 {C_SN}
XMWR_op0_n100_s2_w5_3 sn_op0_n100_s2_w5_3 wwl_des wbl_op0_n100_s2_w5 0 sky130_fd_pr__nfet_01v8 L=0.15 W=0.42 nf=1 ad=0.1218 as=0.1218 pd=1.42 ps=1.42 nrd=0.69047619047619  nrs=0.69047619047619 sa=0 sb=0 sd=0 mult=1 m=1
XMRD_op0_n100_s2_w5_3 rbl_op0_n100_s2_w5 sn_op0_n100_s2_w5_3 rwl_des 0 sky130_fd_pr__nfet_01v8 L=0.15 W=0.42 nf=1 ad=0.1218 as=0.1218 pd=1.42 ps=1.42 nrd=0.69047619047619  nrs=0.69047619047619 sa=0 sb=0 sd=0 mult=1 m=1
csn_op0_n100_s2_w5_3 sn_op0_n100_s2_w5_3 0 {C_SN}
XMN1_op0_n100_s2_w5 rbl_op0_n100_s2_w5 ref_op0_n100_s2_w5 vn_op0_n100_s2_w5 0 sky130_fd_pr__nfet_01v8 L=0.15 W=1 nf=1 ad=0.29 as=0.29 pd=2.58 ps=2.58 mult=1 m=1
XMN2_op0_n100_s2_w5 ref_op0_n100_s2_w5 rbl_op0_n100_s2_w5 vn_op0_n100_s2_w5 0 sky130_fd_pr__nfet_01v8 L=0.15 W=1 nf=1 ad=0.29 as=0.29 pd=2.58 ps=2.58 mult=1 m=1
XMP1_op0_n100_s2_w5 rbl_op0_n100_s2_w5 ref_op0_n100_s2_w5 vp_op0_n100_s2_w5 vdd sky130_fd_pr__pfet_01v8 L=0.15 W=2 nf=1 ad=0.58 as=0.58 pd=4.58 ps=4.58 mult=1 m=1
XMP2_op0_n100_s2_w5 ref_op0_n100_s2_w5 rbl_op0_n100_s2_w5 vp_op0_n100_s2_w5 vdd sky130_fd_pr__pfet_01v8 L=0.15 W=2 nf=1 ad=0.58 as=0.58 pd=4.58 ps=4.58 mult=1 m=1
XMNF_op0_n100_s2_w5 vn_op0_n100_s2_w5 en_op0_n100_s2_w5 0 0 sky130_fd_pr__nfet_01v8 L=0.15 W=2 nf=1 ad=0.58 as=0.58 pd=4.58 ps=4.58 mult=1 m=1
XMPH_op0_n100_s2_w5 vp_op0_n100_s2_w5 enb_op0_n100_s2_w5 vdd vdd sky130_fd_pr__pfet_01v8 L=0.15 W=4 nf=1 ad=1.16 as=1.16 pd=8.58 ps=8.58 mult=1 m=1
bd_op0_n100_s2_w5 d_op0_n100_s2_w5 0 v=v(rbl_op0_n100_s2_w5)-v(ref_op0_n100_s2_w5)

* ---- instance 150: op0_n100_s2_w7p5 (t_en 6 ns, WWL 7..14.5 ns, release 16.5 ns) ----
ven_op0_n100_s2_w7p5  en_op0_n100_s2_w7p5  0 pwl(0 0 6.0000e-09 0 6.1000e-09 {VDD} 1.6500e-08 {VDD} 1.6600e-08 0)
venb_op0_n100_s2_w7p5 enb_op0_n100_s2_w7p5 0 pwl(0 {VDD} 6.0000e-09 {VDD} 6.1000e-09 0 1.6500e-08 0 1.6600e-08 {VDD})
vrs_op0_n100_s2_w7p5  rwls_op0_n100_s2_w7p5 0 pwl(0 {VDD} {T_READ} {VDD} {T_READ+TEDGE} 0 1.6500e-08 0 1.6600e-08 {VDD})
vww_op0_n100_s2_w7p5  wwl_op0_n100_s2_w7p5 0 pwl(0 0 7.0000e-09 0 7.1000e-09 {VDD} 1.4500e-08 {VDD} 1.4600e-08 0)
vwc_op0_n100_s2_w7p5  wbc_op0_n100_s2_w7p5 0 pwl(0 0 7.0000e-09 0 7.1000e-09 {VDD} 1.6500e-08 {VDD} 1.6600e-08 0)
swb_op0_n100_s2_w7p5 ref_op0_n100_s2_w7p5 wbl_op0_n100_s2_w7p5 wbc_op0_n100_s2_w7p5 0 swwbl
cwbl_op0_n100_s2_w7p5 wbl_op0_n100_s2_w7p5 0 {C_WBL}
spa_op0_n100_s2_w7p5 prea rbl_op0_n100_s2_w7p5 ctl 0 swpre
spr_op0_n100_s2_w7p5 pref ref_op0_n100_s2_w7p5 ctl 0 swpre
crbl_op0_n100_s2_w7p5 rbl_op0_n100_s2_w7p5 0 {C_RBL}
cref_op0_n100_s2_w7p5 ref_op0_n100_s2_w7p5 0 {C_RBL}   $ ASSUMPTION: ideal matched dummy load
XMWR_op0_n100_s2_w7p5_0 sn_op0_n100_s2_w7p5_0 wwl_op0_n100_s2_w7p5 wbl_op0_n100_s2_w7p5 0 sky130_fd_pr__nfet_01v8 L=0.15 W=0.42 nf=1 ad=0.1218 as=0.1218 pd=1.42 ps=1.42 nrd=0.69047619047619  nrs=0.69047619047619 sa=0 sb=0 sd=0 mult=1 m=1
XMRD_op0_n100_s2_w7p5_0 rbl_op0_n100_s2_w7p5 sn_op0_n100_s2_w7p5_0 rwls_op0_n100_s2_w7p5 0 sky130_fd_pr__nfet_01v8 L=0.15 W=0.42 nf=1 ad=0.1218 as=0.1218 pd=1.42 ps=1.42 nrd=0.69047619047619  nrs=0.69047619047619 sa=0 sb=0 sd=0 mult=1 m=1
csn_op0_n100_s2_w7p5_0 sn_op0_n100_s2_w7p5_0 0 {C_SN}
XMWR_op0_n100_s2_w7p5_1 sn_op0_n100_s2_w7p5_1 wwl_des wbl_op0_n100_s2_w7p5 0 sky130_fd_pr__nfet_01v8 L=0.15 W=0.42 nf=1 ad=0.1218 as=0.1218 pd=1.42 ps=1.42 nrd=0.69047619047619  nrs=0.69047619047619 sa=0 sb=0 sd=0 mult=1 m=1
XMRD_op0_n100_s2_w7p5_1 rbl_op0_n100_s2_w7p5 sn_op0_n100_s2_w7p5_1 rwl_des 0 sky130_fd_pr__nfet_01v8 L=0.15 W=0.42 nf=1 ad=0.1218 as=0.1218 pd=1.42 ps=1.42 nrd=0.69047619047619  nrs=0.69047619047619 sa=0 sb=0 sd=0 mult=1 m=1
csn_op0_n100_s2_w7p5_1 sn_op0_n100_s2_w7p5_1 0 {C_SN}
XMWR_op0_n100_s2_w7p5_2 sn_op0_n100_s2_w7p5_2 wwl_des wbl_op0_n100_s2_w7p5 0 sky130_fd_pr__nfet_01v8 L=0.15 W=0.42 nf=1 ad=0.1218 as=0.1218 pd=1.42 ps=1.42 nrd=0.69047619047619  nrs=0.69047619047619 sa=0 sb=0 sd=0 mult=1 m=1
XMRD_op0_n100_s2_w7p5_2 rbl_op0_n100_s2_w7p5 sn_op0_n100_s2_w7p5_2 rwl_des 0 sky130_fd_pr__nfet_01v8 L=0.15 W=0.42 nf=1 ad=0.1218 as=0.1218 pd=1.42 ps=1.42 nrd=0.69047619047619  nrs=0.69047619047619 sa=0 sb=0 sd=0 mult=1 m=1
csn_op0_n100_s2_w7p5_2 sn_op0_n100_s2_w7p5_2 0 {C_SN}
XMWR_op0_n100_s2_w7p5_3 sn_op0_n100_s2_w7p5_3 wwl_des wbl_op0_n100_s2_w7p5 0 sky130_fd_pr__nfet_01v8 L=0.15 W=0.42 nf=1 ad=0.1218 as=0.1218 pd=1.42 ps=1.42 nrd=0.69047619047619  nrs=0.69047619047619 sa=0 sb=0 sd=0 mult=1 m=1
XMRD_op0_n100_s2_w7p5_3 rbl_op0_n100_s2_w7p5 sn_op0_n100_s2_w7p5_3 rwl_des 0 sky130_fd_pr__nfet_01v8 L=0.15 W=0.42 nf=1 ad=0.1218 as=0.1218 pd=1.42 ps=1.42 nrd=0.69047619047619  nrs=0.69047619047619 sa=0 sb=0 sd=0 mult=1 m=1
csn_op0_n100_s2_w7p5_3 sn_op0_n100_s2_w7p5_3 0 {C_SN}
XMN1_op0_n100_s2_w7p5 rbl_op0_n100_s2_w7p5 ref_op0_n100_s2_w7p5 vn_op0_n100_s2_w7p5 0 sky130_fd_pr__nfet_01v8 L=0.15 W=1 nf=1 ad=0.29 as=0.29 pd=2.58 ps=2.58 mult=1 m=1
XMN2_op0_n100_s2_w7p5 ref_op0_n100_s2_w7p5 rbl_op0_n100_s2_w7p5 vn_op0_n100_s2_w7p5 0 sky130_fd_pr__nfet_01v8 L=0.15 W=1 nf=1 ad=0.29 as=0.29 pd=2.58 ps=2.58 mult=1 m=1
XMP1_op0_n100_s2_w7p5 rbl_op0_n100_s2_w7p5 ref_op0_n100_s2_w7p5 vp_op0_n100_s2_w7p5 vdd sky130_fd_pr__pfet_01v8 L=0.15 W=2 nf=1 ad=0.58 as=0.58 pd=4.58 ps=4.58 mult=1 m=1
XMP2_op0_n100_s2_w7p5 ref_op0_n100_s2_w7p5 rbl_op0_n100_s2_w7p5 vp_op0_n100_s2_w7p5 vdd sky130_fd_pr__pfet_01v8 L=0.15 W=2 nf=1 ad=0.58 as=0.58 pd=4.58 ps=4.58 mult=1 m=1
XMNF_op0_n100_s2_w7p5 vn_op0_n100_s2_w7p5 en_op0_n100_s2_w7p5 0 0 sky130_fd_pr__nfet_01v8 L=0.15 W=2 nf=1 ad=0.58 as=0.58 pd=4.58 ps=4.58 mult=1 m=1
XMPH_op0_n100_s2_w7p5 vp_op0_n100_s2_w7p5 enb_op0_n100_s2_w7p5 vdd vdd sky130_fd_pr__pfet_01v8 L=0.15 W=4 nf=1 ad=1.16 as=1.16 pd=8.58 ps=8.58 mult=1 m=1
bd_op0_n100_s2_w7p5 d_op0_n100_s2_w7p5 0 v=v(rbl_op0_n100_s2_w7p5)-v(ref_op0_n100_s2_w7p5)

* ---- instance 151: op0_n100_s2_w10 (t_en 6 ns, WWL 7..17 ns, release 19 ns) ----
ven_op0_n100_s2_w10  en_op0_n100_s2_w10  0 pwl(0 0 6.0000e-09 0 6.1000e-09 {VDD} 1.9000e-08 {VDD} 1.9100e-08 0)
venb_op0_n100_s2_w10 enb_op0_n100_s2_w10 0 pwl(0 {VDD} 6.0000e-09 {VDD} 6.1000e-09 0 1.9000e-08 0 1.9100e-08 {VDD})
vrs_op0_n100_s2_w10  rwls_op0_n100_s2_w10 0 pwl(0 {VDD} {T_READ} {VDD} {T_READ+TEDGE} 0 1.9000e-08 0 1.9100e-08 {VDD})
vww_op0_n100_s2_w10  wwl_op0_n100_s2_w10 0 pwl(0 0 7.0000e-09 0 7.1000e-09 {VDD} 1.7000e-08 {VDD} 1.7100e-08 0)
vwc_op0_n100_s2_w10  wbc_op0_n100_s2_w10 0 pwl(0 0 7.0000e-09 0 7.1000e-09 {VDD} 1.9000e-08 {VDD} 1.9100e-08 0)
swb_op0_n100_s2_w10 ref_op0_n100_s2_w10 wbl_op0_n100_s2_w10 wbc_op0_n100_s2_w10 0 swwbl
cwbl_op0_n100_s2_w10 wbl_op0_n100_s2_w10 0 {C_WBL}
spa_op0_n100_s2_w10 prea rbl_op0_n100_s2_w10 ctl 0 swpre
spr_op0_n100_s2_w10 pref ref_op0_n100_s2_w10 ctl 0 swpre
crbl_op0_n100_s2_w10 rbl_op0_n100_s2_w10 0 {C_RBL}
cref_op0_n100_s2_w10 ref_op0_n100_s2_w10 0 {C_RBL}   $ ASSUMPTION: ideal matched dummy load
XMWR_op0_n100_s2_w10_0 sn_op0_n100_s2_w10_0 wwl_op0_n100_s2_w10 wbl_op0_n100_s2_w10 0 sky130_fd_pr__nfet_01v8 L=0.15 W=0.42 nf=1 ad=0.1218 as=0.1218 pd=1.42 ps=1.42 nrd=0.69047619047619  nrs=0.69047619047619 sa=0 sb=0 sd=0 mult=1 m=1
XMRD_op0_n100_s2_w10_0 rbl_op0_n100_s2_w10 sn_op0_n100_s2_w10_0 rwls_op0_n100_s2_w10 0 sky130_fd_pr__nfet_01v8 L=0.15 W=0.42 nf=1 ad=0.1218 as=0.1218 pd=1.42 ps=1.42 nrd=0.69047619047619  nrs=0.69047619047619 sa=0 sb=0 sd=0 mult=1 m=1
csn_op0_n100_s2_w10_0 sn_op0_n100_s2_w10_0 0 {C_SN}
XMWR_op0_n100_s2_w10_1 sn_op0_n100_s2_w10_1 wwl_des wbl_op0_n100_s2_w10 0 sky130_fd_pr__nfet_01v8 L=0.15 W=0.42 nf=1 ad=0.1218 as=0.1218 pd=1.42 ps=1.42 nrd=0.69047619047619  nrs=0.69047619047619 sa=0 sb=0 sd=0 mult=1 m=1
XMRD_op0_n100_s2_w10_1 rbl_op0_n100_s2_w10 sn_op0_n100_s2_w10_1 rwl_des 0 sky130_fd_pr__nfet_01v8 L=0.15 W=0.42 nf=1 ad=0.1218 as=0.1218 pd=1.42 ps=1.42 nrd=0.69047619047619  nrs=0.69047619047619 sa=0 sb=0 sd=0 mult=1 m=1
csn_op0_n100_s2_w10_1 sn_op0_n100_s2_w10_1 0 {C_SN}
XMWR_op0_n100_s2_w10_2 sn_op0_n100_s2_w10_2 wwl_des wbl_op0_n100_s2_w10 0 sky130_fd_pr__nfet_01v8 L=0.15 W=0.42 nf=1 ad=0.1218 as=0.1218 pd=1.42 ps=1.42 nrd=0.69047619047619  nrs=0.69047619047619 sa=0 sb=0 sd=0 mult=1 m=1
XMRD_op0_n100_s2_w10_2 rbl_op0_n100_s2_w10 sn_op0_n100_s2_w10_2 rwl_des 0 sky130_fd_pr__nfet_01v8 L=0.15 W=0.42 nf=1 ad=0.1218 as=0.1218 pd=1.42 ps=1.42 nrd=0.69047619047619  nrs=0.69047619047619 sa=0 sb=0 sd=0 mult=1 m=1
csn_op0_n100_s2_w10_2 sn_op0_n100_s2_w10_2 0 {C_SN}
XMWR_op0_n100_s2_w10_3 sn_op0_n100_s2_w10_3 wwl_des wbl_op0_n100_s2_w10 0 sky130_fd_pr__nfet_01v8 L=0.15 W=0.42 nf=1 ad=0.1218 as=0.1218 pd=1.42 ps=1.42 nrd=0.69047619047619  nrs=0.69047619047619 sa=0 sb=0 sd=0 mult=1 m=1
XMRD_op0_n100_s2_w10_3 rbl_op0_n100_s2_w10 sn_op0_n100_s2_w10_3 rwl_des 0 sky130_fd_pr__nfet_01v8 L=0.15 W=0.42 nf=1 ad=0.1218 as=0.1218 pd=1.42 ps=1.42 nrd=0.69047619047619  nrs=0.69047619047619 sa=0 sb=0 sd=0 mult=1 m=1
csn_op0_n100_s2_w10_3 sn_op0_n100_s2_w10_3 0 {C_SN}
XMN1_op0_n100_s2_w10 rbl_op0_n100_s2_w10 ref_op0_n100_s2_w10 vn_op0_n100_s2_w10 0 sky130_fd_pr__nfet_01v8 L=0.15 W=1 nf=1 ad=0.29 as=0.29 pd=2.58 ps=2.58 mult=1 m=1
XMN2_op0_n100_s2_w10 ref_op0_n100_s2_w10 rbl_op0_n100_s2_w10 vn_op0_n100_s2_w10 0 sky130_fd_pr__nfet_01v8 L=0.15 W=1 nf=1 ad=0.29 as=0.29 pd=2.58 ps=2.58 mult=1 m=1
XMP1_op0_n100_s2_w10 rbl_op0_n100_s2_w10 ref_op0_n100_s2_w10 vp_op0_n100_s2_w10 vdd sky130_fd_pr__pfet_01v8 L=0.15 W=2 nf=1 ad=0.58 as=0.58 pd=4.58 ps=4.58 mult=1 m=1
XMP2_op0_n100_s2_w10 ref_op0_n100_s2_w10 rbl_op0_n100_s2_w10 vp_op0_n100_s2_w10 vdd sky130_fd_pr__pfet_01v8 L=0.15 W=2 nf=1 ad=0.58 as=0.58 pd=4.58 ps=4.58 mult=1 m=1
XMNF_op0_n100_s2_w10 vn_op0_n100_s2_w10 en_op0_n100_s2_w10 0 0 sky130_fd_pr__nfet_01v8 L=0.15 W=2 nf=1 ad=0.58 as=0.58 pd=4.58 ps=4.58 mult=1 m=1
XMPH_op0_n100_s2_w10 vp_op0_n100_s2_w10 enb_op0_n100_s2_w10 vdd vdd sky130_fd_pr__pfet_01v8 L=0.15 W=4 nf=1 ad=1.16 as=1.16 pd=8.58 ps=8.58 mult=1 m=1
bd_op0_n100_s2_w10 d_op0_n100_s2_w10 0 v=v(rbl_op0_n100_s2_w10)-v(ref_op0_n100_s2_w10)

* ---- instance 152: op0_n100_s2_w15 (t_en 6 ns, WWL 7..22 ns, release 24 ns) ----
ven_op0_n100_s2_w15  en_op0_n100_s2_w15  0 pwl(0 0 6.0000e-09 0 6.1000e-09 {VDD} 2.4000e-08 {VDD} 2.4100e-08 0)
venb_op0_n100_s2_w15 enb_op0_n100_s2_w15 0 pwl(0 {VDD} 6.0000e-09 {VDD} 6.1000e-09 0 2.4000e-08 0 2.4100e-08 {VDD})
vrs_op0_n100_s2_w15  rwls_op0_n100_s2_w15 0 pwl(0 {VDD} {T_READ} {VDD} {T_READ+TEDGE} 0 2.4000e-08 0 2.4100e-08 {VDD})
vww_op0_n100_s2_w15  wwl_op0_n100_s2_w15 0 pwl(0 0 7.0000e-09 0 7.1000e-09 {VDD} 2.2000e-08 {VDD} 2.2100e-08 0)
vwc_op0_n100_s2_w15  wbc_op0_n100_s2_w15 0 pwl(0 0 7.0000e-09 0 7.1000e-09 {VDD} 2.4000e-08 {VDD} 2.4100e-08 0)
swb_op0_n100_s2_w15 ref_op0_n100_s2_w15 wbl_op0_n100_s2_w15 wbc_op0_n100_s2_w15 0 swwbl
cwbl_op0_n100_s2_w15 wbl_op0_n100_s2_w15 0 {C_WBL}
spa_op0_n100_s2_w15 prea rbl_op0_n100_s2_w15 ctl 0 swpre
spr_op0_n100_s2_w15 pref ref_op0_n100_s2_w15 ctl 0 swpre
crbl_op0_n100_s2_w15 rbl_op0_n100_s2_w15 0 {C_RBL}
cref_op0_n100_s2_w15 ref_op0_n100_s2_w15 0 {C_RBL}   $ ASSUMPTION: ideal matched dummy load
XMWR_op0_n100_s2_w15_0 sn_op0_n100_s2_w15_0 wwl_op0_n100_s2_w15 wbl_op0_n100_s2_w15 0 sky130_fd_pr__nfet_01v8 L=0.15 W=0.42 nf=1 ad=0.1218 as=0.1218 pd=1.42 ps=1.42 nrd=0.69047619047619  nrs=0.69047619047619 sa=0 sb=0 sd=0 mult=1 m=1
XMRD_op0_n100_s2_w15_0 rbl_op0_n100_s2_w15 sn_op0_n100_s2_w15_0 rwls_op0_n100_s2_w15 0 sky130_fd_pr__nfet_01v8 L=0.15 W=0.42 nf=1 ad=0.1218 as=0.1218 pd=1.42 ps=1.42 nrd=0.69047619047619  nrs=0.69047619047619 sa=0 sb=0 sd=0 mult=1 m=1
csn_op0_n100_s2_w15_0 sn_op0_n100_s2_w15_0 0 {C_SN}
XMWR_op0_n100_s2_w15_1 sn_op0_n100_s2_w15_1 wwl_des wbl_op0_n100_s2_w15 0 sky130_fd_pr__nfet_01v8 L=0.15 W=0.42 nf=1 ad=0.1218 as=0.1218 pd=1.42 ps=1.42 nrd=0.69047619047619  nrs=0.69047619047619 sa=0 sb=0 sd=0 mult=1 m=1
XMRD_op0_n100_s2_w15_1 rbl_op0_n100_s2_w15 sn_op0_n100_s2_w15_1 rwl_des 0 sky130_fd_pr__nfet_01v8 L=0.15 W=0.42 nf=1 ad=0.1218 as=0.1218 pd=1.42 ps=1.42 nrd=0.69047619047619  nrs=0.69047619047619 sa=0 sb=0 sd=0 mult=1 m=1
csn_op0_n100_s2_w15_1 sn_op0_n100_s2_w15_1 0 {C_SN}
XMWR_op0_n100_s2_w15_2 sn_op0_n100_s2_w15_2 wwl_des wbl_op0_n100_s2_w15 0 sky130_fd_pr__nfet_01v8 L=0.15 W=0.42 nf=1 ad=0.1218 as=0.1218 pd=1.42 ps=1.42 nrd=0.69047619047619  nrs=0.69047619047619 sa=0 sb=0 sd=0 mult=1 m=1
XMRD_op0_n100_s2_w15_2 rbl_op0_n100_s2_w15 sn_op0_n100_s2_w15_2 rwl_des 0 sky130_fd_pr__nfet_01v8 L=0.15 W=0.42 nf=1 ad=0.1218 as=0.1218 pd=1.42 ps=1.42 nrd=0.69047619047619  nrs=0.69047619047619 sa=0 sb=0 sd=0 mult=1 m=1
csn_op0_n100_s2_w15_2 sn_op0_n100_s2_w15_2 0 {C_SN}
XMWR_op0_n100_s2_w15_3 sn_op0_n100_s2_w15_3 wwl_des wbl_op0_n100_s2_w15 0 sky130_fd_pr__nfet_01v8 L=0.15 W=0.42 nf=1 ad=0.1218 as=0.1218 pd=1.42 ps=1.42 nrd=0.69047619047619  nrs=0.69047619047619 sa=0 sb=0 sd=0 mult=1 m=1
XMRD_op0_n100_s2_w15_3 rbl_op0_n100_s2_w15 sn_op0_n100_s2_w15_3 rwl_des 0 sky130_fd_pr__nfet_01v8 L=0.15 W=0.42 nf=1 ad=0.1218 as=0.1218 pd=1.42 ps=1.42 nrd=0.69047619047619  nrs=0.69047619047619 sa=0 sb=0 sd=0 mult=1 m=1
csn_op0_n100_s2_w15_3 sn_op0_n100_s2_w15_3 0 {C_SN}
XMN1_op0_n100_s2_w15 rbl_op0_n100_s2_w15 ref_op0_n100_s2_w15 vn_op0_n100_s2_w15 0 sky130_fd_pr__nfet_01v8 L=0.15 W=1 nf=1 ad=0.29 as=0.29 pd=2.58 ps=2.58 mult=1 m=1
XMN2_op0_n100_s2_w15 ref_op0_n100_s2_w15 rbl_op0_n100_s2_w15 vn_op0_n100_s2_w15 0 sky130_fd_pr__nfet_01v8 L=0.15 W=1 nf=1 ad=0.29 as=0.29 pd=2.58 ps=2.58 mult=1 m=1
XMP1_op0_n100_s2_w15 rbl_op0_n100_s2_w15 ref_op0_n100_s2_w15 vp_op0_n100_s2_w15 vdd sky130_fd_pr__pfet_01v8 L=0.15 W=2 nf=1 ad=0.58 as=0.58 pd=4.58 ps=4.58 mult=1 m=1
XMP2_op0_n100_s2_w15 ref_op0_n100_s2_w15 rbl_op0_n100_s2_w15 vp_op0_n100_s2_w15 vdd sky130_fd_pr__pfet_01v8 L=0.15 W=2 nf=1 ad=0.58 as=0.58 pd=4.58 ps=4.58 mult=1 m=1
XMNF_op0_n100_s2_w15 vn_op0_n100_s2_w15 en_op0_n100_s2_w15 0 0 sky130_fd_pr__nfet_01v8 L=0.15 W=2 nf=1 ad=0.58 as=0.58 pd=4.58 ps=4.58 mult=1 m=1
XMPH_op0_n100_s2_w15 vp_op0_n100_s2_w15 enb_op0_n100_s2_w15 vdd vdd sky130_fd_pr__pfet_01v8 L=0.15 W=4 nf=1 ad=1.16 as=1.16 pd=8.58 ps=8.58 mult=1 m=1
bd_op0_n100_s2_w15 d_op0_n100_s2_w15 0 v=v(rbl_op0_n100_s2_w15)-v(ref_op0_n100_s2_w15)

* ---- instance 153: op0_n100_s2_w20 (t_en 6 ns, WWL 7..27 ns, release 29 ns) ----
ven_op0_n100_s2_w20  en_op0_n100_s2_w20  0 pwl(0 0 6.0000e-09 0 6.1000e-09 {VDD} 2.9000e-08 {VDD} 2.9100e-08 0)
venb_op0_n100_s2_w20 enb_op0_n100_s2_w20 0 pwl(0 {VDD} 6.0000e-09 {VDD} 6.1000e-09 0 2.9000e-08 0 2.9100e-08 {VDD})
vrs_op0_n100_s2_w20  rwls_op0_n100_s2_w20 0 pwl(0 {VDD} {T_READ} {VDD} {T_READ+TEDGE} 0 2.9000e-08 0 2.9100e-08 {VDD})
vww_op0_n100_s2_w20  wwl_op0_n100_s2_w20 0 pwl(0 0 7.0000e-09 0 7.1000e-09 {VDD} 2.7000e-08 {VDD} 2.7100e-08 0)
vwc_op0_n100_s2_w20  wbc_op0_n100_s2_w20 0 pwl(0 0 7.0000e-09 0 7.1000e-09 {VDD} 2.9000e-08 {VDD} 2.9100e-08 0)
swb_op0_n100_s2_w20 ref_op0_n100_s2_w20 wbl_op0_n100_s2_w20 wbc_op0_n100_s2_w20 0 swwbl
cwbl_op0_n100_s2_w20 wbl_op0_n100_s2_w20 0 {C_WBL}
spa_op0_n100_s2_w20 prea rbl_op0_n100_s2_w20 ctl 0 swpre
spr_op0_n100_s2_w20 pref ref_op0_n100_s2_w20 ctl 0 swpre
crbl_op0_n100_s2_w20 rbl_op0_n100_s2_w20 0 {C_RBL}
cref_op0_n100_s2_w20 ref_op0_n100_s2_w20 0 {C_RBL}   $ ASSUMPTION: ideal matched dummy load
XMWR_op0_n100_s2_w20_0 sn_op0_n100_s2_w20_0 wwl_op0_n100_s2_w20 wbl_op0_n100_s2_w20 0 sky130_fd_pr__nfet_01v8 L=0.15 W=0.42 nf=1 ad=0.1218 as=0.1218 pd=1.42 ps=1.42 nrd=0.69047619047619  nrs=0.69047619047619 sa=0 sb=0 sd=0 mult=1 m=1
XMRD_op0_n100_s2_w20_0 rbl_op0_n100_s2_w20 sn_op0_n100_s2_w20_0 rwls_op0_n100_s2_w20 0 sky130_fd_pr__nfet_01v8 L=0.15 W=0.42 nf=1 ad=0.1218 as=0.1218 pd=1.42 ps=1.42 nrd=0.69047619047619  nrs=0.69047619047619 sa=0 sb=0 sd=0 mult=1 m=1
csn_op0_n100_s2_w20_0 sn_op0_n100_s2_w20_0 0 {C_SN}
XMWR_op0_n100_s2_w20_1 sn_op0_n100_s2_w20_1 wwl_des wbl_op0_n100_s2_w20 0 sky130_fd_pr__nfet_01v8 L=0.15 W=0.42 nf=1 ad=0.1218 as=0.1218 pd=1.42 ps=1.42 nrd=0.69047619047619  nrs=0.69047619047619 sa=0 sb=0 sd=0 mult=1 m=1
XMRD_op0_n100_s2_w20_1 rbl_op0_n100_s2_w20 sn_op0_n100_s2_w20_1 rwl_des 0 sky130_fd_pr__nfet_01v8 L=0.15 W=0.42 nf=1 ad=0.1218 as=0.1218 pd=1.42 ps=1.42 nrd=0.69047619047619  nrs=0.69047619047619 sa=0 sb=0 sd=0 mult=1 m=1
csn_op0_n100_s2_w20_1 sn_op0_n100_s2_w20_1 0 {C_SN}
XMWR_op0_n100_s2_w20_2 sn_op0_n100_s2_w20_2 wwl_des wbl_op0_n100_s2_w20 0 sky130_fd_pr__nfet_01v8 L=0.15 W=0.42 nf=1 ad=0.1218 as=0.1218 pd=1.42 ps=1.42 nrd=0.69047619047619  nrs=0.69047619047619 sa=0 sb=0 sd=0 mult=1 m=1
XMRD_op0_n100_s2_w20_2 rbl_op0_n100_s2_w20 sn_op0_n100_s2_w20_2 rwl_des 0 sky130_fd_pr__nfet_01v8 L=0.15 W=0.42 nf=1 ad=0.1218 as=0.1218 pd=1.42 ps=1.42 nrd=0.69047619047619  nrs=0.69047619047619 sa=0 sb=0 sd=0 mult=1 m=1
csn_op0_n100_s2_w20_2 sn_op0_n100_s2_w20_2 0 {C_SN}
XMWR_op0_n100_s2_w20_3 sn_op0_n100_s2_w20_3 wwl_des wbl_op0_n100_s2_w20 0 sky130_fd_pr__nfet_01v8 L=0.15 W=0.42 nf=1 ad=0.1218 as=0.1218 pd=1.42 ps=1.42 nrd=0.69047619047619  nrs=0.69047619047619 sa=0 sb=0 sd=0 mult=1 m=1
XMRD_op0_n100_s2_w20_3 rbl_op0_n100_s2_w20 sn_op0_n100_s2_w20_3 rwl_des 0 sky130_fd_pr__nfet_01v8 L=0.15 W=0.42 nf=1 ad=0.1218 as=0.1218 pd=1.42 ps=1.42 nrd=0.69047619047619  nrs=0.69047619047619 sa=0 sb=0 sd=0 mult=1 m=1
csn_op0_n100_s2_w20_3 sn_op0_n100_s2_w20_3 0 {C_SN}
XMN1_op0_n100_s2_w20 rbl_op0_n100_s2_w20 ref_op0_n100_s2_w20 vn_op0_n100_s2_w20 0 sky130_fd_pr__nfet_01v8 L=0.15 W=1 nf=1 ad=0.29 as=0.29 pd=2.58 ps=2.58 mult=1 m=1
XMN2_op0_n100_s2_w20 ref_op0_n100_s2_w20 rbl_op0_n100_s2_w20 vn_op0_n100_s2_w20 0 sky130_fd_pr__nfet_01v8 L=0.15 W=1 nf=1 ad=0.29 as=0.29 pd=2.58 ps=2.58 mult=1 m=1
XMP1_op0_n100_s2_w20 rbl_op0_n100_s2_w20 ref_op0_n100_s2_w20 vp_op0_n100_s2_w20 vdd sky130_fd_pr__pfet_01v8 L=0.15 W=2 nf=1 ad=0.58 as=0.58 pd=4.58 ps=4.58 mult=1 m=1
XMP2_op0_n100_s2_w20 ref_op0_n100_s2_w20 rbl_op0_n100_s2_w20 vp_op0_n100_s2_w20 vdd sky130_fd_pr__pfet_01v8 L=0.15 W=2 nf=1 ad=0.58 as=0.58 pd=4.58 ps=4.58 mult=1 m=1
XMNF_op0_n100_s2_w20 vn_op0_n100_s2_w20 en_op0_n100_s2_w20 0 0 sky130_fd_pr__nfet_01v8 L=0.15 W=2 nf=1 ad=0.58 as=0.58 pd=4.58 ps=4.58 mult=1 m=1
XMPH_op0_n100_s2_w20 vp_op0_n100_s2_w20 enb_op0_n100_s2_w20 vdd vdd sky130_fd_pr__pfet_01v8 L=0.15 W=4 nf=1 ad=1.16 as=1.16 pd=8.58 ps=8.58 mult=1 m=1
bd_op0_n100_s2_w20 d_op0_n100_s2_w20 0 v=v(rbl_op0_n100_s2_w20)-v(ref_op0_n100_s2_w20)

* ---- instance 154: op0_n100_s2_w30 (t_en 6 ns, WWL 7..37 ns, release 39 ns) ----
ven_op0_n100_s2_w30  en_op0_n100_s2_w30  0 pwl(0 0 6.0000e-09 0 6.1000e-09 {VDD} 3.9000e-08 {VDD} 3.9100e-08 0)
venb_op0_n100_s2_w30 enb_op0_n100_s2_w30 0 pwl(0 {VDD} 6.0000e-09 {VDD} 6.1000e-09 0 3.9000e-08 0 3.9100e-08 {VDD})
vrs_op0_n100_s2_w30  rwls_op0_n100_s2_w30 0 pwl(0 {VDD} {T_READ} {VDD} {T_READ+TEDGE} 0 3.9000e-08 0 3.9100e-08 {VDD})
vww_op0_n100_s2_w30  wwl_op0_n100_s2_w30 0 pwl(0 0 7.0000e-09 0 7.1000e-09 {VDD} 3.7000e-08 {VDD} 3.7100e-08 0)
vwc_op0_n100_s2_w30  wbc_op0_n100_s2_w30 0 pwl(0 0 7.0000e-09 0 7.1000e-09 {VDD} 3.9000e-08 {VDD} 3.9100e-08 0)
swb_op0_n100_s2_w30 ref_op0_n100_s2_w30 wbl_op0_n100_s2_w30 wbc_op0_n100_s2_w30 0 swwbl
cwbl_op0_n100_s2_w30 wbl_op0_n100_s2_w30 0 {C_WBL}
spa_op0_n100_s2_w30 prea rbl_op0_n100_s2_w30 ctl 0 swpre
spr_op0_n100_s2_w30 pref ref_op0_n100_s2_w30 ctl 0 swpre
crbl_op0_n100_s2_w30 rbl_op0_n100_s2_w30 0 {C_RBL}
cref_op0_n100_s2_w30 ref_op0_n100_s2_w30 0 {C_RBL}   $ ASSUMPTION: ideal matched dummy load
XMWR_op0_n100_s2_w30_0 sn_op0_n100_s2_w30_0 wwl_op0_n100_s2_w30 wbl_op0_n100_s2_w30 0 sky130_fd_pr__nfet_01v8 L=0.15 W=0.42 nf=1 ad=0.1218 as=0.1218 pd=1.42 ps=1.42 nrd=0.69047619047619  nrs=0.69047619047619 sa=0 sb=0 sd=0 mult=1 m=1
XMRD_op0_n100_s2_w30_0 rbl_op0_n100_s2_w30 sn_op0_n100_s2_w30_0 rwls_op0_n100_s2_w30 0 sky130_fd_pr__nfet_01v8 L=0.15 W=0.42 nf=1 ad=0.1218 as=0.1218 pd=1.42 ps=1.42 nrd=0.69047619047619  nrs=0.69047619047619 sa=0 sb=0 sd=0 mult=1 m=1
csn_op0_n100_s2_w30_0 sn_op0_n100_s2_w30_0 0 {C_SN}
XMWR_op0_n100_s2_w30_1 sn_op0_n100_s2_w30_1 wwl_des wbl_op0_n100_s2_w30 0 sky130_fd_pr__nfet_01v8 L=0.15 W=0.42 nf=1 ad=0.1218 as=0.1218 pd=1.42 ps=1.42 nrd=0.69047619047619  nrs=0.69047619047619 sa=0 sb=0 sd=0 mult=1 m=1
XMRD_op0_n100_s2_w30_1 rbl_op0_n100_s2_w30 sn_op0_n100_s2_w30_1 rwl_des 0 sky130_fd_pr__nfet_01v8 L=0.15 W=0.42 nf=1 ad=0.1218 as=0.1218 pd=1.42 ps=1.42 nrd=0.69047619047619  nrs=0.69047619047619 sa=0 sb=0 sd=0 mult=1 m=1
csn_op0_n100_s2_w30_1 sn_op0_n100_s2_w30_1 0 {C_SN}
XMWR_op0_n100_s2_w30_2 sn_op0_n100_s2_w30_2 wwl_des wbl_op0_n100_s2_w30 0 sky130_fd_pr__nfet_01v8 L=0.15 W=0.42 nf=1 ad=0.1218 as=0.1218 pd=1.42 ps=1.42 nrd=0.69047619047619  nrs=0.69047619047619 sa=0 sb=0 sd=0 mult=1 m=1
XMRD_op0_n100_s2_w30_2 rbl_op0_n100_s2_w30 sn_op0_n100_s2_w30_2 rwl_des 0 sky130_fd_pr__nfet_01v8 L=0.15 W=0.42 nf=1 ad=0.1218 as=0.1218 pd=1.42 ps=1.42 nrd=0.69047619047619  nrs=0.69047619047619 sa=0 sb=0 sd=0 mult=1 m=1
csn_op0_n100_s2_w30_2 sn_op0_n100_s2_w30_2 0 {C_SN}
XMWR_op0_n100_s2_w30_3 sn_op0_n100_s2_w30_3 wwl_des wbl_op0_n100_s2_w30 0 sky130_fd_pr__nfet_01v8 L=0.15 W=0.42 nf=1 ad=0.1218 as=0.1218 pd=1.42 ps=1.42 nrd=0.69047619047619  nrs=0.69047619047619 sa=0 sb=0 sd=0 mult=1 m=1
XMRD_op0_n100_s2_w30_3 rbl_op0_n100_s2_w30 sn_op0_n100_s2_w30_3 rwl_des 0 sky130_fd_pr__nfet_01v8 L=0.15 W=0.42 nf=1 ad=0.1218 as=0.1218 pd=1.42 ps=1.42 nrd=0.69047619047619  nrs=0.69047619047619 sa=0 sb=0 sd=0 mult=1 m=1
csn_op0_n100_s2_w30_3 sn_op0_n100_s2_w30_3 0 {C_SN}
XMN1_op0_n100_s2_w30 rbl_op0_n100_s2_w30 ref_op0_n100_s2_w30 vn_op0_n100_s2_w30 0 sky130_fd_pr__nfet_01v8 L=0.15 W=1 nf=1 ad=0.29 as=0.29 pd=2.58 ps=2.58 mult=1 m=1
XMN2_op0_n100_s2_w30 ref_op0_n100_s2_w30 rbl_op0_n100_s2_w30 vn_op0_n100_s2_w30 0 sky130_fd_pr__nfet_01v8 L=0.15 W=1 nf=1 ad=0.29 as=0.29 pd=2.58 ps=2.58 mult=1 m=1
XMP1_op0_n100_s2_w30 rbl_op0_n100_s2_w30 ref_op0_n100_s2_w30 vp_op0_n100_s2_w30 vdd sky130_fd_pr__pfet_01v8 L=0.15 W=2 nf=1 ad=0.58 as=0.58 pd=4.58 ps=4.58 mult=1 m=1
XMP2_op0_n100_s2_w30 ref_op0_n100_s2_w30 rbl_op0_n100_s2_w30 vp_op0_n100_s2_w30 vdd sky130_fd_pr__pfet_01v8 L=0.15 W=2 nf=1 ad=0.58 as=0.58 pd=4.58 ps=4.58 mult=1 m=1
XMNF_op0_n100_s2_w30 vn_op0_n100_s2_w30 en_op0_n100_s2_w30 0 0 sky130_fd_pr__nfet_01v8 L=0.15 W=2 nf=1 ad=0.58 as=0.58 pd=4.58 ps=4.58 mult=1 m=1
XMPH_op0_n100_s2_w30 vp_op0_n100_s2_w30 enb_op0_n100_s2_w30 vdd vdd sky130_fd_pr__pfet_01v8 L=0.15 W=4 nf=1 ad=1.16 as=1.16 pd=8.58 ps=8.58 mult=1 m=1
bd_op0_n100_s2_w30 d_op0_n100_s2_w30 0 v=v(rbl_op0_n100_s2_w30)-v(ref_op0_n100_s2_w30)

* ---- instance 155: op0_n100_s2_w50 (t_en 6 ns, WWL 7..57 ns, release 59 ns) ----
ven_op0_n100_s2_w50  en_op0_n100_s2_w50  0 pwl(0 0 6.0000e-09 0 6.1000e-09 {VDD} 5.9000e-08 {VDD} 5.9100e-08 0)
venb_op0_n100_s2_w50 enb_op0_n100_s2_w50 0 pwl(0 {VDD} 6.0000e-09 {VDD} 6.1000e-09 0 5.9000e-08 0 5.9100e-08 {VDD})
vrs_op0_n100_s2_w50  rwls_op0_n100_s2_w50 0 pwl(0 {VDD} {T_READ} {VDD} {T_READ+TEDGE} 0 5.9000e-08 0 5.9100e-08 {VDD})
vww_op0_n100_s2_w50  wwl_op0_n100_s2_w50 0 pwl(0 0 7.0000e-09 0 7.1000e-09 {VDD} 5.7000e-08 {VDD} 5.7100e-08 0)
vwc_op0_n100_s2_w50  wbc_op0_n100_s2_w50 0 pwl(0 0 7.0000e-09 0 7.1000e-09 {VDD} 5.9000e-08 {VDD} 5.9100e-08 0)
swb_op0_n100_s2_w50 ref_op0_n100_s2_w50 wbl_op0_n100_s2_w50 wbc_op0_n100_s2_w50 0 swwbl
cwbl_op0_n100_s2_w50 wbl_op0_n100_s2_w50 0 {C_WBL}
spa_op0_n100_s2_w50 prea rbl_op0_n100_s2_w50 ctl 0 swpre
spr_op0_n100_s2_w50 pref ref_op0_n100_s2_w50 ctl 0 swpre
crbl_op0_n100_s2_w50 rbl_op0_n100_s2_w50 0 {C_RBL}
cref_op0_n100_s2_w50 ref_op0_n100_s2_w50 0 {C_RBL}   $ ASSUMPTION: ideal matched dummy load
XMWR_op0_n100_s2_w50_0 sn_op0_n100_s2_w50_0 wwl_op0_n100_s2_w50 wbl_op0_n100_s2_w50 0 sky130_fd_pr__nfet_01v8 L=0.15 W=0.42 nf=1 ad=0.1218 as=0.1218 pd=1.42 ps=1.42 nrd=0.69047619047619  nrs=0.69047619047619 sa=0 sb=0 sd=0 mult=1 m=1
XMRD_op0_n100_s2_w50_0 rbl_op0_n100_s2_w50 sn_op0_n100_s2_w50_0 rwls_op0_n100_s2_w50 0 sky130_fd_pr__nfet_01v8 L=0.15 W=0.42 nf=1 ad=0.1218 as=0.1218 pd=1.42 ps=1.42 nrd=0.69047619047619  nrs=0.69047619047619 sa=0 sb=0 sd=0 mult=1 m=1
csn_op0_n100_s2_w50_0 sn_op0_n100_s2_w50_0 0 {C_SN}
XMWR_op0_n100_s2_w50_1 sn_op0_n100_s2_w50_1 wwl_des wbl_op0_n100_s2_w50 0 sky130_fd_pr__nfet_01v8 L=0.15 W=0.42 nf=1 ad=0.1218 as=0.1218 pd=1.42 ps=1.42 nrd=0.69047619047619  nrs=0.69047619047619 sa=0 sb=0 sd=0 mult=1 m=1
XMRD_op0_n100_s2_w50_1 rbl_op0_n100_s2_w50 sn_op0_n100_s2_w50_1 rwl_des 0 sky130_fd_pr__nfet_01v8 L=0.15 W=0.42 nf=1 ad=0.1218 as=0.1218 pd=1.42 ps=1.42 nrd=0.69047619047619  nrs=0.69047619047619 sa=0 sb=0 sd=0 mult=1 m=1
csn_op0_n100_s2_w50_1 sn_op0_n100_s2_w50_1 0 {C_SN}
XMWR_op0_n100_s2_w50_2 sn_op0_n100_s2_w50_2 wwl_des wbl_op0_n100_s2_w50 0 sky130_fd_pr__nfet_01v8 L=0.15 W=0.42 nf=1 ad=0.1218 as=0.1218 pd=1.42 ps=1.42 nrd=0.69047619047619  nrs=0.69047619047619 sa=0 sb=0 sd=0 mult=1 m=1
XMRD_op0_n100_s2_w50_2 rbl_op0_n100_s2_w50 sn_op0_n100_s2_w50_2 rwl_des 0 sky130_fd_pr__nfet_01v8 L=0.15 W=0.42 nf=1 ad=0.1218 as=0.1218 pd=1.42 ps=1.42 nrd=0.69047619047619  nrs=0.69047619047619 sa=0 sb=0 sd=0 mult=1 m=1
csn_op0_n100_s2_w50_2 sn_op0_n100_s2_w50_2 0 {C_SN}
XMWR_op0_n100_s2_w50_3 sn_op0_n100_s2_w50_3 wwl_des wbl_op0_n100_s2_w50 0 sky130_fd_pr__nfet_01v8 L=0.15 W=0.42 nf=1 ad=0.1218 as=0.1218 pd=1.42 ps=1.42 nrd=0.69047619047619  nrs=0.69047619047619 sa=0 sb=0 sd=0 mult=1 m=1
XMRD_op0_n100_s2_w50_3 rbl_op0_n100_s2_w50 sn_op0_n100_s2_w50_3 rwl_des 0 sky130_fd_pr__nfet_01v8 L=0.15 W=0.42 nf=1 ad=0.1218 as=0.1218 pd=1.42 ps=1.42 nrd=0.69047619047619  nrs=0.69047619047619 sa=0 sb=0 sd=0 mult=1 m=1
csn_op0_n100_s2_w50_3 sn_op0_n100_s2_w50_3 0 {C_SN}
XMN1_op0_n100_s2_w50 rbl_op0_n100_s2_w50 ref_op0_n100_s2_w50 vn_op0_n100_s2_w50 0 sky130_fd_pr__nfet_01v8 L=0.15 W=1 nf=1 ad=0.29 as=0.29 pd=2.58 ps=2.58 mult=1 m=1
XMN2_op0_n100_s2_w50 ref_op0_n100_s2_w50 rbl_op0_n100_s2_w50 vn_op0_n100_s2_w50 0 sky130_fd_pr__nfet_01v8 L=0.15 W=1 nf=1 ad=0.29 as=0.29 pd=2.58 ps=2.58 mult=1 m=1
XMP1_op0_n100_s2_w50 rbl_op0_n100_s2_w50 ref_op0_n100_s2_w50 vp_op0_n100_s2_w50 vdd sky130_fd_pr__pfet_01v8 L=0.15 W=2 nf=1 ad=0.58 as=0.58 pd=4.58 ps=4.58 mult=1 m=1
XMP2_op0_n100_s2_w50 ref_op0_n100_s2_w50 rbl_op0_n100_s2_w50 vp_op0_n100_s2_w50 vdd sky130_fd_pr__pfet_01v8 L=0.15 W=2 nf=1 ad=0.58 as=0.58 pd=4.58 ps=4.58 mult=1 m=1
XMNF_op0_n100_s2_w50 vn_op0_n100_s2_w50 en_op0_n100_s2_w50 0 0 sky130_fd_pr__nfet_01v8 L=0.15 W=2 nf=1 ad=0.58 as=0.58 pd=4.58 ps=4.58 mult=1 m=1
XMPH_op0_n100_s2_w50 vp_op0_n100_s2_w50 enb_op0_n100_s2_w50 vdd vdd sky130_fd_pr__pfet_01v8 L=0.15 W=4 nf=1 ad=1.16 as=1.16 pd=8.58 ps=8.58 mult=1 m=1
bd_op0_n100_s2_w50 d_op0_n100_s2_w50 0 v=v(rbl_op0_n100_s2_w50)-v(ref_op0_n100_s2_w50)

* ---- instance 156: op0_n100_s5_w0p2 (t_en 9 ns, WWL 10..10.2 ns, release 12.2 ns) ----
ven_op0_n100_s5_w0p2  en_op0_n100_s5_w0p2  0 pwl(0 0 9.0000e-09 0 9.1000e-09 {VDD} 1.2200e-08 {VDD} 1.2300e-08 0)
venb_op0_n100_s5_w0p2 enb_op0_n100_s5_w0p2 0 pwl(0 {VDD} 9.0000e-09 {VDD} 9.1000e-09 0 1.2200e-08 0 1.2300e-08 {VDD})
vrs_op0_n100_s5_w0p2  rwls_op0_n100_s5_w0p2 0 pwl(0 {VDD} {T_READ} {VDD} {T_READ+TEDGE} 0 1.2200e-08 0 1.2300e-08 {VDD})
vww_op0_n100_s5_w0p2  wwl_op0_n100_s5_w0p2 0 pwl(0 0 1.0000e-08 0 1.0100e-08 {VDD} 1.0200e-08 {VDD} 1.0300e-08 0)
vwc_op0_n100_s5_w0p2  wbc_op0_n100_s5_w0p2 0 pwl(0 0 1.0000e-08 0 1.0100e-08 {VDD} 1.2200e-08 {VDD} 1.2300e-08 0)
swb_op0_n100_s5_w0p2 ref_op0_n100_s5_w0p2 wbl_op0_n100_s5_w0p2 wbc_op0_n100_s5_w0p2 0 swwbl
cwbl_op0_n100_s5_w0p2 wbl_op0_n100_s5_w0p2 0 {C_WBL}
spa_op0_n100_s5_w0p2 prea rbl_op0_n100_s5_w0p2 ctl 0 swpre
spr_op0_n100_s5_w0p2 pref ref_op0_n100_s5_w0p2 ctl 0 swpre
crbl_op0_n100_s5_w0p2 rbl_op0_n100_s5_w0p2 0 {C_RBL}
cref_op0_n100_s5_w0p2 ref_op0_n100_s5_w0p2 0 {C_RBL}   $ ASSUMPTION: ideal matched dummy load
XMWR_op0_n100_s5_w0p2_0 sn_op0_n100_s5_w0p2_0 wwl_op0_n100_s5_w0p2 wbl_op0_n100_s5_w0p2 0 sky130_fd_pr__nfet_01v8 L=0.15 W=0.42 nf=1 ad=0.1218 as=0.1218 pd=1.42 ps=1.42 nrd=0.69047619047619  nrs=0.69047619047619 sa=0 sb=0 sd=0 mult=1 m=1
XMRD_op0_n100_s5_w0p2_0 rbl_op0_n100_s5_w0p2 sn_op0_n100_s5_w0p2_0 rwls_op0_n100_s5_w0p2 0 sky130_fd_pr__nfet_01v8 L=0.15 W=0.42 nf=1 ad=0.1218 as=0.1218 pd=1.42 ps=1.42 nrd=0.69047619047619  nrs=0.69047619047619 sa=0 sb=0 sd=0 mult=1 m=1
csn_op0_n100_s5_w0p2_0 sn_op0_n100_s5_w0p2_0 0 {C_SN}
XMWR_op0_n100_s5_w0p2_1 sn_op0_n100_s5_w0p2_1 wwl_des wbl_op0_n100_s5_w0p2 0 sky130_fd_pr__nfet_01v8 L=0.15 W=0.42 nf=1 ad=0.1218 as=0.1218 pd=1.42 ps=1.42 nrd=0.69047619047619  nrs=0.69047619047619 sa=0 sb=0 sd=0 mult=1 m=1
XMRD_op0_n100_s5_w0p2_1 rbl_op0_n100_s5_w0p2 sn_op0_n100_s5_w0p2_1 rwl_des 0 sky130_fd_pr__nfet_01v8 L=0.15 W=0.42 nf=1 ad=0.1218 as=0.1218 pd=1.42 ps=1.42 nrd=0.69047619047619  nrs=0.69047619047619 sa=0 sb=0 sd=0 mult=1 m=1
csn_op0_n100_s5_w0p2_1 sn_op0_n100_s5_w0p2_1 0 {C_SN}
XMWR_op0_n100_s5_w0p2_2 sn_op0_n100_s5_w0p2_2 wwl_des wbl_op0_n100_s5_w0p2 0 sky130_fd_pr__nfet_01v8 L=0.15 W=0.42 nf=1 ad=0.1218 as=0.1218 pd=1.42 ps=1.42 nrd=0.69047619047619  nrs=0.69047619047619 sa=0 sb=0 sd=0 mult=1 m=1
XMRD_op0_n100_s5_w0p2_2 rbl_op0_n100_s5_w0p2 sn_op0_n100_s5_w0p2_2 rwl_des 0 sky130_fd_pr__nfet_01v8 L=0.15 W=0.42 nf=1 ad=0.1218 as=0.1218 pd=1.42 ps=1.42 nrd=0.69047619047619  nrs=0.69047619047619 sa=0 sb=0 sd=0 mult=1 m=1
csn_op0_n100_s5_w0p2_2 sn_op0_n100_s5_w0p2_2 0 {C_SN}
XMWR_op0_n100_s5_w0p2_3 sn_op0_n100_s5_w0p2_3 wwl_des wbl_op0_n100_s5_w0p2 0 sky130_fd_pr__nfet_01v8 L=0.15 W=0.42 nf=1 ad=0.1218 as=0.1218 pd=1.42 ps=1.42 nrd=0.69047619047619  nrs=0.69047619047619 sa=0 sb=0 sd=0 mult=1 m=1
XMRD_op0_n100_s5_w0p2_3 rbl_op0_n100_s5_w0p2 sn_op0_n100_s5_w0p2_3 rwl_des 0 sky130_fd_pr__nfet_01v8 L=0.15 W=0.42 nf=1 ad=0.1218 as=0.1218 pd=1.42 ps=1.42 nrd=0.69047619047619  nrs=0.69047619047619 sa=0 sb=0 sd=0 mult=1 m=1
csn_op0_n100_s5_w0p2_3 sn_op0_n100_s5_w0p2_3 0 {C_SN}
XMN1_op0_n100_s5_w0p2 rbl_op0_n100_s5_w0p2 ref_op0_n100_s5_w0p2 vn_op0_n100_s5_w0p2 0 sky130_fd_pr__nfet_01v8 L=0.15 W=1 nf=1 ad=0.29 as=0.29 pd=2.58 ps=2.58 mult=1 m=1
XMN2_op0_n100_s5_w0p2 ref_op0_n100_s5_w0p2 rbl_op0_n100_s5_w0p2 vn_op0_n100_s5_w0p2 0 sky130_fd_pr__nfet_01v8 L=0.15 W=1 nf=1 ad=0.29 as=0.29 pd=2.58 ps=2.58 mult=1 m=1
XMP1_op0_n100_s5_w0p2 rbl_op0_n100_s5_w0p2 ref_op0_n100_s5_w0p2 vp_op0_n100_s5_w0p2 vdd sky130_fd_pr__pfet_01v8 L=0.15 W=2 nf=1 ad=0.58 as=0.58 pd=4.58 ps=4.58 mult=1 m=1
XMP2_op0_n100_s5_w0p2 ref_op0_n100_s5_w0p2 rbl_op0_n100_s5_w0p2 vp_op0_n100_s5_w0p2 vdd sky130_fd_pr__pfet_01v8 L=0.15 W=2 nf=1 ad=0.58 as=0.58 pd=4.58 ps=4.58 mult=1 m=1
XMNF_op0_n100_s5_w0p2 vn_op0_n100_s5_w0p2 en_op0_n100_s5_w0p2 0 0 sky130_fd_pr__nfet_01v8 L=0.15 W=2 nf=1 ad=0.58 as=0.58 pd=4.58 ps=4.58 mult=1 m=1
XMPH_op0_n100_s5_w0p2 vp_op0_n100_s5_w0p2 enb_op0_n100_s5_w0p2 vdd vdd sky130_fd_pr__pfet_01v8 L=0.15 W=4 nf=1 ad=1.16 as=1.16 pd=8.58 ps=8.58 mult=1 m=1
bd_op0_n100_s5_w0p2 d_op0_n100_s5_w0p2 0 v=v(rbl_op0_n100_s5_w0p2)-v(ref_op0_n100_s5_w0p2)

* ---- instance 157: op0_n100_s5_w0p5 (t_en 9 ns, WWL 10..10.5 ns, release 12.5 ns) ----
ven_op0_n100_s5_w0p5  en_op0_n100_s5_w0p5  0 pwl(0 0 9.0000e-09 0 9.1000e-09 {VDD} 1.2500e-08 {VDD} 1.2600e-08 0)
venb_op0_n100_s5_w0p5 enb_op0_n100_s5_w0p5 0 pwl(0 {VDD} 9.0000e-09 {VDD} 9.1000e-09 0 1.2500e-08 0 1.2600e-08 {VDD})
vrs_op0_n100_s5_w0p5  rwls_op0_n100_s5_w0p5 0 pwl(0 {VDD} {T_READ} {VDD} {T_READ+TEDGE} 0 1.2500e-08 0 1.2600e-08 {VDD})
vww_op0_n100_s5_w0p5  wwl_op0_n100_s5_w0p5 0 pwl(0 0 1.0000e-08 0 1.0100e-08 {VDD} 1.0500e-08 {VDD} 1.0600e-08 0)
vwc_op0_n100_s5_w0p5  wbc_op0_n100_s5_w0p5 0 pwl(0 0 1.0000e-08 0 1.0100e-08 {VDD} 1.2500e-08 {VDD} 1.2600e-08 0)
swb_op0_n100_s5_w0p5 ref_op0_n100_s5_w0p5 wbl_op0_n100_s5_w0p5 wbc_op0_n100_s5_w0p5 0 swwbl
cwbl_op0_n100_s5_w0p5 wbl_op0_n100_s5_w0p5 0 {C_WBL}
spa_op0_n100_s5_w0p5 prea rbl_op0_n100_s5_w0p5 ctl 0 swpre
spr_op0_n100_s5_w0p5 pref ref_op0_n100_s5_w0p5 ctl 0 swpre
crbl_op0_n100_s5_w0p5 rbl_op0_n100_s5_w0p5 0 {C_RBL}
cref_op0_n100_s5_w0p5 ref_op0_n100_s5_w0p5 0 {C_RBL}   $ ASSUMPTION: ideal matched dummy load
XMWR_op0_n100_s5_w0p5_0 sn_op0_n100_s5_w0p5_0 wwl_op0_n100_s5_w0p5 wbl_op0_n100_s5_w0p5 0 sky130_fd_pr__nfet_01v8 L=0.15 W=0.42 nf=1 ad=0.1218 as=0.1218 pd=1.42 ps=1.42 nrd=0.69047619047619  nrs=0.69047619047619 sa=0 sb=0 sd=0 mult=1 m=1
XMRD_op0_n100_s5_w0p5_0 rbl_op0_n100_s5_w0p5 sn_op0_n100_s5_w0p5_0 rwls_op0_n100_s5_w0p5 0 sky130_fd_pr__nfet_01v8 L=0.15 W=0.42 nf=1 ad=0.1218 as=0.1218 pd=1.42 ps=1.42 nrd=0.69047619047619  nrs=0.69047619047619 sa=0 sb=0 sd=0 mult=1 m=1
csn_op0_n100_s5_w0p5_0 sn_op0_n100_s5_w0p5_0 0 {C_SN}
XMWR_op0_n100_s5_w0p5_1 sn_op0_n100_s5_w0p5_1 wwl_des wbl_op0_n100_s5_w0p5 0 sky130_fd_pr__nfet_01v8 L=0.15 W=0.42 nf=1 ad=0.1218 as=0.1218 pd=1.42 ps=1.42 nrd=0.69047619047619  nrs=0.69047619047619 sa=0 sb=0 sd=0 mult=1 m=1
XMRD_op0_n100_s5_w0p5_1 rbl_op0_n100_s5_w0p5 sn_op0_n100_s5_w0p5_1 rwl_des 0 sky130_fd_pr__nfet_01v8 L=0.15 W=0.42 nf=1 ad=0.1218 as=0.1218 pd=1.42 ps=1.42 nrd=0.69047619047619  nrs=0.69047619047619 sa=0 sb=0 sd=0 mult=1 m=1
csn_op0_n100_s5_w0p5_1 sn_op0_n100_s5_w0p5_1 0 {C_SN}
XMWR_op0_n100_s5_w0p5_2 sn_op0_n100_s5_w0p5_2 wwl_des wbl_op0_n100_s5_w0p5 0 sky130_fd_pr__nfet_01v8 L=0.15 W=0.42 nf=1 ad=0.1218 as=0.1218 pd=1.42 ps=1.42 nrd=0.69047619047619  nrs=0.69047619047619 sa=0 sb=0 sd=0 mult=1 m=1
XMRD_op0_n100_s5_w0p5_2 rbl_op0_n100_s5_w0p5 sn_op0_n100_s5_w0p5_2 rwl_des 0 sky130_fd_pr__nfet_01v8 L=0.15 W=0.42 nf=1 ad=0.1218 as=0.1218 pd=1.42 ps=1.42 nrd=0.69047619047619  nrs=0.69047619047619 sa=0 sb=0 sd=0 mult=1 m=1
csn_op0_n100_s5_w0p5_2 sn_op0_n100_s5_w0p5_2 0 {C_SN}
XMWR_op0_n100_s5_w0p5_3 sn_op0_n100_s5_w0p5_3 wwl_des wbl_op0_n100_s5_w0p5 0 sky130_fd_pr__nfet_01v8 L=0.15 W=0.42 nf=1 ad=0.1218 as=0.1218 pd=1.42 ps=1.42 nrd=0.69047619047619  nrs=0.69047619047619 sa=0 sb=0 sd=0 mult=1 m=1
XMRD_op0_n100_s5_w0p5_3 rbl_op0_n100_s5_w0p5 sn_op0_n100_s5_w0p5_3 rwl_des 0 sky130_fd_pr__nfet_01v8 L=0.15 W=0.42 nf=1 ad=0.1218 as=0.1218 pd=1.42 ps=1.42 nrd=0.69047619047619  nrs=0.69047619047619 sa=0 sb=0 sd=0 mult=1 m=1
csn_op0_n100_s5_w0p5_3 sn_op0_n100_s5_w0p5_3 0 {C_SN}
XMN1_op0_n100_s5_w0p5 rbl_op0_n100_s5_w0p5 ref_op0_n100_s5_w0p5 vn_op0_n100_s5_w0p5 0 sky130_fd_pr__nfet_01v8 L=0.15 W=1 nf=1 ad=0.29 as=0.29 pd=2.58 ps=2.58 mult=1 m=1
XMN2_op0_n100_s5_w0p5 ref_op0_n100_s5_w0p5 rbl_op0_n100_s5_w0p5 vn_op0_n100_s5_w0p5 0 sky130_fd_pr__nfet_01v8 L=0.15 W=1 nf=1 ad=0.29 as=0.29 pd=2.58 ps=2.58 mult=1 m=1
XMP1_op0_n100_s5_w0p5 rbl_op0_n100_s5_w0p5 ref_op0_n100_s5_w0p5 vp_op0_n100_s5_w0p5 vdd sky130_fd_pr__pfet_01v8 L=0.15 W=2 nf=1 ad=0.58 as=0.58 pd=4.58 ps=4.58 mult=1 m=1
XMP2_op0_n100_s5_w0p5 ref_op0_n100_s5_w0p5 rbl_op0_n100_s5_w0p5 vp_op0_n100_s5_w0p5 vdd sky130_fd_pr__pfet_01v8 L=0.15 W=2 nf=1 ad=0.58 as=0.58 pd=4.58 ps=4.58 mult=1 m=1
XMNF_op0_n100_s5_w0p5 vn_op0_n100_s5_w0p5 en_op0_n100_s5_w0p5 0 0 sky130_fd_pr__nfet_01v8 L=0.15 W=2 nf=1 ad=0.58 as=0.58 pd=4.58 ps=4.58 mult=1 m=1
XMPH_op0_n100_s5_w0p5 vp_op0_n100_s5_w0p5 enb_op0_n100_s5_w0p5 vdd vdd sky130_fd_pr__pfet_01v8 L=0.15 W=4 nf=1 ad=1.16 as=1.16 pd=8.58 ps=8.58 mult=1 m=1
bd_op0_n100_s5_w0p5 d_op0_n100_s5_w0p5 0 v=v(rbl_op0_n100_s5_w0p5)-v(ref_op0_n100_s5_w0p5)

* ---- instance 158: op0_n100_s5_w1 (t_en 9 ns, WWL 10..11 ns, release 13 ns) ----
ven_op0_n100_s5_w1  en_op0_n100_s5_w1  0 pwl(0 0 9.0000e-09 0 9.1000e-09 {VDD} 1.3000e-08 {VDD} 1.3100e-08 0)
venb_op0_n100_s5_w1 enb_op0_n100_s5_w1 0 pwl(0 {VDD} 9.0000e-09 {VDD} 9.1000e-09 0 1.3000e-08 0 1.3100e-08 {VDD})
vrs_op0_n100_s5_w1  rwls_op0_n100_s5_w1 0 pwl(0 {VDD} {T_READ} {VDD} {T_READ+TEDGE} 0 1.3000e-08 0 1.3100e-08 {VDD})
vww_op0_n100_s5_w1  wwl_op0_n100_s5_w1 0 pwl(0 0 1.0000e-08 0 1.0100e-08 {VDD} 1.1000e-08 {VDD} 1.1100e-08 0)
vwc_op0_n100_s5_w1  wbc_op0_n100_s5_w1 0 pwl(0 0 1.0000e-08 0 1.0100e-08 {VDD} 1.3000e-08 {VDD} 1.3100e-08 0)
swb_op0_n100_s5_w1 ref_op0_n100_s5_w1 wbl_op0_n100_s5_w1 wbc_op0_n100_s5_w1 0 swwbl
cwbl_op0_n100_s5_w1 wbl_op0_n100_s5_w1 0 {C_WBL}
spa_op0_n100_s5_w1 prea rbl_op0_n100_s5_w1 ctl 0 swpre
spr_op0_n100_s5_w1 pref ref_op0_n100_s5_w1 ctl 0 swpre
crbl_op0_n100_s5_w1 rbl_op0_n100_s5_w1 0 {C_RBL}
cref_op0_n100_s5_w1 ref_op0_n100_s5_w1 0 {C_RBL}   $ ASSUMPTION: ideal matched dummy load
XMWR_op0_n100_s5_w1_0 sn_op0_n100_s5_w1_0 wwl_op0_n100_s5_w1 wbl_op0_n100_s5_w1 0 sky130_fd_pr__nfet_01v8 L=0.15 W=0.42 nf=1 ad=0.1218 as=0.1218 pd=1.42 ps=1.42 nrd=0.69047619047619  nrs=0.69047619047619 sa=0 sb=0 sd=0 mult=1 m=1
XMRD_op0_n100_s5_w1_0 rbl_op0_n100_s5_w1 sn_op0_n100_s5_w1_0 rwls_op0_n100_s5_w1 0 sky130_fd_pr__nfet_01v8 L=0.15 W=0.42 nf=1 ad=0.1218 as=0.1218 pd=1.42 ps=1.42 nrd=0.69047619047619  nrs=0.69047619047619 sa=0 sb=0 sd=0 mult=1 m=1
csn_op0_n100_s5_w1_0 sn_op0_n100_s5_w1_0 0 {C_SN}
XMWR_op0_n100_s5_w1_1 sn_op0_n100_s5_w1_1 wwl_des wbl_op0_n100_s5_w1 0 sky130_fd_pr__nfet_01v8 L=0.15 W=0.42 nf=1 ad=0.1218 as=0.1218 pd=1.42 ps=1.42 nrd=0.69047619047619  nrs=0.69047619047619 sa=0 sb=0 sd=0 mult=1 m=1
XMRD_op0_n100_s5_w1_1 rbl_op0_n100_s5_w1 sn_op0_n100_s5_w1_1 rwl_des 0 sky130_fd_pr__nfet_01v8 L=0.15 W=0.42 nf=1 ad=0.1218 as=0.1218 pd=1.42 ps=1.42 nrd=0.69047619047619  nrs=0.69047619047619 sa=0 sb=0 sd=0 mult=1 m=1
csn_op0_n100_s5_w1_1 sn_op0_n100_s5_w1_1 0 {C_SN}
XMWR_op0_n100_s5_w1_2 sn_op0_n100_s5_w1_2 wwl_des wbl_op0_n100_s5_w1 0 sky130_fd_pr__nfet_01v8 L=0.15 W=0.42 nf=1 ad=0.1218 as=0.1218 pd=1.42 ps=1.42 nrd=0.69047619047619  nrs=0.69047619047619 sa=0 sb=0 sd=0 mult=1 m=1
XMRD_op0_n100_s5_w1_2 rbl_op0_n100_s5_w1 sn_op0_n100_s5_w1_2 rwl_des 0 sky130_fd_pr__nfet_01v8 L=0.15 W=0.42 nf=1 ad=0.1218 as=0.1218 pd=1.42 ps=1.42 nrd=0.69047619047619  nrs=0.69047619047619 sa=0 sb=0 sd=0 mult=1 m=1
csn_op0_n100_s5_w1_2 sn_op0_n100_s5_w1_2 0 {C_SN}
XMWR_op0_n100_s5_w1_3 sn_op0_n100_s5_w1_3 wwl_des wbl_op0_n100_s5_w1 0 sky130_fd_pr__nfet_01v8 L=0.15 W=0.42 nf=1 ad=0.1218 as=0.1218 pd=1.42 ps=1.42 nrd=0.69047619047619  nrs=0.69047619047619 sa=0 sb=0 sd=0 mult=1 m=1
XMRD_op0_n100_s5_w1_3 rbl_op0_n100_s5_w1 sn_op0_n100_s5_w1_3 rwl_des 0 sky130_fd_pr__nfet_01v8 L=0.15 W=0.42 nf=1 ad=0.1218 as=0.1218 pd=1.42 ps=1.42 nrd=0.69047619047619  nrs=0.69047619047619 sa=0 sb=0 sd=0 mult=1 m=1
csn_op0_n100_s5_w1_3 sn_op0_n100_s5_w1_3 0 {C_SN}
XMN1_op0_n100_s5_w1 rbl_op0_n100_s5_w1 ref_op0_n100_s5_w1 vn_op0_n100_s5_w1 0 sky130_fd_pr__nfet_01v8 L=0.15 W=1 nf=1 ad=0.29 as=0.29 pd=2.58 ps=2.58 mult=1 m=1
XMN2_op0_n100_s5_w1 ref_op0_n100_s5_w1 rbl_op0_n100_s5_w1 vn_op0_n100_s5_w1 0 sky130_fd_pr__nfet_01v8 L=0.15 W=1 nf=1 ad=0.29 as=0.29 pd=2.58 ps=2.58 mult=1 m=1
XMP1_op0_n100_s5_w1 rbl_op0_n100_s5_w1 ref_op0_n100_s5_w1 vp_op0_n100_s5_w1 vdd sky130_fd_pr__pfet_01v8 L=0.15 W=2 nf=1 ad=0.58 as=0.58 pd=4.58 ps=4.58 mult=1 m=1
XMP2_op0_n100_s5_w1 ref_op0_n100_s5_w1 rbl_op0_n100_s5_w1 vp_op0_n100_s5_w1 vdd sky130_fd_pr__pfet_01v8 L=0.15 W=2 nf=1 ad=0.58 as=0.58 pd=4.58 ps=4.58 mult=1 m=1
XMNF_op0_n100_s5_w1 vn_op0_n100_s5_w1 en_op0_n100_s5_w1 0 0 sky130_fd_pr__nfet_01v8 L=0.15 W=2 nf=1 ad=0.58 as=0.58 pd=4.58 ps=4.58 mult=1 m=1
XMPH_op0_n100_s5_w1 vp_op0_n100_s5_w1 enb_op0_n100_s5_w1 vdd vdd sky130_fd_pr__pfet_01v8 L=0.15 W=4 nf=1 ad=1.16 as=1.16 pd=8.58 ps=8.58 mult=1 m=1
bd_op0_n100_s5_w1 d_op0_n100_s5_w1 0 v=v(rbl_op0_n100_s5_w1)-v(ref_op0_n100_s5_w1)

* ---- instance 159: op0_n100_s5_w2 (t_en 9 ns, WWL 10..12 ns, release 14 ns) ----
ven_op0_n100_s5_w2  en_op0_n100_s5_w2  0 pwl(0 0 9.0000e-09 0 9.1000e-09 {VDD} 1.4000e-08 {VDD} 1.4100e-08 0)
venb_op0_n100_s5_w2 enb_op0_n100_s5_w2 0 pwl(0 {VDD} 9.0000e-09 {VDD} 9.1000e-09 0 1.4000e-08 0 1.4100e-08 {VDD})
vrs_op0_n100_s5_w2  rwls_op0_n100_s5_w2 0 pwl(0 {VDD} {T_READ} {VDD} {T_READ+TEDGE} 0 1.4000e-08 0 1.4100e-08 {VDD})
vww_op0_n100_s5_w2  wwl_op0_n100_s5_w2 0 pwl(0 0 1.0000e-08 0 1.0100e-08 {VDD} 1.2000e-08 {VDD} 1.2100e-08 0)
vwc_op0_n100_s5_w2  wbc_op0_n100_s5_w2 0 pwl(0 0 1.0000e-08 0 1.0100e-08 {VDD} 1.4000e-08 {VDD} 1.4100e-08 0)
swb_op0_n100_s5_w2 ref_op0_n100_s5_w2 wbl_op0_n100_s5_w2 wbc_op0_n100_s5_w2 0 swwbl
cwbl_op0_n100_s5_w2 wbl_op0_n100_s5_w2 0 {C_WBL}
spa_op0_n100_s5_w2 prea rbl_op0_n100_s5_w2 ctl 0 swpre
spr_op0_n100_s5_w2 pref ref_op0_n100_s5_w2 ctl 0 swpre
crbl_op0_n100_s5_w2 rbl_op0_n100_s5_w2 0 {C_RBL}
cref_op0_n100_s5_w2 ref_op0_n100_s5_w2 0 {C_RBL}   $ ASSUMPTION: ideal matched dummy load
XMWR_op0_n100_s5_w2_0 sn_op0_n100_s5_w2_0 wwl_op0_n100_s5_w2 wbl_op0_n100_s5_w2 0 sky130_fd_pr__nfet_01v8 L=0.15 W=0.42 nf=1 ad=0.1218 as=0.1218 pd=1.42 ps=1.42 nrd=0.69047619047619  nrs=0.69047619047619 sa=0 sb=0 sd=0 mult=1 m=1
XMRD_op0_n100_s5_w2_0 rbl_op0_n100_s5_w2 sn_op0_n100_s5_w2_0 rwls_op0_n100_s5_w2 0 sky130_fd_pr__nfet_01v8 L=0.15 W=0.42 nf=1 ad=0.1218 as=0.1218 pd=1.42 ps=1.42 nrd=0.69047619047619  nrs=0.69047619047619 sa=0 sb=0 sd=0 mult=1 m=1
csn_op0_n100_s5_w2_0 sn_op0_n100_s5_w2_0 0 {C_SN}
XMWR_op0_n100_s5_w2_1 sn_op0_n100_s5_w2_1 wwl_des wbl_op0_n100_s5_w2 0 sky130_fd_pr__nfet_01v8 L=0.15 W=0.42 nf=1 ad=0.1218 as=0.1218 pd=1.42 ps=1.42 nrd=0.69047619047619  nrs=0.69047619047619 sa=0 sb=0 sd=0 mult=1 m=1
XMRD_op0_n100_s5_w2_1 rbl_op0_n100_s5_w2 sn_op0_n100_s5_w2_1 rwl_des 0 sky130_fd_pr__nfet_01v8 L=0.15 W=0.42 nf=1 ad=0.1218 as=0.1218 pd=1.42 ps=1.42 nrd=0.69047619047619  nrs=0.69047619047619 sa=0 sb=0 sd=0 mult=1 m=1
csn_op0_n100_s5_w2_1 sn_op0_n100_s5_w2_1 0 {C_SN}
XMWR_op0_n100_s5_w2_2 sn_op0_n100_s5_w2_2 wwl_des wbl_op0_n100_s5_w2 0 sky130_fd_pr__nfet_01v8 L=0.15 W=0.42 nf=1 ad=0.1218 as=0.1218 pd=1.42 ps=1.42 nrd=0.69047619047619  nrs=0.69047619047619 sa=0 sb=0 sd=0 mult=1 m=1
XMRD_op0_n100_s5_w2_2 rbl_op0_n100_s5_w2 sn_op0_n100_s5_w2_2 rwl_des 0 sky130_fd_pr__nfet_01v8 L=0.15 W=0.42 nf=1 ad=0.1218 as=0.1218 pd=1.42 ps=1.42 nrd=0.69047619047619  nrs=0.69047619047619 sa=0 sb=0 sd=0 mult=1 m=1
csn_op0_n100_s5_w2_2 sn_op0_n100_s5_w2_2 0 {C_SN}
XMWR_op0_n100_s5_w2_3 sn_op0_n100_s5_w2_3 wwl_des wbl_op0_n100_s5_w2 0 sky130_fd_pr__nfet_01v8 L=0.15 W=0.42 nf=1 ad=0.1218 as=0.1218 pd=1.42 ps=1.42 nrd=0.69047619047619  nrs=0.69047619047619 sa=0 sb=0 sd=0 mult=1 m=1
XMRD_op0_n100_s5_w2_3 rbl_op0_n100_s5_w2 sn_op0_n100_s5_w2_3 rwl_des 0 sky130_fd_pr__nfet_01v8 L=0.15 W=0.42 nf=1 ad=0.1218 as=0.1218 pd=1.42 ps=1.42 nrd=0.69047619047619  nrs=0.69047619047619 sa=0 sb=0 sd=0 mult=1 m=1
csn_op0_n100_s5_w2_3 sn_op0_n100_s5_w2_3 0 {C_SN}
XMN1_op0_n100_s5_w2 rbl_op0_n100_s5_w2 ref_op0_n100_s5_w2 vn_op0_n100_s5_w2 0 sky130_fd_pr__nfet_01v8 L=0.15 W=1 nf=1 ad=0.29 as=0.29 pd=2.58 ps=2.58 mult=1 m=1
XMN2_op0_n100_s5_w2 ref_op0_n100_s5_w2 rbl_op0_n100_s5_w2 vn_op0_n100_s5_w2 0 sky130_fd_pr__nfet_01v8 L=0.15 W=1 nf=1 ad=0.29 as=0.29 pd=2.58 ps=2.58 mult=1 m=1
XMP1_op0_n100_s5_w2 rbl_op0_n100_s5_w2 ref_op0_n100_s5_w2 vp_op0_n100_s5_w2 vdd sky130_fd_pr__pfet_01v8 L=0.15 W=2 nf=1 ad=0.58 as=0.58 pd=4.58 ps=4.58 mult=1 m=1
XMP2_op0_n100_s5_w2 ref_op0_n100_s5_w2 rbl_op0_n100_s5_w2 vp_op0_n100_s5_w2 vdd sky130_fd_pr__pfet_01v8 L=0.15 W=2 nf=1 ad=0.58 as=0.58 pd=4.58 ps=4.58 mult=1 m=1
XMNF_op0_n100_s5_w2 vn_op0_n100_s5_w2 en_op0_n100_s5_w2 0 0 sky130_fd_pr__nfet_01v8 L=0.15 W=2 nf=1 ad=0.58 as=0.58 pd=4.58 ps=4.58 mult=1 m=1
XMPH_op0_n100_s5_w2 vp_op0_n100_s5_w2 enb_op0_n100_s5_w2 vdd vdd sky130_fd_pr__pfet_01v8 L=0.15 W=4 nf=1 ad=1.16 as=1.16 pd=8.58 ps=8.58 mult=1 m=1
bd_op0_n100_s5_w2 d_op0_n100_s5_w2 0 v=v(rbl_op0_n100_s5_w2)-v(ref_op0_n100_s5_w2)

* ---- instance 160: op0_n100_s5_w3 (t_en 9 ns, WWL 10..13 ns, release 15 ns) ----
ven_op0_n100_s5_w3  en_op0_n100_s5_w3  0 pwl(0 0 9.0000e-09 0 9.1000e-09 {VDD} 1.5000e-08 {VDD} 1.5100e-08 0)
venb_op0_n100_s5_w3 enb_op0_n100_s5_w3 0 pwl(0 {VDD} 9.0000e-09 {VDD} 9.1000e-09 0 1.5000e-08 0 1.5100e-08 {VDD})
vrs_op0_n100_s5_w3  rwls_op0_n100_s5_w3 0 pwl(0 {VDD} {T_READ} {VDD} {T_READ+TEDGE} 0 1.5000e-08 0 1.5100e-08 {VDD})
vww_op0_n100_s5_w3  wwl_op0_n100_s5_w3 0 pwl(0 0 1.0000e-08 0 1.0100e-08 {VDD} 1.3000e-08 {VDD} 1.3100e-08 0)
vwc_op0_n100_s5_w3  wbc_op0_n100_s5_w3 0 pwl(0 0 1.0000e-08 0 1.0100e-08 {VDD} 1.5000e-08 {VDD} 1.5100e-08 0)
swb_op0_n100_s5_w3 ref_op0_n100_s5_w3 wbl_op0_n100_s5_w3 wbc_op0_n100_s5_w3 0 swwbl
cwbl_op0_n100_s5_w3 wbl_op0_n100_s5_w3 0 {C_WBL}
spa_op0_n100_s5_w3 prea rbl_op0_n100_s5_w3 ctl 0 swpre
spr_op0_n100_s5_w3 pref ref_op0_n100_s5_w3 ctl 0 swpre
crbl_op0_n100_s5_w3 rbl_op0_n100_s5_w3 0 {C_RBL}
cref_op0_n100_s5_w3 ref_op0_n100_s5_w3 0 {C_RBL}   $ ASSUMPTION: ideal matched dummy load
XMWR_op0_n100_s5_w3_0 sn_op0_n100_s5_w3_0 wwl_op0_n100_s5_w3 wbl_op0_n100_s5_w3 0 sky130_fd_pr__nfet_01v8 L=0.15 W=0.42 nf=1 ad=0.1218 as=0.1218 pd=1.42 ps=1.42 nrd=0.69047619047619  nrs=0.69047619047619 sa=0 sb=0 sd=0 mult=1 m=1
XMRD_op0_n100_s5_w3_0 rbl_op0_n100_s5_w3 sn_op0_n100_s5_w3_0 rwls_op0_n100_s5_w3 0 sky130_fd_pr__nfet_01v8 L=0.15 W=0.42 nf=1 ad=0.1218 as=0.1218 pd=1.42 ps=1.42 nrd=0.69047619047619  nrs=0.69047619047619 sa=0 sb=0 sd=0 mult=1 m=1
csn_op0_n100_s5_w3_0 sn_op0_n100_s5_w3_0 0 {C_SN}
XMWR_op0_n100_s5_w3_1 sn_op0_n100_s5_w3_1 wwl_des wbl_op0_n100_s5_w3 0 sky130_fd_pr__nfet_01v8 L=0.15 W=0.42 nf=1 ad=0.1218 as=0.1218 pd=1.42 ps=1.42 nrd=0.69047619047619  nrs=0.69047619047619 sa=0 sb=0 sd=0 mult=1 m=1
XMRD_op0_n100_s5_w3_1 rbl_op0_n100_s5_w3 sn_op0_n100_s5_w3_1 rwl_des 0 sky130_fd_pr__nfet_01v8 L=0.15 W=0.42 nf=1 ad=0.1218 as=0.1218 pd=1.42 ps=1.42 nrd=0.69047619047619  nrs=0.69047619047619 sa=0 sb=0 sd=0 mult=1 m=1
csn_op0_n100_s5_w3_1 sn_op0_n100_s5_w3_1 0 {C_SN}
XMWR_op0_n100_s5_w3_2 sn_op0_n100_s5_w3_2 wwl_des wbl_op0_n100_s5_w3 0 sky130_fd_pr__nfet_01v8 L=0.15 W=0.42 nf=1 ad=0.1218 as=0.1218 pd=1.42 ps=1.42 nrd=0.69047619047619  nrs=0.69047619047619 sa=0 sb=0 sd=0 mult=1 m=1
XMRD_op0_n100_s5_w3_2 rbl_op0_n100_s5_w3 sn_op0_n100_s5_w3_2 rwl_des 0 sky130_fd_pr__nfet_01v8 L=0.15 W=0.42 nf=1 ad=0.1218 as=0.1218 pd=1.42 ps=1.42 nrd=0.69047619047619  nrs=0.69047619047619 sa=0 sb=0 sd=0 mult=1 m=1
csn_op0_n100_s5_w3_2 sn_op0_n100_s5_w3_2 0 {C_SN}
XMWR_op0_n100_s5_w3_3 sn_op0_n100_s5_w3_3 wwl_des wbl_op0_n100_s5_w3 0 sky130_fd_pr__nfet_01v8 L=0.15 W=0.42 nf=1 ad=0.1218 as=0.1218 pd=1.42 ps=1.42 nrd=0.69047619047619  nrs=0.69047619047619 sa=0 sb=0 sd=0 mult=1 m=1
XMRD_op0_n100_s5_w3_3 rbl_op0_n100_s5_w3 sn_op0_n100_s5_w3_3 rwl_des 0 sky130_fd_pr__nfet_01v8 L=0.15 W=0.42 nf=1 ad=0.1218 as=0.1218 pd=1.42 ps=1.42 nrd=0.69047619047619  nrs=0.69047619047619 sa=0 sb=0 sd=0 mult=1 m=1
csn_op0_n100_s5_w3_3 sn_op0_n100_s5_w3_3 0 {C_SN}
XMN1_op0_n100_s5_w3 rbl_op0_n100_s5_w3 ref_op0_n100_s5_w3 vn_op0_n100_s5_w3 0 sky130_fd_pr__nfet_01v8 L=0.15 W=1 nf=1 ad=0.29 as=0.29 pd=2.58 ps=2.58 mult=1 m=1
XMN2_op0_n100_s5_w3 ref_op0_n100_s5_w3 rbl_op0_n100_s5_w3 vn_op0_n100_s5_w3 0 sky130_fd_pr__nfet_01v8 L=0.15 W=1 nf=1 ad=0.29 as=0.29 pd=2.58 ps=2.58 mult=1 m=1
XMP1_op0_n100_s5_w3 rbl_op0_n100_s5_w3 ref_op0_n100_s5_w3 vp_op0_n100_s5_w3 vdd sky130_fd_pr__pfet_01v8 L=0.15 W=2 nf=1 ad=0.58 as=0.58 pd=4.58 ps=4.58 mult=1 m=1
XMP2_op0_n100_s5_w3 ref_op0_n100_s5_w3 rbl_op0_n100_s5_w3 vp_op0_n100_s5_w3 vdd sky130_fd_pr__pfet_01v8 L=0.15 W=2 nf=1 ad=0.58 as=0.58 pd=4.58 ps=4.58 mult=1 m=1
XMNF_op0_n100_s5_w3 vn_op0_n100_s5_w3 en_op0_n100_s5_w3 0 0 sky130_fd_pr__nfet_01v8 L=0.15 W=2 nf=1 ad=0.58 as=0.58 pd=4.58 ps=4.58 mult=1 m=1
XMPH_op0_n100_s5_w3 vp_op0_n100_s5_w3 enb_op0_n100_s5_w3 vdd vdd sky130_fd_pr__pfet_01v8 L=0.15 W=4 nf=1 ad=1.16 as=1.16 pd=8.58 ps=8.58 mult=1 m=1
bd_op0_n100_s5_w3 d_op0_n100_s5_w3 0 v=v(rbl_op0_n100_s5_w3)-v(ref_op0_n100_s5_w3)

* ---- instance 161: op0_n100_s5_w5 (t_en 9 ns, WWL 10..15 ns, release 17 ns) ----
ven_op0_n100_s5_w5  en_op0_n100_s5_w5  0 pwl(0 0 9.0000e-09 0 9.1000e-09 {VDD} 1.7000e-08 {VDD} 1.7100e-08 0)
venb_op0_n100_s5_w5 enb_op0_n100_s5_w5 0 pwl(0 {VDD} 9.0000e-09 {VDD} 9.1000e-09 0 1.7000e-08 0 1.7100e-08 {VDD})
vrs_op0_n100_s5_w5  rwls_op0_n100_s5_w5 0 pwl(0 {VDD} {T_READ} {VDD} {T_READ+TEDGE} 0 1.7000e-08 0 1.7100e-08 {VDD})
vww_op0_n100_s5_w5  wwl_op0_n100_s5_w5 0 pwl(0 0 1.0000e-08 0 1.0100e-08 {VDD} 1.5000e-08 {VDD} 1.5100e-08 0)
vwc_op0_n100_s5_w5  wbc_op0_n100_s5_w5 0 pwl(0 0 1.0000e-08 0 1.0100e-08 {VDD} 1.7000e-08 {VDD} 1.7100e-08 0)
swb_op0_n100_s5_w5 ref_op0_n100_s5_w5 wbl_op0_n100_s5_w5 wbc_op0_n100_s5_w5 0 swwbl
cwbl_op0_n100_s5_w5 wbl_op0_n100_s5_w5 0 {C_WBL}
spa_op0_n100_s5_w5 prea rbl_op0_n100_s5_w5 ctl 0 swpre
spr_op0_n100_s5_w5 pref ref_op0_n100_s5_w5 ctl 0 swpre
crbl_op0_n100_s5_w5 rbl_op0_n100_s5_w5 0 {C_RBL}
cref_op0_n100_s5_w5 ref_op0_n100_s5_w5 0 {C_RBL}   $ ASSUMPTION: ideal matched dummy load
XMWR_op0_n100_s5_w5_0 sn_op0_n100_s5_w5_0 wwl_op0_n100_s5_w5 wbl_op0_n100_s5_w5 0 sky130_fd_pr__nfet_01v8 L=0.15 W=0.42 nf=1 ad=0.1218 as=0.1218 pd=1.42 ps=1.42 nrd=0.69047619047619  nrs=0.69047619047619 sa=0 sb=0 sd=0 mult=1 m=1
XMRD_op0_n100_s5_w5_0 rbl_op0_n100_s5_w5 sn_op0_n100_s5_w5_0 rwls_op0_n100_s5_w5 0 sky130_fd_pr__nfet_01v8 L=0.15 W=0.42 nf=1 ad=0.1218 as=0.1218 pd=1.42 ps=1.42 nrd=0.69047619047619  nrs=0.69047619047619 sa=0 sb=0 sd=0 mult=1 m=1
csn_op0_n100_s5_w5_0 sn_op0_n100_s5_w5_0 0 {C_SN}
XMWR_op0_n100_s5_w5_1 sn_op0_n100_s5_w5_1 wwl_des wbl_op0_n100_s5_w5 0 sky130_fd_pr__nfet_01v8 L=0.15 W=0.42 nf=1 ad=0.1218 as=0.1218 pd=1.42 ps=1.42 nrd=0.69047619047619  nrs=0.69047619047619 sa=0 sb=0 sd=0 mult=1 m=1
XMRD_op0_n100_s5_w5_1 rbl_op0_n100_s5_w5 sn_op0_n100_s5_w5_1 rwl_des 0 sky130_fd_pr__nfet_01v8 L=0.15 W=0.42 nf=1 ad=0.1218 as=0.1218 pd=1.42 ps=1.42 nrd=0.69047619047619  nrs=0.69047619047619 sa=0 sb=0 sd=0 mult=1 m=1
csn_op0_n100_s5_w5_1 sn_op0_n100_s5_w5_1 0 {C_SN}
XMWR_op0_n100_s5_w5_2 sn_op0_n100_s5_w5_2 wwl_des wbl_op0_n100_s5_w5 0 sky130_fd_pr__nfet_01v8 L=0.15 W=0.42 nf=1 ad=0.1218 as=0.1218 pd=1.42 ps=1.42 nrd=0.69047619047619  nrs=0.69047619047619 sa=0 sb=0 sd=0 mult=1 m=1
XMRD_op0_n100_s5_w5_2 rbl_op0_n100_s5_w5 sn_op0_n100_s5_w5_2 rwl_des 0 sky130_fd_pr__nfet_01v8 L=0.15 W=0.42 nf=1 ad=0.1218 as=0.1218 pd=1.42 ps=1.42 nrd=0.69047619047619  nrs=0.69047619047619 sa=0 sb=0 sd=0 mult=1 m=1
csn_op0_n100_s5_w5_2 sn_op0_n100_s5_w5_2 0 {C_SN}
XMWR_op0_n100_s5_w5_3 sn_op0_n100_s5_w5_3 wwl_des wbl_op0_n100_s5_w5 0 sky130_fd_pr__nfet_01v8 L=0.15 W=0.42 nf=1 ad=0.1218 as=0.1218 pd=1.42 ps=1.42 nrd=0.69047619047619  nrs=0.69047619047619 sa=0 sb=0 sd=0 mult=1 m=1
XMRD_op0_n100_s5_w5_3 rbl_op0_n100_s5_w5 sn_op0_n100_s5_w5_3 rwl_des 0 sky130_fd_pr__nfet_01v8 L=0.15 W=0.42 nf=1 ad=0.1218 as=0.1218 pd=1.42 ps=1.42 nrd=0.69047619047619  nrs=0.69047619047619 sa=0 sb=0 sd=0 mult=1 m=1
csn_op0_n100_s5_w5_3 sn_op0_n100_s5_w5_3 0 {C_SN}
XMN1_op0_n100_s5_w5 rbl_op0_n100_s5_w5 ref_op0_n100_s5_w5 vn_op0_n100_s5_w5 0 sky130_fd_pr__nfet_01v8 L=0.15 W=1 nf=1 ad=0.29 as=0.29 pd=2.58 ps=2.58 mult=1 m=1
XMN2_op0_n100_s5_w5 ref_op0_n100_s5_w5 rbl_op0_n100_s5_w5 vn_op0_n100_s5_w5 0 sky130_fd_pr__nfet_01v8 L=0.15 W=1 nf=1 ad=0.29 as=0.29 pd=2.58 ps=2.58 mult=1 m=1
XMP1_op0_n100_s5_w5 rbl_op0_n100_s5_w5 ref_op0_n100_s5_w5 vp_op0_n100_s5_w5 vdd sky130_fd_pr__pfet_01v8 L=0.15 W=2 nf=1 ad=0.58 as=0.58 pd=4.58 ps=4.58 mult=1 m=1
XMP2_op0_n100_s5_w5 ref_op0_n100_s5_w5 rbl_op0_n100_s5_w5 vp_op0_n100_s5_w5 vdd sky130_fd_pr__pfet_01v8 L=0.15 W=2 nf=1 ad=0.58 as=0.58 pd=4.58 ps=4.58 mult=1 m=1
XMNF_op0_n100_s5_w5 vn_op0_n100_s5_w5 en_op0_n100_s5_w5 0 0 sky130_fd_pr__nfet_01v8 L=0.15 W=2 nf=1 ad=0.58 as=0.58 pd=4.58 ps=4.58 mult=1 m=1
XMPH_op0_n100_s5_w5 vp_op0_n100_s5_w5 enb_op0_n100_s5_w5 vdd vdd sky130_fd_pr__pfet_01v8 L=0.15 W=4 nf=1 ad=1.16 as=1.16 pd=8.58 ps=8.58 mult=1 m=1
bd_op0_n100_s5_w5 d_op0_n100_s5_w5 0 v=v(rbl_op0_n100_s5_w5)-v(ref_op0_n100_s5_w5)

* ---- instance 162: op0_n100_s5_w7p5 (t_en 9 ns, WWL 10..17.5 ns, release 19.5 ns) ----
ven_op0_n100_s5_w7p5  en_op0_n100_s5_w7p5  0 pwl(0 0 9.0000e-09 0 9.1000e-09 {VDD} 1.9500e-08 {VDD} 1.9600e-08 0)
venb_op0_n100_s5_w7p5 enb_op0_n100_s5_w7p5 0 pwl(0 {VDD} 9.0000e-09 {VDD} 9.1000e-09 0 1.9500e-08 0 1.9600e-08 {VDD})
vrs_op0_n100_s5_w7p5  rwls_op0_n100_s5_w7p5 0 pwl(0 {VDD} {T_READ} {VDD} {T_READ+TEDGE} 0 1.9500e-08 0 1.9600e-08 {VDD})
vww_op0_n100_s5_w7p5  wwl_op0_n100_s5_w7p5 0 pwl(0 0 1.0000e-08 0 1.0100e-08 {VDD} 1.7500e-08 {VDD} 1.7600e-08 0)
vwc_op0_n100_s5_w7p5  wbc_op0_n100_s5_w7p5 0 pwl(0 0 1.0000e-08 0 1.0100e-08 {VDD} 1.9500e-08 {VDD} 1.9600e-08 0)
swb_op0_n100_s5_w7p5 ref_op0_n100_s5_w7p5 wbl_op0_n100_s5_w7p5 wbc_op0_n100_s5_w7p5 0 swwbl
cwbl_op0_n100_s5_w7p5 wbl_op0_n100_s5_w7p5 0 {C_WBL}
spa_op0_n100_s5_w7p5 prea rbl_op0_n100_s5_w7p5 ctl 0 swpre
spr_op0_n100_s5_w7p5 pref ref_op0_n100_s5_w7p5 ctl 0 swpre
crbl_op0_n100_s5_w7p5 rbl_op0_n100_s5_w7p5 0 {C_RBL}
cref_op0_n100_s5_w7p5 ref_op0_n100_s5_w7p5 0 {C_RBL}   $ ASSUMPTION: ideal matched dummy load
XMWR_op0_n100_s5_w7p5_0 sn_op0_n100_s5_w7p5_0 wwl_op0_n100_s5_w7p5 wbl_op0_n100_s5_w7p5 0 sky130_fd_pr__nfet_01v8 L=0.15 W=0.42 nf=1 ad=0.1218 as=0.1218 pd=1.42 ps=1.42 nrd=0.69047619047619  nrs=0.69047619047619 sa=0 sb=0 sd=0 mult=1 m=1
XMRD_op0_n100_s5_w7p5_0 rbl_op0_n100_s5_w7p5 sn_op0_n100_s5_w7p5_0 rwls_op0_n100_s5_w7p5 0 sky130_fd_pr__nfet_01v8 L=0.15 W=0.42 nf=1 ad=0.1218 as=0.1218 pd=1.42 ps=1.42 nrd=0.69047619047619  nrs=0.69047619047619 sa=0 sb=0 sd=0 mult=1 m=1
csn_op0_n100_s5_w7p5_0 sn_op0_n100_s5_w7p5_0 0 {C_SN}
XMWR_op0_n100_s5_w7p5_1 sn_op0_n100_s5_w7p5_1 wwl_des wbl_op0_n100_s5_w7p5 0 sky130_fd_pr__nfet_01v8 L=0.15 W=0.42 nf=1 ad=0.1218 as=0.1218 pd=1.42 ps=1.42 nrd=0.69047619047619  nrs=0.69047619047619 sa=0 sb=0 sd=0 mult=1 m=1
XMRD_op0_n100_s5_w7p5_1 rbl_op0_n100_s5_w7p5 sn_op0_n100_s5_w7p5_1 rwl_des 0 sky130_fd_pr__nfet_01v8 L=0.15 W=0.42 nf=1 ad=0.1218 as=0.1218 pd=1.42 ps=1.42 nrd=0.69047619047619  nrs=0.69047619047619 sa=0 sb=0 sd=0 mult=1 m=1
csn_op0_n100_s5_w7p5_1 sn_op0_n100_s5_w7p5_1 0 {C_SN}
XMWR_op0_n100_s5_w7p5_2 sn_op0_n100_s5_w7p5_2 wwl_des wbl_op0_n100_s5_w7p5 0 sky130_fd_pr__nfet_01v8 L=0.15 W=0.42 nf=1 ad=0.1218 as=0.1218 pd=1.42 ps=1.42 nrd=0.69047619047619  nrs=0.69047619047619 sa=0 sb=0 sd=0 mult=1 m=1
XMRD_op0_n100_s5_w7p5_2 rbl_op0_n100_s5_w7p5 sn_op0_n100_s5_w7p5_2 rwl_des 0 sky130_fd_pr__nfet_01v8 L=0.15 W=0.42 nf=1 ad=0.1218 as=0.1218 pd=1.42 ps=1.42 nrd=0.69047619047619  nrs=0.69047619047619 sa=0 sb=0 sd=0 mult=1 m=1
csn_op0_n100_s5_w7p5_2 sn_op0_n100_s5_w7p5_2 0 {C_SN}
XMWR_op0_n100_s5_w7p5_3 sn_op0_n100_s5_w7p5_3 wwl_des wbl_op0_n100_s5_w7p5 0 sky130_fd_pr__nfet_01v8 L=0.15 W=0.42 nf=1 ad=0.1218 as=0.1218 pd=1.42 ps=1.42 nrd=0.69047619047619  nrs=0.69047619047619 sa=0 sb=0 sd=0 mult=1 m=1
XMRD_op0_n100_s5_w7p5_3 rbl_op0_n100_s5_w7p5 sn_op0_n100_s5_w7p5_3 rwl_des 0 sky130_fd_pr__nfet_01v8 L=0.15 W=0.42 nf=1 ad=0.1218 as=0.1218 pd=1.42 ps=1.42 nrd=0.69047619047619  nrs=0.69047619047619 sa=0 sb=0 sd=0 mult=1 m=1
csn_op0_n100_s5_w7p5_3 sn_op0_n100_s5_w7p5_3 0 {C_SN}
XMN1_op0_n100_s5_w7p5 rbl_op0_n100_s5_w7p5 ref_op0_n100_s5_w7p5 vn_op0_n100_s5_w7p5 0 sky130_fd_pr__nfet_01v8 L=0.15 W=1 nf=1 ad=0.29 as=0.29 pd=2.58 ps=2.58 mult=1 m=1
XMN2_op0_n100_s5_w7p5 ref_op0_n100_s5_w7p5 rbl_op0_n100_s5_w7p5 vn_op0_n100_s5_w7p5 0 sky130_fd_pr__nfet_01v8 L=0.15 W=1 nf=1 ad=0.29 as=0.29 pd=2.58 ps=2.58 mult=1 m=1
XMP1_op0_n100_s5_w7p5 rbl_op0_n100_s5_w7p5 ref_op0_n100_s5_w7p5 vp_op0_n100_s5_w7p5 vdd sky130_fd_pr__pfet_01v8 L=0.15 W=2 nf=1 ad=0.58 as=0.58 pd=4.58 ps=4.58 mult=1 m=1
XMP2_op0_n100_s5_w7p5 ref_op0_n100_s5_w7p5 rbl_op0_n100_s5_w7p5 vp_op0_n100_s5_w7p5 vdd sky130_fd_pr__pfet_01v8 L=0.15 W=2 nf=1 ad=0.58 as=0.58 pd=4.58 ps=4.58 mult=1 m=1
XMNF_op0_n100_s5_w7p5 vn_op0_n100_s5_w7p5 en_op0_n100_s5_w7p5 0 0 sky130_fd_pr__nfet_01v8 L=0.15 W=2 nf=1 ad=0.58 as=0.58 pd=4.58 ps=4.58 mult=1 m=1
XMPH_op0_n100_s5_w7p5 vp_op0_n100_s5_w7p5 enb_op0_n100_s5_w7p5 vdd vdd sky130_fd_pr__pfet_01v8 L=0.15 W=4 nf=1 ad=1.16 as=1.16 pd=8.58 ps=8.58 mult=1 m=1
bd_op0_n100_s5_w7p5 d_op0_n100_s5_w7p5 0 v=v(rbl_op0_n100_s5_w7p5)-v(ref_op0_n100_s5_w7p5)

* ---- instance 163: op0_n100_s5_w10 (t_en 9 ns, WWL 10..20 ns, release 22 ns) ----
ven_op0_n100_s5_w10  en_op0_n100_s5_w10  0 pwl(0 0 9.0000e-09 0 9.1000e-09 {VDD} 2.2000e-08 {VDD} 2.2100e-08 0)
venb_op0_n100_s5_w10 enb_op0_n100_s5_w10 0 pwl(0 {VDD} 9.0000e-09 {VDD} 9.1000e-09 0 2.2000e-08 0 2.2100e-08 {VDD})
vrs_op0_n100_s5_w10  rwls_op0_n100_s5_w10 0 pwl(0 {VDD} {T_READ} {VDD} {T_READ+TEDGE} 0 2.2000e-08 0 2.2100e-08 {VDD})
vww_op0_n100_s5_w10  wwl_op0_n100_s5_w10 0 pwl(0 0 1.0000e-08 0 1.0100e-08 {VDD} 2.0000e-08 {VDD} 2.0100e-08 0)
vwc_op0_n100_s5_w10  wbc_op0_n100_s5_w10 0 pwl(0 0 1.0000e-08 0 1.0100e-08 {VDD} 2.2000e-08 {VDD} 2.2100e-08 0)
swb_op0_n100_s5_w10 ref_op0_n100_s5_w10 wbl_op0_n100_s5_w10 wbc_op0_n100_s5_w10 0 swwbl
cwbl_op0_n100_s5_w10 wbl_op0_n100_s5_w10 0 {C_WBL}
spa_op0_n100_s5_w10 prea rbl_op0_n100_s5_w10 ctl 0 swpre
spr_op0_n100_s5_w10 pref ref_op0_n100_s5_w10 ctl 0 swpre
crbl_op0_n100_s5_w10 rbl_op0_n100_s5_w10 0 {C_RBL}
cref_op0_n100_s5_w10 ref_op0_n100_s5_w10 0 {C_RBL}   $ ASSUMPTION: ideal matched dummy load
XMWR_op0_n100_s5_w10_0 sn_op0_n100_s5_w10_0 wwl_op0_n100_s5_w10 wbl_op0_n100_s5_w10 0 sky130_fd_pr__nfet_01v8 L=0.15 W=0.42 nf=1 ad=0.1218 as=0.1218 pd=1.42 ps=1.42 nrd=0.69047619047619  nrs=0.69047619047619 sa=0 sb=0 sd=0 mult=1 m=1
XMRD_op0_n100_s5_w10_0 rbl_op0_n100_s5_w10 sn_op0_n100_s5_w10_0 rwls_op0_n100_s5_w10 0 sky130_fd_pr__nfet_01v8 L=0.15 W=0.42 nf=1 ad=0.1218 as=0.1218 pd=1.42 ps=1.42 nrd=0.69047619047619  nrs=0.69047619047619 sa=0 sb=0 sd=0 mult=1 m=1
csn_op0_n100_s5_w10_0 sn_op0_n100_s5_w10_0 0 {C_SN}
XMWR_op0_n100_s5_w10_1 sn_op0_n100_s5_w10_1 wwl_des wbl_op0_n100_s5_w10 0 sky130_fd_pr__nfet_01v8 L=0.15 W=0.42 nf=1 ad=0.1218 as=0.1218 pd=1.42 ps=1.42 nrd=0.69047619047619  nrs=0.69047619047619 sa=0 sb=0 sd=0 mult=1 m=1
XMRD_op0_n100_s5_w10_1 rbl_op0_n100_s5_w10 sn_op0_n100_s5_w10_1 rwl_des 0 sky130_fd_pr__nfet_01v8 L=0.15 W=0.42 nf=1 ad=0.1218 as=0.1218 pd=1.42 ps=1.42 nrd=0.69047619047619  nrs=0.69047619047619 sa=0 sb=0 sd=0 mult=1 m=1
csn_op0_n100_s5_w10_1 sn_op0_n100_s5_w10_1 0 {C_SN}
XMWR_op0_n100_s5_w10_2 sn_op0_n100_s5_w10_2 wwl_des wbl_op0_n100_s5_w10 0 sky130_fd_pr__nfet_01v8 L=0.15 W=0.42 nf=1 ad=0.1218 as=0.1218 pd=1.42 ps=1.42 nrd=0.69047619047619  nrs=0.69047619047619 sa=0 sb=0 sd=0 mult=1 m=1
XMRD_op0_n100_s5_w10_2 rbl_op0_n100_s5_w10 sn_op0_n100_s5_w10_2 rwl_des 0 sky130_fd_pr__nfet_01v8 L=0.15 W=0.42 nf=1 ad=0.1218 as=0.1218 pd=1.42 ps=1.42 nrd=0.69047619047619  nrs=0.69047619047619 sa=0 sb=0 sd=0 mult=1 m=1
csn_op0_n100_s5_w10_2 sn_op0_n100_s5_w10_2 0 {C_SN}
XMWR_op0_n100_s5_w10_3 sn_op0_n100_s5_w10_3 wwl_des wbl_op0_n100_s5_w10 0 sky130_fd_pr__nfet_01v8 L=0.15 W=0.42 nf=1 ad=0.1218 as=0.1218 pd=1.42 ps=1.42 nrd=0.69047619047619  nrs=0.69047619047619 sa=0 sb=0 sd=0 mult=1 m=1
XMRD_op0_n100_s5_w10_3 rbl_op0_n100_s5_w10 sn_op0_n100_s5_w10_3 rwl_des 0 sky130_fd_pr__nfet_01v8 L=0.15 W=0.42 nf=1 ad=0.1218 as=0.1218 pd=1.42 ps=1.42 nrd=0.69047619047619  nrs=0.69047619047619 sa=0 sb=0 sd=0 mult=1 m=1
csn_op0_n100_s5_w10_3 sn_op0_n100_s5_w10_3 0 {C_SN}
XMN1_op0_n100_s5_w10 rbl_op0_n100_s5_w10 ref_op0_n100_s5_w10 vn_op0_n100_s5_w10 0 sky130_fd_pr__nfet_01v8 L=0.15 W=1 nf=1 ad=0.29 as=0.29 pd=2.58 ps=2.58 mult=1 m=1
XMN2_op0_n100_s5_w10 ref_op0_n100_s5_w10 rbl_op0_n100_s5_w10 vn_op0_n100_s5_w10 0 sky130_fd_pr__nfet_01v8 L=0.15 W=1 nf=1 ad=0.29 as=0.29 pd=2.58 ps=2.58 mult=1 m=1
XMP1_op0_n100_s5_w10 rbl_op0_n100_s5_w10 ref_op0_n100_s5_w10 vp_op0_n100_s5_w10 vdd sky130_fd_pr__pfet_01v8 L=0.15 W=2 nf=1 ad=0.58 as=0.58 pd=4.58 ps=4.58 mult=1 m=1
XMP2_op0_n100_s5_w10 ref_op0_n100_s5_w10 rbl_op0_n100_s5_w10 vp_op0_n100_s5_w10 vdd sky130_fd_pr__pfet_01v8 L=0.15 W=2 nf=1 ad=0.58 as=0.58 pd=4.58 ps=4.58 mult=1 m=1
XMNF_op0_n100_s5_w10 vn_op0_n100_s5_w10 en_op0_n100_s5_w10 0 0 sky130_fd_pr__nfet_01v8 L=0.15 W=2 nf=1 ad=0.58 as=0.58 pd=4.58 ps=4.58 mult=1 m=1
XMPH_op0_n100_s5_w10 vp_op0_n100_s5_w10 enb_op0_n100_s5_w10 vdd vdd sky130_fd_pr__pfet_01v8 L=0.15 W=4 nf=1 ad=1.16 as=1.16 pd=8.58 ps=8.58 mult=1 m=1
bd_op0_n100_s5_w10 d_op0_n100_s5_w10 0 v=v(rbl_op0_n100_s5_w10)-v(ref_op0_n100_s5_w10)

* ---- instance 164: op0_n100_s5_w15 (t_en 9 ns, WWL 10..25 ns, release 27 ns) ----
ven_op0_n100_s5_w15  en_op0_n100_s5_w15  0 pwl(0 0 9.0000e-09 0 9.1000e-09 {VDD} 2.7000e-08 {VDD} 2.7100e-08 0)
venb_op0_n100_s5_w15 enb_op0_n100_s5_w15 0 pwl(0 {VDD} 9.0000e-09 {VDD} 9.1000e-09 0 2.7000e-08 0 2.7100e-08 {VDD})
vrs_op0_n100_s5_w15  rwls_op0_n100_s5_w15 0 pwl(0 {VDD} {T_READ} {VDD} {T_READ+TEDGE} 0 2.7000e-08 0 2.7100e-08 {VDD})
vww_op0_n100_s5_w15  wwl_op0_n100_s5_w15 0 pwl(0 0 1.0000e-08 0 1.0100e-08 {VDD} 2.5000e-08 {VDD} 2.5100e-08 0)
vwc_op0_n100_s5_w15  wbc_op0_n100_s5_w15 0 pwl(0 0 1.0000e-08 0 1.0100e-08 {VDD} 2.7000e-08 {VDD} 2.7100e-08 0)
swb_op0_n100_s5_w15 ref_op0_n100_s5_w15 wbl_op0_n100_s5_w15 wbc_op0_n100_s5_w15 0 swwbl
cwbl_op0_n100_s5_w15 wbl_op0_n100_s5_w15 0 {C_WBL}
spa_op0_n100_s5_w15 prea rbl_op0_n100_s5_w15 ctl 0 swpre
spr_op0_n100_s5_w15 pref ref_op0_n100_s5_w15 ctl 0 swpre
crbl_op0_n100_s5_w15 rbl_op0_n100_s5_w15 0 {C_RBL}
cref_op0_n100_s5_w15 ref_op0_n100_s5_w15 0 {C_RBL}   $ ASSUMPTION: ideal matched dummy load
XMWR_op0_n100_s5_w15_0 sn_op0_n100_s5_w15_0 wwl_op0_n100_s5_w15 wbl_op0_n100_s5_w15 0 sky130_fd_pr__nfet_01v8 L=0.15 W=0.42 nf=1 ad=0.1218 as=0.1218 pd=1.42 ps=1.42 nrd=0.69047619047619  nrs=0.69047619047619 sa=0 sb=0 sd=0 mult=1 m=1
XMRD_op0_n100_s5_w15_0 rbl_op0_n100_s5_w15 sn_op0_n100_s5_w15_0 rwls_op0_n100_s5_w15 0 sky130_fd_pr__nfet_01v8 L=0.15 W=0.42 nf=1 ad=0.1218 as=0.1218 pd=1.42 ps=1.42 nrd=0.69047619047619  nrs=0.69047619047619 sa=0 sb=0 sd=0 mult=1 m=1
csn_op0_n100_s5_w15_0 sn_op0_n100_s5_w15_0 0 {C_SN}
XMWR_op0_n100_s5_w15_1 sn_op0_n100_s5_w15_1 wwl_des wbl_op0_n100_s5_w15 0 sky130_fd_pr__nfet_01v8 L=0.15 W=0.42 nf=1 ad=0.1218 as=0.1218 pd=1.42 ps=1.42 nrd=0.69047619047619  nrs=0.69047619047619 sa=0 sb=0 sd=0 mult=1 m=1
XMRD_op0_n100_s5_w15_1 rbl_op0_n100_s5_w15 sn_op0_n100_s5_w15_1 rwl_des 0 sky130_fd_pr__nfet_01v8 L=0.15 W=0.42 nf=1 ad=0.1218 as=0.1218 pd=1.42 ps=1.42 nrd=0.69047619047619  nrs=0.69047619047619 sa=0 sb=0 sd=0 mult=1 m=1
csn_op0_n100_s5_w15_1 sn_op0_n100_s5_w15_1 0 {C_SN}
XMWR_op0_n100_s5_w15_2 sn_op0_n100_s5_w15_2 wwl_des wbl_op0_n100_s5_w15 0 sky130_fd_pr__nfet_01v8 L=0.15 W=0.42 nf=1 ad=0.1218 as=0.1218 pd=1.42 ps=1.42 nrd=0.69047619047619  nrs=0.69047619047619 sa=0 sb=0 sd=0 mult=1 m=1
XMRD_op0_n100_s5_w15_2 rbl_op0_n100_s5_w15 sn_op0_n100_s5_w15_2 rwl_des 0 sky130_fd_pr__nfet_01v8 L=0.15 W=0.42 nf=1 ad=0.1218 as=0.1218 pd=1.42 ps=1.42 nrd=0.69047619047619  nrs=0.69047619047619 sa=0 sb=0 sd=0 mult=1 m=1
csn_op0_n100_s5_w15_2 sn_op0_n100_s5_w15_2 0 {C_SN}
XMWR_op0_n100_s5_w15_3 sn_op0_n100_s5_w15_3 wwl_des wbl_op0_n100_s5_w15 0 sky130_fd_pr__nfet_01v8 L=0.15 W=0.42 nf=1 ad=0.1218 as=0.1218 pd=1.42 ps=1.42 nrd=0.69047619047619  nrs=0.69047619047619 sa=0 sb=0 sd=0 mult=1 m=1
XMRD_op0_n100_s5_w15_3 rbl_op0_n100_s5_w15 sn_op0_n100_s5_w15_3 rwl_des 0 sky130_fd_pr__nfet_01v8 L=0.15 W=0.42 nf=1 ad=0.1218 as=0.1218 pd=1.42 ps=1.42 nrd=0.69047619047619  nrs=0.69047619047619 sa=0 sb=0 sd=0 mult=1 m=1
csn_op0_n100_s5_w15_3 sn_op0_n100_s5_w15_3 0 {C_SN}
XMN1_op0_n100_s5_w15 rbl_op0_n100_s5_w15 ref_op0_n100_s5_w15 vn_op0_n100_s5_w15 0 sky130_fd_pr__nfet_01v8 L=0.15 W=1 nf=1 ad=0.29 as=0.29 pd=2.58 ps=2.58 mult=1 m=1
XMN2_op0_n100_s5_w15 ref_op0_n100_s5_w15 rbl_op0_n100_s5_w15 vn_op0_n100_s5_w15 0 sky130_fd_pr__nfet_01v8 L=0.15 W=1 nf=1 ad=0.29 as=0.29 pd=2.58 ps=2.58 mult=1 m=1
XMP1_op0_n100_s5_w15 rbl_op0_n100_s5_w15 ref_op0_n100_s5_w15 vp_op0_n100_s5_w15 vdd sky130_fd_pr__pfet_01v8 L=0.15 W=2 nf=1 ad=0.58 as=0.58 pd=4.58 ps=4.58 mult=1 m=1
XMP2_op0_n100_s5_w15 ref_op0_n100_s5_w15 rbl_op0_n100_s5_w15 vp_op0_n100_s5_w15 vdd sky130_fd_pr__pfet_01v8 L=0.15 W=2 nf=1 ad=0.58 as=0.58 pd=4.58 ps=4.58 mult=1 m=1
XMNF_op0_n100_s5_w15 vn_op0_n100_s5_w15 en_op0_n100_s5_w15 0 0 sky130_fd_pr__nfet_01v8 L=0.15 W=2 nf=1 ad=0.58 as=0.58 pd=4.58 ps=4.58 mult=1 m=1
XMPH_op0_n100_s5_w15 vp_op0_n100_s5_w15 enb_op0_n100_s5_w15 vdd vdd sky130_fd_pr__pfet_01v8 L=0.15 W=4 nf=1 ad=1.16 as=1.16 pd=8.58 ps=8.58 mult=1 m=1
bd_op0_n100_s5_w15 d_op0_n100_s5_w15 0 v=v(rbl_op0_n100_s5_w15)-v(ref_op0_n100_s5_w15)

* ---- instance 165: op0_n100_s5_w20 (t_en 9 ns, WWL 10..30 ns, release 32 ns) ----
ven_op0_n100_s5_w20  en_op0_n100_s5_w20  0 pwl(0 0 9.0000e-09 0 9.1000e-09 {VDD} 3.2000e-08 {VDD} 3.2100e-08 0)
venb_op0_n100_s5_w20 enb_op0_n100_s5_w20 0 pwl(0 {VDD} 9.0000e-09 {VDD} 9.1000e-09 0 3.2000e-08 0 3.2100e-08 {VDD})
vrs_op0_n100_s5_w20  rwls_op0_n100_s5_w20 0 pwl(0 {VDD} {T_READ} {VDD} {T_READ+TEDGE} 0 3.2000e-08 0 3.2100e-08 {VDD})
vww_op0_n100_s5_w20  wwl_op0_n100_s5_w20 0 pwl(0 0 1.0000e-08 0 1.0100e-08 {VDD} 3.0000e-08 {VDD} 3.0100e-08 0)
vwc_op0_n100_s5_w20  wbc_op0_n100_s5_w20 0 pwl(0 0 1.0000e-08 0 1.0100e-08 {VDD} 3.2000e-08 {VDD} 3.2100e-08 0)
swb_op0_n100_s5_w20 ref_op0_n100_s5_w20 wbl_op0_n100_s5_w20 wbc_op0_n100_s5_w20 0 swwbl
cwbl_op0_n100_s5_w20 wbl_op0_n100_s5_w20 0 {C_WBL}
spa_op0_n100_s5_w20 prea rbl_op0_n100_s5_w20 ctl 0 swpre
spr_op0_n100_s5_w20 pref ref_op0_n100_s5_w20 ctl 0 swpre
crbl_op0_n100_s5_w20 rbl_op0_n100_s5_w20 0 {C_RBL}
cref_op0_n100_s5_w20 ref_op0_n100_s5_w20 0 {C_RBL}   $ ASSUMPTION: ideal matched dummy load
XMWR_op0_n100_s5_w20_0 sn_op0_n100_s5_w20_0 wwl_op0_n100_s5_w20 wbl_op0_n100_s5_w20 0 sky130_fd_pr__nfet_01v8 L=0.15 W=0.42 nf=1 ad=0.1218 as=0.1218 pd=1.42 ps=1.42 nrd=0.69047619047619  nrs=0.69047619047619 sa=0 sb=0 sd=0 mult=1 m=1
XMRD_op0_n100_s5_w20_0 rbl_op0_n100_s5_w20 sn_op0_n100_s5_w20_0 rwls_op0_n100_s5_w20 0 sky130_fd_pr__nfet_01v8 L=0.15 W=0.42 nf=1 ad=0.1218 as=0.1218 pd=1.42 ps=1.42 nrd=0.69047619047619  nrs=0.69047619047619 sa=0 sb=0 sd=0 mult=1 m=1
csn_op0_n100_s5_w20_0 sn_op0_n100_s5_w20_0 0 {C_SN}
XMWR_op0_n100_s5_w20_1 sn_op0_n100_s5_w20_1 wwl_des wbl_op0_n100_s5_w20 0 sky130_fd_pr__nfet_01v8 L=0.15 W=0.42 nf=1 ad=0.1218 as=0.1218 pd=1.42 ps=1.42 nrd=0.69047619047619  nrs=0.69047619047619 sa=0 sb=0 sd=0 mult=1 m=1
XMRD_op0_n100_s5_w20_1 rbl_op0_n100_s5_w20 sn_op0_n100_s5_w20_1 rwl_des 0 sky130_fd_pr__nfet_01v8 L=0.15 W=0.42 nf=1 ad=0.1218 as=0.1218 pd=1.42 ps=1.42 nrd=0.69047619047619  nrs=0.69047619047619 sa=0 sb=0 sd=0 mult=1 m=1
csn_op0_n100_s5_w20_1 sn_op0_n100_s5_w20_1 0 {C_SN}
XMWR_op0_n100_s5_w20_2 sn_op0_n100_s5_w20_2 wwl_des wbl_op0_n100_s5_w20 0 sky130_fd_pr__nfet_01v8 L=0.15 W=0.42 nf=1 ad=0.1218 as=0.1218 pd=1.42 ps=1.42 nrd=0.69047619047619  nrs=0.69047619047619 sa=0 sb=0 sd=0 mult=1 m=1
XMRD_op0_n100_s5_w20_2 rbl_op0_n100_s5_w20 sn_op0_n100_s5_w20_2 rwl_des 0 sky130_fd_pr__nfet_01v8 L=0.15 W=0.42 nf=1 ad=0.1218 as=0.1218 pd=1.42 ps=1.42 nrd=0.69047619047619  nrs=0.69047619047619 sa=0 sb=0 sd=0 mult=1 m=1
csn_op0_n100_s5_w20_2 sn_op0_n100_s5_w20_2 0 {C_SN}
XMWR_op0_n100_s5_w20_3 sn_op0_n100_s5_w20_3 wwl_des wbl_op0_n100_s5_w20 0 sky130_fd_pr__nfet_01v8 L=0.15 W=0.42 nf=1 ad=0.1218 as=0.1218 pd=1.42 ps=1.42 nrd=0.69047619047619  nrs=0.69047619047619 sa=0 sb=0 sd=0 mult=1 m=1
XMRD_op0_n100_s5_w20_3 rbl_op0_n100_s5_w20 sn_op0_n100_s5_w20_3 rwl_des 0 sky130_fd_pr__nfet_01v8 L=0.15 W=0.42 nf=1 ad=0.1218 as=0.1218 pd=1.42 ps=1.42 nrd=0.69047619047619  nrs=0.69047619047619 sa=0 sb=0 sd=0 mult=1 m=1
csn_op0_n100_s5_w20_3 sn_op0_n100_s5_w20_3 0 {C_SN}
XMN1_op0_n100_s5_w20 rbl_op0_n100_s5_w20 ref_op0_n100_s5_w20 vn_op0_n100_s5_w20 0 sky130_fd_pr__nfet_01v8 L=0.15 W=1 nf=1 ad=0.29 as=0.29 pd=2.58 ps=2.58 mult=1 m=1
XMN2_op0_n100_s5_w20 ref_op0_n100_s5_w20 rbl_op0_n100_s5_w20 vn_op0_n100_s5_w20 0 sky130_fd_pr__nfet_01v8 L=0.15 W=1 nf=1 ad=0.29 as=0.29 pd=2.58 ps=2.58 mult=1 m=1
XMP1_op0_n100_s5_w20 rbl_op0_n100_s5_w20 ref_op0_n100_s5_w20 vp_op0_n100_s5_w20 vdd sky130_fd_pr__pfet_01v8 L=0.15 W=2 nf=1 ad=0.58 as=0.58 pd=4.58 ps=4.58 mult=1 m=1
XMP2_op0_n100_s5_w20 ref_op0_n100_s5_w20 rbl_op0_n100_s5_w20 vp_op0_n100_s5_w20 vdd sky130_fd_pr__pfet_01v8 L=0.15 W=2 nf=1 ad=0.58 as=0.58 pd=4.58 ps=4.58 mult=1 m=1
XMNF_op0_n100_s5_w20 vn_op0_n100_s5_w20 en_op0_n100_s5_w20 0 0 sky130_fd_pr__nfet_01v8 L=0.15 W=2 nf=1 ad=0.58 as=0.58 pd=4.58 ps=4.58 mult=1 m=1
XMPH_op0_n100_s5_w20 vp_op0_n100_s5_w20 enb_op0_n100_s5_w20 vdd vdd sky130_fd_pr__pfet_01v8 L=0.15 W=4 nf=1 ad=1.16 as=1.16 pd=8.58 ps=8.58 mult=1 m=1
bd_op0_n100_s5_w20 d_op0_n100_s5_w20 0 v=v(rbl_op0_n100_s5_w20)-v(ref_op0_n100_s5_w20)

* ---- instance 166: op0_n100_s5_w30 (t_en 9 ns, WWL 10..40 ns, release 42 ns) ----
ven_op0_n100_s5_w30  en_op0_n100_s5_w30  0 pwl(0 0 9.0000e-09 0 9.1000e-09 {VDD} 4.2000e-08 {VDD} 4.2100e-08 0)
venb_op0_n100_s5_w30 enb_op0_n100_s5_w30 0 pwl(0 {VDD} 9.0000e-09 {VDD} 9.1000e-09 0 4.2000e-08 0 4.2100e-08 {VDD})
vrs_op0_n100_s5_w30  rwls_op0_n100_s5_w30 0 pwl(0 {VDD} {T_READ} {VDD} {T_READ+TEDGE} 0 4.2000e-08 0 4.2100e-08 {VDD})
vww_op0_n100_s5_w30  wwl_op0_n100_s5_w30 0 pwl(0 0 1.0000e-08 0 1.0100e-08 {VDD} 4.0000e-08 {VDD} 4.0100e-08 0)
vwc_op0_n100_s5_w30  wbc_op0_n100_s5_w30 0 pwl(0 0 1.0000e-08 0 1.0100e-08 {VDD} 4.2000e-08 {VDD} 4.2100e-08 0)
swb_op0_n100_s5_w30 ref_op0_n100_s5_w30 wbl_op0_n100_s5_w30 wbc_op0_n100_s5_w30 0 swwbl
cwbl_op0_n100_s5_w30 wbl_op0_n100_s5_w30 0 {C_WBL}
spa_op0_n100_s5_w30 prea rbl_op0_n100_s5_w30 ctl 0 swpre
spr_op0_n100_s5_w30 pref ref_op0_n100_s5_w30 ctl 0 swpre
crbl_op0_n100_s5_w30 rbl_op0_n100_s5_w30 0 {C_RBL}
cref_op0_n100_s5_w30 ref_op0_n100_s5_w30 0 {C_RBL}   $ ASSUMPTION: ideal matched dummy load
XMWR_op0_n100_s5_w30_0 sn_op0_n100_s5_w30_0 wwl_op0_n100_s5_w30 wbl_op0_n100_s5_w30 0 sky130_fd_pr__nfet_01v8 L=0.15 W=0.42 nf=1 ad=0.1218 as=0.1218 pd=1.42 ps=1.42 nrd=0.69047619047619  nrs=0.69047619047619 sa=0 sb=0 sd=0 mult=1 m=1
XMRD_op0_n100_s5_w30_0 rbl_op0_n100_s5_w30 sn_op0_n100_s5_w30_0 rwls_op0_n100_s5_w30 0 sky130_fd_pr__nfet_01v8 L=0.15 W=0.42 nf=1 ad=0.1218 as=0.1218 pd=1.42 ps=1.42 nrd=0.69047619047619  nrs=0.69047619047619 sa=0 sb=0 sd=0 mult=1 m=1
csn_op0_n100_s5_w30_0 sn_op0_n100_s5_w30_0 0 {C_SN}
XMWR_op0_n100_s5_w30_1 sn_op0_n100_s5_w30_1 wwl_des wbl_op0_n100_s5_w30 0 sky130_fd_pr__nfet_01v8 L=0.15 W=0.42 nf=1 ad=0.1218 as=0.1218 pd=1.42 ps=1.42 nrd=0.69047619047619  nrs=0.69047619047619 sa=0 sb=0 sd=0 mult=1 m=1
XMRD_op0_n100_s5_w30_1 rbl_op0_n100_s5_w30 sn_op0_n100_s5_w30_1 rwl_des 0 sky130_fd_pr__nfet_01v8 L=0.15 W=0.42 nf=1 ad=0.1218 as=0.1218 pd=1.42 ps=1.42 nrd=0.69047619047619  nrs=0.69047619047619 sa=0 sb=0 sd=0 mult=1 m=1
csn_op0_n100_s5_w30_1 sn_op0_n100_s5_w30_1 0 {C_SN}
XMWR_op0_n100_s5_w30_2 sn_op0_n100_s5_w30_2 wwl_des wbl_op0_n100_s5_w30 0 sky130_fd_pr__nfet_01v8 L=0.15 W=0.42 nf=1 ad=0.1218 as=0.1218 pd=1.42 ps=1.42 nrd=0.69047619047619  nrs=0.69047619047619 sa=0 sb=0 sd=0 mult=1 m=1
XMRD_op0_n100_s5_w30_2 rbl_op0_n100_s5_w30 sn_op0_n100_s5_w30_2 rwl_des 0 sky130_fd_pr__nfet_01v8 L=0.15 W=0.42 nf=1 ad=0.1218 as=0.1218 pd=1.42 ps=1.42 nrd=0.69047619047619  nrs=0.69047619047619 sa=0 sb=0 sd=0 mult=1 m=1
csn_op0_n100_s5_w30_2 sn_op0_n100_s5_w30_2 0 {C_SN}
XMWR_op0_n100_s5_w30_3 sn_op0_n100_s5_w30_3 wwl_des wbl_op0_n100_s5_w30 0 sky130_fd_pr__nfet_01v8 L=0.15 W=0.42 nf=1 ad=0.1218 as=0.1218 pd=1.42 ps=1.42 nrd=0.69047619047619  nrs=0.69047619047619 sa=0 sb=0 sd=0 mult=1 m=1
XMRD_op0_n100_s5_w30_3 rbl_op0_n100_s5_w30 sn_op0_n100_s5_w30_3 rwl_des 0 sky130_fd_pr__nfet_01v8 L=0.15 W=0.42 nf=1 ad=0.1218 as=0.1218 pd=1.42 ps=1.42 nrd=0.69047619047619  nrs=0.69047619047619 sa=0 sb=0 sd=0 mult=1 m=1
csn_op0_n100_s5_w30_3 sn_op0_n100_s5_w30_3 0 {C_SN}
XMN1_op0_n100_s5_w30 rbl_op0_n100_s5_w30 ref_op0_n100_s5_w30 vn_op0_n100_s5_w30 0 sky130_fd_pr__nfet_01v8 L=0.15 W=1 nf=1 ad=0.29 as=0.29 pd=2.58 ps=2.58 mult=1 m=1
XMN2_op0_n100_s5_w30 ref_op0_n100_s5_w30 rbl_op0_n100_s5_w30 vn_op0_n100_s5_w30 0 sky130_fd_pr__nfet_01v8 L=0.15 W=1 nf=1 ad=0.29 as=0.29 pd=2.58 ps=2.58 mult=1 m=1
XMP1_op0_n100_s5_w30 rbl_op0_n100_s5_w30 ref_op0_n100_s5_w30 vp_op0_n100_s5_w30 vdd sky130_fd_pr__pfet_01v8 L=0.15 W=2 nf=1 ad=0.58 as=0.58 pd=4.58 ps=4.58 mult=1 m=1
XMP2_op0_n100_s5_w30 ref_op0_n100_s5_w30 rbl_op0_n100_s5_w30 vp_op0_n100_s5_w30 vdd sky130_fd_pr__pfet_01v8 L=0.15 W=2 nf=1 ad=0.58 as=0.58 pd=4.58 ps=4.58 mult=1 m=1
XMNF_op0_n100_s5_w30 vn_op0_n100_s5_w30 en_op0_n100_s5_w30 0 0 sky130_fd_pr__nfet_01v8 L=0.15 W=2 nf=1 ad=0.58 as=0.58 pd=4.58 ps=4.58 mult=1 m=1
XMPH_op0_n100_s5_w30 vp_op0_n100_s5_w30 enb_op0_n100_s5_w30 vdd vdd sky130_fd_pr__pfet_01v8 L=0.15 W=4 nf=1 ad=1.16 as=1.16 pd=8.58 ps=8.58 mult=1 m=1
bd_op0_n100_s5_w30 d_op0_n100_s5_w30 0 v=v(rbl_op0_n100_s5_w30)-v(ref_op0_n100_s5_w30)

* ---- instance 167: op0_n100_s5_w50 (t_en 9 ns, WWL 10..60 ns, release 62 ns) ----
ven_op0_n100_s5_w50  en_op0_n100_s5_w50  0 pwl(0 0 9.0000e-09 0 9.1000e-09 {VDD} 6.2000e-08 {VDD} 6.2100e-08 0)
venb_op0_n100_s5_w50 enb_op0_n100_s5_w50 0 pwl(0 {VDD} 9.0000e-09 {VDD} 9.1000e-09 0 6.2000e-08 0 6.2100e-08 {VDD})
vrs_op0_n100_s5_w50  rwls_op0_n100_s5_w50 0 pwl(0 {VDD} {T_READ} {VDD} {T_READ+TEDGE} 0 6.2000e-08 0 6.2100e-08 {VDD})
vww_op0_n100_s5_w50  wwl_op0_n100_s5_w50 0 pwl(0 0 1.0000e-08 0 1.0100e-08 {VDD} 6.0000e-08 {VDD} 6.0100e-08 0)
vwc_op0_n100_s5_w50  wbc_op0_n100_s5_w50 0 pwl(0 0 1.0000e-08 0 1.0100e-08 {VDD} 6.2000e-08 {VDD} 6.2100e-08 0)
swb_op0_n100_s5_w50 ref_op0_n100_s5_w50 wbl_op0_n100_s5_w50 wbc_op0_n100_s5_w50 0 swwbl
cwbl_op0_n100_s5_w50 wbl_op0_n100_s5_w50 0 {C_WBL}
spa_op0_n100_s5_w50 prea rbl_op0_n100_s5_w50 ctl 0 swpre
spr_op0_n100_s5_w50 pref ref_op0_n100_s5_w50 ctl 0 swpre
crbl_op0_n100_s5_w50 rbl_op0_n100_s5_w50 0 {C_RBL}
cref_op0_n100_s5_w50 ref_op0_n100_s5_w50 0 {C_RBL}   $ ASSUMPTION: ideal matched dummy load
XMWR_op0_n100_s5_w50_0 sn_op0_n100_s5_w50_0 wwl_op0_n100_s5_w50 wbl_op0_n100_s5_w50 0 sky130_fd_pr__nfet_01v8 L=0.15 W=0.42 nf=1 ad=0.1218 as=0.1218 pd=1.42 ps=1.42 nrd=0.69047619047619  nrs=0.69047619047619 sa=0 sb=0 sd=0 mult=1 m=1
XMRD_op0_n100_s5_w50_0 rbl_op0_n100_s5_w50 sn_op0_n100_s5_w50_0 rwls_op0_n100_s5_w50 0 sky130_fd_pr__nfet_01v8 L=0.15 W=0.42 nf=1 ad=0.1218 as=0.1218 pd=1.42 ps=1.42 nrd=0.69047619047619  nrs=0.69047619047619 sa=0 sb=0 sd=0 mult=1 m=1
csn_op0_n100_s5_w50_0 sn_op0_n100_s5_w50_0 0 {C_SN}
XMWR_op0_n100_s5_w50_1 sn_op0_n100_s5_w50_1 wwl_des wbl_op0_n100_s5_w50 0 sky130_fd_pr__nfet_01v8 L=0.15 W=0.42 nf=1 ad=0.1218 as=0.1218 pd=1.42 ps=1.42 nrd=0.69047619047619  nrs=0.69047619047619 sa=0 sb=0 sd=0 mult=1 m=1
XMRD_op0_n100_s5_w50_1 rbl_op0_n100_s5_w50 sn_op0_n100_s5_w50_1 rwl_des 0 sky130_fd_pr__nfet_01v8 L=0.15 W=0.42 nf=1 ad=0.1218 as=0.1218 pd=1.42 ps=1.42 nrd=0.69047619047619  nrs=0.69047619047619 sa=0 sb=0 sd=0 mult=1 m=1
csn_op0_n100_s5_w50_1 sn_op0_n100_s5_w50_1 0 {C_SN}
XMWR_op0_n100_s5_w50_2 sn_op0_n100_s5_w50_2 wwl_des wbl_op0_n100_s5_w50 0 sky130_fd_pr__nfet_01v8 L=0.15 W=0.42 nf=1 ad=0.1218 as=0.1218 pd=1.42 ps=1.42 nrd=0.69047619047619  nrs=0.69047619047619 sa=0 sb=0 sd=0 mult=1 m=1
XMRD_op0_n100_s5_w50_2 rbl_op0_n100_s5_w50 sn_op0_n100_s5_w50_2 rwl_des 0 sky130_fd_pr__nfet_01v8 L=0.15 W=0.42 nf=1 ad=0.1218 as=0.1218 pd=1.42 ps=1.42 nrd=0.69047619047619  nrs=0.69047619047619 sa=0 sb=0 sd=0 mult=1 m=1
csn_op0_n100_s5_w50_2 sn_op0_n100_s5_w50_2 0 {C_SN}
XMWR_op0_n100_s5_w50_3 sn_op0_n100_s5_w50_3 wwl_des wbl_op0_n100_s5_w50 0 sky130_fd_pr__nfet_01v8 L=0.15 W=0.42 nf=1 ad=0.1218 as=0.1218 pd=1.42 ps=1.42 nrd=0.69047619047619  nrs=0.69047619047619 sa=0 sb=0 sd=0 mult=1 m=1
XMRD_op0_n100_s5_w50_3 rbl_op0_n100_s5_w50 sn_op0_n100_s5_w50_3 rwl_des 0 sky130_fd_pr__nfet_01v8 L=0.15 W=0.42 nf=1 ad=0.1218 as=0.1218 pd=1.42 ps=1.42 nrd=0.69047619047619  nrs=0.69047619047619 sa=0 sb=0 sd=0 mult=1 m=1
csn_op0_n100_s5_w50_3 sn_op0_n100_s5_w50_3 0 {C_SN}
XMN1_op0_n100_s5_w50 rbl_op0_n100_s5_w50 ref_op0_n100_s5_w50 vn_op0_n100_s5_w50 0 sky130_fd_pr__nfet_01v8 L=0.15 W=1 nf=1 ad=0.29 as=0.29 pd=2.58 ps=2.58 mult=1 m=1
XMN2_op0_n100_s5_w50 ref_op0_n100_s5_w50 rbl_op0_n100_s5_w50 vn_op0_n100_s5_w50 0 sky130_fd_pr__nfet_01v8 L=0.15 W=1 nf=1 ad=0.29 as=0.29 pd=2.58 ps=2.58 mult=1 m=1
XMP1_op0_n100_s5_w50 rbl_op0_n100_s5_w50 ref_op0_n100_s5_w50 vp_op0_n100_s5_w50 vdd sky130_fd_pr__pfet_01v8 L=0.15 W=2 nf=1 ad=0.58 as=0.58 pd=4.58 ps=4.58 mult=1 m=1
XMP2_op0_n100_s5_w50 ref_op0_n100_s5_w50 rbl_op0_n100_s5_w50 vp_op0_n100_s5_w50 vdd sky130_fd_pr__pfet_01v8 L=0.15 W=2 nf=1 ad=0.58 as=0.58 pd=4.58 ps=4.58 mult=1 m=1
XMNF_op0_n100_s5_w50 vn_op0_n100_s5_w50 en_op0_n100_s5_w50 0 0 sky130_fd_pr__nfet_01v8 L=0.15 W=2 nf=1 ad=0.58 as=0.58 pd=4.58 ps=4.58 mult=1 m=1
XMPH_op0_n100_s5_w50 vp_op0_n100_s5_w50 enb_op0_n100_s5_w50 vdd vdd sky130_fd_pr__pfet_01v8 L=0.15 W=4 nf=1 ad=1.16 as=1.16 pd=8.58 ps=8.58 mult=1 m=1
bd_op0_n100_s5_w50 d_op0_n100_s5_w50 0 v=v(rbl_op0_n100_s5_w50)-v(ref_op0_n100_s5_w50)

* ---- instance 168: op0_n100_s10_w0p2 (t_en 14 ns, WWL 15..15.2 ns, release 17.2 ns) ----
ven_op0_n100_s10_w0p2  en_op0_n100_s10_w0p2  0 pwl(0 0 1.4000e-08 0 1.4100e-08 {VDD} 1.7200e-08 {VDD} 1.7300e-08 0)
venb_op0_n100_s10_w0p2 enb_op0_n100_s10_w0p2 0 pwl(0 {VDD} 1.4000e-08 {VDD} 1.4100e-08 0 1.7200e-08 0 1.7300e-08 {VDD})
vrs_op0_n100_s10_w0p2  rwls_op0_n100_s10_w0p2 0 pwl(0 {VDD} {T_READ} {VDD} {T_READ+TEDGE} 0 1.7200e-08 0 1.7300e-08 {VDD})
vww_op0_n100_s10_w0p2  wwl_op0_n100_s10_w0p2 0 pwl(0 0 1.5000e-08 0 1.5100e-08 {VDD} 1.5200e-08 {VDD} 1.5300e-08 0)
vwc_op0_n100_s10_w0p2  wbc_op0_n100_s10_w0p2 0 pwl(0 0 1.5000e-08 0 1.5100e-08 {VDD} 1.7200e-08 {VDD} 1.7300e-08 0)
swb_op0_n100_s10_w0p2 ref_op0_n100_s10_w0p2 wbl_op0_n100_s10_w0p2 wbc_op0_n100_s10_w0p2 0 swwbl
cwbl_op0_n100_s10_w0p2 wbl_op0_n100_s10_w0p2 0 {C_WBL}
spa_op0_n100_s10_w0p2 prea rbl_op0_n100_s10_w0p2 ctl 0 swpre
spr_op0_n100_s10_w0p2 pref ref_op0_n100_s10_w0p2 ctl 0 swpre
crbl_op0_n100_s10_w0p2 rbl_op0_n100_s10_w0p2 0 {C_RBL}
cref_op0_n100_s10_w0p2 ref_op0_n100_s10_w0p2 0 {C_RBL}   $ ASSUMPTION: ideal matched dummy load
XMWR_op0_n100_s10_w0p2_0 sn_op0_n100_s10_w0p2_0 wwl_op0_n100_s10_w0p2 wbl_op0_n100_s10_w0p2 0 sky130_fd_pr__nfet_01v8 L=0.15 W=0.42 nf=1 ad=0.1218 as=0.1218 pd=1.42 ps=1.42 nrd=0.69047619047619  nrs=0.69047619047619 sa=0 sb=0 sd=0 mult=1 m=1
XMRD_op0_n100_s10_w0p2_0 rbl_op0_n100_s10_w0p2 sn_op0_n100_s10_w0p2_0 rwls_op0_n100_s10_w0p2 0 sky130_fd_pr__nfet_01v8 L=0.15 W=0.42 nf=1 ad=0.1218 as=0.1218 pd=1.42 ps=1.42 nrd=0.69047619047619  nrs=0.69047619047619 sa=0 sb=0 sd=0 mult=1 m=1
csn_op0_n100_s10_w0p2_0 sn_op0_n100_s10_w0p2_0 0 {C_SN}
XMWR_op0_n100_s10_w0p2_1 sn_op0_n100_s10_w0p2_1 wwl_des wbl_op0_n100_s10_w0p2 0 sky130_fd_pr__nfet_01v8 L=0.15 W=0.42 nf=1 ad=0.1218 as=0.1218 pd=1.42 ps=1.42 nrd=0.69047619047619  nrs=0.69047619047619 sa=0 sb=0 sd=0 mult=1 m=1
XMRD_op0_n100_s10_w0p2_1 rbl_op0_n100_s10_w0p2 sn_op0_n100_s10_w0p2_1 rwl_des 0 sky130_fd_pr__nfet_01v8 L=0.15 W=0.42 nf=1 ad=0.1218 as=0.1218 pd=1.42 ps=1.42 nrd=0.69047619047619  nrs=0.69047619047619 sa=0 sb=0 sd=0 mult=1 m=1
csn_op0_n100_s10_w0p2_1 sn_op0_n100_s10_w0p2_1 0 {C_SN}
XMWR_op0_n100_s10_w0p2_2 sn_op0_n100_s10_w0p2_2 wwl_des wbl_op0_n100_s10_w0p2 0 sky130_fd_pr__nfet_01v8 L=0.15 W=0.42 nf=1 ad=0.1218 as=0.1218 pd=1.42 ps=1.42 nrd=0.69047619047619  nrs=0.69047619047619 sa=0 sb=0 sd=0 mult=1 m=1
XMRD_op0_n100_s10_w0p2_2 rbl_op0_n100_s10_w0p2 sn_op0_n100_s10_w0p2_2 rwl_des 0 sky130_fd_pr__nfet_01v8 L=0.15 W=0.42 nf=1 ad=0.1218 as=0.1218 pd=1.42 ps=1.42 nrd=0.69047619047619  nrs=0.69047619047619 sa=0 sb=0 sd=0 mult=1 m=1
csn_op0_n100_s10_w0p2_2 sn_op0_n100_s10_w0p2_2 0 {C_SN}
XMWR_op0_n100_s10_w0p2_3 sn_op0_n100_s10_w0p2_3 wwl_des wbl_op0_n100_s10_w0p2 0 sky130_fd_pr__nfet_01v8 L=0.15 W=0.42 nf=1 ad=0.1218 as=0.1218 pd=1.42 ps=1.42 nrd=0.69047619047619  nrs=0.69047619047619 sa=0 sb=0 sd=0 mult=1 m=1
XMRD_op0_n100_s10_w0p2_3 rbl_op0_n100_s10_w0p2 sn_op0_n100_s10_w0p2_3 rwl_des 0 sky130_fd_pr__nfet_01v8 L=0.15 W=0.42 nf=1 ad=0.1218 as=0.1218 pd=1.42 ps=1.42 nrd=0.69047619047619  nrs=0.69047619047619 sa=0 sb=0 sd=0 mult=1 m=1
csn_op0_n100_s10_w0p2_3 sn_op0_n100_s10_w0p2_3 0 {C_SN}
XMN1_op0_n100_s10_w0p2 rbl_op0_n100_s10_w0p2 ref_op0_n100_s10_w0p2 vn_op0_n100_s10_w0p2 0 sky130_fd_pr__nfet_01v8 L=0.15 W=1 nf=1 ad=0.29 as=0.29 pd=2.58 ps=2.58 mult=1 m=1
XMN2_op0_n100_s10_w0p2 ref_op0_n100_s10_w0p2 rbl_op0_n100_s10_w0p2 vn_op0_n100_s10_w0p2 0 sky130_fd_pr__nfet_01v8 L=0.15 W=1 nf=1 ad=0.29 as=0.29 pd=2.58 ps=2.58 mult=1 m=1
XMP1_op0_n100_s10_w0p2 rbl_op0_n100_s10_w0p2 ref_op0_n100_s10_w0p2 vp_op0_n100_s10_w0p2 vdd sky130_fd_pr__pfet_01v8 L=0.15 W=2 nf=1 ad=0.58 as=0.58 pd=4.58 ps=4.58 mult=1 m=1
XMP2_op0_n100_s10_w0p2 ref_op0_n100_s10_w0p2 rbl_op0_n100_s10_w0p2 vp_op0_n100_s10_w0p2 vdd sky130_fd_pr__pfet_01v8 L=0.15 W=2 nf=1 ad=0.58 as=0.58 pd=4.58 ps=4.58 mult=1 m=1
XMNF_op0_n100_s10_w0p2 vn_op0_n100_s10_w0p2 en_op0_n100_s10_w0p2 0 0 sky130_fd_pr__nfet_01v8 L=0.15 W=2 nf=1 ad=0.58 as=0.58 pd=4.58 ps=4.58 mult=1 m=1
XMPH_op0_n100_s10_w0p2 vp_op0_n100_s10_w0p2 enb_op0_n100_s10_w0p2 vdd vdd sky130_fd_pr__pfet_01v8 L=0.15 W=4 nf=1 ad=1.16 as=1.16 pd=8.58 ps=8.58 mult=1 m=1
bd_op0_n100_s10_w0p2 d_op0_n100_s10_w0p2 0 v=v(rbl_op0_n100_s10_w0p2)-v(ref_op0_n100_s10_w0p2)

* ---- instance 169: op0_n100_s10_w0p5 (t_en 14 ns, WWL 15..15.5 ns, release 17.5 ns) ----
ven_op0_n100_s10_w0p5  en_op0_n100_s10_w0p5  0 pwl(0 0 1.4000e-08 0 1.4100e-08 {VDD} 1.7500e-08 {VDD} 1.7600e-08 0)
venb_op0_n100_s10_w0p5 enb_op0_n100_s10_w0p5 0 pwl(0 {VDD} 1.4000e-08 {VDD} 1.4100e-08 0 1.7500e-08 0 1.7600e-08 {VDD})
vrs_op0_n100_s10_w0p5  rwls_op0_n100_s10_w0p5 0 pwl(0 {VDD} {T_READ} {VDD} {T_READ+TEDGE} 0 1.7500e-08 0 1.7600e-08 {VDD})
vww_op0_n100_s10_w0p5  wwl_op0_n100_s10_w0p5 0 pwl(0 0 1.5000e-08 0 1.5100e-08 {VDD} 1.5500e-08 {VDD} 1.5600e-08 0)
vwc_op0_n100_s10_w0p5  wbc_op0_n100_s10_w0p5 0 pwl(0 0 1.5000e-08 0 1.5100e-08 {VDD} 1.7500e-08 {VDD} 1.7600e-08 0)
swb_op0_n100_s10_w0p5 ref_op0_n100_s10_w0p5 wbl_op0_n100_s10_w0p5 wbc_op0_n100_s10_w0p5 0 swwbl
cwbl_op0_n100_s10_w0p5 wbl_op0_n100_s10_w0p5 0 {C_WBL}
spa_op0_n100_s10_w0p5 prea rbl_op0_n100_s10_w0p5 ctl 0 swpre
spr_op0_n100_s10_w0p5 pref ref_op0_n100_s10_w0p5 ctl 0 swpre
crbl_op0_n100_s10_w0p5 rbl_op0_n100_s10_w0p5 0 {C_RBL}
cref_op0_n100_s10_w0p5 ref_op0_n100_s10_w0p5 0 {C_RBL}   $ ASSUMPTION: ideal matched dummy load
XMWR_op0_n100_s10_w0p5_0 sn_op0_n100_s10_w0p5_0 wwl_op0_n100_s10_w0p5 wbl_op0_n100_s10_w0p5 0 sky130_fd_pr__nfet_01v8 L=0.15 W=0.42 nf=1 ad=0.1218 as=0.1218 pd=1.42 ps=1.42 nrd=0.69047619047619  nrs=0.69047619047619 sa=0 sb=0 sd=0 mult=1 m=1
XMRD_op0_n100_s10_w0p5_0 rbl_op0_n100_s10_w0p5 sn_op0_n100_s10_w0p5_0 rwls_op0_n100_s10_w0p5 0 sky130_fd_pr__nfet_01v8 L=0.15 W=0.42 nf=1 ad=0.1218 as=0.1218 pd=1.42 ps=1.42 nrd=0.69047619047619  nrs=0.69047619047619 sa=0 sb=0 sd=0 mult=1 m=1
csn_op0_n100_s10_w0p5_0 sn_op0_n100_s10_w0p5_0 0 {C_SN}
XMWR_op0_n100_s10_w0p5_1 sn_op0_n100_s10_w0p5_1 wwl_des wbl_op0_n100_s10_w0p5 0 sky130_fd_pr__nfet_01v8 L=0.15 W=0.42 nf=1 ad=0.1218 as=0.1218 pd=1.42 ps=1.42 nrd=0.69047619047619  nrs=0.69047619047619 sa=0 sb=0 sd=0 mult=1 m=1
XMRD_op0_n100_s10_w0p5_1 rbl_op0_n100_s10_w0p5 sn_op0_n100_s10_w0p5_1 rwl_des 0 sky130_fd_pr__nfet_01v8 L=0.15 W=0.42 nf=1 ad=0.1218 as=0.1218 pd=1.42 ps=1.42 nrd=0.69047619047619  nrs=0.69047619047619 sa=0 sb=0 sd=0 mult=1 m=1
csn_op0_n100_s10_w0p5_1 sn_op0_n100_s10_w0p5_1 0 {C_SN}
XMWR_op0_n100_s10_w0p5_2 sn_op0_n100_s10_w0p5_2 wwl_des wbl_op0_n100_s10_w0p5 0 sky130_fd_pr__nfet_01v8 L=0.15 W=0.42 nf=1 ad=0.1218 as=0.1218 pd=1.42 ps=1.42 nrd=0.69047619047619  nrs=0.69047619047619 sa=0 sb=0 sd=0 mult=1 m=1
XMRD_op0_n100_s10_w0p5_2 rbl_op0_n100_s10_w0p5 sn_op0_n100_s10_w0p5_2 rwl_des 0 sky130_fd_pr__nfet_01v8 L=0.15 W=0.42 nf=1 ad=0.1218 as=0.1218 pd=1.42 ps=1.42 nrd=0.69047619047619  nrs=0.69047619047619 sa=0 sb=0 sd=0 mult=1 m=1
csn_op0_n100_s10_w0p5_2 sn_op0_n100_s10_w0p5_2 0 {C_SN}
XMWR_op0_n100_s10_w0p5_3 sn_op0_n100_s10_w0p5_3 wwl_des wbl_op0_n100_s10_w0p5 0 sky130_fd_pr__nfet_01v8 L=0.15 W=0.42 nf=1 ad=0.1218 as=0.1218 pd=1.42 ps=1.42 nrd=0.69047619047619  nrs=0.69047619047619 sa=0 sb=0 sd=0 mult=1 m=1
XMRD_op0_n100_s10_w0p5_3 rbl_op0_n100_s10_w0p5 sn_op0_n100_s10_w0p5_3 rwl_des 0 sky130_fd_pr__nfet_01v8 L=0.15 W=0.42 nf=1 ad=0.1218 as=0.1218 pd=1.42 ps=1.42 nrd=0.69047619047619  nrs=0.69047619047619 sa=0 sb=0 sd=0 mult=1 m=1
csn_op0_n100_s10_w0p5_3 sn_op0_n100_s10_w0p5_3 0 {C_SN}
XMN1_op0_n100_s10_w0p5 rbl_op0_n100_s10_w0p5 ref_op0_n100_s10_w0p5 vn_op0_n100_s10_w0p5 0 sky130_fd_pr__nfet_01v8 L=0.15 W=1 nf=1 ad=0.29 as=0.29 pd=2.58 ps=2.58 mult=1 m=1
XMN2_op0_n100_s10_w0p5 ref_op0_n100_s10_w0p5 rbl_op0_n100_s10_w0p5 vn_op0_n100_s10_w0p5 0 sky130_fd_pr__nfet_01v8 L=0.15 W=1 nf=1 ad=0.29 as=0.29 pd=2.58 ps=2.58 mult=1 m=1
XMP1_op0_n100_s10_w0p5 rbl_op0_n100_s10_w0p5 ref_op0_n100_s10_w0p5 vp_op0_n100_s10_w0p5 vdd sky130_fd_pr__pfet_01v8 L=0.15 W=2 nf=1 ad=0.58 as=0.58 pd=4.58 ps=4.58 mult=1 m=1
XMP2_op0_n100_s10_w0p5 ref_op0_n100_s10_w0p5 rbl_op0_n100_s10_w0p5 vp_op0_n100_s10_w0p5 vdd sky130_fd_pr__pfet_01v8 L=0.15 W=2 nf=1 ad=0.58 as=0.58 pd=4.58 ps=4.58 mult=1 m=1
XMNF_op0_n100_s10_w0p5 vn_op0_n100_s10_w0p5 en_op0_n100_s10_w0p5 0 0 sky130_fd_pr__nfet_01v8 L=0.15 W=2 nf=1 ad=0.58 as=0.58 pd=4.58 ps=4.58 mult=1 m=1
XMPH_op0_n100_s10_w0p5 vp_op0_n100_s10_w0p5 enb_op0_n100_s10_w0p5 vdd vdd sky130_fd_pr__pfet_01v8 L=0.15 W=4 nf=1 ad=1.16 as=1.16 pd=8.58 ps=8.58 mult=1 m=1
bd_op0_n100_s10_w0p5 d_op0_n100_s10_w0p5 0 v=v(rbl_op0_n100_s10_w0p5)-v(ref_op0_n100_s10_w0p5)

* ---- instance 170: op0_n100_s10_w1 (t_en 14 ns, WWL 15..16 ns, release 18 ns) ----
ven_op0_n100_s10_w1  en_op0_n100_s10_w1  0 pwl(0 0 1.4000e-08 0 1.4100e-08 {VDD} 1.8000e-08 {VDD} 1.8100e-08 0)
venb_op0_n100_s10_w1 enb_op0_n100_s10_w1 0 pwl(0 {VDD} 1.4000e-08 {VDD} 1.4100e-08 0 1.8000e-08 0 1.8100e-08 {VDD})
vrs_op0_n100_s10_w1  rwls_op0_n100_s10_w1 0 pwl(0 {VDD} {T_READ} {VDD} {T_READ+TEDGE} 0 1.8000e-08 0 1.8100e-08 {VDD})
vww_op0_n100_s10_w1  wwl_op0_n100_s10_w1 0 pwl(0 0 1.5000e-08 0 1.5100e-08 {VDD} 1.6000e-08 {VDD} 1.6100e-08 0)
vwc_op0_n100_s10_w1  wbc_op0_n100_s10_w1 0 pwl(0 0 1.5000e-08 0 1.5100e-08 {VDD} 1.8000e-08 {VDD} 1.8100e-08 0)
swb_op0_n100_s10_w1 ref_op0_n100_s10_w1 wbl_op0_n100_s10_w1 wbc_op0_n100_s10_w1 0 swwbl
cwbl_op0_n100_s10_w1 wbl_op0_n100_s10_w1 0 {C_WBL}
spa_op0_n100_s10_w1 prea rbl_op0_n100_s10_w1 ctl 0 swpre
spr_op0_n100_s10_w1 pref ref_op0_n100_s10_w1 ctl 0 swpre
crbl_op0_n100_s10_w1 rbl_op0_n100_s10_w1 0 {C_RBL}
cref_op0_n100_s10_w1 ref_op0_n100_s10_w1 0 {C_RBL}   $ ASSUMPTION: ideal matched dummy load
XMWR_op0_n100_s10_w1_0 sn_op0_n100_s10_w1_0 wwl_op0_n100_s10_w1 wbl_op0_n100_s10_w1 0 sky130_fd_pr__nfet_01v8 L=0.15 W=0.42 nf=1 ad=0.1218 as=0.1218 pd=1.42 ps=1.42 nrd=0.69047619047619  nrs=0.69047619047619 sa=0 sb=0 sd=0 mult=1 m=1
XMRD_op0_n100_s10_w1_0 rbl_op0_n100_s10_w1 sn_op0_n100_s10_w1_0 rwls_op0_n100_s10_w1 0 sky130_fd_pr__nfet_01v8 L=0.15 W=0.42 nf=1 ad=0.1218 as=0.1218 pd=1.42 ps=1.42 nrd=0.69047619047619  nrs=0.69047619047619 sa=0 sb=0 sd=0 mult=1 m=1
csn_op0_n100_s10_w1_0 sn_op0_n100_s10_w1_0 0 {C_SN}
XMWR_op0_n100_s10_w1_1 sn_op0_n100_s10_w1_1 wwl_des wbl_op0_n100_s10_w1 0 sky130_fd_pr__nfet_01v8 L=0.15 W=0.42 nf=1 ad=0.1218 as=0.1218 pd=1.42 ps=1.42 nrd=0.69047619047619  nrs=0.69047619047619 sa=0 sb=0 sd=0 mult=1 m=1
XMRD_op0_n100_s10_w1_1 rbl_op0_n100_s10_w1 sn_op0_n100_s10_w1_1 rwl_des 0 sky130_fd_pr__nfet_01v8 L=0.15 W=0.42 nf=1 ad=0.1218 as=0.1218 pd=1.42 ps=1.42 nrd=0.69047619047619  nrs=0.69047619047619 sa=0 sb=0 sd=0 mult=1 m=1
csn_op0_n100_s10_w1_1 sn_op0_n100_s10_w1_1 0 {C_SN}
XMWR_op0_n100_s10_w1_2 sn_op0_n100_s10_w1_2 wwl_des wbl_op0_n100_s10_w1 0 sky130_fd_pr__nfet_01v8 L=0.15 W=0.42 nf=1 ad=0.1218 as=0.1218 pd=1.42 ps=1.42 nrd=0.69047619047619  nrs=0.69047619047619 sa=0 sb=0 sd=0 mult=1 m=1
XMRD_op0_n100_s10_w1_2 rbl_op0_n100_s10_w1 sn_op0_n100_s10_w1_2 rwl_des 0 sky130_fd_pr__nfet_01v8 L=0.15 W=0.42 nf=1 ad=0.1218 as=0.1218 pd=1.42 ps=1.42 nrd=0.69047619047619  nrs=0.69047619047619 sa=0 sb=0 sd=0 mult=1 m=1
csn_op0_n100_s10_w1_2 sn_op0_n100_s10_w1_2 0 {C_SN}
XMWR_op0_n100_s10_w1_3 sn_op0_n100_s10_w1_3 wwl_des wbl_op0_n100_s10_w1 0 sky130_fd_pr__nfet_01v8 L=0.15 W=0.42 nf=1 ad=0.1218 as=0.1218 pd=1.42 ps=1.42 nrd=0.69047619047619  nrs=0.69047619047619 sa=0 sb=0 sd=0 mult=1 m=1
XMRD_op0_n100_s10_w1_3 rbl_op0_n100_s10_w1 sn_op0_n100_s10_w1_3 rwl_des 0 sky130_fd_pr__nfet_01v8 L=0.15 W=0.42 nf=1 ad=0.1218 as=0.1218 pd=1.42 ps=1.42 nrd=0.69047619047619  nrs=0.69047619047619 sa=0 sb=0 sd=0 mult=1 m=1
csn_op0_n100_s10_w1_3 sn_op0_n100_s10_w1_3 0 {C_SN}
XMN1_op0_n100_s10_w1 rbl_op0_n100_s10_w1 ref_op0_n100_s10_w1 vn_op0_n100_s10_w1 0 sky130_fd_pr__nfet_01v8 L=0.15 W=1 nf=1 ad=0.29 as=0.29 pd=2.58 ps=2.58 mult=1 m=1
XMN2_op0_n100_s10_w1 ref_op0_n100_s10_w1 rbl_op0_n100_s10_w1 vn_op0_n100_s10_w1 0 sky130_fd_pr__nfet_01v8 L=0.15 W=1 nf=1 ad=0.29 as=0.29 pd=2.58 ps=2.58 mult=1 m=1
XMP1_op0_n100_s10_w1 rbl_op0_n100_s10_w1 ref_op0_n100_s10_w1 vp_op0_n100_s10_w1 vdd sky130_fd_pr__pfet_01v8 L=0.15 W=2 nf=1 ad=0.58 as=0.58 pd=4.58 ps=4.58 mult=1 m=1
XMP2_op0_n100_s10_w1 ref_op0_n100_s10_w1 rbl_op0_n100_s10_w1 vp_op0_n100_s10_w1 vdd sky130_fd_pr__pfet_01v8 L=0.15 W=2 nf=1 ad=0.58 as=0.58 pd=4.58 ps=4.58 mult=1 m=1
XMNF_op0_n100_s10_w1 vn_op0_n100_s10_w1 en_op0_n100_s10_w1 0 0 sky130_fd_pr__nfet_01v8 L=0.15 W=2 nf=1 ad=0.58 as=0.58 pd=4.58 ps=4.58 mult=1 m=1
XMPH_op0_n100_s10_w1 vp_op0_n100_s10_w1 enb_op0_n100_s10_w1 vdd vdd sky130_fd_pr__pfet_01v8 L=0.15 W=4 nf=1 ad=1.16 as=1.16 pd=8.58 ps=8.58 mult=1 m=1
bd_op0_n100_s10_w1 d_op0_n100_s10_w1 0 v=v(rbl_op0_n100_s10_w1)-v(ref_op0_n100_s10_w1)

* ---- instance 171: op0_n100_s10_w2 (t_en 14 ns, WWL 15..17 ns, release 19 ns) ----
ven_op0_n100_s10_w2  en_op0_n100_s10_w2  0 pwl(0 0 1.4000e-08 0 1.4100e-08 {VDD} 1.9000e-08 {VDD} 1.9100e-08 0)
venb_op0_n100_s10_w2 enb_op0_n100_s10_w2 0 pwl(0 {VDD} 1.4000e-08 {VDD} 1.4100e-08 0 1.9000e-08 0 1.9100e-08 {VDD})
vrs_op0_n100_s10_w2  rwls_op0_n100_s10_w2 0 pwl(0 {VDD} {T_READ} {VDD} {T_READ+TEDGE} 0 1.9000e-08 0 1.9100e-08 {VDD})
vww_op0_n100_s10_w2  wwl_op0_n100_s10_w2 0 pwl(0 0 1.5000e-08 0 1.5100e-08 {VDD} 1.7000e-08 {VDD} 1.7100e-08 0)
vwc_op0_n100_s10_w2  wbc_op0_n100_s10_w2 0 pwl(0 0 1.5000e-08 0 1.5100e-08 {VDD} 1.9000e-08 {VDD} 1.9100e-08 0)
swb_op0_n100_s10_w2 ref_op0_n100_s10_w2 wbl_op0_n100_s10_w2 wbc_op0_n100_s10_w2 0 swwbl
cwbl_op0_n100_s10_w2 wbl_op0_n100_s10_w2 0 {C_WBL}
spa_op0_n100_s10_w2 prea rbl_op0_n100_s10_w2 ctl 0 swpre
spr_op0_n100_s10_w2 pref ref_op0_n100_s10_w2 ctl 0 swpre
crbl_op0_n100_s10_w2 rbl_op0_n100_s10_w2 0 {C_RBL}
cref_op0_n100_s10_w2 ref_op0_n100_s10_w2 0 {C_RBL}   $ ASSUMPTION: ideal matched dummy load
XMWR_op0_n100_s10_w2_0 sn_op0_n100_s10_w2_0 wwl_op0_n100_s10_w2 wbl_op0_n100_s10_w2 0 sky130_fd_pr__nfet_01v8 L=0.15 W=0.42 nf=1 ad=0.1218 as=0.1218 pd=1.42 ps=1.42 nrd=0.69047619047619  nrs=0.69047619047619 sa=0 sb=0 sd=0 mult=1 m=1
XMRD_op0_n100_s10_w2_0 rbl_op0_n100_s10_w2 sn_op0_n100_s10_w2_0 rwls_op0_n100_s10_w2 0 sky130_fd_pr__nfet_01v8 L=0.15 W=0.42 nf=1 ad=0.1218 as=0.1218 pd=1.42 ps=1.42 nrd=0.69047619047619  nrs=0.69047619047619 sa=0 sb=0 sd=0 mult=1 m=1
csn_op0_n100_s10_w2_0 sn_op0_n100_s10_w2_0 0 {C_SN}
XMWR_op0_n100_s10_w2_1 sn_op0_n100_s10_w2_1 wwl_des wbl_op0_n100_s10_w2 0 sky130_fd_pr__nfet_01v8 L=0.15 W=0.42 nf=1 ad=0.1218 as=0.1218 pd=1.42 ps=1.42 nrd=0.69047619047619  nrs=0.69047619047619 sa=0 sb=0 sd=0 mult=1 m=1
XMRD_op0_n100_s10_w2_1 rbl_op0_n100_s10_w2 sn_op0_n100_s10_w2_1 rwl_des 0 sky130_fd_pr__nfet_01v8 L=0.15 W=0.42 nf=1 ad=0.1218 as=0.1218 pd=1.42 ps=1.42 nrd=0.69047619047619  nrs=0.69047619047619 sa=0 sb=0 sd=0 mult=1 m=1
csn_op0_n100_s10_w2_1 sn_op0_n100_s10_w2_1 0 {C_SN}
XMWR_op0_n100_s10_w2_2 sn_op0_n100_s10_w2_2 wwl_des wbl_op0_n100_s10_w2 0 sky130_fd_pr__nfet_01v8 L=0.15 W=0.42 nf=1 ad=0.1218 as=0.1218 pd=1.42 ps=1.42 nrd=0.69047619047619  nrs=0.69047619047619 sa=0 sb=0 sd=0 mult=1 m=1
XMRD_op0_n100_s10_w2_2 rbl_op0_n100_s10_w2 sn_op0_n100_s10_w2_2 rwl_des 0 sky130_fd_pr__nfet_01v8 L=0.15 W=0.42 nf=1 ad=0.1218 as=0.1218 pd=1.42 ps=1.42 nrd=0.69047619047619  nrs=0.69047619047619 sa=0 sb=0 sd=0 mult=1 m=1
csn_op0_n100_s10_w2_2 sn_op0_n100_s10_w2_2 0 {C_SN}
XMWR_op0_n100_s10_w2_3 sn_op0_n100_s10_w2_3 wwl_des wbl_op0_n100_s10_w2 0 sky130_fd_pr__nfet_01v8 L=0.15 W=0.42 nf=1 ad=0.1218 as=0.1218 pd=1.42 ps=1.42 nrd=0.69047619047619  nrs=0.69047619047619 sa=0 sb=0 sd=0 mult=1 m=1
XMRD_op0_n100_s10_w2_3 rbl_op0_n100_s10_w2 sn_op0_n100_s10_w2_3 rwl_des 0 sky130_fd_pr__nfet_01v8 L=0.15 W=0.42 nf=1 ad=0.1218 as=0.1218 pd=1.42 ps=1.42 nrd=0.69047619047619  nrs=0.69047619047619 sa=0 sb=0 sd=0 mult=1 m=1
csn_op0_n100_s10_w2_3 sn_op0_n100_s10_w2_3 0 {C_SN}
XMN1_op0_n100_s10_w2 rbl_op0_n100_s10_w2 ref_op0_n100_s10_w2 vn_op0_n100_s10_w2 0 sky130_fd_pr__nfet_01v8 L=0.15 W=1 nf=1 ad=0.29 as=0.29 pd=2.58 ps=2.58 mult=1 m=1
XMN2_op0_n100_s10_w2 ref_op0_n100_s10_w2 rbl_op0_n100_s10_w2 vn_op0_n100_s10_w2 0 sky130_fd_pr__nfet_01v8 L=0.15 W=1 nf=1 ad=0.29 as=0.29 pd=2.58 ps=2.58 mult=1 m=1
XMP1_op0_n100_s10_w2 rbl_op0_n100_s10_w2 ref_op0_n100_s10_w2 vp_op0_n100_s10_w2 vdd sky130_fd_pr__pfet_01v8 L=0.15 W=2 nf=1 ad=0.58 as=0.58 pd=4.58 ps=4.58 mult=1 m=1
XMP2_op0_n100_s10_w2 ref_op0_n100_s10_w2 rbl_op0_n100_s10_w2 vp_op0_n100_s10_w2 vdd sky130_fd_pr__pfet_01v8 L=0.15 W=2 nf=1 ad=0.58 as=0.58 pd=4.58 ps=4.58 mult=1 m=1
XMNF_op0_n100_s10_w2 vn_op0_n100_s10_w2 en_op0_n100_s10_w2 0 0 sky130_fd_pr__nfet_01v8 L=0.15 W=2 nf=1 ad=0.58 as=0.58 pd=4.58 ps=4.58 mult=1 m=1
XMPH_op0_n100_s10_w2 vp_op0_n100_s10_w2 enb_op0_n100_s10_w2 vdd vdd sky130_fd_pr__pfet_01v8 L=0.15 W=4 nf=1 ad=1.16 as=1.16 pd=8.58 ps=8.58 mult=1 m=1
bd_op0_n100_s10_w2 d_op0_n100_s10_w2 0 v=v(rbl_op0_n100_s10_w2)-v(ref_op0_n100_s10_w2)

* ---- instance 172: op0_n100_s10_w3 (t_en 14 ns, WWL 15..18 ns, release 20 ns) ----
ven_op0_n100_s10_w3  en_op0_n100_s10_w3  0 pwl(0 0 1.4000e-08 0 1.4100e-08 {VDD} 2.0000e-08 {VDD} 2.0100e-08 0)
venb_op0_n100_s10_w3 enb_op0_n100_s10_w3 0 pwl(0 {VDD} 1.4000e-08 {VDD} 1.4100e-08 0 2.0000e-08 0 2.0100e-08 {VDD})
vrs_op0_n100_s10_w3  rwls_op0_n100_s10_w3 0 pwl(0 {VDD} {T_READ} {VDD} {T_READ+TEDGE} 0 2.0000e-08 0 2.0100e-08 {VDD})
vww_op0_n100_s10_w3  wwl_op0_n100_s10_w3 0 pwl(0 0 1.5000e-08 0 1.5100e-08 {VDD} 1.8000e-08 {VDD} 1.8100e-08 0)
vwc_op0_n100_s10_w3  wbc_op0_n100_s10_w3 0 pwl(0 0 1.5000e-08 0 1.5100e-08 {VDD} 2.0000e-08 {VDD} 2.0100e-08 0)
swb_op0_n100_s10_w3 ref_op0_n100_s10_w3 wbl_op0_n100_s10_w3 wbc_op0_n100_s10_w3 0 swwbl
cwbl_op0_n100_s10_w3 wbl_op0_n100_s10_w3 0 {C_WBL}
spa_op0_n100_s10_w3 prea rbl_op0_n100_s10_w3 ctl 0 swpre
spr_op0_n100_s10_w3 pref ref_op0_n100_s10_w3 ctl 0 swpre
crbl_op0_n100_s10_w3 rbl_op0_n100_s10_w3 0 {C_RBL}
cref_op0_n100_s10_w3 ref_op0_n100_s10_w3 0 {C_RBL}   $ ASSUMPTION: ideal matched dummy load
XMWR_op0_n100_s10_w3_0 sn_op0_n100_s10_w3_0 wwl_op0_n100_s10_w3 wbl_op0_n100_s10_w3 0 sky130_fd_pr__nfet_01v8 L=0.15 W=0.42 nf=1 ad=0.1218 as=0.1218 pd=1.42 ps=1.42 nrd=0.69047619047619  nrs=0.69047619047619 sa=0 sb=0 sd=0 mult=1 m=1
XMRD_op0_n100_s10_w3_0 rbl_op0_n100_s10_w3 sn_op0_n100_s10_w3_0 rwls_op0_n100_s10_w3 0 sky130_fd_pr__nfet_01v8 L=0.15 W=0.42 nf=1 ad=0.1218 as=0.1218 pd=1.42 ps=1.42 nrd=0.69047619047619  nrs=0.69047619047619 sa=0 sb=0 sd=0 mult=1 m=1
csn_op0_n100_s10_w3_0 sn_op0_n100_s10_w3_0 0 {C_SN}
XMWR_op0_n100_s10_w3_1 sn_op0_n100_s10_w3_1 wwl_des wbl_op0_n100_s10_w3 0 sky130_fd_pr__nfet_01v8 L=0.15 W=0.42 nf=1 ad=0.1218 as=0.1218 pd=1.42 ps=1.42 nrd=0.69047619047619  nrs=0.69047619047619 sa=0 sb=0 sd=0 mult=1 m=1
XMRD_op0_n100_s10_w3_1 rbl_op0_n100_s10_w3 sn_op0_n100_s10_w3_1 rwl_des 0 sky130_fd_pr__nfet_01v8 L=0.15 W=0.42 nf=1 ad=0.1218 as=0.1218 pd=1.42 ps=1.42 nrd=0.69047619047619  nrs=0.69047619047619 sa=0 sb=0 sd=0 mult=1 m=1
csn_op0_n100_s10_w3_1 sn_op0_n100_s10_w3_1 0 {C_SN}
XMWR_op0_n100_s10_w3_2 sn_op0_n100_s10_w3_2 wwl_des wbl_op0_n100_s10_w3 0 sky130_fd_pr__nfet_01v8 L=0.15 W=0.42 nf=1 ad=0.1218 as=0.1218 pd=1.42 ps=1.42 nrd=0.69047619047619  nrs=0.69047619047619 sa=0 sb=0 sd=0 mult=1 m=1
XMRD_op0_n100_s10_w3_2 rbl_op0_n100_s10_w3 sn_op0_n100_s10_w3_2 rwl_des 0 sky130_fd_pr__nfet_01v8 L=0.15 W=0.42 nf=1 ad=0.1218 as=0.1218 pd=1.42 ps=1.42 nrd=0.69047619047619  nrs=0.69047619047619 sa=0 sb=0 sd=0 mult=1 m=1
csn_op0_n100_s10_w3_2 sn_op0_n100_s10_w3_2 0 {C_SN}
XMWR_op0_n100_s10_w3_3 sn_op0_n100_s10_w3_3 wwl_des wbl_op0_n100_s10_w3 0 sky130_fd_pr__nfet_01v8 L=0.15 W=0.42 nf=1 ad=0.1218 as=0.1218 pd=1.42 ps=1.42 nrd=0.69047619047619  nrs=0.69047619047619 sa=0 sb=0 sd=0 mult=1 m=1
XMRD_op0_n100_s10_w3_3 rbl_op0_n100_s10_w3 sn_op0_n100_s10_w3_3 rwl_des 0 sky130_fd_pr__nfet_01v8 L=0.15 W=0.42 nf=1 ad=0.1218 as=0.1218 pd=1.42 ps=1.42 nrd=0.69047619047619  nrs=0.69047619047619 sa=0 sb=0 sd=0 mult=1 m=1
csn_op0_n100_s10_w3_3 sn_op0_n100_s10_w3_3 0 {C_SN}
XMN1_op0_n100_s10_w3 rbl_op0_n100_s10_w3 ref_op0_n100_s10_w3 vn_op0_n100_s10_w3 0 sky130_fd_pr__nfet_01v8 L=0.15 W=1 nf=1 ad=0.29 as=0.29 pd=2.58 ps=2.58 mult=1 m=1
XMN2_op0_n100_s10_w3 ref_op0_n100_s10_w3 rbl_op0_n100_s10_w3 vn_op0_n100_s10_w3 0 sky130_fd_pr__nfet_01v8 L=0.15 W=1 nf=1 ad=0.29 as=0.29 pd=2.58 ps=2.58 mult=1 m=1
XMP1_op0_n100_s10_w3 rbl_op0_n100_s10_w3 ref_op0_n100_s10_w3 vp_op0_n100_s10_w3 vdd sky130_fd_pr__pfet_01v8 L=0.15 W=2 nf=1 ad=0.58 as=0.58 pd=4.58 ps=4.58 mult=1 m=1
XMP2_op0_n100_s10_w3 ref_op0_n100_s10_w3 rbl_op0_n100_s10_w3 vp_op0_n100_s10_w3 vdd sky130_fd_pr__pfet_01v8 L=0.15 W=2 nf=1 ad=0.58 as=0.58 pd=4.58 ps=4.58 mult=1 m=1
XMNF_op0_n100_s10_w3 vn_op0_n100_s10_w3 en_op0_n100_s10_w3 0 0 sky130_fd_pr__nfet_01v8 L=0.15 W=2 nf=1 ad=0.58 as=0.58 pd=4.58 ps=4.58 mult=1 m=1
XMPH_op0_n100_s10_w3 vp_op0_n100_s10_w3 enb_op0_n100_s10_w3 vdd vdd sky130_fd_pr__pfet_01v8 L=0.15 W=4 nf=1 ad=1.16 as=1.16 pd=8.58 ps=8.58 mult=1 m=1
bd_op0_n100_s10_w3 d_op0_n100_s10_w3 0 v=v(rbl_op0_n100_s10_w3)-v(ref_op0_n100_s10_w3)

* ---- instance 173: op0_n100_s10_w5 (t_en 14 ns, WWL 15..20 ns, release 22 ns) ----
ven_op0_n100_s10_w5  en_op0_n100_s10_w5  0 pwl(0 0 1.4000e-08 0 1.4100e-08 {VDD} 2.2000e-08 {VDD} 2.2100e-08 0)
venb_op0_n100_s10_w5 enb_op0_n100_s10_w5 0 pwl(0 {VDD} 1.4000e-08 {VDD} 1.4100e-08 0 2.2000e-08 0 2.2100e-08 {VDD})
vrs_op0_n100_s10_w5  rwls_op0_n100_s10_w5 0 pwl(0 {VDD} {T_READ} {VDD} {T_READ+TEDGE} 0 2.2000e-08 0 2.2100e-08 {VDD})
vww_op0_n100_s10_w5  wwl_op0_n100_s10_w5 0 pwl(0 0 1.5000e-08 0 1.5100e-08 {VDD} 2.0000e-08 {VDD} 2.0100e-08 0)
vwc_op0_n100_s10_w5  wbc_op0_n100_s10_w5 0 pwl(0 0 1.5000e-08 0 1.5100e-08 {VDD} 2.2000e-08 {VDD} 2.2100e-08 0)
swb_op0_n100_s10_w5 ref_op0_n100_s10_w5 wbl_op0_n100_s10_w5 wbc_op0_n100_s10_w5 0 swwbl
cwbl_op0_n100_s10_w5 wbl_op0_n100_s10_w5 0 {C_WBL}
spa_op0_n100_s10_w5 prea rbl_op0_n100_s10_w5 ctl 0 swpre
spr_op0_n100_s10_w5 pref ref_op0_n100_s10_w5 ctl 0 swpre
crbl_op0_n100_s10_w5 rbl_op0_n100_s10_w5 0 {C_RBL}
cref_op0_n100_s10_w5 ref_op0_n100_s10_w5 0 {C_RBL}   $ ASSUMPTION: ideal matched dummy load
XMWR_op0_n100_s10_w5_0 sn_op0_n100_s10_w5_0 wwl_op0_n100_s10_w5 wbl_op0_n100_s10_w5 0 sky130_fd_pr__nfet_01v8 L=0.15 W=0.42 nf=1 ad=0.1218 as=0.1218 pd=1.42 ps=1.42 nrd=0.69047619047619  nrs=0.69047619047619 sa=0 sb=0 sd=0 mult=1 m=1
XMRD_op0_n100_s10_w5_0 rbl_op0_n100_s10_w5 sn_op0_n100_s10_w5_0 rwls_op0_n100_s10_w5 0 sky130_fd_pr__nfet_01v8 L=0.15 W=0.42 nf=1 ad=0.1218 as=0.1218 pd=1.42 ps=1.42 nrd=0.69047619047619  nrs=0.69047619047619 sa=0 sb=0 sd=0 mult=1 m=1
csn_op0_n100_s10_w5_0 sn_op0_n100_s10_w5_0 0 {C_SN}
XMWR_op0_n100_s10_w5_1 sn_op0_n100_s10_w5_1 wwl_des wbl_op0_n100_s10_w5 0 sky130_fd_pr__nfet_01v8 L=0.15 W=0.42 nf=1 ad=0.1218 as=0.1218 pd=1.42 ps=1.42 nrd=0.69047619047619  nrs=0.69047619047619 sa=0 sb=0 sd=0 mult=1 m=1
XMRD_op0_n100_s10_w5_1 rbl_op0_n100_s10_w5 sn_op0_n100_s10_w5_1 rwl_des 0 sky130_fd_pr__nfet_01v8 L=0.15 W=0.42 nf=1 ad=0.1218 as=0.1218 pd=1.42 ps=1.42 nrd=0.69047619047619  nrs=0.69047619047619 sa=0 sb=0 sd=0 mult=1 m=1
csn_op0_n100_s10_w5_1 sn_op0_n100_s10_w5_1 0 {C_SN}
XMWR_op0_n100_s10_w5_2 sn_op0_n100_s10_w5_2 wwl_des wbl_op0_n100_s10_w5 0 sky130_fd_pr__nfet_01v8 L=0.15 W=0.42 nf=1 ad=0.1218 as=0.1218 pd=1.42 ps=1.42 nrd=0.69047619047619  nrs=0.69047619047619 sa=0 sb=0 sd=0 mult=1 m=1
XMRD_op0_n100_s10_w5_2 rbl_op0_n100_s10_w5 sn_op0_n100_s10_w5_2 rwl_des 0 sky130_fd_pr__nfet_01v8 L=0.15 W=0.42 nf=1 ad=0.1218 as=0.1218 pd=1.42 ps=1.42 nrd=0.69047619047619  nrs=0.69047619047619 sa=0 sb=0 sd=0 mult=1 m=1
csn_op0_n100_s10_w5_2 sn_op0_n100_s10_w5_2 0 {C_SN}
XMWR_op0_n100_s10_w5_3 sn_op0_n100_s10_w5_3 wwl_des wbl_op0_n100_s10_w5 0 sky130_fd_pr__nfet_01v8 L=0.15 W=0.42 nf=1 ad=0.1218 as=0.1218 pd=1.42 ps=1.42 nrd=0.69047619047619  nrs=0.69047619047619 sa=0 sb=0 sd=0 mult=1 m=1
XMRD_op0_n100_s10_w5_3 rbl_op0_n100_s10_w5 sn_op0_n100_s10_w5_3 rwl_des 0 sky130_fd_pr__nfet_01v8 L=0.15 W=0.42 nf=1 ad=0.1218 as=0.1218 pd=1.42 ps=1.42 nrd=0.69047619047619  nrs=0.69047619047619 sa=0 sb=0 sd=0 mult=1 m=1
csn_op0_n100_s10_w5_3 sn_op0_n100_s10_w5_3 0 {C_SN}
XMN1_op0_n100_s10_w5 rbl_op0_n100_s10_w5 ref_op0_n100_s10_w5 vn_op0_n100_s10_w5 0 sky130_fd_pr__nfet_01v8 L=0.15 W=1 nf=1 ad=0.29 as=0.29 pd=2.58 ps=2.58 mult=1 m=1
XMN2_op0_n100_s10_w5 ref_op0_n100_s10_w5 rbl_op0_n100_s10_w5 vn_op0_n100_s10_w5 0 sky130_fd_pr__nfet_01v8 L=0.15 W=1 nf=1 ad=0.29 as=0.29 pd=2.58 ps=2.58 mult=1 m=1
XMP1_op0_n100_s10_w5 rbl_op0_n100_s10_w5 ref_op0_n100_s10_w5 vp_op0_n100_s10_w5 vdd sky130_fd_pr__pfet_01v8 L=0.15 W=2 nf=1 ad=0.58 as=0.58 pd=4.58 ps=4.58 mult=1 m=1
XMP2_op0_n100_s10_w5 ref_op0_n100_s10_w5 rbl_op0_n100_s10_w5 vp_op0_n100_s10_w5 vdd sky130_fd_pr__pfet_01v8 L=0.15 W=2 nf=1 ad=0.58 as=0.58 pd=4.58 ps=4.58 mult=1 m=1
XMNF_op0_n100_s10_w5 vn_op0_n100_s10_w5 en_op0_n100_s10_w5 0 0 sky130_fd_pr__nfet_01v8 L=0.15 W=2 nf=1 ad=0.58 as=0.58 pd=4.58 ps=4.58 mult=1 m=1
XMPH_op0_n100_s10_w5 vp_op0_n100_s10_w5 enb_op0_n100_s10_w5 vdd vdd sky130_fd_pr__pfet_01v8 L=0.15 W=4 nf=1 ad=1.16 as=1.16 pd=8.58 ps=8.58 mult=1 m=1
bd_op0_n100_s10_w5 d_op0_n100_s10_w5 0 v=v(rbl_op0_n100_s10_w5)-v(ref_op0_n100_s10_w5)

* ---- instance 174: op0_n100_s10_w7p5 (t_en 14 ns, WWL 15..22.5 ns, release 24.5 ns) ----
ven_op0_n100_s10_w7p5  en_op0_n100_s10_w7p5  0 pwl(0 0 1.4000e-08 0 1.4100e-08 {VDD} 2.4500e-08 {VDD} 2.4600e-08 0)
venb_op0_n100_s10_w7p5 enb_op0_n100_s10_w7p5 0 pwl(0 {VDD} 1.4000e-08 {VDD} 1.4100e-08 0 2.4500e-08 0 2.4600e-08 {VDD})
vrs_op0_n100_s10_w7p5  rwls_op0_n100_s10_w7p5 0 pwl(0 {VDD} {T_READ} {VDD} {T_READ+TEDGE} 0 2.4500e-08 0 2.4600e-08 {VDD})
vww_op0_n100_s10_w7p5  wwl_op0_n100_s10_w7p5 0 pwl(0 0 1.5000e-08 0 1.5100e-08 {VDD} 2.2500e-08 {VDD} 2.2600e-08 0)
vwc_op0_n100_s10_w7p5  wbc_op0_n100_s10_w7p5 0 pwl(0 0 1.5000e-08 0 1.5100e-08 {VDD} 2.4500e-08 {VDD} 2.4600e-08 0)
swb_op0_n100_s10_w7p5 ref_op0_n100_s10_w7p5 wbl_op0_n100_s10_w7p5 wbc_op0_n100_s10_w7p5 0 swwbl
cwbl_op0_n100_s10_w7p5 wbl_op0_n100_s10_w7p5 0 {C_WBL}
spa_op0_n100_s10_w7p5 prea rbl_op0_n100_s10_w7p5 ctl 0 swpre
spr_op0_n100_s10_w7p5 pref ref_op0_n100_s10_w7p5 ctl 0 swpre
crbl_op0_n100_s10_w7p5 rbl_op0_n100_s10_w7p5 0 {C_RBL}
cref_op0_n100_s10_w7p5 ref_op0_n100_s10_w7p5 0 {C_RBL}   $ ASSUMPTION: ideal matched dummy load
XMWR_op0_n100_s10_w7p5_0 sn_op0_n100_s10_w7p5_0 wwl_op0_n100_s10_w7p5 wbl_op0_n100_s10_w7p5 0 sky130_fd_pr__nfet_01v8 L=0.15 W=0.42 nf=1 ad=0.1218 as=0.1218 pd=1.42 ps=1.42 nrd=0.69047619047619  nrs=0.69047619047619 sa=0 sb=0 sd=0 mult=1 m=1
XMRD_op0_n100_s10_w7p5_0 rbl_op0_n100_s10_w7p5 sn_op0_n100_s10_w7p5_0 rwls_op0_n100_s10_w7p5 0 sky130_fd_pr__nfet_01v8 L=0.15 W=0.42 nf=1 ad=0.1218 as=0.1218 pd=1.42 ps=1.42 nrd=0.69047619047619  nrs=0.69047619047619 sa=0 sb=0 sd=0 mult=1 m=1
csn_op0_n100_s10_w7p5_0 sn_op0_n100_s10_w7p5_0 0 {C_SN}
XMWR_op0_n100_s10_w7p5_1 sn_op0_n100_s10_w7p5_1 wwl_des wbl_op0_n100_s10_w7p5 0 sky130_fd_pr__nfet_01v8 L=0.15 W=0.42 nf=1 ad=0.1218 as=0.1218 pd=1.42 ps=1.42 nrd=0.69047619047619  nrs=0.69047619047619 sa=0 sb=0 sd=0 mult=1 m=1
XMRD_op0_n100_s10_w7p5_1 rbl_op0_n100_s10_w7p5 sn_op0_n100_s10_w7p5_1 rwl_des 0 sky130_fd_pr__nfet_01v8 L=0.15 W=0.42 nf=1 ad=0.1218 as=0.1218 pd=1.42 ps=1.42 nrd=0.69047619047619  nrs=0.69047619047619 sa=0 sb=0 sd=0 mult=1 m=1
csn_op0_n100_s10_w7p5_1 sn_op0_n100_s10_w7p5_1 0 {C_SN}
XMWR_op0_n100_s10_w7p5_2 sn_op0_n100_s10_w7p5_2 wwl_des wbl_op0_n100_s10_w7p5 0 sky130_fd_pr__nfet_01v8 L=0.15 W=0.42 nf=1 ad=0.1218 as=0.1218 pd=1.42 ps=1.42 nrd=0.69047619047619  nrs=0.69047619047619 sa=0 sb=0 sd=0 mult=1 m=1
XMRD_op0_n100_s10_w7p5_2 rbl_op0_n100_s10_w7p5 sn_op0_n100_s10_w7p5_2 rwl_des 0 sky130_fd_pr__nfet_01v8 L=0.15 W=0.42 nf=1 ad=0.1218 as=0.1218 pd=1.42 ps=1.42 nrd=0.69047619047619  nrs=0.69047619047619 sa=0 sb=0 sd=0 mult=1 m=1
csn_op0_n100_s10_w7p5_2 sn_op0_n100_s10_w7p5_2 0 {C_SN}
XMWR_op0_n100_s10_w7p5_3 sn_op0_n100_s10_w7p5_3 wwl_des wbl_op0_n100_s10_w7p5 0 sky130_fd_pr__nfet_01v8 L=0.15 W=0.42 nf=1 ad=0.1218 as=0.1218 pd=1.42 ps=1.42 nrd=0.69047619047619  nrs=0.69047619047619 sa=0 sb=0 sd=0 mult=1 m=1
XMRD_op0_n100_s10_w7p5_3 rbl_op0_n100_s10_w7p5 sn_op0_n100_s10_w7p5_3 rwl_des 0 sky130_fd_pr__nfet_01v8 L=0.15 W=0.42 nf=1 ad=0.1218 as=0.1218 pd=1.42 ps=1.42 nrd=0.69047619047619  nrs=0.69047619047619 sa=0 sb=0 sd=0 mult=1 m=1
csn_op0_n100_s10_w7p5_3 sn_op0_n100_s10_w7p5_3 0 {C_SN}
XMN1_op0_n100_s10_w7p5 rbl_op0_n100_s10_w7p5 ref_op0_n100_s10_w7p5 vn_op0_n100_s10_w7p5 0 sky130_fd_pr__nfet_01v8 L=0.15 W=1 nf=1 ad=0.29 as=0.29 pd=2.58 ps=2.58 mult=1 m=1
XMN2_op0_n100_s10_w7p5 ref_op0_n100_s10_w7p5 rbl_op0_n100_s10_w7p5 vn_op0_n100_s10_w7p5 0 sky130_fd_pr__nfet_01v8 L=0.15 W=1 nf=1 ad=0.29 as=0.29 pd=2.58 ps=2.58 mult=1 m=1
XMP1_op0_n100_s10_w7p5 rbl_op0_n100_s10_w7p5 ref_op0_n100_s10_w7p5 vp_op0_n100_s10_w7p5 vdd sky130_fd_pr__pfet_01v8 L=0.15 W=2 nf=1 ad=0.58 as=0.58 pd=4.58 ps=4.58 mult=1 m=1
XMP2_op0_n100_s10_w7p5 ref_op0_n100_s10_w7p5 rbl_op0_n100_s10_w7p5 vp_op0_n100_s10_w7p5 vdd sky130_fd_pr__pfet_01v8 L=0.15 W=2 nf=1 ad=0.58 as=0.58 pd=4.58 ps=4.58 mult=1 m=1
XMNF_op0_n100_s10_w7p5 vn_op0_n100_s10_w7p5 en_op0_n100_s10_w7p5 0 0 sky130_fd_pr__nfet_01v8 L=0.15 W=2 nf=1 ad=0.58 as=0.58 pd=4.58 ps=4.58 mult=1 m=1
XMPH_op0_n100_s10_w7p5 vp_op0_n100_s10_w7p5 enb_op0_n100_s10_w7p5 vdd vdd sky130_fd_pr__pfet_01v8 L=0.15 W=4 nf=1 ad=1.16 as=1.16 pd=8.58 ps=8.58 mult=1 m=1
bd_op0_n100_s10_w7p5 d_op0_n100_s10_w7p5 0 v=v(rbl_op0_n100_s10_w7p5)-v(ref_op0_n100_s10_w7p5)

* ---- instance 175: op0_n100_s10_w10 (t_en 14 ns, WWL 15..25 ns, release 27 ns) ----
ven_op0_n100_s10_w10  en_op0_n100_s10_w10  0 pwl(0 0 1.4000e-08 0 1.4100e-08 {VDD} 2.7000e-08 {VDD} 2.7100e-08 0)
venb_op0_n100_s10_w10 enb_op0_n100_s10_w10 0 pwl(0 {VDD} 1.4000e-08 {VDD} 1.4100e-08 0 2.7000e-08 0 2.7100e-08 {VDD})
vrs_op0_n100_s10_w10  rwls_op0_n100_s10_w10 0 pwl(0 {VDD} {T_READ} {VDD} {T_READ+TEDGE} 0 2.7000e-08 0 2.7100e-08 {VDD})
vww_op0_n100_s10_w10  wwl_op0_n100_s10_w10 0 pwl(0 0 1.5000e-08 0 1.5100e-08 {VDD} 2.5000e-08 {VDD} 2.5100e-08 0)
vwc_op0_n100_s10_w10  wbc_op0_n100_s10_w10 0 pwl(0 0 1.5000e-08 0 1.5100e-08 {VDD} 2.7000e-08 {VDD} 2.7100e-08 0)
swb_op0_n100_s10_w10 ref_op0_n100_s10_w10 wbl_op0_n100_s10_w10 wbc_op0_n100_s10_w10 0 swwbl
cwbl_op0_n100_s10_w10 wbl_op0_n100_s10_w10 0 {C_WBL}
spa_op0_n100_s10_w10 prea rbl_op0_n100_s10_w10 ctl 0 swpre
spr_op0_n100_s10_w10 pref ref_op0_n100_s10_w10 ctl 0 swpre
crbl_op0_n100_s10_w10 rbl_op0_n100_s10_w10 0 {C_RBL}
cref_op0_n100_s10_w10 ref_op0_n100_s10_w10 0 {C_RBL}   $ ASSUMPTION: ideal matched dummy load
XMWR_op0_n100_s10_w10_0 sn_op0_n100_s10_w10_0 wwl_op0_n100_s10_w10 wbl_op0_n100_s10_w10 0 sky130_fd_pr__nfet_01v8 L=0.15 W=0.42 nf=1 ad=0.1218 as=0.1218 pd=1.42 ps=1.42 nrd=0.69047619047619  nrs=0.69047619047619 sa=0 sb=0 sd=0 mult=1 m=1
XMRD_op0_n100_s10_w10_0 rbl_op0_n100_s10_w10 sn_op0_n100_s10_w10_0 rwls_op0_n100_s10_w10 0 sky130_fd_pr__nfet_01v8 L=0.15 W=0.42 nf=1 ad=0.1218 as=0.1218 pd=1.42 ps=1.42 nrd=0.69047619047619  nrs=0.69047619047619 sa=0 sb=0 sd=0 mult=1 m=1
csn_op0_n100_s10_w10_0 sn_op0_n100_s10_w10_0 0 {C_SN}
XMWR_op0_n100_s10_w10_1 sn_op0_n100_s10_w10_1 wwl_des wbl_op0_n100_s10_w10 0 sky130_fd_pr__nfet_01v8 L=0.15 W=0.42 nf=1 ad=0.1218 as=0.1218 pd=1.42 ps=1.42 nrd=0.69047619047619  nrs=0.69047619047619 sa=0 sb=0 sd=0 mult=1 m=1
XMRD_op0_n100_s10_w10_1 rbl_op0_n100_s10_w10 sn_op0_n100_s10_w10_1 rwl_des 0 sky130_fd_pr__nfet_01v8 L=0.15 W=0.42 nf=1 ad=0.1218 as=0.1218 pd=1.42 ps=1.42 nrd=0.69047619047619  nrs=0.69047619047619 sa=0 sb=0 sd=0 mult=1 m=1
csn_op0_n100_s10_w10_1 sn_op0_n100_s10_w10_1 0 {C_SN}
XMWR_op0_n100_s10_w10_2 sn_op0_n100_s10_w10_2 wwl_des wbl_op0_n100_s10_w10 0 sky130_fd_pr__nfet_01v8 L=0.15 W=0.42 nf=1 ad=0.1218 as=0.1218 pd=1.42 ps=1.42 nrd=0.69047619047619  nrs=0.69047619047619 sa=0 sb=0 sd=0 mult=1 m=1
XMRD_op0_n100_s10_w10_2 rbl_op0_n100_s10_w10 sn_op0_n100_s10_w10_2 rwl_des 0 sky130_fd_pr__nfet_01v8 L=0.15 W=0.42 nf=1 ad=0.1218 as=0.1218 pd=1.42 ps=1.42 nrd=0.69047619047619  nrs=0.69047619047619 sa=0 sb=0 sd=0 mult=1 m=1
csn_op0_n100_s10_w10_2 sn_op0_n100_s10_w10_2 0 {C_SN}
XMWR_op0_n100_s10_w10_3 sn_op0_n100_s10_w10_3 wwl_des wbl_op0_n100_s10_w10 0 sky130_fd_pr__nfet_01v8 L=0.15 W=0.42 nf=1 ad=0.1218 as=0.1218 pd=1.42 ps=1.42 nrd=0.69047619047619  nrs=0.69047619047619 sa=0 sb=0 sd=0 mult=1 m=1
XMRD_op0_n100_s10_w10_3 rbl_op0_n100_s10_w10 sn_op0_n100_s10_w10_3 rwl_des 0 sky130_fd_pr__nfet_01v8 L=0.15 W=0.42 nf=1 ad=0.1218 as=0.1218 pd=1.42 ps=1.42 nrd=0.69047619047619  nrs=0.69047619047619 sa=0 sb=0 sd=0 mult=1 m=1
csn_op0_n100_s10_w10_3 sn_op0_n100_s10_w10_3 0 {C_SN}
XMN1_op0_n100_s10_w10 rbl_op0_n100_s10_w10 ref_op0_n100_s10_w10 vn_op0_n100_s10_w10 0 sky130_fd_pr__nfet_01v8 L=0.15 W=1 nf=1 ad=0.29 as=0.29 pd=2.58 ps=2.58 mult=1 m=1
XMN2_op0_n100_s10_w10 ref_op0_n100_s10_w10 rbl_op0_n100_s10_w10 vn_op0_n100_s10_w10 0 sky130_fd_pr__nfet_01v8 L=0.15 W=1 nf=1 ad=0.29 as=0.29 pd=2.58 ps=2.58 mult=1 m=1
XMP1_op0_n100_s10_w10 rbl_op0_n100_s10_w10 ref_op0_n100_s10_w10 vp_op0_n100_s10_w10 vdd sky130_fd_pr__pfet_01v8 L=0.15 W=2 nf=1 ad=0.58 as=0.58 pd=4.58 ps=4.58 mult=1 m=1
XMP2_op0_n100_s10_w10 ref_op0_n100_s10_w10 rbl_op0_n100_s10_w10 vp_op0_n100_s10_w10 vdd sky130_fd_pr__pfet_01v8 L=0.15 W=2 nf=1 ad=0.58 as=0.58 pd=4.58 ps=4.58 mult=1 m=1
XMNF_op0_n100_s10_w10 vn_op0_n100_s10_w10 en_op0_n100_s10_w10 0 0 sky130_fd_pr__nfet_01v8 L=0.15 W=2 nf=1 ad=0.58 as=0.58 pd=4.58 ps=4.58 mult=1 m=1
XMPH_op0_n100_s10_w10 vp_op0_n100_s10_w10 enb_op0_n100_s10_w10 vdd vdd sky130_fd_pr__pfet_01v8 L=0.15 W=4 nf=1 ad=1.16 as=1.16 pd=8.58 ps=8.58 mult=1 m=1
bd_op0_n100_s10_w10 d_op0_n100_s10_w10 0 v=v(rbl_op0_n100_s10_w10)-v(ref_op0_n100_s10_w10)

* ---- instance 176: op0_n100_s10_w15 (t_en 14 ns, WWL 15..30 ns, release 32 ns) ----
ven_op0_n100_s10_w15  en_op0_n100_s10_w15  0 pwl(0 0 1.4000e-08 0 1.4100e-08 {VDD} 3.2000e-08 {VDD} 3.2100e-08 0)
venb_op0_n100_s10_w15 enb_op0_n100_s10_w15 0 pwl(0 {VDD} 1.4000e-08 {VDD} 1.4100e-08 0 3.2000e-08 0 3.2100e-08 {VDD})
vrs_op0_n100_s10_w15  rwls_op0_n100_s10_w15 0 pwl(0 {VDD} {T_READ} {VDD} {T_READ+TEDGE} 0 3.2000e-08 0 3.2100e-08 {VDD})
vww_op0_n100_s10_w15  wwl_op0_n100_s10_w15 0 pwl(0 0 1.5000e-08 0 1.5100e-08 {VDD} 3.0000e-08 {VDD} 3.0100e-08 0)
vwc_op0_n100_s10_w15  wbc_op0_n100_s10_w15 0 pwl(0 0 1.5000e-08 0 1.5100e-08 {VDD} 3.2000e-08 {VDD} 3.2100e-08 0)
swb_op0_n100_s10_w15 ref_op0_n100_s10_w15 wbl_op0_n100_s10_w15 wbc_op0_n100_s10_w15 0 swwbl
cwbl_op0_n100_s10_w15 wbl_op0_n100_s10_w15 0 {C_WBL}
spa_op0_n100_s10_w15 prea rbl_op0_n100_s10_w15 ctl 0 swpre
spr_op0_n100_s10_w15 pref ref_op0_n100_s10_w15 ctl 0 swpre
crbl_op0_n100_s10_w15 rbl_op0_n100_s10_w15 0 {C_RBL}
cref_op0_n100_s10_w15 ref_op0_n100_s10_w15 0 {C_RBL}   $ ASSUMPTION: ideal matched dummy load
XMWR_op0_n100_s10_w15_0 sn_op0_n100_s10_w15_0 wwl_op0_n100_s10_w15 wbl_op0_n100_s10_w15 0 sky130_fd_pr__nfet_01v8 L=0.15 W=0.42 nf=1 ad=0.1218 as=0.1218 pd=1.42 ps=1.42 nrd=0.69047619047619  nrs=0.69047619047619 sa=0 sb=0 sd=0 mult=1 m=1
XMRD_op0_n100_s10_w15_0 rbl_op0_n100_s10_w15 sn_op0_n100_s10_w15_0 rwls_op0_n100_s10_w15 0 sky130_fd_pr__nfet_01v8 L=0.15 W=0.42 nf=1 ad=0.1218 as=0.1218 pd=1.42 ps=1.42 nrd=0.69047619047619  nrs=0.69047619047619 sa=0 sb=0 sd=0 mult=1 m=1
csn_op0_n100_s10_w15_0 sn_op0_n100_s10_w15_0 0 {C_SN}
XMWR_op0_n100_s10_w15_1 sn_op0_n100_s10_w15_1 wwl_des wbl_op0_n100_s10_w15 0 sky130_fd_pr__nfet_01v8 L=0.15 W=0.42 nf=1 ad=0.1218 as=0.1218 pd=1.42 ps=1.42 nrd=0.69047619047619  nrs=0.69047619047619 sa=0 sb=0 sd=0 mult=1 m=1
XMRD_op0_n100_s10_w15_1 rbl_op0_n100_s10_w15 sn_op0_n100_s10_w15_1 rwl_des 0 sky130_fd_pr__nfet_01v8 L=0.15 W=0.42 nf=1 ad=0.1218 as=0.1218 pd=1.42 ps=1.42 nrd=0.69047619047619  nrs=0.69047619047619 sa=0 sb=0 sd=0 mult=1 m=1
csn_op0_n100_s10_w15_1 sn_op0_n100_s10_w15_1 0 {C_SN}
XMWR_op0_n100_s10_w15_2 sn_op0_n100_s10_w15_2 wwl_des wbl_op0_n100_s10_w15 0 sky130_fd_pr__nfet_01v8 L=0.15 W=0.42 nf=1 ad=0.1218 as=0.1218 pd=1.42 ps=1.42 nrd=0.69047619047619  nrs=0.69047619047619 sa=0 sb=0 sd=0 mult=1 m=1
XMRD_op0_n100_s10_w15_2 rbl_op0_n100_s10_w15 sn_op0_n100_s10_w15_2 rwl_des 0 sky130_fd_pr__nfet_01v8 L=0.15 W=0.42 nf=1 ad=0.1218 as=0.1218 pd=1.42 ps=1.42 nrd=0.69047619047619  nrs=0.69047619047619 sa=0 sb=0 sd=0 mult=1 m=1
csn_op0_n100_s10_w15_2 sn_op0_n100_s10_w15_2 0 {C_SN}
XMWR_op0_n100_s10_w15_3 sn_op0_n100_s10_w15_3 wwl_des wbl_op0_n100_s10_w15 0 sky130_fd_pr__nfet_01v8 L=0.15 W=0.42 nf=1 ad=0.1218 as=0.1218 pd=1.42 ps=1.42 nrd=0.69047619047619  nrs=0.69047619047619 sa=0 sb=0 sd=0 mult=1 m=1
XMRD_op0_n100_s10_w15_3 rbl_op0_n100_s10_w15 sn_op0_n100_s10_w15_3 rwl_des 0 sky130_fd_pr__nfet_01v8 L=0.15 W=0.42 nf=1 ad=0.1218 as=0.1218 pd=1.42 ps=1.42 nrd=0.69047619047619  nrs=0.69047619047619 sa=0 sb=0 sd=0 mult=1 m=1
csn_op0_n100_s10_w15_3 sn_op0_n100_s10_w15_3 0 {C_SN}
XMN1_op0_n100_s10_w15 rbl_op0_n100_s10_w15 ref_op0_n100_s10_w15 vn_op0_n100_s10_w15 0 sky130_fd_pr__nfet_01v8 L=0.15 W=1 nf=1 ad=0.29 as=0.29 pd=2.58 ps=2.58 mult=1 m=1
XMN2_op0_n100_s10_w15 ref_op0_n100_s10_w15 rbl_op0_n100_s10_w15 vn_op0_n100_s10_w15 0 sky130_fd_pr__nfet_01v8 L=0.15 W=1 nf=1 ad=0.29 as=0.29 pd=2.58 ps=2.58 mult=1 m=1
XMP1_op0_n100_s10_w15 rbl_op0_n100_s10_w15 ref_op0_n100_s10_w15 vp_op0_n100_s10_w15 vdd sky130_fd_pr__pfet_01v8 L=0.15 W=2 nf=1 ad=0.58 as=0.58 pd=4.58 ps=4.58 mult=1 m=1
XMP2_op0_n100_s10_w15 ref_op0_n100_s10_w15 rbl_op0_n100_s10_w15 vp_op0_n100_s10_w15 vdd sky130_fd_pr__pfet_01v8 L=0.15 W=2 nf=1 ad=0.58 as=0.58 pd=4.58 ps=4.58 mult=1 m=1
XMNF_op0_n100_s10_w15 vn_op0_n100_s10_w15 en_op0_n100_s10_w15 0 0 sky130_fd_pr__nfet_01v8 L=0.15 W=2 nf=1 ad=0.58 as=0.58 pd=4.58 ps=4.58 mult=1 m=1
XMPH_op0_n100_s10_w15 vp_op0_n100_s10_w15 enb_op0_n100_s10_w15 vdd vdd sky130_fd_pr__pfet_01v8 L=0.15 W=4 nf=1 ad=1.16 as=1.16 pd=8.58 ps=8.58 mult=1 m=1
bd_op0_n100_s10_w15 d_op0_n100_s10_w15 0 v=v(rbl_op0_n100_s10_w15)-v(ref_op0_n100_s10_w15)

* ---- instance 177: op0_n100_s10_w20 (t_en 14 ns, WWL 15..35 ns, release 37 ns) ----
ven_op0_n100_s10_w20  en_op0_n100_s10_w20  0 pwl(0 0 1.4000e-08 0 1.4100e-08 {VDD} 3.7000e-08 {VDD} 3.7100e-08 0)
venb_op0_n100_s10_w20 enb_op0_n100_s10_w20 0 pwl(0 {VDD} 1.4000e-08 {VDD} 1.4100e-08 0 3.7000e-08 0 3.7100e-08 {VDD})
vrs_op0_n100_s10_w20  rwls_op0_n100_s10_w20 0 pwl(0 {VDD} {T_READ} {VDD} {T_READ+TEDGE} 0 3.7000e-08 0 3.7100e-08 {VDD})
vww_op0_n100_s10_w20  wwl_op0_n100_s10_w20 0 pwl(0 0 1.5000e-08 0 1.5100e-08 {VDD} 3.5000e-08 {VDD} 3.5100e-08 0)
vwc_op0_n100_s10_w20  wbc_op0_n100_s10_w20 0 pwl(0 0 1.5000e-08 0 1.5100e-08 {VDD} 3.7000e-08 {VDD} 3.7100e-08 0)
swb_op0_n100_s10_w20 ref_op0_n100_s10_w20 wbl_op0_n100_s10_w20 wbc_op0_n100_s10_w20 0 swwbl
cwbl_op0_n100_s10_w20 wbl_op0_n100_s10_w20 0 {C_WBL}
spa_op0_n100_s10_w20 prea rbl_op0_n100_s10_w20 ctl 0 swpre
spr_op0_n100_s10_w20 pref ref_op0_n100_s10_w20 ctl 0 swpre
crbl_op0_n100_s10_w20 rbl_op0_n100_s10_w20 0 {C_RBL}
cref_op0_n100_s10_w20 ref_op0_n100_s10_w20 0 {C_RBL}   $ ASSUMPTION: ideal matched dummy load
XMWR_op0_n100_s10_w20_0 sn_op0_n100_s10_w20_0 wwl_op0_n100_s10_w20 wbl_op0_n100_s10_w20 0 sky130_fd_pr__nfet_01v8 L=0.15 W=0.42 nf=1 ad=0.1218 as=0.1218 pd=1.42 ps=1.42 nrd=0.69047619047619  nrs=0.69047619047619 sa=0 sb=0 sd=0 mult=1 m=1
XMRD_op0_n100_s10_w20_0 rbl_op0_n100_s10_w20 sn_op0_n100_s10_w20_0 rwls_op0_n100_s10_w20 0 sky130_fd_pr__nfet_01v8 L=0.15 W=0.42 nf=1 ad=0.1218 as=0.1218 pd=1.42 ps=1.42 nrd=0.69047619047619  nrs=0.69047619047619 sa=0 sb=0 sd=0 mult=1 m=1
csn_op0_n100_s10_w20_0 sn_op0_n100_s10_w20_0 0 {C_SN}
XMWR_op0_n100_s10_w20_1 sn_op0_n100_s10_w20_1 wwl_des wbl_op0_n100_s10_w20 0 sky130_fd_pr__nfet_01v8 L=0.15 W=0.42 nf=1 ad=0.1218 as=0.1218 pd=1.42 ps=1.42 nrd=0.69047619047619  nrs=0.69047619047619 sa=0 sb=0 sd=0 mult=1 m=1
XMRD_op0_n100_s10_w20_1 rbl_op0_n100_s10_w20 sn_op0_n100_s10_w20_1 rwl_des 0 sky130_fd_pr__nfet_01v8 L=0.15 W=0.42 nf=1 ad=0.1218 as=0.1218 pd=1.42 ps=1.42 nrd=0.69047619047619  nrs=0.69047619047619 sa=0 sb=0 sd=0 mult=1 m=1
csn_op0_n100_s10_w20_1 sn_op0_n100_s10_w20_1 0 {C_SN}
XMWR_op0_n100_s10_w20_2 sn_op0_n100_s10_w20_2 wwl_des wbl_op0_n100_s10_w20 0 sky130_fd_pr__nfet_01v8 L=0.15 W=0.42 nf=1 ad=0.1218 as=0.1218 pd=1.42 ps=1.42 nrd=0.69047619047619  nrs=0.69047619047619 sa=0 sb=0 sd=0 mult=1 m=1
XMRD_op0_n100_s10_w20_2 rbl_op0_n100_s10_w20 sn_op0_n100_s10_w20_2 rwl_des 0 sky130_fd_pr__nfet_01v8 L=0.15 W=0.42 nf=1 ad=0.1218 as=0.1218 pd=1.42 ps=1.42 nrd=0.69047619047619  nrs=0.69047619047619 sa=0 sb=0 sd=0 mult=1 m=1
csn_op0_n100_s10_w20_2 sn_op0_n100_s10_w20_2 0 {C_SN}
XMWR_op0_n100_s10_w20_3 sn_op0_n100_s10_w20_3 wwl_des wbl_op0_n100_s10_w20 0 sky130_fd_pr__nfet_01v8 L=0.15 W=0.42 nf=1 ad=0.1218 as=0.1218 pd=1.42 ps=1.42 nrd=0.69047619047619  nrs=0.69047619047619 sa=0 sb=0 sd=0 mult=1 m=1
XMRD_op0_n100_s10_w20_3 rbl_op0_n100_s10_w20 sn_op0_n100_s10_w20_3 rwl_des 0 sky130_fd_pr__nfet_01v8 L=0.15 W=0.42 nf=1 ad=0.1218 as=0.1218 pd=1.42 ps=1.42 nrd=0.69047619047619  nrs=0.69047619047619 sa=0 sb=0 sd=0 mult=1 m=1
csn_op0_n100_s10_w20_3 sn_op0_n100_s10_w20_3 0 {C_SN}
XMN1_op0_n100_s10_w20 rbl_op0_n100_s10_w20 ref_op0_n100_s10_w20 vn_op0_n100_s10_w20 0 sky130_fd_pr__nfet_01v8 L=0.15 W=1 nf=1 ad=0.29 as=0.29 pd=2.58 ps=2.58 mult=1 m=1
XMN2_op0_n100_s10_w20 ref_op0_n100_s10_w20 rbl_op0_n100_s10_w20 vn_op0_n100_s10_w20 0 sky130_fd_pr__nfet_01v8 L=0.15 W=1 nf=1 ad=0.29 as=0.29 pd=2.58 ps=2.58 mult=1 m=1
XMP1_op0_n100_s10_w20 rbl_op0_n100_s10_w20 ref_op0_n100_s10_w20 vp_op0_n100_s10_w20 vdd sky130_fd_pr__pfet_01v8 L=0.15 W=2 nf=1 ad=0.58 as=0.58 pd=4.58 ps=4.58 mult=1 m=1
XMP2_op0_n100_s10_w20 ref_op0_n100_s10_w20 rbl_op0_n100_s10_w20 vp_op0_n100_s10_w20 vdd sky130_fd_pr__pfet_01v8 L=0.15 W=2 nf=1 ad=0.58 as=0.58 pd=4.58 ps=4.58 mult=1 m=1
XMNF_op0_n100_s10_w20 vn_op0_n100_s10_w20 en_op0_n100_s10_w20 0 0 sky130_fd_pr__nfet_01v8 L=0.15 W=2 nf=1 ad=0.58 as=0.58 pd=4.58 ps=4.58 mult=1 m=1
XMPH_op0_n100_s10_w20 vp_op0_n100_s10_w20 enb_op0_n100_s10_w20 vdd vdd sky130_fd_pr__pfet_01v8 L=0.15 W=4 nf=1 ad=1.16 as=1.16 pd=8.58 ps=8.58 mult=1 m=1
bd_op0_n100_s10_w20 d_op0_n100_s10_w20 0 v=v(rbl_op0_n100_s10_w20)-v(ref_op0_n100_s10_w20)

* ---- instance 178: op0_n100_s10_w30 (t_en 14 ns, WWL 15..45 ns, release 47 ns) ----
ven_op0_n100_s10_w30  en_op0_n100_s10_w30  0 pwl(0 0 1.4000e-08 0 1.4100e-08 {VDD} 4.7000e-08 {VDD} 4.7100e-08 0)
venb_op0_n100_s10_w30 enb_op0_n100_s10_w30 0 pwl(0 {VDD} 1.4000e-08 {VDD} 1.4100e-08 0 4.7000e-08 0 4.7100e-08 {VDD})
vrs_op0_n100_s10_w30  rwls_op0_n100_s10_w30 0 pwl(0 {VDD} {T_READ} {VDD} {T_READ+TEDGE} 0 4.7000e-08 0 4.7100e-08 {VDD})
vww_op0_n100_s10_w30  wwl_op0_n100_s10_w30 0 pwl(0 0 1.5000e-08 0 1.5100e-08 {VDD} 4.5000e-08 {VDD} 4.5100e-08 0)
vwc_op0_n100_s10_w30  wbc_op0_n100_s10_w30 0 pwl(0 0 1.5000e-08 0 1.5100e-08 {VDD} 4.7000e-08 {VDD} 4.7100e-08 0)
swb_op0_n100_s10_w30 ref_op0_n100_s10_w30 wbl_op0_n100_s10_w30 wbc_op0_n100_s10_w30 0 swwbl
cwbl_op0_n100_s10_w30 wbl_op0_n100_s10_w30 0 {C_WBL}
spa_op0_n100_s10_w30 prea rbl_op0_n100_s10_w30 ctl 0 swpre
spr_op0_n100_s10_w30 pref ref_op0_n100_s10_w30 ctl 0 swpre
crbl_op0_n100_s10_w30 rbl_op0_n100_s10_w30 0 {C_RBL}
cref_op0_n100_s10_w30 ref_op0_n100_s10_w30 0 {C_RBL}   $ ASSUMPTION: ideal matched dummy load
XMWR_op0_n100_s10_w30_0 sn_op0_n100_s10_w30_0 wwl_op0_n100_s10_w30 wbl_op0_n100_s10_w30 0 sky130_fd_pr__nfet_01v8 L=0.15 W=0.42 nf=1 ad=0.1218 as=0.1218 pd=1.42 ps=1.42 nrd=0.69047619047619  nrs=0.69047619047619 sa=0 sb=0 sd=0 mult=1 m=1
XMRD_op0_n100_s10_w30_0 rbl_op0_n100_s10_w30 sn_op0_n100_s10_w30_0 rwls_op0_n100_s10_w30 0 sky130_fd_pr__nfet_01v8 L=0.15 W=0.42 nf=1 ad=0.1218 as=0.1218 pd=1.42 ps=1.42 nrd=0.69047619047619  nrs=0.69047619047619 sa=0 sb=0 sd=0 mult=1 m=1
csn_op0_n100_s10_w30_0 sn_op0_n100_s10_w30_0 0 {C_SN}
XMWR_op0_n100_s10_w30_1 sn_op0_n100_s10_w30_1 wwl_des wbl_op0_n100_s10_w30 0 sky130_fd_pr__nfet_01v8 L=0.15 W=0.42 nf=1 ad=0.1218 as=0.1218 pd=1.42 ps=1.42 nrd=0.69047619047619  nrs=0.69047619047619 sa=0 sb=0 sd=0 mult=1 m=1
XMRD_op0_n100_s10_w30_1 rbl_op0_n100_s10_w30 sn_op0_n100_s10_w30_1 rwl_des 0 sky130_fd_pr__nfet_01v8 L=0.15 W=0.42 nf=1 ad=0.1218 as=0.1218 pd=1.42 ps=1.42 nrd=0.69047619047619  nrs=0.69047619047619 sa=0 sb=0 sd=0 mult=1 m=1
csn_op0_n100_s10_w30_1 sn_op0_n100_s10_w30_1 0 {C_SN}
XMWR_op0_n100_s10_w30_2 sn_op0_n100_s10_w30_2 wwl_des wbl_op0_n100_s10_w30 0 sky130_fd_pr__nfet_01v8 L=0.15 W=0.42 nf=1 ad=0.1218 as=0.1218 pd=1.42 ps=1.42 nrd=0.69047619047619  nrs=0.69047619047619 sa=0 sb=0 sd=0 mult=1 m=1
XMRD_op0_n100_s10_w30_2 rbl_op0_n100_s10_w30 sn_op0_n100_s10_w30_2 rwl_des 0 sky130_fd_pr__nfet_01v8 L=0.15 W=0.42 nf=1 ad=0.1218 as=0.1218 pd=1.42 ps=1.42 nrd=0.69047619047619  nrs=0.69047619047619 sa=0 sb=0 sd=0 mult=1 m=1
csn_op0_n100_s10_w30_2 sn_op0_n100_s10_w30_2 0 {C_SN}
XMWR_op0_n100_s10_w30_3 sn_op0_n100_s10_w30_3 wwl_des wbl_op0_n100_s10_w30 0 sky130_fd_pr__nfet_01v8 L=0.15 W=0.42 nf=1 ad=0.1218 as=0.1218 pd=1.42 ps=1.42 nrd=0.69047619047619  nrs=0.69047619047619 sa=0 sb=0 sd=0 mult=1 m=1
XMRD_op0_n100_s10_w30_3 rbl_op0_n100_s10_w30 sn_op0_n100_s10_w30_3 rwl_des 0 sky130_fd_pr__nfet_01v8 L=0.15 W=0.42 nf=1 ad=0.1218 as=0.1218 pd=1.42 ps=1.42 nrd=0.69047619047619  nrs=0.69047619047619 sa=0 sb=0 sd=0 mult=1 m=1
csn_op0_n100_s10_w30_3 sn_op0_n100_s10_w30_3 0 {C_SN}
XMN1_op0_n100_s10_w30 rbl_op0_n100_s10_w30 ref_op0_n100_s10_w30 vn_op0_n100_s10_w30 0 sky130_fd_pr__nfet_01v8 L=0.15 W=1 nf=1 ad=0.29 as=0.29 pd=2.58 ps=2.58 mult=1 m=1
XMN2_op0_n100_s10_w30 ref_op0_n100_s10_w30 rbl_op0_n100_s10_w30 vn_op0_n100_s10_w30 0 sky130_fd_pr__nfet_01v8 L=0.15 W=1 nf=1 ad=0.29 as=0.29 pd=2.58 ps=2.58 mult=1 m=1
XMP1_op0_n100_s10_w30 rbl_op0_n100_s10_w30 ref_op0_n100_s10_w30 vp_op0_n100_s10_w30 vdd sky130_fd_pr__pfet_01v8 L=0.15 W=2 nf=1 ad=0.58 as=0.58 pd=4.58 ps=4.58 mult=1 m=1
XMP2_op0_n100_s10_w30 ref_op0_n100_s10_w30 rbl_op0_n100_s10_w30 vp_op0_n100_s10_w30 vdd sky130_fd_pr__pfet_01v8 L=0.15 W=2 nf=1 ad=0.58 as=0.58 pd=4.58 ps=4.58 mult=1 m=1
XMNF_op0_n100_s10_w30 vn_op0_n100_s10_w30 en_op0_n100_s10_w30 0 0 sky130_fd_pr__nfet_01v8 L=0.15 W=2 nf=1 ad=0.58 as=0.58 pd=4.58 ps=4.58 mult=1 m=1
XMPH_op0_n100_s10_w30 vp_op0_n100_s10_w30 enb_op0_n100_s10_w30 vdd vdd sky130_fd_pr__pfet_01v8 L=0.15 W=4 nf=1 ad=1.16 as=1.16 pd=8.58 ps=8.58 mult=1 m=1
bd_op0_n100_s10_w30 d_op0_n100_s10_w30 0 v=v(rbl_op0_n100_s10_w30)-v(ref_op0_n100_s10_w30)

* ---- instance 179: op0_n100_s10_w50 (t_en 14 ns, WWL 15..65 ns, release 67 ns) ----
ven_op0_n100_s10_w50  en_op0_n100_s10_w50  0 pwl(0 0 1.4000e-08 0 1.4100e-08 {VDD} 6.7000e-08 {VDD} 6.7100e-08 0)
venb_op0_n100_s10_w50 enb_op0_n100_s10_w50 0 pwl(0 {VDD} 1.4000e-08 {VDD} 1.4100e-08 0 6.7000e-08 0 6.7100e-08 {VDD})
vrs_op0_n100_s10_w50  rwls_op0_n100_s10_w50 0 pwl(0 {VDD} {T_READ} {VDD} {T_READ+TEDGE} 0 6.7000e-08 0 6.7100e-08 {VDD})
vww_op0_n100_s10_w50  wwl_op0_n100_s10_w50 0 pwl(0 0 1.5000e-08 0 1.5100e-08 {VDD} 6.5000e-08 {VDD} 6.5100e-08 0)
vwc_op0_n100_s10_w50  wbc_op0_n100_s10_w50 0 pwl(0 0 1.5000e-08 0 1.5100e-08 {VDD} 6.7000e-08 {VDD} 6.7100e-08 0)
swb_op0_n100_s10_w50 ref_op0_n100_s10_w50 wbl_op0_n100_s10_w50 wbc_op0_n100_s10_w50 0 swwbl
cwbl_op0_n100_s10_w50 wbl_op0_n100_s10_w50 0 {C_WBL}
spa_op0_n100_s10_w50 prea rbl_op0_n100_s10_w50 ctl 0 swpre
spr_op0_n100_s10_w50 pref ref_op0_n100_s10_w50 ctl 0 swpre
crbl_op0_n100_s10_w50 rbl_op0_n100_s10_w50 0 {C_RBL}
cref_op0_n100_s10_w50 ref_op0_n100_s10_w50 0 {C_RBL}   $ ASSUMPTION: ideal matched dummy load
XMWR_op0_n100_s10_w50_0 sn_op0_n100_s10_w50_0 wwl_op0_n100_s10_w50 wbl_op0_n100_s10_w50 0 sky130_fd_pr__nfet_01v8 L=0.15 W=0.42 nf=1 ad=0.1218 as=0.1218 pd=1.42 ps=1.42 nrd=0.69047619047619  nrs=0.69047619047619 sa=0 sb=0 sd=0 mult=1 m=1
XMRD_op0_n100_s10_w50_0 rbl_op0_n100_s10_w50 sn_op0_n100_s10_w50_0 rwls_op0_n100_s10_w50 0 sky130_fd_pr__nfet_01v8 L=0.15 W=0.42 nf=1 ad=0.1218 as=0.1218 pd=1.42 ps=1.42 nrd=0.69047619047619  nrs=0.69047619047619 sa=0 sb=0 sd=0 mult=1 m=1
csn_op0_n100_s10_w50_0 sn_op0_n100_s10_w50_0 0 {C_SN}
XMWR_op0_n100_s10_w50_1 sn_op0_n100_s10_w50_1 wwl_des wbl_op0_n100_s10_w50 0 sky130_fd_pr__nfet_01v8 L=0.15 W=0.42 nf=1 ad=0.1218 as=0.1218 pd=1.42 ps=1.42 nrd=0.69047619047619  nrs=0.69047619047619 sa=0 sb=0 sd=0 mult=1 m=1
XMRD_op0_n100_s10_w50_1 rbl_op0_n100_s10_w50 sn_op0_n100_s10_w50_1 rwl_des 0 sky130_fd_pr__nfet_01v8 L=0.15 W=0.42 nf=1 ad=0.1218 as=0.1218 pd=1.42 ps=1.42 nrd=0.69047619047619  nrs=0.69047619047619 sa=0 sb=0 sd=0 mult=1 m=1
csn_op0_n100_s10_w50_1 sn_op0_n100_s10_w50_1 0 {C_SN}
XMWR_op0_n100_s10_w50_2 sn_op0_n100_s10_w50_2 wwl_des wbl_op0_n100_s10_w50 0 sky130_fd_pr__nfet_01v8 L=0.15 W=0.42 nf=1 ad=0.1218 as=0.1218 pd=1.42 ps=1.42 nrd=0.69047619047619  nrs=0.69047619047619 sa=0 sb=0 sd=0 mult=1 m=1
XMRD_op0_n100_s10_w50_2 rbl_op0_n100_s10_w50 sn_op0_n100_s10_w50_2 rwl_des 0 sky130_fd_pr__nfet_01v8 L=0.15 W=0.42 nf=1 ad=0.1218 as=0.1218 pd=1.42 ps=1.42 nrd=0.69047619047619  nrs=0.69047619047619 sa=0 sb=0 sd=0 mult=1 m=1
csn_op0_n100_s10_w50_2 sn_op0_n100_s10_w50_2 0 {C_SN}
XMWR_op0_n100_s10_w50_3 sn_op0_n100_s10_w50_3 wwl_des wbl_op0_n100_s10_w50 0 sky130_fd_pr__nfet_01v8 L=0.15 W=0.42 nf=1 ad=0.1218 as=0.1218 pd=1.42 ps=1.42 nrd=0.69047619047619  nrs=0.69047619047619 sa=0 sb=0 sd=0 mult=1 m=1
XMRD_op0_n100_s10_w50_3 rbl_op0_n100_s10_w50 sn_op0_n100_s10_w50_3 rwl_des 0 sky130_fd_pr__nfet_01v8 L=0.15 W=0.42 nf=1 ad=0.1218 as=0.1218 pd=1.42 ps=1.42 nrd=0.69047619047619  nrs=0.69047619047619 sa=0 sb=0 sd=0 mult=1 m=1
csn_op0_n100_s10_w50_3 sn_op0_n100_s10_w50_3 0 {C_SN}
XMN1_op0_n100_s10_w50 rbl_op0_n100_s10_w50 ref_op0_n100_s10_w50 vn_op0_n100_s10_w50 0 sky130_fd_pr__nfet_01v8 L=0.15 W=1 nf=1 ad=0.29 as=0.29 pd=2.58 ps=2.58 mult=1 m=1
XMN2_op0_n100_s10_w50 ref_op0_n100_s10_w50 rbl_op0_n100_s10_w50 vn_op0_n100_s10_w50 0 sky130_fd_pr__nfet_01v8 L=0.15 W=1 nf=1 ad=0.29 as=0.29 pd=2.58 ps=2.58 mult=1 m=1
XMP1_op0_n100_s10_w50 rbl_op0_n100_s10_w50 ref_op0_n100_s10_w50 vp_op0_n100_s10_w50 vdd sky130_fd_pr__pfet_01v8 L=0.15 W=2 nf=1 ad=0.58 as=0.58 pd=4.58 ps=4.58 mult=1 m=1
XMP2_op0_n100_s10_w50 ref_op0_n100_s10_w50 rbl_op0_n100_s10_w50 vp_op0_n100_s10_w50 vdd sky130_fd_pr__pfet_01v8 L=0.15 W=2 nf=1 ad=0.58 as=0.58 pd=4.58 ps=4.58 mult=1 m=1
XMNF_op0_n100_s10_w50 vn_op0_n100_s10_w50 en_op0_n100_s10_w50 0 0 sky130_fd_pr__nfet_01v8 L=0.15 W=2 nf=1 ad=0.58 as=0.58 pd=4.58 ps=4.58 mult=1 m=1
XMPH_op0_n100_s10_w50 vp_op0_n100_s10_w50 enb_op0_n100_s10_w50 vdd vdd sky130_fd_pr__pfet_01v8 L=0.15 W=4 nf=1 ad=1.16 as=1.16 pd=8.58 ps=8.58 mult=1 m=1
bd_op0_n100_s10_w50 d_op0_n100_s10_w50 0 v=v(rbl_op0_n100_s10_w50)-v(ref_op0_n100_s10_w50)

* ---- instance 180: op0_0000_s0p5_w0p2 (t_en 4.5 ns, WWL 5.5..5.7 ns, release 7.7 ns) ----
ven_op0_0000_s0p5_w0p2  en_op0_0000_s0p5_w0p2  0 pwl(0 0 4.5000e-09 0 4.6000e-09 {VDD} 7.7000e-09 {VDD} 7.8000e-09 0)
venb_op0_0000_s0p5_w0p2 enb_op0_0000_s0p5_w0p2 0 pwl(0 {VDD} 4.5000e-09 {VDD} 4.6000e-09 0 7.7000e-09 0 7.8000e-09 {VDD})
vrs_op0_0000_s0p5_w0p2  rwls_op0_0000_s0p5_w0p2 0 pwl(0 {VDD} {T_READ} {VDD} {T_READ+TEDGE} 0 7.7000e-09 0 7.8000e-09 {VDD})
vww_op0_0000_s0p5_w0p2  wwl_op0_0000_s0p5_w0p2 0 pwl(0 0 5.5000e-09 0 5.6000e-09 {VDD} 5.7000e-09 {VDD} 5.8000e-09 0)
vwc_op0_0000_s0p5_w0p2  wbc_op0_0000_s0p5_w0p2 0 pwl(0 0 5.5000e-09 0 5.6000e-09 {VDD} 7.7000e-09 {VDD} 7.8000e-09 0)
swb_op0_0000_s0p5_w0p2 ref_op0_0000_s0p5_w0p2 wbl_op0_0000_s0p5_w0p2 wbc_op0_0000_s0p5_w0p2 0 swwbl
cwbl_op0_0000_s0p5_w0p2 wbl_op0_0000_s0p5_w0p2 0 {C_WBL}
spa_op0_0000_s0p5_w0p2 prea rbl_op0_0000_s0p5_w0p2 ctl 0 swpre
spr_op0_0000_s0p5_w0p2 pref ref_op0_0000_s0p5_w0p2 ctl 0 swpre
crbl_op0_0000_s0p5_w0p2 rbl_op0_0000_s0p5_w0p2 0 {C_RBL}
cref_op0_0000_s0p5_w0p2 ref_op0_0000_s0p5_w0p2 0 {C_RBL}   $ ASSUMPTION: ideal matched dummy load
XMWR_op0_0000_s0p5_w0p2_0 sn_op0_0000_s0p5_w0p2_0 wwl_op0_0000_s0p5_w0p2 wbl_op0_0000_s0p5_w0p2 0 sky130_fd_pr__nfet_01v8 L=0.15 W=0.42 nf=1 ad=0.1218 as=0.1218 pd=1.42 ps=1.42 nrd=0.69047619047619  nrs=0.69047619047619 sa=0 sb=0 sd=0 mult=1 m=1
XMRD_op0_0000_s0p5_w0p2_0 rbl_op0_0000_s0p5_w0p2 sn_op0_0000_s0p5_w0p2_0 rwls_op0_0000_s0p5_w0p2 0 sky130_fd_pr__nfet_01v8 L=0.15 W=0.42 nf=1 ad=0.1218 as=0.1218 pd=1.42 ps=1.42 nrd=0.69047619047619  nrs=0.69047619047619 sa=0 sb=0 sd=0 mult=1 m=1
csn_op0_0000_s0p5_w0p2_0 sn_op0_0000_s0p5_w0p2_0 0 {C_SN}
XMWR_op0_0000_s0p5_w0p2_1 sn_op0_0000_s0p5_w0p2_1 wwl_des wbl_op0_0000_s0p5_w0p2 0 sky130_fd_pr__nfet_01v8 L=0.15 W=0.42 nf=1 ad=0.1218 as=0.1218 pd=1.42 ps=1.42 nrd=0.69047619047619  nrs=0.69047619047619 sa=0 sb=0 sd=0 mult=1 m=1
XMRD_op0_0000_s0p5_w0p2_1 rbl_op0_0000_s0p5_w0p2 sn_op0_0000_s0p5_w0p2_1 rwl_des 0 sky130_fd_pr__nfet_01v8 L=0.15 W=0.42 nf=1 ad=0.1218 as=0.1218 pd=1.42 ps=1.42 nrd=0.69047619047619  nrs=0.69047619047619 sa=0 sb=0 sd=0 mult=1 m=1
csn_op0_0000_s0p5_w0p2_1 sn_op0_0000_s0p5_w0p2_1 0 {C_SN}
XMWR_op0_0000_s0p5_w0p2_2 sn_op0_0000_s0p5_w0p2_2 wwl_des wbl_op0_0000_s0p5_w0p2 0 sky130_fd_pr__nfet_01v8 L=0.15 W=0.42 nf=1 ad=0.1218 as=0.1218 pd=1.42 ps=1.42 nrd=0.69047619047619  nrs=0.69047619047619 sa=0 sb=0 sd=0 mult=1 m=1
XMRD_op0_0000_s0p5_w0p2_2 rbl_op0_0000_s0p5_w0p2 sn_op0_0000_s0p5_w0p2_2 rwl_des 0 sky130_fd_pr__nfet_01v8 L=0.15 W=0.42 nf=1 ad=0.1218 as=0.1218 pd=1.42 ps=1.42 nrd=0.69047619047619  nrs=0.69047619047619 sa=0 sb=0 sd=0 mult=1 m=1
csn_op0_0000_s0p5_w0p2_2 sn_op0_0000_s0p5_w0p2_2 0 {C_SN}
XMWR_op0_0000_s0p5_w0p2_3 sn_op0_0000_s0p5_w0p2_3 wwl_des wbl_op0_0000_s0p5_w0p2 0 sky130_fd_pr__nfet_01v8 L=0.15 W=0.42 nf=1 ad=0.1218 as=0.1218 pd=1.42 ps=1.42 nrd=0.69047619047619  nrs=0.69047619047619 sa=0 sb=0 sd=0 mult=1 m=1
XMRD_op0_0000_s0p5_w0p2_3 rbl_op0_0000_s0p5_w0p2 sn_op0_0000_s0p5_w0p2_3 rwl_des 0 sky130_fd_pr__nfet_01v8 L=0.15 W=0.42 nf=1 ad=0.1218 as=0.1218 pd=1.42 ps=1.42 nrd=0.69047619047619  nrs=0.69047619047619 sa=0 sb=0 sd=0 mult=1 m=1
csn_op0_0000_s0p5_w0p2_3 sn_op0_0000_s0p5_w0p2_3 0 {C_SN}
XMN1_op0_0000_s0p5_w0p2 rbl_op0_0000_s0p5_w0p2 ref_op0_0000_s0p5_w0p2 vn_op0_0000_s0p5_w0p2 0 sky130_fd_pr__nfet_01v8 L=0.15 W=1 nf=1 ad=0.29 as=0.29 pd=2.58 ps=2.58 mult=1 m=1
XMN2_op0_0000_s0p5_w0p2 ref_op0_0000_s0p5_w0p2 rbl_op0_0000_s0p5_w0p2 vn_op0_0000_s0p5_w0p2 0 sky130_fd_pr__nfet_01v8 L=0.15 W=1 nf=1 ad=0.29 as=0.29 pd=2.58 ps=2.58 mult=1 m=1
XMP1_op0_0000_s0p5_w0p2 rbl_op0_0000_s0p5_w0p2 ref_op0_0000_s0p5_w0p2 vp_op0_0000_s0p5_w0p2 vdd sky130_fd_pr__pfet_01v8 L=0.15 W=2 nf=1 ad=0.58 as=0.58 pd=4.58 ps=4.58 mult=1 m=1
XMP2_op0_0000_s0p5_w0p2 ref_op0_0000_s0p5_w0p2 rbl_op0_0000_s0p5_w0p2 vp_op0_0000_s0p5_w0p2 vdd sky130_fd_pr__pfet_01v8 L=0.15 W=2 nf=1 ad=0.58 as=0.58 pd=4.58 ps=4.58 mult=1 m=1
XMNF_op0_0000_s0p5_w0p2 vn_op0_0000_s0p5_w0p2 en_op0_0000_s0p5_w0p2 0 0 sky130_fd_pr__nfet_01v8 L=0.15 W=2 nf=1 ad=0.58 as=0.58 pd=4.58 ps=4.58 mult=1 m=1
XMPH_op0_0000_s0p5_w0p2 vp_op0_0000_s0p5_w0p2 enb_op0_0000_s0p5_w0p2 vdd vdd sky130_fd_pr__pfet_01v8 L=0.15 W=4 nf=1 ad=1.16 as=1.16 pd=8.58 ps=8.58 mult=1 m=1
bd_op0_0000_s0p5_w0p2 d_op0_0000_s0p5_w0p2 0 v=v(rbl_op0_0000_s0p5_w0p2)-v(ref_op0_0000_s0p5_w0p2)

* ---- instance 181: op0_0000_s0p5_w0p5 (t_en 4.5 ns, WWL 5.5..6 ns, release 8 ns) ----
ven_op0_0000_s0p5_w0p5  en_op0_0000_s0p5_w0p5  0 pwl(0 0 4.5000e-09 0 4.6000e-09 {VDD} 8.0000e-09 {VDD} 8.1000e-09 0)
venb_op0_0000_s0p5_w0p5 enb_op0_0000_s0p5_w0p5 0 pwl(0 {VDD} 4.5000e-09 {VDD} 4.6000e-09 0 8.0000e-09 0 8.1000e-09 {VDD})
vrs_op0_0000_s0p5_w0p5  rwls_op0_0000_s0p5_w0p5 0 pwl(0 {VDD} {T_READ} {VDD} {T_READ+TEDGE} 0 8.0000e-09 0 8.1000e-09 {VDD})
vww_op0_0000_s0p5_w0p5  wwl_op0_0000_s0p5_w0p5 0 pwl(0 0 5.5000e-09 0 5.6000e-09 {VDD} 6.0000e-09 {VDD} 6.1000e-09 0)
vwc_op0_0000_s0p5_w0p5  wbc_op0_0000_s0p5_w0p5 0 pwl(0 0 5.5000e-09 0 5.6000e-09 {VDD} 8.0000e-09 {VDD} 8.1000e-09 0)
swb_op0_0000_s0p5_w0p5 ref_op0_0000_s0p5_w0p5 wbl_op0_0000_s0p5_w0p5 wbc_op0_0000_s0p5_w0p5 0 swwbl
cwbl_op0_0000_s0p5_w0p5 wbl_op0_0000_s0p5_w0p5 0 {C_WBL}
spa_op0_0000_s0p5_w0p5 prea rbl_op0_0000_s0p5_w0p5 ctl 0 swpre
spr_op0_0000_s0p5_w0p5 pref ref_op0_0000_s0p5_w0p5 ctl 0 swpre
crbl_op0_0000_s0p5_w0p5 rbl_op0_0000_s0p5_w0p5 0 {C_RBL}
cref_op0_0000_s0p5_w0p5 ref_op0_0000_s0p5_w0p5 0 {C_RBL}   $ ASSUMPTION: ideal matched dummy load
XMWR_op0_0000_s0p5_w0p5_0 sn_op0_0000_s0p5_w0p5_0 wwl_op0_0000_s0p5_w0p5 wbl_op0_0000_s0p5_w0p5 0 sky130_fd_pr__nfet_01v8 L=0.15 W=0.42 nf=1 ad=0.1218 as=0.1218 pd=1.42 ps=1.42 nrd=0.69047619047619  nrs=0.69047619047619 sa=0 sb=0 sd=0 mult=1 m=1
XMRD_op0_0000_s0p5_w0p5_0 rbl_op0_0000_s0p5_w0p5 sn_op0_0000_s0p5_w0p5_0 rwls_op0_0000_s0p5_w0p5 0 sky130_fd_pr__nfet_01v8 L=0.15 W=0.42 nf=1 ad=0.1218 as=0.1218 pd=1.42 ps=1.42 nrd=0.69047619047619  nrs=0.69047619047619 sa=0 sb=0 sd=0 mult=1 m=1
csn_op0_0000_s0p5_w0p5_0 sn_op0_0000_s0p5_w0p5_0 0 {C_SN}
XMWR_op0_0000_s0p5_w0p5_1 sn_op0_0000_s0p5_w0p5_1 wwl_des wbl_op0_0000_s0p5_w0p5 0 sky130_fd_pr__nfet_01v8 L=0.15 W=0.42 nf=1 ad=0.1218 as=0.1218 pd=1.42 ps=1.42 nrd=0.69047619047619  nrs=0.69047619047619 sa=0 sb=0 sd=0 mult=1 m=1
XMRD_op0_0000_s0p5_w0p5_1 rbl_op0_0000_s0p5_w0p5 sn_op0_0000_s0p5_w0p5_1 rwl_des 0 sky130_fd_pr__nfet_01v8 L=0.15 W=0.42 nf=1 ad=0.1218 as=0.1218 pd=1.42 ps=1.42 nrd=0.69047619047619  nrs=0.69047619047619 sa=0 sb=0 sd=0 mult=1 m=1
csn_op0_0000_s0p5_w0p5_1 sn_op0_0000_s0p5_w0p5_1 0 {C_SN}
XMWR_op0_0000_s0p5_w0p5_2 sn_op0_0000_s0p5_w0p5_2 wwl_des wbl_op0_0000_s0p5_w0p5 0 sky130_fd_pr__nfet_01v8 L=0.15 W=0.42 nf=1 ad=0.1218 as=0.1218 pd=1.42 ps=1.42 nrd=0.69047619047619  nrs=0.69047619047619 sa=0 sb=0 sd=0 mult=1 m=1
XMRD_op0_0000_s0p5_w0p5_2 rbl_op0_0000_s0p5_w0p5 sn_op0_0000_s0p5_w0p5_2 rwl_des 0 sky130_fd_pr__nfet_01v8 L=0.15 W=0.42 nf=1 ad=0.1218 as=0.1218 pd=1.42 ps=1.42 nrd=0.69047619047619  nrs=0.69047619047619 sa=0 sb=0 sd=0 mult=1 m=1
csn_op0_0000_s0p5_w0p5_2 sn_op0_0000_s0p5_w0p5_2 0 {C_SN}
XMWR_op0_0000_s0p5_w0p5_3 sn_op0_0000_s0p5_w0p5_3 wwl_des wbl_op0_0000_s0p5_w0p5 0 sky130_fd_pr__nfet_01v8 L=0.15 W=0.42 nf=1 ad=0.1218 as=0.1218 pd=1.42 ps=1.42 nrd=0.69047619047619  nrs=0.69047619047619 sa=0 sb=0 sd=0 mult=1 m=1
XMRD_op0_0000_s0p5_w0p5_3 rbl_op0_0000_s0p5_w0p5 sn_op0_0000_s0p5_w0p5_3 rwl_des 0 sky130_fd_pr__nfet_01v8 L=0.15 W=0.42 nf=1 ad=0.1218 as=0.1218 pd=1.42 ps=1.42 nrd=0.69047619047619  nrs=0.69047619047619 sa=0 sb=0 sd=0 mult=1 m=1
csn_op0_0000_s0p5_w0p5_3 sn_op0_0000_s0p5_w0p5_3 0 {C_SN}
XMN1_op0_0000_s0p5_w0p5 rbl_op0_0000_s0p5_w0p5 ref_op0_0000_s0p5_w0p5 vn_op0_0000_s0p5_w0p5 0 sky130_fd_pr__nfet_01v8 L=0.15 W=1 nf=1 ad=0.29 as=0.29 pd=2.58 ps=2.58 mult=1 m=1
XMN2_op0_0000_s0p5_w0p5 ref_op0_0000_s0p5_w0p5 rbl_op0_0000_s0p5_w0p5 vn_op0_0000_s0p5_w0p5 0 sky130_fd_pr__nfet_01v8 L=0.15 W=1 nf=1 ad=0.29 as=0.29 pd=2.58 ps=2.58 mult=1 m=1
XMP1_op0_0000_s0p5_w0p5 rbl_op0_0000_s0p5_w0p5 ref_op0_0000_s0p5_w0p5 vp_op0_0000_s0p5_w0p5 vdd sky130_fd_pr__pfet_01v8 L=0.15 W=2 nf=1 ad=0.58 as=0.58 pd=4.58 ps=4.58 mult=1 m=1
XMP2_op0_0000_s0p5_w0p5 ref_op0_0000_s0p5_w0p5 rbl_op0_0000_s0p5_w0p5 vp_op0_0000_s0p5_w0p5 vdd sky130_fd_pr__pfet_01v8 L=0.15 W=2 nf=1 ad=0.58 as=0.58 pd=4.58 ps=4.58 mult=1 m=1
XMNF_op0_0000_s0p5_w0p5 vn_op0_0000_s0p5_w0p5 en_op0_0000_s0p5_w0p5 0 0 sky130_fd_pr__nfet_01v8 L=0.15 W=2 nf=1 ad=0.58 as=0.58 pd=4.58 ps=4.58 mult=1 m=1
XMPH_op0_0000_s0p5_w0p5 vp_op0_0000_s0p5_w0p5 enb_op0_0000_s0p5_w0p5 vdd vdd sky130_fd_pr__pfet_01v8 L=0.15 W=4 nf=1 ad=1.16 as=1.16 pd=8.58 ps=8.58 mult=1 m=1
bd_op0_0000_s0p5_w0p5 d_op0_0000_s0p5_w0p5 0 v=v(rbl_op0_0000_s0p5_w0p5)-v(ref_op0_0000_s0p5_w0p5)

* ---- instance 182: op0_0000_s0p5_w1 (t_en 4.5 ns, WWL 5.5..6.5 ns, release 8.5 ns) ----
ven_op0_0000_s0p5_w1  en_op0_0000_s0p5_w1  0 pwl(0 0 4.5000e-09 0 4.6000e-09 {VDD} 8.5000e-09 {VDD} 8.6000e-09 0)
venb_op0_0000_s0p5_w1 enb_op0_0000_s0p5_w1 0 pwl(0 {VDD} 4.5000e-09 {VDD} 4.6000e-09 0 8.5000e-09 0 8.6000e-09 {VDD})
vrs_op0_0000_s0p5_w1  rwls_op0_0000_s0p5_w1 0 pwl(0 {VDD} {T_READ} {VDD} {T_READ+TEDGE} 0 8.5000e-09 0 8.6000e-09 {VDD})
vww_op0_0000_s0p5_w1  wwl_op0_0000_s0p5_w1 0 pwl(0 0 5.5000e-09 0 5.6000e-09 {VDD} 6.5000e-09 {VDD} 6.6000e-09 0)
vwc_op0_0000_s0p5_w1  wbc_op0_0000_s0p5_w1 0 pwl(0 0 5.5000e-09 0 5.6000e-09 {VDD} 8.5000e-09 {VDD} 8.6000e-09 0)
swb_op0_0000_s0p5_w1 ref_op0_0000_s0p5_w1 wbl_op0_0000_s0p5_w1 wbc_op0_0000_s0p5_w1 0 swwbl
cwbl_op0_0000_s0p5_w1 wbl_op0_0000_s0p5_w1 0 {C_WBL}
spa_op0_0000_s0p5_w1 prea rbl_op0_0000_s0p5_w1 ctl 0 swpre
spr_op0_0000_s0p5_w1 pref ref_op0_0000_s0p5_w1 ctl 0 swpre
crbl_op0_0000_s0p5_w1 rbl_op0_0000_s0p5_w1 0 {C_RBL}
cref_op0_0000_s0p5_w1 ref_op0_0000_s0p5_w1 0 {C_RBL}   $ ASSUMPTION: ideal matched dummy load
XMWR_op0_0000_s0p5_w1_0 sn_op0_0000_s0p5_w1_0 wwl_op0_0000_s0p5_w1 wbl_op0_0000_s0p5_w1 0 sky130_fd_pr__nfet_01v8 L=0.15 W=0.42 nf=1 ad=0.1218 as=0.1218 pd=1.42 ps=1.42 nrd=0.69047619047619  nrs=0.69047619047619 sa=0 sb=0 sd=0 mult=1 m=1
XMRD_op0_0000_s0p5_w1_0 rbl_op0_0000_s0p5_w1 sn_op0_0000_s0p5_w1_0 rwls_op0_0000_s0p5_w1 0 sky130_fd_pr__nfet_01v8 L=0.15 W=0.42 nf=1 ad=0.1218 as=0.1218 pd=1.42 ps=1.42 nrd=0.69047619047619  nrs=0.69047619047619 sa=0 sb=0 sd=0 mult=1 m=1
csn_op0_0000_s0p5_w1_0 sn_op0_0000_s0p5_w1_0 0 {C_SN}
XMWR_op0_0000_s0p5_w1_1 sn_op0_0000_s0p5_w1_1 wwl_des wbl_op0_0000_s0p5_w1 0 sky130_fd_pr__nfet_01v8 L=0.15 W=0.42 nf=1 ad=0.1218 as=0.1218 pd=1.42 ps=1.42 nrd=0.69047619047619  nrs=0.69047619047619 sa=0 sb=0 sd=0 mult=1 m=1
XMRD_op0_0000_s0p5_w1_1 rbl_op0_0000_s0p5_w1 sn_op0_0000_s0p5_w1_1 rwl_des 0 sky130_fd_pr__nfet_01v8 L=0.15 W=0.42 nf=1 ad=0.1218 as=0.1218 pd=1.42 ps=1.42 nrd=0.69047619047619  nrs=0.69047619047619 sa=0 sb=0 sd=0 mult=1 m=1
csn_op0_0000_s0p5_w1_1 sn_op0_0000_s0p5_w1_1 0 {C_SN}
XMWR_op0_0000_s0p5_w1_2 sn_op0_0000_s0p5_w1_2 wwl_des wbl_op0_0000_s0p5_w1 0 sky130_fd_pr__nfet_01v8 L=0.15 W=0.42 nf=1 ad=0.1218 as=0.1218 pd=1.42 ps=1.42 nrd=0.69047619047619  nrs=0.69047619047619 sa=0 sb=0 sd=0 mult=1 m=1
XMRD_op0_0000_s0p5_w1_2 rbl_op0_0000_s0p5_w1 sn_op0_0000_s0p5_w1_2 rwl_des 0 sky130_fd_pr__nfet_01v8 L=0.15 W=0.42 nf=1 ad=0.1218 as=0.1218 pd=1.42 ps=1.42 nrd=0.69047619047619  nrs=0.69047619047619 sa=0 sb=0 sd=0 mult=1 m=1
csn_op0_0000_s0p5_w1_2 sn_op0_0000_s0p5_w1_2 0 {C_SN}
XMWR_op0_0000_s0p5_w1_3 sn_op0_0000_s0p5_w1_3 wwl_des wbl_op0_0000_s0p5_w1 0 sky130_fd_pr__nfet_01v8 L=0.15 W=0.42 nf=1 ad=0.1218 as=0.1218 pd=1.42 ps=1.42 nrd=0.69047619047619  nrs=0.69047619047619 sa=0 sb=0 sd=0 mult=1 m=1
XMRD_op0_0000_s0p5_w1_3 rbl_op0_0000_s0p5_w1 sn_op0_0000_s0p5_w1_3 rwl_des 0 sky130_fd_pr__nfet_01v8 L=0.15 W=0.42 nf=1 ad=0.1218 as=0.1218 pd=1.42 ps=1.42 nrd=0.69047619047619  nrs=0.69047619047619 sa=0 sb=0 sd=0 mult=1 m=1
csn_op0_0000_s0p5_w1_3 sn_op0_0000_s0p5_w1_3 0 {C_SN}
XMN1_op0_0000_s0p5_w1 rbl_op0_0000_s0p5_w1 ref_op0_0000_s0p5_w1 vn_op0_0000_s0p5_w1 0 sky130_fd_pr__nfet_01v8 L=0.15 W=1 nf=1 ad=0.29 as=0.29 pd=2.58 ps=2.58 mult=1 m=1
XMN2_op0_0000_s0p5_w1 ref_op0_0000_s0p5_w1 rbl_op0_0000_s0p5_w1 vn_op0_0000_s0p5_w1 0 sky130_fd_pr__nfet_01v8 L=0.15 W=1 nf=1 ad=0.29 as=0.29 pd=2.58 ps=2.58 mult=1 m=1
XMP1_op0_0000_s0p5_w1 rbl_op0_0000_s0p5_w1 ref_op0_0000_s0p5_w1 vp_op0_0000_s0p5_w1 vdd sky130_fd_pr__pfet_01v8 L=0.15 W=2 nf=1 ad=0.58 as=0.58 pd=4.58 ps=4.58 mult=1 m=1
XMP2_op0_0000_s0p5_w1 ref_op0_0000_s0p5_w1 rbl_op0_0000_s0p5_w1 vp_op0_0000_s0p5_w1 vdd sky130_fd_pr__pfet_01v8 L=0.15 W=2 nf=1 ad=0.58 as=0.58 pd=4.58 ps=4.58 mult=1 m=1
XMNF_op0_0000_s0p5_w1 vn_op0_0000_s0p5_w1 en_op0_0000_s0p5_w1 0 0 sky130_fd_pr__nfet_01v8 L=0.15 W=2 nf=1 ad=0.58 as=0.58 pd=4.58 ps=4.58 mult=1 m=1
XMPH_op0_0000_s0p5_w1 vp_op0_0000_s0p5_w1 enb_op0_0000_s0p5_w1 vdd vdd sky130_fd_pr__pfet_01v8 L=0.15 W=4 nf=1 ad=1.16 as=1.16 pd=8.58 ps=8.58 mult=1 m=1
bd_op0_0000_s0p5_w1 d_op0_0000_s0p5_w1 0 v=v(rbl_op0_0000_s0p5_w1)-v(ref_op0_0000_s0p5_w1)

* ---- instance 183: op0_0000_s0p5_w2 (t_en 4.5 ns, WWL 5.5..7.5 ns, release 9.5 ns) ----
ven_op0_0000_s0p5_w2  en_op0_0000_s0p5_w2  0 pwl(0 0 4.5000e-09 0 4.6000e-09 {VDD} 9.5000e-09 {VDD} 9.6000e-09 0)
venb_op0_0000_s0p5_w2 enb_op0_0000_s0p5_w2 0 pwl(0 {VDD} 4.5000e-09 {VDD} 4.6000e-09 0 9.5000e-09 0 9.6000e-09 {VDD})
vrs_op0_0000_s0p5_w2  rwls_op0_0000_s0p5_w2 0 pwl(0 {VDD} {T_READ} {VDD} {T_READ+TEDGE} 0 9.5000e-09 0 9.6000e-09 {VDD})
vww_op0_0000_s0p5_w2  wwl_op0_0000_s0p5_w2 0 pwl(0 0 5.5000e-09 0 5.6000e-09 {VDD} 7.5000e-09 {VDD} 7.6000e-09 0)
vwc_op0_0000_s0p5_w2  wbc_op0_0000_s0p5_w2 0 pwl(0 0 5.5000e-09 0 5.6000e-09 {VDD} 9.5000e-09 {VDD} 9.6000e-09 0)
swb_op0_0000_s0p5_w2 ref_op0_0000_s0p5_w2 wbl_op0_0000_s0p5_w2 wbc_op0_0000_s0p5_w2 0 swwbl
cwbl_op0_0000_s0p5_w2 wbl_op0_0000_s0p5_w2 0 {C_WBL}
spa_op0_0000_s0p5_w2 prea rbl_op0_0000_s0p5_w2 ctl 0 swpre
spr_op0_0000_s0p5_w2 pref ref_op0_0000_s0p5_w2 ctl 0 swpre
crbl_op0_0000_s0p5_w2 rbl_op0_0000_s0p5_w2 0 {C_RBL}
cref_op0_0000_s0p5_w2 ref_op0_0000_s0p5_w2 0 {C_RBL}   $ ASSUMPTION: ideal matched dummy load
XMWR_op0_0000_s0p5_w2_0 sn_op0_0000_s0p5_w2_0 wwl_op0_0000_s0p5_w2 wbl_op0_0000_s0p5_w2 0 sky130_fd_pr__nfet_01v8 L=0.15 W=0.42 nf=1 ad=0.1218 as=0.1218 pd=1.42 ps=1.42 nrd=0.69047619047619  nrs=0.69047619047619 sa=0 sb=0 sd=0 mult=1 m=1
XMRD_op0_0000_s0p5_w2_0 rbl_op0_0000_s0p5_w2 sn_op0_0000_s0p5_w2_0 rwls_op0_0000_s0p5_w2 0 sky130_fd_pr__nfet_01v8 L=0.15 W=0.42 nf=1 ad=0.1218 as=0.1218 pd=1.42 ps=1.42 nrd=0.69047619047619  nrs=0.69047619047619 sa=0 sb=0 sd=0 mult=1 m=1
csn_op0_0000_s0p5_w2_0 sn_op0_0000_s0p5_w2_0 0 {C_SN}
XMWR_op0_0000_s0p5_w2_1 sn_op0_0000_s0p5_w2_1 wwl_des wbl_op0_0000_s0p5_w2 0 sky130_fd_pr__nfet_01v8 L=0.15 W=0.42 nf=1 ad=0.1218 as=0.1218 pd=1.42 ps=1.42 nrd=0.69047619047619  nrs=0.69047619047619 sa=0 sb=0 sd=0 mult=1 m=1
XMRD_op0_0000_s0p5_w2_1 rbl_op0_0000_s0p5_w2 sn_op0_0000_s0p5_w2_1 rwl_des 0 sky130_fd_pr__nfet_01v8 L=0.15 W=0.42 nf=1 ad=0.1218 as=0.1218 pd=1.42 ps=1.42 nrd=0.69047619047619  nrs=0.69047619047619 sa=0 sb=0 sd=0 mult=1 m=1
csn_op0_0000_s0p5_w2_1 sn_op0_0000_s0p5_w2_1 0 {C_SN}
XMWR_op0_0000_s0p5_w2_2 sn_op0_0000_s0p5_w2_2 wwl_des wbl_op0_0000_s0p5_w2 0 sky130_fd_pr__nfet_01v8 L=0.15 W=0.42 nf=1 ad=0.1218 as=0.1218 pd=1.42 ps=1.42 nrd=0.69047619047619  nrs=0.69047619047619 sa=0 sb=0 sd=0 mult=1 m=1
XMRD_op0_0000_s0p5_w2_2 rbl_op0_0000_s0p5_w2 sn_op0_0000_s0p5_w2_2 rwl_des 0 sky130_fd_pr__nfet_01v8 L=0.15 W=0.42 nf=1 ad=0.1218 as=0.1218 pd=1.42 ps=1.42 nrd=0.69047619047619  nrs=0.69047619047619 sa=0 sb=0 sd=0 mult=1 m=1
csn_op0_0000_s0p5_w2_2 sn_op0_0000_s0p5_w2_2 0 {C_SN}
XMWR_op0_0000_s0p5_w2_3 sn_op0_0000_s0p5_w2_3 wwl_des wbl_op0_0000_s0p5_w2 0 sky130_fd_pr__nfet_01v8 L=0.15 W=0.42 nf=1 ad=0.1218 as=0.1218 pd=1.42 ps=1.42 nrd=0.69047619047619  nrs=0.69047619047619 sa=0 sb=0 sd=0 mult=1 m=1
XMRD_op0_0000_s0p5_w2_3 rbl_op0_0000_s0p5_w2 sn_op0_0000_s0p5_w2_3 rwl_des 0 sky130_fd_pr__nfet_01v8 L=0.15 W=0.42 nf=1 ad=0.1218 as=0.1218 pd=1.42 ps=1.42 nrd=0.69047619047619  nrs=0.69047619047619 sa=0 sb=0 sd=0 mult=1 m=1
csn_op0_0000_s0p5_w2_3 sn_op0_0000_s0p5_w2_3 0 {C_SN}
XMN1_op0_0000_s0p5_w2 rbl_op0_0000_s0p5_w2 ref_op0_0000_s0p5_w2 vn_op0_0000_s0p5_w2 0 sky130_fd_pr__nfet_01v8 L=0.15 W=1 nf=1 ad=0.29 as=0.29 pd=2.58 ps=2.58 mult=1 m=1
XMN2_op0_0000_s0p5_w2 ref_op0_0000_s0p5_w2 rbl_op0_0000_s0p5_w2 vn_op0_0000_s0p5_w2 0 sky130_fd_pr__nfet_01v8 L=0.15 W=1 nf=1 ad=0.29 as=0.29 pd=2.58 ps=2.58 mult=1 m=1
XMP1_op0_0000_s0p5_w2 rbl_op0_0000_s0p5_w2 ref_op0_0000_s0p5_w2 vp_op0_0000_s0p5_w2 vdd sky130_fd_pr__pfet_01v8 L=0.15 W=2 nf=1 ad=0.58 as=0.58 pd=4.58 ps=4.58 mult=1 m=1
XMP2_op0_0000_s0p5_w2 ref_op0_0000_s0p5_w2 rbl_op0_0000_s0p5_w2 vp_op0_0000_s0p5_w2 vdd sky130_fd_pr__pfet_01v8 L=0.15 W=2 nf=1 ad=0.58 as=0.58 pd=4.58 ps=4.58 mult=1 m=1
XMNF_op0_0000_s0p5_w2 vn_op0_0000_s0p5_w2 en_op0_0000_s0p5_w2 0 0 sky130_fd_pr__nfet_01v8 L=0.15 W=2 nf=1 ad=0.58 as=0.58 pd=4.58 ps=4.58 mult=1 m=1
XMPH_op0_0000_s0p5_w2 vp_op0_0000_s0p5_w2 enb_op0_0000_s0p5_w2 vdd vdd sky130_fd_pr__pfet_01v8 L=0.15 W=4 nf=1 ad=1.16 as=1.16 pd=8.58 ps=8.58 mult=1 m=1
bd_op0_0000_s0p5_w2 d_op0_0000_s0p5_w2 0 v=v(rbl_op0_0000_s0p5_w2)-v(ref_op0_0000_s0p5_w2)

* ---- instance 184: op0_0000_s0p5_w3 (t_en 4.5 ns, WWL 5.5..8.5 ns, release 10.5 ns) ----
ven_op0_0000_s0p5_w3  en_op0_0000_s0p5_w3  0 pwl(0 0 4.5000e-09 0 4.6000e-09 {VDD} 1.0500e-08 {VDD} 1.0600e-08 0)
venb_op0_0000_s0p5_w3 enb_op0_0000_s0p5_w3 0 pwl(0 {VDD} 4.5000e-09 {VDD} 4.6000e-09 0 1.0500e-08 0 1.0600e-08 {VDD})
vrs_op0_0000_s0p5_w3  rwls_op0_0000_s0p5_w3 0 pwl(0 {VDD} {T_READ} {VDD} {T_READ+TEDGE} 0 1.0500e-08 0 1.0600e-08 {VDD})
vww_op0_0000_s0p5_w3  wwl_op0_0000_s0p5_w3 0 pwl(0 0 5.5000e-09 0 5.6000e-09 {VDD} 8.5000e-09 {VDD} 8.6000e-09 0)
vwc_op0_0000_s0p5_w3  wbc_op0_0000_s0p5_w3 0 pwl(0 0 5.5000e-09 0 5.6000e-09 {VDD} 1.0500e-08 {VDD} 1.0600e-08 0)
swb_op0_0000_s0p5_w3 ref_op0_0000_s0p5_w3 wbl_op0_0000_s0p5_w3 wbc_op0_0000_s0p5_w3 0 swwbl
cwbl_op0_0000_s0p5_w3 wbl_op0_0000_s0p5_w3 0 {C_WBL}
spa_op0_0000_s0p5_w3 prea rbl_op0_0000_s0p5_w3 ctl 0 swpre
spr_op0_0000_s0p5_w3 pref ref_op0_0000_s0p5_w3 ctl 0 swpre
crbl_op0_0000_s0p5_w3 rbl_op0_0000_s0p5_w3 0 {C_RBL}
cref_op0_0000_s0p5_w3 ref_op0_0000_s0p5_w3 0 {C_RBL}   $ ASSUMPTION: ideal matched dummy load
XMWR_op0_0000_s0p5_w3_0 sn_op0_0000_s0p5_w3_0 wwl_op0_0000_s0p5_w3 wbl_op0_0000_s0p5_w3 0 sky130_fd_pr__nfet_01v8 L=0.15 W=0.42 nf=1 ad=0.1218 as=0.1218 pd=1.42 ps=1.42 nrd=0.69047619047619  nrs=0.69047619047619 sa=0 sb=0 sd=0 mult=1 m=1
XMRD_op0_0000_s0p5_w3_0 rbl_op0_0000_s0p5_w3 sn_op0_0000_s0p5_w3_0 rwls_op0_0000_s0p5_w3 0 sky130_fd_pr__nfet_01v8 L=0.15 W=0.42 nf=1 ad=0.1218 as=0.1218 pd=1.42 ps=1.42 nrd=0.69047619047619  nrs=0.69047619047619 sa=0 sb=0 sd=0 mult=1 m=1
csn_op0_0000_s0p5_w3_0 sn_op0_0000_s0p5_w3_0 0 {C_SN}
XMWR_op0_0000_s0p5_w3_1 sn_op0_0000_s0p5_w3_1 wwl_des wbl_op0_0000_s0p5_w3 0 sky130_fd_pr__nfet_01v8 L=0.15 W=0.42 nf=1 ad=0.1218 as=0.1218 pd=1.42 ps=1.42 nrd=0.69047619047619  nrs=0.69047619047619 sa=0 sb=0 sd=0 mult=1 m=1
XMRD_op0_0000_s0p5_w3_1 rbl_op0_0000_s0p5_w3 sn_op0_0000_s0p5_w3_1 rwl_des 0 sky130_fd_pr__nfet_01v8 L=0.15 W=0.42 nf=1 ad=0.1218 as=0.1218 pd=1.42 ps=1.42 nrd=0.69047619047619  nrs=0.69047619047619 sa=0 sb=0 sd=0 mult=1 m=1
csn_op0_0000_s0p5_w3_1 sn_op0_0000_s0p5_w3_1 0 {C_SN}
XMWR_op0_0000_s0p5_w3_2 sn_op0_0000_s0p5_w3_2 wwl_des wbl_op0_0000_s0p5_w3 0 sky130_fd_pr__nfet_01v8 L=0.15 W=0.42 nf=1 ad=0.1218 as=0.1218 pd=1.42 ps=1.42 nrd=0.69047619047619  nrs=0.69047619047619 sa=0 sb=0 sd=0 mult=1 m=1
XMRD_op0_0000_s0p5_w3_2 rbl_op0_0000_s0p5_w3 sn_op0_0000_s0p5_w3_2 rwl_des 0 sky130_fd_pr__nfet_01v8 L=0.15 W=0.42 nf=1 ad=0.1218 as=0.1218 pd=1.42 ps=1.42 nrd=0.69047619047619  nrs=0.69047619047619 sa=0 sb=0 sd=0 mult=1 m=1
csn_op0_0000_s0p5_w3_2 sn_op0_0000_s0p5_w3_2 0 {C_SN}
XMWR_op0_0000_s0p5_w3_3 sn_op0_0000_s0p5_w3_3 wwl_des wbl_op0_0000_s0p5_w3 0 sky130_fd_pr__nfet_01v8 L=0.15 W=0.42 nf=1 ad=0.1218 as=0.1218 pd=1.42 ps=1.42 nrd=0.69047619047619  nrs=0.69047619047619 sa=0 sb=0 sd=0 mult=1 m=1
XMRD_op0_0000_s0p5_w3_3 rbl_op0_0000_s0p5_w3 sn_op0_0000_s0p5_w3_3 rwl_des 0 sky130_fd_pr__nfet_01v8 L=0.15 W=0.42 nf=1 ad=0.1218 as=0.1218 pd=1.42 ps=1.42 nrd=0.69047619047619  nrs=0.69047619047619 sa=0 sb=0 sd=0 mult=1 m=1
csn_op0_0000_s0p5_w3_3 sn_op0_0000_s0p5_w3_3 0 {C_SN}
XMN1_op0_0000_s0p5_w3 rbl_op0_0000_s0p5_w3 ref_op0_0000_s0p5_w3 vn_op0_0000_s0p5_w3 0 sky130_fd_pr__nfet_01v8 L=0.15 W=1 nf=1 ad=0.29 as=0.29 pd=2.58 ps=2.58 mult=1 m=1
XMN2_op0_0000_s0p5_w3 ref_op0_0000_s0p5_w3 rbl_op0_0000_s0p5_w3 vn_op0_0000_s0p5_w3 0 sky130_fd_pr__nfet_01v8 L=0.15 W=1 nf=1 ad=0.29 as=0.29 pd=2.58 ps=2.58 mult=1 m=1
XMP1_op0_0000_s0p5_w3 rbl_op0_0000_s0p5_w3 ref_op0_0000_s0p5_w3 vp_op0_0000_s0p5_w3 vdd sky130_fd_pr__pfet_01v8 L=0.15 W=2 nf=1 ad=0.58 as=0.58 pd=4.58 ps=4.58 mult=1 m=1
XMP2_op0_0000_s0p5_w3 ref_op0_0000_s0p5_w3 rbl_op0_0000_s0p5_w3 vp_op0_0000_s0p5_w3 vdd sky130_fd_pr__pfet_01v8 L=0.15 W=2 nf=1 ad=0.58 as=0.58 pd=4.58 ps=4.58 mult=1 m=1
XMNF_op0_0000_s0p5_w3 vn_op0_0000_s0p5_w3 en_op0_0000_s0p5_w3 0 0 sky130_fd_pr__nfet_01v8 L=0.15 W=2 nf=1 ad=0.58 as=0.58 pd=4.58 ps=4.58 mult=1 m=1
XMPH_op0_0000_s0p5_w3 vp_op0_0000_s0p5_w3 enb_op0_0000_s0p5_w3 vdd vdd sky130_fd_pr__pfet_01v8 L=0.15 W=4 nf=1 ad=1.16 as=1.16 pd=8.58 ps=8.58 mult=1 m=1
bd_op0_0000_s0p5_w3 d_op0_0000_s0p5_w3 0 v=v(rbl_op0_0000_s0p5_w3)-v(ref_op0_0000_s0p5_w3)

* ---- instance 185: op0_0000_s0p5_w5 (t_en 4.5 ns, WWL 5.5..10.5 ns, release 12.5 ns) ----
ven_op0_0000_s0p5_w5  en_op0_0000_s0p5_w5  0 pwl(0 0 4.5000e-09 0 4.6000e-09 {VDD} 1.2500e-08 {VDD} 1.2600e-08 0)
venb_op0_0000_s0p5_w5 enb_op0_0000_s0p5_w5 0 pwl(0 {VDD} 4.5000e-09 {VDD} 4.6000e-09 0 1.2500e-08 0 1.2600e-08 {VDD})
vrs_op0_0000_s0p5_w5  rwls_op0_0000_s0p5_w5 0 pwl(0 {VDD} {T_READ} {VDD} {T_READ+TEDGE} 0 1.2500e-08 0 1.2600e-08 {VDD})
vww_op0_0000_s0p5_w5  wwl_op0_0000_s0p5_w5 0 pwl(0 0 5.5000e-09 0 5.6000e-09 {VDD} 1.0500e-08 {VDD} 1.0600e-08 0)
vwc_op0_0000_s0p5_w5  wbc_op0_0000_s0p5_w5 0 pwl(0 0 5.5000e-09 0 5.6000e-09 {VDD} 1.2500e-08 {VDD} 1.2600e-08 0)
swb_op0_0000_s0p5_w5 ref_op0_0000_s0p5_w5 wbl_op0_0000_s0p5_w5 wbc_op0_0000_s0p5_w5 0 swwbl
cwbl_op0_0000_s0p5_w5 wbl_op0_0000_s0p5_w5 0 {C_WBL}
spa_op0_0000_s0p5_w5 prea rbl_op0_0000_s0p5_w5 ctl 0 swpre
spr_op0_0000_s0p5_w5 pref ref_op0_0000_s0p5_w5 ctl 0 swpre
crbl_op0_0000_s0p5_w5 rbl_op0_0000_s0p5_w5 0 {C_RBL}
cref_op0_0000_s0p5_w5 ref_op0_0000_s0p5_w5 0 {C_RBL}   $ ASSUMPTION: ideal matched dummy load
XMWR_op0_0000_s0p5_w5_0 sn_op0_0000_s0p5_w5_0 wwl_op0_0000_s0p5_w5 wbl_op0_0000_s0p5_w5 0 sky130_fd_pr__nfet_01v8 L=0.15 W=0.42 nf=1 ad=0.1218 as=0.1218 pd=1.42 ps=1.42 nrd=0.69047619047619  nrs=0.69047619047619 sa=0 sb=0 sd=0 mult=1 m=1
XMRD_op0_0000_s0p5_w5_0 rbl_op0_0000_s0p5_w5 sn_op0_0000_s0p5_w5_0 rwls_op0_0000_s0p5_w5 0 sky130_fd_pr__nfet_01v8 L=0.15 W=0.42 nf=1 ad=0.1218 as=0.1218 pd=1.42 ps=1.42 nrd=0.69047619047619  nrs=0.69047619047619 sa=0 sb=0 sd=0 mult=1 m=1
csn_op0_0000_s0p5_w5_0 sn_op0_0000_s0p5_w5_0 0 {C_SN}
XMWR_op0_0000_s0p5_w5_1 sn_op0_0000_s0p5_w5_1 wwl_des wbl_op0_0000_s0p5_w5 0 sky130_fd_pr__nfet_01v8 L=0.15 W=0.42 nf=1 ad=0.1218 as=0.1218 pd=1.42 ps=1.42 nrd=0.69047619047619  nrs=0.69047619047619 sa=0 sb=0 sd=0 mult=1 m=1
XMRD_op0_0000_s0p5_w5_1 rbl_op0_0000_s0p5_w5 sn_op0_0000_s0p5_w5_1 rwl_des 0 sky130_fd_pr__nfet_01v8 L=0.15 W=0.42 nf=1 ad=0.1218 as=0.1218 pd=1.42 ps=1.42 nrd=0.69047619047619  nrs=0.69047619047619 sa=0 sb=0 sd=0 mult=1 m=1
csn_op0_0000_s0p5_w5_1 sn_op0_0000_s0p5_w5_1 0 {C_SN}
XMWR_op0_0000_s0p5_w5_2 sn_op0_0000_s0p5_w5_2 wwl_des wbl_op0_0000_s0p5_w5 0 sky130_fd_pr__nfet_01v8 L=0.15 W=0.42 nf=1 ad=0.1218 as=0.1218 pd=1.42 ps=1.42 nrd=0.69047619047619  nrs=0.69047619047619 sa=0 sb=0 sd=0 mult=1 m=1
XMRD_op0_0000_s0p5_w5_2 rbl_op0_0000_s0p5_w5 sn_op0_0000_s0p5_w5_2 rwl_des 0 sky130_fd_pr__nfet_01v8 L=0.15 W=0.42 nf=1 ad=0.1218 as=0.1218 pd=1.42 ps=1.42 nrd=0.69047619047619  nrs=0.69047619047619 sa=0 sb=0 sd=0 mult=1 m=1
csn_op0_0000_s0p5_w5_2 sn_op0_0000_s0p5_w5_2 0 {C_SN}
XMWR_op0_0000_s0p5_w5_3 sn_op0_0000_s0p5_w5_3 wwl_des wbl_op0_0000_s0p5_w5 0 sky130_fd_pr__nfet_01v8 L=0.15 W=0.42 nf=1 ad=0.1218 as=0.1218 pd=1.42 ps=1.42 nrd=0.69047619047619  nrs=0.69047619047619 sa=0 sb=0 sd=0 mult=1 m=1
XMRD_op0_0000_s0p5_w5_3 rbl_op0_0000_s0p5_w5 sn_op0_0000_s0p5_w5_3 rwl_des 0 sky130_fd_pr__nfet_01v8 L=0.15 W=0.42 nf=1 ad=0.1218 as=0.1218 pd=1.42 ps=1.42 nrd=0.69047619047619  nrs=0.69047619047619 sa=0 sb=0 sd=0 mult=1 m=1
csn_op0_0000_s0p5_w5_3 sn_op0_0000_s0p5_w5_3 0 {C_SN}
XMN1_op0_0000_s0p5_w5 rbl_op0_0000_s0p5_w5 ref_op0_0000_s0p5_w5 vn_op0_0000_s0p5_w5 0 sky130_fd_pr__nfet_01v8 L=0.15 W=1 nf=1 ad=0.29 as=0.29 pd=2.58 ps=2.58 mult=1 m=1
XMN2_op0_0000_s0p5_w5 ref_op0_0000_s0p5_w5 rbl_op0_0000_s0p5_w5 vn_op0_0000_s0p5_w5 0 sky130_fd_pr__nfet_01v8 L=0.15 W=1 nf=1 ad=0.29 as=0.29 pd=2.58 ps=2.58 mult=1 m=1
XMP1_op0_0000_s0p5_w5 rbl_op0_0000_s0p5_w5 ref_op0_0000_s0p5_w5 vp_op0_0000_s0p5_w5 vdd sky130_fd_pr__pfet_01v8 L=0.15 W=2 nf=1 ad=0.58 as=0.58 pd=4.58 ps=4.58 mult=1 m=1
XMP2_op0_0000_s0p5_w5 ref_op0_0000_s0p5_w5 rbl_op0_0000_s0p5_w5 vp_op0_0000_s0p5_w5 vdd sky130_fd_pr__pfet_01v8 L=0.15 W=2 nf=1 ad=0.58 as=0.58 pd=4.58 ps=4.58 mult=1 m=1
XMNF_op0_0000_s0p5_w5 vn_op0_0000_s0p5_w5 en_op0_0000_s0p5_w5 0 0 sky130_fd_pr__nfet_01v8 L=0.15 W=2 nf=1 ad=0.58 as=0.58 pd=4.58 ps=4.58 mult=1 m=1
XMPH_op0_0000_s0p5_w5 vp_op0_0000_s0p5_w5 enb_op0_0000_s0p5_w5 vdd vdd sky130_fd_pr__pfet_01v8 L=0.15 W=4 nf=1 ad=1.16 as=1.16 pd=8.58 ps=8.58 mult=1 m=1
bd_op0_0000_s0p5_w5 d_op0_0000_s0p5_w5 0 v=v(rbl_op0_0000_s0p5_w5)-v(ref_op0_0000_s0p5_w5)

* ---- instance 186: op0_0000_s0p5_w7p5 (t_en 4.5 ns, WWL 5.5..13 ns, release 15 ns) ----
ven_op0_0000_s0p5_w7p5  en_op0_0000_s0p5_w7p5  0 pwl(0 0 4.5000e-09 0 4.6000e-09 {VDD} 1.5000e-08 {VDD} 1.5100e-08 0)
venb_op0_0000_s0p5_w7p5 enb_op0_0000_s0p5_w7p5 0 pwl(0 {VDD} 4.5000e-09 {VDD} 4.6000e-09 0 1.5000e-08 0 1.5100e-08 {VDD})
vrs_op0_0000_s0p5_w7p5  rwls_op0_0000_s0p5_w7p5 0 pwl(0 {VDD} {T_READ} {VDD} {T_READ+TEDGE} 0 1.5000e-08 0 1.5100e-08 {VDD})
vww_op0_0000_s0p5_w7p5  wwl_op0_0000_s0p5_w7p5 0 pwl(0 0 5.5000e-09 0 5.6000e-09 {VDD} 1.3000e-08 {VDD} 1.3100e-08 0)
vwc_op0_0000_s0p5_w7p5  wbc_op0_0000_s0p5_w7p5 0 pwl(0 0 5.5000e-09 0 5.6000e-09 {VDD} 1.5000e-08 {VDD} 1.5100e-08 0)
swb_op0_0000_s0p5_w7p5 ref_op0_0000_s0p5_w7p5 wbl_op0_0000_s0p5_w7p5 wbc_op0_0000_s0p5_w7p5 0 swwbl
cwbl_op0_0000_s0p5_w7p5 wbl_op0_0000_s0p5_w7p5 0 {C_WBL}
spa_op0_0000_s0p5_w7p5 prea rbl_op0_0000_s0p5_w7p5 ctl 0 swpre
spr_op0_0000_s0p5_w7p5 pref ref_op0_0000_s0p5_w7p5 ctl 0 swpre
crbl_op0_0000_s0p5_w7p5 rbl_op0_0000_s0p5_w7p5 0 {C_RBL}
cref_op0_0000_s0p5_w7p5 ref_op0_0000_s0p5_w7p5 0 {C_RBL}   $ ASSUMPTION: ideal matched dummy load
XMWR_op0_0000_s0p5_w7p5_0 sn_op0_0000_s0p5_w7p5_0 wwl_op0_0000_s0p5_w7p5 wbl_op0_0000_s0p5_w7p5 0 sky130_fd_pr__nfet_01v8 L=0.15 W=0.42 nf=1 ad=0.1218 as=0.1218 pd=1.42 ps=1.42 nrd=0.69047619047619  nrs=0.69047619047619 sa=0 sb=0 sd=0 mult=1 m=1
XMRD_op0_0000_s0p5_w7p5_0 rbl_op0_0000_s0p5_w7p5 sn_op0_0000_s0p5_w7p5_0 rwls_op0_0000_s0p5_w7p5 0 sky130_fd_pr__nfet_01v8 L=0.15 W=0.42 nf=1 ad=0.1218 as=0.1218 pd=1.42 ps=1.42 nrd=0.69047619047619  nrs=0.69047619047619 sa=0 sb=0 sd=0 mult=1 m=1
csn_op0_0000_s0p5_w7p5_0 sn_op0_0000_s0p5_w7p5_0 0 {C_SN}
XMWR_op0_0000_s0p5_w7p5_1 sn_op0_0000_s0p5_w7p5_1 wwl_des wbl_op0_0000_s0p5_w7p5 0 sky130_fd_pr__nfet_01v8 L=0.15 W=0.42 nf=1 ad=0.1218 as=0.1218 pd=1.42 ps=1.42 nrd=0.69047619047619  nrs=0.69047619047619 sa=0 sb=0 sd=0 mult=1 m=1
XMRD_op0_0000_s0p5_w7p5_1 rbl_op0_0000_s0p5_w7p5 sn_op0_0000_s0p5_w7p5_1 rwl_des 0 sky130_fd_pr__nfet_01v8 L=0.15 W=0.42 nf=1 ad=0.1218 as=0.1218 pd=1.42 ps=1.42 nrd=0.69047619047619  nrs=0.69047619047619 sa=0 sb=0 sd=0 mult=1 m=1
csn_op0_0000_s0p5_w7p5_1 sn_op0_0000_s0p5_w7p5_1 0 {C_SN}
XMWR_op0_0000_s0p5_w7p5_2 sn_op0_0000_s0p5_w7p5_2 wwl_des wbl_op0_0000_s0p5_w7p5 0 sky130_fd_pr__nfet_01v8 L=0.15 W=0.42 nf=1 ad=0.1218 as=0.1218 pd=1.42 ps=1.42 nrd=0.69047619047619  nrs=0.69047619047619 sa=0 sb=0 sd=0 mult=1 m=1
XMRD_op0_0000_s0p5_w7p5_2 rbl_op0_0000_s0p5_w7p5 sn_op0_0000_s0p5_w7p5_2 rwl_des 0 sky130_fd_pr__nfet_01v8 L=0.15 W=0.42 nf=1 ad=0.1218 as=0.1218 pd=1.42 ps=1.42 nrd=0.69047619047619  nrs=0.69047619047619 sa=0 sb=0 sd=0 mult=1 m=1
csn_op0_0000_s0p5_w7p5_2 sn_op0_0000_s0p5_w7p5_2 0 {C_SN}
XMWR_op0_0000_s0p5_w7p5_3 sn_op0_0000_s0p5_w7p5_3 wwl_des wbl_op0_0000_s0p5_w7p5 0 sky130_fd_pr__nfet_01v8 L=0.15 W=0.42 nf=1 ad=0.1218 as=0.1218 pd=1.42 ps=1.42 nrd=0.69047619047619  nrs=0.69047619047619 sa=0 sb=0 sd=0 mult=1 m=1
XMRD_op0_0000_s0p5_w7p5_3 rbl_op0_0000_s0p5_w7p5 sn_op0_0000_s0p5_w7p5_3 rwl_des 0 sky130_fd_pr__nfet_01v8 L=0.15 W=0.42 nf=1 ad=0.1218 as=0.1218 pd=1.42 ps=1.42 nrd=0.69047619047619  nrs=0.69047619047619 sa=0 sb=0 sd=0 mult=1 m=1
csn_op0_0000_s0p5_w7p5_3 sn_op0_0000_s0p5_w7p5_3 0 {C_SN}
XMN1_op0_0000_s0p5_w7p5 rbl_op0_0000_s0p5_w7p5 ref_op0_0000_s0p5_w7p5 vn_op0_0000_s0p5_w7p5 0 sky130_fd_pr__nfet_01v8 L=0.15 W=1 nf=1 ad=0.29 as=0.29 pd=2.58 ps=2.58 mult=1 m=1
XMN2_op0_0000_s0p5_w7p5 ref_op0_0000_s0p5_w7p5 rbl_op0_0000_s0p5_w7p5 vn_op0_0000_s0p5_w7p5 0 sky130_fd_pr__nfet_01v8 L=0.15 W=1 nf=1 ad=0.29 as=0.29 pd=2.58 ps=2.58 mult=1 m=1
XMP1_op0_0000_s0p5_w7p5 rbl_op0_0000_s0p5_w7p5 ref_op0_0000_s0p5_w7p5 vp_op0_0000_s0p5_w7p5 vdd sky130_fd_pr__pfet_01v8 L=0.15 W=2 nf=1 ad=0.58 as=0.58 pd=4.58 ps=4.58 mult=1 m=1
XMP2_op0_0000_s0p5_w7p5 ref_op0_0000_s0p5_w7p5 rbl_op0_0000_s0p5_w7p5 vp_op0_0000_s0p5_w7p5 vdd sky130_fd_pr__pfet_01v8 L=0.15 W=2 nf=1 ad=0.58 as=0.58 pd=4.58 ps=4.58 mult=1 m=1
XMNF_op0_0000_s0p5_w7p5 vn_op0_0000_s0p5_w7p5 en_op0_0000_s0p5_w7p5 0 0 sky130_fd_pr__nfet_01v8 L=0.15 W=2 nf=1 ad=0.58 as=0.58 pd=4.58 ps=4.58 mult=1 m=1
XMPH_op0_0000_s0p5_w7p5 vp_op0_0000_s0p5_w7p5 enb_op0_0000_s0p5_w7p5 vdd vdd sky130_fd_pr__pfet_01v8 L=0.15 W=4 nf=1 ad=1.16 as=1.16 pd=8.58 ps=8.58 mult=1 m=1
bd_op0_0000_s0p5_w7p5 d_op0_0000_s0p5_w7p5 0 v=v(rbl_op0_0000_s0p5_w7p5)-v(ref_op0_0000_s0p5_w7p5)

* ---- instance 187: op0_0000_s0p5_w10 (t_en 4.5 ns, WWL 5.5..15.5 ns, release 17.5 ns) ----
ven_op0_0000_s0p5_w10  en_op0_0000_s0p5_w10  0 pwl(0 0 4.5000e-09 0 4.6000e-09 {VDD} 1.7500e-08 {VDD} 1.7600e-08 0)
venb_op0_0000_s0p5_w10 enb_op0_0000_s0p5_w10 0 pwl(0 {VDD} 4.5000e-09 {VDD} 4.6000e-09 0 1.7500e-08 0 1.7600e-08 {VDD})
vrs_op0_0000_s0p5_w10  rwls_op0_0000_s0p5_w10 0 pwl(0 {VDD} {T_READ} {VDD} {T_READ+TEDGE} 0 1.7500e-08 0 1.7600e-08 {VDD})
vww_op0_0000_s0p5_w10  wwl_op0_0000_s0p5_w10 0 pwl(0 0 5.5000e-09 0 5.6000e-09 {VDD} 1.5500e-08 {VDD} 1.5600e-08 0)
vwc_op0_0000_s0p5_w10  wbc_op0_0000_s0p5_w10 0 pwl(0 0 5.5000e-09 0 5.6000e-09 {VDD} 1.7500e-08 {VDD} 1.7600e-08 0)
swb_op0_0000_s0p5_w10 ref_op0_0000_s0p5_w10 wbl_op0_0000_s0p5_w10 wbc_op0_0000_s0p5_w10 0 swwbl
cwbl_op0_0000_s0p5_w10 wbl_op0_0000_s0p5_w10 0 {C_WBL}
spa_op0_0000_s0p5_w10 prea rbl_op0_0000_s0p5_w10 ctl 0 swpre
spr_op0_0000_s0p5_w10 pref ref_op0_0000_s0p5_w10 ctl 0 swpre
crbl_op0_0000_s0p5_w10 rbl_op0_0000_s0p5_w10 0 {C_RBL}
cref_op0_0000_s0p5_w10 ref_op0_0000_s0p5_w10 0 {C_RBL}   $ ASSUMPTION: ideal matched dummy load
XMWR_op0_0000_s0p5_w10_0 sn_op0_0000_s0p5_w10_0 wwl_op0_0000_s0p5_w10 wbl_op0_0000_s0p5_w10 0 sky130_fd_pr__nfet_01v8 L=0.15 W=0.42 nf=1 ad=0.1218 as=0.1218 pd=1.42 ps=1.42 nrd=0.69047619047619  nrs=0.69047619047619 sa=0 sb=0 sd=0 mult=1 m=1
XMRD_op0_0000_s0p5_w10_0 rbl_op0_0000_s0p5_w10 sn_op0_0000_s0p5_w10_0 rwls_op0_0000_s0p5_w10 0 sky130_fd_pr__nfet_01v8 L=0.15 W=0.42 nf=1 ad=0.1218 as=0.1218 pd=1.42 ps=1.42 nrd=0.69047619047619  nrs=0.69047619047619 sa=0 sb=0 sd=0 mult=1 m=1
csn_op0_0000_s0p5_w10_0 sn_op0_0000_s0p5_w10_0 0 {C_SN}
XMWR_op0_0000_s0p5_w10_1 sn_op0_0000_s0p5_w10_1 wwl_des wbl_op0_0000_s0p5_w10 0 sky130_fd_pr__nfet_01v8 L=0.15 W=0.42 nf=1 ad=0.1218 as=0.1218 pd=1.42 ps=1.42 nrd=0.69047619047619  nrs=0.69047619047619 sa=0 sb=0 sd=0 mult=1 m=1
XMRD_op0_0000_s0p5_w10_1 rbl_op0_0000_s0p5_w10 sn_op0_0000_s0p5_w10_1 rwl_des 0 sky130_fd_pr__nfet_01v8 L=0.15 W=0.42 nf=1 ad=0.1218 as=0.1218 pd=1.42 ps=1.42 nrd=0.69047619047619  nrs=0.69047619047619 sa=0 sb=0 sd=0 mult=1 m=1
csn_op0_0000_s0p5_w10_1 sn_op0_0000_s0p5_w10_1 0 {C_SN}
XMWR_op0_0000_s0p5_w10_2 sn_op0_0000_s0p5_w10_2 wwl_des wbl_op0_0000_s0p5_w10 0 sky130_fd_pr__nfet_01v8 L=0.15 W=0.42 nf=1 ad=0.1218 as=0.1218 pd=1.42 ps=1.42 nrd=0.69047619047619  nrs=0.69047619047619 sa=0 sb=0 sd=0 mult=1 m=1
XMRD_op0_0000_s0p5_w10_2 rbl_op0_0000_s0p5_w10 sn_op0_0000_s0p5_w10_2 rwl_des 0 sky130_fd_pr__nfet_01v8 L=0.15 W=0.42 nf=1 ad=0.1218 as=0.1218 pd=1.42 ps=1.42 nrd=0.69047619047619  nrs=0.69047619047619 sa=0 sb=0 sd=0 mult=1 m=1
csn_op0_0000_s0p5_w10_2 sn_op0_0000_s0p5_w10_2 0 {C_SN}
XMWR_op0_0000_s0p5_w10_3 sn_op0_0000_s0p5_w10_3 wwl_des wbl_op0_0000_s0p5_w10 0 sky130_fd_pr__nfet_01v8 L=0.15 W=0.42 nf=1 ad=0.1218 as=0.1218 pd=1.42 ps=1.42 nrd=0.69047619047619  nrs=0.69047619047619 sa=0 sb=0 sd=0 mult=1 m=1
XMRD_op0_0000_s0p5_w10_3 rbl_op0_0000_s0p5_w10 sn_op0_0000_s0p5_w10_3 rwl_des 0 sky130_fd_pr__nfet_01v8 L=0.15 W=0.42 nf=1 ad=0.1218 as=0.1218 pd=1.42 ps=1.42 nrd=0.69047619047619  nrs=0.69047619047619 sa=0 sb=0 sd=0 mult=1 m=1
csn_op0_0000_s0p5_w10_3 sn_op0_0000_s0p5_w10_3 0 {C_SN}
XMN1_op0_0000_s0p5_w10 rbl_op0_0000_s0p5_w10 ref_op0_0000_s0p5_w10 vn_op0_0000_s0p5_w10 0 sky130_fd_pr__nfet_01v8 L=0.15 W=1 nf=1 ad=0.29 as=0.29 pd=2.58 ps=2.58 mult=1 m=1
XMN2_op0_0000_s0p5_w10 ref_op0_0000_s0p5_w10 rbl_op0_0000_s0p5_w10 vn_op0_0000_s0p5_w10 0 sky130_fd_pr__nfet_01v8 L=0.15 W=1 nf=1 ad=0.29 as=0.29 pd=2.58 ps=2.58 mult=1 m=1
XMP1_op0_0000_s0p5_w10 rbl_op0_0000_s0p5_w10 ref_op0_0000_s0p5_w10 vp_op0_0000_s0p5_w10 vdd sky130_fd_pr__pfet_01v8 L=0.15 W=2 nf=1 ad=0.58 as=0.58 pd=4.58 ps=4.58 mult=1 m=1
XMP2_op0_0000_s0p5_w10 ref_op0_0000_s0p5_w10 rbl_op0_0000_s0p5_w10 vp_op0_0000_s0p5_w10 vdd sky130_fd_pr__pfet_01v8 L=0.15 W=2 nf=1 ad=0.58 as=0.58 pd=4.58 ps=4.58 mult=1 m=1
XMNF_op0_0000_s0p5_w10 vn_op0_0000_s0p5_w10 en_op0_0000_s0p5_w10 0 0 sky130_fd_pr__nfet_01v8 L=0.15 W=2 nf=1 ad=0.58 as=0.58 pd=4.58 ps=4.58 mult=1 m=1
XMPH_op0_0000_s0p5_w10 vp_op0_0000_s0p5_w10 enb_op0_0000_s0p5_w10 vdd vdd sky130_fd_pr__pfet_01v8 L=0.15 W=4 nf=1 ad=1.16 as=1.16 pd=8.58 ps=8.58 mult=1 m=1
bd_op0_0000_s0p5_w10 d_op0_0000_s0p5_w10 0 v=v(rbl_op0_0000_s0p5_w10)-v(ref_op0_0000_s0p5_w10)

* ---- instance 188: op0_0000_s0p5_w15 (t_en 4.5 ns, WWL 5.5..20.5 ns, release 22.5 ns) ----
ven_op0_0000_s0p5_w15  en_op0_0000_s0p5_w15  0 pwl(0 0 4.5000e-09 0 4.6000e-09 {VDD} 2.2500e-08 {VDD} 2.2600e-08 0)
venb_op0_0000_s0p5_w15 enb_op0_0000_s0p5_w15 0 pwl(0 {VDD} 4.5000e-09 {VDD} 4.6000e-09 0 2.2500e-08 0 2.2600e-08 {VDD})
vrs_op0_0000_s0p5_w15  rwls_op0_0000_s0p5_w15 0 pwl(0 {VDD} {T_READ} {VDD} {T_READ+TEDGE} 0 2.2500e-08 0 2.2600e-08 {VDD})
vww_op0_0000_s0p5_w15  wwl_op0_0000_s0p5_w15 0 pwl(0 0 5.5000e-09 0 5.6000e-09 {VDD} 2.0500e-08 {VDD} 2.0600e-08 0)
vwc_op0_0000_s0p5_w15  wbc_op0_0000_s0p5_w15 0 pwl(0 0 5.5000e-09 0 5.6000e-09 {VDD} 2.2500e-08 {VDD} 2.2600e-08 0)
swb_op0_0000_s0p5_w15 ref_op0_0000_s0p5_w15 wbl_op0_0000_s0p5_w15 wbc_op0_0000_s0p5_w15 0 swwbl
cwbl_op0_0000_s0p5_w15 wbl_op0_0000_s0p5_w15 0 {C_WBL}
spa_op0_0000_s0p5_w15 prea rbl_op0_0000_s0p5_w15 ctl 0 swpre
spr_op0_0000_s0p5_w15 pref ref_op0_0000_s0p5_w15 ctl 0 swpre
crbl_op0_0000_s0p5_w15 rbl_op0_0000_s0p5_w15 0 {C_RBL}
cref_op0_0000_s0p5_w15 ref_op0_0000_s0p5_w15 0 {C_RBL}   $ ASSUMPTION: ideal matched dummy load
XMWR_op0_0000_s0p5_w15_0 sn_op0_0000_s0p5_w15_0 wwl_op0_0000_s0p5_w15 wbl_op0_0000_s0p5_w15 0 sky130_fd_pr__nfet_01v8 L=0.15 W=0.42 nf=1 ad=0.1218 as=0.1218 pd=1.42 ps=1.42 nrd=0.69047619047619  nrs=0.69047619047619 sa=0 sb=0 sd=0 mult=1 m=1
XMRD_op0_0000_s0p5_w15_0 rbl_op0_0000_s0p5_w15 sn_op0_0000_s0p5_w15_0 rwls_op0_0000_s0p5_w15 0 sky130_fd_pr__nfet_01v8 L=0.15 W=0.42 nf=1 ad=0.1218 as=0.1218 pd=1.42 ps=1.42 nrd=0.69047619047619  nrs=0.69047619047619 sa=0 sb=0 sd=0 mult=1 m=1
csn_op0_0000_s0p5_w15_0 sn_op0_0000_s0p5_w15_0 0 {C_SN}
XMWR_op0_0000_s0p5_w15_1 sn_op0_0000_s0p5_w15_1 wwl_des wbl_op0_0000_s0p5_w15 0 sky130_fd_pr__nfet_01v8 L=0.15 W=0.42 nf=1 ad=0.1218 as=0.1218 pd=1.42 ps=1.42 nrd=0.69047619047619  nrs=0.69047619047619 sa=0 sb=0 sd=0 mult=1 m=1
XMRD_op0_0000_s0p5_w15_1 rbl_op0_0000_s0p5_w15 sn_op0_0000_s0p5_w15_1 rwl_des 0 sky130_fd_pr__nfet_01v8 L=0.15 W=0.42 nf=1 ad=0.1218 as=0.1218 pd=1.42 ps=1.42 nrd=0.69047619047619  nrs=0.69047619047619 sa=0 sb=0 sd=0 mult=1 m=1
csn_op0_0000_s0p5_w15_1 sn_op0_0000_s0p5_w15_1 0 {C_SN}
XMWR_op0_0000_s0p5_w15_2 sn_op0_0000_s0p5_w15_2 wwl_des wbl_op0_0000_s0p5_w15 0 sky130_fd_pr__nfet_01v8 L=0.15 W=0.42 nf=1 ad=0.1218 as=0.1218 pd=1.42 ps=1.42 nrd=0.69047619047619  nrs=0.69047619047619 sa=0 sb=0 sd=0 mult=1 m=1
XMRD_op0_0000_s0p5_w15_2 rbl_op0_0000_s0p5_w15 sn_op0_0000_s0p5_w15_2 rwl_des 0 sky130_fd_pr__nfet_01v8 L=0.15 W=0.42 nf=1 ad=0.1218 as=0.1218 pd=1.42 ps=1.42 nrd=0.69047619047619  nrs=0.69047619047619 sa=0 sb=0 sd=0 mult=1 m=1
csn_op0_0000_s0p5_w15_2 sn_op0_0000_s0p5_w15_2 0 {C_SN}
XMWR_op0_0000_s0p5_w15_3 sn_op0_0000_s0p5_w15_3 wwl_des wbl_op0_0000_s0p5_w15 0 sky130_fd_pr__nfet_01v8 L=0.15 W=0.42 nf=1 ad=0.1218 as=0.1218 pd=1.42 ps=1.42 nrd=0.69047619047619  nrs=0.69047619047619 sa=0 sb=0 sd=0 mult=1 m=1
XMRD_op0_0000_s0p5_w15_3 rbl_op0_0000_s0p5_w15 sn_op0_0000_s0p5_w15_3 rwl_des 0 sky130_fd_pr__nfet_01v8 L=0.15 W=0.42 nf=1 ad=0.1218 as=0.1218 pd=1.42 ps=1.42 nrd=0.69047619047619  nrs=0.69047619047619 sa=0 sb=0 sd=0 mult=1 m=1
csn_op0_0000_s0p5_w15_3 sn_op0_0000_s0p5_w15_3 0 {C_SN}
XMN1_op0_0000_s0p5_w15 rbl_op0_0000_s0p5_w15 ref_op0_0000_s0p5_w15 vn_op0_0000_s0p5_w15 0 sky130_fd_pr__nfet_01v8 L=0.15 W=1 nf=1 ad=0.29 as=0.29 pd=2.58 ps=2.58 mult=1 m=1
XMN2_op0_0000_s0p5_w15 ref_op0_0000_s0p5_w15 rbl_op0_0000_s0p5_w15 vn_op0_0000_s0p5_w15 0 sky130_fd_pr__nfet_01v8 L=0.15 W=1 nf=1 ad=0.29 as=0.29 pd=2.58 ps=2.58 mult=1 m=1
XMP1_op0_0000_s0p5_w15 rbl_op0_0000_s0p5_w15 ref_op0_0000_s0p5_w15 vp_op0_0000_s0p5_w15 vdd sky130_fd_pr__pfet_01v8 L=0.15 W=2 nf=1 ad=0.58 as=0.58 pd=4.58 ps=4.58 mult=1 m=1
XMP2_op0_0000_s0p5_w15 ref_op0_0000_s0p5_w15 rbl_op0_0000_s0p5_w15 vp_op0_0000_s0p5_w15 vdd sky130_fd_pr__pfet_01v8 L=0.15 W=2 nf=1 ad=0.58 as=0.58 pd=4.58 ps=4.58 mult=1 m=1
XMNF_op0_0000_s0p5_w15 vn_op0_0000_s0p5_w15 en_op0_0000_s0p5_w15 0 0 sky130_fd_pr__nfet_01v8 L=0.15 W=2 nf=1 ad=0.58 as=0.58 pd=4.58 ps=4.58 mult=1 m=1
XMPH_op0_0000_s0p5_w15 vp_op0_0000_s0p5_w15 enb_op0_0000_s0p5_w15 vdd vdd sky130_fd_pr__pfet_01v8 L=0.15 W=4 nf=1 ad=1.16 as=1.16 pd=8.58 ps=8.58 mult=1 m=1
bd_op0_0000_s0p5_w15 d_op0_0000_s0p5_w15 0 v=v(rbl_op0_0000_s0p5_w15)-v(ref_op0_0000_s0p5_w15)

* ---- instance 189: op0_0000_s0p5_w20 (t_en 4.5 ns, WWL 5.5..25.5 ns, release 27.5 ns) ----
ven_op0_0000_s0p5_w20  en_op0_0000_s0p5_w20  0 pwl(0 0 4.5000e-09 0 4.6000e-09 {VDD} 2.7500e-08 {VDD} 2.7600e-08 0)
venb_op0_0000_s0p5_w20 enb_op0_0000_s0p5_w20 0 pwl(0 {VDD} 4.5000e-09 {VDD} 4.6000e-09 0 2.7500e-08 0 2.7600e-08 {VDD})
vrs_op0_0000_s0p5_w20  rwls_op0_0000_s0p5_w20 0 pwl(0 {VDD} {T_READ} {VDD} {T_READ+TEDGE} 0 2.7500e-08 0 2.7600e-08 {VDD})
vww_op0_0000_s0p5_w20  wwl_op0_0000_s0p5_w20 0 pwl(0 0 5.5000e-09 0 5.6000e-09 {VDD} 2.5500e-08 {VDD} 2.5600e-08 0)
vwc_op0_0000_s0p5_w20  wbc_op0_0000_s0p5_w20 0 pwl(0 0 5.5000e-09 0 5.6000e-09 {VDD} 2.7500e-08 {VDD} 2.7600e-08 0)
swb_op0_0000_s0p5_w20 ref_op0_0000_s0p5_w20 wbl_op0_0000_s0p5_w20 wbc_op0_0000_s0p5_w20 0 swwbl
cwbl_op0_0000_s0p5_w20 wbl_op0_0000_s0p5_w20 0 {C_WBL}
spa_op0_0000_s0p5_w20 prea rbl_op0_0000_s0p5_w20 ctl 0 swpre
spr_op0_0000_s0p5_w20 pref ref_op0_0000_s0p5_w20 ctl 0 swpre
crbl_op0_0000_s0p5_w20 rbl_op0_0000_s0p5_w20 0 {C_RBL}
cref_op0_0000_s0p5_w20 ref_op0_0000_s0p5_w20 0 {C_RBL}   $ ASSUMPTION: ideal matched dummy load
XMWR_op0_0000_s0p5_w20_0 sn_op0_0000_s0p5_w20_0 wwl_op0_0000_s0p5_w20 wbl_op0_0000_s0p5_w20 0 sky130_fd_pr__nfet_01v8 L=0.15 W=0.42 nf=1 ad=0.1218 as=0.1218 pd=1.42 ps=1.42 nrd=0.69047619047619  nrs=0.69047619047619 sa=0 sb=0 sd=0 mult=1 m=1
XMRD_op0_0000_s0p5_w20_0 rbl_op0_0000_s0p5_w20 sn_op0_0000_s0p5_w20_0 rwls_op0_0000_s0p5_w20 0 sky130_fd_pr__nfet_01v8 L=0.15 W=0.42 nf=1 ad=0.1218 as=0.1218 pd=1.42 ps=1.42 nrd=0.69047619047619  nrs=0.69047619047619 sa=0 sb=0 sd=0 mult=1 m=1
csn_op0_0000_s0p5_w20_0 sn_op0_0000_s0p5_w20_0 0 {C_SN}
XMWR_op0_0000_s0p5_w20_1 sn_op0_0000_s0p5_w20_1 wwl_des wbl_op0_0000_s0p5_w20 0 sky130_fd_pr__nfet_01v8 L=0.15 W=0.42 nf=1 ad=0.1218 as=0.1218 pd=1.42 ps=1.42 nrd=0.69047619047619  nrs=0.69047619047619 sa=0 sb=0 sd=0 mult=1 m=1
XMRD_op0_0000_s0p5_w20_1 rbl_op0_0000_s0p5_w20 sn_op0_0000_s0p5_w20_1 rwl_des 0 sky130_fd_pr__nfet_01v8 L=0.15 W=0.42 nf=1 ad=0.1218 as=0.1218 pd=1.42 ps=1.42 nrd=0.69047619047619  nrs=0.69047619047619 sa=0 sb=0 sd=0 mult=1 m=1
csn_op0_0000_s0p5_w20_1 sn_op0_0000_s0p5_w20_1 0 {C_SN}
XMWR_op0_0000_s0p5_w20_2 sn_op0_0000_s0p5_w20_2 wwl_des wbl_op0_0000_s0p5_w20 0 sky130_fd_pr__nfet_01v8 L=0.15 W=0.42 nf=1 ad=0.1218 as=0.1218 pd=1.42 ps=1.42 nrd=0.69047619047619  nrs=0.69047619047619 sa=0 sb=0 sd=0 mult=1 m=1
XMRD_op0_0000_s0p5_w20_2 rbl_op0_0000_s0p5_w20 sn_op0_0000_s0p5_w20_2 rwl_des 0 sky130_fd_pr__nfet_01v8 L=0.15 W=0.42 nf=1 ad=0.1218 as=0.1218 pd=1.42 ps=1.42 nrd=0.69047619047619  nrs=0.69047619047619 sa=0 sb=0 sd=0 mult=1 m=1
csn_op0_0000_s0p5_w20_2 sn_op0_0000_s0p5_w20_2 0 {C_SN}
XMWR_op0_0000_s0p5_w20_3 sn_op0_0000_s0p5_w20_3 wwl_des wbl_op0_0000_s0p5_w20 0 sky130_fd_pr__nfet_01v8 L=0.15 W=0.42 nf=1 ad=0.1218 as=0.1218 pd=1.42 ps=1.42 nrd=0.69047619047619  nrs=0.69047619047619 sa=0 sb=0 sd=0 mult=1 m=1
XMRD_op0_0000_s0p5_w20_3 rbl_op0_0000_s0p5_w20 sn_op0_0000_s0p5_w20_3 rwl_des 0 sky130_fd_pr__nfet_01v8 L=0.15 W=0.42 nf=1 ad=0.1218 as=0.1218 pd=1.42 ps=1.42 nrd=0.69047619047619  nrs=0.69047619047619 sa=0 sb=0 sd=0 mult=1 m=1
csn_op0_0000_s0p5_w20_3 sn_op0_0000_s0p5_w20_3 0 {C_SN}
XMN1_op0_0000_s0p5_w20 rbl_op0_0000_s0p5_w20 ref_op0_0000_s0p5_w20 vn_op0_0000_s0p5_w20 0 sky130_fd_pr__nfet_01v8 L=0.15 W=1 nf=1 ad=0.29 as=0.29 pd=2.58 ps=2.58 mult=1 m=1
XMN2_op0_0000_s0p5_w20 ref_op0_0000_s0p5_w20 rbl_op0_0000_s0p5_w20 vn_op0_0000_s0p5_w20 0 sky130_fd_pr__nfet_01v8 L=0.15 W=1 nf=1 ad=0.29 as=0.29 pd=2.58 ps=2.58 mult=1 m=1
XMP1_op0_0000_s0p5_w20 rbl_op0_0000_s0p5_w20 ref_op0_0000_s0p5_w20 vp_op0_0000_s0p5_w20 vdd sky130_fd_pr__pfet_01v8 L=0.15 W=2 nf=1 ad=0.58 as=0.58 pd=4.58 ps=4.58 mult=1 m=1
XMP2_op0_0000_s0p5_w20 ref_op0_0000_s0p5_w20 rbl_op0_0000_s0p5_w20 vp_op0_0000_s0p5_w20 vdd sky130_fd_pr__pfet_01v8 L=0.15 W=2 nf=1 ad=0.58 as=0.58 pd=4.58 ps=4.58 mult=1 m=1
XMNF_op0_0000_s0p5_w20 vn_op0_0000_s0p5_w20 en_op0_0000_s0p5_w20 0 0 sky130_fd_pr__nfet_01v8 L=0.15 W=2 nf=1 ad=0.58 as=0.58 pd=4.58 ps=4.58 mult=1 m=1
XMPH_op0_0000_s0p5_w20 vp_op0_0000_s0p5_w20 enb_op0_0000_s0p5_w20 vdd vdd sky130_fd_pr__pfet_01v8 L=0.15 W=4 nf=1 ad=1.16 as=1.16 pd=8.58 ps=8.58 mult=1 m=1
bd_op0_0000_s0p5_w20 d_op0_0000_s0p5_w20 0 v=v(rbl_op0_0000_s0p5_w20)-v(ref_op0_0000_s0p5_w20)

* ---- instance 190: op0_0000_s0p5_w30 (t_en 4.5 ns, WWL 5.5..35.5 ns, release 37.5 ns) ----
ven_op0_0000_s0p5_w30  en_op0_0000_s0p5_w30  0 pwl(0 0 4.5000e-09 0 4.6000e-09 {VDD} 3.7500e-08 {VDD} 3.7600e-08 0)
venb_op0_0000_s0p5_w30 enb_op0_0000_s0p5_w30 0 pwl(0 {VDD} 4.5000e-09 {VDD} 4.6000e-09 0 3.7500e-08 0 3.7600e-08 {VDD})
vrs_op0_0000_s0p5_w30  rwls_op0_0000_s0p5_w30 0 pwl(0 {VDD} {T_READ} {VDD} {T_READ+TEDGE} 0 3.7500e-08 0 3.7600e-08 {VDD})
vww_op0_0000_s0p5_w30  wwl_op0_0000_s0p5_w30 0 pwl(0 0 5.5000e-09 0 5.6000e-09 {VDD} 3.5500e-08 {VDD} 3.5600e-08 0)
vwc_op0_0000_s0p5_w30  wbc_op0_0000_s0p5_w30 0 pwl(0 0 5.5000e-09 0 5.6000e-09 {VDD} 3.7500e-08 {VDD} 3.7600e-08 0)
swb_op0_0000_s0p5_w30 ref_op0_0000_s0p5_w30 wbl_op0_0000_s0p5_w30 wbc_op0_0000_s0p5_w30 0 swwbl
cwbl_op0_0000_s0p5_w30 wbl_op0_0000_s0p5_w30 0 {C_WBL}
spa_op0_0000_s0p5_w30 prea rbl_op0_0000_s0p5_w30 ctl 0 swpre
spr_op0_0000_s0p5_w30 pref ref_op0_0000_s0p5_w30 ctl 0 swpre
crbl_op0_0000_s0p5_w30 rbl_op0_0000_s0p5_w30 0 {C_RBL}
cref_op0_0000_s0p5_w30 ref_op0_0000_s0p5_w30 0 {C_RBL}   $ ASSUMPTION: ideal matched dummy load
XMWR_op0_0000_s0p5_w30_0 sn_op0_0000_s0p5_w30_0 wwl_op0_0000_s0p5_w30 wbl_op0_0000_s0p5_w30 0 sky130_fd_pr__nfet_01v8 L=0.15 W=0.42 nf=1 ad=0.1218 as=0.1218 pd=1.42 ps=1.42 nrd=0.69047619047619  nrs=0.69047619047619 sa=0 sb=0 sd=0 mult=1 m=1
XMRD_op0_0000_s0p5_w30_0 rbl_op0_0000_s0p5_w30 sn_op0_0000_s0p5_w30_0 rwls_op0_0000_s0p5_w30 0 sky130_fd_pr__nfet_01v8 L=0.15 W=0.42 nf=1 ad=0.1218 as=0.1218 pd=1.42 ps=1.42 nrd=0.69047619047619  nrs=0.69047619047619 sa=0 sb=0 sd=0 mult=1 m=1
csn_op0_0000_s0p5_w30_0 sn_op0_0000_s0p5_w30_0 0 {C_SN}
XMWR_op0_0000_s0p5_w30_1 sn_op0_0000_s0p5_w30_1 wwl_des wbl_op0_0000_s0p5_w30 0 sky130_fd_pr__nfet_01v8 L=0.15 W=0.42 nf=1 ad=0.1218 as=0.1218 pd=1.42 ps=1.42 nrd=0.69047619047619  nrs=0.69047619047619 sa=0 sb=0 sd=0 mult=1 m=1
XMRD_op0_0000_s0p5_w30_1 rbl_op0_0000_s0p5_w30 sn_op0_0000_s0p5_w30_1 rwl_des 0 sky130_fd_pr__nfet_01v8 L=0.15 W=0.42 nf=1 ad=0.1218 as=0.1218 pd=1.42 ps=1.42 nrd=0.69047619047619  nrs=0.69047619047619 sa=0 sb=0 sd=0 mult=1 m=1
csn_op0_0000_s0p5_w30_1 sn_op0_0000_s0p5_w30_1 0 {C_SN}
XMWR_op0_0000_s0p5_w30_2 sn_op0_0000_s0p5_w30_2 wwl_des wbl_op0_0000_s0p5_w30 0 sky130_fd_pr__nfet_01v8 L=0.15 W=0.42 nf=1 ad=0.1218 as=0.1218 pd=1.42 ps=1.42 nrd=0.69047619047619  nrs=0.69047619047619 sa=0 sb=0 sd=0 mult=1 m=1
XMRD_op0_0000_s0p5_w30_2 rbl_op0_0000_s0p5_w30 sn_op0_0000_s0p5_w30_2 rwl_des 0 sky130_fd_pr__nfet_01v8 L=0.15 W=0.42 nf=1 ad=0.1218 as=0.1218 pd=1.42 ps=1.42 nrd=0.69047619047619  nrs=0.69047619047619 sa=0 sb=0 sd=0 mult=1 m=1
csn_op0_0000_s0p5_w30_2 sn_op0_0000_s0p5_w30_2 0 {C_SN}
XMWR_op0_0000_s0p5_w30_3 sn_op0_0000_s0p5_w30_3 wwl_des wbl_op0_0000_s0p5_w30 0 sky130_fd_pr__nfet_01v8 L=0.15 W=0.42 nf=1 ad=0.1218 as=0.1218 pd=1.42 ps=1.42 nrd=0.69047619047619  nrs=0.69047619047619 sa=0 sb=0 sd=0 mult=1 m=1
XMRD_op0_0000_s0p5_w30_3 rbl_op0_0000_s0p5_w30 sn_op0_0000_s0p5_w30_3 rwl_des 0 sky130_fd_pr__nfet_01v8 L=0.15 W=0.42 nf=1 ad=0.1218 as=0.1218 pd=1.42 ps=1.42 nrd=0.69047619047619  nrs=0.69047619047619 sa=0 sb=0 sd=0 mult=1 m=1
csn_op0_0000_s0p5_w30_3 sn_op0_0000_s0p5_w30_3 0 {C_SN}
XMN1_op0_0000_s0p5_w30 rbl_op0_0000_s0p5_w30 ref_op0_0000_s0p5_w30 vn_op0_0000_s0p5_w30 0 sky130_fd_pr__nfet_01v8 L=0.15 W=1 nf=1 ad=0.29 as=0.29 pd=2.58 ps=2.58 mult=1 m=1
XMN2_op0_0000_s0p5_w30 ref_op0_0000_s0p5_w30 rbl_op0_0000_s0p5_w30 vn_op0_0000_s0p5_w30 0 sky130_fd_pr__nfet_01v8 L=0.15 W=1 nf=1 ad=0.29 as=0.29 pd=2.58 ps=2.58 mult=1 m=1
XMP1_op0_0000_s0p5_w30 rbl_op0_0000_s0p5_w30 ref_op0_0000_s0p5_w30 vp_op0_0000_s0p5_w30 vdd sky130_fd_pr__pfet_01v8 L=0.15 W=2 nf=1 ad=0.58 as=0.58 pd=4.58 ps=4.58 mult=1 m=1
XMP2_op0_0000_s0p5_w30 ref_op0_0000_s0p5_w30 rbl_op0_0000_s0p5_w30 vp_op0_0000_s0p5_w30 vdd sky130_fd_pr__pfet_01v8 L=0.15 W=2 nf=1 ad=0.58 as=0.58 pd=4.58 ps=4.58 mult=1 m=1
XMNF_op0_0000_s0p5_w30 vn_op0_0000_s0p5_w30 en_op0_0000_s0p5_w30 0 0 sky130_fd_pr__nfet_01v8 L=0.15 W=2 nf=1 ad=0.58 as=0.58 pd=4.58 ps=4.58 mult=1 m=1
XMPH_op0_0000_s0p5_w30 vp_op0_0000_s0p5_w30 enb_op0_0000_s0p5_w30 vdd vdd sky130_fd_pr__pfet_01v8 L=0.15 W=4 nf=1 ad=1.16 as=1.16 pd=8.58 ps=8.58 mult=1 m=1
bd_op0_0000_s0p5_w30 d_op0_0000_s0p5_w30 0 v=v(rbl_op0_0000_s0p5_w30)-v(ref_op0_0000_s0p5_w30)

* ---- instance 191: op0_0000_s0p5_w50 (t_en 4.5 ns, WWL 5.5..55.5 ns, release 57.5 ns) ----
ven_op0_0000_s0p5_w50  en_op0_0000_s0p5_w50  0 pwl(0 0 4.5000e-09 0 4.6000e-09 {VDD} 5.7500e-08 {VDD} 5.7600e-08 0)
venb_op0_0000_s0p5_w50 enb_op0_0000_s0p5_w50 0 pwl(0 {VDD} 4.5000e-09 {VDD} 4.6000e-09 0 5.7500e-08 0 5.7600e-08 {VDD})
vrs_op0_0000_s0p5_w50  rwls_op0_0000_s0p5_w50 0 pwl(0 {VDD} {T_READ} {VDD} {T_READ+TEDGE} 0 5.7500e-08 0 5.7600e-08 {VDD})
vww_op0_0000_s0p5_w50  wwl_op0_0000_s0p5_w50 0 pwl(0 0 5.5000e-09 0 5.6000e-09 {VDD} 5.5500e-08 {VDD} 5.5600e-08 0)
vwc_op0_0000_s0p5_w50  wbc_op0_0000_s0p5_w50 0 pwl(0 0 5.5000e-09 0 5.6000e-09 {VDD} 5.7500e-08 {VDD} 5.7600e-08 0)
swb_op0_0000_s0p5_w50 ref_op0_0000_s0p5_w50 wbl_op0_0000_s0p5_w50 wbc_op0_0000_s0p5_w50 0 swwbl
cwbl_op0_0000_s0p5_w50 wbl_op0_0000_s0p5_w50 0 {C_WBL}
spa_op0_0000_s0p5_w50 prea rbl_op0_0000_s0p5_w50 ctl 0 swpre
spr_op0_0000_s0p5_w50 pref ref_op0_0000_s0p5_w50 ctl 0 swpre
crbl_op0_0000_s0p5_w50 rbl_op0_0000_s0p5_w50 0 {C_RBL}
cref_op0_0000_s0p5_w50 ref_op0_0000_s0p5_w50 0 {C_RBL}   $ ASSUMPTION: ideal matched dummy load
XMWR_op0_0000_s0p5_w50_0 sn_op0_0000_s0p5_w50_0 wwl_op0_0000_s0p5_w50 wbl_op0_0000_s0p5_w50 0 sky130_fd_pr__nfet_01v8 L=0.15 W=0.42 nf=1 ad=0.1218 as=0.1218 pd=1.42 ps=1.42 nrd=0.69047619047619  nrs=0.69047619047619 sa=0 sb=0 sd=0 mult=1 m=1
XMRD_op0_0000_s0p5_w50_0 rbl_op0_0000_s0p5_w50 sn_op0_0000_s0p5_w50_0 rwls_op0_0000_s0p5_w50 0 sky130_fd_pr__nfet_01v8 L=0.15 W=0.42 nf=1 ad=0.1218 as=0.1218 pd=1.42 ps=1.42 nrd=0.69047619047619  nrs=0.69047619047619 sa=0 sb=0 sd=0 mult=1 m=1
csn_op0_0000_s0p5_w50_0 sn_op0_0000_s0p5_w50_0 0 {C_SN}
XMWR_op0_0000_s0p5_w50_1 sn_op0_0000_s0p5_w50_1 wwl_des wbl_op0_0000_s0p5_w50 0 sky130_fd_pr__nfet_01v8 L=0.15 W=0.42 nf=1 ad=0.1218 as=0.1218 pd=1.42 ps=1.42 nrd=0.69047619047619  nrs=0.69047619047619 sa=0 sb=0 sd=0 mult=1 m=1
XMRD_op0_0000_s0p5_w50_1 rbl_op0_0000_s0p5_w50 sn_op0_0000_s0p5_w50_1 rwl_des 0 sky130_fd_pr__nfet_01v8 L=0.15 W=0.42 nf=1 ad=0.1218 as=0.1218 pd=1.42 ps=1.42 nrd=0.69047619047619  nrs=0.69047619047619 sa=0 sb=0 sd=0 mult=1 m=1
csn_op0_0000_s0p5_w50_1 sn_op0_0000_s0p5_w50_1 0 {C_SN}
XMWR_op0_0000_s0p5_w50_2 sn_op0_0000_s0p5_w50_2 wwl_des wbl_op0_0000_s0p5_w50 0 sky130_fd_pr__nfet_01v8 L=0.15 W=0.42 nf=1 ad=0.1218 as=0.1218 pd=1.42 ps=1.42 nrd=0.69047619047619  nrs=0.69047619047619 sa=0 sb=0 sd=0 mult=1 m=1
XMRD_op0_0000_s0p5_w50_2 rbl_op0_0000_s0p5_w50 sn_op0_0000_s0p5_w50_2 rwl_des 0 sky130_fd_pr__nfet_01v8 L=0.15 W=0.42 nf=1 ad=0.1218 as=0.1218 pd=1.42 ps=1.42 nrd=0.69047619047619  nrs=0.69047619047619 sa=0 sb=0 sd=0 mult=1 m=1
csn_op0_0000_s0p5_w50_2 sn_op0_0000_s0p5_w50_2 0 {C_SN}
XMWR_op0_0000_s0p5_w50_3 sn_op0_0000_s0p5_w50_3 wwl_des wbl_op0_0000_s0p5_w50 0 sky130_fd_pr__nfet_01v8 L=0.15 W=0.42 nf=1 ad=0.1218 as=0.1218 pd=1.42 ps=1.42 nrd=0.69047619047619  nrs=0.69047619047619 sa=0 sb=0 sd=0 mult=1 m=1
XMRD_op0_0000_s0p5_w50_3 rbl_op0_0000_s0p5_w50 sn_op0_0000_s0p5_w50_3 rwl_des 0 sky130_fd_pr__nfet_01v8 L=0.15 W=0.42 nf=1 ad=0.1218 as=0.1218 pd=1.42 ps=1.42 nrd=0.69047619047619  nrs=0.69047619047619 sa=0 sb=0 sd=0 mult=1 m=1
csn_op0_0000_s0p5_w50_3 sn_op0_0000_s0p5_w50_3 0 {C_SN}
XMN1_op0_0000_s0p5_w50 rbl_op0_0000_s0p5_w50 ref_op0_0000_s0p5_w50 vn_op0_0000_s0p5_w50 0 sky130_fd_pr__nfet_01v8 L=0.15 W=1 nf=1 ad=0.29 as=0.29 pd=2.58 ps=2.58 mult=1 m=1
XMN2_op0_0000_s0p5_w50 ref_op0_0000_s0p5_w50 rbl_op0_0000_s0p5_w50 vn_op0_0000_s0p5_w50 0 sky130_fd_pr__nfet_01v8 L=0.15 W=1 nf=1 ad=0.29 as=0.29 pd=2.58 ps=2.58 mult=1 m=1
XMP1_op0_0000_s0p5_w50 rbl_op0_0000_s0p5_w50 ref_op0_0000_s0p5_w50 vp_op0_0000_s0p5_w50 vdd sky130_fd_pr__pfet_01v8 L=0.15 W=2 nf=1 ad=0.58 as=0.58 pd=4.58 ps=4.58 mult=1 m=1
XMP2_op0_0000_s0p5_w50 ref_op0_0000_s0p5_w50 rbl_op0_0000_s0p5_w50 vp_op0_0000_s0p5_w50 vdd sky130_fd_pr__pfet_01v8 L=0.15 W=2 nf=1 ad=0.58 as=0.58 pd=4.58 ps=4.58 mult=1 m=1
XMNF_op0_0000_s0p5_w50 vn_op0_0000_s0p5_w50 en_op0_0000_s0p5_w50 0 0 sky130_fd_pr__nfet_01v8 L=0.15 W=2 nf=1 ad=0.58 as=0.58 pd=4.58 ps=4.58 mult=1 m=1
XMPH_op0_0000_s0p5_w50 vp_op0_0000_s0p5_w50 enb_op0_0000_s0p5_w50 vdd vdd sky130_fd_pr__pfet_01v8 L=0.15 W=4 nf=1 ad=1.16 as=1.16 pd=8.58 ps=8.58 mult=1 m=1
bd_op0_0000_s0p5_w50 d_op0_0000_s0p5_w50 0 v=v(rbl_op0_0000_s0p5_w50)-v(ref_op0_0000_s0p5_w50)

* ---- instance 192: op0_0000_s1_w0p2 (t_en 5 ns, WWL 6..6.2 ns, release 8.2 ns) ----
ven_op0_0000_s1_w0p2  en_op0_0000_s1_w0p2  0 pwl(0 0 5.0000e-09 0 5.1000e-09 {VDD} 8.2000e-09 {VDD} 8.3000e-09 0)
venb_op0_0000_s1_w0p2 enb_op0_0000_s1_w0p2 0 pwl(0 {VDD} 5.0000e-09 {VDD} 5.1000e-09 0 8.2000e-09 0 8.3000e-09 {VDD})
vrs_op0_0000_s1_w0p2  rwls_op0_0000_s1_w0p2 0 pwl(0 {VDD} {T_READ} {VDD} {T_READ+TEDGE} 0 8.2000e-09 0 8.3000e-09 {VDD})
vww_op0_0000_s1_w0p2  wwl_op0_0000_s1_w0p2 0 pwl(0 0 6.0000e-09 0 6.1000e-09 {VDD} 6.2000e-09 {VDD} 6.3000e-09 0)
vwc_op0_0000_s1_w0p2  wbc_op0_0000_s1_w0p2 0 pwl(0 0 6.0000e-09 0 6.1000e-09 {VDD} 8.2000e-09 {VDD} 8.3000e-09 0)
swb_op0_0000_s1_w0p2 ref_op0_0000_s1_w0p2 wbl_op0_0000_s1_w0p2 wbc_op0_0000_s1_w0p2 0 swwbl
cwbl_op0_0000_s1_w0p2 wbl_op0_0000_s1_w0p2 0 {C_WBL}
spa_op0_0000_s1_w0p2 prea rbl_op0_0000_s1_w0p2 ctl 0 swpre
spr_op0_0000_s1_w0p2 pref ref_op0_0000_s1_w0p2 ctl 0 swpre
crbl_op0_0000_s1_w0p2 rbl_op0_0000_s1_w0p2 0 {C_RBL}
cref_op0_0000_s1_w0p2 ref_op0_0000_s1_w0p2 0 {C_RBL}   $ ASSUMPTION: ideal matched dummy load
XMWR_op0_0000_s1_w0p2_0 sn_op0_0000_s1_w0p2_0 wwl_op0_0000_s1_w0p2 wbl_op0_0000_s1_w0p2 0 sky130_fd_pr__nfet_01v8 L=0.15 W=0.42 nf=1 ad=0.1218 as=0.1218 pd=1.42 ps=1.42 nrd=0.69047619047619  nrs=0.69047619047619 sa=0 sb=0 sd=0 mult=1 m=1
XMRD_op0_0000_s1_w0p2_0 rbl_op0_0000_s1_w0p2 sn_op0_0000_s1_w0p2_0 rwls_op0_0000_s1_w0p2 0 sky130_fd_pr__nfet_01v8 L=0.15 W=0.42 nf=1 ad=0.1218 as=0.1218 pd=1.42 ps=1.42 nrd=0.69047619047619  nrs=0.69047619047619 sa=0 sb=0 sd=0 mult=1 m=1
csn_op0_0000_s1_w0p2_0 sn_op0_0000_s1_w0p2_0 0 {C_SN}
XMWR_op0_0000_s1_w0p2_1 sn_op0_0000_s1_w0p2_1 wwl_des wbl_op0_0000_s1_w0p2 0 sky130_fd_pr__nfet_01v8 L=0.15 W=0.42 nf=1 ad=0.1218 as=0.1218 pd=1.42 ps=1.42 nrd=0.69047619047619  nrs=0.69047619047619 sa=0 sb=0 sd=0 mult=1 m=1
XMRD_op0_0000_s1_w0p2_1 rbl_op0_0000_s1_w0p2 sn_op0_0000_s1_w0p2_1 rwl_des 0 sky130_fd_pr__nfet_01v8 L=0.15 W=0.42 nf=1 ad=0.1218 as=0.1218 pd=1.42 ps=1.42 nrd=0.69047619047619  nrs=0.69047619047619 sa=0 sb=0 sd=0 mult=1 m=1
csn_op0_0000_s1_w0p2_1 sn_op0_0000_s1_w0p2_1 0 {C_SN}
XMWR_op0_0000_s1_w0p2_2 sn_op0_0000_s1_w0p2_2 wwl_des wbl_op0_0000_s1_w0p2 0 sky130_fd_pr__nfet_01v8 L=0.15 W=0.42 nf=1 ad=0.1218 as=0.1218 pd=1.42 ps=1.42 nrd=0.69047619047619  nrs=0.69047619047619 sa=0 sb=0 sd=0 mult=1 m=1
XMRD_op0_0000_s1_w0p2_2 rbl_op0_0000_s1_w0p2 sn_op0_0000_s1_w0p2_2 rwl_des 0 sky130_fd_pr__nfet_01v8 L=0.15 W=0.42 nf=1 ad=0.1218 as=0.1218 pd=1.42 ps=1.42 nrd=0.69047619047619  nrs=0.69047619047619 sa=0 sb=0 sd=0 mult=1 m=1
csn_op0_0000_s1_w0p2_2 sn_op0_0000_s1_w0p2_2 0 {C_SN}
XMWR_op0_0000_s1_w0p2_3 sn_op0_0000_s1_w0p2_3 wwl_des wbl_op0_0000_s1_w0p2 0 sky130_fd_pr__nfet_01v8 L=0.15 W=0.42 nf=1 ad=0.1218 as=0.1218 pd=1.42 ps=1.42 nrd=0.69047619047619  nrs=0.69047619047619 sa=0 sb=0 sd=0 mult=1 m=1
XMRD_op0_0000_s1_w0p2_3 rbl_op0_0000_s1_w0p2 sn_op0_0000_s1_w0p2_3 rwl_des 0 sky130_fd_pr__nfet_01v8 L=0.15 W=0.42 nf=1 ad=0.1218 as=0.1218 pd=1.42 ps=1.42 nrd=0.69047619047619  nrs=0.69047619047619 sa=0 sb=0 sd=0 mult=1 m=1
csn_op0_0000_s1_w0p2_3 sn_op0_0000_s1_w0p2_3 0 {C_SN}
XMN1_op0_0000_s1_w0p2 rbl_op0_0000_s1_w0p2 ref_op0_0000_s1_w0p2 vn_op0_0000_s1_w0p2 0 sky130_fd_pr__nfet_01v8 L=0.15 W=1 nf=1 ad=0.29 as=0.29 pd=2.58 ps=2.58 mult=1 m=1
XMN2_op0_0000_s1_w0p2 ref_op0_0000_s1_w0p2 rbl_op0_0000_s1_w0p2 vn_op0_0000_s1_w0p2 0 sky130_fd_pr__nfet_01v8 L=0.15 W=1 nf=1 ad=0.29 as=0.29 pd=2.58 ps=2.58 mult=1 m=1
XMP1_op0_0000_s1_w0p2 rbl_op0_0000_s1_w0p2 ref_op0_0000_s1_w0p2 vp_op0_0000_s1_w0p2 vdd sky130_fd_pr__pfet_01v8 L=0.15 W=2 nf=1 ad=0.58 as=0.58 pd=4.58 ps=4.58 mult=1 m=1
XMP2_op0_0000_s1_w0p2 ref_op0_0000_s1_w0p2 rbl_op0_0000_s1_w0p2 vp_op0_0000_s1_w0p2 vdd sky130_fd_pr__pfet_01v8 L=0.15 W=2 nf=1 ad=0.58 as=0.58 pd=4.58 ps=4.58 mult=1 m=1
XMNF_op0_0000_s1_w0p2 vn_op0_0000_s1_w0p2 en_op0_0000_s1_w0p2 0 0 sky130_fd_pr__nfet_01v8 L=0.15 W=2 nf=1 ad=0.58 as=0.58 pd=4.58 ps=4.58 mult=1 m=1
XMPH_op0_0000_s1_w0p2 vp_op0_0000_s1_w0p2 enb_op0_0000_s1_w0p2 vdd vdd sky130_fd_pr__pfet_01v8 L=0.15 W=4 nf=1 ad=1.16 as=1.16 pd=8.58 ps=8.58 mult=1 m=1
bd_op0_0000_s1_w0p2 d_op0_0000_s1_w0p2 0 v=v(rbl_op0_0000_s1_w0p2)-v(ref_op0_0000_s1_w0p2)

* ---- instance 193: op0_0000_s1_w0p5 (t_en 5 ns, WWL 6..6.5 ns, release 8.5 ns) ----
ven_op0_0000_s1_w0p5  en_op0_0000_s1_w0p5  0 pwl(0 0 5.0000e-09 0 5.1000e-09 {VDD} 8.5000e-09 {VDD} 8.6000e-09 0)
venb_op0_0000_s1_w0p5 enb_op0_0000_s1_w0p5 0 pwl(0 {VDD} 5.0000e-09 {VDD} 5.1000e-09 0 8.5000e-09 0 8.6000e-09 {VDD})
vrs_op0_0000_s1_w0p5  rwls_op0_0000_s1_w0p5 0 pwl(0 {VDD} {T_READ} {VDD} {T_READ+TEDGE} 0 8.5000e-09 0 8.6000e-09 {VDD})
vww_op0_0000_s1_w0p5  wwl_op0_0000_s1_w0p5 0 pwl(0 0 6.0000e-09 0 6.1000e-09 {VDD} 6.5000e-09 {VDD} 6.6000e-09 0)
vwc_op0_0000_s1_w0p5  wbc_op0_0000_s1_w0p5 0 pwl(0 0 6.0000e-09 0 6.1000e-09 {VDD} 8.5000e-09 {VDD} 8.6000e-09 0)
swb_op0_0000_s1_w0p5 ref_op0_0000_s1_w0p5 wbl_op0_0000_s1_w0p5 wbc_op0_0000_s1_w0p5 0 swwbl
cwbl_op0_0000_s1_w0p5 wbl_op0_0000_s1_w0p5 0 {C_WBL}
spa_op0_0000_s1_w0p5 prea rbl_op0_0000_s1_w0p5 ctl 0 swpre
spr_op0_0000_s1_w0p5 pref ref_op0_0000_s1_w0p5 ctl 0 swpre
crbl_op0_0000_s1_w0p5 rbl_op0_0000_s1_w0p5 0 {C_RBL}
cref_op0_0000_s1_w0p5 ref_op0_0000_s1_w0p5 0 {C_RBL}   $ ASSUMPTION: ideal matched dummy load
XMWR_op0_0000_s1_w0p5_0 sn_op0_0000_s1_w0p5_0 wwl_op0_0000_s1_w0p5 wbl_op0_0000_s1_w0p5 0 sky130_fd_pr__nfet_01v8 L=0.15 W=0.42 nf=1 ad=0.1218 as=0.1218 pd=1.42 ps=1.42 nrd=0.69047619047619  nrs=0.69047619047619 sa=0 sb=0 sd=0 mult=1 m=1
XMRD_op0_0000_s1_w0p5_0 rbl_op0_0000_s1_w0p5 sn_op0_0000_s1_w0p5_0 rwls_op0_0000_s1_w0p5 0 sky130_fd_pr__nfet_01v8 L=0.15 W=0.42 nf=1 ad=0.1218 as=0.1218 pd=1.42 ps=1.42 nrd=0.69047619047619  nrs=0.69047619047619 sa=0 sb=0 sd=0 mult=1 m=1
csn_op0_0000_s1_w0p5_0 sn_op0_0000_s1_w0p5_0 0 {C_SN}
XMWR_op0_0000_s1_w0p5_1 sn_op0_0000_s1_w0p5_1 wwl_des wbl_op0_0000_s1_w0p5 0 sky130_fd_pr__nfet_01v8 L=0.15 W=0.42 nf=1 ad=0.1218 as=0.1218 pd=1.42 ps=1.42 nrd=0.69047619047619  nrs=0.69047619047619 sa=0 sb=0 sd=0 mult=1 m=1
XMRD_op0_0000_s1_w0p5_1 rbl_op0_0000_s1_w0p5 sn_op0_0000_s1_w0p5_1 rwl_des 0 sky130_fd_pr__nfet_01v8 L=0.15 W=0.42 nf=1 ad=0.1218 as=0.1218 pd=1.42 ps=1.42 nrd=0.69047619047619  nrs=0.69047619047619 sa=0 sb=0 sd=0 mult=1 m=1
csn_op0_0000_s1_w0p5_1 sn_op0_0000_s1_w0p5_1 0 {C_SN}
XMWR_op0_0000_s1_w0p5_2 sn_op0_0000_s1_w0p5_2 wwl_des wbl_op0_0000_s1_w0p5 0 sky130_fd_pr__nfet_01v8 L=0.15 W=0.42 nf=1 ad=0.1218 as=0.1218 pd=1.42 ps=1.42 nrd=0.69047619047619  nrs=0.69047619047619 sa=0 sb=0 sd=0 mult=1 m=1
XMRD_op0_0000_s1_w0p5_2 rbl_op0_0000_s1_w0p5 sn_op0_0000_s1_w0p5_2 rwl_des 0 sky130_fd_pr__nfet_01v8 L=0.15 W=0.42 nf=1 ad=0.1218 as=0.1218 pd=1.42 ps=1.42 nrd=0.69047619047619  nrs=0.69047619047619 sa=0 sb=0 sd=0 mult=1 m=1
csn_op0_0000_s1_w0p5_2 sn_op0_0000_s1_w0p5_2 0 {C_SN}
XMWR_op0_0000_s1_w0p5_3 sn_op0_0000_s1_w0p5_3 wwl_des wbl_op0_0000_s1_w0p5 0 sky130_fd_pr__nfet_01v8 L=0.15 W=0.42 nf=1 ad=0.1218 as=0.1218 pd=1.42 ps=1.42 nrd=0.69047619047619  nrs=0.69047619047619 sa=0 sb=0 sd=0 mult=1 m=1
XMRD_op0_0000_s1_w0p5_3 rbl_op0_0000_s1_w0p5 sn_op0_0000_s1_w0p5_3 rwl_des 0 sky130_fd_pr__nfet_01v8 L=0.15 W=0.42 nf=1 ad=0.1218 as=0.1218 pd=1.42 ps=1.42 nrd=0.69047619047619  nrs=0.69047619047619 sa=0 sb=0 sd=0 mult=1 m=1
csn_op0_0000_s1_w0p5_3 sn_op0_0000_s1_w0p5_3 0 {C_SN}
XMN1_op0_0000_s1_w0p5 rbl_op0_0000_s1_w0p5 ref_op0_0000_s1_w0p5 vn_op0_0000_s1_w0p5 0 sky130_fd_pr__nfet_01v8 L=0.15 W=1 nf=1 ad=0.29 as=0.29 pd=2.58 ps=2.58 mult=1 m=1
XMN2_op0_0000_s1_w0p5 ref_op0_0000_s1_w0p5 rbl_op0_0000_s1_w0p5 vn_op0_0000_s1_w0p5 0 sky130_fd_pr__nfet_01v8 L=0.15 W=1 nf=1 ad=0.29 as=0.29 pd=2.58 ps=2.58 mult=1 m=1
XMP1_op0_0000_s1_w0p5 rbl_op0_0000_s1_w0p5 ref_op0_0000_s1_w0p5 vp_op0_0000_s1_w0p5 vdd sky130_fd_pr__pfet_01v8 L=0.15 W=2 nf=1 ad=0.58 as=0.58 pd=4.58 ps=4.58 mult=1 m=1
XMP2_op0_0000_s1_w0p5 ref_op0_0000_s1_w0p5 rbl_op0_0000_s1_w0p5 vp_op0_0000_s1_w0p5 vdd sky130_fd_pr__pfet_01v8 L=0.15 W=2 nf=1 ad=0.58 as=0.58 pd=4.58 ps=4.58 mult=1 m=1
XMNF_op0_0000_s1_w0p5 vn_op0_0000_s1_w0p5 en_op0_0000_s1_w0p5 0 0 sky130_fd_pr__nfet_01v8 L=0.15 W=2 nf=1 ad=0.58 as=0.58 pd=4.58 ps=4.58 mult=1 m=1
XMPH_op0_0000_s1_w0p5 vp_op0_0000_s1_w0p5 enb_op0_0000_s1_w0p5 vdd vdd sky130_fd_pr__pfet_01v8 L=0.15 W=4 nf=1 ad=1.16 as=1.16 pd=8.58 ps=8.58 mult=1 m=1
bd_op0_0000_s1_w0p5 d_op0_0000_s1_w0p5 0 v=v(rbl_op0_0000_s1_w0p5)-v(ref_op0_0000_s1_w0p5)

* ---- instance 194: op0_0000_s1_w1 (t_en 5 ns, WWL 6..7 ns, release 9 ns) ----
ven_op0_0000_s1_w1  en_op0_0000_s1_w1  0 pwl(0 0 5.0000e-09 0 5.1000e-09 {VDD} 9.0000e-09 {VDD} 9.1000e-09 0)
venb_op0_0000_s1_w1 enb_op0_0000_s1_w1 0 pwl(0 {VDD} 5.0000e-09 {VDD} 5.1000e-09 0 9.0000e-09 0 9.1000e-09 {VDD})
vrs_op0_0000_s1_w1  rwls_op0_0000_s1_w1 0 pwl(0 {VDD} {T_READ} {VDD} {T_READ+TEDGE} 0 9.0000e-09 0 9.1000e-09 {VDD})
vww_op0_0000_s1_w1  wwl_op0_0000_s1_w1 0 pwl(0 0 6.0000e-09 0 6.1000e-09 {VDD} 7.0000e-09 {VDD} 7.1000e-09 0)
vwc_op0_0000_s1_w1  wbc_op0_0000_s1_w1 0 pwl(0 0 6.0000e-09 0 6.1000e-09 {VDD} 9.0000e-09 {VDD} 9.1000e-09 0)
swb_op0_0000_s1_w1 ref_op0_0000_s1_w1 wbl_op0_0000_s1_w1 wbc_op0_0000_s1_w1 0 swwbl
cwbl_op0_0000_s1_w1 wbl_op0_0000_s1_w1 0 {C_WBL}
spa_op0_0000_s1_w1 prea rbl_op0_0000_s1_w1 ctl 0 swpre
spr_op0_0000_s1_w1 pref ref_op0_0000_s1_w1 ctl 0 swpre
crbl_op0_0000_s1_w1 rbl_op0_0000_s1_w1 0 {C_RBL}
cref_op0_0000_s1_w1 ref_op0_0000_s1_w1 0 {C_RBL}   $ ASSUMPTION: ideal matched dummy load
XMWR_op0_0000_s1_w1_0 sn_op0_0000_s1_w1_0 wwl_op0_0000_s1_w1 wbl_op0_0000_s1_w1 0 sky130_fd_pr__nfet_01v8 L=0.15 W=0.42 nf=1 ad=0.1218 as=0.1218 pd=1.42 ps=1.42 nrd=0.69047619047619  nrs=0.69047619047619 sa=0 sb=0 sd=0 mult=1 m=1
XMRD_op0_0000_s1_w1_0 rbl_op0_0000_s1_w1 sn_op0_0000_s1_w1_0 rwls_op0_0000_s1_w1 0 sky130_fd_pr__nfet_01v8 L=0.15 W=0.42 nf=1 ad=0.1218 as=0.1218 pd=1.42 ps=1.42 nrd=0.69047619047619  nrs=0.69047619047619 sa=0 sb=0 sd=0 mult=1 m=1
csn_op0_0000_s1_w1_0 sn_op0_0000_s1_w1_0 0 {C_SN}
XMWR_op0_0000_s1_w1_1 sn_op0_0000_s1_w1_1 wwl_des wbl_op0_0000_s1_w1 0 sky130_fd_pr__nfet_01v8 L=0.15 W=0.42 nf=1 ad=0.1218 as=0.1218 pd=1.42 ps=1.42 nrd=0.69047619047619  nrs=0.69047619047619 sa=0 sb=0 sd=0 mult=1 m=1
XMRD_op0_0000_s1_w1_1 rbl_op0_0000_s1_w1 sn_op0_0000_s1_w1_1 rwl_des 0 sky130_fd_pr__nfet_01v8 L=0.15 W=0.42 nf=1 ad=0.1218 as=0.1218 pd=1.42 ps=1.42 nrd=0.69047619047619  nrs=0.69047619047619 sa=0 sb=0 sd=0 mult=1 m=1
csn_op0_0000_s1_w1_1 sn_op0_0000_s1_w1_1 0 {C_SN}
XMWR_op0_0000_s1_w1_2 sn_op0_0000_s1_w1_2 wwl_des wbl_op0_0000_s1_w1 0 sky130_fd_pr__nfet_01v8 L=0.15 W=0.42 nf=1 ad=0.1218 as=0.1218 pd=1.42 ps=1.42 nrd=0.69047619047619  nrs=0.69047619047619 sa=0 sb=0 sd=0 mult=1 m=1
XMRD_op0_0000_s1_w1_2 rbl_op0_0000_s1_w1 sn_op0_0000_s1_w1_2 rwl_des 0 sky130_fd_pr__nfet_01v8 L=0.15 W=0.42 nf=1 ad=0.1218 as=0.1218 pd=1.42 ps=1.42 nrd=0.69047619047619  nrs=0.69047619047619 sa=0 sb=0 sd=0 mult=1 m=1
csn_op0_0000_s1_w1_2 sn_op0_0000_s1_w1_2 0 {C_SN}
XMWR_op0_0000_s1_w1_3 sn_op0_0000_s1_w1_3 wwl_des wbl_op0_0000_s1_w1 0 sky130_fd_pr__nfet_01v8 L=0.15 W=0.42 nf=1 ad=0.1218 as=0.1218 pd=1.42 ps=1.42 nrd=0.69047619047619  nrs=0.69047619047619 sa=0 sb=0 sd=0 mult=1 m=1
XMRD_op0_0000_s1_w1_3 rbl_op0_0000_s1_w1 sn_op0_0000_s1_w1_3 rwl_des 0 sky130_fd_pr__nfet_01v8 L=0.15 W=0.42 nf=1 ad=0.1218 as=0.1218 pd=1.42 ps=1.42 nrd=0.69047619047619  nrs=0.69047619047619 sa=0 sb=0 sd=0 mult=1 m=1
csn_op0_0000_s1_w1_3 sn_op0_0000_s1_w1_3 0 {C_SN}
XMN1_op0_0000_s1_w1 rbl_op0_0000_s1_w1 ref_op0_0000_s1_w1 vn_op0_0000_s1_w1 0 sky130_fd_pr__nfet_01v8 L=0.15 W=1 nf=1 ad=0.29 as=0.29 pd=2.58 ps=2.58 mult=1 m=1
XMN2_op0_0000_s1_w1 ref_op0_0000_s1_w1 rbl_op0_0000_s1_w1 vn_op0_0000_s1_w1 0 sky130_fd_pr__nfet_01v8 L=0.15 W=1 nf=1 ad=0.29 as=0.29 pd=2.58 ps=2.58 mult=1 m=1
XMP1_op0_0000_s1_w1 rbl_op0_0000_s1_w1 ref_op0_0000_s1_w1 vp_op0_0000_s1_w1 vdd sky130_fd_pr__pfet_01v8 L=0.15 W=2 nf=1 ad=0.58 as=0.58 pd=4.58 ps=4.58 mult=1 m=1
XMP2_op0_0000_s1_w1 ref_op0_0000_s1_w1 rbl_op0_0000_s1_w1 vp_op0_0000_s1_w1 vdd sky130_fd_pr__pfet_01v8 L=0.15 W=2 nf=1 ad=0.58 as=0.58 pd=4.58 ps=4.58 mult=1 m=1
XMNF_op0_0000_s1_w1 vn_op0_0000_s1_w1 en_op0_0000_s1_w1 0 0 sky130_fd_pr__nfet_01v8 L=0.15 W=2 nf=1 ad=0.58 as=0.58 pd=4.58 ps=4.58 mult=1 m=1
XMPH_op0_0000_s1_w1 vp_op0_0000_s1_w1 enb_op0_0000_s1_w1 vdd vdd sky130_fd_pr__pfet_01v8 L=0.15 W=4 nf=1 ad=1.16 as=1.16 pd=8.58 ps=8.58 mult=1 m=1
bd_op0_0000_s1_w1 d_op0_0000_s1_w1 0 v=v(rbl_op0_0000_s1_w1)-v(ref_op0_0000_s1_w1)

* ---- instance 195: op0_0000_s1_w2 (t_en 5 ns, WWL 6..8 ns, release 10 ns) ----
ven_op0_0000_s1_w2  en_op0_0000_s1_w2  0 pwl(0 0 5.0000e-09 0 5.1000e-09 {VDD} 1.0000e-08 {VDD} 1.0100e-08 0)
venb_op0_0000_s1_w2 enb_op0_0000_s1_w2 0 pwl(0 {VDD} 5.0000e-09 {VDD} 5.1000e-09 0 1.0000e-08 0 1.0100e-08 {VDD})
vrs_op0_0000_s1_w2  rwls_op0_0000_s1_w2 0 pwl(0 {VDD} {T_READ} {VDD} {T_READ+TEDGE} 0 1.0000e-08 0 1.0100e-08 {VDD})
vww_op0_0000_s1_w2  wwl_op0_0000_s1_w2 0 pwl(0 0 6.0000e-09 0 6.1000e-09 {VDD} 8.0000e-09 {VDD} 8.1000e-09 0)
vwc_op0_0000_s1_w2  wbc_op0_0000_s1_w2 0 pwl(0 0 6.0000e-09 0 6.1000e-09 {VDD} 1.0000e-08 {VDD} 1.0100e-08 0)
swb_op0_0000_s1_w2 ref_op0_0000_s1_w2 wbl_op0_0000_s1_w2 wbc_op0_0000_s1_w2 0 swwbl
cwbl_op0_0000_s1_w2 wbl_op0_0000_s1_w2 0 {C_WBL}
spa_op0_0000_s1_w2 prea rbl_op0_0000_s1_w2 ctl 0 swpre
spr_op0_0000_s1_w2 pref ref_op0_0000_s1_w2 ctl 0 swpre
crbl_op0_0000_s1_w2 rbl_op0_0000_s1_w2 0 {C_RBL}
cref_op0_0000_s1_w2 ref_op0_0000_s1_w2 0 {C_RBL}   $ ASSUMPTION: ideal matched dummy load
XMWR_op0_0000_s1_w2_0 sn_op0_0000_s1_w2_0 wwl_op0_0000_s1_w2 wbl_op0_0000_s1_w2 0 sky130_fd_pr__nfet_01v8 L=0.15 W=0.42 nf=1 ad=0.1218 as=0.1218 pd=1.42 ps=1.42 nrd=0.69047619047619  nrs=0.69047619047619 sa=0 sb=0 sd=0 mult=1 m=1
XMRD_op0_0000_s1_w2_0 rbl_op0_0000_s1_w2 sn_op0_0000_s1_w2_0 rwls_op0_0000_s1_w2 0 sky130_fd_pr__nfet_01v8 L=0.15 W=0.42 nf=1 ad=0.1218 as=0.1218 pd=1.42 ps=1.42 nrd=0.69047619047619  nrs=0.69047619047619 sa=0 sb=0 sd=0 mult=1 m=1
csn_op0_0000_s1_w2_0 sn_op0_0000_s1_w2_0 0 {C_SN}
XMWR_op0_0000_s1_w2_1 sn_op0_0000_s1_w2_1 wwl_des wbl_op0_0000_s1_w2 0 sky130_fd_pr__nfet_01v8 L=0.15 W=0.42 nf=1 ad=0.1218 as=0.1218 pd=1.42 ps=1.42 nrd=0.69047619047619  nrs=0.69047619047619 sa=0 sb=0 sd=0 mult=1 m=1
XMRD_op0_0000_s1_w2_1 rbl_op0_0000_s1_w2 sn_op0_0000_s1_w2_1 rwl_des 0 sky130_fd_pr__nfet_01v8 L=0.15 W=0.42 nf=1 ad=0.1218 as=0.1218 pd=1.42 ps=1.42 nrd=0.69047619047619  nrs=0.69047619047619 sa=0 sb=0 sd=0 mult=1 m=1
csn_op0_0000_s1_w2_1 sn_op0_0000_s1_w2_1 0 {C_SN}
XMWR_op0_0000_s1_w2_2 sn_op0_0000_s1_w2_2 wwl_des wbl_op0_0000_s1_w2 0 sky130_fd_pr__nfet_01v8 L=0.15 W=0.42 nf=1 ad=0.1218 as=0.1218 pd=1.42 ps=1.42 nrd=0.69047619047619  nrs=0.69047619047619 sa=0 sb=0 sd=0 mult=1 m=1
XMRD_op0_0000_s1_w2_2 rbl_op0_0000_s1_w2 sn_op0_0000_s1_w2_2 rwl_des 0 sky130_fd_pr__nfet_01v8 L=0.15 W=0.42 nf=1 ad=0.1218 as=0.1218 pd=1.42 ps=1.42 nrd=0.69047619047619  nrs=0.69047619047619 sa=0 sb=0 sd=0 mult=1 m=1
csn_op0_0000_s1_w2_2 sn_op0_0000_s1_w2_2 0 {C_SN}
XMWR_op0_0000_s1_w2_3 sn_op0_0000_s1_w2_3 wwl_des wbl_op0_0000_s1_w2 0 sky130_fd_pr__nfet_01v8 L=0.15 W=0.42 nf=1 ad=0.1218 as=0.1218 pd=1.42 ps=1.42 nrd=0.69047619047619  nrs=0.69047619047619 sa=0 sb=0 sd=0 mult=1 m=1
XMRD_op0_0000_s1_w2_3 rbl_op0_0000_s1_w2 sn_op0_0000_s1_w2_3 rwl_des 0 sky130_fd_pr__nfet_01v8 L=0.15 W=0.42 nf=1 ad=0.1218 as=0.1218 pd=1.42 ps=1.42 nrd=0.69047619047619  nrs=0.69047619047619 sa=0 sb=0 sd=0 mult=1 m=1
csn_op0_0000_s1_w2_3 sn_op0_0000_s1_w2_3 0 {C_SN}
XMN1_op0_0000_s1_w2 rbl_op0_0000_s1_w2 ref_op0_0000_s1_w2 vn_op0_0000_s1_w2 0 sky130_fd_pr__nfet_01v8 L=0.15 W=1 nf=1 ad=0.29 as=0.29 pd=2.58 ps=2.58 mult=1 m=1
XMN2_op0_0000_s1_w2 ref_op0_0000_s1_w2 rbl_op0_0000_s1_w2 vn_op0_0000_s1_w2 0 sky130_fd_pr__nfet_01v8 L=0.15 W=1 nf=1 ad=0.29 as=0.29 pd=2.58 ps=2.58 mult=1 m=1
XMP1_op0_0000_s1_w2 rbl_op0_0000_s1_w2 ref_op0_0000_s1_w2 vp_op0_0000_s1_w2 vdd sky130_fd_pr__pfet_01v8 L=0.15 W=2 nf=1 ad=0.58 as=0.58 pd=4.58 ps=4.58 mult=1 m=1
XMP2_op0_0000_s1_w2 ref_op0_0000_s1_w2 rbl_op0_0000_s1_w2 vp_op0_0000_s1_w2 vdd sky130_fd_pr__pfet_01v8 L=0.15 W=2 nf=1 ad=0.58 as=0.58 pd=4.58 ps=4.58 mult=1 m=1
XMNF_op0_0000_s1_w2 vn_op0_0000_s1_w2 en_op0_0000_s1_w2 0 0 sky130_fd_pr__nfet_01v8 L=0.15 W=2 nf=1 ad=0.58 as=0.58 pd=4.58 ps=4.58 mult=1 m=1
XMPH_op0_0000_s1_w2 vp_op0_0000_s1_w2 enb_op0_0000_s1_w2 vdd vdd sky130_fd_pr__pfet_01v8 L=0.15 W=4 nf=1 ad=1.16 as=1.16 pd=8.58 ps=8.58 mult=1 m=1
bd_op0_0000_s1_w2 d_op0_0000_s1_w2 0 v=v(rbl_op0_0000_s1_w2)-v(ref_op0_0000_s1_w2)

* ---- instance 196: op0_0000_s1_w3 (t_en 5 ns, WWL 6..9 ns, release 11 ns) ----
ven_op0_0000_s1_w3  en_op0_0000_s1_w3  0 pwl(0 0 5.0000e-09 0 5.1000e-09 {VDD} 1.1000e-08 {VDD} 1.1100e-08 0)
venb_op0_0000_s1_w3 enb_op0_0000_s1_w3 0 pwl(0 {VDD} 5.0000e-09 {VDD} 5.1000e-09 0 1.1000e-08 0 1.1100e-08 {VDD})
vrs_op0_0000_s1_w3  rwls_op0_0000_s1_w3 0 pwl(0 {VDD} {T_READ} {VDD} {T_READ+TEDGE} 0 1.1000e-08 0 1.1100e-08 {VDD})
vww_op0_0000_s1_w3  wwl_op0_0000_s1_w3 0 pwl(0 0 6.0000e-09 0 6.1000e-09 {VDD} 9.0000e-09 {VDD} 9.1000e-09 0)
vwc_op0_0000_s1_w3  wbc_op0_0000_s1_w3 0 pwl(0 0 6.0000e-09 0 6.1000e-09 {VDD} 1.1000e-08 {VDD} 1.1100e-08 0)
swb_op0_0000_s1_w3 ref_op0_0000_s1_w3 wbl_op0_0000_s1_w3 wbc_op0_0000_s1_w3 0 swwbl
cwbl_op0_0000_s1_w3 wbl_op0_0000_s1_w3 0 {C_WBL}
spa_op0_0000_s1_w3 prea rbl_op0_0000_s1_w3 ctl 0 swpre
spr_op0_0000_s1_w3 pref ref_op0_0000_s1_w3 ctl 0 swpre
crbl_op0_0000_s1_w3 rbl_op0_0000_s1_w3 0 {C_RBL}
cref_op0_0000_s1_w3 ref_op0_0000_s1_w3 0 {C_RBL}   $ ASSUMPTION: ideal matched dummy load
XMWR_op0_0000_s1_w3_0 sn_op0_0000_s1_w3_0 wwl_op0_0000_s1_w3 wbl_op0_0000_s1_w3 0 sky130_fd_pr__nfet_01v8 L=0.15 W=0.42 nf=1 ad=0.1218 as=0.1218 pd=1.42 ps=1.42 nrd=0.69047619047619  nrs=0.69047619047619 sa=0 sb=0 sd=0 mult=1 m=1
XMRD_op0_0000_s1_w3_0 rbl_op0_0000_s1_w3 sn_op0_0000_s1_w3_0 rwls_op0_0000_s1_w3 0 sky130_fd_pr__nfet_01v8 L=0.15 W=0.42 nf=1 ad=0.1218 as=0.1218 pd=1.42 ps=1.42 nrd=0.69047619047619  nrs=0.69047619047619 sa=0 sb=0 sd=0 mult=1 m=1
csn_op0_0000_s1_w3_0 sn_op0_0000_s1_w3_0 0 {C_SN}
XMWR_op0_0000_s1_w3_1 sn_op0_0000_s1_w3_1 wwl_des wbl_op0_0000_s1_w3 0 sky130_fd_pr__nfet_01v8 L=0.15 W=0.42 nf=1 ad=0.1218 as=0.1218 pd=1.42 ps=1.42 nrd=0.69047619047619  nrs=0.69047619047619 sa=0 sb=0 sd=0 mult=1 m=1
XMRD_op0_0000_s1_w3_1 rbl_op0_0000_s1_w3 sn_op0_0000_s1_w3_1 rwl_des 0 sky130_fd_pr__nfet_01v8 L=0.15 W=0.42 nf=1 ad=0.1218 as=0.1218 pd=1.42 ps=1.42 nrd=0.69047619047619  nrs=0.69047619047619 sa=0 sb=0 sd=0 mult=1 m=1
csn_op0_0000_s1_w3_1 sn_op0_0000_s1_w3_1 0 {C_SN}
XMWR_op0_0000_s1_w3_2 sn_op0_0000_s1_w3_2 wwl_des wbl_op0_0000_s1_w3 0 sky130_fd_pr__nfet_01v8 L=0.15 W=0.42 nf=1 ad=0.1218 as=0.1218 pd=1.42 ps=1.42 nrd=0.69047619047619  nrs=0.69047619047619 sa=0 sb=0 sd=0 mult=1 m=1
XMRD_op0_0000_s1_w3_2 rbl_op0_0000_s1_w3 sn_op0_0000_s1_w3_2 rwl_des 0 sky130_fd_pr__nfet_01v8 L=0.15 W=0.42 nf=1 ad=0.1218 as=0.1218 pd=1.42 ps=1.42 nrd=0.69047619047619  nrs=0.69047619047619 sa=0 sb=0 sd=0 mult=1 m=1
csn_op0_0000_s1_w3_2 sn_op0_0000_s1_w3_2 0 {C_SN}
XMWR_op0_0000_s1_w3_3 sn_op0_0000_s1_w3_3 wwl_des wbl_op0_0000_s1_w3 0 sky130_fd_pr__nfet_01v8 L=0.15 W=0.42 nf=1 ad=0.1218 as=0.1218 pd=1.42 ps=1.42 nrd=0.69047619047619  nrs=0.69047619047619 sa=0 sb=0 sd=0 mult=1 m=1
XMRD_op0_0000_s1_w3_3 rbl_op0_0000_s1_w3 sn_op0_0000_s1_w3_3 rwl_des 0 sky130_fd_pr__nfet_01v8 L=0.15 W=0.42 nf=1 ad=0.1218 as=0.1218 pd=1.42 ps=1.42 nrd=0.69047619047619  nrs=0.69047619047619 sa=0 sb=0 sd=0 mult=1 m=1
csn_op0_0000_s1_w3_3 sn_op0_0000_s1_w3_3 0 {C_SN}
XMN1_op0_0000_s1_w3 rbl_op0_0000_s1_w3 ref_op0_0000_s1_w3 vn_op0_0000_s1_w3 0 sky130_fd_pr__nfet_01v8 L=0.15 W=1 nf=1 ad=0.29 as=0.29 pd=2.58 ps=2.58 mult=1 m=1
XMN2_op0_0000_s1_w3 ref_op0_0000_s1_w3 rbl_op0_0000_s1_w3 vn_op0_0000_s1_w3 0 sky130_fd_pr__nfet_01v8 L=0.15 W=1 nf=1 ad=0.29 as=0.29 pd=2.58 ps=2.58 mult=1 m=1
XMP1_op0_0000_s1_w3 rbl_op0_0000_s1_w3 ref_op0_0000_s1_w3 vp_op0_0000_s1_w3 vdd sky130_fd_pr__pfet_01v8 L=0.15 W=2 nf=1 ad=0.58 as=0.58 pd=4.58 ps=4.58 mult=1 m=1
XMP2_op0_0000_s1_w3 ref_op0_0000_s1_w3 rbl_op0_0000_s1_w3 vp_op0_0000_s1_w3 vdd sky130_fd_pr__pfet_01v8 L=0.15 W=2 nf=1 ad=0.58 as=0.58 pd=4.58 ps=4.58 mult=1 m=1
XMNF_op0_0000_s1_w3 vn_op0_0000_s1_w3 en_op0_0000_s1_w3 0 0 sky130_fd_pr__nfet_01v8 L=0.15 W=2 nf=1 ad=0.58 as=0.58 pd=4.58 ps=4.58 mult=1 m=1
XMPH_op0_0000_s1_w3 vp_op0_0000_s1_w3 enb_op0_0000_s1_w3 vdd vdd sky130_fd_pr__pfet_01v8 L=0.15 W=4 nf=1 ad=1.16 as=1.16 pd=8.58 ps=8.58 mult=1 m=1
bd_op0_0000_s1_w3 d_op0_0000_s1_w3 0 v=v(rbl_op0_0000_s1_w3)-v(ref_op0_0000_s1_w3)

* ---- instance 197: op0_0000_s1_w5 (t_en 5 ns, WWL 6..11 ns, release 13 ns) ----
ven_op0_0000_s1_w5  en_op0_0000_s1_w5  0 pwl(0 0 5.0000e-09 0 5.1000e-09 {VDD} 1.3000e-08 {VDD} 1.3100e-08 0)
venb_op0_0000_s1_w5 enb_op0_0000_s1_w5 0 pwl(0 {VDD} 5.0000e-09 {VDD} 5.1000e-09 0 1.3000e-08 0 1.3100e-08 {VDD})
vrs_op0_0000_s1_w5  rwls_op0_0000_s1_w5 0 pwl(0 {VDD} {T_READ} {VDD} {T_READ+TEDGE} 0 1.3000e-08 0 1.3100e-08 {VDD})
vww_op0_0000_s1_w5  wwl_op0_0000_s1_w5 0 pwl(0 0 6.0000e-09 0 6.1000e-09 {VDD} 1.1000e-08 {VDD} 1.1100e-08 0)
vwc_op0_0000_s1_w5  wbc_op0_0000_s1_w5 0 pwl(0 0 6.0000e-09 0 6.1000e-09 {VDD} 1.3000e-08 {VDD} 1.3100e-08 0)
swb_op0_0000_s1_w5 ref_op0_0000_s1_w5 wbl_op0_0000_s1_w5 wbc_op0_0000_s1_w5 0 swwbl
cwbl_op0_0000_s1_w5 wbl_op0_0000_s1_w5 0 {C_WBL}
spa_op0_0000_s1_w5 prea rbl_op0_0000_s1_w5 ctl 0 swpre
spr_op0_0000_s1_w5 pref ref_op0_0000_s1_w5 ctl 0 swpre
crbl_op0_0000_s1_w5 rbl_op0_0000_s1_w5 0 {C_RBL}
cref_op0_0000_s1_w5 ref_op0_0000_s1_w5 0 {C_RBL}   $ ASSUMPTION: ideal matched dummy load
XMWR_op0_0000_s1_w5_0 sn_op0_0000_s1_w5_0 wwl_op0_0000_s1_w5 wbl_op0_0000_s1_w5 0 sky130_fd_pr__nfet_01v8 L=0.15 W=0.42 nf=1 ad=0.1218 as=0.1218 pd=1.42 ps=1.42 nrd=0.69047619047619  nrs=0.69047619047619 sa=0 sb=0 sd=0 mult=1 m=1
XMRD_op0_0000_s1_w5_0 rbl_op0_0000_s1_w5 sn_op0_0000_s1_w5_0 rwls_op0_0000_s1_w5 0 sky130_fd_pr__nfet_01v8 L=0.15 W=0.42 nf=1 ad=0.1218 as=0.1218 pd=1.42 ps=1.42 nrd=0.69047619047619  nrs=0.69047619047619 sa=0 sb=0 sd=0 mult=1 m=1
csn_op0_0000_s1_w5_0 sn_op0_0000_s1_w5_0 0 {C_SN}
XMWR_op0_0000_s1_w5_1 sn_op0_0000_s1_w5_1 wwl_des wbl_op0_0000_s1_w5 0 sky130_fd_pr__nfet_01v8 L=0.15 W=0.42 nf=1 ad=0.1218 as=0.1218 pd=1.42 ps=1.42 nrd=0.69047619047619  nrs=0.69047619047619 sa=0 sb=0 sd=0 mult=1 m=1
XMRD_op0_0000_s1_w5_1 rbl_op0_0000_s1_w5 sn_op0_0000_s1_w5_1 rwl_des 0 sky130_fd_pr__nfet_01v8 L=0.15 W=0.42 nf=1 ad=0.1218 as=0.1218 pd=1.42 ps=1.42 nrd=0.69047619047619  nrs=0.69047619047619 sa=0 sb=0 sd=0 mult=1 m=1
csn_op0_0000_s1_w5_1 sn_op0_0000_s1_w5_1 0 {C_SN}
XMWR_op0_0000_s1_w5_2 sn_op0_0000_s1_w5_2 wwl_des wbl_op0_0000_s1_w5 0 sky130_fd_pr__nfet_01v8 L=0.15 W=0.42 nf=1 ad=0.1218 as=0.1218 pd=1.42 ps=1.42 nrd=0.69047619047619  nrs=0.69047619047619 sa=0 sb=0 sd=0 mult=1 m=1
XMRD_op0_0000_s1_w5_2 rbl_op0_0000_s1_w5 sn_op0_0000_s1_w5_2 rwl_des 0 sky130_fd_pr__nfet_01v8 L=0.15 W=0.42 nf=1 ad=0.1218 as=0.1218 pd=1.42 ps=1.42 nrd=0.69047619047619  nrs=0.69047619047619 sa=0 sb=0 sd=0 mult=1 m=1
csn_op0_0000_s1_w5_2 sn_op0_0000_s1_w5_2 0 {C_SN}
XMWR_op0_0000_s1_w5_3 sn_op0_0000_s1_w5_3 wwl_des wbl_op0_0000_s1_w5 0 sky130_fd_pr__nfet_01v8 L=0.15 W=0.42 nf=1 ad=0.1218 as=0.1218 pd=1.42 ps=1.42 nrd=0.69047619047619  nrs=0.69047619047619 sa=0 sb=0 sd=0 mult=1 m=1
XMRD_op0_0000_s1_w5_3 rbl_op0_0000_s1_w5 sn_op0_0000_s1_w5_3 rwl_des 0 sky130_fd_pr__nfet_01v8 L=0.15 W=0.42 nf=1 ad=0.1218 as=0.1218 pd=1.42 ps=1.42 nrd=0.69047619047619  nrs=0.69047619047619 sa=0 sb=0 sd=0 mult=1 m=1
csn_op0_0000_s1_w5_3 sn_op0_0000_s1_w5_3 0 {C_SN}
XMN1_op0_0000_s1_w5 rbl_op0_0000_s1_w5 ref_op0_0000_s1_w5 vn_op0_0000_s1_w5 0 sky130_fd_pr__nfet_01v8 L=0.15 W=1 nf=1 ad=0.29 as=0.29 pd=2.58 ps=2.58 mult=1 m=1
XMN2_op0_0000_s1_w5 ref_op0_0000_s1_w5 rbl_op0_0000_s1_w5 vn_op0_0000_s1_w5 0 sky130_fd_pr__nfet_01v8 L=0.15 W=1 nf=1 ad=0.29 as=0.29 pd=2.58 ps=2.58 mult=1 m=1
XMP1_op0_0000_s1_w5 rbl_op0_0000_s1_w5 ref_op0_0000_s1_w5 vp_op0_0000_s1_w5 vdd sky130_fd_pr__pfet_01v8 L=0.15 W=2 nf=1 ad=0.58 as=0.58 pd=4.58 ps=4.58 mult=1 m=1
XMP2_op0_0000_s1_w5 ref_op0_0000_s1_w5 rbl_op0_0000_s1_w5 vp_op0_0000_s1_w5 vdd sky130_fd_pr__pfet_01v8 L=0.15 W=2 nf=1 ad=0.58 as=0.58 pd=4.58 ps=4.58 mult=1 m=1
XMNF_op0_0000_s1_w5 vn_op0_0000_s1_w5 en_op0_0000_s1_w5 0 0 sky130_fd_pr__nfet_01v8 L=0.15 W=2 nf=1 ad=0.58 as=0.58 pd=4.58 ps=4.58 mult=1 m=1
XMPH_op0_0000_s1_w5 vp_op0_0000_s1_w5 enb_op0_0000_s1_w5 vdd vdd sky130_fd_pr__pfet_01v8 L=0.15 W=4 nf=1 ad=1.16 as=1.16 pd=8.58 ps=8.58 mult=1 m=1
bd_op0_0000_s1_w5 d_op0_0000_s1_w5 0 v=v(rbl_op0_0000_s1_w5)-v(ref_op0_0000_s1_w5)

* ---- instance 198: op0_0000_s1_w7p5 (t_en 5 ns, WWL 6..13.5 ns, release 15.5 ns) ----
ven_op0_0000_s1_w7p5  en_op0_0000_s1_w7p5  0 pwl(0 0 5.0000e-09 0 5.1000e-09 {VDD} 1.5500e-08 {VDD} 1.5600e-08 0)
venb_op0_0000_s1_w7p5 enb_op0_0000_s1_w7p5 0 pwl(0 {VDD} 5.0000e-09 {VDD} 5.1000e-09 0 1.5500e-08 0 1.5600e-08 {VDD})
vrs_op0_0000_s1_w7p5  rwls_op0_0000_s1_w7p5 0 pwl(0 {VDD} {T_READ} {VDD} {T_READ+TEDGE} 0 1.5500e-08 0 1.5600e-08 {VDD})
vww_op0_0000_s1_w7p5  wwl_op0_0000_s1_w7p5 0 pwl(0 0 6.0000e-09 0 6.1000e-09 {VDD} 1.3500e-08 {VDD} 1.3600e-08 0)
vwc_op0_0000_s1_w7p5  wbc_op0_0000_s1_w7p5 0 pwl(0 0 6.0000e-09 0 6.1000e-09 {VDD} 1.5500e-08 {VDD} 1.5600e-08 0)
swb_op0_0000_s1_w7p5 ref_op0_0000_s1_w7p5 wbl_op0_0000_s1_w7p5 wbc_op0_0000_s1_w7p5 0 swwbl
cwbl_op0_0000_s1_w7p5 wbl_op0_0000_s1_w7p5 0 {C_WBL}
spa_op0_0000_s1_w7p5 prea rbl_op0_0000_s1_w7p5 ctl 0 swpre
spr_op0_0000_s1_w7p5 pref ref_op0_0000_s1_w7p5 ctl 0 swpre
crbl_op0_0000_s1_w7p5 rbl_op0_0000_s1_w7p5 0 {C_RBL}
cref_op0_0000_s1_w7p5 ref_op0_0000_s1_w7p5 0 {C_RBL}   $ ASSUMPTION: ideal matched dummy load
XMWR_op0_0000_s1_w7p5_0 sn_op0_0000_s1_w7p5_0 wwl_op0_0000_s1_w7p5 wbl_op0_0000_s1_w7p5 0 sky130_fd_pr__nfet_01v8 L=0.15 W=0.42 nf=1 ad=0.1218 as=0.1218 pd=1.42 ps=1.42 nrd=0.69047619047619  nrs=0.69047619047619 sa=0 sb=0 sd=0 mult=1 m=1
XMRD_op0_0000_s1_w7p5_0 rbl_op0_0000_s1_w7p5 sn_op0_0000_s1_w7p5_0 rwls_op0_0000_s1_w7p5 0 sky130_fd_pr__nfet_01v8 L=0.15 W=0.42 nf=1 ad=0.1218 as=0.1218 pd=1.42 ps=1.42 nrd=0.69047619047619  nrs=0.69047619047619 sa=0 sb=0 sd=0 mult=1 m=1
csn_op0_0000_s1_w7p5_0 sn_op0_0000_s1_w7p5_0 0 {C_SN}
XMWR_op0_0000_s1_w7p5_1 sn_op0_0000_s1_w7p5_1 wwl_des wbl_op0_0000_s1_w7p5 0 sky130_fd_pr__nfet_01v8 L=0.15 W=0.42 nf=1 ad=0.1218 as=0.1218 pd=1.42 ps=1.42 nrd=0.69047619047619  nrs=0.69047619047619 sa=0 sb=0 sd=0 mult=1 m=1
XMRD_op0_0000_s1_w7p5_1 rbl_op0_0000_s1_w7p5 sn_op0_0000_s1_w7p5_1 rwl_des 0 sky130_fd_pr__nfet_01v8 L=0.15 W=0.42 nf=1 ad=0.1218 as=0.1218 pd=1.42 ps=1.42 nrd=0.69047619047619  nrs=0.69047619047619 sa=0 sb=0 sd=0 mult=1 m=1
csn_op0_0000_s1_w7p5_1 sn_op0_0000_s1_w7p5_1 0 {C_SN}
XMWR_op0_0000_s1_w7p5_2 sn_op0_0000_s1_w7p5_2 wwl_des wbl_op0_0000_s1_w7p5 0 sky130_fd_pr__nfet_01v8 L=0.15 W=0.42 nf=1 ad=0.1218 as=0.1218 pd=1.42 ps=1.42 nrd=0.69047619047619  nrs=0.69047619047619 sa=0 sb=0 sd=0 mult=1 m=1
XMRD_op0_0000_s1_w7p5_2 rbl_op0_0000_s1_w7p5 sn_op0_0000_s1_w7p5_2 rwl_des 0 sky130_fd_pr__nfet_01v8 L=0.15 W=0.42 nf=1 ad=0.1218 as=0.1218 pd=1.42 ps=1.42 nrd=0.69047619047619  nrs=0.69047619047619 sa=0 sb=0 sd=0 mult=1 m=1
csn_op0_0000_s1_w7p5_2 sn_op0_0000_s1_w7p5_2 0 {C_SN}
XMWR_op0_0000_s1_w7p5_3 sn_op0_0000_s1_w7p5_3 wwl_des wbl_op0_0000_s1_w7p5 0 sky130_fd_pr__nfet_01v8 L=0.15 W=0.42 nf=1 ad=0.1218 as=0.1218 pd=1.42 ps=1.42 nrd=0.69047619047619  nrs=0.69047619047619 sa=0 sb=0 sd=0 mult=1 m=1
XMRD_op0_0000_s1_w7p5_3 rbl_op0_0000_s1_w7p5 sn_op0_0000_s1_w7p5_3 rwl_des 0 sky130_fd_pr__nfet_01v8 L=0.15 W=0.42 nf=1 ad=0.1218 as=0.1218 pd=1.42 ps=1.42 nrd=0.69047619047619  nrs=0.69047619047619 sa=0 sb=0 sd=0 mult=1 m=1
csn_op0_0000_s1_w7p5_3 sn_op0_0000_s1_w7p5_3 0 {C_SN}
XMN1_op0_0000_s1_w7p5 rbl_op0_0000_s1_w7p5 ref_op0_0000_s1_w7p5 vn_op0_0000_s1_w7p5 0 sky130_fd_pr__nfet_01v8 L=0.15 W=1 nf=1 ad=0.29 as=0.29 pd=2.58 ps=2.58 mult=1 m=1
XMN2_op0_0000_s1_w7p5 ref_op0_0000_s1_w7p5 rbl_op0_0000_s1_w7p5 vn_op0_0000_s1_w7p5 0 sky130_fd_pr__nfet_01v8 L=0.15 W=1 nf=1 ad=0.29 as=0.29 pd=2.58 ps=2.58 mult=1 m=1
XMP1_op0_0000_s1_w7p5 rbl_op0_0000_s1_w7p5 ref_op0_0000_s1_w7p5 vp_op0_0000_s1_w7p5 vdd sky130_fd_pr__pfet_01v8 L=0.15 W=2 nf=1 ad=0.58 as=0.58 pd=4.58 ps=4.58 mult=1 m=1
XMP2_op0_0000_s1_w7p5 ref_op0_0000_s1_w7p5 rbl_op0_0000_s1_w7p5 vp_op0_0000_s1_w7p5 vdd sky130_fd_pr__pfet_01v8 L=0.15 W=2 nf=1 ad=0.58 as=0.58 pd=4.58 ps=4.58 mult=1 m=1
XMNF_op0_0000_s1_w7p5 vn_op0_0000_s1_w7p5 en_op0_0000_s1_w7p5 0 0 sky130_fd_pr__nfet_01v8 L=0.15 W=2 nf=1 ad=0.58 as=0.58 pd=4.58 ps=4.58 mult=1 m=1
XMPH_op0_0000_s1_w7p5 vp_op0_0000_s1_w7p5 enb_op0_0000_s1_w7p5 vdd vdd sky130_fd_pr__pfet_01v8 L=0.15 W=4 nf=1 ad=1.16 as=1.16 pd=8.58 ps=8.58 mult=1 m=1
bd_op0_0000_s1_w7p5 d_op0_0000_s1_w7p5 0 v=v(rbl_op0_0000_s1_w7p5)-v(ref_op0_0000_s1_w7p5)

* ---- instance 199: op0_0000_s1_w10 (t_en 5 ns, WWL 6..16 ns, release 18 ns) ----
ven_op0_0000_s1_w10  en_op0_0000_s1_w10  0 pwl(0 0 5.0000e-09 0 5.1000e-09 {VDD} 1.8000e-08 {VDD} 1.8100e-08 0)
venb_op0_0000_s1_w10 enb_op0_0000_s1_w10 0 pwl(0 {VDD} 5.0000e-09 {VDD} 5.1000e-09 0 1.8000e-08 0 1.8100e-08 {VDD})
vrs_op0_0000_s1_w10  rwls_op0_0000_s1_w10 0 pwl(0 {VDD} {T_READ} {VDD} {T_READ+TEDGE} 0 1.8000e-08 0 1.8100e-08 {VDD})
vww_op0_0000_s1_w10  wwl_op0_0000_s1_w10 0 pwl(0 0 6.0000e-09 0 6.1000e-09 {VDD} 1.6000e-08 {VDD} 1.6100e-08 0)
vwc_op0_0000_s1_w10  wbc_op0_0000_s1_w10 0 pwl(0 0 6.0000e-09 0 6.1000e-09 {VDD} 1.8000e-08 {VDD} 1.8100e-08 0)
swb_op0_0000_s1_w10 ref_op0_0000_s1_w10 wbl_op0_0000_s1_w10 wbc_op0_0000_s1_w10 0 swwbl
cwbl_op0_0000_s1_w10 wbl_op0_0000_s1_w10 0 {C_WBL}
spa_op0_0000_s1_w10 prea rbl_op0_0000_s1_w10 ctl 0 swpre
spr_op0_0000_s1_w10 pref ref_op0_0000_s1_w10 ctl 0 swpre
crbl_op0_0000_s1_w10 rbl_op0_0000_s1_w10 0 {C_RBL}
cref_op0_0000_s1_w10 ref_op0_0000_s1_w10 0 {C_RBL}   $ ASSUMPTION: ideal matched dummy load
XMWR_op0_0000_s1_w10_0 sn_op0_0000_s1_w10_0 wwl_op0_0000_s1_w10 wbl_op0_0000_s1_w10 0 sky130_fd_pr__nfet_01v8 L=0.15 W=0.42 nf=1 ad=0.1218 as=0.1218 pd=1.42 ps=1.42 nrd=0.69047619047619  nrs=0.69047619047619 sa=0 sb=0 sd=0 mult=1 m=1
XMRD_op0_0000_s1_w10_0 rbl_op0_0000_s1_w10 sn_op0_0000_s1_w10_0 rwls_op0_0000_s1_w10 0 sky130_fd_pr__nfet_01v8 L=0.15 W=0.42 nf=1 ad=0.1218 as=0.1218 pd=1.42 ps=1.42 nrd=0.69047619047619  nrs=0.69047619047619 sa=0 sb=0 sd=0 mult=1 m=1
csn_op0_0000_s1_w10_0 sn_op0_0000_s1_w10_0 0 {C_SN}
XMWR_op0_0000_s1_w10_1 sn_op0_0000_s1_w10_1 wwl_des wbl_op0_0000_s1_w10 0 sky130_fd_pr__nfet_01v8 L=0.15 W=0.42 nf=1 ad=0.1218 as=0.1218 pd=1.42 ps=1.42 nrd=0.69047619047619  nrs=0.69047619047619 sa=0 sb=0 sd=0 mult=1 m=1
XMRD_op0_0000_s1_w10_1 rbl_op0_0000_s1_w10 sn_op0_0000_s1_w10_1 rwl_des 0 sky130_fd_pr__nfet_01v8 L=0.15 W=0.42 nf=1 ad=0.1218 as=0.1218 pd=1.42 ps=1.42 nrd=0.69047619047619  nrs=0.69047619047619 sa=0 sb=0 sd=0 mult=1 m=1
csn_op0_0000_s1_w10_1 sn_op0_0000_s1_w10_1 0 {C_SN}
XMWR_op0_0000_s1_w10_2 sn_op0_0000_s1_w10_2 wwl_des wbl_op0_0000_s1_w10 0 sky130_fd_pr__nfet_01v8 L=0.15 W=0.42 nf=1 ad=0.1218 as=0.1218 pd=1.42 ps=1.42 nrd=0.69047619047619  nrs=0.69047619047619 sa=0 sb=0 sd=0 mult=1 m=1
XMRD_op0_0000_s1_w10_2 rbl_op0_0000_s1_w10 sn_op0_0000_s1_w10_2 rwl_des 0 sky130_fd_pr__nfet_01v8 L=0.15 W=0.42 nf=1 ad=0.1218 as=0.1218 pd=1.42 ps=1.42 nrd=0.69047619047619  nrs=0.69047619047619 sa=0 sb=0 sd=0 mult=1 m=1
csn_op0_0000_s1_w10_2 sn_op0_0000_s1_w10_2 0 {C_SN}
XMWR_op0_0000_s1_w10_3 sn_op0_0000_s1_w10_3 wwl_des wbl_op0_0000_s1_w10 0 sky130_fd_pr__nfet_01v8 L=0.15 W=0.42 nf=1 ad=0.1218 as=0.1218 pd=1.42 ps=1.42 nrd=0.69047619047619  nrs=0.69047619047619 sa=0 sb=0 sd=0 mult=1 m=1
XMRD_op0_0000_s1_w10_3 rbl_op0_0000_s1_w10 sn_op0_0000_s1_w10_3 rwl_des 0 sky130_fd_pr__nfet_01v8 L=0.15 W=0.42 nf=1 ad=0.1218 as=0.1218 pd=1.42 ps=1.42 nrd=0.69047619047619  nrs=0.69047619047619 sa=0 sb=0 sd=0 mult=1 m=1
csn_op0_0000_s1_w10_3 sn_op0_0000_s1_w10_3 0 {C_SN}
XMN1_op0_0000_s1_w10 rbl_op0_0000_s1_w10 ref_op0_0000_s1_w10 vn_op0_0000_s1_w10 0 sky130_fd_pr__nfet_01v8 L=0.15 W=1 nf=1 ad=0.29 as=0.29 pd=2.58 ps=2.58 mult=1 m=1
XMN2_op0_0000_s1_w10 ref_op0_0000_s1_w10 rbl_op0_0000_s1_w10 vn_op0_0000_s1_w10 0 sky130_fd_pr__nfet_01v8 L=0.15 W=1 nf=1 ad=0.29 as=0.29 pd=2.58 ps=2.58 mult=1 m=1
XMP1_op0_0000_s1_w10 rbl_op0_0000_s1_w10 ref_op0_0000_s1_w10 vp_op0_0000_s1_w10 vdd sky130_fd_pr__pfet_01v8 L=0.15 W=2 nf=1 ad=0.58 as=0.58 pd=4.58 ps=4.58 mult=1 m=1
XMP2_op0_0000_s1_w10 ref_op0_0000_s1_w10 rbl_op0_0000_s1_w10 vp_op0_0000_s1_w10 vdd sky130_fd_pr__pfet_01v8 L=0.15 W=2 nf=1 ad=0.58 as=0.58 pd=4.58 ps=4.58 mult=1 m=1
XMNF_op0_0000_s1_w10 vn_op0_0000_s1_w10 en_op0_0000_s1_w10 0 0 sky130_fd_pr__nfet_01v8 L=0.15 W=2 nf=1 ad=0.58 as=0.58 pd=4.58 ps=4.58 mult=1 m=1
XMPH_op0_0000_s1_w10 vp_op0_0000_s1_w10 enb_op0_0000_s1_w10 vdd vdd sky130_fd_pr__pfet_01v8 L=0.15 W=4 nf=1 ad=1.16 as=1.16 pd=8.58 ps=8.58 mult=1 m=1
bd_op0_0000_s1_w10 d_op0_0000_s1_w10 0 v=v(rbl_op0_0000_s1_w10)-v(ref_op0_0000_s1_w10)

* ---- instance 200: op0_0000_s1_w15 (t_en 5 ns, WWL 6..21 ns, release 23 ns) ----
ven_op0_0000_s1_w15  en_op0_0000_s1_w15  0 pwl(0 0 5.0000e-09 0 5.1000e-09 {VDD} 2.3000e-08 {VDD} 2.3100e-08 0)
venb_op0_0000_s1_w15 enb_op0_0000_s1_w15 0 pwl(0 {VDD} 5.0000e-09 {VDD} 5.1000e-09 0 2.3000e-08 0 2.3100e-08 {VDD})
vrs_op0_0000_s1_w15  rwls_op0_0000_s1_w15 0 pwl(0 {VDD} {T_READ} {VDD} {T_READ+TEDGE} 0 2.3000e-08 0 2.3100e-08 {VDD})
vww_op0_0000_s1_w15  wwl_op0_0000_s1_w15 0 pwl(0 0 6.0000e-09 0 6.1000e-09 {VDD} 2.1000e-08 {VDD} 2.1100e-08 0)
vwc_op0_0000_s1_w15  wbc_op0_0000_s1_w15 0 pwl(0 0 6.0000e-09 0 6.1000e-09 {VDD} 2.3000e-08 {VDD} 2.3100e-08 0)
swb_op0_0000_s1_w15 ref_op0_0000_s1_w15 wbl_op0_0000_s1_w15 wbc_op0_0000_s1_w15 0 swwbl
cwbl_op0_0000_s1_w15 wbl_op0_0000_s1_w15 0 {C_WBL}
spa_op0_0000_s1_w15 prea rbl_op0_0000_s1_w15 ctl 0 swpre
spr_op0_0000_s1_w15 pref ref_op0_0000_s1_w15 ctl 0 swpre
crbl_op0_0000_s1_w15 rbl_op0_0000_s1_w15 0 {C_RBL}
cref_op0_0000_s1_w15 ref_op0_0000_s1_w15 0 {C_RBL}   $ ASSUMPTION: ideal matched dummy load
XMWR_op0_0000_s1_w15_0 sn_op0_0000_s1_w15_0 wwl_op0_0000_s1_w15 wbl_op0_0000_s1_w15 0 sky130_fd_pr__nfet_01v8 L=0.15 W=0.42 nf=1 ad=0.1218 as=0.1218 pd=1.42 ps=1.42 nrd=0.69047619047619  nrs=0.69047619047619 sa=0 sb=0 sd=0 mult=1 m=1
XMRD_op0_0000_s1_w15_0 rbl_op0_0000_s1_w15 sn_op0_0000_s1_w15_0 rwls_op0_0000_s1_w15 0 sky130_fd_pr__nfet_01v8 L=0.15 W=0.42 nf=1 ad=0.1218 as=0.1218 pd=1.42 ps=1.42 nrd=0.69047619047619  nrs=0.69047619047619 sa=0 sb=0 sd=0 mult=1 m=1
csn_op0_0000_s1_w15_0 sn_op0_0000_s1_w15_0 0 {C_SN}
XMWR_op0_0000_s1_w15_1 sn_op0_0000_s1_w15_1 wwl_des wbl_op0_0000_s1_w15 0 sky130_fd_pr__nfet_01v8 L=0.15 W=0.42 nf=1 ad=0.1218 as=0.1218 pd=1.42 ps=1.42 nrd=0.69047619047619  nrs=0.69047619047619 sa=0 sb=0 sd=0 mult=1 m=1
XMRD_op0_0000_s1_w15_1 rbl_op0_0000_s1_w15 sn_op0_0000_s1_w15_1 rwl_des 0 sky130_fd_pr__nfet_01v8 L=0.15 W=0.42 nf=1 ad=0.1218 as=0.1218 pd=1.42 ps=1.42 nrd=0.69047619047619  nrs=0.69047619047619 sa=0 sb=0 sd=0 mult=1 m=1
csn_op0_0000_s1_w15_1 sn_op0_0000_s1_w15_1 0 {C_SN}
XMWR_op0_0000_s1_w15_2 sn_op0_0000_s1_w15_2 wwl_des wbl_op0_0000_s1_w15 0 sky130_fd_pr__nfet_01v8 L=0.15 W=0.42 nf=1 ad=0.1218 as=0.1218 pd=1.42 ps=1.42 nrd=0.69047619047619  nrs=0.69047619047619 sa=0 sb=0 sd=0 mult=1 m=1
XMRD_op0_0000_s1_w15_2 rbl_op0_0000_s1_w15 sn_op0_0000_s1_w15_2 rwl_des 0 sky130_fd_pr__nfet_01v8 L=0.15 W=0.42 nf=1 ad=0.1218 as=0.1218 pd=1.42 ps=1.42 nrd=0.69047619047619  nrs=0.69047619047619 sa=0 sb=0 sd=0 mult=1 m=1
csn_op0_0000_s1_w15_2 sn_op0_0000_s1_w15_2 0 {C_SN}
XMWR_op0_0000_s1_w15_3 sn_op0_0000_s1_w15_3 wwl_des wbl_op0_0000_s1_w15 0 sky130_fd_pr__nfet_01v8 L=0.15 W=0.42 nf=1 ad=0.1218 as=0.1218 pd=1.42 ps=1.42 nrd=0.69047619047619  nrs=0.69047619047619 sa=0 sb=0 sd=0 mult=1 m=1
XMRD_op0_0000_s1_w15_3 rbl_op0_0000_s1_w15 sn_op0_0000_s1_w15_3 rwl_des 0 sky130_fd_pr__nfet_01v8 L=0.15 W=0.42 nf=1 ad=0.1218 as=0.1218 pd=1.42 ps=1.42 nrd=0.69047619047619  nrs=0.69047619047619 sa=0 sb=0 sd=0 mult=1 m=1
csn_op0_0000_s1_w15_3 sn_op0_0000_s1_w15_3 0 {C_SN}
XMN1_op0_0000_s1_w15 rbl_op0_0000_s1_w15 ref_op0_0000_s1_w15 vn_op0_0000_s1_w15 0 sky130_fd_pr__nfet_01v8 L=0.15 W=1 nf=1 ad=0.29 as=0.29 pd=2.58 ps=2.58 mult=1 m=1
XMN2_op0_0000_s1_w15 ref_op0_0000_s1_w15 rbl_op0_0000_s1_w15 vn_op0_0000_s1_w15 0 sky130_fd_pr__nfet_01v8 L=0.15 W=1 nf=1 ad=0.29 as=0.29 pd=2.58 ps=2.58 mult=1 m=1
XMP1_op0_0000_s1_w15 rbl_op0_0000_s1_w15 ref_op0_0000_s1_w15 vp_op0_0000_s1_w15 vdd sky130_fd_pr__pfet_01v8 L=0.15 W=2 nf=1 ad=0.58 as=0.58 pd=4.58 ps=4.58 mult=1 m=1
XMP2_op0_0000_s1_w15 ref_op0_0000_s1_w15 rbl_op0_0000_s1_w15 vp_op0_0000_s1_w15 vdd sky130_fd_pr__pfet_01v8 L=0.15 W=2 nf=1 ad=0.58 as=0.58 pd=4.58 ps=4.58 mult=1 m=1
XMNF_op0_0000_s1_w15 vn_op0_0000_s1_w15 en_op0_0000_s1_w15 0 0 sky130_fd_pr__nfet_01v8 L=0.15 W=2 nf=1 ad=0.58 as=0.58 pd=4.58 ps=4.58 mult=1 m=1
XMPH_op0_0000_s1_w15 vp_op0_0000_s1_w15 enb_op0_0000_s1_w15 vdd vdd sky130_fd_pr__pfet_01v8 L=0.15 W=4 nf=1 ad=1.16 as=1.16 pd=8.58 ps=8.58 mult=1 m=1
bd_op0_0000_s1_w15 d_op0_0000_s1_w15 0 v=v(rbl_op0_0000_s1_w15)-v(ref_op0_0000_s1_w15)

* ---- instance 201: op0_0000_s1_w20 (t_en 5 ns, WWL 6..26 ns, release 28 ns) ----
ven_op0_0000_s1_w20  en_op0_0000_s1_w20  0 pwl(0 0 5.0000e-09 0 5.1000e-09 {VDD} 2.8000e-08 {VDD} 2.8100e-08 0)
venb_op0_0000_s1_w20 enb_op0_0000_s1_w20 0 pwl(0 {VDD} 5.0000e-09 {VDD} 5.1000e-09 0 2.8000e-08 0 2.8100e-08 {VDD})
vrs_op0_0000_s1_w20  rwls_op0_0000_s1_w20 0 pwl(0 {VDD} {T_READ} {VDD} {T_READ+TEDGE} 0 2.8000e-08 0 2.8100e-08 {VDD})
vww_op0_0000_s1_w20  wwl_op0_0000_s1_w20 0 pwl(0 0 6.0000e-09 0 6.1000e-09 {VDD} 2.6000e-08 {VDD} 2.6100e-08 0)
vwc_op0_0000_s1_w20  wbc_op0_0000_s1_w20 0 pwl(0 0 6.0000e-09 0 6.1000e-09 {VDD} 2.8000e-08 {VDD} 2.8100e-08 0)
swb_op0_0000_s1_w20 ref_op0_0000_s1_w20 wbl_op0_0000_s1_w20 wbc_op0_0000_s1_w20 0 swwbl
cwbl_op0_0000_s1_w20 wbl_op0_0000_s1_w20 0 {C_WBL}
spa_op0_0000_s1_w20 prea rbl_op0_0000_s1_w20 ctl 0 swpre
spr_op0_0000_s1_w20 pref ref_op0_0000_s1_w20 ctl 0 swpre
crbl_op0_0000_s1_w20 rbl_op0_0000_s1_w20 0 {C_RBL}
cref_op0_0000_s1_w20 ref_op0_0000_s1_w20 0 {C_RBL}   $ ASSUMPTION: ideal matched dummy load
XMWR_op0_0000_s1_w20_0 sn_op0_0000_s1_w20_0 wwl_op0_0000_s1_w20 wbl_op0_0000_s1_w20 0 sky130_fd_pr__nfet_01v8 L=0.15 W=0.42 nf=1 ad=0.1218 as=0.1218 pd=1.42 ps=1.42 nrd=0.69047619047619  nrs=0.69047619047619 sa=0 sb=0 sd=0 mult=1 m=1
XMRD_op0_0000_s1_w20_0 rbl_op0_0000_s1_w20 sn_op0_0000_s1_w20_0 rwls_op0_0000_s1_w20 0 sky130_fd_pr__nfet_01v8 L=0.15 W=0.42 nf=1 ad=0.1218 as=0.1218 pd=1.42 ps=1.42 nrd=0.69047619047619  nrs=0.69047619047619 sa=0 sb=0 sd=0 mult=1 m=1
csn_op0_0000_s1_w20_0 sn_op0_0000_s1_w20_0 0 {C_SN}
XMWR_op0_0000_s1_w20_1 sn_op0_0000_s1_w20_1 wwl_des wbl_op0_0000_s1_w20 0 sky130_fd_pr__nfet_01v8 L=0.15 W=0.42 nf=1 ad=0.1218 as=0.1218 pd=1.42 ps=1.42 nrd=0.69047619047619  nrs=0.69047619047619 sa=0 sb=0 sd=0 mult=1 m=1
XMRD_op0_0000_s1_w20_1 rbl_op0_0000_s1_w20 sn_op0_0000_s1_w20_1 rwl_des 0 sky130_fd_pr__nfet_01v8 L=0.15 W=0.42 nf=1 ad=0.1218 as=0.1218 pd=1.42 ps=1.42 nrd=0.69047619047619  nrs=0.69047619047619 sa=0 sb=0 sd=0 mult=1 m=1
csn_op0_0000_s1_w20_1 sn_op0_0000_s1_w20_1 0 {C_SN}
XMWR_op0_0000_s1_w20_2 sn_op0_0000_s1_w20_2 wwl_des wbl_op0_0000_s1_w20 0 sky130_fd_pr__nfet_01v8 L=0.15 W=0.42 nf=1 ad=0.1218 as=0.1218 pd=1.42 ps=1.42 nrd=0.69047619047619  nrs=0.69047619047619 sa=0 sb=0 sd=0 mult=1 m=1
XMRD_op0_0000_s1_w20_2 rbl_op0_0000_s1_w20 sn_op0_0000_s1_w20_2 rwl_des 0 sky130_fd_pr__nfet_01v8 L=0.15 W=0.42 nf=1 ad=0.1218 as=0.1218 pd=1.42 ps=1.42 nrd=0.69047619047619  nrs=0.69047619047619 sa=0 sb=0 sd=0 mult=1 m=1
csn_op0_0000_s1_w20_2 sn_op0_0000_s1_w20_2 0 {C_SN}
XMWR_op0_0000_s1_w20_3 sn_op0_0000_s1_w20_3 wwl_des wbl_op0_0000_s1_w20 0 sky130_fd_pr__nfet_01v8 L=0.15 W=0.42 nf=1 ad=0.1218 as=0.1218 pd=1.42 ps=1.42 nrd=0.69047619047619  nrs=0.69047619047619 sa=0 sb=0 sd=0 mult=1 m=1
XMRD_op0_0000_s1_w20_3 rbl_op0_0000_s1_w20 sn_op0_0000_s1_w20_3 rwl_des 0 sky130_fd_pr__nfet_01v8 L=0.15 W=0.42 nf=1 ad=0.1218 as=0.1218 pd=1.42 ps=1.42 nrd=0.69047619047619  nrs=0.69047619047619 sa=0 sb=0 sd=0 mult=1 m=1
csn_op0_0000_s1_w20_3 sn_op0_0000_s1_w20_3 0 {C_SN}
XMN1_op0_0000_s1_w20 rbl_op0_0000_s1_w20 ref_op0_0000_s1_w20 vn_op0_0000_s1_w20 0 sky130_fd_pr__nfet_01v8 L=0.15 W=1 nf=1 ad=0.29 as=0.29 pd=2.58 ps=2.58 mult=1 m=1
XMN2_op0_0000_s1_w20 ref_op0_0000_s1_w20 rbl_op0_0000_s1_w20 vn_op0_0000_s1_w20 0 sky130_fd_pr__nfet_01v8 L=0.15 W=1 nf=1 ad=0.29 as=0.29 pd=2.58 ps=2.58 mult=1 m=1
XMP1_op0_0000_s1_w20 rbl_op0_0000_s1_w20 ref_op0_0000_s1_w20 vp_op0_0000_s1_w20 vdd sky130_fd_pr__pfet_01v8 L=0.15 W=2 nf=1 ad=0.58 as=0.58 pd=4.58 ps=4.58 mult=1 m=1
XMP2_op0_0000_s1_w20 ref_op0_0000_s1_w20 rbl_op0_0000_s1_w20 vp_op0_0000_s1_w20 vdd sky130_fd_pr__pfet_01v8 L=0.15 W=2 nf=1 ad=0.58 as=0.58 pd=4.58 ps=4.58 mult=1 m=1
XMNF_op0_0000_s1_w20 vn_op0_0000_s1_w20 en_op0_0000_s1_w20 0 0 sky130_fd_pr__nfet_01v8 L=0.15 W=2 nf=1 ad=0.58 as=0.58 pd=4.58 ps=4.58 mult=1 m=1
XMPH_op0_0000_s1_w20 vp_op0_0000_s1_w20 enb_op0_0000_s1_w20 vdd vdd sky130_fd_pr__pfet_01v8 L=0.15 W=4 nf=1 ad=1.16 as=1.16 pd=8.58 ps=8.58 mult=1 m=1
bd_op0_0000_s1_w20 d_op0_0000_s1_w20 0 v=v(rbl_op0_0000_s1_w20)-v(ref_op0_0000_s1_w20)

* ---- instance 202: op0_0000_s1_w30 (t_en 5 ns, WWL 6..36 ns, release 38 ns) ----
ven_op0_0000_s1_w30  en_op0_0000_s1_w30  0 pwl(0 0 5.0000e-09 0 5.1000e-09 {VDD} 3.8000e-08 {VDD} 3.8100e-08 0)
venb_op0_0000_s1_w30 enb_op0_0000_s1_w30 0 pwl(0 {VDD} 5.0000e-09 {VDD} 5.1000e-09 0 3.8000e-08 0 3.8100e-08 {VDD})
vrs_op0_0000_s1_w30  rwls_op0_0000_s1_w30 0 pwl(0 {VDD} {T_READ} {VDD} {T_READ+TEDGE} 0 3.8000e-08 0 3.8100e-08 {VDD})
vww_op0_0000_s1_w30  wwl_op0_0000_s1_w30 0 pwl(0 0 6.0000e-09 0 6.1000e-09 {VDD} 3.6000e-08 {VDD} 3.6100e-08 0)
vwc_op0_0000_s1_w30  wbc_op0_0000_s1_w30 0 pwl(0 0 6.0000e-09 0 6.1000e-09 {VDD} 3.8000e-08 {VDD} 3.8100e-08 0)
swb_op0_0000_s1_w30 ref_op0_0000_s1_w30 wbl_op0_0000_s1_w30 wbc_op0_0000_s1_w30 0 swwbl
cwbl_op0_0000_s1_w30 wbl_op0_0000_s1_w30 0 {C_WBL}
spa_op0_0000_s1_w30 prea rbl_op0_0000_s1_w30 ctl 0 swpre
spr_op0_0000_s1_w30 pref ref_op0_0000_s1_w30 ctl 0 swpre
crbl_op0_0000_s1_w30 rbl_op0_0000_s1_w30 0 {C_RBL}
cref_op0_0000_s1_w30 ref_op0_0000_s1_w30 0 {C_RBL}   $ ASSUMPTION: ideal matched dummy load
XMWR_op0_0000_s1_w30_0 sn_op0_0000_s1_w30_0 wwl_op0_0000_s1_w30 wbl_op0_0000_s1_w30 0 sky130_fd_pr__nfet_01v8 L=0.15 W=0.42 nf=1 ad=0.1218 as=0.1218 pd=1.42 ps=1.42 nrd=0.69047619047619  nrs=0.69047619047619 sa=0 sb=0 sd=0 mult=1 m=1
XMRD_op0_0000_s1_w30_0 rbl_op0_0000_s1_w30 sn_op0_0000_s1_w30_0 rwls_op0_0000_s1_w30 0 sky130_fd_pr__nfet_01v8 L=0.15 W=0.42 nf=1 ad=0.1218 as=0.1218 pd=1.42 ps=1.42 nrd=0.69047619047619  nrs=0.69047619047619 sa=0 sb=0 sd=0 mult=1 m=1
csn_op0_0000_s1_w30_0 sn_op0_0000_s1_w30_0 0 {C_SN}
XMWR_op0_0000_s1_w30_1 sn_op0_0000_s1_w30_1 wwl_des wbl_op0_0000_s1_w30 0 sky130_fd_pr__nfet_01v8 L=0.15 W=0.42 nf=1 ad=0.1218 as=0.1218 pd=1.42 ps=1.42 nrd=0.69047619047619  nrs=0.69047619047619 sa=0 sb=0 sd=0 mult=1 m=1
XMRD_op0_0000_s1_w30_1 rbl_op0_0000_s1_w30 sn_op0_0000_s1_w30_1 rwl_des 0 sky130_fd_pr__nfet_01v8 L=0.15 W=0.42 nf=1 ad=0.1218 as=0.1218 pd=1.42 ps=1.42 nrd=0.69047619047619  nrs=0.69047619047619 sa=0 sb=0 sd=0 mult=1 m=1
csn_op0_0000_s1_w30_1 sn_op0_0000_s1_w30_1 0 {C_SN}
XMWR_op0_0000_s1_w30_2 sn_op0_0000_s1_w30_2 wwl_des wbl_op0_0000_s1_w30 0 sky130_fd_pr__nfet_01v8 L=0.15 W=0.42 nf=1 ad=0.1218 as=0.1218 pd=1.42 ps=1.42 nrd=0.69047619047619  nrs=0.69047619047619 sa=0 sb=0 sd=0 mult=1 m=1
XMRD_op0_0000_s1_w30_2 rbl_op0_0000_s1_w30 sn_op0_0000_s1_w30_2 rwl_des 0 sky130_fd_pr__nfet_01v8 L=0.15 W=0.42 nf=1 ad=0.1218 as=0.1218 pd=1.42 ps=1.42 nrd=0.69047619047619  nrs=0.69047619047619 sa=0 sb=0 sd=0 mult=1 m=1
csn_op0_0000_s1_w30_2 sn_op0_0000_s1_w30_2 0 {C_SN}
XMWR_op0_0000_s1_w30_3 sn_op0_0000_s1_w30_3 wwl_des wbl_op0_0000_s1_w30 0 sky130_fd_pr__nfet_01v8 L=0.15 W=0.42 nf=1 ad=0.1218 as=0.1218 pd=1.42 ps=1.42 nrd=0.69047619047619  nrs=0.69047619047619 sa=0 sb=0 sd=0 mult=1 m=1
XMRD_op0_0000_s1_w30_3 rbl_op0_0000_s1_w30 sn_op0_0000_s1_w30_3 rwl_des 0 sky130_fd_pr__nfet_01v8 L=0.15 W=0.42 nf=1 ad=0.1218 as=0.1218 pd=1.42 ps=1.42 nrd=0.69047619047619  nrs=0.69047619047619 sa=0 sb=0 sd=0 mult=1 m=1
csn_op0_0000_s1_w30_3 sn_op0_0000_s1_w30_3 0 {C_SN}
XMN1_op0_0000_s1_w30 rbl_op0_0000_s1_w30 ref_op0_0000_s1_w30 vn_op0_0000_s1_w30 0 sky130_fd_pr__nfet_01v8 L=0.15 W=1 nf=1 ad=0.29 as=0.29 pd=2.58 ps=2.58 mult=1 m=1
XMN2_op0_0000_s1_w30 ref_op0_0000_s1_w30 rbl_op0_0000_s1_w30 vn_op0_0000_s1_w30 0 sky130_fd_pr__nfet_01v8 L=0.15 W=1 nf=1 ad=0.29 as=0.29 pd=2.58 ps=2.58 mult=1 m=1
XMP1_op0_0000_s1_w30 rbl_op0_0000_s1_w30 ref_op0_0000_s1_w30 vp_op0_0000_s1_w30 vdd sky130_fd_pr__pfet_01v8 L=0.15 W=2 nf=1 ad=0.58 as=0.58 pd=4.58 ps=4.58 mult=1 m=1
XMP2_op0_0000_s1_w30 ref_op0_0000_s1_w30 rbl_op0_0000_s1_w30 vp_op0_0000_s1_w30 vdd sky130_fd_pr__pfet_01v8 L=0.15 W=2 nf=1 ad=0.58 as=0.58 pd=4.58 ps=4.58 mult=1 m=1
XMNF_op0_0000_s1_w30 vn_op0_0000_s1_w30 en_op0_0000_s1_w30 0 0 sky130_fd_pr__nfet_01v8 L=0.15 W=2 nf=1 ad=0.58 as=0.58 pd=4.58 ps=4.58 mult=1 m=1
XMPH_op0_0000_s1_w30 vp_op0_0000_s1_w30 enb_op0_0000_s1_w30 vdd vdd sky130_fd_pr__pfet_01v8 L=0.15 W=4 nf=1 ad=1.16 as=1.16 pd=8.58 ps=8.58 mult=1 m=1
bd_op0_0000_s1_w30 d_op0_0000_s1_w30 0 v=v(rbl_op0_0000_s1_w30)-v(ref_op0_0000_s1_w30)

* ---- instance 203: op0_0000_s1_w50 (t_en 5 ns, WWL 6..56 ns, release 58 ns) ----
ven_op0_0000_s1_w50  en_op0_0000_s1_w50  0 pwl(0 0 5.0000e-09 0 5.1000e-09 {VDD} 5.8000e-08 {VDD} 5.8100e-08 0)
venb_op0_0000_s1_w50 enb_op0_0000_s1_w50 0 pwl(0 {VDD} 5.0000e-09 {VDD} 5.1000e-09 0 5.8000e-08 0 5.8100e-08 {VDD})
vrs_op0_0000_s1_w50  rwls_op0_0000_s1_w50 0 pwl(0 {VDD} {T_READ} {VDD} {T_READ+TEDGE} 0 5.8000e-08 0 5.8100e-08 {VDD})
vww_op0_0000_s1_w50  wwl_op0_0000_s1_w50 0 pwl(0 0 6.0000e-09 0 6.1000e-09 {VDD} 5.6000e-08 {VDD} 5.6100e-08 0)
vwc_op0_0000_s1_w50  wbc_op0_0000_s1_w50 0 pwl(0 0 6.0000e-09 0 6.1000e-09 {VDD} 5.8000e-08 {VDD} 5.8100e-08 0)
swb_op0_0000_s1_w50 ref_op0_0000_s1_w50 wbl_op0_0000_s1_w50 wbc_op0_0000_s1_w50 0 swwbl
cwbl_op0_0000_s1_w50 wbl_op0_0000_s1_w50 0 {C_WBL}
spa_op0_0000_s1_w50 prea rbl_op0_0000_s1_w50 ctl 0 swpre
spr_op0_0000_s1_w50 pref ref_op0_0000_s1_w50 ctl 0 swpre
crbl_op0_0000_s1_w50 rbl_op0_0000_s1_w50 0 {C_RBL}
cref_op0_0000_s1_w50 ref_op0_0000_s1_w50 0 {C_RBL}   $ ASSUMPTION: ideal matched dummy load
XMWR_op0_0000_s1_w50_0 sn_op0_0000_s1_w50_0 wwl_op0_0000_s1_w50 wbl_op0_0000_s1_w50 0 sky130_fd_pr__nfet_01v8 L=0.15 W=0.42 nf=1 ad=0.1218 as=0.1218 pd=1.42 ps=1.42 nrd=0.69047619047619  nrs=0.69047619047619 sa=0 sb=0 sd=0 mult=1 m=1
XMRD_op0_0000_s1_w50_0 rbl_op0_0000_s1_w50 sn_op0_0000_s1_w50_0 rwls_op0_0000_s1_w50 0 sky130_fd_pr__nfet_01v8 L=0.15 W=0.42 nf=1 ad=0.1218 as=0.1218 pd=1.42 ps=1.42 nrd=0.69047619047619  nrs=0.69047619047619 sa=0 sb=0 sd=0 mult=1 m=1
csn_op0_0000_s1_w50_0 sn_op0_0000_s1_w50_0 0 {C_SN}
XMWR_op0_0000_s1_w50_1 sn_op0_0000_s1_w50_1 wwl_des wbl_op0_0000_s1_w50 0 sky130_fd_pr__nfet_01v8 L=0.15 W=0.42 nf=1 ad=0.1218 as=0.1218 pd=1.42 ps=1.42 nrd=0.69047619047619  nrs=0.69047619047619 sa=0 sb=0 sd=0 mult=1 m=1
XMRD_op0_0000_s1_w50_1 rbl_op0_0000_s1_w50 sn_op0_0000_s1_w50_1 rwl_des 0 sky130_fd_pr__nfet_01v8 L=0.15 W=0.42 nf=1 ad=0.1218 as=0.1218 pd=1.42 ps=1.42 nrd=0.69047619047619  nrs=0.69047619047619 sa=0 sb=0 sd=0 mult=1 m=1
csn_op0_0000_s1_w50_1 sn_op0_0000_s1_w50_1 0 {C_SN}
XMWR_op0_0000_s1_w50_2 sn_op0_0000_s1_w50_2 wwl_des wbl_op0_0000_s1_w50 0 sky130_fd_pr__nfet_01v8 L=0.15 W=0.42 nf=1 ad=0.1218 as=0.1218 pd=1.42 ps=1.42 nrd=0.69047619047619  nrs=0.69047619047619 sa=0 sb=0 sd=0 mult=1 m=1
XMRD_op0_0000_s1_w50_2 rbl_op0_0000_s1_w50 sn_op0_0000_s1_w50_2 rwl_des 0 sky130_fd_pr__nfet_01v8 L=0.15 W=0.42 nf=1 ad=0.1218 as=0.1218 pd=1.42 ps=1.42 nrd=0.69047619047619  nrs=0.69047619047619 sa=0 sb=0 sd=0 mult=1 m=1
csn_op0_0000_s1_w50_2 sn_op0_0000_s1_w50_2 0 {C_SN}
XMWR_op0_0000_s1_w50_3 sn_op0_0000_s1_w50_3 wwl_des wbl_op0_0000_s1_w50 0 sky130_fd_pr__nfet_01v8 L=0.15 W=0.42 nf=1 ad=0.1218 as=0.1218 pd=1.42 ps=1.42 nrd=0.69047619047619  nrs=0.69047619047619 sa=0 sb=0 sd=0 mult=1 m=1
XMRD_op0_0000_s1_w50_3 rbl_op0_0000_s1_w50 sn_op0_0000_s1_w50_3 rwl_des 0 sky130_fd_pr__nfet_01v8 L=0.15 W=0.42 nf=1 ad=0.1218 as=0.1218 pd=1.42 ps=1.42 nrd=0.69047619047619  nrs=0.69047619047619 sa=0 sb=0 sd=0 mult=1 m=1
csn_op0_0000_s1_w50_3 sn_op0_0000_s1_w50_3 0 {C_SN}
XMN1_op0_0000_s1_w50 rbl_op0_0000_s1_w50 ref_op0_0000_s1_w50 vn_op0_0000_s1_w50 0 sky130_fd_pr__nfet_01v8 L=0.15 W=1 nf=1 ad=0.29 as=0.29 pd=2.58 ps=2.58 mult=1 m=1
XMN2_op0_0000_s1_w50 ref_op0_0000_s1_w50 rbl_op0_0000_s1_w50 vn_op0_0000_s1_w50 0 sky130_fd_pr__nfet_01v8 L=0.15 W=1 nf=1 ad=0.29 as=0.29 pd=2.58 ps=2.58 mult=1 m=1
XMP1_op0_0000_s1_w50 rbl_op0_0000_s1_w50 ref_op0_0000_s1_w50 vp_op0_0000_s1_w50 vdd sky130_fd_pr__pfet_01v8 L=0.15 W=2 nf=1 ad=0.58 as=0.58 pd=4.58 ps=4.58 mult=1 m=1
XMP2_op0_0000_s1_w50 ref_op0_0000_s1_w50 rbl_op0_0000_s1_w50 vp_op0_0000_s1_w50 vdd sky130_fd_pr__pfet_01v8 L=0.15 W=2 nf=1 ad=0.58 as=0.58 pd=4.58 ps=4.58 mult=1 m=1
XMNF_op0_0000_s1_w50 vn_op0_0000_s1_w50 en_op0_0000_s1_w50 0 0 sky130_fd_pr__nfet_01v8 L=0.15 W=2 nf=1 ad=0.58 as=0.58 pd=4.58 ps=4.58 mult=1 m=1
XMPH_op0_0000_s1_w50 vp_op0_0000_s1_w50 enb_op0_0000_s1_w50 vdd vdd sky130_fd_pr__pfet_01v8 L=0.15 W=4 nf=1 ad=1.16 as=1.16 pd=8.58 ps=8.58 mult=1 m=1
bd_op0_0000_s1_w50 d_op0_0000_s1_w50 0 v=v(rbl_op0_0000_s1_w50)-v(ref_op0_0000_s1_w50)

* ---- instance 204: op0_0000_s2_w0p2 (t_en 6 ns, WWL 7..7.2 ns, release 9.2 ns) ----
ven_op0_0000_s2_w0p2  en_op0_0000_s2_w0p2  0 pwl(0 0 6.0000e-09 0 6.1000e-09 {VDD} 9.2000e-09 {VDD} 9.3000e-09 0)
venb_op0_0000_s2_w0p2 enb_op0_0000_s2_w0p2 0 pwl(0 {VDD} 6.0000e-09 {VDD} 6.1000e-09 0 9.2000e-09 0 9.3000e-09 {VDD})
vrs_op0_0000_s2_w0p2  rwls_op0_0000_s2_w0p2 0 pwl(0 {VDD} {T_READ} {VDD} {T_READ+TEDGE} 0 9.2000e-09 0 9.3000e-09 {VDD})
vww_op0_0000_s2_w0p2  wwl_op0_0000_s2_w0p2 0 pwl(0 0 7.0000e-09 0 7.1000e-09 {VDD} 7.2000e-09 {VDD} 7.3000e-09 0)
vwc_op0_0000_s2_w0p2  wbc_op0_0000_s2_w0p2 0 pwl(0 0 7.0000e-09 0 7.1000e-09 {VDD} 9.2000e-09 {VDD} 9.3000e-09 0)
swb_op0_0000_s2_w0p2 ref_op0_0000_s2_w0p2 wbl_op0_0000_s2_w0p2 wbc_op0_0000_s2_w0p2 0 swwbl
cwbl_op0_0000_s2_w0p2 wbl_op0_0000_s2_w0p2 0 {C_WBL}
spa_op0_0000_s2_w0p2 prea rbl_op0_0000_s2_w0p2 ctl 0 swpre
spr_op0_0000_s2_w0p2 pref ref_op0_0000_s2_w0p2 ctl 0 swpre
crbl_op0_0000_s2_w0p2 rbl_op0_0000_s2_w0p2 0 {C_RBL}
cref_op0_0000_s2_w0p2 ref_op0_0000_s2_w0p2 0 {C_RBL}   $ ASSUMPTION: ideal matched dummy load
XMWR_op0_0000_s2_w0p2_0 sn_op0_0000_s2_w0p2_0 wwl_op0_0000_s2_w0p2 wbl_op0_0000_s2_w0p2 0 sky130_fd_pr__nfet_01v8 L=0.15 W=0.42 nf=1 ad=0.1218 as=0.1218 pd=1.42 ps=1.42 nrd=0.69047619047619  nrs=0.69047619047619 sa=0 sb=0 sd=0 mult=1 m=1
XMRD_op0_0000_s2_w0p2_0 rbl_op0_0000_s2_w0p2 sn_op0_0000_s2_w0p2_0 rwls_op0_0000_s2_w0p2 0 sky130_fd_pr__nfet_01v8 L=0.15 W=0.42 nf=1 ad=0.1218 as=0.1218 pd=1.42 ps=1.42 nrd=0.69047619047619  nrs=0.69047619047619 sa=0 sb=0 sd=0 mult=1 m=1
csn_op0_0000_s2_w0p2_0 sn_op0_0000_s2_w0p2_0 0 {C_SN}
XMWR_op0_0000_s2_w0p2_1 sn_op0_0000_s2_w0p2_1 wwl_des wbl_op0_0000_s2_w0p2 0 sky130_fd_pr__nfet_01v8 L=0.15 W=0.42 nf=1 ad=0.1218 as=0.1218 pd=1.42 ps=1.42 nrd=0.69047619047619  nrs=0.69047619047619 sa=0 sb=0 sd=0 mult=1 m=1
XMRD_op0_0000_s2_w0p2_1 rbl_op0_0000_s2_w0p2 sn_op0_0000_s2_w0p2_1 rwl_des 0 sky130_fd_pr__nfet_01v8 L=0.15 W=0.42 nf=1 ad=0.1218 as=0.1218 pd=1.42 ps=1.42 nrd=0.69047619047619  nrs=0.69047619047619 sa=0 sb=0 sd=0 mult=1 m=1
csn_op0_0000_s2_w0p2_1 sn_op0_0000_s2_w0p2_1 0 {C_SN}
XMWR_op0_0000_s2_w0p2_2 sn_op0_0000_s2_w0p2_2 wwl_des wbl_op0_0000_s2_w0p2 0 sky130_fd_pr__nfet_01v8 L=0.15 W=0.42 nf=1 ad=0.1218 as=0.1218 pd=1.42 ps=1.42 nrd=0.69047619047619  nrs=0.69047619047619 sa=0 sb=0 sd=0 mult=1 m=1
XMRD_op0_0000_s2_w0p2_2 rbl_op0_0000_s2_w0p2 sn_op0_0000_s2_w0p2_2 rwl_des 0 sky130_fd_pr__nfet_01v8 L=0.15 W=0.42 nf=1 ad=0.1218 as=0.1218 pd=1.42 ps=1.42 nrd=0.69047619047619  nrs=0.69047619047619 sa=0 sb=0 sd=0 mult=1 m=1
csn_op0_0000_s2_w0p2_2 sn_op0_0000_s2_w0p2_2 0 {C_SN}
XMWR_op0_0000_s2_w0p2_3 sn_op0_0000_s2_w0p2_3 wwl_des wbl_op0_0000_s2_w0p2 0 sky130_fd_pr__nfet_01v8 L=0.15 W=0.42 nf=1 ad=0.1218 as=0.1218 pd=1.42 ps=1.42 nrd=0.69047619047619  nrs=0.69047619047619 sa=0 sb=0 sd=0 mult=1 m=1
XMRD_op0_0000_s2_w0p2_3 rbl_op0_0000_s2_w0p2 sn_op0_0000_s2_w0p2_3 rwl_des 0 sky130_fd_pr__nfet_01v8 L=0.15 W=0.42 nf=1 ad=0.1218 as=0.1218 pd=1.42 ps=1.42 nrd=0.69047619047619  nrs=0.69047619047619 sa=0 sb=0 sd=0 mult=1 m=1
csn_op0_0000_s2_w0p2_3 sn_op0_0000_s2_w0p2_3 0 {C_SN}
XMN1_op0_0000_s2_w0p2 rbl_op0_0000_s2_w0p2 ref_op0_0000_s2_w0p2 vn_op0_0000_s2_w0p2 0 sky130_fd_pr__nfet_01v8 L=0.15 W=1 nf=1 ad=0.29 as=0.29 pd=2.58 ps=2.58 mult=1 m=1
XMN2_op0_0000_s2_w0p2 ref_op0_0000_s2_w0p2 rbl_op0_0000_s2_w0p2 vn_op0_0000_s2_w0p2 0 sky130_fd_pr__nfet_01v8 L=0.15 W=1 nf=1 ad=0.29 as=0.29 pd=2.58 ps=2.58 mult=1 m=1
XMP1_op0_0000_s2_w0p2 rbl_op0_0000_s2_w0p2 ref_op0_0000_s2_w0p2 vp_op0_0000_s2_w0p2 vdd sky130_fd_pr__pfet_01v8 L=0.15 W=2 nf=1 ad=0.58 as=0.58 pd=4.58 ps=4.58 mult=1 m=1
XMP2_op0_0000_s2_w0p2 ref_op0_0000_s2_w0p2 rbl_op0_0000_s2_w0p2 vp_op0_0000_s2_w0p2 vdd sky130_fd_pr__pfet_01v8 L=0.15 W=2 nf=1 ad=0.58 as=0.58 pd=4.58 ps=4.58 mult=1 m=1
XMNF_op0_0000_s2_w0p2 vn_op0_0000_s2_w0p2 en_op0_0000_s2_w0p2 0 0 sky130_fd_pr__nfet_01v8 L=0.15 W=2 nf=1 ad=0.58 as=0.58 pd=4.58 ps=4.58 mult=1 m=1
XMPH_op0_0000_s2_w0p2 vp_op0_0000_s2_w0p2 enb_op0_0000_s2_w0p2 vdd vdd sky130_fd_pr__pfet_01v8 L=0.15 W=4 nf=1 ad=1.16 as=1.16 pd=8.58 ps=8.58 mult=1 m=1
bd_op0_0000_s2_w0p2 d_op0_0000_s2_w0p2 0 v=v(rbl_op0_0000_s2_w0p2)-v(ref_op0_0000_s2_w0p2)

* ---- instance 205: op0_0000_s2_w0p5 (t_en 6 ns, WWL 7..7.5 ns, release 9.5 ns) ----
ven_op0_0000_s2_w0p5  en_op0_0000_s2_w0p5  0 pwl(0 0 6.0000e-09 0 6.1000e-09 {VDD} 9.5000e-09 {VDD} 9.6000e-09 0)
venb_op0_0000_s2_w0p5 enb_op0_0000_s2_w0p5 0 pwl(0 {VDD} 6.0000e-09 {VDD} 6.1000e-09 0 9.5000e-09 0 9.6000e-09 {VDD})
vrs_op0_0000_s2_w0p5  rwls_op0_0000_s2_w0p5 0 pwl(0 {VDD} {T_READ} {VDD} {T_READ+TEDGE} 0 9.5000e-09 0 9.6000e-09 {VDD})
vww_op0_0000_s2_w0p5  wwl_op0_0000_s2_w0p5 0 pwl(0 0 7.0000e-09 0 7.1000e-09 {VDD} 7.5000e-09 {VDD} 7.6000e-09 0)
vwc_op0_0000_s2_w0p5  wbc_op0_0000_s2_w0p5 0 pwl(0 0 7.0000e-09 0 7.1000e-09 {VDD} 9.5000e-09 {VDD} 9.6000e-09 0)
swb_op0_0000_s2_w0p5 ref_op0_0000_s2_w0p5 wbl_op0_0000_s2_w0p5 wbc_op0_0000_s2_w0p5 0 swwbl
cwbl_op0_0000_s2_w0p5 wbl_op0_0000_s2_w0p5 0 {C_WBL}
spa_op0_0000_s2_w0p5 prea rbl_op0_0000_s2_w0p5 ctl 0 swpre
spr_op0_0000_s2_w0p5 pref ref_op0_0000_s2_w0p5 ctl 0 swpre
crbl_op0_0000_s2_w0p5 rbl_op0_0000_s2_w0p5 0 {C_RBL}
cref_op0_0000_s2_w0p5 ref_op0_0000_s2_w0p5 0 {C_RBL}   $ ASSUMPTION: ideal matched dummy load
XMWR_op0_0000_s2_w0p5_0 sn_op0_0000_s2_w0p5_0 wwl_op0_0000_s2_w0p5 wbl_op0_0000_s2_w0p5 0 sky130_fd_pr__nfet_01v8 L=0.15 W=0.42 nf=1 ad=0.1218 as=0.1218 pd=1.42 ps=1.42 nrd=0.69047619047619  nrs=0.69047619047619 sa=0 sb=0 sd=0 mult=1 m=1
XMRD_op0_0000_s2_w0p5_0 rbl_op0_0000_s2_w0p5 sn_op0_0000_s2_w0p5_0 rwls_op0_0000_s2_w0p5 0 sky130_fd_pr__nfet_01v8 L=0.15 W=0.42 nf=1 ad=0.1218 as=0.1218 pd=1.42 ps=1.42 nrd=0.69047619047619  nrs=0.69047619047619 sa=0 sb=0 sd=0 mult=1 m=1
csn_op0_0000_s2_w0p5_0 sn_op0_0000_s2_w0p5_0 0 {C_SN}
XMWR_op0_0000_s2_w0p5_1 sn_op0_0000_s2_w0p5_1 wwl_des wbl_op0_0000_s2_w0p5 0 sky130_fd_pr__nfet_01v8 L=0.15 W=0.42 nf=1 ad=0.1218 as=0.1218 pd=1.42 ps=1.42 nrd=0.69047619047619  nrs=0.69047619047619 sa=0 sb=0 sd=0 mult=1 m=1
XMRD_op0_0000_s2_w0p5_1 rbl_op0_0000_s2_w0p5 sn_op0_0000_s2_w0p5_1 rwl_des 0 sky130_fd_pr__nfet_01v8 L=0.15 W=0.42 nf=1 ad=0.1218 as=0.1218 pd=1.42 ps=1.42 nrd=0.69047619047619  nrs=0.69047619047619 sa=0 sb=0 sd=0 mult=1 m=1
csn_op0_0000_s2_w0p5_1 sn_op0_0000_s2_w0p5_1 0 {C_SN}
XMWR_op0_0000_s2_w0p5_2 sn_op0_0000_s2_w0p5_2 wwl_des wbl_op0_0000_s2_w0p5 0 sky130_fd_pr__nfet_01v8 L=0.15 W=0.42 nf=1 ad=0.1218 as=0.1218 pd=1.42 ps=1.42 nrd=0.69047619047619  nrs=0.69047619047619 sa=0 sb=0 sd=0 mult=1 m=1
XMRD_op0_0000_s2_w0p5_2 rbl_op0_0000_s2_w0p5 sn_op0_0000_s2_w0p5_2 rwl_des 0 sky130_fd_pr__nfet_01v8 L=0.15 W=0.42 nf=1 ad=0.1218 as=0.1218 pd=1.42 ps=1.42 nrd=0.69047619047619  nrs=0.69047619047619 sa=0 sb=0 sd=0 mult=1 m=1
csn_op0_0000_s2_w0p5_2 sn_op0_0000_s2_w0p5_2 0 {C_SN}
XMWR_op0_0000_s2_w0p5_3 sn_op0_0000_s2_w0p5_3 wwl_des wbl_op0_0000_s2_w0p5 0 sky130_fd_pr__nfet_01v8 L=0.15 W=0.42 nf=1 ad=0.1218 as=0.1218 pd=1.42 ps=1.42 nrd=0.69047619047619  nrs=0.69047619047619 sa=0 sb=0 sd=0 mult=1 m=1
XMRD_op0_0000_s2_w0p5_3 rbl_op0_0000_s2_w0p5 sn_op0_0000_s2_w0p5_3 rwl_des 0 sky130_fd_pr__nfet_01v8 L=0.15 W=0.42 nf=1 ad=0.1218 as=0.1218 pd=1.42 ps=1.42 nrd=0.69047619047619  nrs=0.69047619047619 sa=0 sb=0 sd=0 mult=1 m=1
csn_op0_0000_s2_w0p5_3 sn_op0_0000_s2_w0p5_3 0 {C_SN}
XMN1_op0_0000_s2_w0p5 rbl_op0_0000_s2_w0p5 ref_op0_0000_s2_w0p5 vn_op0_0000_s2_w0p5 0 sky130_fd_pr__nfet_01v8 L=0.15 W=1 nf=1 ad=0.29 as=0.29 pd=2.58 ps=2.58 mult=1 m=1
XMN2_op0_0000_s2_w0p5 ref_op0_0000_s2_w0p5 rbl_op0_0000_s2_w0p5 vn_op0_0000_s2_w0p5 0 sky130_fd_pr__nfet_01v8 L=0.15 W=1 nf=1 ad=0.29 as=0.29 pd=2.58 ps=2.58 mult=1 m=1
XMP1_op0_0000_s2_w0p5 rbl_op0_0000_s2_w0p5 ref_op0_0000_s2_w0p5 vp_op0_0000_s2_w0p5 vdd sky130_fd_pr__pfet_01v8 L=0.15 W=2 nf=1 ad=0.58 as=0.58 pd=4.58 ps=4.58 mult=1 m=1
XMP2_op0_0000_s2_w0p5 ref_op0_0000_s2_w0p5 rbl_op0_0000_s2_w0p5 vp_op0_0000_s2_w0p5 vdd sky130_fd_pr__pfet_01v8 L=0.15 W=2 nf=1 ad=0.58 as=0.58 pd=4.58 ps=4.58 mult=1 m=1
XMNF_op0_0000_s2_w0p5 vn_op0_0000_s2_w0p5 en_op0_0000_s2_w0p5 0 0 sky130_fd_pr__nfet_01v8 L=0.15 W=2 nf=1 ad=0.58 as=0.58 pd=4.58 ps=4.58 mult=1 m=1
XMPH_op0_0000_s2_w0p5 vp_op0_0000_s2_w0p5 enb_op0_0000_s2_w0p5 vdd vdd sky130_fd_pr__pfet_01v8 L=0.15 W=4 nf=1 ad=1.16 as=1.16 pd=8.58 ps=8.58 mult=1 m=1
bd_op0_0000_s2_w0p5 d_op0_0000_s2_w0p5 0 v=v(rbl_op0_0000_s2_w0p5)-v(ref_op0_0000_s2_w0p5)

* ---- instance 206: op0_0000_s2_w1 (t_en 6 ns, WWL 7..8 ns, release 10 ns) ----
ven_op0_0000_s2_w1  en_op0_0000_s2_w1  0 pwl(0 0 6.0000e-09 0 6.1000e-09 {VDD} 1.0000e-08 {VDD} 1.0100e-08 0)
venb_op0_0000_s2_w1 enb_op0_0000_s2_w1 0 pwl(0 {VDD} 6.0000e-09 {VDD} 6.1000e-09 0 1.0000e-08 0 1.0100e-08 {VDD})
vrs_op0_0000_s2_w1  rwls_op0_0000_s2_w1 0 pwl(0 {VDD} {T_READ} {VDD} {T_READ+TEDGE} 0 1.0000e-08 0 1.0100e-08 {VDD})
vww_op0_0000_s2_w1  wwl_op0_0000_s2_w1 0 pwl(0 0 7.0000e-09 0 7.1000e-09 {VDD} 8.0000e-09 {VDD} 8.1000e-09 0)
vwc_op0_0000_s2_w1  wbc_op0_0000_s2_w1 0 pwl(0 0 7.0000e-09 0 7.1000e-09 {VDD} 1.0000e-08 {VDD} 1.0100e-08 0)
swb_op0_0000_s2_w1 ref_op0_0000_s2_w1 wbl_op0_0000_s2_w1 wbc_op0_0000_s2_w1 0 swwbl
cwbl_op0_0000_s2_w1 wbl_op0_0000_s2_w1 0 {C_WBL}
spa_op0_0000_s2_w1 prea rbl_op0_0000_s2_w1 ctl 0 swpre
spr_op0_0000_s2_w1 pref ref_op0_0000_s2_w1 ctl 0 swpre
crbl_op0_0000_s2_w1 rbl_op0_0000_s2_w1 0 {C_RBL}
cref_op0_0000_s2_w1 ref_op0_0000_s2_w1 0 {C_RBL}   $ ASSUMPTION: ideal matched dummy load
XMWR_op0_0000_s2_w1_0 sn_op0_0000_s2_w1_0 wwl_op0_0000_s2_w1 wbl_op0_0000_s2_w1 0 sky130_fd_pr__nfet_01v8 L=0.15 W=0.42 nf=1 ad=0.1218 as=0.1218 pd=1.42 ps=1.42 nrd=0.69047619047619  nrs=0.69047619047619 sa=0 sb=0 sd=0 mult=1 m=1
XMRD_op0_0000_s2_w1_0 rbl_op0_0000_s2_w1 sn_op0_0000_s2_w1_0 rwls_op0_0000_s2_w1 0 sky130_fd_pr__nfet_01v8 L=0.15 W=0.42 nf=1 ad=0.1218 as=0.1218 pd=1.42 ps=1.42 nrd=0.69047619047619  nrs=0.69047619047619 sa=0 sb=0 sd=0 mult=1 m=1
csn_op0_0000_s2_w1_0 sn_op0_0000_s2_w1_0 0 {C_SN}
XMWR_op0_0000_s2_w1_1 sn_op0_0000_s2_w1_1 wwl_des wbl_op0_0000_s2_w1 0 sky130_fd_pr__nfet_01v8 L=0.15 W=0.42 nf=1 ad=0.1218 as=0.1218 pd=1.42 ps=1.42 nrd=0.69047619047619  nrs=0.69047619047619 sa=0 sb=0 sd=0 mult=1 m=1
XMRD_op0_0000_s2_w1_1 rbl_op0_0000_s2_w1 sn_op0_0000_s2_w1_1 rwl_des 0 sky130_fd_pr__nfet_01v8 L=0.15 W=0.42 nf=1 ad=0.1218 as=0.1218 pd=1.42 ps=1.42 nrd=0.69047619047619  nrs=0.69047619047619 sa=0 sb=0 sd=0 mult=1 m=1
csn_op0_0000_s2_w1_1 sn_op0_0000_s2_w1_1 0 {C_SN}
XMWR_op0_0000_s2_w1_2 sn_op0_0000_s2_w1_2 wwl_des wbl_op0_0000_s2_w1 0 sky130_fd_pr__nfet_01v8 L=0.15 W=0.42 nf=1 ad=0.1218 as=0.1218 pd=1.42 ps=1.42 nrd=0.69047619047619  nrs=0.69047619047619 sa=0 sb=0 sd=0 mult=1 m=1
XMRD_op0_0000_s2_w1_2 rbl_op0_0000_s2_w1 sn_op0_0000_s2_w1_2 rwl_des 0 sky130_fd_pr__nfet_01v8 L=0.15 W=0.42 nf=1 ad=0.1218 as=0.1218 pd=1.42 ps=1.42 nrd=0.69047619047619  nrs=0.69047619047619 sa=0 sb=0 sd=0 mult=1 m=1
csn_op0_0000_s2_w1_2 sn_op0_0000_s2_w1_2 0 {C_SN}
XMWR_op0_0000_s2_w1_3 sn_op0_0000_s2_w1_3 wwl_des wbl_op0_0000_s2_w1 0 sky130_fd_pr__nfet_01v8 L=0.15 W=0.42 nf=1 ad=0.1218 as=0.1218 pd=1.42 ps=1.42 nrd=0.69047619047619  nrs=0.69047619047619 sa=0 sb=0 sd=0 mult=1 m=1
XMRD_op0_0000_s2_w1_3 rbl_op0_0000_s2_w1 sn_op0_0000_s2_w1_3 rwl_des 0 sky130_fd_pr__nfet_01v8 L=0.15 W=0.42 nf=1 ad=0.1218 as=0.1218 pd=1.42 ps=1.42 nrd=0.69047619047619  nrs=0.69047619047619 sa=0 sb=0 sd=0 mult=1 m=1
csn_op0_0000_s2_w1_3 sn_op0_0000_s2_w1_3 0 {C_SN}
XMN1_op0_0000_s2_w1 rbl_op0_0000_s2_w1 ref_op0_0000_s2_w1 vn_op0_0000_s2_w1 0 sky130_fd_pr__nfet_01v8 L=0.15 W=1 nf=1 ad=0.29 as=0.29 pd=2.58 ps=2.58 mult=1 m=1
XMN2_op0_0000_s2_w1 ref_op0_0000_s2_w1 rbl_op0_0000_s2_w1 vn_op0_0000_s2_w1 0 sky130_fd_pr__nfet_01v8 L=0.15 W=1 nf=1 ad=0.29 as=0.29 pd=2.58 ps=2.58 mult=1 m=1
XMP1_op0_0000_s2_w1 rbl_op0_0000_s2_w1 ref_op0_0000_s2_w1 vp_op0_0000_s2_w1 vdd sky130_fd_pr__pfet_01v8 L=0.15 W=2 nf=1 ad=0.58 as=0.58 pd=4.58 ps=4.58 mult=1 m=1
XMP2_op0_0000_s2_w1 ref_op0_0000_s2_w1 rbl_op0_0000_s2_w1 vp_op0_0000_s2_w1 vdd sky130_fd_pr__pfet_01v8 L=0.15 W=2 nf=1 ad=0.58 as=0.58 pd=4.58 ps=4.58 mult=1 m=1
XMNF_op0_0000_s2_w1 vn_op0_0000_s2_w1 en_op0_0000_s2_w1 0 0 sky130_fd_pr__nfet_01v8 L=0.15 W=2 nf=1 ad=0.58 as=0.58 pd=4.58 ps=4.58 mult=1 m=1
XMPH_op0_0000_s2_w1 vp_op0_0000_s2_w1 enb_op0_0000_s2_w1 vdd vdd sky130_fd_pr__pfet_01v8 L=0.15 W=4 nf=1 ad=1.16 as=1.16 pd=8.58 ps=8.58 mult=1 m=1
bd_op0_0000_s2_w1 d_op0_0000_s2_w1 0 v=v(rbl_op0_0000_s2_w1)-v(ref_op0_0000_s2_w1)

* ---- instance 207: op0_0000_s2_w2 (t_en 6 ns, WWL 7..9 ns, release 11 ns) ----
ven_op0_0000_s2_w2  en_op0_0000_s2_w2  0 pwl(0 0 6.0000e-09 0 6.1000e-09 {VDD} 1.1000e-08 {VDD} 1.1100e-08 0)
venb_op0_0000_s2_w2 enb_op0_0000_s2_w2 0 pwl(0 {VDD} 6.0000e-09 {VDD} 6.1000e-09 0 1.1000e-08 0 1.1100e-08 {VDD})
vrs_op0_0000_s2_w2  rwls_op0_0000_s2_w2 0 pwl(0 {VDD} {T_READ} {VDD} {T_READ+TEDGE} 0 1.1000e-08 0 1.1100e-08 {VDD})
vww_op0_0000_s2_w2  wwl_op0_0000_s2_w2 0 pwl(0 0 7.0000e-09 0 7.1000e-09 {VDD} 9.0000e-09 {VDD} 9.1000e-09 0)
vwc_op0_0000_s2_w2  wbc_op0_0000_s2_w2 0 pwl(0 0 7.0000e-09 0 7.1000e-09 {VDD} 1.1000e-08 {VDD} 1.1100e-08 0)
swb_op0_0000_s2_w2 ref_op0_0000_s2_w2 wbl_op0_0000_s2_w2 wbc_op0_0000_s2_w2 0 swwbl
cwbl_op0_0000_s2_w2 wbl_op0_0000_s2_w2 0 {C_WBL}
spa_op0_0000_s2_w2 prea rbl_op0_0000_s2_w2 ctl 0 swpre
spr_op0_0000_s2_w2 pref ref_op0_0000_s2_w2 ctl 0 swpre
crbl_op0_0000_s2_w2 rbl_op0_0000_s2_w2 0 {C_RBL}
cref_op0_0000_s2_w2 ref_op0_0000_s2_w2 0 {C_RBL}   $ ASSUMPTION: ideal matched dummy load
XMWR_op0_0000_s2_w2_0 sn_op0_0000_s2_w2_0 wwl_op0_0000_s2_w2 wbl_op0_0000_s2_w2 0 sky130_fd_pr__nfet_01v8 L=0.15 W=0.42 nf=1 ad=0.1218 as=0.1218 pd=1.42 ps=1.42 nrd=0.69047619047619  nrs=0.69047619047619 sa=0 sb=0 sd=0 mult=1 m=1
XMRD_op0_0000_s2_w2_0 rbl_op0_0000_s2_w2 sn_op0_0000_s2_w2_0 rwls_op0_0000_s2_w2 0 sky130_fd_pr__nfet_01v8 L=0.15 W=0.42 nf=1 ad=0.1218 as=0.1218 pd=1.42 ps=1.42 nrd=0.69047619047619  nrs=0.69047619047619 sa=0 sb=0 sd=0 mult=1 m=1
csn_op0_0000_s2_w2_0 sn_op0_0000_s2_w2_0 0 {C_SN}
XMWR_op0_0000_s2_w2_1 sn_op0_0000_s2_w2_1 wwl_des wbl_op0_0000_s2_w2 0 sky130_fd_pr__nfet_01v8 L=0.15 W=0.42 nf=1 ad=0.1218 as=0.1218 pd=1.42 ps=1.42 nrd=0.69047619047619  nrs=0.69047619047619 sa=0 sb=0 sd=0 mult=1 m=1
XMRD_op0_0000_s2_w2_1 rbl_op0_0000_s2_w2 sn_op0_0000_s2_w2_1 rwl_des 0 sky130_fd_pr__nfet_01v8 L=0.15 W=0.42 nf=1 ad=0.1218 as=0.1218 pd=1.42 ps=1.42 nrd=0.69047619047619  nrs=0.69047619047619 sa=0 sb=0 sd=0 mult=1 m=1
csn_op0_0000_s2_w2_1 sn_op0_0000_s2_w2_1 0 {C_SN}
XMWR_op0_0000_s2_w2_2 sn_op0_0000_s2_w2_2 wwl_des wbl_op0_0000_s2_w2 0 sky130_fd_pr__nfet_01v8 L=0.15 W=0.42 nf=1 ad=0.1218 as=0.1218 pd=1.42 ps=1.42 nrd=0.69047619047619  nrs=0.69047619047619 sa=0 sb=0 sd=0 mult=1 m=1
XMRD_op0_0000_s2_w2_2 rbl_op0_0000_s2_w2 sn_op0_0000_s2_w2_2 rwl_des 0 sky130_fd_pr__nfet_01v8 L=0.15 W=0.42 nf=1 ad=0.1218 as=0.1218 pd=1.42 ps=1.42 nrd=0.69047619047619  nrs=0.69047619047619 sa=0 sb=0 sd=0 mult=1 m=1
csn_op0_0000_s2_w2_2 sn_op0_0000_s2_w2_2 0 {C_SN}
XMWR_op0_0000_s2_w2_3 sn_op0_0000_s2_w2_3 wwl_des wbl_op0_0000_s2_w2 0 sky130_fd_pr__nfet_01v8 L=0.15 W=0.42 nf=1 ad=0.1218 as=0.1218 pd=1.42 ps=1.42 nrd=0.69047619047619  nrs=0.69047619047619 sa=0 sb=0 sd=0 mult=1 m=1
XMRD_op0_0000_s2_w2_3 rbl_op0_0000_s2_w2 sn_op0_0000_s2_w2_3 rwl_des 0 sky130_fd_pr__nfet_01v8 L=0.15 W=0.42 nf=1 ad=0.1218 as=0.1218 pd=1.42 ps=1.42 nrd=0.69047619047619  nrs=0.69047619047619 sa=0 sb=0 sd=0 mult=1 m=1
csn_op0_0000_s2_w2_3 sn_op0_0000_s2_w2_3 0 {C_SN}
XMN1_op0_0000_s2_w2 rbl_op0_0000_s2_w2 ref_op0_0000_s2_w2 vn_op0_0000_s2_w2 0 sky130_fd_pr__nfet_01v8 L=0.15 W=1 nf=1 ad=0.29 as=0.29 pd=2.58 ps=2.58 mult=1 m=1
XMN2_op0_0000_s2_w2 ref_op0_0000_s2_w2 rbl_op0_0000_s2_w2 vn_op0_0000_s2_w2 0 sky130_fd_pr__nfet_01v8 L=0.15 W=1 nf=1 ad=0.29 as=0.29 pd=2.58 ps=2.58 mult=1 m=1
XMP1_op0_0000_s2_w2 rbl_op0_0000_s2_w2 ref_op0_0000_s2_w2 vp_op0_0000_s2_w2 vdd sky130_fd_pr__pfet_01v8 L=0.15 W=2 nf=1 ad=0.58 as=0.58 pd=4.58 ps=4.58 mult=1 m=1
XMP2_op0_0000_s2_w2 ref_op0_0000_s2_w2 rbl_op0_0000_s2_w2 vp_op0_0000_s2_w2 vdd sky130_fd_pr__pfet_01v8 L=0.15 W=2 nf=1 ad=0.58 as=0.58 pd=4.58 ps=4.58 mult=1 m=1
XMNF_op0_0000_s2_w2 vn_op0_0000_s2_w2 en_op0_0000_s2_w2 0 0 sky130_fd_pr__nfet_01v8 L=0.15 W=2 nf=1 ad=0.58 as=0.58 pd=4.58 ps=4.58 mult=1 m=1
XMPH_op0_0000_s2_w2 vp_op0_0000_s2_w2 enb_op0_0000_s2_w2 vdd vdd sky130_fd_pr__pfet_01v8 L=0.15 W=4 nf=1 ad=1.16 as=1.16 pd=8.58 ps=8.58 mult=1 m=1
bd_op0_0000_s2_w2 d_op0_0000_s2_w2 0 v=v(rbl_op0_0000_s2_w2)-v(ref_op0_0000_s2_w2)

* ---- instance 208: op0_0000_s2_w3 (t_en 6 ns, WWL 7..10 ns, release 12 ns) ----
ven_op0_0000_s2_w3  en_op0_0000_s2_w3  0 pwl(0 0 6.0000e-09 0 6.1000e-09 {VDD} 1.2000e-08 {VDD} 1.2100e-08 0)
venb_op0_0000_s2_w3 enb_op0_0000_s2_w3 0 pwl(0 {VDD} 6.0000e-09 {VDD} 6.1000e-09 0 1.2000e-08 0 1.2100e-08 {VDD})
vrs_op0_0000_s2_w3  rwls_op0_0000_s2_w3 0 pwl(0 {VDD} {T_READ} {VDD} {T_READ+TEDGE} 0 1.2000e-08 0 1.2100e-08 {VDD})
vww_op0_0000_s2_w3  wwl_op0_0000_s2_w3 0 pwl(0 0 7.0000e-09 0 7.1000e-09 {VDD} 1.0000e-08 {VDD} 1.0100e-08 0)
vwc_op0_0000_s2_w3  wbc_op0_0000_s2_w3 0 pwl(0 0 7.0000e-09 0 7.1000e-09 {VDD} 1.2000e-08 {VDD} 1.2100e-08 0)
swb_op0_0000_s2_w3 ref_op0_0000_s2_w3 wbl_op0_0000_s2_w3 wbc_op0_0000_s2_w3 0 swwbl
cwbl_op0_0000_s2_w3 wbl_op0_0000_s2_w3 0 {C_WBL}
spa_op0_0000_s2_w3 prea rbl_op0_0000_s2_w3 ctl 0 swpre
spr_op0_0000_s2_w3 pref ref_op0_0000_s2_w3 ctl 0 swpre
crbl_op0_0000_s2_w3 rbl_op0_0000_s2_w3 0 {C_RBL}
cref_op0_0000_s2_w3 ref_op0_0000_s2_w3 0 {C_RBL}   $ ASSUMPTION: ideal matched dummy load
XMWR_op0_0000_s2_w3_0 sn_op0_0000_s2_w3_0 wwl_op0_0000_s2_w3 wbl_op0_0000_s2_w3 0 sky130_fd_pr__nfet_01v8 L=0.15 W=0.42 nf=1 ad=0.1218 as=0.1218 pd=1.42 ps=1.42 nrd=0.69047619047619  nrs=0.69047619047619 sa=0 sb=0 sd=0 mult=1 m=1
XMRD_op0_0000_s2_w3_0 rbl_op0_0000_s2_w3 sn_op0_0000_s2_w3_0 rwls_op0_0000_s2_w3 0 sky130_fd_pr__nfet_01v8 L=0.15 W=0.42 nf=1 ad=0.1218 as=0.1218 pd=1.42 ps=1.42 nrd=0.69047619047619  nrs=0.69047619047619 sa=0 sb=0 sd=0 mult=1 m=1
csn_op0_0000_s2_w3_0 sn_op0_0000_s2_w3_0 0 {C_SN}
XMWR_op0_0000_s2_w3_1 sn_op0_0000_s2_w3_1 wwl_des wbl_op0_0000_s2_w3 0 sky130_fd_pr__nfet_01v8 L=0.15 W=0.42 nf=1 ad=0.1218 as=0.1218 pd=1.42 ps=1.42 nrd=0.69047619047619  nrs=0.69047619047619 sa=0 sb=0 sd=0 mult=1 m=1
XMRD_op0_0000_s2_w3_1 rbl_op0_0000_s2_w3 sn_op0_0000_s2_w3_1 rwl_des 0 sky130_fd_pr__nfet_01v8 L=0.15 W=0.42 nf=1 ad=0.1218 as=0.1218 pd=1.42 ps=1.42 nrd=0.69047619047619  nrs=0.69047619047619 sa=0 sb=0 sd=0 mult=1 m=1
csn_op0_0000_s2_w3_1 sn_op0_0000_s2_w3_1 0 {C_SN}
XMWR_op0_0000_s2_w3_2 sn_op0_0000_s2_w3_2 wwl_des wbl_op0_0000_s2_w3 0 sky130_fd_pr__nfet_01v8 L=0.15 W=0.42 nf=1 ad=0.1218 as=0.1218 pd=1.42 ps=1.42 nrd=0.69047619047619  nrs=0.69047619047619 sa=0 sb=0 sd=0 mult=1 m=1
XMRD_op0_0000_s2_w3_2 rbl_op0_0000_s2_w3 sn_op0_0000_s2_w3_2 rwl_des 0 sky130_fd_pr__nfet_01v8 L=0.15 W=0.42 nf=1 ad=0.1218 as=0.1218 pd=1.42 ps=1.42 nrd=0.69047619047619  nrs=0.69047619047619 sa=0 sb=0 sd=0 mult=1 m=1
csn_op0_0000_s2_w3_2 sn_op0_0000_s2_w3_2 0 {C_SN}
XMWR_op0_0000_s2_w3_3 sn_op0_0000_s2_w3_3 wwl_des wbl_op0_0000_s2_w3 0 sky130_fd_pr__nfet_01v8 L=0.15 W=0.42 nf=1 ad=0.1218 as=0.1218 pd=1.42 ps=1.42 nrd=0.69047619047619  nrs=0.69047619047619 sa=0 sb=0 sd=0 mult=1 m=1
XMRD_op0_0000_s2_w3_3 rbl_op0_0000_s2_w3 sn_op0_0000_s2_w3_3 rwl_des 0 sky130_fd_pr__nfet_01v8 L=0.15 W=0.42 nf=1 ad=0.1218 as=0.1218 pd=1.42 ps=1.42 nrd=0.69047619047619  nrs=0.69047619047619 sa=0 sb=0 sd=0 mult=1 m=1
csn_op0_0000_s2_w3_3 sn_op0_0000_s2_w3_3 0 {C_SN}
XMN1_op0_0000_s2_w3 rbl_op0_0000_s2_w3 ref_op0_0000_s2_w3 vn_op0_0000_s2_w3 0 sky130_fd_pr__nfet_01v8 L=0.15 W=1 nf=1 ad=0.29 as=0.29 pd=2.58 ps=2.58 mult=1 m=1
XMN2_op0_0000_s2_w3 ref_op0_0000_s2_w3 rbl_op0_0000_s2_w3 vn_op0_0000_s2_w3 0 sky130_fd_pr__nfet_01v8 L=0.15 W=1 nf=1 ad=0.29 as=0.29 pd=2.58 ps=2.58 mult=1 m=1
XMP1_op0_0000_s2_w3 rbl_op0_0000_s2_w3 ref_op0_0000_s2_w3 vp_op0_0000_s2_w3 vdd sky130_fd_pr__pfet_01v8 L=0.15 W=2 nf=1 ad=0.58 as=0.58 pd=4.58 ps=4.58 mult=1 m=1
XMP2_op0_0000_s2_w3 ref_op0_0000_s2_w3 rbl_op0_0000_s2_w3 vp_op0_0000_s2_w3 vdd sky130_fd_pr__pfet_01v8 L=0.15 W=2 nf=1 ad=0.58 as=0.58 pd=4.58 ps=4.58 mult=1 m=1
XMNF_op0_0000_s2_w3 vn_op0_0000_s2_w3 en_op0_0000_s2_w3 0 0 sky130_fd_pr__nfet_01v8 L=0.15 W=2 nf=1 ad=0.58 as=0.58 pd=4.58 ps=4.58 mult=1 m=1
XMPH_op0_0000_s2_w3 vp_op0_0000_s2_w3 enb_op0_0000_s2_w3 vdd vdd sky130_fd_pr__pfet_01v8 L=0.15 W=4 nf=1 ad=1.16 as=1.16 pd=8.58 ps=8.58 mult=1 m=1
bd_op0_0000_s2_w3 d_op0_0000_s2_w3 0 v=v(rbl_op0_0000_s2_w3)-v(ref_op0_0000_s2_w3)

* ---- instance 209: op0_0000_s2_w5 (t_en 6 ns, WWL 7..12 ns, release 14 ns) ----
ven_op0_0000_s2_w5  en_op0_0000_s2_w5  0 pwl(0 0 6.0000e-09 0 6.1000e-09 {VDD} 1.4000e-08 {VDD} 1.4100e-08 0)
venb_op0_0000_s2_w5 enb_op0_0000_s2_w5 0 pwl(0 {VDD} 6.0000e-09 {VDD} 6.1000e-09 0 1.4000e-08 0 1.4100e-08 {VDD})
vrs_op0_0000_s2_w5  rwls_op0_0000_s2_w5 0 pwl(0 {VDD} {T_READ} {VDD} {T_READ+TEDGE} 0 1.4000e-08 0 1.4100e-08 {VDD})
vww_op0_0000_s2_w5  wwl_op0_0000_s2_w5 0 pwl(0 0 7.0000e-09 0 7.1000e-09 {VDD} 1.2000e-08 {VDD} 1.2100e-08 0)
vwc_op0_0000_s2_w5  wbc_op0_0000_s2_w5 0 pwl(0 0 7.0000e-09 0 7.1000e-09 {VDD} 1.4000e-08 {VDD} 1.4100e-08 0)
swb_op0_0000_s2_w5 ref_op0_0000_s2_w5 wbl_op0_0000_s2_w5 wbc_op0_0000_s2_w5 0 swwbl
cwbl_op0_0000_s2_w5 wbl_op0_0000_s2_w5 0 {C_WBL}
spa_op0_0000_s2_w5 prea rbl_op0_0000_s2_w5 ctl 0 swpre
spr_op0_0000_s2_w5 pref ref_op0_0000_s2_w5 ctl 0 swpre
crbl_op0_0000_s2_w5 rbl_op0_0000_s2_w5 0 {C_RBL}
cref_op0_0000_s2_w5 ref_op0_0000_s2_w5 0 {C_RBL}   $ ASSUMPTION: ideal matched dummy load
XMWR_op0_0000_s2_w5_0 sn_op0_0000_s2_w5_0 wwl_op0_0000_s2_w5 wbl_op0_0000_s2_w5 0 sky130_fd_pr__nfet_01v8 L=0.15 W=0.42 nf=1 ad=0.1218 as=0.1218 pd=1.42 ps=1.42 nrd=0.69047619047619  nrs=0.69047619047619 sa=0 sb=0 sd=0 mult=1 m=1
XMRD_op0_0000_s2_w5_0 rbl_op0_0000_s2_w5 sn_op0_0000_s2_w5_0 rwls_op0_0000_s2_w5 0 sky130_fd_pr__nfet_01v8 L=0.15 W=0.42 nf=1 ad=0.1218 as=0.1218 pd=1.42 ps=1.42 nrd=0.69047619047619  nrs=0.69047619047619 sa=0 sb=0 sd=0 mult=1 m=1
csn_op0_0000_s2_w5_0 sn_op0_0000_s2_w5_0 0 {C_SN}
XMWR_op0_0000_s2_w5_1 sn_op0_0000_s2_w5_1 wwl_des wbl_op0_0000_s2_w5 0 sky130_fd_pr__nfet_01v8 L=0.15 W=0.42 nf=1 ad=0.1218 as=0.1218 pd=1.42 ps=1.42 nrd=0.69047619047619  nrs=0.69047619047619 sa=0 sb=0 sd=0 mult=1 m=1
XMRD_op0_0000_s2_w5_1 rbl_op0_0000_s2_w5 sn_op0_0000_s2_w5_1 rwl_des 0 sky130_fd_pr__nfet_01v8 L=0.15 W=0.42 nf=1 ad=0.1218 as=0.1218 pd=1.42 ps=1.42 nrd=0.69047619047619  nrs=0.69047619047619 sa=0 sb=0 sd=0 mult=1 m=1
csn_op0_0000_s2_w5_1 sn_op0_0000_s2_w5_1 0 {C_SN}
XMWR_op0_0000_s2_w5_2 sn_op0_0000_s2_w5_2 wwl_des wbl_op0_0000_s2_w5 0 sky130_fd_pr__nfet_01v8 L=0.15 W=0.42 nf=1 ad=0.1218 as=0.1218 pd=1.42 ps=1.42 nrd=0.69047619047619  nrs=0.69047619047619 sa=0 sb=0 sd=0 mult=1 m=1
XMRD_op0_0000_s2_w5_2 rbl_op0_0000_s2_w5 sn_op0_0000_s2_w5_2 rwl_des 0 sky130_fd_pr__nfet_01v8 L=0.15 W=0.42 nf=1 ad=0.1218 as=0.1218 pd=1.42 ps=1.42 nrd=0.69047619047619  nrs=0.69047619047619 sa=0 sb=0 sd=0 mult=1 m=1
csn_op0_0000_s2_w5_2 sn_op0_0000_s2_w5_2 0 {C_SN}
XMWR_op0_0000_s2_w5_3 sn_op0_0000_s2_w5_3 wwl_des wbl_op0_0000_s2_w5 0 sky130_fd_pr__nfet_01v8 L=0.15 W=0.42 nf=1 ad=0.1218 as=0.1218 pd=1.42 ps=1.42 nrd=0.69047619047619  nrs=0.69047619047619 sa=0 sb=0 sd=0 mult=1 m=1
XMRD_op0_0000_s2_w5_3 rbl_op0_0000_s2_w5 sn_op0_0000_s2_w5_3 rwl_des 0 sky130_fd_pr__nfet_01v8 L=0.15 W=0.42 nf=1 ad=0.1218 as=0.1218 pd=1.42 ps=1.42 nrd=0.69047619047619  nrs=0.69047619047619 sa=0 sb=0 sd=0 mult=1 m=1
csn_op0_0000_s2_w5_3 sn_op0_0000_s2_w5_3 0 {C_SN}
XMN1_op0_0000_s2_w5 rbl_op0_0000_s2_w5 ref_op0_0000_s2_w5 vn_op0_0000_s2_w5 0 sky130_fd_pr__nfet_01v8 L=0.15 W=1 nf=1 ad=0.29 as=0.29 pd=2.58 ps=2.58 mult=1 m=1
XMN2_op0_0000_s2_w5 ref_op0_0000_s2_w5 rbl_op0_0000_s2_w5 vn_op0_0000_s2_w5 0 sky130_fd_pr__nfet_01v8 L=0.15 W=1 nf=1 ad=0.29 as=0.29 pd=2.58 ps=2.58 mult=1 m=1
XMP1_op0_0000_s2_w5 rbl_op0_0000_s2_w5 ref_op0_0000_s2_w5 vp_op0_0000_s2_w5 vdd sky130_fd_pr__pfet_01v8 L=0.15 W=2 nf=1 ad=0.58 as=0.58 pd=4.58 ps=4.58 mult=1 m=1
XMP2_op0_0000_s2_w5 ref_op0_0000_s2_w5 rbl_op0_0000_s2_w5 vp_op0_0000_s2_w5 vdd sky130_fd_pr__pfet_01v8 L=0.15 W=2 nf=1 ad=0.58 as=0.58 pd=4.58 ps=4.58 mult=1 m=1
XMNF_op0_0000_s2_w5 vn_op0_0000_s2_w5 en_op0_0000_s2_w5 0 0 sky130_fd_pr__nfet_01v8 L=0.15 W=2 nf=1 ad=0.58 as=0.58 pd=4.58 ps=4.58 mult=1 m=1
XMPH_op0_0000_s2_w5 vp_op0_0000_s2_w5 enb_op0_0000_s2_w5 vdd vdd sky130_fd_pr__pfet_01v8 L=0.15 W=4 nf=1 ad=1.16 as=1.16 pd=8.58 ps=8.58 mult=1 m=1
bd_op0_0000_s2_w5 d_op0_0000_s2_w5 0 v=v(rbl_op0_0000_s2_w5)-v(ref_op0_0000_s2_w5)

* ---- instance 210: op0_0000_s2_w7p5 (t_en 6 ns, WWL 7..14.5 ns, release 16.5 ns) ----
ven_op0_0000_s2_w7p5  en_op0_0000_s2_w7p5  0 pwl(0 0 6.0000e-09 0 6.1000e-09 {VDD} 1.6500e-08 {VDD} 1.6600e-08 0)
venb_op0_0000_s2_w7p5 enb_op0_0000_s2_w7p5 0 pwl(0 {VDD} 6.0000e-09 {VDD} 6.1000e-09 0 1.6500e-08 0 1.6600e-08 {VDD})
vrs_op0_0000_s2_w7p5  rwls_op0_0000_s2_w7p5 0 pwl(0 {VDD} {T_READ} {VDD} {T_READ+TEDGE} 0 1.6500e-08 0 1.6600e-08 {VDD})
vww_op0_0000_s2_w7p5  wwl_op0_0000_s2_w7p5 0 pwl(0 0 7.0000e-09 0 7.1000e-09 {VDD} 1.4500e-08 {VDD} 1.4600e-08 0)
vwc_op0_0000_s2_w7p5  wbc_op0_0000_s2_w7p5 0 pwl(0 0 7.0000e-09 0 7.1000e-09 {VDD} 1.6500e-08 {VDD} 1.6600e-08 0)
swb_op0_0000_s2_w7p5 ref_op0_0000_s2_w7p5 wbl_op0_0000_s2_w7p5 wbc_op0_0000_s2_w7p5 0 swwbl
cwbl_op0_0000_s2_w7p5 wbl_op0_0000_s2_w7p5 0 {C_WBL}
spa_op0_0000_s2_w7p5 prea rbl_op0_0000_s2_w7p5 ctl 0 swpre
spr_op0_0000_s2_w7p5 pref ref_op0_0000_s2_w7p5 ctl 0 swpre
crbl_op0_0000_s2_w7p5 rbl_op0_0000_s2_w7p5 0 {C_RBL}
cref_op0_0000_s2_w7p5 ref_op0_0000_s2_w7p5 0 {C_RBL}   $ ASSUMPTION: ideal matched dummy load
XMWR_op0_0000_s2_w7p5_0 sn_op0_0000_s2_w7p5_0 wwl_op0_0000_s2_w7p5 wbl_op0_0000_s2_w7p5 0 sky130_fd_pr__nfet_01v8 L=0.15 W=0.42 nf=1 ad=0.1218 as=0.1218 pd=1.42 ps=1.42 nrd=0.69047619047619  nrs=0.69047619047619 sa=0 sb=0 sd=0 mult=1 m=1
XMRD_op0_0000_s2_w7p5_0 rbl_op0_0000_s2_w7p5 sn_op0_0000_s2_w7p5_0 rwls_op0_0000_s2_w7p5 0 sky130_fd_pr__nfet_01v8 L=0.15 W=0.42 nf=1 ad=0.1218 as=0.1218 pd=1.42 ps=1.42 nrd=0.69047619047619  nrs=0.69047619047619 sa=0 sb=0 sd=0 mult=1 m=1
csn_op0_0000_s2_w7p5_0 sn_op0_0000_s2_w7p5_0 0 {C_SN}
XMWR_op0_0000_s2_w7p5_1 sn_op0_0000_s2_w7p5_1 wwl_des wbl_op0_0000_s2_w7p5 0 sky130_fd_pr__nfet_01v8 L=0.15 W=0.42 nf=1 ad=0.1218 as=0.1218 pd=1.42 ps=1.42 nrd=0.69047619047619  nrs=0.69047619047619 sa=0 sb=0 sd=0 mult=1 m=1
XMRD_op0_0000_s2_w7p5_1 rbl_op0_0000_s2_w7p5 sn_op0_0000_s2_w7p5_1 rwl_des 0 sky130_fd_pr__nfet_01v8 L=0.15 W=0.42 nf=1 ad=0.1218 as=0.1218 pd=1.42 ps=1.42 nrd=0.69047619047619  nrs=0.69047619047619 sa=0 sb=0 sd=0 mult=1 m=1
csn_op0_0000_s2_w7p5_1 sn_op0_0000_s2_w7p5_1 0 {C_SN}
XMWR_op0_0000_s2_w7p5_2 sn_op0_0000_s2_w7p5_2 wwl_des wbl_op0_0000_s2_w7p5 0 sky130_fd_pr__nfet_01v8 L=0.15 W=0.42 nf=1 ad=0.1218 as=0.1218 pd=1.42 ps=1.42 nrd=0.69047619047619  nrs=0.69047619047619 sa=0 sb=0 sd=0 mult=1 m=1
XMRD_op0_0000_s2_w7p5_2 rbl_op0_0000_s2_w7p5 sn_op0_0000_s2_w7p5_2 rwl_des 0 sky130_fd_pr__nfet_01v8 L=0.15 W=0.42 nf=1 ad=0.1218 as=0.1218 pd=1.42 ps=1.42 nrd=0.69047619047619  nrs=0.69047619047619 sa=0 sb=0 sd=0 mult=1 m=1
csn_op0_0000_s2_w7p5_2 sn_op0_0000_s2_w7p5_2 0 {C_SN}
XMWR_op0_0000_s2_w7p5_3 sn_op0_0000_s2_w7p5_3 wwl_des wbl_op0_0000_s2_w7p5 0 sky130_fd_pr__nfet_01v8 L=0.15 W=0.42 nf=1 ad=0.1218 as=0.1218 pd=1.42 ps=1.42 nrd=0.69047619047619  nrs=0.69047619047619 sa=0 sb=0 sd=0 mult=1 m=1
XMRD_op0_0000_s2_w7p5_3 rbl_op0_0000_s2_w7p5 sn_op0_0000_s2_w7p5_3 rwl_des 0 sky130_fd_pr__nfet_01v8 L=0.15 W=0.42 nf=1 ad=0.1218 as=0.1218 pd=1.42 ps=1.42 nrd=0.69047619047619  nrs=0.69047619047619 sa=0 sb=0 sd=0 mult=1 m=1
csn_op0_0000_s2_w7p5_3 sn_op0_0000_s2_w7p5_3 0 {C_SN}
XMN1_op0_0000_s2_w7p5 rbl_op0_0000_s2_w7p5 ref_op0_0000_s2_w7p5 vn_op0_0000_s2_w7p5 0 sky130_fd_pr__nfet_01v8 L=0.15 W=1 nf=1 ad=0.29 as=0.29 pd=2.58 ps=2.58 mult=1 m=1
XMN2_op0_0000_s2_w7p5 ref_op0_0000_s2_w7p5 rbl_op0_0000_s2_w7p5 vn_op0_0000_s2_w7p5 0 sky130_fd_pr__nfet_01v8 L=0.15 W=1 nf=1 ad=0.29 as=0.29 pd=2.58 ps=2.58 mult=1 m=1
XMP1_op0_0000_s2_w7p5 rbl_op0_0000_s2_w7p5 ref_op0_0000_s2_w7p5 vp_op0_0000_s2_w7p5 vdd sky130_fd_pr__pfet_01v8 L=0.15 W=2 nf=1 ad=0.58 as=0.58 pd=4.58 ps=4.58 mult=1 m=1
XMP2_op0_0000_s2_w7p5 ref_op0_0000_s2_w7p5 rbl_op0_0000_s2_w7p5 vp_op0_0000_s2_w7p5 vdd sky130_fd_pr__pfet_01v8 L=0.15 W=2 nf=1 ad=0.58 as=0.58 pd=4.58 ps=4.58 mult=1 m=1
XMNF_op0_0000_s2_w7p5 vn_op0_0000_s2_w7p5 en_op0_0000_s2_w7p5 0 0 sky130_fd_pr__nfet_01v8 L=0.15 W=2 nf=1 ad=0.58 as=0.58 pd=4.58 ps=4.58 mult=1 m=1
XMPH_op0_0000_s2_w7p5 vp_op0_0000_s2_w7p5 enb_op0_0000_s2_w7p5 vdd vdd sky130_fd_pr__pfet_01v8 L=0.15 W=4 nf=1 ad=1.16 as=1.16 pd=8.58 ps=8.58 mult=1 m=1
bd_op0_0000_s2_w7p5 d_op0_0000_s2_w7p5 0 v=v(rbl_op0_0000_s2_w7p5)-v(ref_op0_0000_s2_w7p5)

* ---- instance 211: op0_0000_s2_w10 (t_en 6 ns, WWL 7..17 ns, release 19 ns) ----
ven_op0_0000_s2_w10  en_op0_0000_s2_w10  0 pwl(0 0 6.0000e-09 0 6.1000e-09 {VDD} 1.9000e-08 {VDD} 1.9100e-08 0)
venb_op0_0000_s2_w10 enb_op0_0000_s2_w10 0 pwl(0 {VDD} 6.0000e-09 {VDD} 6.1000e-09 0 1.9000e-08 0 1.9100e-08 {VDD})
vrs_op0_0000_s2_w10  rwls_op0_0000_s2_w10 0 pwl(0 {VDD} {T_READ} {VDD} {T_READ+TEDGE} 0 1.9000e-08 0 1.9100e-08 {VDD})
vww_op0_0000_s2_w10  wwl_op0_0000_s2_w10 0 pwl(0 0 7.0000e-09 0 7.1000e-09 {VDD} 1.7000e-08 {VDD} 1.7100e-08 0)
vwc_op0_0000_s2_w10  wbc_op0_0000_s2_w10 0 pwl(0 0 7.0000e-09 0 7.1000e-09 {VDD} 1.9000e-08 {VDD} 1.9100e-08 0)
swb_op0_0000_s2_w10 ref_op0_0000_s2_w10 wbl_op0_0000_s2_w10 wbc_op0_0000_s2_w10 0 swwbl
cwbl_op0_0000_s2_w10 wbl_op0_0000_s2_w10 0 {C_WBL}
spa_op0_0000_s2_w10 prea rbl_op0_0000_s2_w10 ctl 0 swpre
spr_op0_0000_s2_w10 pref ref_op0_0000_s2_w10 ctl 0 swpre
crbl_op0_0000_s2_w10 rbl_op0_0000_s2_w10 0 {C_RBL}
cref_op0_0000_s2_w10 ref_op0_0000_s2_w10 0 {C_RBL}   $ ASSUMPTION: ideal matched dummy load
XMWR_op0_0000_s2_w10_0 sn_op0_0000_s2_w10_0 wwl_op0_0000_s2_w10 wbl_op0_0000_s2_w10 0 sky130_fd_pr__nfet_01v8 L=0.15 W=0.42 nf=1 ad=0.1218 as=0.1218 pd=1.42 ps=1.42 nrd=0.69047619047619  nrs=0.69047619047619 sa=0 sb=0 sd=0 mult=1 m=1
XMRD_op0_0000_s2_w10_0 rbl_op0_0000_s2_w10 sn_op0_0000_s2_w10_0 rwls_op0_0000_s2_w10 0 sky130_fd_pr__nfet_01v8 L=0.15 W=0.42 nf=1 ad=0.1218 as=0.1218 pd=1.42 ps=1.42 nrd=0.69047619047619  nrs=0.69047619047619 sa=0 sb=0 sd=0 mult=1 m=1
csn_op0_0000_s2_w10_0 sn_op0_0000_s2_w10_0 0 {C_SN}
XMWR_op0_0000_s2_w10_1 sn_op0_0000_s2_w10_1 wwl_des wbl_op0_0000_s2_w10 0 sky130_fd_pr__nfet_01v8 L=0.15 W=0.42 nf=1 ad=0.1218 as=0.1218 pd=1.42 ps=1.42 nrd=0.69047619047619  nrs=0.69047619047619 sa=0 sb=0 sd=0 mult=1 m=1
XMRD_op0_0000_s2_w10_1 rbl_op0_0000_s2_w10 sn_op0_0000_s2_w10_1 rwl_des 0 sky130_fd_pr__nfet_01v8 L=0.15 W=0.42 nf=1 ad=0.1218 as=0.1218 pd=1.42 ps=1.42 nrd=0.69047619047619  nrs=0.69047619047619 sa=0 sb=0 sd=0 mult=1 m=1
csn_op0_0000_s2_w10_1 sn_op0_0000_s2_w10_1 0 {C_SN}
XMWR_op0_0000_s2_w10_2 sn_op0_0000_s2_w10_2 wwl_des wbl_op0_0000_s2_w10 0 sky130_fd_pr__nfet_01v8 L=0.15 W=0.42 nf=1 ad=0.1218 as=0.1218 pd=1.42 ps=1.42 nrd=0.69047619047619  nrs=0.69047619047619 sa=0 sb=0 sd=0 mult=1 m=1
XMRD_op0_0000_s2_w10_2 rbl_op0_0000_s2_w10 sn_op0_0000_s2_w10_2 rwl_des 0 sky130_fd_pr__nfet_01v8 L=0.15 W=0.42 nf=1 ad=0.1218 as=0.1218 pd=1.42 ps=1.42 nrd=0.69047619047619  nrs=0.69047619047619 sa=0 sb=0 sd=0 mult=1 m=1
csn_op0_0000_s2_w10_2 sn_op0_0000_s2_w10_2 0 {C_SN}
XMWR_op0_0000_s2_w10_3 sn_op0_0000_s2_w10_3 wwl_des wbl_op0_0000_s2_w10 0 sky130_fd_pr__nfet_01v8 L=0.15 W=0.42 nf=1 ad=0.1218 as=0.1218 pd=1.42 ps=1.42 nrd=0.69047619047619  nrs=0.69047619047619 sa=0 sb=0 sd=0 mult=1 m=1
XMRD_op0_0000_s2_w10_3 rbl_op0_0000_s2_w10 sn_op0_0000_s2_w10_3 rwl_des 0 sky130_fd_pr__nfet_01v8 L=0.15 W=0.42 nf=1 ad=0.1218 as=0.1218 pd=1.42 ps=1.42 nrd=0.69047619047619  nrs=0.69047619047619 sa=0 sb=0 sd=0 mult=1 m=1
csn_op0_0000_s2_w10_3 sn_op0_0000_s2_w10_3 0 {C_SN}
XMN1_op0_0000_s2_w10 rbl_op0_0000_s2_w10 ref_op0_0000_s2_w10 vn_op0_0000_s2_w10 0 sky130_fd_pr__nfet_01v8 L=0.15 W=1 nf=1 ad=0.29 as=0.29 pd=2.58 ps=2.58 mult=1 m=1
XMN2_op0_0000_s2_w10 ref_op0_0000_s2_w10 rbl_op0_0000_s2_w10 vn_op0_0000_s2_w10 0 sky130_fd_pr__nfet_01v8 L=0.15 W=1 nf=1 ad=0.29 as=0.29 pd=2.58 ps=2.58 mult=1 m=1
XMP1_op0_0000_s2_w10 rbl_op0_0000_s2_w10 ref_op0_0000_s2_w10 vp_op0_0000_s2_w10 vdd sky130_fd_pr__pfet_01v8 L=0.15 W=2 nf=1 ad=0.58 as=0.58 pd=4.58 ps=4.58 mult=1 m=1
XMP2_op0_0000_s2_w10 ref_op0_0000_s2_w10 rbl_op0_0000_s2_w10 vp_op0_0000_s2_w10 vdd sky130_fd_pr__pfet_01v8 L=0.15 W=2 nf=1 ad=0.58 as=0.58 pd=4.58 ps=4.58 mult=1 m=1
XMNF_op0_0000_s2_w10 vn_op0_0000_s2_w10 en_op0_0000_s2_w10 0 0 sky130_fd_pr__nfet_01v8 L=0.15 W=2 nf=1 ad=0.58 as=0.58 pd=4.58 ps=4.58 mult=1 m=1
XMPH_op0_0000_s2_w10 vp_op0_0000_s2_w10 enb_op0_0000_s2_w10 vdd vdd sky130_fd_pr__pfet_01v8 L=0.15 W=4 nf=1 ad=1.16 as=1.16 pd=8.58 ps=8.58 mult=1 m=1
bd_op0_0000_s2_w10 d_op0_0000_s2_w10 0 v=v(rbl_op0_0000_s2_w10)-v(ref_op0_0000_s2_w10)

* ---- instance 212: op0_0000_s2_w15 (t_en 6 ns, WWL 7..22 ns, release 24 ns) ----
ven_op0_0000_s2_w15  en_op0_0000_s2_w15  0 pwl(0 0 6.0000e-09 0 6.1000e-09 {VDD} 2.4000e-08 {VDD} 2.4100e-08 0)
venb_op0_0000_s2_w15 enb_op0_0000_s2_w15 0 pwl(0 {VDD} 6.0000e-09 {VDD} 6.1000e-09 0 2.4000e-08 0 2.4100e-08 {VDD})
vrs_op0_0000_s2_w15  rwls_op0_0000_s2_w15 0 pwl(0 {VDD} {T_READ} {VDD} {T_READ+TEDGE} 0 2.4000e-08 0 2.4100e-08 {VDD})
vww_op0_0000_s2_w15  wwl_op0_0000_s2_w15 0 pwl(0 0 7.0000e-09 0 7.1000e-09 {VDD} 2.2000e-08 {VDD} 2.2100e-08 0)
vwc_op0_0000_s2_w15  wbc_op0_0000_s2_w15 0 pwl(0 0 7.0000e-09 0 7.1000e-09 {VDD} 2.4000e-08 {VDD} 2.4100e-08 0)
swb_op0_0000_s2_w15 ref_op0_0000_s2_w15 wbl_op0_0000_s2_w15 wbc_op0_0000_s2_w15 0 swwbl
cwbl_op0_0000_s2_w15 wbl_op0_0000_s2_w15 0 {C_WBL}
spa_op0_0000_s2_w15 prea rbl_op0_0000_s2_w15 ctl 0 swpre
spr_op0_0000_s2_w15 pref ref_op0_0000_s2_w15 ctl 0 swpre
crbl_op0_0000_s2_w15 rbl_op0_0000_s2_w15 0 {C_RBL}
cref_op0_0000_s2_w15 ref_op0_0000_s2_w15 0 {C_RBL}   $ ASSUMPTION: ideal matched dummy load
XMWR_op0_0000_s2_w15_0 sn_op0_0000_s2_w15_0 wwl_op0_0000_s2_w15 wbl_op0_0000_s2_w15 0 sky130_fd_pr__nfet_01v8 L=0.15 W=0.42 nf=1 ad=0.1218 as=0.1218 pd=1.42 ps=1.42 nrd=0.69047619047619  nrs=0.69047619047619 sa=0 sb=0 sd=0 mult=1 m=1
XMRD_op0_0000_s2_w15_0 rbl_op0_0000_s2_w15 sn_op0_0000_s2_w15_0 rwls_op0_0000_s2_w15 0 sky130_fd_pr__nfet_01v8 L=0.15 W=0.42 nf=1 ad=0.1218 as=0.1218 pd=1.42 ps=1.42 nrd=0.69047619047619  nrs=0.69047619047619 sa=0 sb=0 sd=0 mult=1 m=1
csn_op0_0000_s2_w15_0 sn_op0_0000_s2_w15_0 0 {C_SN}
XMWR_op0_0000_s2_w15_1 sn_op0_0000_s2_w15_1 wwl_des wbl_op0_0000_s2_w15 0 sky130_fd_pr__nfet_01v8 L=0.15 W=0.42 nf=1 ad=0.1218 as=0.1218 pd=1.42 ps=1.42 nrd=0.69047619047619  nrs=0.69047619047619 sa=0 sb=0 sd=0 mult=1 m=1
XMRD_op0_0000_s2_w15_1 rbl_op0_0000_s2_w15 sn_op0_0000_s2_w15_1 rwl_des 0 sky130_fd_pr__nfet_01v8 L=0.15 W=0.42 nf=1 ad=0.1218 as=0.1218 pd=1.42 ps=1.42 nrd=0.69047619047619  nrs=0.69047619047619 sa=0 sb=0 sd=0 mult=1 m=1
csn_op0_0000_s2_w15_1 sn_op0_0000_s2_w15_1 0 {C_SN}
XMWR_op0_0000_s2_w15_2 sn_op0_0000_s2_w15_2 wwl_des wbl_op0_0000_s2_w15 0 sky130_fd_pr__nfet_01v8 L=0.15 W=0.42 nf=1 ad=0.1218 as=0.1218 pd=1.42 ps=1.42 nrd=0.69047619047619  nrs=0.69047619047619 sa=0 sb=0 sd=0 mult=1 m=1
XMRD_op0_0000_s2_w15_2 rbl_op0_0000_s2_w15 sn_op0_0000_s2_w15_2 rwl_des 0 sky130_fd_pr__nfet_01v8 L=0.15 W=0.42 nf=1 ad=0.1218 as=0.1218 pd=1.42 ps=1.42 nrd=0.69047619047619  nrs=0.69047619047619 sa=0 sb=0 sd=0 mult=1 m=1
csn_op0_0000_s2_w15_2 sn_op0_0000_s2_w15_2 0 {C_SN}
XMWR_op0_0000_s2_w15_3 sn_op0_0000_s2_w15_3 wwl_des wbl_op0_0000_s2_w15 0 sky130_fd_pr__nfet_01v8 L=0.15 W=0.42 nf=1 ad=0.1218 as=0.1218 pd=1.42 ps=1.42 nrd=0.69047619047619  nrs=0.69047619047619 sa=0 sb=0 sd=0 mult=1 m=1
XMRD_op0_0000_s2_w15_3 rbl_op0_0000_s2_w15 sn_op0_0000_s2_w15_3 rwl_des 0 sky130_fd_pr__nfet_01v8 L=0.15 W=0.42 nf=1 ad=0.1218 as=0.1218 pd=1.42 ps=1.42 nrd=0.69047619047619  nrs=0.69047619047619 sa=0 sb=0 sd=0 mult=1 m=1
csn_op0_0000_s2_w15_3 sn_op0_0000_s2_w15_3 0 {C_SN}
XMN1_op0_0000_s2_w15 rbl_op0_0000_s2_w15 ref_op0_0000_s2_w15 vn_op0_0000_s2_w15 0 sky130_fd_pr__nfet_01v8 L=0.15 W=1 nf=1 ad=0.29 as=0.29 pd=2.58 ps=2.58 mult=1 m=1
XMN2_op0_0000_s2_w15 ref_op0_0000_s2_w15 rbl_op0_0000_s2_w15 vn_op0_0000_s2_w15 0 sky130_fd_pr__nfet_01v8 L=0.15 W=1 nf=1 ad=0.29 as=0.29 pd=2.58 ps=2.58 mult=1 m=1
XMP1_op0_0000_s2_w15 rbl_op0_0000_s2_w15 ref_op0_0000_s2_w15 vp_op0_0000_s2_w15 vdd sky130_fd_pr__pfet_01v8 L=0.15 W=2 nf=1 ad=0.58 as=0.58 pd=4.58 ps=4.58 mult=1 m=1
XMP2_op0_0000_s2_w15 ref_op0_0000_s2_w15 rbl_op0_0000_s2_w15 vp_op0_0000_s2_w15 vdd sky130_fd_pr__pfet_01v8 L=0.15 W=2 nf=1 ad=0.58 as=0.58 pd=4.58 ps=4.58 mult=1 m=1
XMNF_op0_0000_s2_w15 vn_op0_0000_s2_w15 en_op0_0000_s2_w15 0 0 sky130_fd_pr__nfet_01v8 L=0.15 W=2 nf=1 ad=0.58 as=0.58 pd=4.58 ps=4.58 mult=1 m=1
XMPH_op0_0000_s2_w15 vp_op0_0000_s2_w15 enb_op0_0000_s2_w15 vdd vdd sky130_fd_pr__pfet_01v8 L=0.15 W=4 nf=1 ad=1.16 as=1.16 pd=8.58 ps=8.58 mult=1 m=1
bd_op0_0000_s2_w15 d_op0_0000_s2_w15 0 v=v(rbl_op0_0000_s2_w15)-v(ref_op0_0000_s2_w15)

* ---- instance 213: op0_0000_s2_w20 (t_en 6 ns, WWL 7..27 ns, release 29 ns) ----
ven_op0_0000_s2_w20  en_op0_0000_s2_w20  0 pwl(0 0 6.0000e-09 0 6.1000e-09 {VDD} 2.9000e-08 {VDD} 2.9100e-08 0)
venb_op0_0000_s2_w20 enb_op0_0000_s2_w20 0 pwl(0 {VDD} 6.0000e-09 {VDD} 6.1000e-09 0 2.9000e-08 0 2.9100e-08 {VDD})
vrs_op0_0000_s2_w20  rwls_op0_0000_s2_w20 0 pwl(0 {VDD} {T_READ} {VDD} {T_READ+TEDGE} 0 2.9000e-08 0 2.9100e-08 {VDD})
vww_op0_0000_s2_w20  wwl_op0_0000_s2_w20 0 pwl(0 0 7.0000e-09 0 7.1000e-09 {VDD} 2.7000e-08 {VDD} 2.7100e-08 0)
vwc_op0_0000_s2_w20  wbc_op0_0000_s2_w20 0 pwl(0 0 7.0000e-09 0 7.1000e-09 {VDD} 2.9000e-08 {VDD} 2.9100e-08 0)
swb_op0_0000_s2_w20 ref_op0_0000_s2_w20 wbl_op0_0000_s2_w20 wbc_op0_0000_s2_w20 0 swwbl
cwbl_op0_0000_s2_w20 wbl_op0_0000_s2_w20 0 {C_WBL}
spa_op0_0000_s2_w20 prea rbl_op0_0000_s2_w20 ctl 0 swpre
spr_op0_0000_s2_w20 pref ref_op0_0000_s2_w20 ctl 0 swpre
crbl_op0_0000_s2_w20 rbl_op0_0000_s2_w20 0 {C_RBL}
cref_op0_0000_s2_w20 ref_op0_0000_s2_w20 0 {C_RBL}   $ ASSUMPTION: ideal matched dummy load
XMWR_op0_0000_s2_w20_0 sn_op0_0000_s2_w20_0 wwl_op0_0000_s2_w20 wbl_op0_0000_s2_w20 0 sky130_fd_pr__nfet_01v8 L=0.15 W=0.42 nf=1 ad=0.1218 as=0.1218 pd=1.42 ps=1.42 nrd=0.69047619047619  nrs=0.69047619047619 sa=0 sb=0 sd=0 mult=1 m=1
XMRD_op0_0000_s2_w20_0 rbl_op0_0000_s2_w20 sn_op0_0000_s2_w20_0 rwls_op0_0000_s2_w20 0 sky130_fd_pr__nfet_01v8 L=0.15 W=0.42 nf=1 ad=0.1218 as=0.1218 pd=1.42 ps=1.42 nrd=0.69047619047619  nrs=0.69047619047619 sa=0 sb=0 sd=0 mult=1 m=1
csn_op0_0000_s2_w20_0 sn_op0_0000_s2_w20_0 0 {C_SN}
XMWR_op0_0000_s2_w20_1 sn_op0_0000_s2_w20_1 wwl_des wbl_op0_0000_s2_w20 0 sky130_fd_pr__nfet_01v8 L=0.15 W=0.42 nf=1 ad=0.1218 as=0.1218 pd=1.42 ps=1.42 nrd=0.69047619047619  nrs=0.69047619047619 sa=0 sb=0 sd=0 mult=1 m=1
XMRD_op0_0000_s2_w20_1 rbl_op0_0000_s2_w20 sn_op0_0000_s2_w20_1 rwl_des 0 sky130_fd_pr__nfet_01v8 L=0.15 W=0.42 nf=1 ad=0.1218 as=0.1218 pd=1.42 ps=1.42 nrd=0.69047619047619  nrs=0.69047619047619 sa=0 sb=0 sd=0 mult=1 m=1
csn_op0_0000_s2_w20_1 sn_op0_0000_s2_w20_1 0 {C_SN}
XMWR_op0_0000_s2_w20_2 sn_op0_0000_s2_w20_2 wwl_des wbl_op0_0000_s2_w20 0 sky130_fd_pr__nfet_01v8 L=0.15 W=0.42 nf=1 ad=0.1218 as=0.1218 pd=1.42 ps=1.42 nrd=0.69047619047619  nrs=0.69047619047619 sa=0 sb=0 sd=0 mult=1 m=1
XMRD_op0_0000_s2_w20_2 rbl_op0_0000_s2_w20 sn_op0_0000_s2_w20_2 rwl_des 0 sky130_fd_pr__nfet_01v8 L=0.15 W=0.42 nf=1 ad=0.1218 as=0.1218 pd=1.42 ps=1.42 nrd=0.69047619047619  nrs=0.69047619047619 sa=0 sb=0 sd=0 mult=1 m=1
csn_op0_0000_s2_w20_2 sn_op0_0000_s2_w20_2 0 {C_SN}
XMWR_op0_0000_s2_w20_3 sn_op0_0000_s2_w20_3 wwl_des wbl_op0_0000_s2_w20 0 sky130_fd_pr__nfet_01v8 L=0.15 W=0.42 nf=1 ad=0.1218 as=0.1218 pd=1.42 ps=1.42 nrd=0.69047619047619  nrs=0.69047619047619 sa=0 sb=0 sd=0 mult=1 m=1
XMRD_op0_0000_s2_w20_3 rbl_op0_0000_s2_w20 sn_op0_0000_s2_w20_3 rwl_des 0 sky130_fd_pr__nfet_01v8 L=0.15 W=0.42 nf=1 ad=0.1218 as=0.1218 pd=1.42 ps=1.42 nrd=0.69047619047619  nrs=0.69047619047619 sa=0 sb=0 sd=0 mult=1 m=1
csn_op0_0000_s2_w20_3 sn_op0_0000_s2_w20_3 0 {C_SN}
XMN1_op0_0000_s2_w20 rbl_op0_0000_s2_w20 ref_op0_0000_s2_w20 vn_op0_0000_s2_w20 0 sky130_fd_pr__nfet_01v8 L=0.15 W=1 nf=1 ad=0.29 as=0.29 pd=2.58 ps=2.58 mult=1 m=1
XMN2_op0_0000_s2_w20 ref_op0_0000_s2_w20 rbl_op0_0000_s2_w20 vn_op0_0000_s2_w20 0 sky130_fd_pr__nfet_01v8 L=0.15 W=1 nf=1 ad=0.29 as=0.29 pd=2.58 ps=2.58 mult=1 m=1
XMP1_op0_0000_s2_w20 rbl_op0_0000_s2_w20 ref_op0_0000_s2_w20 vp_op0_0000_s2_w20 vdd sky130_fd_pr__pfet_01v8 L=0.15 W=2 nf=1 ad=0.58 as=0.58 pd=4.58 ps=4.58 mult=1 m=1
XMP2_op0_0000_s2_w20 ref_op0_0000_s2_w20 rbl_op0_0000_s2_w20 vp_op0_0000_s2_w20 vdd sky130_fd_pr__pfet_01v8 L=0.15 W=2 nf=1 ad=0.58 as=0.58 pd=4.58 ps=4.58 mult=1 m=1
XMNF_op0_0000_s2_w20 vn_op0_0000_s2_w20 en_op0_0000_s2_w20 0 0 sky130_fd_pr__nfet_01v8 L=0.15 W=2 nf=1 ad=0.58 as=0.58 pd=4.58 ps=4.58 mult=1 m=1
XMPH_op0_0000_s2_w20 vp_op0_0000_s2_w20 enb_op0_0000_s2_w20 vdd vdd sky130_fd_pr__pfet_01v8 L=0.15 W=4 nf=1 ad=1.16 as=1.16 pd=8.58 ps=8.58 mult=1 m=1
bd_op0_0000_s2_w20 d_op0_0000_s2_w20 0 v=v(rbl_op0_0000_s2_w20)-v(ref_op0_0000_s2_w20)

* ---- instance 214: op0_0000_s2_w30 (t_en 6 ns, WWL 7..37 ns, release 39 ns) ----
ven_op0_0000_s2_w30  en_op0_0000_s2_w30  0 pwl(0 0 6.0000e-09 0 6.1000e-09 {VDD} 3.9000e-08 {VDD} 3.9100e-08 0)
venb_op0_0000_s2_w30 enb_op0_0000_s2_w30 0 pwl(0 {VDD} 6.0000e-09 {VDD} 6.1000e-09 0 3.9000e-08 0 3.9100e-08 {VDD})
vrs_op0_0000_s2_w30  rwls_op0_0000_s2_w30 0 pwl(0 {VDD} {T_READ} {VDD} {T_READ+TEDGE} 0 3.9000e-08 0 3.9100e-08 {VDD})
vww_op0_0000_s2_w30  wwl_op0_0000_s2_w30 0 pwl(0 0 7.0000e-09 0 7.1000e-09 {VDD} 3.7000e-08 {VDD} 3.7100e-08 0)
vwc_op0_0000_s2_w30  wbc_op0_0000_s2_w30 0 pwl(0 0 7.0000e-09 0 7.1000e-09 {VDD} 3.9000e-08 {VDD} 3.9100e-08 0)
swb_op0_0000_s2_w30 ref_op0_0000_s2_w30 wbl_op0_0000_s2_w30 wbc_op0_0000_s2_w30 0 swwbl
cwbl_op0_0000_s2_w30 wbl_op0_0000_s2_w30 0 {C_WBL}
spa_op0_0000_s2_w30 prea rbl_op0_0000_s2_w30 ctl 0 swpre
spr_op0_0000_s2_w30 pref ref_op0_0000_s2_w30 ctl 0 swpre
crbl_op0_0000_s2_w30 rbl_op0_0000_s2_w30 0 {C_RBL}
cref_op0_0000_s2_w30 ref_op0_0000_s2_w30 0 {C_RBL}   $ ASSUMPTION: ideal matched dummy load
XMWR_op0_0000_s2_w30_0 sn_op0_0000_s2_w30_0 wwl_op0_0000_s2_w30 wbl_op0_0000_s2_w30 0 sky130_fd_pr__nfet_01v8 L=0.15 W=0.42 nf=1 ad=0.1218 as=0.1218 pd=1.42 ps=1.42 nrd=0.69047619047619  nrs=0.69047619047619 sa=0 sb=0 sd=0 mult=1 m=1
XMRD_op0_0000_s2_w30_0 rbl_op0_0000_s2_w30 sn_op0_0000_s2_w30_0 rwls_op0_0000_s2_w30 0 sky130_fd_pr__nfet_01v8 L=0.15 W=0.42 nf=1 ad=0.1218 as=0.1218 pd=1.42 ps=1.42 nrd=0.69047619047619  nrs=0.69047619047619 sa=0 sb=0 sd=0 mult=1 m=1
csn_op0_0000_s2_w30_0 sn_op0_0000_s2_w30_0 0 {C_SN}
XMWR_op0_0000_s2_w30_1 sn_op0_0000_s2_w30_1 wwl_des wbl_op0_0000_s2_w30 0 sky130_fd_pr__nfet_01v8 L=0.15 W=0.42 nf=1 ad=0.1218 as=0.1218 pd=1.42 ps=1.42 nrd=0.69047619047619  nrs=0.69047619047619 sa=0 sb=0 sd=0 mult=1 m=1
XMRD_op0_0000_s2_w30_1 rbl_op0_0000_s2_w30 sn_op0_0000_s2_w30_1 rwl_des 0 sky130_fd_pr__nfet_01v8 L=0.15 W=0.42 nf=1 ad=0.1218 as=0.1218 pd=1.42 ps=1.42 nrd=0.69047619047619  nrs=0.69047619047619 sa=0 sb=0 sd=0 mult=1 m=1
csn_op0_0000_s2_w30_1 sn_op0_0000_s2_w30_1 0 {C_SN}
XMWR_op0_0000_s2_w30_2 sn_op0_0000_s2_w30_2 wwl_des wbl_op0_0000_s2_w30 0 sky130_fd_pr__nfet_01v8 L=0.15 W=0.42 nf=1 ad=0.1218 as=0.1218 pd=1.42 ps=1.42 nrd=0.69047619047619  nrs=0.69047619047619 sa=0 sb=0 sd=0 mult=1 m=1
XMRD_op0_0000_s2_w30_2 rbl_op0_0000_s2_w30 sn_op0_0000_s2_w30_2 rwl_des 0 sky130_fd_pr__nfet_01v8 L=0.15 W=0.42 nf=1 ad=0.1218 as=0.1218 pd=1.42 ps=1.42 nrd=0.69047619047619  nrs=0.69047619047619 sa=0 sb=0 sd=0 mult=1 m=1
csn_op0_0000_s2_w30_2 sn_op0_0000_s2_w30_2 0 {C_SN}
XMWR_op0_0000_s2_w30_3 sn_op0_0000_s2_w30_3 wwl_des wbl_op0_0000_s2_w30 0 sky130_fd_pr__nfet_01v8 L=0.15 W=0.42 nf=1 ad=0.1218 as=0.1218 pd=1.42 ps=1.42 nrd=0.69047619047619  nrs=0.69047619047619 sa=0 sb=0 sd=0 mult=1 m=1
XMRD_op0_0000_s2_w30_3 rbl_op0_0000_s2_w30 sn_op0_0000_s2_w30_3 rwl_des 0 sky130_fd_pr__nfet_01v8 L=0.15 W=0.42 nf=1 ad=0.1218 as=0.1218 pd=1.42 ps=1.42 nrd=0.69047619047619  nrs=0.69047619047619 sa=0 sb=0 sd=0 mult=1 m=1
csn_op0_0000_s2_w30_3 sn_op0_0000_s2_w30_3 0 {C_SN}
XMN1_op0_0000_s2_w30 rbl_op0_0000_s2_w30 ref_op0_0000_s2_w30 vn_op0_0000_s2_w30 0 sky130_fd_pr__nfet_01v8 L=0.15 W=1 nf=1 ad=0.29 as=0.29 pd=2.58 ps=2.58 mult=1 m=1
XMN2_op0_0000_s2_w30 ref_op0_0000_s2_w30 rbl_op0_0000_s2_w30 vn_op0_0000_s2_w30 0 sky130_fd_pr__nfet_01v8 L=0.15 W=1 nf=1 ad=0.29 as=0.29 pd=2.58 ps=2.58 mult=1 m=1
XMP1_op0_0000_s2_w30 rbl_op0_0000_s2_w30 ref_op0_0000_s2_w30 vp_op0_0000_s2_w30 vdd sky130_fd_pr__pfet_01v8 L=0.15 W=2 nf=1 ad=0.58 as=0.58 pd=4.58 ps=4.58 mult=1 m=1
XMP2_op0_0000_s2_w30 ref_op0_0000_s2_w30 rbl_op0_0000_s2_w30 vp_op0_0000_s2_w30 vdd sky130_fd_pr__pfet_01v8 L=0.15 W=2 nf=1 ad=0.58 as=0.58 pd=4.58 ps=4.58 mult=1 m=1
XMNF_op0_0000_s2_w30 vn_op0_0000_s2_w30 en_op0_0000_s2_w30 0 0 sky130_fd_pr__nfet_01v8 L=0.15 W=2 nf=1 ad=0.58 as=0.58 pd=4.58 ps=4.58 mult=1 m=1
XMPH_op0_0000_s2_w30 vp_op0_0000_s2_w30 enb_op0_0000_s2_w30 vdd vdd sky130_fd_pr__pfet_01v8 L=0.15 W=4 nf=1 ad=1.16 as=1.16 pd=8.58 ps=8.58 mult=1 m=1
bd_op0_0000_s2_w30 d_op0_0000_s2_w30 0 v=v(rbl_op0_0000_s2_w30)-v(ref_op0_0000_s2_w30)

* ---- instance 215: op0_0000_s2_w50 (t_en 6 ns, WWL 7..57 ns, release 59 ns) ----
ven_op0_0000_s2_w50  en_op0_0000_s2_w50  0 pwl(0 0 6.0000e-09 0 6.1000e-09 {VDD} 5.9000e-08 {VDD} 5.9100e-08 0)
venb_op0_0000_s2_w50 enb_op0_0000_s2_w50 0 pwl(0 {VDD} 6.0000e-09 {VDD} 6.1000e-09 0 5.9000e-08 0 5.9100e-08 {VDD})
vrs_op0_0000_s2_w50  rwls_op0_0000_s2_w50 0 pwl(0 {VDD} {T_READ} {VDD} {T_READ+TEDGE} 0 5.9000e-08 0 5.9100e-08 {VDD})
vww_op0_0000_s2_w50  wwl_op0_0000_s2_w50 0 pwl(0 0 7.0000e-09 0 7.1000e-09 {VDD} 5.7000e-08 {VDD} 5.7100e-08 0)
vwc_op0_0000_s2_w50  wbc_op0_0000_s2_w50 0 pwl(0 0 7.0000e-09 0 7.1000e-09 {VDD} 5.9000e-08 {VDD} 5.9100e-08 0)
swb_op0_0000_s2_w50 ref_op0_0000_s2_w50 wbl_op0_0000_s2_w50 wbc_op0_0000_s2_w50 0 swwbl
cwbl_op0_0000_s2_w50 wbl_op0_0000_s2_w50 0 {C_WBL}
spa_op0_0000_s2_w50 prea rbl_op0_0000_s2_w50 ctl 0 swpre
spr_op0_0000_s2_w50 pref ref_op0_0000_s2_w50 ctl 0 swpre
crbl_op0_0000_s2_w50 rbl_op0_0000_s2_w50 0 {C_RBL}
cref_op0_0000_s2_w50 ref_op0_0000_s2_w50 0 {C_RBL}   $ ASSUMPTION: ideal matched dummy load
XMWR_op0_0000_s2_w50_0 sn_op0_0000_s2_w50_0 wwl_op0_0000_s2_w50 wbl_op0_0000_s2_w50 0 sky130_fd_pr__nfet_01v8 L=0.15 W=0.42 nf=1 ad=0.1218 as=0.1218 pd=1.42 ps=1.42 nrd=0.69047619047619  nrs=0.69047619047619 sa=0 sb=0 sd=0 mult=1 m=1
XMRD_op0_0000_s2_w50_0 rbl_op0_0000_s2_w50 sn_op0_0000_s2_w50_0 rwls_op0_0000_s2_w50 0 sky130_fd_pr__nfet_01v8 L=0.15 W=0.42 nf=1 ad=0.1218 as=0.1218 pd=1.42 ps=1.42 nrd=0.69047619047619  nrs=0.69047619047619 sa=0 sb=0 sd=0 mult=1 m=1
csn_op0_0000_s2_w50_0 sn_op0_0000_s2_w50_0 0 {C_SN}
XMWR_op0_0000_s2_w50_1 sn_op0_0000_s2_w50_1 wwl_des wbl_op0_0000_s2_w50 0 sky130_fd_pr__nfet_01v8 L=0.15 W=0.42 nf=1 ad=0.1218 as=0.1218 pd=1.42 ps=1.42 nrd=0.69047619047619  nrs=0.69047619047619 sa=0 sb=0 sd=0 mult=1 m=1
XMRD_op0_0000_s2_w50_1 rbl_op0_0000_s2_w50 sn_op0_0000_s2_w50_1 rwl_des 0 sky130_fd_pr__nfet_01v8 L=0.15 W=0.42 nf=1 ad=0.1218 as=0.1218 pd=1.42 ps=1.42 nrd=0.69047619047619  nrs=0.69047619047619 sa=0 sb=0 sd=0 mult=1 m=1
csn_op0_0000_s2_w50_1 sn_op0_0000_s2_w50_1 0 {C_SN}
XMWR_op0_0000_s2_w50_2 sn_op0_0000_s2_w50_2 wwl_des wbl_op0_0000_s2_w50 0 sky130_fd_pr__nfet_01v8 L=0.15 W=0.42 nf=1 ad=0.1218 as=0.1218 pd=1.42 ps=1.42 nrd=0.69047619047619  nrs=0.69047619047619 sa=0 sb=0 sd=0 mult=1 m=1
XMRD_op0_0000_s2_w50_2 rbl_op0_0000_s2_w50 sn_op0_0000_s2_w50_2 rwl_des 0 sky130_fd_pr__nfet_01v8 L=0.15 W=0.42 nf=1 ad=0.1218 as=0.1218 pd=1.42 ps=1.42 nrd=0.69047619047619  nrs=0.69047619047619 sa=0 sb=0 sd=0 mult=1 m=1
csn_op0_0000_s2_w50_2 sn_op0_0000_s2_w50_2 0 {C_SN}
XMWR_op0_0000_s2_w50_3 sn_op0_0000_s2_w50_3 wwl_des wbl_op0_0000_s2_w50 0 sky130_fd_pr__nfet_01v8 L=0.15 W=0.42 nf=1 ad=0.1218 as=0.1218 pd=1.42 ps=1.42 nrd=0.69047619047619  nrs=0.69047619047619 sa=0 sb=0 sd=0 mult=1 m=1
XMRD_op0_0000_s2_w50_3 rbl_op0_0000_s2_w50 sn_op0_0000_s2_w50_3 rwl_des 0 sky130_fd_pr__nfet_01v8 L=0.15 W=0.42 nf=1 ad=0.1218 as=0.1218 pd=1.42 ps=1.42 nrd=0.69047619047619  nrs=0.69047619047619 sa=0 sb=0 sd=0 mult=1 m=1
csn_op0_0000_s2_w50_3 sn_op0_0000_s2_w50_3 0 {C_SN}
XMN1_op0_0000_s2_w50 rbl_op0_0000_s2_w50 ref_op0_0000_s2_w50 vn_op0_0000_s2_w50 0 sky130_fd_pr__nfet_01v8 L=0.15 W=1 nf=1 ad=0.29 as=0.29 pd=2.58 ps=2.58 mult=1 m=1
XMN2_op0_0000_s2_w50 ref_op0_0000_s2_w50 rbl_op0_0000_s2_w50 vn_op0_0000_s2_w50 0 sky130_fd_pr__nfet_01v8 L=0.15 W=1 nf=1 ad=0.29 as=0.29 pd=2.58 ps=2.58 mult=1 m=1
XMP1_op0_0000_s2_w50 rbl_op0_0000_s2_w50 ref_op0_0000_s2_w50 vp_op0_0000_s2_w50 vdd sky130_fd_pr__pfet_01v8 L=0.15 W=2 nf=1 ad=0.58 as=0.58 pd=4.58 ps=4.58 mult=1 m=1
XMP2_op0_0000_s2_w50 ref_op0_0000_s2_w50 rbl_op0_0000_s2_w50 vp_op0_0000_s2_w50 vdd sky130_fd_pr__pfet_01v8 L=0.15 W=2 nf=1 ad=0.58 as=0.58 pd=4.58 ps=4.58 mult=1 m=1
XMNF_op0_0000_s2_w50 vn_op0_0000_s2_w50 en_op0_0000_s2_w50 0 0 sky130_fd_pr__nfet_01v8 L=0.15 W=2 nf=1 ad=0.58 as=0.58 pd=4.58 ps=4.58 mult=1 m=1
XMPH_op0_0000_s2_w50 vp_op0_0000_s2_w50 enb_op0_0000_s2_w50 vdd vdd sky130_fd_pr__pfet_01v8 L=0.15 W=4 nf=1 ad=1.16 as=1.16 pd=8.58 ps=8.58 mult=1 m=1
bd_op0_0000_s2_w50 d_op0_0000_s2_w50 0 v=v(rbl_op0_0000_s2_w50)-v(ref_op0_0000_s2_w50)

* ---- instance 216: op0_0000_s5_w0p2 (t_en 9 ns, WWL 10..10.2 ns, release 12.2 ns) ----
ven_op0_0000_s5_w0p2  en_op0_0000_s5_w0p2  0 pwl(0 0 9.0000e-09 0 9.1000e-09 {VDD} 1.2200e-08 {VDD} 1.2300e-08 0)
venb_op0_0000_s5_w0p2 enb_op0_0000_s5_w0p2 0 pwl(0 {VDD} 9.0000e-09 {VDD} 9.1000e-09 0 1.2200e-08 0 1.2300e-08 {VDD})
vrs_op0_0000_s5_w0p2  rwls_op0_0000_s5_w0p2 0 pwl(0 {VDD} {T_READ} {VDD} {T_READ+TEDGE} 0 1.2200e-08 0 1.2300e-08 {VDD})
vww_op0_0000_s5_w0p2  wwl_op0_0000_s5_w0p2 0 pwl(0 0 1.0000e-08 0 1.0100e-08 {VDD} 1.0200e-08 {VDD} 1.0300e-08 0)
vwc_op0_0000_s5_w0p2  wbc_op0_0000_s5_w0p2 0 pwl(0 0 1.0000e-08 0 1.0100e-08 {VDD} 1.2200e-08 {VDD} 1.2300e-08 0)
swb_op0_0000_s5_w0p2 ref_op0_0000_s5_w0p2 wbl_op0_0000_s5_w0p2 wbc_op0_0000_s5_w0p2 0 swwbl
cwbl_op0_0000_s5_w0p2 wbl_op0_0000_s5_w0p2 0 {C_WBL}
spa_op0_0000_s5_w0p2 prea rbl_op0_0000_s5_w0p2 ctl 0 swpre
spr_op0_0000_s5_w0p2 pref ref_op0_0000_s5_w0p2 ctl 0 swpre
crbl_op0_0000_s5_w0p2 rbl_op0_0000_s5_w0p2 0 {C_RBL}
cref_op0_0000_s5_w0p2 ref_op0_0000_s5_w0p2 0 {C_RBL}   $ ASSUMPTION: ideal matched dummy load
XMWR_op0_0000_s5_w0p2_0 sn_op0_0000_s5_w0p2_0 wwl_op0_0000_s5_w0p2 wbl_op0_0000_s5_w0p2 0 sky130_fd_pr__nfet_01v8 L=0.15 W=0.42 nf=1 ad=0.1218 as=0.1218 pd=1.42 ps=1.42 nrd=0.69047619047619  nrs=0.69047619047619 sa=0 sb=0 sd=0 mult=1 m=1
XMRD_op0_0000_s5_w0p2_0 rbl_op0_0000_s5_w0p2 sn_op0_0000_s5_w0p2_0 rwls_op0_0000_s5_w0p2 0 sky130_fd_pr__nfet_01v8 L=0.15 W=0.42 nf=1 ad=0.1218 as=0.1218 pd=1.42 ps=1.42 nrd=0.69047619047619  nrs=0.69047619047619 sa=0 sb=0 sd=0 mult=1 m=1
csn_op0_0000_s5_w0p2_0 sn_op0_0000_s5_w0p2_0 0 {C_SN}
XMWR_op0_0000_s5_w0p2_1 sn_op0_0000_s5_w0p2_1 wwl_des wbl_op0_0000_s5_w0p2 0 sky130_fd_pr__nfet_01v8 L=0.15 W=0.42 nf=1 ad=0.1218 as=0.1218 pd=1.42 ps=1.42 nrd=0.69047619047619  nrs=0.69047619047619 sa=0 sb=0 sd=0 mult=1 m=1
XMRD_op0_0000_s5_w0p2_1 rbl_op0_0000_s5_w0p2 sn_op0_0000_s5_w0p2_1 rwl_des 0 sky130_fd_pr__nfet_01v8 L=0.15 W=0.42 nf=1 ad=0.1218 as=0.1218 pd=1.42 ps=1.42 nrd=0.69047619047619  nrs=0.69047619047619 sa=0 sb=0 sd=0 mult=1 m=1
csn_op0_0000_s5_w0p2_1 sn_op0_0000_s5_w0p2_1 0 {C_SN}
XMWR_op0_0000_s5_w0p2_2 sn_op0_0000_s5_w0p2_2 wwl_des wbl_op0_0000_s5_w0p2 0 sky130_fd_pr__nfet_01v8 L=0.15 W=0.42 nf=1 ad=0.1218 as=0.1218 pd=1.42 ps=1.42 nrd=0.69047619047619  nrs=0.69047619047619 sa=0 sb=0 sd=0 mult=1 m=1
XMRD_op0_0000_s5_w0p2_2 rbl_op0_0000_s5_w0p2 sn_op0_0000_s5_w0p2_2 rwl_des 0 sky130_fd_pr__nfet_01v8 L=0.15 W=0.42 nf=1 ad=0.1218 as=0.1218 pd=1.42 ps=1.42 nrd=0.69047619047619  nrs=0.69047619047619 sa=0 sb=0 sd=0 mult=1 m=1
csn_op0_0000_s5_w0p2_2 sn_op0_0000_s5_w0p2_2 0 {C_SN}
XMWR_op0_0000_s5_w0p2_3 sn_op0_0000_s5_w0p2_3 wwl_des wbl_op0_0000_s5_w0p2 0 sky130_fd_pr__nfet_01v8 L=0.15 W=0.42 nf=1 ad=0.1218 as=0.1218 pd=1.42 ps=1.42 nrd=0.69047619047619  nrs=0.69047619047619 sa=0 sb=0 sd=0 mult=1 m=1
XMRD_op0_0000_s5_w0p2_3 rbl_op0_0000_s5_w0p2 sn_op0_0000_s5_w0p2_3 rwl_des 0 sky130_fd_pr__nfet_01v8 L=0.15 W=0.42 nf=1 ad=0.1218 as=0.1218 pd=1.42 ps=1.42 nrd=0.69047619047619  nrs=0.69047619047619 sa=0 sb=0 sd=0 mult=1 m=1
csn_op0_0000_s5_w0p2_3 sn_op0_0000_s5_w0p2_3 0 {C_SN}
XMN1_op0_0000_s5_w0p2 rbl_op0_0000_s5_w0p2 ref_op0_0000_s5_w0p2 vn_op0_0000_s5_w0p2 0 sky130_fd_pr__nfet_01v8 L=0.15 W=1 nf=1 ad=0.29 as=0.29 pd=2.58 ps=2.58 mult=1 m=1
XMN2_op0_0000_s5_w0p2 ref_op0_0000_s5_w0p2 rbl_op0_0000_s5_w0p2 vn_op0_0000_s5_w0p2 0 sky130_fd_pr__nfet_01v8 L=0.15 W=1 nf=1 ad=0.29 as=0.29 pd=2.58 ps=2.58 mult=1 m=1
XMP1_op0_0000_s5_w0p2 rbl_op0_0000_s5_w0p2 ref_op0_0000_s5_w0p2 vp_op0_0000_s5_w0p2 vdd sky130_fd_pr__pfet_01v8 L=0.15 W=2 nf=1 ad=0.58 as=0.58 pd=4.58 ps=4.58 mult=1 m=1
XMP2_op0_0000_s5_w0p2 ref_op0_0000_s5_w0p2 rbl_op0_0000_s5_w0p2 vp_op0_0000_s5_w0p2 vdd sky130_fd_pr__pfet_01v8 L=0.15 W=2 nf=1 ad=0.58 as=0.58 pd=4.58 ps=4.58 mult=1 m=1
XMNF_op0_0000_s5_w0p2 vn_op0_0000_s5_w0p2 en_op0_0000_s5_w0p2 0 0 sky130_fd_pr__nfet_01v8 L=0.15 W=2 nf=1 ad=0.58 as=0.58 pd=4.58 ps=4.58 mult=1 m=1
XMPH_op0_0000_s5_w0p2 vp_op0_0000_s5_w0p2 enb_op0_0000_s5_w0p2 vdd vdd sky130_fd_pr__pfet_01v8 L=0.15 W=4 nf=1 ad=1.16 as=1.16 pd=8.58 ps=8.58 mult=1 m=1
bd_op0_0000_s5_w0p2 d_op0_0000_s5_w0p2 0 v=v(rbl_op0_0000_s5_w0p2)-v(ref_op0_0000_s5_w0p2)

* ---- instance 217: op0_0000_s5_w0p5 (t_en 9 ns, WWL 10..10.5 ns, release 12.5 ns) ----
ven_op0_0000_s5_w0p5  en_op0_0000_s5_w0p5  0 pwl(0 0 9.0000e-09 0 9.1000e-09 {VDD} 1.2500e-08 {VDD} 1.2600e-08 0)
venb_op0_0000_s5_w0p5 enb_op0_0000_s5_w0p5 0 pwl(0 {VDD} 9.0000e-09 {VDD} 9.1000e-09 0 1.2500e-08 0 1.2600e-08 {VDD})
vrs_op0_0000_s5_w0p5  rwls_op0_0000_s5_w0p5 0 pwl(0 {VDD} {T_READ} {VDD} {T_READ+TEDGE} 0 1.2500e-08 0 1.2600e-08 {VDD})
vww_op0_0000_s5_w0p5  wwl_op0_0000_s5_w0p5 0 pwl(0 0 1.0000e-08 0 1.0100e-08 {VDD} 1.0500e-08 {VDD} 1.0600e-08 0)
vwc_op0_0000_s5_w0p5  wbc_op0_0000_s5_w0p5 0 pwl(0 0 1.0000e-08 0 1.0100e-08 {VDD} 1.2500e-08 {VDD} 1.2600e-08 0)
swb_op0_0000_s5_w0p5 ref_op0_0000_s5_w0p5 wbl_op0_0000_s5_w0p5 wbc_op0_0000_s5_w0p5 0 swwbl
cwbl_op0_0000_s5_w0p5 wbl_op0_0000_s5_w0p5 0 {C_WBL}
spa_op0_0000_s5_w0p5 prea rbl_op0_0000_s5_w0p5 ctl 0 swpre
spr_op0_0000_s5_w0p5 pref ref_op0_0000_s5_w0p5 ctl 0 swpre
crbl_op0_0000_s5_w0p5 rbl_op0_0000_s5_w0p5 0 {C_RBL}
cref_op0_0000_s5_w0p5 ref_op0_0000_s5_w0p5 0 {C_RBL}   $ ASSUMPTION: ideal matched dummy load
XMWR_op0_0000_s5_w0p5_0 sn_op0_0000_s5_w0p5_0 wwl_op0_0000_s5_w0p5 wbl_op0_0000_s5_w0p5 0 sky130_fd_pr__nfet_01v8 L=0.15 W=0.42 nf=1 ad=0.1218 as=0.1218 pd=1.42 ps=1.42 nrd=0.69047619047619  nrs=0.69047619047619 sa=0 sb=0 sd=0 mult=1 m=1
XMRD_op0_0000_s5_w0p5_0 rbl_op0_0000_s5_w0p5 sn_op0_0000_s5_w0p5_0 rwls_op0_0000_s5_w0p5 0 sky130_fd_pr__nfet_01v8 L=0.15 W=0.42 nf=1 ad=0.1218 as=0.1218 pd=1.42 ps=1.42 nrd=0.69047619047619  nrs=0.69047619047619 sa=0 sb=0 sd=0 mult=1 m=1
csn_op0_0000_s5_w0p5_0 sn_op0_0000_s5_w0p5_0 0 {C_SN}
XMWR_op0_0000_s5_w0p5_1 sn_op0_0000_s5_w0p5_1 wwl_des wbl_op0_0000_s5_w0p5 0 sky130_fd_pr__nfet_01v8 L=0.15 W=0.42 nf=1 ad=0.1218 as=0.1218 pd=1.42 ps=1.42 nrd=0.69047619047619  nrs=0.69047619047619 sa=0 sb=0 sd=0 mult=1 m=1
XMRD_op0_0000_s5_w0p5_1 rbl_op0_0000_s5_w0p5 sn_op0_0000_s5_w0p5_1 rwl_des 0 sky130_fd_pr__nfet_01v8 L=0.15 W=0.42 nf=1 ad=0.1218 as=0.1218 pd=1.42 ps=1.42 nrd=0.69047619047619  nrs=0.69047619047619 sa=0 sb=0 sd=0 mult=1 m=1
csn_op0_0000_s5_w0p5_1 sn_op0_0000_s5_w0p5_1 0 {C_SN}
XMWR_op0_0000_s5_w0p5_2 sn_op0_0000_s5_w0p5_2 wwl_des wbl_op0_0000_s5_w0p5 0 sky130_fd_pr__nfet_01v8 L=0.15 W=0.42 nf=1 ad=0.1218 as=0.1218 pd=1.42 ps=1.42 nrd=0.69047619047619  nrs=0.69047619047619 sa=0 sb=0 sd=0 mult=1 m=1
XMRD_op0_0000_s5_w0p5_2 rbl_op0_0000_s5_w0p5 sn_op0_0000_s5_w0p5_2 rwl_des 0 sky130_fd_pr__nfet_01v8 L=0.15 W=0.42 nf=1 ad=0.1218 as=0.1218 pd=1.42 ps=1.42 nrd=0.69047619047619  nrs=0.69047619047619 sa=0 sb=0 sd=0 mult=1 m=1
csn_op0_0000_s5_w0p5_2 sn_op0_0000_s5_w0p5_2 0 {C_SN}
XMWR_op0_0000_s5_w0p5_3 sn_op0_0000_s5_w0p5_3 wwl_des wbl_op0_0000_s5_w0p5 0 sky130_fd_pr__nfet_01v8 L=0.15 W=0.42 nf=1 ad=0.1218 as=0.1218 pd=1.42 ps=1.42 nrd=0.69047619047619  nrs=0.69047619047619 sa=0 sb=0 sd=0 mult=1 m=1
XMRD_op0_0000_s5_w0p5_3 rbl_op0_0000_s5_w0p5 sn_op0_0000_s5_w0p5_3 rwl_des 0 sky130_fd_pr__nfet_01v8 L=0.15 W=0.42 nf=1 ad=0.1218 as=0.1218 pd=1.42 ps=1.42 nrd=0.69047619047619  nrs=0.69047619047619 sa=0 sb=0 sd=0 mult=1 m=1
csn_op0_0000_s5_w0p5_3 sn_op0_0000_s5_w0p5_3 0 {C_SN}
XMN1_op0_0000_s5_w0p5 rbl_op0_0000_s5_w0p5 ref_op0_0000_s5_w0p5 vn_op0_0000_s5_w0p5 0 sky130_fd_pr__nfet_01v8 L=0.15 W=1 nf=1 ad=0.29 as=0.29 pd=2.58 ps=2.58 mult=1 m=1
XMN2_op0_0000_s5_w0p5 ref_op0_0000_s5_w0p5 rbl_op0_0000_s5_w0p5 vn_op0_0000_s5_w0p5 0 sky130_fd_pr__nfet_01v8 L=0.15 W=1 nf=1 ad=0.29 as=0.29 pd=2.58 ps=2.58 mult=1 m=1
XMP1_op0_0000_s5_w0p5 rbl_op0_0000_s5_w0p5 ref_op0_0000_s5_w0p5 vp_op0_0000_s5_w0p5 vdd sky130_fd_pr__pfet_01v8 L=0.15 W=2 nf=1 ad=0.58 as=0.58 pd=4.58 ps=4.58 mult=1 m=1
XMP2_op0_0000_s5_w0p5 ref_op0_0000_s5_w0p5 rbl_op0_0000_s5_w0p5 vp_op0_0000_s5_w0p5 vdd sky130_fd_pr__pfet_01v8 L=0.15 W=2 nf=1 ad=0.58 as=0.58 pd=4.58 ps=4.58 mult=1 m=1
XMNF_op0_0000_s5_w0p5 vn_op0_0000_s5_w0p5 en_op0_0000_s5_w0p5 0 0 sky130_fd_pr__nfet_01v8 L=0.15 W=2 nf=1 ad=0.58 as=0.58 pd=4.58 ps=4.58 mult=1 m=1
XMPH_op0_0000_s5_w0p5 vp_op0_0000_s5_w0p5 enb_op0_0000_s5_w0p5 vdd vdd sky130_fd_pr__pfet_01v8 L=0.15 W=4 nf=1 ad=1.16 as=1.16 pd=8.58 ps=8.58 mult=1 m=1
bd_op0_0000_s5_w0p5 d_op0_0000_s5_w0p5 0 v=v(rbl_op0_0000_s5_w0p5)-v(ref_op0_0000_s5_w0p5)

* ---- instance 218: op0_0000_s5_w1 (t_en 9 ns, WWL 10..11 ns, release 13 ns) ----
ven_op0_0000_s5_w1  en_op0_0000_s5_w1  0 pwl(0 0 9.0000e-09 0 9.1000e-09 {VDD} 1.3000e-08 {VDD} 1.3100e-08 0)
venb_op0_0000_s5_w1 enb_op0_0000_s5_w1 0 pwl(0 {VDD} 9.0000e-09 {VDD} 9.1000e-09 0 1.3000e-08 0 1.3100e-08 {VDD})
vrs_op0_0000_s5_w1  rwls_op0_0000_s5_w1 0 pwl(0 {VDD} {T_READ} {VDD} {T_READ+TEDGE} 0 1.3000e-08 0 1.3100e-08 {VDD})
vww_op0_0000_s5_w1  wwl_op0_0000_s5_w1 0 pwl(0 0 1.0000e-08 0 1.0100e-08 {VDD} 1.1000e-08 {VDD} 1.1100e-08 0)
vwc_op0_0000_s5_w1  wbc_op0_0000_s5_w1 0 pwl(0 0 1.0000e-08 0 1.0100e-08 {VDD} 1.3000e-08 {VDD} 1.3100e-08 0)
swb_op0_0000_s5_w1 ref_op0_0000_s5_w1 wbl_op0_0000_s5_w1 wbc_op0_0000_s5_w1 0 swwbl
cwbl_op0_0000_s5_w1 wbl_op0_0000_s5_w1 0 {C_WBL}
spa_op0_0000_s5_w1 prea rbl_op0_0000_s5_w1 ctl 0 swpre
spr_op0_0000_s5_w1 pref ref_op0_0000_s5_w1 ctl 0 swpre
crbl_op0_0000_s5_w1 rbl_op0_0000_s5_w1 0 {C_RBL}
cref_op0_0000_s5_w1 ref_op0_0000_s5_w1 0 {C_RBL}   $ ASSUMPTION: ideal matched dummy load
XMWR_op0_0000_s5_w1_0 sn_op0_0000_s5_w1_0 wwl_op0_0000_s5_w1 wbl_op0_0000_s5_w1 0 sky130_fd_pr__nfet_01v8 L=0.15 W=0.42 nf=1 ad=0.1218 as=0.1218 pd=1.42 ps=1.42 nrd=0.69047619047619  nrs=0.69047619047619 sa=0 sb=0 sd=0 mult=1 m=1
XMRD_op0_0000_s5_w1_0 rbl_op0_0000_s5_w1 sn_op0_0000_s5_w1_0 rwls_op0_0000_s5_w1 0 sky130_fd_pr__nfet_01v8 L=0.15 W=0.42 nf=1 ad=0.1218 as=0.1218 pd=1.42 ps=1.42 nrd=0.69047619047619  nrs=0.69047619047619 sa=0 sb=0 sd=0 mult=1 m=1
csn_op0_0000_s5_w1_0 sn_op0_0000_s5_w1_0 0 {C_SN}
XMWR_op0_0000_s5_w1_1 sn_op0_0000_s5_w1_1 wwl_des wbl_op0_0000_s5_w1 0 sky130_fd_pr__nfet_01v8 L=0.15 W=0.42 nf=1 ad=0.1218 as=0.1218 pd=1.42 ps=1.42 nrd=0.69047619047619  nrs=0.69047619047619 sa=0 sb=0 sd=0 mult=1 m=1
XMRD_op0_0000_s5_w1_1 rbl_op0_0000_s5_w1 sn_op0_0000_s5_w1_1 rwl_des 0 sky130_fd_pr__nfet_01v8 L=0.15 W=0.42 nf=1 ad=0.1218 as=0.1218 pd=1.42 ps=1.42 nrd=0.69047619047619  nrs=0.69047619047619 sa=0 sb=0 sd=0 mult=1 m=1
csn_op0_0000_s5_w1_1 sn_op0_0000_s5_w1_1 0 {C_SN}
XMWR_op0_0000_s5_w1_2 sn_op0_0000_s5_w1_2 wwl_des wbl_op0_0000_s5_w1 0 sky130_fd_pr__nfet_01v8 L=0.15 W=0.42 nf=1 ad=0.1218 as=0.1218 pd=1.42 ps=1.42 nrd=0.69047619047619  nrs=0.69047619047619 sa=0 sb=0 sd=0 mult=1 m=1
XMRD_op0_0000_s5_w1_2 rbl_op0_0000_s5_w1 sn_op0_0000_s5_w1_2 rwl_des 0 sky130_fd_pr__nfet_01v8 L=0.15 W=0.42 nf=1 ad=0.1218 as=0.1218 pd=1.42 ps=1.42 nrd=0.69047619047619  nrs=0.69047619047619 sa=0 sb=0 sd=0 mult=1 m=1
csn_op0_0000_s5_w1_2 sn_op0_0000_s5_w1_2 0 {C_SN}
XMWR_op0_0000_s5_w1_3 sn_op0_0000_s5_w1_3 wwl_des wbl_op0_0000_s5_w1 0 sky130_fd_pr__nfet_01v8 L=0.15 W=0.42 nf=1 ad=0.1218 as=0.1218 pd=1.42 ps=1.42 nrd=0.69047619047619  nrs=0.69047619047619 sa=0 sb=0 sd=0 mult=1 m=1
XMRD_op0_0000_s5_w1_3 rbl_op0_0000_s5_w1 sn_op0_0000_s5_w1_3 rwl_des 0 sky130_fd_pr__nfet_01v8 L=0.15 W=0.42 nf=1 ad=0.1218 as=0.1218 pd=1.42 ps=1.42 nrd=0.69047619047619  nrs=0.69047619047619 sa=0 sb=0 sd=0 mult=1 m=1
csn_op0_0000_s5_w1_3 sn_op0_0000_s5_w1_3 0 {C_SN}
XMN1_op0_0000_s5_w1 rbl_op0_0000_s5_w1 ref_op0_0000_s5_w1 vn_op0_0000_s5_w1 0 sky130_fd_pr__nfet_01v8 L=0.15 W=1 nf=1 ad=0.29 as=0.29 pd=2.58 ps=2.58 mult=1 m=1
XMN2_op0_0000_s5_w1 ref_op0_0000_s5_w1 rbl_op0_0000_s5_w1 vn_op0_0000_s5_w1 0 sky130_fd_pr__nfet_01v8 L=0.15 W=1 nf=1 ad=0.29 as=0.29 pd=2.58 ps=2.58 mult=1 m=1
XMP1_op0_0000_s5_w1 rbl_op0_0000_s5_w1 ref_op0_0000_s5_w1 vp_op0_0000_s5_w1 vdd sky130_fd_pr__pfet_01v8 L=0.15 W=2 nf=1 ad=0.58 as=0.58 pd=4.58 ps=4.58 mult=1 m=1
XMP2_op0_0000_s5_w1 ref_op0_0000_s5_w1 rbl_op0_0000_s5_w1 vp_op0_0000_s5_w1 vdd sky130_fd_pr__pfet_01v8 L=0.15 W=2 nf=1 ad=0.58 as=0.58 pd=4.58 ps=4.58 mult=1 m=1
XMNF_op0_0000_s5_w1 vn_op0_0000_s5_w1 en_op0_0000_s5_w1 0 0 sky130_fd_pr__nfet_01v8 L=0.15 W=2 nf=1 ad=0.58 as=0.58 pd=4.58 ps=4.58 mult=1 m=1
XMPH_op0_0000_s5_w1 vp_op0_0000_s5_w1 enb_op0_0000_s5_w1 vdd vdd sky130_fd_pr__pfet_01v8 L=0.15 W=4 nf=1 ad=1.16 as=1.16 pd=8.58 ps=8.58 mult=1 m=1
bd_op0_0000_s5_w1 d_op0_0000_s5_w1 0 v=v(rbl_op0_0000_s5_w1)-v(ref_op0_0000_s5_w1)

* ---- instance 219: op0_0000_s5_w2 (t_en 9 ns, WWL 10..12 ns, release 14 ns) ----
ven_op0_0000_s5_w2  en_op0_0000_s5_w2  0 pwl(0 0 9.0000e-09 0 9.1000e-09 {VDD} 1.4000e-08 {VDD} 1.4100e-08 0)
venb_op0_0000_s5_w2 enb_op0_0000_s5_w2 0 pwl(0 {VDD} 9.0000e-09 {VDD} 9.1000e-09 0 1.4000e-08 0 1.4100e-08 {VDD})
vrs_op0_0000_s5_w2  rwls_op0_0000_s5_w2 0 pwl(0 {VDD} {T_READ} {VDD} {T_READ+TEDGE} 0 1.4000e-08 0 1.4100e-08 {VDD})
vww_op0_0000_s5_w2  wwl_op0_0000_s5_w2 0 pwl(0 0 1.0000e-08 0 1.0100e-08 {VDD} 1.2000e-08 {VDD} 1.2100e-08 0)
vwc_op0_0000_s5_w2  wbc_op0_0000_s5_w2 0 pwl(0 0 1.0000e-08 0 1.0100e-08 {VDD} 1.4000e-08 {VDD} 1.4100e-08 0)
swb_op0_0000_s5_w2 ref_op0_0000_s5_w2 wbl_op0_0000_s5_w2 wbc_op0_0000_s5_w2 0 swwbl
cwbl_op0_0000_s5_w2 wbl_op0_0000_s5_w2 0 {C_WBL}
spa_op0_0000_s5_w2 prea rbl_op0_0000_s5_w2 ctl 0 swpre
spr_op0_0000_s5_w2 pref ref_op0_0000_s5_w2 ctl 0 swpre
crbl_op0_0000_s5_w2 rbl_op0_0000_s5_w2 0 {C_RBL}
cref_op0_0000_s5_w2 ref_op0_0000_s5_w2 0 {C_RBL}   $ ASSUMPTION: ideal matched dummy load
XMWR_op0_0000_s5_w2_0 sn_op0_0000_s5_w2_0 wwl_op0_0000_s5_w2 wbl_op0_0000_s5_w2 0 sky130_fd_pr__nfet_01v8 L=0.15 W=0.42 nf=1 ad=0.1218 as=0.1218 pd=1.42 ps=1.42 nrd=0.69047619047619  nrs=0.69047619047619 sa=0 sb=0 sd=0 mult=1 m=1
XMRD_op0_0000_s5_w2_0 rbl_op0_0000_s5_w2 sn_op0_0000_s5_w2_0 rwls_op0_0000_s5_w2 0 sky130_fd_pr__nfet_01v8 L=0.15 W=0.42 nf=1 ad=0.1218 as=0.1218 pd=1.42 ps=1.42 nrd=0.69047619047619  nrs=0.69047619047619 sa=0 sb=0 sd=0 mult=1 m=1
csn_op0_0000_s5_w2_0 sn_op0_0000_s5_w2_0 0 {C_SN}
XMWR_op0_0000_s5_w2_1 sn_op0_0000_s5_w2_1 wwl_des wbl_op0_0000_s5_w2 0 sky130_fd_pr__nfet_01v8 L=0.15 W=0.42 nf=1 ad=0.1218 as=0.1218 pd=1.42 ps=1.42 nrd=0.69047619047619  nrs=0.69047619047619 sa=0 sb=0 sd=0 mult=1 m=1
XMRD_op0_0000_s5_w2_1 rbl_op0_0000_s5_w2 sn_op0_0000_s5_w2_1 rwl_des 0 sky130_fd_pr__nfet_01v8 L=0.15 W=0.42 nf=1 ad=0.1218 as=0.1218 pd=1.42 ps=1.42 nrd=0.69047619047619  nrs=0.69047619047619 sa=0 sb=0 sd=0 mult=1 m=1
csn_op0_0000_s5_w2_1 sn_op0_0000_s5_w2_1 0 {C_SN}
XMWR_op0_0000_s5_w2_2 sn_op0_0000_s5_w2_2 wwl_des wbl_op0_0000_s5_w2 0 sky130_fd_pr__nfet_01v8 L=0.15 W=0.42 nf=1 ad=0.1218 as=0.1218 pd=1.42 ps=1.42 nrd=0.69047619047619  nrs=0.69047619047619 sa=0 sb=0 sd=0 mult=1 m=1
XMRD_op0_0000_s5_w2_2 rbl_op0_0000_s5_w2 sn_op0_0000_s5_w2_2 rwl_des 0 sky130_fd_pr__nfet_01v8 L=0.15 W=0.42 nf=1 ad=0.1218 as=0.1218 pd=1.42 ps=1.42 nrd=0.69047619047619  nrs=0.69047619047619 sa=0 sb=0 sd=0 mult=1 m=1
csn_op0_0000_s5_w2_2 sn_op0_0000_s5_w2_2 0 {C_SN}
XMWR_op0_0000_s5_w2_3 sn_op0_0000_s5_w2_3 wwl_des wbl_op0_0000_s5_w2 0 sky130_fd_pr__nfet_01v8 L=0.15 W=0.42 nf=1 ad=0.1218 as=0.1218 pd=1.42 ps=1.42 nrd=0.69047619047619  nrs=0.69047619047619 sa=0 sb=0 sd=0 mult=1 m=1
XMRD_op0_0000_s5_w2_3 rbl_op0_0000_s5_w2 sn_op0_0000_s5_w2_3 rwl_des 0 sky130_fd_pr__nfet_01v8 L=0.15 W=0.42 nf=1 ad=0.1218 as=0.1218 pd=1.42 ps=1.42 nrd=0.69047619047619  nrs=0.69047619047619 sa=0 sb=0 sd=0 mult=1 m=1
csn_op0_0000_s5_w2_3 sn_op0_0000_s5_w2_3 0 {C_SN}
XMN1_op0_0000_s5_w2 rbl_op0_0000_s5_w2 ref_op0_0000_s5_w2 vn_op0_0000_s5_w2 0 sky130_fd_pr__nfet_01v8 L=0.15 W=1 nf=1 ad=0.29 as=0.29 pd=2.58 ps=2.58 mult=1 m=1
XMN2_op0_0000_s5_w2 ref_op0_0000_s5_w2 rbl_op0_0000_s5_w2 vn_op0_0000_s5_w2 0 sky130_fd_pr__nfet_01v8 L=0.15 W=1 nf=1 ad=0.29 as=0.29 pd=2.58 ps=2.58 mult=1 m=1
XMP1_op0_0000_s5_w2 rbl_op0_0000_s5_w2 ref_op0_0000_s5_w2 vp_op0_0000_s5_w2 vdd sky130_fd_pr__pfet_01v8 L=0.15 W=2 nf=1 ad=0.58 as=0.58 pd=4.58 ps=4.58 mult=1 m=1
XMP2_op0_0000_s5_w2 ref_op0_0000_s5_w2 rbl_op0_0000_s5_w2 vp_op0_0000_s5_w2 vdd sky130_fd_pr__pfet_01v8 L=0.15 W=2 nf=1 ad=0.58 as=0.58 pd=4.58 ps=4.58 mult=1 m=1
XMNF_op0_0000_s5_w2 vn_op0_0000_s5_w2 en_op0_0000_s5_w2 0 0 sky130_fd_pr__nfet_01v8 L=0.15 W=2 nf=1 ad=0.58 as=0.58 pd=4.58 ps=4.58 mult=1 m=1
XMPH_op0_0000_s5_w2 vp_op0_0000_s5_w2 enb_op0_0000_s5_w2 vdd vdd sky130_fd_pr__pfet_01v8 L=0.15 W=4 nf=1 ad=1.16 as=1.16 pd=8.58 ps=8.58 mult=1 m=1
bd_op0_0000_s5_w2 d_op0_0000_s5_w2 0 v=v(rbl_op0_0000_s5_w2)-v(ref_op0_0000_s5_w2)

* ---- instance 220: op0_0000_s5_w3 (t_en 9 ns, WWL 10..13 ns, release 15 ns) ----
ven_op0_0000_s5_w3  en_op0_0000_s5_w3  0 pwl(0 0 9.0000e-09 0 9.1000e-09 {VDD} 1.5000e-08 {VDD} 1.5100e-08 0)
venb_op0_0000_s5_w3 enb_op0_0000_s5_w3 0 pwl(0 {VDD} 9.0000e-09 {VDD} 9.1000e-09 0 1.5000e-08 0 1.5100e-08 {VDD})
vrs_op0_0000_s5_w3  rwls_op0_0000_s5_w3 0 pwl(0 {VDD} {T_READ} {VDD} {T_READ+TEDGE} 0 1.5000e-08 0 1.5100e-08 {VDD})
vww_op0_0000_s5_w3  wwl_op0_0000_s5_w3 0 pwl(0 0 1.0000e-08 0 1.0100e-08 {VDD} 1.3000e-08 {VDD} 1.3100e-08 0)
vwc_op0_0000_s5_w3  wbc_op0_0000_s5_w3 0 pwl(0 0 1.0000e-08 0 1.0100e-08 {VDD} 1.5000e-08 {VDD} 1.5100e-08 0)
swb_op0_0000_s5_w3 ref_op0_0000_s5_w3 wbl_op0_0000_s5_w3 wbc_op0_0000_s5_w3 0 swwbl
cwbl_op0_0000_s5_w3 wbl_op0_0000_s5_w3 0 {C_WBL}
spa_op0_0000_s5_w3 prea rbl_op0_0000_s5_w3 ctl 0 swpre
spr_op0_0000_s5_w3 pref ref_op0_0000_s5_w3 ctl 0 swpre
crbl_op0_0000_s5_w3 rbl_op0_0000_s5_w3 0 {C_RBL}
cref_op0_0000_s5_w3 ref_op0_0000_s5_w3 0 {C_RBL}   $ ASSUMPTION: ideal matched dummy load
XMWR_op0_0000_s5_w3_0 sn_op0_0000_s5_w3_0 wwl_op0_0000_s5_w3 wbl_op0_0000_s5_w3 0 sky130_fd_pr__nfet_01v8 L=0.15 W=0.42 nf=1 ad=0.1218 as=0.1218 pd=1.42 ps=1.42 nrd=0.69047619047619  nrs=0.69047619047619 sa=0 sb=0 sd=0 mult=1 m=1
XMRD_op0_0000_s5_w3_0 rbl_op0_0000_s5_w3 sn_op0_0000_s5_w3_0 rwls_op0_0000_s5_w3 0 sky130_fd_pr__nfet_01v8 L=0.15 W=0.42 nf=1 ad=0.1218 as=0.1218 pd=1.42 ps=1.42 nrd=0.69047619047619  nrs=0.69047619047619 sa=0 sb=0 sd=0 mult=1 m=1
csn_op0_0000_s5_w3_0 sn_op0_0000_s5_w3_0 0 {C_SN}
XMWR_op0_0000_s5_w3_1 sn_op0_0000_s5_w3_1 wwl_des wbl_op0_0000_s5_w3 0 sky130_fd_pr__nfet_01v8 L=0.15 W=0.42 nf=1 ad=0.1218 as=0.1218 pd=1.42 ps=1.42 nrd=0.69047619047619  nrs=0.69047619047619 sa=0 sb=0 sd=0 mult=1 m=1
XMRD_op0_0000_s5_w3_1 rbl_op0_0000_s5_w3 sn_op0_0000_s5_w3_1 rwl_des 0 sky130_fd_pr__nfet_01v8 L=0.15 W=0.42 nf=1 ad=0.1218 as=0.1218 pd=1.42 ps=1.42 nrd=0.69047619047619  nrs=0.69047619047619 sa=0 sb=0 sd=0 mult=1 m=1
csn_op0_0000_s5_w3_1 sn_op0_0000_s5_w3_1 0 {C_SN}
XMWR_op0_0000_s5_w3_2 sn_op0_0000_s5_w3_2 wwl_des wbl_op0_0000_s5_w3 0 sky130_fd_pr__nfet_01v8 L=0.15 W=0.42 nf=1 ad=0.1218 as=0.1218 pd=1.42 ps=1.42 nrd=0.69047619047619  nrs=0.69047619047619 sa=0 sb=0 sd=0 mult=1 m=1
XMRD_op0_0000_s5_w3_2 rbl_op0_0000_s5_w3 sn_op0_0000_s5_w3_2 rwl_des 0 sky130_fd_pr__nfet_01v8 L=0.15 W=0.42 nf=1 ad=0.1218 as=0.1218 pd=1.42 ps=1.42 nrd=0.69047619047619  nrs=0.69047619047619 sa=0 sb=0 sd=0 mult=1 m=1
csn_op0_0000_s5_w3_2 sn_op0_0000_s5_w3_2 0 {C_SN}
XMWR_op0_0000_s5_w3_3 sn_op0_0000_s5_w3_3 wwl_des wbl_op0_0000_s5_w3 0 sky130_fd_pr__nfet_01v8 L=0.15 W=0.42 nf=1 ad=0.1218 as=0.1218 pd=1.42 ps=1.42 nrd=0.69047619047619  nrs=0.69047619047619 sa=0 sb=0 sd=0 mult=1 m=1
XMRD_op0_0000_s5_w3_3 rbl_op0_0000_s5_w3 sn_op0_0000_s5_w3_3 rwl_des 0 sky130_fd_pr__nfet_01v8 L=0.15 W=0.42 nf=1 ad=0.1218 as=0.1218 pd=1.42 ps=1.42 nrd=0.69047619047619  nrs=0.69047619047619 sa=0 sb=0 sd=0 mult=1 m=1
csn_op0_0000_s5_w3_3 sn_op0_0000_s5_w3_3 0 {C_SN}
XMN1_op0_0000_s5_w3 rbl_op0_0000_s5_w3 ref_op0_0000_s5_w3 vn_op0_0000_s5_w3 0 sky130_fd_pr__nfet_01v8 L=0.15 W=1 nf=1 ad=0.29 as=0.29 pd=2.58 ps=2.58 mult=1 m=1
XMN2_op0_0000_s5_w3 ref_op0_0000_s5_w3 rbl_op0_0000_s5_w3 vn_op0_0000_s5_w3 0 sky130_fd_pr__nfet_01v8 L=0.15 W=1 nf=1 ad=0.29 as=0.29 pd=2.58 ps=2.58 mult=1 m=1
XMP1_op0_0000_s5_w3 rbl_op0_0000_s5_w3 ref_op0_0000_s5_w3 vp_op0_0000_s5_w3 vdd sky130_fd_pr__pfet_01v8 L=0.15 W=2 nf=1 ad=0.58 as=0.58 pd=4.58 ps=4.58 mult=1 m=1
XMP2_op0_0000_s5_w3 ref_op0_0000_s5_w3 rbl_op0_0000_s5_w3 vp_op0_0000_s5_w3 vdd sky130_fd_pr__pfet_01v8 L=0.15 W=2 nf=1 ad=0.58 as=0.58 pd=4.58 ps=4.58 mult=1 m=1
XMNF_op0_0000_s5_w3 vn_op0_0000_s5_w3 en_op0_0000_s5_w3 0 0 sky130_fd_pr__nfet_01v8 L=0.15 W=2 nf=1 ad=0.58 as=0.58 pd=4.58 ps=4.58 mult=1 m=1
XMPH_op0_0000_s5_w3 vp_op0_0000_s5_w3 enb_op0_0000_s5_w3 vdd vdd sky130_fd_pr__pfet_01v8 L=0.15 W=4 nf=1 ad=1.16 as=1.16 pd=8.58 ps=8.58 mult=1 m=1
bd_op0_0000_s5_w3 d_op0_0000_s5_w3 0 v=v(rbl_op0_0000_s5_w3)-v(ref_op0_0000_s5_w3)

* ---- instance 221: op0_0000_s5_w5 (t_en 9 ns, WWL 10..15 ns, release 17 ns) ----
ven_op0_0000_s5_w5  en_op0_0000_s5_w5  0 pwl(0 0 9.0000e-09 0 9.1000e-09 {VDD} 1.7000e-08 {VDD} 1.7100e-08 0)
venb_op0_0000_s5_w5 enb_op0_0000_s5_w5 0 pwl(0 {VDD} 9.0000e-09 {VDD} 9.1000e-09 0 1.7000e-08 0 1.7100e-08 {VDD})
vrs_op0_0000_s5_w5  rwls_op0_0000_s5_w5 0 pwl(0 {VDD} {T_READ} {VDD} {T_READ+TEDGE} 0 1.7000e-08 0 1.7100e-08 {VDD})
vww_op0_0000_s5_w5  wwl_op0_0000_s5_w5 0 pwl(0 0 1.0000e-08 0 1.0100e-08 {VDD} 1.5000e-08 {VDD} 1.5100e-08 0)
vwc_op0_0000_s5_w5  wbc_op0_0000_s5_w5 0 pwl(0 0 1.0000e-08 0 1.0100e-08 {VDD} 1.7000e-08 {VDD} 1.7100e-08 0)
swb_op0_0000_s5_w5 ref_op0_0000_s5_w5 wbl_op0_0000_s5_w5 wbc_op0_0000_s5_w5 0 swwbl
cwbl_op0_0000_s5_w5 wbl_op0_0000_s5_w5 0 {C_WBL}
spa_op0_0000_s5_w5 prea rbl_op0_0000_s5_w5 ctl 0 swpre
spr_op0_0000_s5_w5 pref ref_op0_0000_s5_w5 ctl 0 swpre
crbl_op0_0000_s5_w5 rbl_op0_0000_s5_w5 0 {C_RBL}
cref_op0_0000_s5_w5 ref_op0_0000_s5_w5 0 {C_RBL}   $ ASSUMPTION: ideal matched dummy load
XMWR_op0_0000_s5_w5_0 sn_op0_0000_s5_w5_0 wwl_op0_0000_s5_w5 wbl_op0_0000_s5_w5 0 sky130_fd_pr__nfet_01v8 L=0.15 W=0.42 nf=1 ad=0.1218 as=0.1218 pd=1.42 ps=1.42 nrd=0.69047619047619  nrs=0.69047619047619 sa=0 sb=0 sd=0 mult=1 m=1
XMRD_op0_0000_s5_w5_0 rbl_op0_0000_s5_w5 sn_op0_0000_s5_w5_0 rwls_op0_0000_s5_w5 0 sky130_fd_pr__nfet_01v8 L=0.15 W=0.42 nf=1 ad=0.1218 as=0.1218 pd=1.42 ps=1.42 nrd=0.69047619047619  nrs=0.69047619047619 sa=0 sb=0 sd=0 mult=1 m=1
csn_op0_0000_s5_w5_0 sn_op0_0000_s5_w5_0 0 {C_SN}
XMWR_op0_0000_s5_w5_1 sn_op0_0000_s5_w5_1 wwl_des wbl_op0_0000_s5_w5 0 sky130_fd_pr__nfet_01v8 L=0.15 W=0.42 nf=1 ad=0.1218 as=0.1218 pd=1.42 ps=1.42 nrd=0.69047619047619  nrs=0.69047619047619 sa=0 sb=0 sd=0 mult=1 m=1
XMRD_op0_0000_s5_w5_1 rbl_op0_0000_s5_w5 sn_op0_0000_s5_w5_1 rwl_des 0 sky130_fd_pr__nfet_01v8 L=0.15 W=0.42 nf=1 ad=0.1218 as=0.1218 pd=1.42 ps=1.42 nrd=0.69047619047619  nrs=0.69047619047619 sa=0 sb=0 sd=0 mult=1 m=1
csn_op0_0000_s5_w5_1 sn_op0_0000_s5_w5_1 0 {C_SN}
XMWR_op0_0000_s5_w5_2 sn_op0_0000_s5_w5_2 wwl_des wbl_op0_0000_s5_w5 0 sky130_fd_pr__nfet_01v8 L=0.15 W=0.42 nf=1 ad=0.1218 as=0.1218 pd=1.42 ps=1.42 nrd=0.69047619047619  nrs=0.69047619047619 sa=0 sb=0 sd=0 mult=1 m=1
XMRD_op0_0000_s5_w5_2 rbl_op0_0000_s5_w5 sn_op0_0000_s5_w5_2 rwl_des 0 sky130_fd_pr__nfet_01v8 L=0.15 W=0.42 nf=1 ad=0.1218 as=0.1218 pd=1.42 ps=1.42 nrd=0.69047619047619  nrs=0.69047619047619 sa=0 sb=0 sd=0 mult=1 m=1
csn_op0_0000_s5_w5_2 sn_op0_0000_s5_w5_2 0 {C_SN}
XMWR_op0_0000_s5_w5_3 sn_op0_0000_s5_w5_3 wwl_des wbl_op0_0000_s5_w5 0 sky130_fd_pr__nfet_01v8 L=0.15 W=0.42 nf=1 ad=0.1218 as=0.1218 pd=1.42 ps=1.42 nrd=0.69047619047619  nrs=0.69047619047619 sa=0 sb=0 sd=0 mult=1 m=1
XMRD_op0_0000_s5_w5_3 rbl_op0_0000_s5_w5 sn_op0_0000_s5_w5_3 rwl_des 0 sky130_fd_pr__nfet_01v8 L=0.15 W=0.42 nf=1 ad=0.1218 as=0.1218 pd=1.42 ps=1.42 nrd=0.69047619047619  nrs=0.69047619047619 sa=0 sb=0 sd=0 mult=1 m=1
csn_op0_0000_s5_w5_3 sn_op0_0000_s5_w5_3 0 {C_SN}
XMN1_op0_0000_s5_w5 rbl_op0_0000_s5_w5 ref_op0_0000_s5_w5 vn_op0_0000_s5_w5 0 sky130_fd_pr__nfet_01v8 L=0.15 W=1 nf=1 ad=0.29 as=0.29 pd=2.58 ps=2.58 mult=1 m=1
XMN2_op0_0000_s5_w5 ref_op0_0000_s5_w5 rbl_op0_0000_s5_w5 vn_op0_0000_s5_w5 0 sky130_fd_pr__nfet_01v8 L=0.15 W=1 nf=1 ad=0.29 as=0.29 pd=2.58 ps=2.58 mult=1 m=1
XMP1_op0_0000_s5_w5 rbl_op0_0000_s5_w5 ref_op0_0000_s5_w5 vp_op0_0000_s5_w5 vdd sky130_fd_pr__pfet_01v8 L=0.15 W=2 nf=1 ad=0.58 as=0.58 pd=4.58 ps=4.58 mult=1 m=1
XMP2_op0_0000_s5_w5 ref_op0_0000_s5_w5 rbl_op0_0000_s5_w5 vp_op0_0000_s5_w5 vdd sky130_fd_pr__pfet_01v8 L=0.15 W=2 nf=1 ad=0.58 as=0.58 pd=4.58 ps=4.58 mult=1 m=1
XMNF_op0_0000_s5_w5 vn_op0_0000_s5_w5 en_op0_0000_s5_w5 0 0 sky130_fd_pr__nfet_01v8 L=0.15 W=2 nf=1 ad=0.58 as=0.58 pd=4.58 ps=4.58 mult=1 m=1
XMPH_op0_0000_s5_w5 vp_op0_0000_s5_w5 enb_op0_0000_s5_w5 vdd vdd sky130_fd_pr__pfet_01v8 L=0.15 W=4 nf=1 ad=1.16 as=1.16 pd=8.58 ps=8.58 mult=1 m=1
bd_op0_0000_s5_w5 d_op0_0000_s5_w5 0 v=v(rbl_op0_0000_s5_w5)-v(ref_op0_0000_s5_w5)

* ---- instance 222: op0_0000_s5_w7p5 (t_en 9 ns, WWL 10..17.5 ns, release 19.5 ns) ----
ven_op0_0000_s5_w7p5  en_op0_0000_s5_w7p5  0 pwl(0 0 9.0000e-09 0 9.1000e-09 {VDD} 1.9500e-08 {VDD} 1.9600e-08 0)
venb_op0_0000_s5_w7p5 enb_op0_0000_s5_w7p5 0 pwl(0 {VDD} 9.0000e-09 {VDD} 9.1000e-09 0 1.9500e-08 0 1.9600e-08 {VDD})
vrs_op0_0000_s5_w7p5  rwls_op0_0000_s5_w7p5 0 pwl(0 {VDD} {T_READ} {VDD} {T_READ+TEDGE} 0 1.9500e-08 0 1.9600e-08 {VDD})
vww_op0_0000_s5_w7p5  wwl_op0_0000_s5_w7p5 0 pwl(0 0 1.0000e-08 0 1.0100e-08 {VDD} 1.7500e-08 {VDD} 1.7600e-08 0)
vwc_op0_0000_s5_w7p5  wbc_op0_0000_s5_w7p5 0 pwl(0 0 1.0000e-08 0 1.0100e-08 {VDD} 1.9500e-08 {VDD} 1.9600e-08 0)
swb_op0_0000_s5_w7p5 ref_op0_0000_s5_w7p5 wbl_op0_0000_s5_w7p5 wbc_op0_0000_s5_w7p5 0 swwbl
cwbl_op0_0000_s5_w7p5 wbl_op0_0000_s5_w7p5 0 {C_WBL}
spa_op0_0000_s5_w7p5 prea rbl_op0_0000_s5_w7p5 ctl 0 swpre
spr_op0_0000_s5_w7p5 pref ref_op0_0000_s5_w7p5 ctl 0 swpre
crbl_op0_0000_s5_w7p5 rbl_op0_0000_s5_w7p5 0 {C_RBL}
cref_op0_0000_s5_w7p5 ref_op0_0000_s5_w7p5 0 {C_RBL}   $ ASSUMPTION: ideal matched dummy load
XMWR_op0_0000_s5_w7p5_0 sn_op0_0000_s5_w7p5_0 wwl_op0_0000_s5_w7p5 wbl_op0_0000_s5_w7p5 0 sky130_fd_pr__nfet_01v8 L=0.15 W=0.42 nf=1 ad=0.1218 as=0.1218 pd=1.42 ps=1.42 nrd=0.69047619047619  nrs=0.69047619047619 sa=0 sb=0 sd=0 mult=1 m=1
XMRD_op0_0000_s5_w7p5_0 rbl_op0_0000_s5_w7p5 sn_op0_0000_s5_w7p5_0 rwls_op0_0000_s5_w7p5 0 sky130_fd_pr__nfet_01v8 L=0.15 W=0.42 nf=1 ad=0.1218 as=0.1218 pd=1.42 ps=1.42 nrd=0.69047619047619  nrs=0.69047619047619 sa=0 sb=0 sd=0 mult=1 m=1
csn_op0_0000_s5_w7p5_0 sn_op0_0000_s5_w7p5_0 0 {C_SN}
XMWR_op0_0000_s5_w7p5_1 sn_op0_0000_s5_w7p5_1 wwl_des wbl_op0_0000_s5_w7p5 0 sky130_fd_pr__nfet_01v8 L=0.15 W=0.42 nf=1 ad=0.1218 as=0.1218 pd=1.42 ps=1.42 nrd=0.69047619047619  nrs=0.69047619047619 sa=0 sb=0 sd=0 mult=1 m=1
XMRD_op0_0000_s5_w7p5_1 rbl_op0_0000_s5_w7p5 sn_op0_0000_s5_w7p5_1 rwl_des 0 sky130_fd_pr__nfet_01v8 L=0.15 W=0.42 nf=1 ad=0.1218 as=0.1218 pd=1.42 ps=1.42 nrd=0.69047619047619  nrs=0.69047619047619 sa=0 sb=0 sd=0 mult=1 m=1
csn_op0_0000_s5_w7p5_1 sn_op0_0000_s5_w7p5_1 0 {C_SN}
XMWR_op0_0000_s5_w7p5_2 sn_op0_0000_s5_w7p5_2 wwl_des wbl_op0_0000_s5_w7p5 0 sky130_fd_pr__nfet_01v8 L=0.15 W=0.42 nf=1 ad=0.1218 as=0.1218 pd=1.42 ps=1.42 nrd=0.69047619047619  nrs=0.69047619047619 sa=0 sb=0 sd=0 mult=1 m=1
XMRD_op0_0000_s5_w7p5_2 rbl_op0_0000_s5_w7p5 sn_op0_0000_s5_w7p5_2 rwl_des 0 sky130_fd_pr__nfet_01v8 L=0.15 W=0.42 nf=1 ad=0.1218 as=0.1218 pd=1.42 ps=1.42 nrd=0.69047619047619  nrs=0.69047619047619 sa=0 sb=0 sd=0 mult=1 m=1
csn_op0_0000_s5_w7p5_2 sn_op0_0000_s5_w7p5_2 0 {C_SN}
XMWR_op0_0000_s5_w7p5_3 sn_op0_0000_s5_w7p5_3 wwl_des wbl_op0_0000_s5_w7p5 0 sky130_fd_pr__nfet_01v8 L=0.15 W=0.42 nf=1 ad=0.1218 as=0.1218 pd=1.42 ps=1.42 nrd=0.69047619047619  nrs=0.69047619047619 sa=0 sb=0 sd=0 mult=1 m=1
XMRD_op0_0000_s5_w7p5_3 rbl_op0_0000_s5_w7p5 sn_op0_0000_s5_w7p5_3 rwl_des 0 sky130_fd_pr__nfet_01v8 L=0.15 W=0.42 nf=1 ad=0.1218 as=0.1218 pd=1.42 ps=1.42 nrd=0.69047619047619  nrs=0.69047619047619 sa=0 sb=0 sd=0 mult=1 m=1
csn_op0_0000_s5_w7p5_3 sn_op0_0000_s5_w7p5_3 0 {C_SN}
XMN1_op0_0000_s5_w7p5 rbl_op0_0000_s5_w7p5 ref_op0_0000_s5_w7p5 vn_op0_0000_s5_w7p5 0 sky130_fd_pr__nfet_01v8 L=0.15 W=1 nf=1 ad=0.29 as=0.29 pd=2.58 ps=2.58 mult=1 m=1
XMN2_op0_0000_s5_w7p5 ref_op0_0000_s5_w7p5 rbl_op0_0000_s5_w7p5 vn_op0_0000_s5_w7p5 0 sky130_fd_pr__nfet_01v8 L=0.15 W=1 nf=1 ad=0.29 as=0.29 pd=2.58 ps=2.58 mult=1 m=1
XMP1_op0_0000_s5_w7p5 rbl_op0_0000_s5_w7p5 ref_op0_0000_s5_w7p5 vp_op0_0000_s5_w7p5 vdd sky130_fd_pr__pfet_01v8 L=0.15 W=2 nf=1 ad=0.58 as=0.58 pd=4.58 ps=4.58 mult=1 m=1
XMP2_op0_0000_s5_w7p5 ref_op0_0000_s5_w7p5 rbl_op0_0000_s5_w7p5 vp_op0_0000_s5_w7p5 vdd sky130_fd_pr__pfet_01v8 L=0.15 W=2 nf=1 ad=0.58 as=0.58 pd=4.58 ps=4.58 mult=1 m=1
XMNF_op0_0000_s5_w7p5 vn_op0_0000_s5_w7p5 en_op0_0000_s5_w7p5 0 0 sky130_fd_pr__nfet_01v8 L=0.15 W=2 nf=1 ad=0.58 as=0.58 pd=4.58 ps=4.58 mult=1 m=1
XMPH_op0_0000_s5_w7p5 vp_op0_0000_s5_w7p5 enb_op0_0000_s5_w7p5 vdd vdd sky130_fd_pr__pfet_01v8 L=0.15 W=4 nf=1 ad=1.16 as=1.16 pd=8.58 ps=8.58 mult=1 m=1
bd_op0_0000_s5_w7p5 d_op0_0000_s5_w7p5 0 v=v(rbl_op0_0000_s5_w7p5)-v(ref_op0_0000_s5_w7p5)

* ---- instance 223: op0_0000_s5_w10 (t_en 9 ns, WWL 10..20 ns, release 22 ns) ----
ven_op0_0000_s5_w10  en_op0_0000_s5_w10  0 pwl(0 0 9.0000e-09 0 9.1000e-09 {VDD} 2.2000e-08 {VDD} 2.2100e-08 0)
venb_op0_0000_s5_w10 enb_op0_0000_s5_w10 0 pwl(0 {VDD} 9.0000e-09 {VDD} 9.1000e-09 0 2.2000e-08 0 2.2100e-08 {VDD})
vrs_op0_0000_s5_w10  rwls_op0_0000_s5_w10 0 pwl(0 {VDD} {T_READ} {VDD} {T_READ+TEDGE} 0 2.2000e-08 0 2.2100e-08 {VDD})
vww_op0_0000_s5_w10  wwl_op0_0000_s5_w10 0 pwl(0 0 1.0000e-08 0 1.0100e-08 {VDD} 2.0000e-08 {VDD} 2.0100e-08 0)
vwc_op0_0000_s5_w10  wbc_op0_0000_s5_w10 0 pwl(0 0 1.0000e-08 0 1.0100e-08 {VDD} 2.2000e-08 {VDD} 2.2100e-08 0)
swb_op0_0000_s5_w10 ref_op0_0000_s5_w10 wbl_op0_0000_s5_w10 wbc_op0_0000_s5_w10 0 swwbl
cwbl_op0_0000_s5_w10 wbl_op0_0000_s5_w10 0 {C_WBL}
spa_op0_0000_s5_w10 prea rbl_op0_0000_s5_w10 ctl 0 swpre
spr_op0_0000_s5_w10 pref ref_op0_0000_s5_w10 ctl 0 swpre
crbl_op0_0000_s5_w10 rbl_op0_0000_s5_w10 0 {C_RBL}
cref_op0_0000_s5_w10 ref_op0_0000_s5_w10 0 {C_RBL}   $ ASSUMPTION: ideal matched dummy load
XMWR_op0_0000_s5_w10_0 sn_op0_0000_s5_w10_0 wwl_op0_0000_s5_w10 wbl_op0_0000_s5_w10 0 sky130_fd_pr__nfet_01v8 L=0.15 W=0.42 nf=1 ad=0.1218 as=0.1218 pd=1.42 ps=1.42 nrd=0.69047619047619  nrs=0.69047619047619 sa=0 sb=0 sd=0 mult=1 m=1
XMRD_op0_0000_s5_w10_0 rbl_op0_0000_s5_w10 sn_op0_0000_s5_w10_0 rwls_op0_0000_s5_w10 0 sky130_fd_pr__nfet_01v8 L=0.15 W=0.42 nf=1 ad=0.1218 as=0.1218 pd=1.42 ps=1.42 nrd=0.69047619047619  nrs=0.69047619047619 sa=0 sb=0 sd=0 mult=1 m=1
csn_op0_0000_s5_w10_0 sn_op0_0000_s5_w10_0 0 {C_SN}
XMWR_op0_0000_s5_w10_1 sn_op0_0000_s5_w10_1 wwl_des wbl_op0_0000_s5_w10 0 sky130_fd_pr__nfet_01v8 L=0.15 W=0.42 nf=1 ad=0.1218 as=0.1218 pd=1.42 ps=1.42 nrd=0.69047619047619  nrs=0.69047619047619 sa=0 sb=0 sd=0 mult=1 m=1
XMRD_op0_0000_s5_w10_1 rbl_op0_0000_s5_w10 sn_op0_0000_s5_w10_1 rwl_des 0 sky130_fd_pr__nfet_01v8 L=0.15 W=0.42 nf=1 ad=0.1218 as=0.1218 pd=1.42 ps=1.42 nrd=0.69047619047619  nrs=0.69047619047619 sa=0 sb=0 sd=0 mult=1 m=1
csn_op0_0000_s5_w10_1 sn_op0_0000_s5_w10_1 0 {C_SN}
XMWR_op0_0000_s5_w10_2 sn_op0_0000_s5_w10_2 wwl_des wbl_op0_0000_s5_w10 0 sky130_fd_pr__nfet_01v8 L=0.15 W=0.42 nf=1 ad=0.1218 as=0.1218 pd=1.42 ps=1.42 nrd=0.69047619047619  nrs=0.69047619047619 sa=0 sb=0 sd=0 mult=1 m=1
XMRD_op0_0000_s5_w10_2 rbl_op0_0000_s5_w10 sn_op0_0000_s5_w10_2 rwl_des 0 sky130_fd_pr__nfet_01v8 L=0.15 W=0.42 nf=1 ad=0.1218 as=0.1218 pd=1.42 ps=1.42 nrd=0.69047619047619  nrs=0.69047619047619 sa=0 sb=0 sd=0 mult=1 m=1
csn_op0_0000_s5_w10_2 sn_op0_0000_s5_w10_2 0 {C_SN}
XMWR_op0_0000_s5_w10_3 sn_op0_0000_s5_w10_3 wwl_des wbl_op0_0000_s5_w10 0 sky130_fd_pr__nfet_01v8 L=0.15 W=0.42 nf=1 ad=0.1218 as=0.1218 pd=1.42 ps=1.42 nrd=0.69047619047619  nrs=0.69047619047619 sa=0 sb=0 sd=0 mult=1 m=1
XMRD_op0_0000_s5_w10_3 rbl_op0_0000_s5_w10 sn_op0_0000_s5_w10_3 rwl_des 0 sky130_fd_pr__nfet_01v8 L=0.15 W=0.42 nf=1 ad=0.1218 as=0.1218 pd=1.42 ps=1.42 nrd=0.69047619047619  nrs=0.69047619047619 sa=0 sb=0 sd=0 mult=1 m=1
csn_op0_0000_s5_w10_3 sn_op0_0000_s5_w10_3 0 {C_SN}
XMN1_op0_0000_s5_w10 rbl_op0_0000_s5_w10 ref_op0_0000_s5_w10 vn_op0_0000_s5_w10 0 sky130_fd_pr__nfet_01v8 L=0.15 W=1 nf=1 ad=0.29 as=0.29 pd=2.58 ps=2.58 mult=1 m=1
XMN2_op0_0000_s5_w10 ref_op0_0000_s5_w10 rbl_op0_0000_s5_w10 vn_op0_0000_s5_w10 0 sky130_fd_pr__nfet_01v8 L=0.15 W=1 nf=1 ad=0.29 as=0.29 pd=2.58 ps=2.58 mult=1 m=1
XMP1_op0_0000_s5_w10 rbl_op0_0000_s5_w10 ref_op0_0000_s5_w10 vp_op0_0000_s5_w10 vdd sky130_fd_pr__pfet_01v8 L=0.15 W=2 nf=1 ad=0.58 as=0.58 pd=4.58 ps=4.58 mult=1 m=1
XMP2_op0_0000_s5_w10 ref_op0_0000_s5_w10 rbl_op0_0000_s5_w10 vp_op0_0000_s5_w10 vdd sky130_fd_pr__pfet_01v8 L=0.15 W=2 nf=1 ad=0.58 as=0.58 pd=4.58 ps=4.58 mult=1 m=1
XMNF_op0_0000_s5_w10 vn_op0_0000_s5_w10 en_op0_0000_s5_w10 0 0 sky130_fd_pr__nfet_01v8 L=0.15 W=2 nf=1 ad=0.58 as=0.58 pd=4.58 ps=4.58 mult=1 m=1
XMPH_op0_0000_s5_w10 vp_op0_0000_s5_w10 enb_op0_0000_s5_w10 vdd vdd sky130_fd_pr__pfet_01v8 L=0.15 W=4 nf=1 ad=1.16 as=1.16 pd=8.58 ps=8.58 mult=1 m=1
bd_op0_0000_s5_w10 d_op0_0000_s5_w10 0 v=v(rbl_op0_0000_s5_w10)-v(ref_op0_0000_s5_w10)

* ---- instance 224: op0_0000_s5_w15 (t_en 9 ns, WWL 10..25 ns, release 27 ns) ----
ven_op0_0000_s5_w15  en_op0_0000_s5_w15  0 pwl(0 0 9.0000e-09 0 9.1000e-09 {VDD} 2.7000e-08 {VDD} 2.7100e-08 0)
venb_op0_0000_s5_w15 enb_op0_0000_s5_w15 0 pwl(0 {VDD} 9.0000e-09 {VDD} 9.1000e-09 0 2.7000e-08 0 2.7100e-08 {VDD})
vrs_op0_0000_s5_w15  rwls_op0_0000_s5_w15 0 pwl(0 {VDD} {T_READ} {VDD} {T_READ+TEDGE} 0 2.7000e-08 0 2.7100e-08 {VDD})
vww_op0_0000_s5_w15  wwl_op0_0000_s5_w15 0 pwl(0 0 1.0000e-08 0 1.0100e-08 {VDD} 2.5000e-08 {VDD} 2.5100e-08 0)
vwc_op0_0000_s5_w15  wbc_op0_0000_s5_w15 0 pwl(0 0 1.0000e-08 0 1.0100e-08 {VDD} 2.7000e-08 {VDD} 2.7100e-08 0)
swb_op0_0000_s5_w15 ref_op0_0000_s5_w15 wbl_op0_0000_s5_w15 wbc_op0_0000_s5_w15 0 swwbl
cwbl_op0_0000_s5_w15 wbl_op0_0000_s5_w15 0 {C_WBL}
spa_op0_0000_s5_w15 prea rbl_op0_0000_s5_w15 ctl 0 swpre
spr_op0_0000_s5_w15 pref ref_op0_0000_s5_w15 ctl 0 swpre
crbl_op0_0000_s5_w15 rbl_op0_0000_s5_w15 0 {C_RBL}
cref_op0_0000_s5_w15 ref_op0_0000_s5_w15 0 {C_RBL}   $ ASSUMPTION: ideal matched dummy load
XMWR_op0_0000_s5_w15_0 sn_op0_0000_s5_w15_0 wwl_op0_0000_s5_w15 wbl_op0_0000_s5_w15 0 sky130_fd_pr__nfet_01v8 L=0.15 W=0.42 nf=1 ad=0.1218 as=0.1218 pd=1.42 ps=1.42 nrd=0.69047619047619  nrs=0.69047619047619 sa=0 sb=0 sd=0 mult=1 m=1
XMRD_op0_0000_s5_w15_0 rbl_op0_0000_s5_w15 sn_op0_0000_s5_w15_0 rwls_op0_0000_s5_w15 0 sky130_fd_pr__nfet_01v8 L=0.15 W=0.42 nf=1 ad=0.1218 as=0.1218 pd=1.42 ps=1.42 nrd=0.69047619047619  nrs=0.69047619047619 sa=0 sb=0 sd=0 mult=1 m=1
csn_op0_0000_s5_w15_0 sn_op0_0000_s5_w15_0 0 {C_SN}
XMWR_op0_0000_s5_w15_1 sn_op0_0000_s5_w15_1 wwl_des wbl_op0_0000_s5_w15 0 sky130_fd_pr__nfet_01v8 L=0.15 W=0.42 nf=1 ad=0.1218 as=0.1218 pd=1.42 ps=1.42 nrd=0.69047619047619  nrs=0.69047619047619 sa=0 sb=0 sd=0 mult=1 m=1
XMRD_op0_0000_s5_w15_1 rbl_op0_0000_s5_w15 sn_op0_0000_s5_w15_1 rwl_des 0 sky130_fd_pr__nfet_01v8 L=0.15 W=0.42 nf=1 ad=0.1218 as=0.1218 pd=1.42 ps=1.42 nrd=0.69047619047619  nrs=0.69047619047619 sa=0 sb=0 sd=0 mult=1 m=1
csn_op0_0000_s5_w15_1 sn_op0_0000_s5_w15_1 0 {C_SN}
XMWR_op0_0000_s5_w15_2 sn_op0_0000_s5_w15_2 wwl_des wbl_op0_0000_s5_w15 0 sky130_fd_pr__nfet_01v8 L=0.15 W=0.42 nf=1 ad=0.1218 as=0.1218 pd=1.42 ps=1.42 nrd=0.69047619047619  nrs=0.69047619047619 sa=0 sb=0 sd=0 mult=1 m=1
XMRD_op0_0000_s5_w15_2 rbl_op0_0000_s5_w15 sn_op0_0000_s5_w15_2 rwl_des 0 sky130_fd_pr__nfet_01v8 L=0.15 W=0.42 nf=1 ad=0.1218 as=0.1218 pd=1.42 ps=1.42 nrd=0.69047619047619  nrs=0.69047619047619 sa=0 sb=0 sd=0 mult=1 m=1
csn_op0_0000_s5_w15_2 sn_op0_0000_s5_w15_2 0 {C_SN}
XMWR_op0_0000_s5_w15_3 sn_op0_0000_s5_w15_3 wwl_des wbl_op0_0000_s5_w15 0 sky130_fd_pr__nfet_01v8 L=0.15 W=0.42 nf=1 ad=0.1218 as=0.1218 pd=1.42 ps=1.42 nrd=0.69047619047619  nrs=0.69047619047619 sa=0 sb=0 sd=0 mult=1 m=1
XMRD_op0_0000_s5_w15_3 rbl_op0_0000_s5_w15 sn_op0_0000_s5_w15_3 rwl_des 0 sky130_fd_pr__nfet_01v8 L=0.15 W=0.42 nf=1 ad=0.1218 as=0.1218 pd=1.42 ps=1.42 nrd=0.69047619047619  nrs=0.69047619047619 sa=0 sb=0 sd=0 mult=1 m=1
csn_op0_0000_s5_w15_3 sn_op0_0000_s5_w15_3 0 {C_SN}
XMN1_op0_0000_s5_w15 rbl_op0_0000_s5_w15 ref_op0_0000_s5_w15 vn_op0_0000_s5_w15 0 sky130_fd_pr__nfet_01v8 L=0.15 W=1 nf=1 ad=0.29 as=0.29 pd=2.58 ps=2.58 mult=1 m=1
XMN2_op0_0000_s5_w15 ref_op0_0000_s5_w15 rbl_op0_0000_s5_w15 vn_op0_0000_s5_w15 0 sky130_fd_pr__nfet_01v8 L=0.15 W=1 nf=1 ad=0.29 as=0.29 pd=2.58 ps=2.58 mult=1 m=1
XMP1_op0_0000_s5_w15 rbl_op0_0000_s5_w15 ref_op0_0000_s5_w15 vp_op0_0000_s5_w15 vdd sky130_fd_pr__pfet_01v8 L=0.15 W=2 nf=1 ad=0.58 as=0.58 pd=4.58 ps=4.58 mult=1 m=1
XMP2_op0_0000_s5_w15 ref_op0_0000_s5_w15 rbl_op0_0000_s5_w15 vp_op0_0000_s5_w15 vdd sky130_fd_pr__pfet_01v8 L=0.15 W=2 nf=1 ad=0.58 as=0.58 pd=4.58 ps=4.58 mult=1 m=1
XMNF_op0_0000_s5_w15 vn_op0_0000_s5_w15 en_op0_0000_s5_w15 0 0 sky130_fd_pr__nfet_01v8 L=0.15 W=2 nf=1 ad=0.58 as=0.58 pd=4.58 ps=4.58 mult=1 m=1
XMPH_op0_0000_s5_w15 vp_op0_0000_s5_w15 enb_op0_0000_s5_w15 vdd vdd sky130_fd_pr__pfet_01v8 L=0.15 W=4 nf=1 ad=1.16 as=1.16 pd=8.58 ps=8.58 mult=1 m=1
bd_op0_0000_s5_w15 d_op0_0000_s5_w15 0 v=v(rbl_op0_0000_s5_w15)-v(ref_op0_0000_s5_w15)

* ---- instance 225: op0_0000_s5_w20 (t_en 9 ns, WWL 10..30 ns, release 32 ns) ----
ven_op0_0000_s5_w20  en_op0_0000_s5_w20  0 pwl(0 0 9.0000e-09 0 9.1000e-09 {VDD} 3.2000e-08 {VDD} 3.2100e-08 0)
venb_op0_0000_s5_w20 enb_op0_0000_s5_w20 0 pwl(0 {VDD} 9.0000e-09 {VDD} 9.1000e-09 0 3.2000e-08 0 3.2100e-08 {VDD})
vrs_op0_0000_s5_w20  rwls_op0_0000_s5_w20 0 pwl(0 {VDD} {T_READ} {VDD} {T_READ+TEDGE} 0 3.2000e-08 0 3.2100e-08 {VDD})
vww_op0_0000_s5_w20  wwl_op0_0000_s5_w20 0 pwl(0 0 1.0000e-08 0 1.0100e-08 {VDD} 3.0000e-08 {VDD} 3.0100e-08 0)
vwc_op0_0000_s5_w20  wbc_op0_0000_s5_w20 0 pwl(0 0 1.0000e-08 0 1.0100e-08 {VDD} 3.2000e-08 {VDD} 3.2100e-08 0)
swb_op0_0000_s5_w20 ref_op0_0000_s5_w20 wbl_op0_0000_s5_w20 wbc_op0_0000_s5_w20 0 swwbl
cwbl_op0_0000_s5_w20 wbl_op0_0000_s5_w20 0 {C_WBL}
spa_op0_0000_s5_w20 prea rbl_op0_0000_s5_w20 ctl 0 swpre
spr_op0_0000_s5_w20 pref ref_op0_0000_s5_w20 ctl 0 swpre
crbl_op0_0000_s5_w20 rbl_op0_0000_s5_w20 0 {C_RBL}
cref_op0_0000_s5_w20 ref_op0_0000_s5_w20 0 {C_RBL}   $ ASSUMPTION: ideal matched dummy load
XMWR_op0_0000_s5_w20_0 sn_op0_0000_s5_w20_0 wwl_op0_0000_s5_w20 wbl_op0_0000_s5_w20 0 sky130_fd_pr__nfet_01v8 L=0.15 W=0.42 nf=1 ad=0.1218 as=0.1218 pd=1.42 ps=1.42 nrd=0.69047619047619  nrs=0.69047619047619 sa=0 sb=0 sd=0 mult=1 m=1
XMRD_op0_0000_s5_w20_0 rbl_op0_0000_s5_w20 sn_op0_0000_s5_w20_0 rwls_op0_0000_s5_w20 0 sky130_fd_pr__nfet_01v8 L=0.15 W=0.42 nf=1 ad=0.1218 as=0.1218 pd=1.42 ps=1.42 nrd=0.69047619047619  nrs=0.69047619047619 sa=0 sb=0 sd=0 mult=1 m=1
csn_op0_0000_s5_w20_0 sn_op0_0000_s5_w20_0 0 {C_SN}
XMWR_op0_0000_s5_w20_1 sn_op0_0000_s5_w20_1 wwl_des wbl_op0_0000_s5_w20 0 sky130_fd_pr__nfet_01v8 L=0.15 W=0.42 nf=1 ad=0.1218 as=0.1218 pd=1.42 ps=1.42 nrd=0.69047619047619  nrs=0.69047619047619 sa=0 sb=0 sd=0 mult=1 m=1
XMRD_op0_0000_s5_w20_1 rbl_op0_0000_s5_w20 sn_op0_0000_s5_w20_1 rwl_des 0 sky130_fd_pr__nfet_01v8 L=0.15 W=0.42 nf=1 ad=0.1218 as=0.1218 pd=1.42 ps=1.42 nrd=0.69047619047619  nrs=0.69047619047619 sa=0 sb=0 sd=0 mult=1 m=1
csn_op0_0000_s5_w20_1 sn_op0_0000_s5_w20_1 0 {C_SN}
XMWR_op0_0000_s5_w20_2 sn_op0_0000_s5_w20_2 wwl_des wbl_op0_0000_s5_w20 0 sky130_fd_pr__nfet_01v8 L=0.15 W=0.42 nf=1 ad=0.1218 as=0.1218 pd=1.42 ps=1.42 nrd=0.69047619047619  nrs=0.69047619047619 sa=0 sb=0 sd=0 mult=1 m=1
XMRD_op0_0000_s5_w20_2 rbl_op0_0000_s5_w20 sn_op0_0000_s5_w20_2 rwl_des 0 sky130_fd_pr__nfet_01v8 L=0.15 W=0.42 nf=1 ad=0.1218 as=0.1218 pd=1.42 ps=1.42 nrd=0.69047619047619  nrs=0.69047619047619 sa=0 sb=0 sd=0 mult=1 m=1
csn_op0_0000_s5_w20_2 sn_op0_0000_s5_w20_2 0 {C_SN}
XMWR_op0_0000_s5_w20_3 sn_op0_0000_s5_w20_3 wwl_des wbl_op0_0000_s5_w20 0 sky130_fd_pr__nfet_01v8 L=0.15 W=0.42 nf=1 ad=0.1218 as=0.1218 pd=1.42 ps=1.42 nrd=0.69047619047619  nrs=0.69047619047619 sa=0 sb=0 sd=0 mult=1 m=1
XMRD_op0_0000_s5_w20_3 rbl_op0_0000_s5_w20 sn_op0_0000_s5_w20_3 rwl_des 0 sky130_fd_pr__nfet_01v8 L=0.15 W=0.42 nf=1 ad=0.1218 as=0.1218 pd=1.42 ps=1.42 nrd=0.69047619047619  nrs=0.69047619047619 sa=0 sb=0 sd=0 mult=1 m=1
csn_op0_0000_s5_w20_3 sn_op0_0000_s5_w20_3 0 {C_SN}
XMN1_op0_0000_s5_w20 rbl_op0_0000_s5_w20 ref_op0_0000_s5_w20 vn_op0_0000_s5_w20 0 sky130_fd_pr__nfet_01v8 L=0.15 W=1 nf=1 ad=0.29 as=0.29 pd=2.58 ps=2.58 mult=1 m=1
XMN2_op0_0000_s5_w20 ref_op0_0000_s5_w20 rbl_op0_0000_s5_w20 vn_op0_0000_s5_w20 0 sky130_fd_pr__nfet_01v8 L=0.15 W=1 nf=1 ad=0.29 as=0.29 pd=2.58 ps=2.58 mult=1 m=1
XMP1_op0_0000_s5_w20 rbl_op0_0000_s5_w20 ref_op0_0000_s5_w20 vp_op0_0000_s5_w20 vdd sky130_fd_pr__pfet_01v8 L=0.15 W=2 nf=1 ad=0.58 as=0.58 pd=4.58 ps=4.58 mult=1 m=1
XMP2_op0_0000_s5_w20 ref_op0_0000_s5_w20 rbl_op0_0000_s5_w20 vp_op0_0000_s5_w20 vdd sky130_fd_pr__pfet_01v8 L=0.15 W=2 nf=1 ad=0.58 as=0.58 pd=4.58 ps=4.58 mult=1 m=1
XMNF_op0_0000_s5_w20 vn_op0_0000_s5_w20 en_op0_0000_s5_w20 0 0 sky130_fd_pr__nfet_01v8 L=0.15 W=2 nf=1 ad=0.58 as=0.58 pd=4.58 ps=4.58 mult=1 m=1
XMPH_op0_0000_s5_w20 vp_op0_0000_s5_w20 enb_op0_0000_s5_w20 vdd vdd sky130_fd_pr__pfet_01v8 L=0.15 W=4 nf=1 ad=1.16 as=1.16 pd=8.58 ps=8.58 mult=1 m=1
bd_op0_0000_s5_w20 d_op0_0000_s5_w20 0 v=v(rbl_op0_0000_s5_w20)-v(ref_op0_0000_s5_w20)

* ---- instance 226: op0_0000_s5_w30 (t_en 9 ns, WWL 10..40 ns, release 42 ns) ----
ven_op0_0000_s5_w30  en_op0_0000_s5_w30  0 pwl(0 0 9.0000e-09 0 9.1000e-09 {VDD} 4.2000e-08 {VDD} 4.2100e-08 0)
venb_op0_0000_s5_w30 enb_op0_0000_s5_w30 0 pwl(0 {VDD} 9.0000e-09 {VDD} 9.1000e-09 0 4.2000e-08 0 4.2100e-08 {VDD})
vrs_op0_0000_s5_w30  rwls_op0_0000_s5_w30 0 pwl(0 {VDD} {T_READ} {VDD} {T_READ+TEDGE} 0 4.2000e-08 0 4.2100e-08 {VDD})
vww_op0_0000_s5_w30  wwl_op0_0000_s5_w30 0 pwl(0 0 1.0000e-08 0 1.0100e-08 {VDD} 4.0000e-08 {VDD} 4.0100e-08 0)
vwc_op0_0000_s5_w30  wbc_op0_0000_s5_w30 0 pwl(0 0 1.0000e-08 0 1.0100e-08 {VDD} 4.2000e-08 {VDD} 4.2100e-08 0)
swb_op0_0000_s5_w30 ref_op0_0000_s5_w30 wbl_op0_0000_s5_w30 wbc_op0_0000_s5_w30 0 swwbl
cwbl_op0_0000_s5_w30 wbl_op0_0000_s5_w30 0 {C_WBL}
spa_op0_0000_s5_w30 prea rbl_op0_0000_s5_w30 ctl 0 swpre
spr_op0_0000_s5_w30 pref ref_op0_0000_s5_w30 ctl 0 swpre
crbl_op0_0000_s5_w30 rbl_op0_0000_s5_w30 0 {C_RBL}
cref_op0_0000_s5_w30 ref_op0_0000_s5_w30 0 {C_RBL}   $ ASSUMPTION: ideal matched dummy load
XMWR_op0_0000_s5_w30_0 sn_op0_0000_s5_w30_0 wwl_op0_0000_s5_w30 wbl_op0_0000_s5_w30 0 sky130_fd_pr__nfet_01v8 L=0.15 W=0.42 nf=1 ad=0.1218 as=0.1218 pd=1.42 ps=1.42 nrd=0.69047619047619  nrs=0.69047619047619 sa=0 sb=0 sd=0 mult=1 m=1
XMRD_op0_0000_s5_w30_0 rbl_op0_0000_s5_w30 sn_op0_0000_s5_w30_0 rwls_op0_0000_s5_w30 0 sky130_fd_pr__nfet_01v8 L=0.15 W=0.42 nf=1 ad=0.1218 as=0.1218 pd=1.42 ps=1.42 nrd=0.69047619047619  nrs=0.69047619047619 sa=0 sb=0 sd=0 mult=1 m=1
csn_op0_0000_s5_w30_0 sn_op0_0000_s5_w30_0 0 {C_SN}
XMWR_op0_0000_s5_w30_1 sn_op0_0000_s5_w30_1 wwl_des wbl_op0_0000_s5_w30 0 sky130_fd_pr__nfet_01v8 L=0.15 W=0.42 nf=1 ad=0.1218 as=0.1218 pd=1.42 ps=1.42 nrd=0.69047619047619  nrs=0.69047619047619 sa=0 sb=0 sd=0 mult=1 m=1
XMRD_op0_0000_s5_w30_1 rbl_op0_0000_s5_w30 sn_op0_0000_s5_w30_1 rwl_des 0 sky130_fd_pr__nfet_01v8 L=0.15 W=0.42 nf=1 ad=0.1218 as=0.1218 pd=1.42 ps=1.42 nrd=0.69047619047619  nrs=0.69047619047619 sa=0 sb=0 sd=0 mult=1 m=1
csn_op0_0000_s5_w30_1 sn_op0_0000_s5_w30_1 0 {C_SN}
XMWR_op0_0000_s5_w30_2 sn_op0_0000_s5_w30_2 wwl_des wbl_op0_0000_s5_w30 0 sky130_fd_pr__nfet_01v8 L=0.15 W=0.42 nf=1 ad=0.1218 as=0.1218 pd=1.42 ps=1.42 nrd=0.69047619047619  nrs=0.69047619047619 sa=0 sb=0 sd=0 mult=1 m=1
XMRD_op0_0000_s5_w30_2 rbl_op0_0000_s5_w30 sn_op0_0000_s5_w30_2 rwl_des 0 sky130_fd_pr__nfet_01v8 L=0.15 W=0.42 nf=1 ad=0.1218 as=0.1218 pd=1.42 ps=1.42 nrd=0.69047619047619  nrs=0.69047619047619 sa=0 sb=0 sd=0 mult=1 m=1
csn_op0_0000_s5_w30_2 sn_op0_0000_s5_w30_2 0 {C_SN}
XMWR_op0_0000_s5_w30_3 sn_op0_0000_s5_w30_3 wwl_des wbl_op0_0000_s5_w30 0 sky130_fd_pr__nfet_01v8 L=0.15 W=0.42 nf=1 ad=0.1218 as=0.1218 pd=1.42 ps=1.42 nrd=0.69047619047619  nrs=0.69047619047619 sa=0 sb=0 sd=0 mult=1 m=1
XMRD_op0_0000_s5_w30_3 rbl_op0_0000_s5_w30 sn_op0_0000_s5_w30_3 rwl_des 0 sky130_fd_pr__nfet_01v8 L=0.15 W=0.42 nf=1 ad=0.1218 as=0.1218 pd=1.42 ps=1.42 nrd=0.69047619047619  nrs=0.69047619047619 sa=0 sb=0 sd=0 mult=1 m=1
csn_op0_0000_s5_w30_3 sn_op0_0000_s5_w30_3 0 {C_SN}
XMN1_op0_0000_s5_w30 rbl_op0_0000_s5_w30 ref_op0_0000_s5_w30 vn_op0_0000_s5_w30 0 sky130_fd_pr__nfet_01v8 L=0.15 W=1 nf=1 ad=0.29 as=0.29 pd=2.58 ps=2.58 mult=1 m=1
XMN2_op0_0000_s5_w30 ref_op0_0000_s5_w30 rbl_op0_0000_s5_w30 vn_op0_0000_s5_w30 0 sky130_fd_pr__nfet_01v8 L=0.15 W=1 nf=1 ad=0.29 as=0.29 pd=2.58 ps=2.58 mult=1 m=1
XMP1_op0_0000_s5_w30 rbl_op0_0000_s5_w30 ref_op0_0000_s5_w30 vp_op0_0000_s5_w30 vdd sky130_fd_pr__pfet_01v8 L=0.15 W=2 nf=1 ad=0.58 as=0.58 pd=4.58 ps=4.58 mult=1 m=1
XMP2_op0_0000_s5_w30 ref_op0_0000_s5_w30 rbl_op0_0000_s5_w30 vp_op0_0000_s5_w30 vdd sky130_fd_pr__pfet_01v8 L=0.15 W=2 nf=1 ad=0.58 as=0.58 pd=4.58 ps=4.58 mult=1 m=1
XMNF_op0_0000_s5_w30 vn_op0_0000_s5_w30 en_op0_0000_s5_w30 0 0 sky130_fd_pr__nfet_01v8 L=0.15 W=2 nf=1 ad=0.58 as=0.58 pd=4.58 ps=4.58 mult=1 m=1
XMPH_op0_0000_s5_w30 vp_op0_0000_s5_w30 enb_op0_0000_s5_w30 vdd vdd sky130_fd_pr__pfet_01v8 L=0.15 W=4 nf=1 ad=1.16 as=1.16 pd=8.58 ps=8.58 mult=1 m=1
bd_op0_0000_s5_w30 d_op0_0000_s5_w30 0 v=v(rbl_op0_0000_s5_w30)-v(ref_op0_0000_s5_w30)

* ---- instance 227: op0_0000_s5_w50 (t_en 9 ns, WWL 10..60 ns, release 62 ns) ----
ven_op0_0000_s5_w50  en_op0_0000_s5_w50  0 pwl(0 0 9.0000e-09 0 9.1000e-09 {VDD} 6.2000e-08 {VDD} 6.2100e-08 0)
venb_op0_0000_s5_w50 enb_op0_0000_s5_w50 0 pwl(0 {VDD} 9.0000e-09 {VDD} 9.1000e-09 0 6.2000e-08 0 6.2100e-08 {VDD})
vrs_op0_0000_s5_w50  rwls_op0_0000_s5_w50 0 pwl(0 {VDD} {T_READ} {VDD} {T_READ+TEDGE} 0 6.2000e-08 0 6.2100e-08 {VDD})
vww_op0_0000_s5_w50  wwl_op0_0000_s5_w50 0 pwl(0 0 1.0000e-08 0 1.0100e-08 {VDD} 6.0000e-08 {VDD} 6.0100e-08 0)
vwc_op0_0000_s5_w50  wbc_op0_0000_s5_w50 0 pwl(0 0 1.0000e-08 0 1.0100e-08 {VDD} 6.2000e-08 {VDD} 6.2100e-08 0)
swb_op0_0000_s5_w50 ref_op0_0000_s5_w50 wbl_op0_0000_s5_w50 wbc_op0_0000_s5_w50 0 swwbl
cwbl_op0_0000_s5_w50 wbl_op0_0000_s5_w50 0 {C_WBL}
spa_op0_0000_s5_w50 prea rbl_op0_0000_s5_w50 ctl 0 swpre
spr_op0_0000_s5_w50 pref ref_op0_0000_s5_w50 ctl 0 swpre
crbl_op0_0000_s5_w50 rbl_op0_0000_s5_w50 0 {C_RBL}
cref_op0_0000_s5_w50 ref_op0_0000_s5_w50 0 {C_RBL}   $ ASSUMPTION: ideal matched dummy load
XMWR_op0_0000_s5_w50_0 sn_op0_0000_s5_w50_0 wwl_op0_0000_s5_w50 wbl_op0_0000_s5_w50 0 sky130_fd_pr__nfet_01v8 L=0.15 W=0.42 nf=1 ad=0.1218 as=0.1218 pd=1.42 ps=1.42 nrd=0.69047619047619  nrs=0.69047619047619 sa=0 sb=0 sd=0 mult=1 m=1
XMRD_op0_0000_s5_w50_0 rbl_op0_0000_s5_w50 sn_op0_0000_s5_w50_0 rwls_op0_0000_s5_w50 0 sky130_fd_pr__nfet_01v8 L=0.15 W=0.42 nf=1 ad=0.1218 as=0.1218 pd=1.42 ps=1.42 nrd=0.69047619047619  nrs=0.69047619047619 sa=0 sb=0 sd=0 mult=1 m=1
csn_op0_0000_s5_w50_0 sn_op0_0000_s5_w50_0 0 {C_SN}
XMWR_op0_0000_s5_w50_1 sn_op0_0000_s5_w50_1 wwl_des wbl_op0_0000_s5_w50 0 sky130_fd_pr__nfet_01v8 L=0.15 W=0.42 nf=1 ad=0.1218 as=0.1218 pd=1.42 ps=1.42 nrd=0.69047619047619  nrs=0.69047619047619 sa=0 sb=0 sd=0 mult=1 m=1
XMRD_op0_0000_s5_w50_1 rbl_op0_0000_s5_w50 sn_op0_0000_s5_w50_1 rwl_des 0 sky130_fd_pr__nfet_01v8 L=0.15 W=0.42 nf=1 ad=0.1218 as=0.1218 pd=1.42 ps=1.42 nrd=0.69047619047619  nrs=0.69047619047619 sa=0 sb=0 sd=0 mult=1 m=1
csn_op0_0000_s5_w50_1 sn_op0_0000_s5_w50_1 0 {C_SN}
XMWR_op0_0000_s5_w50_2 sn_op0_0000_s5_w50_2 wwl_des wbl_op0_0000_s5_w50 0 sky130_fd_pr__nfet_01v8 L=0.15 W=0.42 nf=1 ad=0.1218 as=0.1218 pd=1.42 ps=1.42 nrd=0.69047619047619  nrs=0.69047619047619 sa=0 sb=0 sd=0 mult=1 m=1
XMRD_op0_0000_s5_w50_2 rbl_op0_0000_s5_w50 sn_op0_0000_s5_w50_2 rwl_des 0 sky130_fd_pr__nfet_01v8 L=0.15 W=0.42 nf=1 ad=0.1218 as=0.1218 pd=1.42 ps=1.42 nrd=0.69047619047619  nrs=0.69047619047619 sa=0 sb=0 sd=0 mult=1 m=1
csn_op0_0000_s5_w50_2 sn_op0_0000_s5_w50_2 0 {C_SN}
XMWR_op0_0000_s5_w50_3 sn_op0_0000_s5_w50_3 wwl_des wbl_op0_0000_s5_w50 0 sky130_fd_pr__nfet_01v8 L=0.15 W=0.42 nf=1 ad=0.1218 as=0.1218 pd=1.42 ps=1.42 nrd=0.69047619047619  nrs=0.69047619047619 sa=0 sb=0 sd=0 mult=1 m=1
XMRD_op0_0000_s5_w50_3 rbl_op0_0000_s5_w50 sn_op0_0000_s5_w50_3 rwl_des 0 sky130_fd_pr__nfet_01v8 L=0.15 W=0.42 nf=1 ad=0.1218 as=0.1218 pd=1.42 ps=1.42 nrd=0.69047619047619  nrs=0.69047619047619 sa=0 sb=0 sd=0 mult=1 m=1
csn_op0_0000_s5_w50_3 sn_op0_0000_s5_w50_3 0 {C_SN}
XMN1_op0_0000_s5_w50 rbl_op0_0000_s5_w50 ref_op0_0000_s5_w50 vn_op0_0000_s5_w50 0 sky130_fd_pr__nfet_01v8 L=0.15 W=1 nf=1 ad=0.29 as=0.29 pd=2.58 ps=2.58 mult=1 m=1
XMN2_op0_0000_s5_w50 ref_op0_0000_s5_w50 rbl_op0_0000_s5_w50 vn_op0_0000_s5_w50 0 sky130_fd_pr__nfet_01v8 L=0.15 W=1 nf=1 ad=0.29 as=0.29 pd=2.58 ps=2.58 mult=1 m=1
XMP1_op0_0000_s5_w50 rbl_op0_0000_s5_w50 ref_op0_0000_s5_w50 vp_op0_0000_s5_w50 vdd sky130_fd_pr__pfet_01v8 L=0.15 W=2 nf=1 ad=0.58 as=0.58 pd=4.58 ps=4.58 mult=1 m=1
XMP2_op0_0000_s5_w50 ref_op0_0000_s5_w50 rbl_op0_0000_s5_w50 vp_op0_0000_s5_w50 vdd sky130_fd_pr__pfet_01v8 L=0.15 W=2 nf=1 ad=0.58 as=0.58 pd=4.58 ps=4.58 mult=1 m=1
XMNF_op0_0000_s5_w50 vn_op0_0000_s5_w50 en_op0_0000_s5_w50 0 0 sky130_fd_pr__nfet_01v8 L=0.15 W=2 nf=1 ad=0.58 as=0.58 pd=4.58 ps=4.58 mult=1 m=1
XMPH_op0_0000_s5_w50 vp_op0_0000_s5_w50 enb_op0_0000_s5_w50 vdd vdd sky130_fd_pr__pfet_01v8 L=0.15 W=4 nf=1 ad=1.16 as=1.16 pd=8.58 ps=8.58 mult=1 m=1
bd_op0_0000_s5_w50 d_op0_0000_s5_w50 0 v=v(rbl_op0_0000_s5_w50)-v(ref_op0_0000_s5_w50)

* ---- instance 228: op0_0000_s10_w0p2 (t_en 14 ns, WWL 15..15.2 ns, release 17.2 ns) ----
ven_op0_0000_s10_w0p2  en_op0_0000_s10_w0p2  0 pwl(0 0 1.4000e-08 0 1.4100e-08 {VDD} 1.7200e-08 {VDD} 1.7300e-08 0)
venb_op0_0000_s10_w0p2 enb_op0_0000_s10_w0p2 0 pwl(0 {VDD} 1.4000e-08 {VDD} 1.4100e-08 0 1.7200e-08 0 1.7300e-08 {VDD})
vrs_op0_0000_s10_w0p2  rwls_op0_0000_s10_w0p2 0 pwl(0 {VDD} {T_READ} {VDD} {T_READ+TEDGE} 0 1.7200e-08 0 1.7300e-08 {VDD})
vww_op0_0000_s10_w0p2  wwl_op0_0000_s10_w0p2 0 pwl(0 0 1.5000e-08 0 1.5100e-08 {VDD} 1.5200e-08 {VDD} 1.5300e-08 0)
vwc_op0_0000_s10_w0p2  wbc_op0_0000_s10_w0p2 0 pwl(0 0 1.5000e-08 0 1.5100e-08 {VDD} 1.7200e-08 {VDD} 1.7300e-08 0)
swb_op0_0000_s10_w0p2 ref_op0_0000_s10_w0p2 wbl_op0_0000_s10_w0p2 wbc_op0_0000_s10_w0p2 0 swwbl
cwbl_op0_0000_s10_w0p2 wbl_op0_0000_s10_w0p2 0 {C_WBL}
spa_op0_0000_s10_w0p2 prea rbl_op0_0000_s10_w0p2 ctl 0 swpre
spr_op0_0000_s10_w0p2 pref ref_op0_0000_s10_w0p2 ctl 0 swpre
crbl_op0_0000_s10_w0p2 rbl_op0_0000_s10_w0p2 0 {C_RBL}
cref_op0_0000_s10_w0p2 ref_op0_0000_s10_w0p2 0 {C_RBL}   $ ASSUMPTION: ideal matched dummy load
XMWR_op0_0000_s10_w0p2_0 sn_op0_0000_s10_w0p2_0 wwl_op0_0000_s10_w0p2 wbl_op0_0000_s10_w0p2 0 sky130_fd_pr__nfet_01v8 L=0.15 W=0.42 nf=1 ad=0.1218 as=0.1218 pd=1.42 ps=1.42 nrd=0.69047619047619  nrs=0.69047619047619 sa=0 sb=0 sd=0 mult=1 m=1
XMRD_op0_0000_s10_w0p2_0 rbl_op0_0000_s10_w0p2 sn_op0_0000_s10_w0p2_0 rwls_op0_0000_s10_w0p2 0 sky130_fd_pr__nfet_01v8 L=0.15 W=0.42 nf=1 ad=0.1218 as=0.1218 pd=1.42 ps=1.42 nrd=0.69047619047619  nrs=0.69047619047619 sa=0 sb=0 sd=0 mult=1 m=1
csn_op0_0000_s10_w0p2_0 sn_op0_0000_s10_w0p2_0 0 {C_SN}
XMWR_op0_0000_s10_w0p2_1 sn_op0_0000_s10_w0p2_1 wwl_des wbl_op0_0000_s10_w0p2 0 sky130_fd_pr__nfet_01v8 L=0.15 W=0.42 nf=1 ad=0.1218 as=0.1218 pd=1.42 ps=1.42 nrd=0.69047619047619  nrs=0.69047619047619 sa=0 sb=0 sd=0 mult=1 m=1
XMRD_op0_0000_s10_w0p2_1 rbl_op0_0000_s10_w0p2 sn_op0_0000_s10_w0p2_1 rwl_des 0 sky130_fd_pr__nfet_01v8 L=0.15 W=0.42 nf=1 ad=0.1218 as=0.1218 pd=1.42 ps=1.42 nrd=0.69047619047619  nrs=0.69047619047619 sa=0 sb=0 sd=0 mult=1 m=1
csn_op0_0000_s10_w0p2_1 sn_op0_0000_s10_w0p2_1 0 {C_SN}
XMWR_op0_0000_s10_w0p2_2 sn_op0_0000_s10_w0p2_2 wwl_des wbl_op0_0000_s10_w0p2 0 sky130_fd_pr__nfet_01v8 L=0.15 W=0.42 nf=1 ad=0.1218 as=0.1218 pd=1.42 ps=1.42 nrd=0.69047619047619  nrs=0.69047619047619 sa=0 sb=0 sd=0 mult=1 m=1
XMRD_op0_0000_s10_w0p2_2 rbl_op0_0000_s10_w0p2 sn_op0_0000_s10_w0p2_2 rwl_des 0 sky130_fd_pr__nfet_01v8 L=0.15 W=0.42 nf=1 ad=0.1218 as=0.1218 pd=1.42 ps=1.42 nrd=0.69047619047619  nrs=0.69047619047619 sa=0 sb=0 sd=0 mult=1 m=1
csn_op0_0000_s10_w0p2_2 sn_op0_0000_s10_w0p2_2 0 {C_SN}
XMWR_op0_0000_s10_w0p2_3 sn_op0_0000_s10_w0p2_3 wwl_des wbl_op0_0000_s10_w0p2 0 sky130_fd_pr__nfet_01v8 L=0.15 W=0.42 nf=1 ad=0.1218 as=0.1218 pd=1.42 ps=1.42 nrd=0.69047619047619  nrs=0.69047619047619 sa=0 sb=0 sd=0 mult=1 m=1
XMRD_op0_0000_s10_w0p2_3 rbl_op0_0000_s10_w0p2 sn_op0_0000_s10_w0p2_3 rwl_des 0 sky130_fd_pr__nfet_01v8 L=0.15 W=0.42 nf=1 ad=0.1218 as=0.1218 pd=1.42 ps=1.42 nrd=0.69047619047619  nrs=0.69047619047619 sa=0 sb=0 sd=0 mult=1 m=1
csn_op0_0000_s10_w0p2_3 sn_op0_0000_s10_w0p2_3 0 {C_SN}
XMN1_op0_0000_s10_w0p2 rbl_op0_0000_s10_w0p2 ref_op0_0000_s10_w0p2 vn_op0_0000_s10_w0p2 0 sky130_fd_pr__nfet_01v8 L=0.15 W=1 nf=1 ad=0.29 as=0.29 pd=2.58 ps=2.58 mult=1 m=1
XMN2_op0_0000_s10_w0p2 ref_op0_0000_s10_w0p2 rbl_op0_0000_s10_w0p2 vn_op0_0000_s10_w0p2 0 sky130_fd_pr__nfet_01v8 L=0.15 W=1 nf=1 ad=0.29 as=0.29 pd=2.58 ps=2.58 mult=1 m=1
XMP1_op0_0000_s10_w0p2 rbl_op0_0000_s10_w0p2 ref_op0_0000_s10_w0p2 vp_op0_0000_s10_w0p2 vdd sky130_fd_pr__pfet_01v8 L=0.15 W=2 nf=1 ad=0.58 as=0.58 pd=4.58 ps=4.58 mult=1 m=1
XMP2_op0_0000_s10_w0p2 ref_op0_0000_s10_w0p2 rbl_op0_0000_s10_w0p2 vp_op0_0000_s10_w0p2 vdd sky130_fd_pr__pfet_01v8 L=0.15 W=2 nf=1 ad=0.58 as=0.58 pd=4.58 ps=4.58 mult=1 m=1
XMNF_op0_0000_s10_w0p2 vn_op0_0000_s10_w0p2 en_op0_0000_s10_w0p2 0 0 sky130_fd_pr__nfet_01v8 L=0.15 W=2 nf=1 ad=0.58 as=0.58 pd=4.58 ps=4.58 mult=1 m=1
XMPH_op0_0000_s10_w0p2 vp_op0_0000_s10_w0p2 enb_op0_0000_s10_w0p2 vdd vdd sky130_fd_pr__pfet_01v8 L=0.15 W=4 nf=1 ad=1.16 as=1.16 pd=8.58 ps=8.58 mult=1 m=1
bd_op0_0000_s10_w0p2 d_op0_0000_s10_w0p2 0 v=v(rbl_op0_0000_s10_w0p2)-v(ref_op0_0000_s10_w0p2)

* ---- instance 229: op0_0000_s10_w0p5 (t_en 14 ns, WWL 15..15.5 ns, release 17.5 ns) ----
ven_op0_0000_s10_w0p5  en_op0_0000_s10_w0p5  0 pwl(0 0 1.4000e-08 0 1.4100e-08 {VDD} 1.7500e-08 {VDD} 1.7600e-08 0)
venb_op0_0000_s10_w0p5 enb_op0_0000_s10_w0p5 0 pwl(0 {VDD} 1.4000e-08 {VDD} 1.4100e-08 0 1.7500e-08 0 1.7600e-08 {VDD})
vrs_op0_0000_s10_w0p5  rwls_op0_0000_s10_w0p5 0 pwl(0 {VDD} {T_READ} {VDD} {T_READ+TEDGE} 0 1.7500e-08 0 1.7600e-08 {VDD})
vww_op0_0000_s10_w0p5  wwl_op0_0000_s10_w0p5 0 pwl(0 0 1.5000e-08 0 1.5100e-08 {VDD} 1.5500e-08 {VDD} 1.5600e-08 0)
vwc_op0_0000_s10_w0p5  wbc_op0_0000_s10_w0p5 0 pwl(0 0 1.5000e-08 0 1.5100e-08 {VDD} 1.7500e-08 {VDD} 1.7600e-08 0)
swb_op0_0000_s10_w0p5 ref_op0_0000_s10_w0p5 wbl_op0_0000_s10_w0p5 wbc_op0_0000_s10_w0p5 0 swwbl
cwbl_op0_0000_s10_w0p5 wbl_op0_0000_s10_w0p5 0 {C_WBL}
spa_op0_0000_s10_w0p5 prea rbl_op0_0000_s10_w0p5 ctl 0 swpre
spr_op0_0000_s10_w0p5 pref ref_op0_0000_s10_w0p5 ctl 0 swpre
crbl_op0_0000_s10_w0p5 rbl_op0_0000_s10_w0p5 0 {C_RBL}
cref_op0_0000_s10_w0p5 ref_op0_0000_s10_w0p5 0 {C_RBL}   $ ASSUMPTION: ideal matched dummy load
XMWR_op0_0000_s10_w0p5_0 sn_op0_0000_s10_w0p5_0 wwl_op0_0000_s10_w0p5 wbl_op0_0000_s10_w0p5 0 sky130_fd_pr__nfet_01v8 L=0.15 W=0.42 nf=1 ad=0.1218 as=0.1218 pd=1.42 ps=1.42 nrd=0.69047619047619  nrs=0.69047619047619 sa=0 sb=0 sd=0 mult=1 m=1
XMRD_op0_0000_s10_w0p5_0 rbl_op0_0000_s10_w0p5 sn_op0_0000_s10_w0p5_0 rwls_op0_0000_s10_w0p5 0 sky130_fd_pr__nfet_01v8 L=0.15 W=0.42 nf=1 ad=0.1218 as=0.1218 pd=1.42 ps=1.42 nrd=0.69047619047619  nrs=0.69047619047619 sa=0 sb=0 sd=0 mult=1 m=1
csn_op0_0000_s10_w0p5_0 sn_op0_0000_s10_w0p5_0 0 {C_SN}
XMWR_op0_0000_s10_w0p5_1 sn_op0_0000_s10_w0p5_1 wwl_des wbl_op0_0000_s10_w0p5 0 sky130_fd_pr__nfet_01v8 L=0.15 W=0.42 nf=1 ad=0.1218 as=0.1218 pd=1.42 ps=1.42 nrd=0.69047619047619  nrs=0.69047619047619 sa=0 sb=0 sd=0 mult=1 m=1
XMRD_op0_0000_s10_w0p5_1 rbl_op0_0000_s10_w0p5 sn_op0_0000_s10_w0p5_1 rwl_des 0 sky130_fd_pr__nfet_01v8 L=0.15 W=0.42 nf=1 ad=0.1218 as=0.1218 pd=1.42 ps=1.42 nrd=0.69047619047619  nrs=0.69047619047619 sa=0 sb=0 sd=0 mult=1 m=1
csn_op0_0000_s10_w0p5_1 sn_op0_0000_s10_w0p5_1 0 {C_SN}
XMWR_op0_0000_s10_w0p5_2 sn_op0_0000_s10_w0p5_2 wwl_des wbl_op0_0000_s10_w0p5 0 sky130_fd_pr__nfet_01v8 L=0.15 W=0.42 nf=1 ad=0.1218 as=0.1218 pd=1.42 ps=1.42 nrd=0.69047619047619  nrs=0.69047619047619 sa=0 sb=0 sd=0 mult=1 m=1
XMRD_op0_0000_s10_w0p5_2 rbl_op0_0000_s10_w0p5 sn_op0_0000_s10_w0p5_2 rwl_des 0 sky130_fd_pr__nfet_01v8 L=0.15 W=0.42 nf=1 ad=0.1218 as=0.1218 pd=1.42 ps=1.42 nrd=0.69047619047619  nrs=0.69047619047619 sa=0 sb=0 sd=0 mult=1 m=1
csn_op0_0000_s10_w0p5_2 sn_op0_0000_s10_w0p5_2 0 {C_SN}
XMWR_op0_0000_s10_w0p5_3 sn_op0_0000_s10_w0p5_3 wwl_des wbl_op0_0000_s10_w0p5 0 sky130_fd_pr__nfet_01v8 L=0.15 W=0.42 nf=1 ad=0.1218 as=0.1218 pd=1.42 ps=1.42 nrd=0.69047619047619  nrs=0.69047619047619 sa=0 sb=0 sd=0 mult=1 m=1
XMRD_op0_0000_s10_w0p5_3 rbl_op0_0000_s10_w0p5 sn_op0_0000_s10_w0p5_3 rwl_des 0 sky130_fd_pr__nfet_01v8 L=0.15 W=0.42 nf=1 ad=0.1218 as=0.1218 pd=1.42 ps=1.42 nrd=0.69047619047619  nrs=0.69047619047619 sa=0 sb=0 sd=0 mult=1 m=1
csn_op0_0000_s10_w0p5_3 sn_op0_0000_s10_w0p5_3 0 {C_SN}
XMN1_op0_0000_s10_w0p5 rbl_op0_0000_s10_w0p5 ref_op0_0000_s10_w0p5 vn_op0_0000_s10_w0p5 0 sky130_fd_pr__nfet_01v8 L=0.15 W=1 nf=1 ad=0.29 as=0.29 pd=2.58 ps=2.58 mult=1 m=1
XMN2_op0_0000_s10_w0p5 ref_op0_0000_s10_w0p5 rbl_op0_0000_s10_w0p5 vn_op0_0000_s10_w0p5 0 sky130_fd_pr__nfet_01v8 L=0.15 W=1 nf=1 ad=0.29 as=0.29 pd=2.58 ps=2.58 mult=1 m=1
XMP1_op0_0000_s10_w0p5 rbl_op0_0000_s10_w0p5 ref_op0_0000_s10_w0p5 vp_op0_0000_s10_w0p5 vdd sky130_fd_pr__pfet_01v8 L=0.15 W=2 nf=1 ad=0.58 as=0.58 pd=4.58 ps=4.58 mult=1 m=1
XMP2_op0_0000_s10_w0p5 ref_op0_0000_s10_w0p5 rbl_op0_0000_s10_w0p5 vp_op0_0000_s10_w0p5 vdd sky130_fd_pr__pfet_01v8 L=0.15 W=2 nf=1 ad=0.58 as=0.58 pd=4.58 ps=4.58 mult=1 m=1
XMNF_op0_0000_s10_w0p5 vn_op0_0000_s10_w0p5 en_op0_0000_s10_w0p5 0 0 sky130_fd_pr__nfet_01v8 L=0.15 W=2 nf=1 ad=0.58 as=0.58 pd=4.58 ps=4.58 mult=1 m=1
XMPH_op0_0000_s10_w0p5 vp_op0_0000_s10_w0p5 enb_op0_0000_s10_w0p5 vdd vdd sky130_fd_pr__pfet_01v8 L=0.15 W=4 nf=1 ad=1.16 as=1.16 pd=8.58 ps=8.58 mult=1 m=1
bd_op0_0000_s10_w0p5 d_op0_0000_s10_w0p5 0 v=v(rbl_op0_0000_s10_w0p5)-v(ref_op0_0000_s10_w0p5)

* ---- instance 230: op0_0000_s10_w1 (t_en 14 ns, WWL 15..16 ns, release 18 ns) ----
ven_op0_0000_s10_w1  en_op0_0000_s10_w1  0 pwl(0 0 1.4000e-08 0 1.4100e-08 {VDD} 1.8000e-08 {VDD} 1.8100e-08 0)
venb_op0_0000_s10_w1 enb_op0_0000_s10_w1 0 pwl(0 {VDD} 1.4000e-08 {VDD} 1.4100e-08 0 1.8000e-08 0 1.8100e-08 {VDD})
vrs_op0_0000_s10_w1  rwls_op0_0000_s10_w1 0 pwl(0 {VDD} {T_READ} {VDD} {T_READ+TEDGE} 0 1.8000e-08 0 1.8100e-08 {VDD})
vww_op0_0000_s10_w1  wwl_op0_0000_s10_w1 0 pwl(0 0 1.5000e-08 0 1.5100e-08 {VDD} 1.6000e-08 {VDD} 1.6100e-08 0)
vwc_op0_0000_s10_w1  wbc_op0_0000_s10_w1 0 pwl(0 0 1.5000e-08 0 1.5100e-08 {VDD} 1.8000e-08 {VDD} 1.8100e-08 0)
swb_op0_0000_s10_w1 ref_op0_0000_s10_w1 wbl_op0_0000_s10_w1 wbc_op0_0000_s10_w1 0 swwbl
cwbl_op0_0000_s10_w1 wbl_op0_0000_s10_w1 0 {C_WBL}
spa_op0_0000_s10_w1 prea rbl_op0_0000_s10_w1 ctl 0 swpre
spr_op0_0000_s10_w1 pref ref_op0_0000_s10_w1 ctl 0 swpre
crbl_op0_0000_s10_w1 rbl_op0_0000_s10_w1 0 {C_RBL}
cref_op0_0000_s10_w1 ref_op0_0000_s10_w1 0 {C_RBL}   $ ASSUMPTION: ideal matched dummy load
XMWR_op0_0000_s10_w1_0 sn_op0_0000_s10_w1_0 wwl_op0_0000_s10_w1 wbl_op0_0000_s10_w1 0 sky130_fd_pr__nfet_01v8 L=0.15 W=0.42 nf=1 ad=0.1218 as=0.1218 pd=1.42 ps=1.42 nrd=0.69047619047619  nrs=0.69047619047619 sa=0 sb=0 sd=0 mult=1 m=1
XMRD_op0_0000_s10_w1_0 rbl_op0_0000_s10_w1 sn_op0_0000_s10_w1_0 rwls_op0_0000_s10_w1 0 sky130_fd_pr__nfet_01v8 L=0.15 W=0.42 nf=1 ad=0.1218 as=0.1218 pd=1.42 ps=1.42 nrd=0.69047619047619  nrs=0.69047619047619 sa=0 sb=0 sd=0 mult=1 m=1
csn_op0_0000_s10_w1_0 sn_op0_0000_s10_w1_0 0 {C_SN}
XMWR_op0_0000_s10_w1_1 sn_op0_0000_s10_w1_1 wwl_des wbl_op0_0000_s10_w1 0 sky130_fd_pr__nfet_01v8 L=0.15 W=0.42 nf=1 ad=0.1218 as=0.1218 pd=1.42 ps=1.42 nrd=0.69047619047619  nrs=0.69047619047619 sa=0 sb=0 sd=0 mult=1 m=1
XMRD_op0_0000_s10_w1_1 rbl_op0_0000_s10_w1 sn_op0_0000_s10_w1_1 rwl_des 0 sky130_fd_pr__nfet_01v8 L=0.15 W=0.42 nf=1 ad=0.1218 as=0.1218 pd=1.42 ps=1.42 nrd=0.69047619047619  nrs=0.69047619047619 sa=0 sb=0 sd=0 mult=1 m=1
csn_op0_0000_s10_w1_1 sn_op0_0000_s10_w1_1 0 {C_SN}
XMWR_op0_0000_s10_w1_2 sn_op0_0000_s10_w1_2 wwl_des wbl_op0_0000_s10_w1 0 sky130_fd_pr__nfet_01v8 L=0.15 W=0.42 nf=1 ad=0.1218 as=0.1218 pd=1.42 ps=1.42 nrd=0.69047619047619  nrs=0.69047619047619 sa=0 sb=0 sd=0 mult=1 m=1
XMRD_op0_0000_s10_w1_2 rbl_op0_0000_s10_w1 sn_op0_0000_s10_w1_2 rwl_des 0 sky130_fd_pr__nfet_01v8 L=0.15 W=0.42 nf=1 ad=0.1218 as=0.1218 pd=1.42 ps=1.42 nrd=0.69047619047619  nrs=0.69047619047619 sa=0 sb=0 sd=0 mult=1 m=1
csn_op0_0000_s10_w1_2 sn_op0_0000_s10_w1_2 0 {C_SN}
XMWR_op0_0000_s10_w1_3 sn_op0_0000_s10_w1_3 wwl_des wbl_op0_0000_s10_w1 0 sky130_fd_pr__nfet_01v8 L=0.15 W=0.42 nf=1 ad=0.1218 as=0.1218 pd=1.42 ps=1.42 nrd=0.69047619047619  nrs=0.69047619047619 sa=0 sb=0 sd=0 mult=1 m=1
XMRD_op0_0000_s10_w1_3 rbl_op0_0000_s10_w1 sn_op0_0000_s10_w1_3 rwl_des 0 sky130_fd_pr__nfet_01v8 L=0.15 W=0.42 nf=1 ad=0.1218 as=0.1218 pd=1.42 ps=1.42 nrd=0.69047619047619  nrs=0.69047619047619 sa=0 sb=0 sd=0 mult=1 m=1
csn_op0_0000_s10_w1_3 sn_op0_0000_s10_w1_3 0 {C_SN}
XMN1_op0_0000_s10_w1 rbl_op0_0000_s10_w1 ref_op0_0000_s10_w1 vn_op0_0000_s10_w1 0 sky130_fd_pr__nfet_01v8 L=0.15 W=1 nf=1 ad=0.29 as=0.29 pd=2.58 ps=2.58 mult=1 m=1
XMN2_op0_0000_s10_w1 ref_op0_0000_s10_w1 rbl_op0_0000_s10_w1 vn_op0_0000_s10_w1 0 sky130_fd_pr__nfet_01v8 L=0.15 W=1 nf=1 ad=0.29 as=0.29 pd=2.58 ps=2.58 mult=1 m=1
XMP1_op0_0000_s10_w1 rbl_op0_0000_s10_w1 ref_op0_0000_s10_w1 vp_op0_0000_s10_w1 vdd sky130_fd_pr__pfet_01v8 L=0.15 W=2 nf=1 ad=0.58 as=0.58 pd=4.58 ps=4.58 mult=1 m=1
XMP2_op0_0000_s10_w1 ref_op0_0000_s10_w1 rbl_op0_0000_s10_w1 vp_op0_0000_s10_w1 vdd sky130_fd_pr__pfet_01v8 L=0.15 W=2 nf=1 ad=0.58 as=0.58 pd=4.58 ps=4.58 mult=1 m=1
XMNF_op0_0000_s10_w1 vn_op0_0000_s10_w1 en_op0_0000_s10_w1 0 0 sky130_fd_pr__nfet_01v8 L=0.15 W=2 nf=1 ad=0.58 as=0.58 pd=4.58 ps=4.58 mult=1 m=1
XMPH_op0_0000_s10_w1 vp_op0_0000_s10_w1 enb_op0_0000_s10_w1 vdd vdd sky130_fd_pr__pfet_01v8 L=0.15 W=4 nf=1 ad=1.16 as=1.16 pd=8.58 ps=8.58 mult=1 m=1
bd_op0_0000_s10_w1 d_op0_0000_s10_w1 0 v=v(rbl_op0_0000_s10_w1)-v(ref_op0_0000_s10_w1)

* ---- instance 231: op0_0000_s10_w2 (t_en 14 ns, WWL 15..17 ns, release 19 ns) ----
ven_op0_0000_s10_w2  en_op0_0000_s10_w2  0 pwl(0 0 1.4000e-08 0 1.4100e-08 {VDD} 1.9000e-08 {VDD} 1.9100e-08 0)
venb_op0_0000_s10_w2 enb_op0_0000_s10_w2 0 pwl(0 {VDD} 1.4000e-08 {VDD} 1.4100e-08 0 1.9000e-08 0 1.9100e-08 {VDD})
vrs_op0_0000_s10_w2  rwls_op0_0000_s10_w2 0 pwl(0 {VDD} {T_READ} {VDD} {T_READ+TEDGE} 0 1.9000e-08 0 1.9100e-08 {VDD})
vww_op0_0000_s10_w2  wwl_op0_0000_s10_w2 0 pwl(0 0 1.5000e-08 0 1.5100e-08 {VDD} 1.7000e-08 {VDD} 1.7100e-08 0)
vwc_op0_0000_s10_w2  wbc_op0_0000_s10_w2 0 pwl(0 0 1.5000e-08 0 1.5100e-08 {VDD} 1.9000e-08 {VDD} 1.9100e-08 0)
swb_op0_0000_s10_w2 ref_op0_0000_s10_w2 wbl_op0_0000_s10_w2 wbc_op0_0000_s10_w2 0 swwbl
cwbl_op0_0000_s10_w2 wbl_op0_0000_s10_w2 0 {C_WBL}
spa_op0_0000_s10_w2 prea rbl_op0_0000_s10_w2 ctl 0 swpre
spr_op0_0000_s10_w2 pref ref_op0_0000_s10_w2 ctl 0 swpre
crbl_op0_0000_s10_w2 rbl_op0_0000_s10_w2 0 {C_RBL}
cref_op0_0000_s10_w2 ref_op0_0000_s10_w2 0 {C_RBL}   $ ASSUMPTION: ideal matched dummy load
XMWR_op0_0000_s10_w2_0 sn_op0_0000_s10_w2_0 wwl_op0_0000_s10_w2 wbl_op0_0000_s10_w2 0 sky130_fd_pr__nfet_01v8 L=0.15 W=0.42 nf=1 ad=0.1218 as=0.1218 pd=1.42 ps=1.42 nrd=0.69047619047619  nrs=0.69047619047619 sa=0 sb=0 sd=0 mult=1 m=1
XMRD_op0_0000_s10_w2_0 rbl_op0_0000_s10_w2 sn_op0_0000_s10_w2_0 rwls_op0_0000_s10_w2 0 sky130_fd_pr__nfet_01v8 L=0.15 W=0.42 nf=1 ad=0.1218 as=0.1218 pd=1.42 ps=1.42 nrd=0.69047619047619  nrs=0.69047619047619 sa=0 sb=0 sd=0 mult=1 m=1
csn_op0_0000_s10_w2_0 sn_op0_0000_s10_w2_0 0 {C_SN}
XMWR_op0_0000_s10_w2_1 sn_op0_0000_s10_w2_1 wwl_des wbl_op0_0000_s10_w2 0 sky130_fd_pr__nfet_01v8 L=0.15 W=0.42 nf=1 ad=0.1218 as=0.1218 pd=1.42 ps=1.42 nrd=0.69047619047619  nrs=0.69047619047619 sa=0 sb=0 sd=0 mult=1 m=1
XMRD_op0_0000_s10_w2_1 rbl_op0_0000_s10_w2 sn_op0_0000_s10_w2_1 rwl_des 0 sky130_fd_pr__nfet_01v8 L=0.15 W=0.42 nf=1 ad=0.1218 as=0.1218 pd=1.42 ps=1.42 nrd=0.69047619047619  nrs=0.69047619047619 sa=0 sb=0 sd=0 mult=1 m=1
csn_op0_0000_s10_w2_1 sn_op0_0000_s10_w2_1 0 {C_SN}
XMWR_op0_0000_s10_w2_2 sn_op0_0000_s10_w2_2 wwl_des wbl_op0_0000_s10_w2 0 sky130_fd_pr__nfet_01v8 L=0.15 W=0.42 nf=1 ad=0.1218 as=0.1218 pd=1.42 ps=1.42 nrd=0.69047619047619  nrs=0.69047619047619 sa=0 sb=0 sd=0 mult=1 m=1
XMRD_op0_0000_s10_w2_2 rbl_op0_0000_s10_w2 sn_op0_0000_s10_w2_2 rwl_des 0 sky130_fd_pr__nfet_01v8 L=0.15 W=0.42 nf=1 ad=0.1218 as=0.1218 pd=1.42 ps=1.42 nrd=0.69047619047619  nrs=0.69047619047619 sa=0 sb=0 sd=0 mult=1 m=1
csn_op0_0000_s10_w2_2 sn_op0_0000_s10_w2_2 0 {C_SN}
XMWR_op0_0000_s10_w2_3 sn_op0_0000_s10_w2_3 wwl_des wbl_op0_0000_s10_w2 0 sky130_fd_pr__nfet_01v8 L=0.15 W=0.42 nf=1 ad=0.1218 as=0.1218 pd=1.42 ps=1.42 nrd=0.69047619047619  nrs=0.69047619047619 sa=0 sb=0 sd=0 mult=1 m=1
XMRD_op0_0000_s10_w2_3 rbl_op0_0000_s10_w2 sn_op0_0000_s10_w2_3 rwl_des 0 sky130_fd_pr__nfet_01v8 L=0.15 W=0.42 nf=1 ad=0.1218 as=0.1218 pd=1.42 ps=1.42 nrd=0.69047619047619  nrs=0.69047619047619 sa=0 sb=0 sd=0 mult=1 m=1
csn_op0_0000_s10_w2_3 sn_op0_0000_s10_w2_3 0 {C_SN}
XMN1_op0_0000_s10_w2 rbl_op0_0000_s10_w2 ref_op0_0000_s10_w2 vn_op0_0000_s10_w2 0 sky130_fd_pr__nfet_01v8 L=0.15 W=1 nf=1 ad=0.29 as=0.29 pd=2.58 ps=2.58 mult=1 m=1
XMN2_op0_0000_s10_w2 ref_op0_0000_s10_w2 rbl_op0_0000_s10_w2 vn_op0_0000_s10_w2 0 sky130_fd_pr__nfet_01v8 L=0.15 W=1 nf=1 ad=0.29 as=0.29 pd=2.58 ps=2.58 mult=1 m=1
XMP1_op0_0000_s10_w2 rbl_op0_0000_s10_w2 ref_op0_0000_s10_w2 vp_op0_0000_s10_w2 vdd sky130_fd_pr__pfet_01v8 L=0.15 W=2 nf=1 ad=0.58 as=0.58 pd=4.58 ps=4.58 mult=1 m=1
XMP2_op0_0000_s10_w2 ref_op0_0000_s10_w2 rbl_op0_0000_s10_w2 vp_op0_0000_s10_w2 vdd sky130_fd_pr__pfet_01v8 L=0.15 W=2 nf=1 ad=0.58 as=0.58 pd=4.58 ps=4.58 mult=1 m=1
XMNF_op0_0000_s10_w2 vn_op0_0000_s10_w2 en_op0_0000_s10_w2 0 0 sky130_fd_pr__nfet_01v8 L=0.15 W=2 nf=1 ad=0.58 as=0.58 pd=4.58 ps=4.58 mult=1 m=1
XMPH_op0_0000_s10_w2 vp_op0_0000_s10_w2 enb_op0_0000_s10_w2 vdd vdd sky130_fd_pr__pfet_01v8 L=0.15 W=4 nf=1 ad=1.16 as=1.16 pd=8.58 ps=8.58 mult=1 m=1
bd_op0_0000_s10_w2 d_op0_0000_s10_w2 0 v=v(rbl_op0_0000_s10_w2)-v(ref_op0_0000_s10_w2)

* ---- instance 232: op0_0000_s10_w3 (t_en 14 ns, WWL 15..18 ns, release 20 ns) ----
ven_op0_0000_s10_w3  en_op0_0000_s10_w3  0 pwl(0 0 1.4000e-08 0 1.4100e-08 {VDD} 2.0000e-08 {VDD} 2.0100e-08 0)
venb_op0_0000_s10_w3 enb_op0_0000_s10_w3 0 pwl(0 {VDD} 1.4000e-08 {VDD} 1.4100e-08 0 2.0000e-08 0 2.0100e-08 {VDD})
vrs_op0_0000_s10_w3  rwls_op0_0000_s10_w3 0 pwl(0 {VDD} {T_READ} {VDD} {T_READ+TEDGE} 0 2.0000e-08 0 2.0100e-08 {VDD})
vww_op0_0000_s10_w3  wwl_op0_0000_s10_w3 0 pwl(0 0 1.5000e-08 0 1.5100e-08 {VDD} 1.8000e-08 {VDD} 1.8100e-08 0)
vwc_op0_0000_s10_w3  wbc_op0_0000_s10_w3 0 pwl(0 0 1.5000e-08 0 1.5100e-08 {VDD} 2.0000e-08 {VDD} 2.0100e-08 0)
swb_op0_0000_s10_w3 ref_op0_0000_s10_w3 wbl_op0_0000_s10_w3 wbc_op0_0000_s10_w3 0 swwbl
cwbl_op0_0000_s10_w3 wbl_op0_0000_s10_w3 0 {C_WBL}
spa_op0_0000_s10_w3 prea rbl_op0_0000_s10_w3 ctl 0 swpre
spr_op0_0000_s10_w3 pref ref_op0_0000_s10_w3 ctl 0 swpre
crbl_op0_0000_s10_w3 rbl_op0_0000_s10_w3 0 {C_RBL}
cref_op0_0000_s10_w3 ref_op0_0000_s10_w3 0 {C_RBL}   $ ASSUMPTION: ideal matched dummy load
XMWR_op0_0000_s10_w3_0 sn_op0_0000_s10_w3_0 wwl_op0_0000_s10_w3 wbl_op0_0000_s10_w3 0 sky130_fd_pr__nfet_01v8 L=0.15 W=0.42 nf=1 ad=0.1218 as=0.1218 pd=1.42 ps=1.42 nrd=0.69047619047619  nrs=0.69047619047619 sa=0 sb=0 sd=0 mult=1 m=1
XMRD_op0_0000_s10_w3_0 rbl_op0_0000_s10_w3 sn_op0_0000_s10_w3_0 rwls_op0_0000_s10_w3 0 sky130_fd_pr__nfet_01v8 L=0.15 W=0.42 nf=1 ad=0.1218 as=0.1218 pd=1.42 ps=1.42 nrd=0.69047619047619  nrs=0.69047619047619 sa=0 sb=0 sd=0 mult=1 m=1
csn_op0_0000_s10_w3_0 sn_op0_0000_s10_w3_0 0 {C_SN}
XMWR_op0_0000_s10_w3_1 sn_op0_0000_s10_w3_1 wwl_des wbl_op0_0000_s10_w3 0 sky130_fd_pr__nfet_01v8 L=0.15 W=0.42 nf=1 ad=0.1218 as=0.1218 pd=1.42 ps=1.42 nrd=0.69047619047619  nrs=0.69047619047619 sa=0 sb=0 sd=0 mult=1 m=1
XMRD_op0_0000_s10_w3_1 rbl_op0_0000_s10_w3 sn_op0_0000_s10_w3_1 rwl_des 0 sky130_fd_pr__nfet_01v8 L=0.15 W=0.42 nf=1 ad=0.1218 as=0.1218 pd=1.42 ps=1.42 nrd=0.69047619047619  nrs=0.69047619047619 sa=0 sb=0 sd=0 mult=1 m=1
csn_op0_0000_s10_w3_1 sn_op0_0000_s10_w3_1 0 {C_SN}
XMWR_op0_0000_s10_w3_2 sn_op0_0000_s10_w3_2 wwl_des wbl_op0_0000_s10_w3 0 sky130_fd_pr__nfet_01v8 L=0.15 W=0.42 nf=1 ad=0.1218 as=0.1218 pd=1.42 ps=1.42 nrd=0.69047619047619  nrs=0.69047619047619 sa=0 sb=0 sd=0 mult=1 m=1
XMRD_op0_0000_s10_w3_2 rbl_op0_0000_s10_w3 sn_op0_0000_s10_w3_2 rwl_des 0 sky130_fd_pr__nfet_01v8 L=0.15 W=0.42 nf=1 ad=0.1218 as=0.1218 pd=1.42 ps=1.42 nrd=0.69047619047619  nrs=0.69047619047619 sa=0 sb=0 sd=0 mult=1 m=1
csn_op0_0000_s10_w3_2 sn_op0_0000_s10_w3_2 0 {C_SN}
XMWR_op0_0000_s10_w3_3 sn_op0_0000_s10_w3_3 wwl_des wbl_op0_0000_s10_w3 0 sky130_fd_pr__nfet_01v8 L=0.15 W=0.42 nf=1 ad=0.1218 as=0.1218 pd=1.42 ps=1.42 nrd=0.69047619047619  nrs=0.69047619047619 sa=0 sb=0 sd=0 mult=1 m=1
XMRD_op0_0000_s10_w3_3 rbl_op0_0000_s10_w3 sn_op0_0000_s10_w3_3 rwl_des 0 sky130_fd_pr__nfet_01v8 L=0.15 W=0.42 nf=1 ad=0.1218 as=0.1218 pd=1.42 ps=1.42 nrd=0.69047619047619  nrs=0.69047619047619 sa=0 sb=0 sd=0 mult=1 m=1
csn_op0_0000_s10_w3_3 sn_op0_0000_s10_w3_3 0 {C_SN}
XMN1_op0_0000_s10_w3 rbl_op0_0000_s10_w3 ref_op0_0000_s10_w3 vn_op0_0000_s10_w3 0 sky130_fd_pr__nfet_01v8 L=0.15 W=1 nf=1 ad=0.29 as=0.29 pd=2.58 ps=2.58 mult=1 m=1
XMN2_op0_0000_s10_w3 ref_op0_0000_s10_w3 rbl_op0_0000_s10_w3 vn_op0_0000_s10_w3 0 sky130_fd_pr__nfet_01v8 L=0.15 W=1 nf=1 ad=0.29 as=0.29 pd=2.58 ps=2.58 mult=1 m=1
XMP1_op0_0000_s10_w3 rbl_op0_0000_s10_w3 ref_op0_0000_s10_w3 vp_op0_0000_s10_w3 vdd sky130_fd_pr__pfet_01v8 L=0.15 W=2 nf=1 ad=0.58 as=0.58 pd=4.58 ps=4.58 mult=1 m=1
XMP2_op0_0000_s10_w3 ref_op0_0000_s10_w3 rbl_op0_0000_s10_w3 vp_op0_0000_s10_w3 vdd sky130_fd_pr__pfet_01v8 L=0.15 W=2 nf=1 ad=0.58 as=0.58 pd=4.58 ps=4.58 mult=1 m=1
XMNF_op0_0000_s10_w3 vn_op0_0000_s10_w3 en_op0_0000_s10_w3 0 0 sky130_fd_pr__nfet_01v8 L=0.15 W=2 nf=1 ad=0.58 as=0.58 pd=4.58 ps=4.58 mult=1 m=1
XMPH_op0_0000_s10_w3 vp_op0_0000_s10_w3 enb_op0_0000_s10_w3 vdd vdd sky130_fd_pr__pfet_01v8 L=0.15 W=4 nf=1 ad=1.16 as=1.16 pd=8.58 ps=8.58 mult=1 m=1
bd_op0_0000_s10_w3 d_op0_0000_s10_w3 0 v=v(rbl_op0_0000_s10_w3)-v(ref_op0_0000_s10_w3)

* ---- instance 233: op0_0000_s10_w5 (t_en 14 ns, WWL 15..20 ns, release 22 ns) ----
ven_op0_0000_s10_w5  en_op0_0000_s10_w5  0 pwl(0 0 1.4000e-08 0 1.4100e-08 {VDD} 2.2000e-08 {VDD} 2.2100e-08 0)
venb_op0_0000_s10_w5 enb_op0_0000_s10_w5 0 pwl(0 {VDD} 1.4000e-08 {VDD} 1.4100e-08 0 2.2000e-08 0 2.2100e-08 {VDD})
vrs_op0_0000_s10_w5  rwls_op0_0000_s10_w5 0 pwl(0 {VDD} {T_READ} {VDD} {T_READ+TEDGE} 0 2.2000e-08 0 2.2100e-08 {VDD})
vww_op0_0000_s10_w5  wwl_op0_0000_s10_w5 0 pwl(0 0 1.5000e-08 0 1.5100e-08 {VDD} 2.0000e-08 {VDD} 2.0100e-08 0)
vwc_op0_0000_s10_w5  wbc_op0_0000_s10_w5 0 pwl(0 0 1.5000e-08 0 1.5100e-08 {VDD} 2.2000e-08 {VDD} 2.2100e-08 0)
swb_op0_0000_s10_w5 ref_op0_0000_s10_w5 wbl_op0_0000_s10_w5 wbc_op0_0000_s10_w5 0 swwbl
cwbl_op0_0000_s10_w5 wbl_op0_0000_s10_w5 0 {C_WBL}
spa_op0_0000_s10_w5 prea rbl_op0_0000_s10_w5 ctl 0 swpre
spr_op0_0000_s10_w5 pref ref_op0_0000_s10_w5 ctl 0 swpre
crbl_op0_0000_s10_w5 rbl_op0_0000_s10_w5 0 {C_RBL}
cref_op0_0000_s10_w5 ref_op0_0000_s10_w5 0 {C_RBL}   $ ASSUMPTION: ideal matched dummy load
XMWR_op0_0000_s10_w5_0 sn_op0_0000_s10_w5_0 wwl_op0_0000_s10_w5 wbl_op0_0000_s10_w5 0 sky130_fd_pr__nfet_01v8 L=0.15 W=0.42 nf=1 ad=0.1218 as=0.1218 pd=1.42 ps=1.42 nrd=0.69047619047619  nrs=0.69047619047619 sa=0 sb=0 sd=0 mult=1 m=1
XMRD_op0_0000_s10_w5_0 rbl_op0_0000_s10_w5 sn_op0_0000_s10_w5_0 rwls_op0_0000_s10_w5 0 sky130_fd_pr__nfet_01v8 L=0.15 W=0.42 nf=1 ad=0.1218 as=0.1218 pd=1.42 ps=1.42 nrd=0.69047619047619  nrs=0.69047619047619 sa=0 sb=0 sd=0 mult=1 m=1
csn_op0_0000_s10_w5_0 sn_op0_0000_s10_w5_0 0 {C_SN}
XMWR_op0_0000_s10_w5_1 sn_op0_0000_s10_w5_1 wwl_des wbl_op0_0000_s10_w5 0 sky130_fd_pr__nfet_01v8 L=0.15 W=0.42 nf=1 ad=0.1218 as=0.1218 pd=1.42 ps=1.42 nrd=0.69047619047619  nrs=0.69047619047619 sa=0 sb=0 sd=0 mult=1 m=1
XMRD_op0_0000_s10_w5_1 rbl_op0_0000_s10_w5 sn_op0_0000_s10_w5_1 rwl_des 0 sky130_fd_pr__nfet_01v8 L=0.15 W=0.42 nf=1 ad=0.1218 as=0.1218 pd=1.42 ps=1.42 nrd=0.69047619047619  nrs=0.69047619047619 sa=0 sb=0 sd=0 mult=1 m=1
csn_op0_0000_s10_w5_1 sn_op0_0000_s10_w5_1 0 {C_SN}
XMWR_op0_0000_s10_w5_2 sn_op0_0000_s10_w5_2 wwl_des wbl_op0_0000_s10_w5 0 sky130_fd_pr__nfet_01v8 L=0.15 W=0.42 nf=1 ad=0.1218 as=0.1218 pd=1.42 ps=1.42 nrd=0.69047619047619  nrs=0.69047619047619 sa=0 sb=0 sd=0 mult=1 m=1
XMRD_op0_0000_s10_w5_2 rbl_op0_0000_s10_w5 sn_op0_0000_s10_w5_2 rwl_des 0 sky130_fd_pr__nfet_01v8 L=0.15 W=0.42 nf=1 ad=0.1218 as=0.1218 pd=1.42 ps=1.42 nrd=0.69047619047619  nrs=0.69047619047619 sa=0 sb=0 sd=0 mult=1 m=1
csn_op0_0000_s10_w5_2 sn_op0_0000_s10_w5_2 0 {C_SN}
XMWR_op0_0000_s10_w5_3 sn_op0_0000_s10_w5_3 wwl_des wbl_op0_0000_s10_w5 0 sky130_fd_pr__nfet_01v8 L=0.15 W=0.42 nf=1 ad=0.1218 as=0.1218 pd=1.42 ps=1.42 nrd=0.69047619047619  nrs=0.69047619047619 sa=0 sb=0 sd=0 mult=1 m=1
XMRD_op0_0000_s10_w5_3 rbl_op0_0000_s10_w5 sn_op0_0000_s10_w5_3 rwl_des 0 sky130_fd_pr__nfet_01v8 L=0.15 W=0.42 nf=1 ad=0.1218 as=0.1218 pd=1.42 ps=1.42 nrd=0.69047619047619  nrs=0.69047619047619 sa=0 sb=0 sd=0 mult=1 m=1
csn_op0_0000_s10_w5_3 sn_op0_0000_s10_w5_3 0 {C_SN}
XMN1_op0_0000_s10_w5 rbl_op0_0000_s10_w5 ref_op0_0000_s10_w5 vn_op0_0000_s10_w5 0 sky130_fd_pr__nfet_01v8 L=0.15 W=1 nf=1 ad=0.29 as=0.29 pd=2.58 ps=2.58 mult=1 m=1
XMN2_op0_0000_s10_w5 ref_op0_0000_s10_w5 rbl_op0_0000_s10_w5 vn_op0_0000_s10_w5 0 sky130_fd_pr__nfet_01v8 L=0.15 W=1 nf=1 ad=0.29 as=0.29 pd=2.58 ps=2.58 mult=1 m=1
XMP1_op0_0000_s10_w5 rbl_op0_0000_s10_w5 ref_op0_0000_s10_w5 vp_op0_0000_s10_w5 vdd sky130_fd_pr__pfet_01v8 L=0.15 W=2 nf=1 ad=0.58 as=0.58 pd=4.58 ps=4.58 mult=1 m=1
XMP2_op0_0000_s10_w5 ref_op0_0000_s10_w5 rbl_op0_0000_s10_w5 vp_op0_0000_s10_w5 vdd sky130_fd_pr__pfet_01v8 L=0.15 W=2 nf=1 ad=0.58 as=0.58 pd=4.58 ps=4.58 mult=1 m=1
XMNF_op0_0000_s10_w5 vn_op0_0000_s10_w5 en_op0_0000_s10_w5 0 0 sky130_fd_pr__nfet_01v8 L=0.15 W=2 nf=1 ad=0.58 as=0.58 pd=4.58 ps=4.58 mult=1 m=1
XMPH_op0_0000_s10_w5 vp_op0_0000_s10_w5 enb_op0_0000_s10_w5 vdd vdd sky130_fd_pr__pfet_01v8 L=0.15 W=4 nf=1 ad=1.16 as=1.16 pd=8.58 ps=8.58 mult=1 m=1
bd_op0_0000_s10_w5 d_op0_0000_s10_w5 0 v=v(rbl_op0_0000_s10_w5)-v(ref_op0_0000_s10_w5)

* ---- instance 234: op0_0000_s10_w7p5 (t_en 14 ns, WWL 15..22.5 ns, release 24.5 ns) ----
ven_op0_0000_s10_w7p5  en_op0_0000_s10_w7p5  0 pwl(0 0 1.4000e-08 0 1.4100e-08 {VDD} 2.4500e-08 {VDD} 2.4600e-08 0)
venb_op0_0000_s10_w7p5 enb_op0_0000_s10_w7p5 0 pwl(0 {VDD} 1.4000e-08 {VDD} 1.4100e-08 0 2.4500e-08 0 2.4600e-08 {VDD})
vrs_op0_0000_s10_w7p5  rwls_op0_0000_s10_w7p5 0 pwl(0 {VDD} {T_READ} {VDD} {T_READ+TEDGE} 0 2.4500e-08 0 2.4600e-08 {VDD})
vww_op0_0000_s10_w7p5  wwl_op0_0000_s10_w7p5 0 pwl(0 0 1.5000e-08 0 1.5100e-08 {VDD} 2.2500e-08 {VDD} 2.2600e-08 0)
vwc_op0_0000_s10_w7p5  wbc_op0_0000_s10_w7p5 0 pwl(0 0 1.5000e-08 0 1.5100e-08 {VDD} 2.4500e-08 {VDD} 2.4600e-08 0)
swb_op0_0000_s10_w7p5 ref_op0_0000_s10_w7p5 wbl_op0_0000_s10_w7p5 wbc_op0_0000_s10_w7p5 0 swwbl
cwbl_op0_0000_s10_w7p5 wbl_op0_0000_s10_w7p5 0 {C_WBL}
spa_op0_0000_s10_w7p5 prea rbl_op0_0000_s10_w7p5 ctl 0 swpre
spr_op0_0000_s10_w7p5 pref ref_op0_0000_s10_w7p5 ctl 0 swpre
crbl_op0_0000_s10_w7p5 rbl_op0_0000_s10_w7p5 0 {C_RBL}
cref_op0_0000_s10_w7p5 ref_op0_0000_s10_w7p5 0 {C_RBL}   $ ASSUMPTION: ideal matched dummy load
XMWR_op0_0000_s10_w7p5_0 sn_op0_0000_s10_w7p5_0 wwl_op0_0000_s10_w7p5 wbl_op0_0000_s10_w7p5 0 sky130_fd_pr__nfet_01v8 L=0.15 W=0.42 nf=1 ad=0.1218 as=0.1218 pd=1.42 ps=1.42 nrd=0.69047619047619  nrs=0.69047619047619 sa=0 sb=0 sd=0 mult=1 m=1
XMRD_op0_0000_s10_w7p5_0 rbl_op0_0000_s10_w7p5 sn_op0_0000_s10_w7p5_0 rwls_op0_0000_s10_w7p5 0 sky130_fd_pr__nfet_01v8 L=0.15 W=0.42 nf=1 ad=0.1218 as=0.1218 pd=1.42 ps=1.42 nrd=0.69047619047619  nrs=0.69047619047619 sa=0 sb=0 sd=0 mult=1 m=1
csn_op0_0000_s10_w7p5_0 sn_op0_0000_s10_w7p5_0 0 {C_SN}
XMWR_op0_0000_s10_w7p5_1 sn_op0_0000_s10_w7p5_1 wwl_des wbl_op0_0000_s10_w7p5 0 sky130_fd_pr__nfet_01v8 L=0.15 W=0.42 nf=1 ad=0.1218 as=0.1218 pd=1.42 ps=1.42 nrd=0.69047619047619  nrs=0.69047619047619 sa=0 sb=0 sd=0 mult=1 m=1
XMRD_op0_0000_s10_w7p5_1 rbl_op0_0000_s10_w7p5 sn_op0_0000_s10_w7p5_1 rwl_des 0 sky130_fd_pr__nfet_01v8 L=0.15 W=0.42 nf=1 ad=0.1218 as=0.1218 pd=1.42 ps=1.42 nrd=0.69047619047619  nrs=0.69047619047619 sa=0 sb=0 sd=0 mult=1 m=1
csn_op0_0000_s10_w7p5_1 sn_op0_0000_s10_w7p5_1 0 {C_SN}
XMWR_op0_0000_s10_w7p5_2 sn_op0_0000_s10_w7p5_2 wwl_des wbl_op0_0000_s10_w7p5 0 sky130_fd_pr__nfet_01v8 L=0.15 W=0.42 nf=1 ad=0.1218 as=0.1218 pd=1.42 ps=1.42 nrd=0.69047619047619  nrs=0.69047619047619 sa=0 sb=0 sd=0 mult=1 m=1
XMRD_op0_0000_s10_w7p5_2 rbl_op0_0000_s10_w7p5 sn_op0_0000_s10_w7p5_2 rwl_des 0 sky130_fd_pr__nfet_01v8 L=0.15 W=0.42 nf=1 ad=0.1218 as=0.1218 pd=1.42 ps=1.42 nrd=0.69047619047619  nrs=0.69047619047619 sa=0 sb=0 sd=0 mult=1 m=1
csn_op0_0000_s10_w7p5_2 sn_op0_0000_s10_w7p5_2 0 {C_SN}
XMWR_op0_0000_s10_w7p5_3 sn_op0_0000_s10_w7p5_3 wwl_des wbl_op0_0000_s10_w7p5 0 sky130_fd_pr__nfet_01v8 L=0.15 W=0.42 nf=1 ad=0.1218 as=0.1218 pd=1.42 ps=1.42 nrd=0.69047619047619  nrs=0.69047619047619 sa=0 sb=0 sd=0 mult=1 m=1
XMRD_op0_0000_s10_w7p5_3 rbl_op0_0000_s10_w7p5 sn_op0_0000_s10_w7p5_3 rwl_des 0 sky130_fd_pr__nfet_01v8 L=0.15 W=0.42 nf=1 ad=0.1218 as=0.1218 pd=1.42 ps=1.42 nrd=0.69047619047619  nrs=0.69047619047619 sa=0 sb=0 sd=0 mult=1 m=1
csn_op0_0000_s10_w7p5_3 sn_op0_0000_s10_w7p5_3 0 {C_SN}
XMN1_op0_0000_s10_w7p5 rbl_op0_0000_s10_w7p5 ref_op0_0000_s10_w7p5 vn_op0_0000_s10_w7p5 0 sky130_fd_pr__nfet_01v8 L=0.15 W=1 nf=1 ad=0.29 as=0.29 pd=2.58 ps=2.58 mult=1 m=1
XMN2_op0_0000_s10_w7p5 ref_op0_0000_s10_w7p5 rbl_op0_0000_s10_w7p5 vn_op0_0000_s10_w7p5 0 sky130_fd_pr__nfet_01v8 L=0.15 W=1 nf=1 ad=0.29 as=0.29 pd=2.58 ps=2.58 mult=1 m=1
XMP1_op0_0000_s10_w7p5 rbl_op0_0000_s10_w7p5 ref_op0_0000_s10_w7p5 vp_op0_0000_s10_w7p5 vdd sky130_fd_pr__pfet_01v8 L=0.15 W=2 nf=1 ad=0.58 as=0.58 pd=4.58 ps=4.58 mult=1 m=1
XMP2_op0_0000_s10_w7p5 ref_op0_0000_s10_w7p5 rbl_op0_0000_s10_w7p5 vp_op0_0000_s10_w7p5 vdd sky130_fd_pr__pfet_01v8 L=0.15 W=2 nf=1 ad=0.58 as=0.58 pd=4.58 ps=4.58 mult=1 m=1
XMNF_op0_0000_s10_w7p5 vn_op0_0000_s10_w7p5 en_op0_0000_s10_w7p5 0 0 sky130_fd_pr__nfet_01v8 L=0.15 W=2 nf=1 ad=0.58 as=0.58 pd=4.58 ps=4.58 mult=1 m=1
XMPH_op0_0000_s10_w7p5 vp_op0_0000_s10_w7p5 enb_op0_0000_s10_w7p5 vdd vdd sky130_fd_pr__pfet_01v8 L=0.15 W=4 nf=1 ad=1.16 as=1.16 pd=8.58 ps=8.58 mult=1 m=1
bd_op0_0000_s10_w7p5 d_op0_0000_s10_w7p5 0 v=v(rbl_op0_0000_s10_w7p5)-v(ref_op0_0000_s10_w7p5)

* ---- instance 235: op0_0000_s10_w10 (t_en 14 ns, WWL 15..25 ns, release 27 ns) ----
ven_op0_0000_s10_w10  en_op0_0000_s10_w10  0 pwl(0 0 1.4000e-08 0 1.4100e-08 {VDD} 2.7000e-08 {VDD} 2.7100e-08 0)
venb_op0_0000_s10_w10 enb_op0_0000_s10_w10 0 pwl(0 {VDD} 1.4000e-08 {VDD} 1.4100e-08 0 2.7000e-08 0 2.7100e-08 {VDD})
vrs_op0_0000_s10_w10  rwls_op0_0000_s10_w10 0 pwl(0 {VDD} {T_READ} {VDD} {T_READ+TEDGE} 0 2.7000e-08 0 2.7100e-08 {VDD})
vww_op0_0000_s10_w10  wwl_op0_0000_s10_w10 0 pwl(0 0 1.5000e-08 0 1.5100e-08 {VDD} 2.5000e-08 {VDD} 2.5100e-08 0)
vwc_op0_0000_s10_w10  wbc_op0_0000_s10_w10 0 pwl(0 0 1.5000e-08 0 1.5100e-08 {VDD} 2.7000e-08 {VDD} 2.7100e-08 0)
swb_op0_0000_s10_w10 ref_op0_0000_s10_w10 wbl_op0_0000_s10_w10 wbc_op0_0000_s10_w10 0 swwbl
cwbl_op0_0000_s10_w10 wbl_op0_0000_s10_w10 0 {C_WBL}
spa_op0_0000_s10_w10 prea rbl_op0_0000_s10_w10 ctl 0 swpre
spr_op0_0000_s10_w10 pref ref_op0_0000_s10_w10 ctl 0 swpre
crbl_op0_0000_s10_w10 rbl_op0_0000_s10_w10 0 {C_RBL}
cref_op0_0000_s10_w10 ref_op0_0000_s10_w10 0 {C_RBL}   $ ASSUMPTION: ideal matched dummy load
XMWR_op0_0000_s10_w10_0 sn_op0_0000_s10_w10_0 wwl_op0_0000_s10_w10 wbl_op0_0000_s10_w10 0 sky130_fd_pr__nfet_01v8 L=0.15 W=0.42 nf=1 ad=0.1218 as=0.1218 pd=1.42 ps=1.42 nrd=0.69047619047619  nrs=0.69047619047619 sa=0 sb=0 sd=0 mult=1 m=1
XMRD_op0_0000_s10_w10_0 rbl_op0_0000_s10_w10 sn_op0_0000_s10_w10_0 rwls_op0_0000_s10_w10 0 sky130_fd_pr__nfet_01v8 L=0.15 W=0.42 nf=1 ad=0.1218 as=0.1218 pd=1.42 ps=1.42 nrd=0.69047619047619  nrs=0.69047619047619 sa=0 sb=0 sd=0 mult=1 m=1
csn_op0_0000_s10_w10_0 sn_op0_0000_s10_w10_0 0 {C_SN}
XMWR_op0_0000_s10_w10_1 sn_op0_0000_s10_w10_1 wwl_des wbl_op0_0000_s10_w10 0 sky130_fd_pr__nfet_01v8 L=0.15 W=0.42 nf=1 ad=0.1218 as=0.1218 pd=1.42 ps=1.42 nrd=0.69047619047619  nrs=0.69047619047619 sa=0 sb=0 sd=0 mult=1 m=1
XMRD_op0_0000_s10_w10_1 rbl_op0_0000_s10_w10 sn_op0_0000_s10_w10_1 rwl_des 0 sky130_fd_pr__nfet_01v8 L=0.15 W=0.42 nf=1 ad=0.1218 as=0.1218 pd=1.42 ps=1.42 nrd=0.69047619047619  nrs=0.69047619047619 sa=0 sb=0 sd=0 mult=1 m=1
csn_op0_0000_s10_w10_1 sn_op0_0000_s10_w10_1 0 {C_SN}
XMWR_op0_0000_s10_w10_2 sn_op0_0000_s10_w10_2 wwl_des wbl_op0_0000_s10_w10 0 sky130_fd_pr__nfet_01v8 L=0.15 W=0.42 nf=1 ad=0.1218 as=0.1218 pd=1.42 ps=1.42 nrd=0.69047619047619  nrs=0.69047619047619 sa=0 sb=0 sd=0 mult=1 m=1
XMRD_op0_0000_s10_w10_2 rbl_op0_0000_s10_w10 sn_op0_0000_s10_w10_2 rwl_des 0 sky130_fd_pr__nfet_01v8 L=0.15 W=0.42 nf=1 ad=0.1218 as=0.1218 pd=1.42 ps=1.42 nrd=0.69047619047619  nrs=0.69047619047619 sa=0 sb=0 sd=0 mult=1 m=1
csn_op0_0000_s10_w10_2 sn_op0_0000_s10_w10_2 0 {C_SN}
XMWR_op0_0000_s10_w10_3 sn_op0_0000_s10_w10_3 wwl_des wbl_op0_0000_s10_w10 0 sky130_fd_pr__nfet_01v8 L=0.15 W=0.42 nf=1 ad=0.1218 as=0.1218 pd=1.42 ps=1.42 nrd=0.69047619047619  nrs=0.69047619047619 sa=0 sb=0 sd=0 mult=1 m=1
XMRD_op0_0000_s10_w10_3 rbl_op0_0000_s10_w10 sn_op0_0000_s10_w10_3 rwl_des 0 sky130_fd_pr__nfet_01v8 L=0.15 W=0.42 nf=1 ad=0.1218 as=0.1218 pd=1.42 ps=1.42 nrd=0.69047619047619  nrs=0.69047619047619 sa=0 sb=0 sd=0 mult=1 m=1
csn_op0_0000_s10_w10_3 sn_op0_0000_s10_w10_3 0 {C_SN}
XMN1_op0_0000_s10_w10 rbl_op0_0000_s10_w10 ref_op0_0000_s10_w10 vn_op0_0000_s10_w10 0 sky130_fd_pr__nfet_01v8 L=0.15 W=1 nf=1 ad=0.29 as=0.29 pd=2.58 ps=2.58 mult=1 m=1
XMN2_op0_0000_s10_w10 ref_op0_0000_s10_w10 rbl_op0_0000_s10_w10 vn_op0_0000_s10_w10 0 sky130_fd_pr__nfet_01v8 L=0.15 W=1 nf=1 ad=0.29 as=0.29 pd=2.58 ps=2.58 mult=1 m=1
XMP1_op0_0000_s10_w10 rbl_op0_0000_s10_w10 ref_op0_0000_s10_w10 vp_op0_0000_s10_w10 vdd sky130_fd_pr__pfet_01v8 L=0.15 W=2 nf=1 ad=0.58 as=0.58 pd=4.58 ps=4.58 mult=1 m=1
XMP2_op0_0000_s10_w10 ref_op0_0000_s10_w10 rbl_op0_0000_s10_w10 vp_op0_0000_s10_w10 vdd sky130_fd_pr__pfet_01v8 L=0.15 W=2 nf=1 ad=0.58 as=0.58 pd=4.58 ps=4.58 mult=1 m=1
XMNF_op0_0000_s10_w10 vn_op0_0000_s10_w10 en_op0_0000_s10_w10 0 0 sky130_fd_pr__nfet_01v8 L=0.15 W=2 nf=1 ad=0.58 as=0.58 pd=4.58 ps=4.58 mult=1 m=1
XMPH_op0_0000_s10_w10 vp_op0_0000_s10_w10 enb_op0_0000_s10_w10 vdd vdd sky130_fd_pr__pfet_01v8 L=0.15 W=4 nf=1 ad=1.16 as=1.16 pd=8.58 ps=8.58 mult=1 m=1
bd_op0_0000_s10_w10 d_op0_0000_s10_w10 0 v=v(rbl_op0_0000_s10_w10)-v(ref_op0_0000_s10_w10)

* ---- instance 236: op0_0000_s10_w15 (t_en 14 ns, WWL 15..30 ns, release 32 ns) ----
ven_op0_0000_s10_w15  en_op0_0000_s10_w15  0 pwl(0 0 1.4000e-08 0 1.4100e-08 {VDD} 3.2000e-08 {VDD} 3.2100e-08 0)
venb_op0_0000_s10_w15 enb_op0_0000_s10_w15 0 pwl(0 {VDD} 1.4000e-08 {VDD} 1.4100e-08 0 3.2000e-08 0 3.2100e-08 {VDD})
vrs_op0_0000_s10_w15  rwls_op0_0000_s10_w15 0 pwl(0 {VDD} {T_READ} {VDD} {T_READ+TEDGE} 0 3.2000e-08 0 3.2100e-08 {VDD})
vww_op0_0000_s10_w15  wwl_op0_0000_s10_w15 0 pwl(0 0 1.5000e-08 0 1.5100e-08 {VDD} 3.0000e-08 {VDD} 3.0100e-08 0)
vwc_op0_0000_s10_w15  wbc_op0_0000_s10_w15 0 pwl(0 0 1.5000e-08 0 1.5100e-08 {VDD} 3.2000e-08 {VDD} 3.2100e-08 0)
swb_op0_0000_s10_w15 ref_op0_0000_s10_w15 wbl_op0_0000_s10_w15 wbc_op0_0000_s10_w15 0 swwbl
cwbl_op0_0000_s10_w15 wbl_op0_0000_s10_w15 0 {C_WBL}
spa_op0_0000_s10_w15 prea rbl_op0_0000_s10_w15 ctl 0 swpre
spr_op0_0000_s10_w15 pref ref_op0_0000_s10_w15 ctl 0 swpre
crbl_op0_0000_s10_w15 rbl_op0_0000_s10_w15 0 {C_RBL}
cref_op0_0000_s10_w15 ref_op0_0000_s10_w15 0 {C_RBL}   $ ASSUMPTION: ideal matched dummy load
XMWR_op0_0000_s10_w15_0 sn_op0_0000_s10_w15_0 wwl_op0_0000_s10_w15 wbl_op0_0000_s10_w15 0 sky130_fd_pr__nfet_01v8 L=0.15 W=0.42 nf=1 ad=0.1218 as=0.1218 pd=1.42 ps=1.42 nrd=0.69047619047619  nrs=0.69047619047619 sa=0 sb=0 sd=0 mult=1 m=1
XMRD_op0_0000_s10_w15_0 rbl_op0_0000_s10_w15 sn_op0_0000_s10_w15_0 rwls_op0_0000_s10_w15 0 sky130_fd_pr__nfet_01v8 L=0.15 W=0.42 nf=1 ad=0.1218 as=0.1218 pd=1.42 ps=1.42 nrd=0.69047619047619  nrs=0.69047619047619 sa=0 sb=0 sd=0 mult=1 m=1
csn_op0_0000_s10_w15_0 sn_op0_0000_s10_w15_0 0 {C_SN}
XMWR_op0_0000_s10_w15_1 sn_op0_0000_s10_w15_1 wwl_des wbl_op0_0000_s10_w15 0 sky130_fd_pr__nfet_01v8 L=0.15 W=0.42 nf=1 ad=0.1218 as=0.1218 pd=1.42 ps=1.42 nrd=0.69047619047619  nrs=0.69047619047619 sa=0 sb=0 sd=0 mult=1 m=1
XMRD_op0_0000_s10_w15_1 rbl_op0_0000_s10_w15 sn_op0_0000_s10_w15_1 rwl_des 0 sky130_fd_pr__nfet_01v8 L=0.15 W=0.42 nf=1 ad=0.1218 as=0.1218 pd=1.42 ps=1.42 nrd=0.69047619047619  nrs=0.69047619047619 sa=0 sb=0 sd=0 mult=1 m=1
csn_op0_0000_s10_w15_1 sn_op0_0000_s10_w15_1 0 {C_SN}
XMWR_op0_0000_s10_w15_2 sn_op0_0000_s10_w15_2 wwl_des wbl_op0_0000_s10_w15 0 sky130_fd_pr__nfet_01v8 L=0.15 W=0.42 nf=1 ad=0.1218 as=0.1218 pd=1.42 ps=1.42 nrd=0.69047619047619  nrs=0.69047619047619 sa=0 sb=0 sd=0 mult=1 m=1
XMRD_op0_0000_s10_w15_2 rbl_op0_0000_s10_w15 sn_op0_0000_s10_w15_2 rwl_des 0 sky130_fd_pr__nfet_01v8 L=0.15 W=0.42 nf=1 ad=0.1218 as=0.1218 pd=1.42 ps=1.42 nrd=0.69047619047619  nrs=0.69047619047619 sa=0 sb=0 sd=0 mult=1 m=1
csn_op0_0000_s10_w15_2 sn_op0_0000_s10_w15_2 0 {C_SN}
XMWR_op0_0000_s10_w15_3 sn_op0_0000_s10_w15_3 wwl_des wbl_op0_0000_s10_w15 0 sky130_fd_pr__nfet_01v8 L=0.15 W=0.42 nf=1 ad=0.1218 as=0.1218 pd=1.42 ps=1.42 nrd=0.69047619047619  nrs=0.69047619047619 sa=0 sb=0 sd=0 mult=1 m=1
XMRD_op0_0000_s10_w15_3 rbl_op0_0000_s10_w15 sn_op0_0000_s10_w15_3 rwl_des 0 sky130_fd_pr__nfet_01v8 L=0.15 W=0.42 nf=1 ad=0.1218 as=0.1218 pd=1.42 ps=1.42 nrd=0.69047619047619  nrs=0.69047619047619 sa=0 sb=0 sd=0 mult=1 m=1
csn_op0_0000_s10_w15_3 sn_op0_0000_s10_w15_3 0 {C_SN}
XMN1_op0_0000_s10_w15 rbl_op0_0000_s10_w15 ref_op0_0000_s10_w15 vn_op0_0000_s10_w15 0 sky130_fd_pr__nfet_01v8 L=0.15 W=1 nf=1 ad=0.29 as=0.29 pd=2.58 ps=2.58 mult=1 m=1
XMN2_op0_0000_s10_w15 ref_op0_0000_s10_w15 rbl_op0_0000_s10_w15 vn_op0_0000_s10_w15 0 sky130_fd_pr__nfet_01v8 L=0.15 W=1 nf=1 ad=0.29 as=0.29 pd=2.58 ps=2.58 mult=1 m=1
XMP1_op0_0000_s10_w15 rbl_op0_0000_s10_w15 ref_op0_0000_s10_w15 vp_op0_0000_s10_w15 vdd sky130_fd_pr__pfet_01v8 L=0.15 W=2 nf=1 ad=0.58 as=0.58 pd=4.58 ps=4.58 mult=1 m=1
XMP2_op0_0000_s10_w15 ref_op0_0000_s10_w15 rbl_op0_0000_s10_w15 vp_op0_0000_s10_w15 vdd sky130_fd_pr__pfet_01v8 L=0.15 W=2 nf=1 ad=0.58 as=0.58 pd=4.58 ps=4.58 mult=1 m=1
XMNF_op0_0000_s10_w15 vn_op0_0000_s10_w15 en_op0_0000_s10_w15 0 0 sky130_fd_pr__nfet_01v8 L=0.15 W=2 nf=1 ad=0.58 as=0.58 pd=4.58 ps=4.58 mult=1 m=1
XMPH_op0_0000_s10_w15 vp_op0_0000_s10_w15 enb_op0_0000_s10_w15 vdd vdd sky130_fd_pr__pfet_01v8 L=0.15 W=4 nf=1 ad=1.16 as=1.16 pd=8.58 ps=8.58 mult=1 m=1
bd_op0_0000_s10_w15 d_op0_0000_s10_w15 0 v=v(rbl_op0_0000_s10_w15)-v(ref_op0_0000_s10_w15)

* ---- instance 237: op0_0000_s10_w20 (t_en 14 ns, WWL 15..35 ns, release 37 ns) ----
ven_op0_0000_s10_w20  en_op0_0000_s10_w20  0 pwl(0 0 1.4000e-08 0 1.4100e-08 {VDD} 3.7000e-08 {VDD} 3.7100e-08 0)
venb_op0_0000_s10_w20 enb_op0_0000_s10_w20 0 pwl(0 {VDD} 1.4000e-08 {VDD} 1.4100e-08 0 3.7000e-08 0 3.7100e-08 {VDD})
vrs_op0_0000_s10_w20  rwls_op0_0000_s10_w20 0 pwl(0 {VDD} {T_READ} {VDD} {T_READ+TEDGE} 0 3.7000e-08 0 3.7100e-08 {VDD})
vww_op0_0000_s10_w20  wwl_op0_0000_s10_w20 0 pwl(0 0 1.5000e-08 0 1.5100e-08 {VDD} 3.5000e-08 {VDD} 3.5100e-08 0)
vwc_op0_0000_s10_w20  wbc_op0_0000_s10_w20 0 pwl(0 0 1.5000e-08 0 1.5100e-08 {VDD} 3.7000e-08 {VDD} 3.7100e-08 0)
swb_op0_0000_s10_w20 ref_op0_0000_s10_w20 wbl_op0_0000_s10_w20 wbc_op0_0000_s10_w20 0 swwbl
cwbl_op0_0000_s10_w20 wbl_op0_0000_s10_w20 0 {C_WBL}
spa_op0_0000_s10_w20 prea rbl_op0_0000_s10_w20 ctl 0 swpre
spr_op0_0000_s10_w20 pref ref_op0_0000_s10_w20 ctl 0 swpre
crbl_op0_0000_s10_w20 rbl_op0_0000_s10_w20 0 {C_RBL}
cref_op0_0000_s10_w20 ref_op0_0000_s10_w20 0 {C_RBL}   $ ASSUMPTION: ideal matched dummy load
XMWR_op0_0000_s10_w20_0 sn_op0_0000_s10_w20_0 wwl_op0_0000_s10_w20 wbl_op0_0000_s10_w20 0 sky130_fd_pr__nfet_01v8 L=0.15 W=0.42 nf=1 ad=0.1218 as=0.1218 pd=1.42 ps=1.42 nrd=0.69047619047619  nrs=0.69047619047619 sa=0 sb=0 sd=0 mult=1 m=1
XMRD_op0_0000_s10_w20_0 rbl_op0_0000_s10_w20 sn_op0_0000_s10_w20_0 rwls_op0_0000_s10_w20 0 sky130_fd_pr__nfet_01v8 L=0.15 W=0.42 nf=1 ad=0.1218 as=0.1218 pd=1.42 ps=1.42 nrd=0.69047619047619  nrs=0.69047619047619 sa=0 sb=0 sd=0 mult=1 m=1
csn_op0_0000_s10_w20_0 sn_op0_0000_s10_w20_0 0 {C_SN}
XMWR_op0_0000_s10_w20_1 sn_op0_0000_s10_w20_1 wwl_des wbl_op0_0000_s10_w20 0 sky130_fd_pr__nfet_01v8 L=0.15 W=0.42 nf=1 ad=0.1218 as=0.1218 pd=1.42 ps=1.42 nrd=0.69047619047619  nrs=0.69047619047619 sa=0 sb=0 sd=0 mult=1 m=1
XMRD_op0_0000_s10_w20_1 rbl_op0_0000_s10_w20 sn_op0_0000_s10_w20_1 rwl_des 0 sky130_fd_pr__nfet_01v8 L=0.15 W=0.42 nf=1 ad=0.1218 as=0.1218 pd=1.42 ps=1.42 nrd=0.69047619047619  nrs=0.69047619047619 sa=0 sb=0 sd=0 mult=1 m=1
csn_op0_0000_s10_w20_1 sn_op0_0000_s10_w20_1 0 {C_SN}
XMWR_op0_0000_s10_w20_2 sn_op0_0000_s10_w20_2 wwl_des wbl_op0_0000_s10_w20 0 sky130_fd_pr__nfet_01v8 L=0.15 W=0.42 nf=1 ad=0.1218 as=0.1218 pd=1.42 ps=1.42 nrd=0.69047619047619  nrs=0.69047619047619 sa=0 sb=0 sd=0 mult=1 m=1
XMRD_op0_0000_s10_w20_2 rbl_op0_0000_s10_w20 sn_op0_0000_s10_w20_2 rwl_des 0 sky130_fd_pr__nfet_01v8 L=0.15 W=0.42 nf=1 ad=0.1218 as=0.1218 pd=1.42 ps=1.42 nrd=0.69047619047619  nrs=0.69047619047619 sa=0 sb=0 sd=0 mult=1 m=1
csn_op0_0000_s10_w20_2 sn_op0_0000_s10_w20_2 0 {C_SN}
XMWR_op0_0000_s10_w20_3 sn_op0_0000_s10_w20_3 wwl_des wbl_op0_0000_s10_w20 0 sky130_fd_pr__nfet_01v8 L=0.15 W=0.42 nf=1 ad=0.1218 as=0.1218 pd=1.42 ps=1.42 nrd=0.69047619047619  nrs=0.69047619047619 sa=0 sb=0 sd=0 mult=1 m=1
XMRD_op0_0000_s10_w20_3 rbl_op0_0000_s10_w20 sn_op0_0000_s10_w20_3 rwl_des 0 sky130_fd_pr__nfet_01v8 L=0.15 W=0.42 nf=1 ad=0.1218 as=0.1218 pd=1.42 ps=1.42 nrd=0.69047619047619  nrs=0.69047619047619 sa=0 sb=0 sd=0 mult=1 m=1
csn_op0_0000_s10_w20_3 sn_op0_0000_s10_w20_3 0 {C_SN}
XMN1_op0_0000_s10_w20 rbl_op0_0000_s10_w20 ref_op0_0000_s10_w20 vn_op0_0000_s10_w20 0 sky130_fd_pr__nfet_01v8 L=0.15 W=1 nf=1 ad=0.29 as=0.29 pd=2.58 ps=2.58 mult=1 m=1
XMN2_op0_0000_s10_w20 ref_op0_0000_s10_w20 rbl_op0_0000_s10_w20 vn_op0_0000_s10_w20 0 sky130_fd_pr__nfet_01v8 L=0.15 W=1 nf=1 ad=0.29 as=0.29 pd=2.58 ps=2.58 mult=1 m=1
XMP1_op0_0000_s10_w20 rbl_op0_0000_s10_w20 ref_op0_0000_s10_w20 vp_op0_0000_s10_w20 vdd sky130_fd_pr__pfet_01v8 L=0.15 W=2 nf=1 ad=0.58 as=0.58 pd=4.58 ps=4.58 mult=1 m=1
XMP2_op0_0000_s10_w20 ref_op0_0000_s10_w20 rbl_op0_0000_s10_w20 vp_op0_0000_s10_w20 vdd sky130_fd_pr__pfet_01v8 L=0.15 W=2 nf=1 ad=0.58 as=0.58 pd=4.58 ps=4.58 mult=1 m=1
XMNF_op0_0000_s10_w20 vn_op0_0000_s10_w20 en_op0_0000_s10_w20 0 0 sky130_fd_pr__nfet_01v8 L=0.15 W=2 nf=1 ad=0.58 as=0.58 pd=4.58 ps=4.58 mult=1 m=1
XMPH_op0_0000_s10_w20 vp_op0_0000_s10_w20 enb_op0_0000_s10_w20 vdd vdd sky130_fd_pr__pfet_01v8 L=0.15 W=4 nf=1 ad=1.16 as=1.16 pd=8.58 ps=8.58 mult=1 m=1
bd_op0_0000_s10_w20 d_op0_0000_s10_w20 0 v=v(rbl_op0_0000_s10_w20)-v(ref_op0_0000_s10_w20)

* ---- instance 238: op0_0000_s10_w30 (t_en 14 ns, WWL 15..45 ns, release 47 ns) ----
ven_op0_0000_s10_w30  en_op0_0000_s10_w30  0 pwl(0 0 1.4000e-08 0 1.4100e-08 {VDD} 4.7000e-08 {VDD} 4.7100e-08 0)
venb_op0_0000_s10_w30 enb_op0_0000_s10_w30 0 pwl(0 {VDD} 1.4000e-08 {VDD} 1.4100e-08 0 4.7000e-08 0 4.7100e-08 {VDD})
vrs_op0_0000_s10_w30  rwls_op0_0000_s10_w30 0 pwl(0 {VDD} {T_READ} {VDD} {T_READ+TEDGE} 0 4.7000e-08 0 4.7100e-08 {VDD})
vww_op0_0000_s10_w30  wwl_op0_0000_s10_w30 0 pwl(0 0 1.5000e-08 0 1.5100e-08 {VDD} 4.5000e-08 {VDD} 4.5100e-08 0)
vwc_op0_0000_s10_w30  wbc_op0_0000_s10_w30 0 pwl(0 0 1.5000e-08 0 1.5100e-08 {VDD} 4.7000e-08 {VDD} 4.7100e-08 0)
swb_op0_0000_s10_w30 ref_op0_0000_s10_w30 wbl_op0_0000_s10_w30 wbc_op0_0000_s10_w30 0 swwbl
cwbl_op0_0000_s10_w30 wbl_op0_0000_s10_w30 0 {C_WBL}
spa_op0_0000_s10_w30 prea rbl_op0_0000_s10_w30 ctl 0 swpre
spr_op0_0000_s10_w30 pref ref_op0_0000_s10_w30 ctl 0 swpre
crbl_op0_0000_s10_w30 rbl_op0_0000_s10_w30 0 {C_RBL}
cref_op0_0000_s10_w30 ref_op0_0000_s10_w30 0 {C_RBL}   $ ASSUMPTION: ideal matched dummy load
XMWR_op0_0000_s10_w30_0 sn_op0_0000_s10_w30_0 wwl_op0_0000_s10_w30 wbl_op0_0000_s10_w30 0 sky130_fd_pr__nfet_01v8 L=0.15 W=0.42 nf=1 ad=0.1218 as=0.1218 pd=1.42 ps=1.42 nrd=0.69047619047619  nrs=0.69047619047619 sa=0 sb=0 sd=0 mult=1 m=1
XMRD_op0_0000_s10_w30_0 rbl_op0_0000_s10_w30 sn_op0_0000_s10_w30_0 rwls_op0_0000_s10_w30 0 sky130_fd_pr__nfet_01v8 L=0.15 W=0.42 nf=1 ad=0.1218 as=0.1218 pd=1.42 ps=1.42 nrd=0.69047619047619  nrs=0.69047619047619 sa=0 sb=0 sd=0 mult=1 m=1
csn_op0_0000_s10_w30_0 sn_op0_0000_s10_w30_0 0 {C_SN}
XMWR_op0_0000_s10_w30_1 sn_op0_0000_s10_w30_1 wwl_des wbl_op0_0000_s10_w30 0 sky130_fd_pr__nfet_01v8 L=0.15 W=0.42 nf=1 ad=0.1218 as=0.1218 pd=1.42 ps=1.42 nrd=0.69047619047619  nrs=0.69047619047619 sa=0 sb=0 sd=0 mult=1 m=1
XMRD_op0_0000_s10_w30_1 rbl_op0_0000_s10_w30 sn_op0_0000_s10_w30_1 rwl_des 0 sky130_fd_pr__nfet_01v8 L=0.15 W=0.42 nf=1 ad=0.1218 as=0.1218 pd=1.42 ps=1.42 nrd=0.69047619047619  nrs=0.69047619047619 sa=0 sb=0 sd=0 mult=1 m=1
csn_op0_0000_s10_w30_1 sn_op0_0000_s10_w30_1 0 {C_SN}
XMWR_op0_0000_s10_w30_2 sn_op0_0000_s10_w30_2 wwl_des wbl_op0_0000_s10_w30 0 sky130_fd_pr__nfet_01v8 L=0.15 W=0.42 nf=1 ad=0.1218 as=0.1218 pd=1.42 ps=1.42 nrd=0.69047619047619  nrs=0.69047619047619 sa=0 sb=0 sd=0 mult=1 m=1
XMRD_op0_0000_s10_w30_2 rbl_op0_0000_s10_w30 sn_op0_0000_s10_w30_2 rwl_des 0 sky130_fd_pr__nfet_01v8 L=0.15 W=0.42 nf=1 ad=0.1218 as=0.1218 pd=1.42 ps=1.42 nrd=0.69047619047619  nrs=0.69047619047619 sa=0 sb=0 sd=0 mult=1 m=1
csn_op0_0000_s10_w30_2 sn_op0_0000_s10_w30_2 0 {C_SN}
XMWR_op0_0000_s10_w30_3 sn_op0_0000_s10_w30_3 wwl_des wbl_op0_0000_s10_w30 0 sky130_fd_pr__nfet_01v8 L=0.15 W=0.42 nf=1 ad=0.1218 as=0.1218 pd=1.42 ps=1.42 nrd=0.69047619047619  nrs=0.69047619047619 sa=0 sb=0 sd=0 mult=1 m=1
XMRD_op0_0000_s10_w30_3 rbl_op0_0000_s10_w30 sn_op0_0000_s10_w30_3 rwl_des 0 sky130_fd_pr__nfet_01v8 L=0.15 W=0.42 nf=1 ad=0.1218 as=0.1218 pd=1.42 ps=1.42 nrd=0.69047619047619  nrs=0.69047619047619 sa=0 sb=0 sd=0 mult=1 m=1
csn_op0_0000_s10_w30_3 sn_op0_0000_s10_w30_3 0 {C_SN}
XMN1_op0_0000_s10_w30 rbl_op0_0000_s10_w30 ref_op0_0000_s10_w30 vn_op0_0000_s10_w30 0 sky130_fd_pr__nfet_01v8 L=0.15 W=1 nf=1 ad=0.29 as=0.29 pd=2.58 ps=2.58 mult=1 m=1
XMN2_op0_0000_s10_w30 ref_op0_0000_s10_w30 rbl_op0_0000_s10_w30 vn_op0_0000_s10_w30 0 sky130_fd_pr__nfet_01v8 L=0.15 W=1 nf=1 ad=0.29 as=0.29 pd=2.58 ps=2.58 mult=1 m=1
XMP1_op0_0000_s10_w30 rbl_op0_0000_s10_w30 ref_op0_0000_s10_w30 vp_op0_0000_s10_w30 vdd sky130_fd_pr__pfet_01v8 L=0.15 W=2 nf=1 ad=0.58 as=0.58 pd=4.58 ps=4.58 mult=1 m=1
XMP2_op0_0000_s10_w30 ref_op0_0000_s10_w30 rbl_op0_0000_s10_w30 vp_op0_0000_s10_w30 vdd sky130_fd_pr__pfet_01v8 L=0.15 W=2 nf=1 ad=0.58 as=0.58 pd=4.58 ps=4.58 mult=1 m=1
XMNF_op0_0000_s10_w30 vn_op0_0000_s10_w30 en_op0_0000_s10_w30 0 0 sky130_fd_pr__nfet_01v8 L=0.15 W=2 nf=1 ad=0.58 as=0.58 pd=4.58 ps=4.58 mult=1 m=1
XMPH_op0_0000_s10_w30 vp_op0_0000_s10_w30 enb_op0_0000_s10_w30 vdd vdd sky130_fd_pr__pfet_01v8 L=0.15 W=4 nf=1 ad=1.16 as=1.16 pd=8.58 ps=8.58 mult=1 m=1
bd_op0_0000_s10_w30 d_op0_0000_s10_w30 0 v=v(rbl_op0_0000_s10_w30)-v(ref_op0_0000_s10_w30)

* ---- instance 239: op0_0000_s10_w50 (t_en 14 ns, WWL 15..65 ns, release 67 ns) ----
ven_op0_0000_s10_w50  en_op0_0000_s10_w50  0 pwl(0 0 1.4000e-08 0 1.4100e-08 {VDD} 6.7000e-08 {VDD} 6.7100e-08 0)
venb_op0_0000_s10_w50 enb_op0_0000_s10_w50 0 pwl(0 {VDD} 1.4000e-08 {VDD} 1.4100e-08 0 6.7000e-08 0 6.7100e-08 {VDD})
vrs_op0_0000_s10_w50  rwls_op0_0000_s10_w50 0 pwl(0 {VDD} {T_READ} {VDD} {T_READ+TEDGE} 0 6.7000e-08 0 6.7100e-08 {VDD})
vww_op0_0000_s10_w50  wwl_op0_0000_s10_w50 0 pwl(0 0 1.5000e-08 0 1.5100e-08 {VDD} 6.5000e-08 {VDD} 6.5100e-08 0)
vwc_op0_0000_s10_w50  wbc_op0_0000_s10_w50 0 pwl(0 0 1.5000e-08 0 1.5100e-08 {VDD} 6.7000e-08 {VDD} 6.7100e-08 0)
swb_op0_0000_s10_w50 ref_op0_0000_s10_w50 wbl_op0_0000_s10_w50 wbc_op0_0000_s10_w50 0 swwbl
cwbl_op0_0000_s10_w50 wbl_op0_0000_s10_w50 0 {C_WBL}
spa_op0_0000_s10_w50 prea rbl_op0_0000_s10_w50 ctl 0 swpre
spr_op0_0000_s10_w50 pref ref_op0_0000_s10_w50 ctl 0 swpre
crbl_op0_0000_s10_w50 rbl_op0_0000_s10_w50 0 {C_RBL}
cref_op0_0000_s10_w50 ref_op0_0000_s10_w50 0 {C_RBL}   $ ASSUMPTION: ideal matched dummy load
XMWR_op0_0000_s10_w50_0 sn_op0_0000_s10_w50_0 wwl_op0_0000_s10_w50 wbl_op0_0000_s10_w50 0 sky130_fd_pr__nfet_01v8 L=0.15 W=0.42 nf=1 ad=0.1218 as=0.1218 pd=1.42 ps=1.42 nrd=0.69047619047619  nrs=0.69047619047619 sa=0 sb=0 sd=0 mult=1 m=1
XMRD_op0_0000_s10_w50_0 rbl_op0_0000_s10_w50 sn_op0_0000_s10_w50_0 rwls_op0_0000_s10_w50 0 sky130_fd_pr__nfet_01v8 L=0.15 W=0.42 nf=1 ad=0.1218 as=0.1218 pd=1.42 ps=1.42 nrd=0.69047619047619  nrs=0.69047619047619 sa=0 sb=0 sd=0 mult=1 m=1
csn_op0_0000_s10_w50_0 sn_op0_0000_s10_w50_0 0 {C_SN}
XMWR_op0_0000_s10_w50_1 sn_op0_0000_s10_w50_1 wwl_des wbl_op0_0000_s10_w50 0 sky130_fd_pr__nfet_01v8 L=0.15 W=0.42 nf=1 ad=0.1218 as=0.1218 pd=1.42 ps=1.42 nrd=0.69047619047619  nrs=0.69047619047619 sa=0 sb=0 sd=0 mult=1 m=1
XMRD_op0_0000_s10_w50_1 rbl_op0_0000_s10_w50 sn_op0_0000_s10_w50_1 rwl_des 0 sky130_fd_pr__nfet_01v8 L=0.15 W=0.42 nf=1 ad=0.1218 as=0.1218 pd=1.42 ps=1.42 nrd=0.69047619047619  nrs=0.69047619047619 sa=0 sb=0 sd=0 mult=1 m=1
csn_op0_0000_s10_w50_1 sn_op0_0000_s10_w50_1 0 {C_SN}
XMWR_op0_0000_s10_w50_2 sn_op0_0000_s10_w50_2 wwl_des wbl_op0_0000_s10_w50 0 sky130_fd_pr__nfet_01v8 L=0.15 W=0.42 nf=1 ad=0.1218 as=0.1218 pd=1.42 ps=1.42 nrd=0.69047619047619  nrs=0.69047619047619 sa=0 sb=0 sd=0 mult=1 m=1
XMRD_op0_0000_s10_w50_2 rbl_op0_0000_s10_w50 sn_op0_0000_s10_w50_2 rwl_des 0 sky130_fd_pr__nfet_01v8 L=0.15 W=0.42 nf=1 ad=0.1218 as=0.1218 pd=1.42 ps=1.42 nrd=0.69047619047619  nrs=0.69047619047619 sa=0 sb=0 sd=0 mult=1 m=1
csn_op0_0000_s10_w50_2 sn_op0_0000_s10_w50_2 0 {C_SN}
XMWR_op0_0000_s10_w50_3 sn_op0_0000_s10_w50_3 wwl_des wbl_op0_0000_s10_w50 0 sky130_fd_pr__nfet_01v8 L=0.15 W=0.42 nf=1 ad=0.1218 as=0.1218 pd=1.42 ps=1.42 nrd=0.69047619047619  nrs=0.69047619047619 sa=0 sb=0 sd=0 mult=1 m=1
XMRD_op0_0000_s10_w50_3 rbl_op0_0000_s10_w50 sn_op0_0000_s10_w50_3 rwl_des 0 sky130_fd_pr__nfet_01v8 L=0.15 W=0.42 nf=1 ad=0.1218 as=0.1218 pd=1.42 ps=1.42 nrd=0.69047619047619  nrs=0.69047619047619 sa=0 sb=0 sd=0 mult=1 m=1
csn_op0_0000_s10_w50_3 sn_op0_0000_s10_w50_3 0 {C_SN}
XMN1_op0_0000_s10_w50 rbl_op0_0000_s10_w50 ref_op0_0000_s10_w50 vn_op0_0000_s10_w50 0 sky130_fd_pr__nfet_01v8 L=0.15 W=1 nf=1 ad=0.29 as=0.29 pd=2.58 ps=2.58 mult=1 m=1
XMN2_op0_0000_s10_w50 ref_op0_0000_s10_w50 rbl_op0_0000_s10_w50 vn_op0_0000_s10_w50 0 sky130_fd_pr__nfet_01v8 L=0.15 W=1 nf=1 ad=0.29 as=0.29 pd=2.58 ps=2.58 mult=1 m=1
XMP1_op0_0000_s10_w50 rbl_op0_0000_s10_w50 ref_op0_0000_s10_w50 vp_op0_0000_s10_w50 vdd sky130_fd_pr__pfet_01v8 L=0.15 W=2 nf=1 ad=0.58 as=0.58 pd=4.58 ps=4.58 mult=1 m=1
XMP2_op0_0000_s10_w50 ref_op0_0000_s10_w50 rbl_op0_0000_s10_w50 vp_op0_0000_s10_w50 vdd sky130_fd_pr__pfet_01v8 L=0.15 W=2 nf=1 ad=0.58 as=0.58 pd=4.58 ps=4.58 mult=1 m=1
XMNF_op0_0000_s10_w50 vn_op0_0000_s10_w50 en_op0_0000_s10_w50 0 0 sky130_fd_pr__nfet_01v8 L=0.15 W=2 nf=1 ad=0.58 as=0.58 pd=4.58 ps=4.58 mult=1 m=1
XMPH_op0_0000_s10_w50 vp_op0_0000_s10_w50 enb_op0_0000_s10_w50 vdd vdd sky130_fd_pr__pfet_01v8 L=0.15 W=4 nf=1 ad=1.16 as=1.16 pd=8.58 ps=8.58 mult=1 m=1
bd_op0_0000_s10_w50 d_op0_0000_s10_w50 0 v=v(rbl_op0_0000_s10_w50)-v(ref_op0_0000_s10_w50)

* ---- instance 240: refw (t_en 14 ns, WWL 15..35 ns, release 37 ns) ----
ven_refw  en_refw  0 pwl(0 0 1.4000e-08 0 1.4100e-08 {VDD} 3.7000e-08 {VDD} 3.7100e-08 0)
venb_refw enb_refw 0 pwl(0 {VDD} 1.4000e-08 {VDD} 1.4100e-08 0 3.7000e-08 0 3.7100e-08 {VDD})
vrs_refw  rwls_refw 0 pwl(0 {VDD} {T_READ} {VDD} {T_READ+TEDGE} 0 3.7000e-08 0 3.7100e-08 {VDD})
vww_refw  wwl_refw 0 pwl(0 0 1.5000e-08 0 1.5100e-08 {VDD} 3.5000e-08 {VDD} 3.5100e-08 0)
vwc_refw  wbc_refw 0 pwl(0 0 1.5000e-08 0 1.5100e-08 {VDD} 3.7000e-08 {VDD} 3.7100e-08 0)
* reference write: ideal 1.8 V WBL; rbl/ref/latch idle (no read)
vwbr_refw wbl_refw 0 dc {VDD}
cwbl_refw wbl_refw 0 {C_WBL}
spa_refw prea rbl_refw ctl 0 swpre
spr_refw pref ref_refw ctl 0 swpre
crbl_refw rbl_refw 0 {C_RBL}
cref_refw ref_refw 0 {C_RBL}   $ ASSUMPTION: ideal matched dummy load
XMWR_refw_0 sn_refw_0 wwl_refw wbl_refw 0 sky130_fd_pr__nfet_01v8 L=0.15 W=0.42 nf=1 ad=0.1218 as=0.1218 pd=1.42 ps=1.42 nrd=0.69047619047619  nrs=0.69047619047619 sa=0 sb=0 sd=0 mult=1 m=1
XMRD_refw_0 rbl_refw sn_refw_0 rwls_refw 0 sky130_fd_pr__nfet_01v8 L=0.15 W=0.42 nf=1 ad=0.1218 as=0.1218 pd=1.42 ps=1.42 nrd=0.69047619047619  nrs=0.69047619047619 sa=0 sb=0 sd=0 mult=1 m=1
csn_refw_0 sn_refw_0 0 {C_SN}
XMWR_refw_1 sn_refw_1 wwl_des wbl_refw 0 sky130_fd_pr__nfet_01v8 L=0.15 W=0.42 nf=1 ad=0.1218 as=0.1218 pd=1.42 ps=1.42 nrd=0.69047619047619  nrs=0.69047619047619 sa=0 sb=0 sd=0 mult=1 m=1
XMRD_refw_1 rbl_refw sn_refw_1 rwl_des 0 sky130_fd_pr__nfet_01v8 L=0.15 W=0.42 nf=1 ad=0.1218 as=0.1218 pd=1.42 ps=1.42 nrd=0.69047619047619  nrs=0.69047619047619 sa=0 sb=0 sd=0 mult=1 m=1
csn_refw_1 sn_refw_1 0 {C_SN}
XMWR_refw_2 sn_refw_2 wwl_des wbl_refw 0 sky130_fd_pr__nfet_01v8 L=0.15 W=0.42 nf=1 ad=0.1218 as=0.1218 pd=1.42 ps=1.42 nrd=0.69047619047619  nrs=0.69047619047619 sa=0 sb=0 sd=0 mult=1 m=1
XMRD_refw_2 rbl_refw sn_refw_2 rwl_des 0 sky130_fd_pr__nfet_01v8 L=0.15 W=0.42 nf=1 ad=0.1218 as=0.1218 pd=1.42 ps=1.42 nrd=0.69047619047619  nrs=0.69047619047619 sa=0 sb=0 sd=0 mult=1 m=1
csn_refw_2 sn_refw_2 0 {C_SN}
XMWR_refw_3 sn_refw_3 wwl_des wbl_refw 0 sky130_fd_pr__nfet_01v8 L=0.15 W=0.42 nf=1 ad=0.1218 as=0.1218 pd=1.42 ps=1.42 nrd=0.69047619047619  nrs=0.69047619047619 sa=0 sb=0 sd=0 mult=1 m=1
XMRD_refw_3 rbl_refw sn_refw_3 rwl_des 0 sky130_fd_pr__nfet_01v8 L=0.15 W=0.42 nf=1 ad=0.1218 as=0.1218 pd=1.42 ps=1.42 nrd=0.69047619047619  nrs=0.69047619047619 sa=0 sb=0 sd=0 mult=1 m=1
csn_refw_3 sn_refw_3 0 {C_SN}
XMN1_refw rbl_refw ref_refw vn_refw 0 sky130_fd_pr__nfet_01v8 L=0.15 W=1 nf=1 ad=0.29 as=0.29 pd=2.58 ps=2.58 mult=1 m=1
XMN2_refw ref_refw rbl_refw vn_refw 0 sky130_fd_pr__nfet_01v8 L=0.15 W=1 nf=1 ad=0.29 as=0.29 pd=2.58 ps=2.58 mult=1 m=1
XMP1_refw rbl_refw ref_refw vp_refw vdd sky130_fd_pr__pfet_01v8 L=0.15 W=2 nf=1 ad=0.58 as=0.58 pd=4.58 ps=4.58 mult=1 m=1
XMP2_refw ref_refw rbl_refw vp_refw vdd sky130_fd_pr__pfet_01v8 L=0.15 W=2 nf=1 ad=0.58 as=0.58 pd=4.58 ps=4.58 mult=1 m=1
XMNF_refw vn_refw en_refw 0 0 sky130_fd_pr__nfet_01v8 L=0.15 W=2 nf=1 ad=0.58 as=0.58 pd=4.58 ps=4.58 mult=1 m=1
XMPH_refw vp_refw enb_refw vdd vdd sky130_fd_pr__pfet_01v8 L=0.15 W=4 nf=1 ad=1.16 as=1.16 pd=8.58 ps=8.58 mult=1 m=1
bd_refw d_refw 0 v=v(rbl_refw)-v(ref_refw)

* initial conditions (tran uic)
.ic v(wbl_op1_0900_s0p5_w0p2)=0 v(rbl_op1_0900_s0p5_w0p2)=1.8 v(ref_op1_0900_s0p5_w0p2)=0 v(sn_op1_0900_s0p5_w0p2_0)=0.9 v(sn_op1_0900_s0p5_w0p2_1)=0.9 v(sn_op1_0900_s0p5_w0p2_2)=0.9
.ic v(sn_op1_0900_s0p5_w0p2_3)=0.9 v(vn_op1_0900_s0p5_w0p2)=0.45 v(vp_op1_0900_s0p5_w0p2)=1.35 v(wbl_op1_0900_s0p5_w0p5)=0 v(rbl_op1_0900_s0p5_w0p5)=1.8 v(ref_op1_0900_s0p5_w0p5)=0
.ic v(sn_op1_0900_s0p5_w0p5_0)=0.9 v(sn_op1_0900_s0p5_w0p5_1)=0.9 v(sn_op1_0900_s0p5_w0p5_2)=0.9 v(sn_op1_0900_s0p5_w0p5_3)=0.9 v(vn_op1_0900_s0p5_w0p5)=0.45 v(vp_op1_0900_s0p5_w0p5)=1.35
.ic v(wbl_op1_0900_s0p5_w1)=0 v(rbl_op1_0900_s0p5_w1)=1.8 v(ref_op1_0900_s0p5_w1)=0 v(sn_op1_0900_s0p5_w1_0)=0.9 v(sn_op1_0900_s0p5_w1_1)=0.9 v(sn_op1_0900_s0p5_w1_2)=0.9
.ic v(sn_op1_0900_s0p5_w1_3)=0.9 v(vn_op1_0900_s0p5_w1)=0.45 v(vp_op1_0900_s0p5_w1)=1.35 v(wbl_op1_0900_s0p5_w2)=0 v(rbl_op1_0900_s0p5_w2)=1.8 v(ref_op1_0900_s0p5_w2)=0
.ic v(sn_op1_0900_s0p5_w2_0)=0.9 v(sn_op1_0900_s0p5_w2_1)=0.9 v(sn_op1_0900_s0p5_w2_2)=0.9 v(sn_op1_0900_s0p5_w2_3)=0.9 v(vn_op1_0900_s0p5_w2)=0.45 v(vp_op1_0900_s0p5_w2)=1.35
.ic v(wbl_op1_0900_s0p5_w3)=0 v(rbl_op1_0900_s0p5_w3)=1.8 v(ref_op1_0900_s0p5_w3)=0 v(sn_op1_0900_s0p5_w3_0)=0.9 v(sn_op1_0900_s0p5_w3_1)=0.9 v(sn_op1_0900_s0p5_w3_2)=0.9
.ic v(sn_op1_0900_s0p5_w3_3)=0.9 v(vn_op1_0900_s0p5_w3)=0.45 v(vp_op1_0900_s0p5_w3)=1.35 v(wbl_op1_0900_s0p5_w5)=0 v(rbl_op1_0900_s0p5_w5)=1.8 v(ref_op1_0900_s0p5_w5)=0
.ic v(sn_op1_0900_s0p5_w5_0)=0.9 v(sn_op1_0900_s0p5_w5_1)=0.9 v(sn_op1_0900_s0p5_w5_2)=0.9 v(sn_op1_0900_s0p5_w5_3)=0.9 v(vn_op1_0900_s0p5_w5)=0.45 v(vp_op1_0900_s0p5_w5)=1.35
.ic v(wbl_op1_0900_s0p5_w7p5)=0 v(rbl_op1_0900_s0p5_w7p5)=1.8 v(ref_op1_0900_s0p5_w7p5)=0 v(sn_op1_0900_s0p5_w7p5_0)=0.9 v(sn_op1_0900_s0p5_w7p5_1)=0.9 v(sn_op1_0900_s0p5_w7p5_2)=0.9
.ic v(sn_op1_0900_s0p5_w7p5_3)=0.9 v(vn_op1_0900_s0p5_w7p5)=0.45 v(vp_op1_0900_s0p5_w7p5)=1.35 v(wbl_op1_0900_s0p5_w10)=0 v(rbl_op1_0900_s0p5_w10)=1.8 v(ref_op1_0900_s0p5_w10)=0
.ic v(sn_op1_0900_s0p5_w10_0)=0.9 v(sn_op1_0900_s0p5_w10_1)=0.9 v(sn_op1_0900_s0p5_w10_2)=0.9 v(sn_op1_0900_s0p5_w10_3)=0.9 v(vn_op1_0900_s0p5_w10)=0.45 v(vp_op1_0900_s0p5_w10)=1.35
.ic v(wbl_op1_0900_s0p5_w15)=0 v(rbl_op1_0900_s0p5_w15)=1.8 v(ref_op1_0900_s0p5_w15)=0 v(sn_op1_0900_s0p5_w15_0)=0.9 v(sn_op1_0900_s0p5_w15_1)=0.9 v(sn_op1_0900_s0p5_w15_2)=0.9
.ic v(sn_op1_0900_s0p5_w15_3)=0.9 v(vn_op1_0900_s0p5_w15)=0.45 v(vp_op1_0900_s0p5_w15)=1.35 v(wbl_op1_0900_s0p5_w20)=0 v(rbl_op1_0900_s0p5_w20)=1.8 v(ref_op1_0900_s0p5_w20)=0
.ic v(sn_op1_0900_s0p5_w20_0)=0.9 v(sn_op1_0900_s0p5_w20_1)=0.9 v(sn_op1_0900_s0p5_w20_2)=0.9 v(sn_op1_0900_s0p5_w20_3)=0.9 v(vn_op1_0900_s0p5_w20)=0.45 v(vp_op1_0900_s0p5_w20)=1.35
.ic v(wbl_op1_0900_s0p5_w30)=0 v(rbl_op1_0900_s0p5_w30)=1.8 v(ref_op1_0900_s0p5_w30)=0 v(sn_op1_0900_s0p5_w30_0)=0.9 v(sn_op1_0900_s0p5_w30_1)=0.9 v(sn_op1_0900_s0p5_w30_2)=0.9
.ic v(sn_op1_0900_s0p5_w30_3)=0.9 v(vn_op1_0900_s0p5_w30)=0.45 v(vp_op1_0900_s0p5_w30)=1.35 v(wbl_op1_0900_s0p5_w50)=0 v(rbl_op1_0900_s0p5_w50)=1.8 v(ref_op1_0900_s0p5_w50)=0
.ic v(sn_op1_0900_s0p5_w50_0)=0.9 v(sn_op1_0900_s0p5_w50_1)=0.9 v(sn_op1_0900_s0p5_w50_2)=0.9 v(sn_op1_0900_s0p5_w50_3)=0.9 v(vn_op1_0900_s0p5_w50)=0.45 v(vp_op1_0900_s0p5_w50)=1.35
.ic v(wbl_op1_0900_s1_w0p2)=0 v(rbl_op1_0900_s1_w0p2)=1.8 v(ref_op1_0900_s1_w0p2)=0 v(sn_op1_0900_s1_w0p2_0)=0.9 v(sn_op1_0900_s1_w0p2_1)=0.9 v(sn_op1_0900_s1_w0p2_2)=0.9
.ic v(sn_op1_0900_s1_w0p2_3)=0.9 v(vn_op1_0900_s1_w0p2)=0.45 v(vp_op1_0900_s1_w0p2)=1.35 v(wbl_op1_0900_s1_w0p5)=0 v(rbl_op1_0900_s1_w0p5)=1.8 v(ref_op1_0900_s1_w0p5)=0
.ic v(sn_op1_0900_s1_w0p5_0)=0.9 v(sn_op1_0900_s1_w0p5_1)=0.9 v(sn_op1_0900_s1_w0p5_2)=0.9 v(sn_op1_0900_s1_w0p5_3)=0.9 v(vn_op1_0900_s1_w0p5)=0.45 v(vp_op1_0900_s1_w0p5)=1.35
.ic v(wbl_op1_0900_s1_w1)=0 v(rbl_op1_0900_s1_w1)=1.8 v(ref_op1_0900_s1_w1)=0 v(sn_op1_0900_s1_w1_0)=0.9 v(sn_op1_0900_s1_w1_1)=0.9 v(sn_op1_0900_s1_w1_2)=0.9
.ic v(sn_op1_0900_s1_w1_3)=0.9 v(vn_op1_0900_s1_w1)=0.45 v(vp_op1_0900_s1_w1)=1.35 v(wbl_op1_0900_s1_w2)=0 v(rbl_op1_0900_s1_w2)=1.8 v(ref_op1_0900_s1_w2)=0
.ic v(sn_op1_0900_s1_w2_0)=0.9 v(sn_op1_0900_s1_w2_1)=0.9 v(sn_op1_0900_s1_w2_2)=0.9 v(sn_op1_0900_s1_w2_3)=0.9 v(vn_op1_0900_s1_w2)=0.45 v(vp_op1_0900_s1_w2)=1.35
.ic v(wbl_op1_0900_s1_w3)=0 v(rbl_op1_0900_s1_w3)=1.8 v(ref_op1_0900_s1_w3)=0 v(sn_op1_0900_s1_w3_0)=0.9 v(sn_op1_0900_s1_w3_1)=0.9 v(sn_op1_0900_s1_w3_2)=0.9
.ic v(sn_op1_0900_s1_w3_3)=0.9 v(vn_op1_0900_s1_w3)=0.45 v(vp_op1_0900_s1_w3)=1.35 v(wbl_op1_0900_s1_w5)=0 v(rbl_op1_0900_s1_w5)=1.8 v(ref_op1_0900_s1_w5)=0
.ic v(sn_op1_0900_s1_w5_0)=0.9 v(sn_op1_0900_s1_w5_1)=0.9 v(sn_op1_0900_s1_w5_2)=0.9 v(sn_op1_0900_s1_w5_3)=0.9 v(vn_op1_0900_s1_w5)=0.45 v(vp_op1_0900_s1_w5)=1.35
.ic v(wbl_op1_0900_s1_w7p5)=0 v(rbl_op1_0900_s1_w7p5)=1.8 v(ref_op1_0900_s1_w7p5)=0 v(sn_op1_0900_s1_w7p5_0)=0.9 v(sn_op1_0900_s1_w7p5_1)=0.9 v(sn_op1_0900_s1_w7p5_2)=0.9
.ic v(sn_op1_0900_s1_w7p5_3)=0.9 v(vn_op1_0900_s1_w7p5)=0.45 v(vp_op1_0900_s1_w7p5)=1.35 v(wbl_op1_0900_s1_w10)=0 v(rbl_op1_0900_s1_w10)=1.8 v(ref_op1_0900_s1_w10)=0
.ic v(sn_op1_0900_s1_w10_0)=0.9 v(sn_op1_0900_s1_w10_1)=0.9 v(sn_op1_0900_s1_w10_2)=0.9 v(sn_op1_0900_s1_w10_3)=0.9 v(vn_op1_0900_s1_w10)=0.45 v(vp_op1_0900_s1_w10)=1.35
.ic v(wbl_op1_0900_s1_w15)=0 v(rbl_op1_0900_s1_w15)=1.8 v(ref_op1_0900_s1_w15)=0 v(sn_op1_0900_s1_w15_0)=0.9 v(sn_op1_0900_s1_w15_1)=0.9 v(sn_op1_0900_s1_w15_2)=0.9
.ic v(sn_op1_0900_s1_w15_3)=0.9 v(vn_op1_0900_s1_w15)=0.45 v(vp_op1_0900_s1_w15)=1.35 v(wbl_op1_0900_s1_w20)=0 v(rbl_op1_0900_s1_w20)=1.8 v(ref_op1_0900_s1_w20)=0
.ic v(sn_op1_0900_s1_w20_0)=0.9 v(sn_op1_0900_s1_w20_1)=0.9 v(sn_op1_0900_s1_w20_2)=0.9 v(sn_op1_0900_s1_w20_3)=0.9 v(vn_op1_0900_s1_w20)=0.45 v(vp_op1_0900_s1_w20)=1.35
.ic v(wbl_op1_0900_s1_w30)=0 v(rbl_op1_0900_s1_w30)=1.8 v(ref_op1_0900_s1_w30)=0 v(sn_op1_0900_s1_w30_0)=0.9 v(sn_op1_0900_s1_w30_1)=0.9 v(sn_op1_0900_s1_w30_2)=0.9
.ic v(sn_op1_0900_s1_w30_3)=0.9 v(vn_op1_0900_s1_w30)=0.45 v(vp_op1_0900_s1_w30)=1.35 v(wbl_op1_0900_s1_w50)=0 v(rbl_op1_0900_s1_w50)=1.8 v(ref_op1_0900_s1_w50)=0
.ic v(sn_op1_0900_s1_w50_0)=0.9 v(sn_op1_0900_s1_w50_1)=0.9 v(sn_op1_0900_s1_w50_2)=0.9 v(sn_op1_0900_s1_w50_3)=0.9 v(vn_op1_0900_s1_w50)=0.45 v(vp_op1_0900_s1_w50)=1.35
.ic v(wbl_op1_0900_s2_w0p2)=0 v(rbl_op1_0900_s2_w0p2)=1.8 v(ref_op1_0900_s2_w0p2)=0 v(sn_op1_0900_s2_w0p2_0)=0.9 v(sn_op1_0900_s2_w0p2_1)=0.9 v(sn_op1_0900_s2_w0p2_2)=0.9
.ic v(sn_op1_0900_s2_w0p2_3)=0.9 v(vn_op1_0900_s2_w0p2)=0.45 v(vp_op1_0900_s2_w0p2)=1.35 v(wbl_op1_0900_s2_w0p5)=0 v(rbl_op1_0900_s2_w0p5)=1.8 v(ref_op1_0900_s2_w0p5)=0
.ic v(sn_op1_0900_s2_w0p5_0)=0.9 v(sn_op1_0900_s2_w0p5_1)=0.9 v(sn_op1_0900_s2_w0p5_2)=0.9 v(sn_op1_0900_s2_w0p5_3)=0.9 v(vn_op1_0900_s2_w0p5)=0.45 v(vp_op1_0900_s2_w0p5)=1.35
.ic v(wbl_op1_0900_s2_w1)=0 v(rbl_op1_0900_s2_w1)=1.8 v(ref_op1_0900_s2_w1)=0 v(sn_op1_0900_s2_w1_0)=0.9 v(sn_op1_0900_s2_w1_1)=0.9 v(sn_op1_0900_s2_w1_2)=0.9
.ic v(sn_op1_0900_s2_w1_3)=0.9 v(vn_op1_0900_s2_w1)=0.45 v(vp_op1_0900_s2_w1)=1.35 v(wbl_op1_0900_s2_w2)=0 v(rbl_op1_0900_s2_w2)=1.8 v(ref_op1_0900_s2_w2)=0
.ic v(sn_op1_0900_s2_w2_0)=0.9 v(sn_op1_0900_s2_w2_1)=0.9 v(sn_op1_0900_s2_w2_2)=0.9 v(sn_op1_0900_s2_w2_3)=0.9 v(vn_op1_0900_s2_w2)=0.45 v(vp_op1_0900_s2_w2)=1.35
.ic v(wbl_op1_0900_s2_w3)=0 v(rbl_op1_0900_s2_w3)=1.8 v(ref_op1_0900_s2_w3)=0 v(sn_op1_0900_s2_w3_0)=0.9 v(sn_op1_0900_s2_w3_1)=0.9 v(sn_op1_0900_s2_w3_2)=0.9
.ic v(sn_op1_0900_s2_w3_3)=0.9 v(vn_op1_0900_s2_w3)=0.45 v(vp_op1_0900_s2_w3)=1.35 v(wbl_op1_0900_s2_w5)=0 v(rbl_op1_0900_s2_w5)=1.8 v(ref_op1_0900_s2_w5)=0
.ic v(sn_op1_0900_s2_w5_0)=0.9 v(sn_op1_0900_s2_w5_1)=0.9 v(sn_op1_0900_s2_w5_2)=0.9 v(sn_op1_0900_s2_w5_3)=0.9 v(vn_op1_0900_s2_w5)=0.45 v(vp_op1_0900_s2_w5)=1.35
.ic v(wbl_op1_0900_s2_w7p5)=0 v(rbl_op1_0900_s2_w7p5)=1.8 v(ref_op1_0900_s2_w7p5)=0 v(sn_op1_0900_s2_w7p5_0)=0.9 v(sn_op1_0900_s2_w7p5_1)=0.9 v(sn_op1_0900_s2_w7p5_2)=0.9
.ic v(sn_op1_0900_s2_w7p5_3)=0.9 v(vn_op1_0900_s2_w7p5)=0.45 v(vp_op1_0900_s2_w7p5)=1.35 v(wbl_op1_0900_s2_w10)=0 v(rbl_op1_0900_s2_w10)=1.8 v(ref_op1_0900_s2_w10)=0
.ic v(sn_op1_0900_s2_w10_0)=0.9 v(sn_op1_0900_s2_w10_1)=0.9 v(sn_op1_0900_s2_w10_2)=0.9 v(sn_op1_0900_s2_w10_3)=0.9 v(vn_op1_0900_s2_w10)=0.45 v(vp_op1_0900_s2_w10)=1.35
.ic v(wbl_op1_0900_s2_w15)=0 v(rbl_op1_0900_s2_w15)=1.8 v(ref_op1_0900_s2_w15)=0 v(sn_op1_0900_s2_w15_0)=0.9 v(sn_op1_0900_s2_w15_1)=0.9 v(sn_op1_0900_s2_w15_2)=0.9
.ic v(sn_op1_0900_s2_w15_3)=0.9 v(vn_op1_0900_s2_w15)=0.45 v(vp_op1_0900_s2_w15)=1.35 v(wbl_op1_0900_s2_w20)=0 v(rbl_op1_0900_s2_w20)=1.8 v(ref_op1_0900_s2_w20)=0
.ic v(sn_op1_0900_s2_w20_0)=0.9 v(sn_op1_0900_s2_w20_1)=0.9 v(sn_op1_0900_s2_w20_2)=0.9 v(sn_op1_0900_s2_w20_3)=0.9 v(vn_op1_0900_s2_w20)=0.45 v(vp_op1_0900_s2_w20)=1.35
.ic v(wbl_op1_0900_s2_w30)=0 v(rbl_op1_0900_s2_w30)=1.8 v(ref_op1_0900_s2_w30)=0 v(sn_op1_0900_s2_w30_0)=0.9 v(sn_op1_0900_s2_w30_1)=0.9 v(sn_op1_0900_s2_w30_2)=0.9
.ic v(sn_op1_0900_s2_w30_3)=0.9 v(vn_op1_0900_s2_w30)=0.45 v(vp_op1_0900_s2_w30)=1.35 v(wbl_op1_0900_s2_w50)=0 v(rbl_op1_0900_s2_w50)=1.8 v(ref_op1_0900_s2_w50)=0
.ic v(sn_op1_0900_s2_w50_0)=0.9 v(sn_op1_0900_s2_w50_1)=0.9 v(sn_op1_0900_s2_w50_2)=0.9 v(sn_op1_0900_s2_w50_3)=0.9 v(vn_op1_0900_s2_w50)=0.45 v(vp_op1_0900_s2_w50)=1.35
.ic v(wbl_op1_0900_s5_w0p2)=0 v(rbl_op1_0900_s5_w0p2)=1.8 v(ref_op1_0900_s5_w0p2)=0 v(sn_op1_0900_s5_w0p2_0)=0.9 v(sn_op1_0900_s5_w0p2_1)=0.9 v(sn_op1_0900_s5_w0p2_2)=0.9
.ic v(sn_op1_0900_s5_w0p2_3)=0.9 v(vn_op1_0900_s5_w0p2)=0.45 v(vp_op1_0900_s5_w0p2)=1.35 v(wbl_op1_0900_s5_w0p5)=0 v(rbl_op1_0900_s5_w0p5)=1.8 v(ref_op1_0900_s5_w0p5)=0
.ic v(sn_op1_0900_s5_w0p5_0)=0.9 v(sn_op1_0900_s5_w0p5_1)=0.9 v(sn_op1_0900_s5_w0p5_2)=0.9 v(sn_op1_0900_s5_w0p5_3)=0.9 v(vn_op1_0900_s5_w0p5)=0.45 v(vp_op1_0900_s5_w0p5)=1.35
.ic v(wbl_op1_0900_s5_w1)=0 v(rbl_op1_0900_s5_w1)=1.8 v(ref_op1_0900_s5_w1)=0 v(sn_op1_0900_s5_w1_0)=0.9 v(sn_op1_0900_s5_w1_1)=0.9 v(sn_op1_0900_s5_w1_2)=0.9
.ic v(sn_op1_0900_s5_w1_3)=0.9 v(vn_op1_0900_s5_w1)=0.45 v(vp_op1_0900_s5_w1)=1.35 v(wbl_op1_0900_s5_w2)=0 v(rbl_op1_0900_s5_w2)=1.8 v(ref_op1_0900_s5_w2)=0
.ic v(sn_op1_0900_s5_w2_0)=0.9 v(sn_op1_0900_s5_w2_1)=0.9 v(sn_op1_0900_s5_w2_2)=0.9 v(sn_op1_0900_s5_w2_3)=0.9 v(vn_op1_0900_s5_w2)=0.45 v(vp_op1_0900_s5_w2)=1.35
.ic v(wbl_op1_0900_s5_w3)=0 v(rbl_op1_0900_s5_w3)=1.8 v(ref_op1_0900_s5_w3)=0 v(sn_op1_0900_s5_w3_0)=0.9 v(sn_op1_0900_s5_w3_1)=0.9 v(sn_op1_0900_s5_w3_2)=0.9
.ic v(sn_op1_0900_s5_w3_3)=0.9 v(vn_op1_0900_s5_w3)=0.45 v(vp_op1_0900_s5_w3)=1.35 v(wbl_op1_0900_s5_w5)=0 v(rbl_op1_0900_s5_w5)=1.8 v(ref_op1_0900_s5_w5)=0
.ic v(sn_op1_0900_s5_w5_0)=0.9 v(sn_op1_0900_s5_w5_1)=0.9 v(sn_op1_0900_s5_w5_2)=0.9 v(sn_op1_0900_s5_w5_3)=0.9 v(vn_op1_0900_s5_w5)=0.45 v(vp_op1_0900_s5_w5)=1.35
.ic v(wbl_op1_0900_s5_w7p5)=0 v(rbl_op1_0900_s5_w7p5)=1.8 v(ref_op1_0900_s5_w7p5)=0 v(sn_op1_0900_s5_w7p5_0)=0.9 v(sn_op1_0900_s5_w7p5_1)=0.9 v(sn_op1_0900_s5_w7p5_2)=0.9
.ic v(sn_op1_0900_s5_w7p5_3)=0.9 v(vn_op1_0900_s5_w7p5)=0.45 v(vp_op1_0900_s5_w7p5)=1.35 v(wbl_op1_0900_s5_w10)=0 v(rbl_op1_0900_s5_w10)=1.8 v(ref_op1_0900_s5_w10)=0
.ic v(sn_op1_0900_s5_w10_0)=0.9 v(sn_op1_0900_s5_w10_1)=0.9 v(sn_op1_0900_s5_w10_2)=0.9 v(sn_op1_0900_s5_w10_3)=0.9 v(vn_op1_0900_s5_w10)=0.45 v(vp_op1_0900_s5_w10)=1.35
.ic v(wbl_op1_0900_s5_w15)=0 v(rbl_op1_0900_s5_w15)=1.8 v(ref_op1_0900_s5_w15)=0 v(sn_op1_0900_s5_w15_0)=0.9 v(sn_op1_0900_s5_w15_1)=0.9 v(sn_op1_0900_s5_w15_2)=0.9
.ic v(sn_op1_0900_s5_w15_3)=0.9 v(vn_op1_0900_s5_w15)=0.45 v(vp_op1_0900_s5_w15)=1.35 v(wbl_op1_0900_s5_w20)=0 v(rbl_op1_0900_s5_w20)=1.8 v(ref_op1_0900_s5_w20)=0
.ic v(sn_op1_0900_s5_w20_0)=0.9 v(sn_op1_0900_s5_w20_1)=0.9 v(sn_op1_0900_s5_w20_2)=0.9 v(sn_op1_0900_s5_w20_3)=0.9 v(vn_op1_0900_s5_w20)=0.45 v(vp_op1_0900_s5_w20)=1.35
.ic v(wbl_op1_0900_s5_w30)=0 v(rbl_op1_0900_s5_w30)=1.8 v(ref_op1_0900_s5_w30)=0 v(sn_op1_0900_s5_w30_0)=0.9 v(sn_op1_0900_s5_w30_1)=0.9 v(sn_op1_0900_s5_w30_2)=0.9
.ic v(sn_op1_0900_s5_w30_3)=0.9 v(vn_op1_0900_s5_w30)=0.45 v(vp_op1_0900_s5_w30)=1.35 v(wbl_op1_0900_s5_w50)=0 v(rbl_op1_0900_s5_w50)=1.8 v(ref_op1_0900_s5_w50)=0
.ic v(sn_op1_0900_s5_w50_0)=0.9 v(sn_op1_0900_s5_w50_1)=0.9 v(sn_op1_0900_s5_w50_2)=0.9 v(sn_op1_0900_s5_w50_3)=0.9 v(vn_op1_0900_s5_w50)=0.45 v(vp_op1_0900_s5_w50)=1.35
.ic v(wbl_op1_0900_s10_w0p2)=0 v(rbl_op1_0900_s10_w0p2)=1.8 v(ref_op1_0900_s10_w0p2)=0 v(sn_op1_0900_s10_w0p2_0)=0.9 v(sn_op1_0900_s10_w0p2_1)=0.9 v(sn_op1_0900_s10_w0p2_2)=0.9
.ic v(sn_op1_0900_s10_w0p2_3)=0.9 v(vn_op1_0900_s10_w0p2)=0.45 v(vp_op1_0900_s10_w0p2)=1.35 v(wbl_op1_0900_s10_w0p5)=0 v(rbl_op1_0900_s10_w0p5)=1.8 v(ref_op1_0900_s10_w0p5)=0
.ic v(sn_op1_0900_s10_w0p5_0)=0.9 v(sn_op1_0900_s10_w0p5_1)=0.9 v(sn_op1_0900_s10_w0p5_2)=0.9 v(sn_op1_0900_s10_w0p5_3)=0.9 v(vn_op1_0900_s10_w0p5)=0.45 v(vp_op1_0900_s10_w0p5)=1.35
.ic v(wbl_op1_0900_s10_w1)=0 v(rbl_op1_0900_s10_w1)=1.8 v(ref_op1_0900_s10_w1)=0 v(sn_op1_0900_s10_w1_0)=0.9 v(sn_op1_0900_s10_w1_1)=0.9 v(sn_op1_0900_s10_w1_2)=0.9
.ic v(sn_op1_0900_s10_w1_3)=0.9 v(vn_op1_0900_s10_w1)=0.45 v(vp_op1_0900_s10_w1)=1.35 v(wbl_op1_0900_s10_w2)=0 v(rbl_op1_0900_s10_w2)=1.8 v(ref_op1_0900_s10_w2)=0
.ic v(sn_op1_0900_s10_w2_0)=0.9 v(sn_op1_0900_s10_w2_1)=0.9 v(sn_op1_0900_s10_w2_2)=0.9 v(sn_op1_0900_s10_w2_3)=0.9 v(vn_op1_0900_s10_w2)=0.45 v(vp_op1_0900_s10_w2)=1.35
.ic v(wbl_op1_0900_s10_w3)=0 v(rbl_op1_0900_s10_w3)=1.8 v(ref_op1_0900_s10_w3)=0 v(sn_op1_0900_s10_w3_0)=0.9 v(sn_op1_0900_s10_w3_1)=0.9 v(sn_op1_0900_s10_w3_2)=0.9
.ic v(sn_op1_0900_s10_w3_3)=0.9 v(vn_op1_0900_s10_w3)=0.45 v(vp_op1_0900_s10_w3)=1.35 v(wbl_op1_0900_s10_w5)=0 v(rbl_op1_0900_s10_w5)=1.8 v(ref_op1_0900_s10_w5)=0
.ic v(sn_op1_0900_s10_w5_0)=0.9 v(sn_op1_0900_s10_w5_1)=0.9 v(sn_op1_0900_s10_w5_2)=0.9 v(sn_op1_0900_s10_w5_3)=0.9 v(vn_op1_0900_s10_w5)=0.45 v(vp_op1_0900_s10_w5)=1.35
.ic v(wbl_op1_0900_s10_w7p5)=0 v(rbl_op1_0900_s10_w7p5)=1.8 v(ref_op1_0900_s10_w7p5)=0 v(sn_op1_0900_s10_w7p5_0)=0.9 v(sn_op1_0900_s10_w7p5_1)=0.9 v(sn_op1_0900_s10_w7p5_2)=0.9
.ic v(sn_op1_0900_s10_w7p5_3)=0.9 v(vn_op1_0900_s10_w7p5)=0.45 v(vp_op1_0900_s10_w7p5)=1.35 v(wbl_op1_0900_s10_w10)=0 v(rbl_op1_0900_s10_w10)=1.8 v(ref_op1_0900_s10_w10)=0
.ic v(sn_op1_0900_s10_w10_0)=0.9 v(sn_op1_0900_s10_w10_1)=0.9 v(sn_op1_0900_s10_w10_2)=0.9 v(sn_op1_0900_s10_w10_3)=0.9 v(vn_op1_0900_s10_w10)=0.45 v(vp_op1_0900_s10_w10)=1.35
.ic v(wbl_op1_0900_s10_w15)=0 v(rbl_op1_0900_s10_w15)=1.8 v(ref_op1_0900_s10_w15)=0 v(sn_op1_0900_s10_w15_0)=0.9 v(sn_op1_0900_s10_w15_1)=0.9 v(sn_op1_0900_s10_w15_2)=0.9
.ic v(sn_op1_0900_s10_w15_3)=0.9 v(vn_op1_0900_s10_w15)=0.45 v(vp_op1_0900_s10_w15)=1.35 v(wbl_op1_0900_s10_w20)=0 v(rbl_op1_0900_s10_w20)=1.8 v(ref_op1_0900_s10_w20)=0
.ic v(sn_op1_0900_s10_w20_0)=0.9 v(sn_op1_0900_s10_w20_1)=0.9 v(sn_op1_0900_s10_w20_2)=0.9 v(sn_op1_0900_s10_w20_3)=0.9 v(vn_op1_0900_s10_w20)=0.45 v(vp_op1_0900_s10_w20)=1.35
.ic v(wbl_op1_0900_s10_w30)=0 v(rbl_op1_0900_s10_w30)=1.8 v(ref_op1_0900_s10_w30)=0 v(sn_op1_0900_s10_w30_0)=0.9 v(sn_op1_0900_s10_w30_1)=0.9 v(sn_op1_0900_s10_w30_2)=0.9
.ic v(sn_op1_0900_s10_w30_3)=0.9 v(vn_op1_0900_s10_w30)=0.45 v(vp_op1_0900_s10_w30)=1.35 v(wbl_op1_0900_s10_w50)=0 v(rbl_op1_0900_s10_w50)=1.8 v(ref_op1_0900_s10_w50)=0
.ic v(sn_op1_0900_s10_w50_0)=0.9 v(sn_op1_0900_s10_w50_1)=0.9 v(sn_op1_0900_s10_w50_2)=0.9 v(sn_op1_0900_s10_w50_3)=0.9 v(vn_op1_0900_s10_w50)=0.45 v(vp_op1_0900_s10_w50)=1.35
.ic v(wbl_op1_1000_s0p5_w0p2)=0 v(rbl_op1_1000_s0p5_w0p2)=1.8 v(ref_op1_1000_s0p5_w0p2)=0 v(sn_op1_1000_s0p5_w0p2_0)=1 v(sn_op1_1000_s0p5_w0p2_1)=1 v(sn_op1_1000_s0p5_w0p2_2)=1
.ic v(sn_op1_1000_s0p5_w0p2_3)=1 v(vn_op1_1000_s0p5_w0p2)=0.45 v(vp_op1_1000_s0p5_w0p2)=1.35 v(wbl_op1_1000_s0p5_w0p5)=0 v(rbl_op1_1000_s0p5_w0p5)=1.8 v(ref_op1_1000_s0p5_w0p5)=0
.ic v(sn_op1_1000_s0p5_w0p5_0)=1 v(sn_op1_1000_s0p5_w0p5_1)=1 v(sn_op1_1000_s0p5_w0p5_2)=1 v(sn_op1_1000_s0p5_w0p5_3)=1 v(vn_op1_1000_s0p5_w0p5)=0.45 v(vp_op1_1000_s0p5_w0p5)=1.35
.ic v(wbl_op1_1000_s0p5_w1)=0 v(rbl_op1_1000_s0p5_w1)=1.8 v(ref_op1_1000_s0p5_w1)=0 v(sn_op1_1000_s0p5_w1_0)=1 v(sn_op1_1000_s0p5_w1_1)=1 v(sn_op1_1000_s0p5_w1_2)=1
.ic v(sn_op1_1000_s0p5_w1_3)=1 v(vn_op1_1000_s0p5_w1)=0.45 v(vp_op1_1000_s0p5_w1)=1.35 v(wbl_op1_1000_s0p5_w2)=0 v(rbl_op1_1000_s0p5_w2)=1.8 v(ref_op1_1000_s0p5_w2)=0
.ic v(sn_op1_1000_s0p5_w2_0)=1 v(sn_op1_1000_s0p5_w2_1)=1 v(sn_op1_1000_s0p5_w2_2)=1 v(sn_op1_1000_s0p5_w2_3)=1 v(vn_op1_1000_s0p5_w2)=0.45 v(vp_op1_1000_s0p5_w2)=1.35
.ic v(wbl_op1_1000_s0p5_w3)=0 v(rbl_op1_1000_s0p5_w3)=1.8 v(ref_op1_1000_s0p5_w3)=0 v(sn_op1_1000_s0p5_w3_0)=1 v(sn_op1_1000_s0p5_w3_1)=1 v(sn_op1_1000_s0p5_w3_2)=1
.ic v(sn_op1_1000_s0p5_w3_3)=1 v(vn_op1_1000_s0p5_w3)=0.45 v(vp_op1_1000_s0p5_w3)=1.35 v(wbl_op1_1000_s0p5_w5)=0 v(rbl_op1_1000_s0p5_w5)=1.8 v(ref_op1_1000_s0p5_w5)=0
.ic v(sn_op1_1000_s0p5_w5_0)=1 v(sn_op1_1000_s0p5_w5_1)=1 v(sn_op1_1000_s0p5_w5_2)=1 v(sn_op1_1000_s0p5_w5_3)=1 v(vn_op1_1000_s0p5_w5)=0.45 v(vp_op1_1000_s0p5_w5)=1.35
.ic v(wbl_op1_1000_s0p5_w7p5)=0 v(rbl_op1_1000_s0p5_w7p5)=1.8 v(ref_op1_1000_s0p5_w7p5)=0 v(sn_op1_1000_s0p5_w7p5_0)=1 v(sn_op1_1000_s0p5_w7p5_1)=1 v(sn_op1_1000_s0p5_w7p5_2)=1
.ic v(sn_op1_1000_s0p5_w7p5_3)=1 v(vn_op1_1000_s0p5_w7p5)=0.45 v(vp_op1_1000_s0p5_w7p5)=1.35 v(wbl_op1_1000_s0p5_w10)=0 v(rbl_op1_1000_s0p5_w10)=1.8 v(ref_op1_1000_s0p5_w10)=0
.ic v(sn_op1_1000_s0p5_w10_0)=1 v(sn_op1_1000_s0p5_w10_1)=1 v(sn_op1_1000_s0p5_w10_2)=1 v(sn_op1_1000_s0p5_w10_3)=1 v(vn_op1_1000_s0p5_w10)=0.45 v(vp_op1_1000_s0p5_w10)=1.35
.ic v(wbl_op1_1000_s0p5_w15)=0 v(rbl_op1_1000_s0p5_w15)=1.8 v(ref_op1_1000_s0p5_w15)=0 v(sn_op1_1000_s0p5_w15_0)=1 v(sn_op1_1000_s0p5_w15_1)=1 v(sn_op1_1000_s0p5_w15_2)=1
.ic v(sn_op1_1000_s0p5_w15_3)=1 v(vn_op1_1000_s0p5_w15)=0.45 v(vp_op1_1000_s0p5_w15)=1.35 v(wbl_op1_1000_s0p5_w20)=0 v(rbl_op1_1000_s0p5_w20)=1.8 v(ref_op1_1000_s0p5_w20)=0
.ic v(sn_op1_1000_s0p5_w20_0)=1 v(sn_op1_1000_s0p5_w20_1)=1 v(sn_op1_1000_s0p5_w20_2)=1 v(sn_op1_1000_s0p5_w20_3)=1 v(vn_op1_1000_s0p5_w20)=0.45 v(vp_op1_1000_s0p5_w20)=1.35
.ic v(wbl_op1_1000_s0p5_w30)=0 v(rbl_op1_1000_s0p5_w30)=1.8 v(ref_op1_1000_s0p5_w30)=0 v(sn_op1_1000_s0p5_w30_0)=1 v(sn_op1_1000_s0p5_w30_1)=1 v(sn_op1_1000_s0p5_w30_2)=1
.ic v(sn_op1_1000_s0p5_w30_3)=1 v(vn_op1_1000_s0p5_w30)=0.45 v(vp_op1_1000_s0p5_w30)=1.35 v(wbl_op1_1000_s0p5_w50)=0 v(rbl_op1_1000_s0p5_w50)=1.8 v(ref_op1_1000_s0p5_w50)=0
.ic v(sn_op1_1000_s0p5_w50_0)=1 v(sn_op1_1000_s0p5_w50_1)=1 v(sn_op1_1000_s0p5_w50_2)=1 v(sn_op1_1000_s0p5_w50_3)=1 v(vn_op1_1000_s0p5_w50)=0.45 v(vp_op1_1000_s0p5_w50)=1.35
.ic v(wbl_op1_1000_s1_w0p2)=0 v(rbl_op1_1000_s1_w0p2)=1.8 v(ref_op1_1000_s1_w0p2)=0 v(sn_op1_1000_s1_w0p2_0)=1 v(sn_op1_1000_s1_w0p2_1)=1 v(sn_op1_1000_s1_w0p2_2)=1
.ic v(sn_op1_1000_s1_w0p2_3)=1 v(vn_op1_1000_s1_w0p2)=0.45 v(vp_op1_1000_s1_w0p2)=1.35 v(wbl_op1_1000_s1_w0p5)=0 v(rbl_op1_1000_s1_w0p5)=1.8 v(ref_op1_1000_s1_w0p5)=0
.ic v(sn_op1_1000_s1_w0p5_0)=1 v(sn_op1_1000_s1_w0p5_1)=1 v(sn_op1_1000_s1_w0p5_2)=1 v(sn_op1_1000_s1_w0p5_3)=1 v(vn_op1_1000_s1_w0p5)=0.45 v(vp_op1_1000_s1_w0p5)=1.35
.ic v(wbl_op1_1000_s1_w1)=0 v(rbl_op1_1000_s1_w1)=1.8 v(ref_op1_1000_s1_w1)=0 v(sn_op1_1000_s1_w1_0)=1 v(sn_op1_1000_s1_w1_1)=1 v(sn_op1_1000_s1_w1_2)=1
.ic v(sn_op1_1000_s1_w1_3)=1 v(vn_op1_1000_s1_w1)=0.45 v(vp_op1_1000_s1_w1)=1.35 v(wbl_op1_1000_s1_w2)=0 v(rbl_op1_1000_s1_w2)=1.8 v(ref_op1_1000_s1_w2)=0
.ic v(sn_op1_1000_s1_w2_0)=1 v(sn_op1_1000_s1_w2_1)=1 v(sn_op1_1000_s1_w2_2)=1 v(sn_op1_1000_s1_w2_3)=1 v(vn_op1_1000_s1_w2)=0.45 v(vp_op1_1000_s1_w2)=1.35
.ic v(wbl_op1_1000_s1_w3)=0 v(rbl_op1_1000_s1_w3)=1.8 v(ref_op1_1000_s1_w3)=0 v(sn_op1_1000_s1_w3_0)=1 v(sn_op1_1000_s1_w3_1)=1 v(sn_op1_1000_s1_w3_2)=1
.ic v(sn_op1_1000_s1_w3_3)=1 v(vn_op1_1000_s1_w3)=0.45 v(vp_op1_1000_s1_w3)=1.35 v(wbl_op1_1000_s1_w5)=0 v(rbl_op1_1000_s1_w5)=1.8 v(ref_op1_1000_s1_w5)=0
.ic v(sn_op1_1000_s1_w5_0)=1 v(sn_op1_1000_s1_w5_1)=1 v(sn_op1_1000_s1_w5_2)=1 v(sn_op1_1000_s1_w5_3)=1 v(vn_op1_1000_s1_w5)=0.45 v(vp_op1_1000_s1_w5)=1.35
.ic v(wbl_op1_1000_s1_w7p5)=0 v(rbl_op1_1000_s1_w7p5)=1.8 v(ref_op1_1000_s1_w7p5)=0 v(sn_op1_1000_s1_w7p5_0)=1 v(sn_op1_1000_s1_w7p5_1)=1 v(sn_op1_1000_s1_w7p5_2)=1
.ic v(sn_op1_1000_s1_w7p5_3)=1 v(vn_op1_1000_s1_w7p5)=0.45 v(vp_op1_1000_s1_w7p5)=1.35 v(wbl_op1_1000_s1_w10)=0 v(rbl_op1_1000_s1_w10)=1.8 v(ref_op1_1000_s1_w10)=0
.ic v(sn_op1_1000_s1_w10_0)=1 v(sn_op1_1000_s1_w10_1)=1 v(sn_op1_1000_s1_w10_2)=1 v(sn_op1_1000_s1_w10_3)=1 v(vn_op1_1000_s1_w10)=0.45 v(vp_op1_1000_s1_w10)=1.35
.ic v(wbl_op1_1000_s1_w15)=0 v(rbl_op1_1000_s1_w15)=1.8 v(ref_op1_1000_s1_w15)=0 v(sn_op1_1000_s1_w15_0)=1 v(sn_op1_1000_s1_w15_1)=1 v(sn_op1_1000_s1_w15_2)=1
.ic v(sn_op1_1000_s1_w15_3)=1 v(vn_op1_1000_s1_w15)=0.45 v(vp_op1_1000_s1_w15)=1.35 v(wbl_op1_1000_s1_w20)=0 v(rbl_op1_1000_s1_w20)=1.8 v(ref_op1_1000_s1_w20)=0
.ic v(sn_op1_1000_s1_w20_0)=1 v(sn_op1_1000_s1_w20_1)=1 v(sn_op1_1000_s1_w20_2)=1 v(sn_op1_1000_s1_w20_3)=1 v(vn_op1_1000_s1_w20)=0.45 v(vp_op1_1000_s1_w20)=1.35
.ic v(wbl_op1_1000_s1_w30)=0 v(rbl_op1_1000_s1_w30)=1.8 v(ref_op1_1000_s1_w30)=0 v(sn_op1_1000_s1_w30_0)=1 v(sn_op1_1000_s1_w30_1)=1 v(sn_op1_1000_s1_w30_2)=1
.ic v(sn_op1_1000_s1_w30_3)=1 v(vn_op1_1000_s1_w30)=0.45 v(vp_op1_1000_s1_w30)=1.35 v(wbl_op1_1000_s1_w50)=0 v(rbl_op1_1000_s1_w50)=1.8 v(ref_op1_1000_s1_w50)=0
.ic v(sn_op1_1000_s1_w50_0)=1 v(sn_op1_1000_s1_w50_1)=1 v(sn_op1_1000_s1_w50_2)=1 v(sn_op1_1000_s1_w50_3)=1 v(vn_op1_1000_s1_w50)=0.45 v(vp_op1_1000_s1_w50)=1.35
.ic v(wbl_op1_1000_s2_w0p2)=0 v(rbl_op1_1000_s2_w0p2)=1.8 v(ref_op1_1000_s2_w0p2)=0 v(sn_op1_1000_s2_w0p2_0)=1 v(sn_op1_1000_s2_w0p2_1)=1 v(sn_op1_1000_s2_w0p2_2)=1
.ic v(sn_op1_1000_s2_w0p2_3)=1 v(vn_op1_1000_s2_w0p2)=0.45 v(vp_op1_1000_s2_w0p2)=1.35 v(wbl_op1_1000_s2_w0p5)=0 v(rbl_op1_1000_s2_w0p5)=1.8 v(ref_op1_1000_s2_w0p5)=0
.ic v(sn_op1_1000_s2_w0p5_0)=1 v(sn_op1_1000_s2_w0p5_1)=1 v(sn_op1_1000_s2_w0p5_2)=1 v(sn_op1_1000_s2_w0p5_3)=1 v(vn_op1_1000_s2_w0p5)=0.45 v(vp_op1_1000_s2_w0p5)=1.35
.ic v(wbl_op1_1000_s2_w1)=0 v(rbl_op1_1000_s2_w1)=1.8 v(ref_op1_1000_s2_w1)=0 v(sn_op1_1000_s2_w1_0)=1 v(sn_op1_1000_s2_w1_1)=1 v(sn_op1_1000_s2_w1_2)=1
.ic v(sn_op1_1000_s2_w1_3)=1 v(vn_op1_1000_s2_w1)=0.45 v(vp_op1_1000_s2_w1)=1.35 v(wbl_op1_1000_s2_w2)=0 v(rbl_op1_1000_s2_w2)=1.8 v(ref_op1_1000_s2_w2)=0
.ic v(sn_op1_1000_s2_w2_0)=1 v(sn_op1_1000_s2_w2_1)=1 v(sn_op1_1000_s2_w2_2)=1 v(sn_op1_1000_s2_w2_3)=1 v(vn_op1_1000_s2_w2)=0.45 v(vp_op1_1000_s2_w2)=1.35
.ic v(wbl_op1_1000_s2_w3)=0 v(rbl_op1_1000_s2_w3)=1.8 v(ref_op1_1000_s2_w3)=0 v(sn_op1_1000_s2_w3_0)=1 v(sn_op1_1000_s2_w3_1)=1 v(sn_op1_1000_s2_w3_2)=1
.ic v(sn_op1_1000_s2_w3_3)=1 v(vn_op1_1000_s2_w3)=0.45 v(vp_op1_1000_s2_w3)=1.35 v(wbl_op1_1000_s2_w5)=0 v(rbl_op1_1000_s2_w5)=1.8 v(ref_op1_1000_s2_w5)=0
.ic v(sn_op1_1000_s2_w5_0)=1 v(sn_op1_1000_s2_w5_1)=1 v(sn_op1_1000_s2_w5_2)=1 v(sn_op1_1000_s2_w5_3)=1 v(vn_op1_1000_s2_w5)=0.45 v(vp_op1_1000_s2_w5)=1.35
.ic v(wbl_op1_1000_s2_w7p5)=0 v(rbl_op1_1000_s2_w7p5)=1.8 v(ref_op1_1000_s2_w7p5)=0 v(sn_op1_1000_s2_w7p5_0)=1 v(sn_op1_1000_s2_w7p5_1)=1 v(sn_op1_1000_s2_w7p5_2)=1
.ic v(sn_op1_1000_s2_w7p5_3)=1 v(vn_op1_1000_s2_w7p5)=0.45 v(vp_op1_1000_s2_w7p5)=1.35 v(wbl_op1_1000_s2_w10)=0 v(rbl_op1_1000_s2_w10)=1.8 v(ref_op1_1000_s2_w10)=0
.ic v(sn_op1_1000_s2_w10_0)=1 v(sn_op1_1000_s2_w10_1)=1 v(sn_op1_1000_s2_w10_2)=1 v(sn_op1_1000_s2_w10_3)=1 v(vn_op1_1000_s2_w10)=0.45 v(vp_op1_1000_s2_w10)=1.35
.ic v(wbl_op1_1000_s2_w15)=0 v(rbl_op1_1000_s2_w15)=1.8 v(ref_op1_1000_s2_w15)=0 v(sn_op1_1000_s2_w15_0)=1 v(sn_op1_1000_s2_w15_1)=1 v(sn_op1_1000_s2_w15_2)=1
.ic v(sn_op1_1000_s2_w15_3)=1 v(vn_op1_1000_s2_w15)=0.45 v(vp_op1_1000_s2_w15)=1.35 v(wbl_op1_1000_s2_w20)=0 v(rbl_op1_1000_s2_w20)=1.8 v(ref_op1_1000_s2_w20)=0
.ic v(sn_op1_1000_s2_w20_0)=1 v(sn_op1_1000_s2_w20_1)=1 v(sn_op1_1000_s2_w20_2)=1 v(sn_op1_1000_s2_w20_3)=1 v(vn_op1_1000_s2_w20)=0.45 v(vp_op1_1000_s2_w20)=1.35
.ic v(wbl_op1_1000_s2_w30)=0 v(rbl_op1_1000_s2_w30)=1.8 v(ref_op1_1000_s2_w30)=0 v(sn_op1_1000_s2_w30_0)=1 v(sn_op1_1000_s2_w30_1)=1 v(sn_op1_1000_s2_w30_2)=1
.ic v(sn_op1_1000_s2_w30_3)=1 v(vn_op1_1000_s2_w30)=0.45 v(vp_op1_1000_s2_w30)=1.35 v(wbl_op1_1000_s2_w50)=0 v(rbl_op1_1000_s2_w50)=1.8 v(ref_op1_1000_s2_w50)=0
.ic v(sn_op1_1000_s2_w50_0)=1 v(sn_op1_1000_s2_w50_1)=1 v(sn_op1_1000_s2_w50_2)=1 v(sn_op1_1000_s2_w50_3)=1 v(vn_op1_1000_s2_w50)=0.45 v(vp_op1_1000_s2_w50)=1.35
.ic v(wbl_op1_1000_s5_w0p2)=0 v(rbl_op1_1000_s5_w0p2)=1.8 v(ref_op1_1000_s5_w0p2)=0 v(sn_op1_1000_s5_w0p2_0)=1 v(sn_op1_1000_s5_w0p2_1)=1 v(sn_op1_1000_s5_w0p2_2)=1
.ic v(sn_op1_1000_s5_w0p2_3)=1 v(vn_op1_1000_s5_w0p2)=0.45 v(vp_op1_1000_s5_w0p2)=1.35 v(wbl_op1_1000_s5_w0p5)=0 v(rbl_op1_1000_s5_w0p5)=1.8 v(ref_op1_1000_s5_w0p5)=0
.ic v(sn_op1_1000_s5_w0p5_0)=1 v(sn_op1_1000_s5_w0p5_1)=1 v(sn_op1_1000_s5_w0p5_2)=1 v(sn_op1_1000_s5_w0p5_3)=1 v(vn_op1_1000_s5_w0p5)=0.45 v(vp_op1_1000_s5_w0p5)=1.35
.ic v(wbl_op1_1000_s5_w1)=0 v(rbl_op1_1000_s5_w1)=1.8 v(ref_op1_1000_s5_w1)=0 v(sn_op1_1000_s5_w1_0)=1 v(sn_op1_1000_s5_w1_1)=1 v(sn_op1_1000_s5_w1_2)=1
.ic v(sn_op1_1000_s5_w1_3)=1 v(vn_op1_1000_s5_w1)=0.45 v(vp_op1_1000_s5_w1)=1.35 v(wbl_op1_1000_s5_w2)=0 v(rbl_op1_1000_s5_w2)=1.8 v(ref_op1_1000_s5_w2)=0
.ic v(sn_op1_1000_s5_w2_0)=1 v(sn_op1_1000_s5_w2_1)=1 v(sn_op1_1000_s5_w2_2)=1 v(sn_op1_1000_s5_w2_3)=1 v(vn_op1_1000_s5_w2)=0.45 v(vp_op1_1000_s5_w2)=1.35
.ic v(wbl_op1_1000_s5_w3)=0 v(rbl_op1_1000_s5_w3)=1.8 v(ref_op1_1000_s5_w3)=0 v(sn_op1_1000_s5_w3_0)=1 v(sn_op1_1000_s5_w3_1)=1 v(sn_op1_1000_s5_w3_2)=1
.ic v(sn_op1_1000_s5_w3_3)=1 v(vn_op1_1000_s5_w3)=0.45 v(vp_op1_1000_s5_w3)=1.35 v(wbl_op1_1000_s5_w5)=0 v(rbl_op1_1000_s5_w5)=1.8 v(ref_op1_1000_s5_w5)=0
.ic v(sn_op1_1000_s5_w5_0)=1 v(sn_op1_1000_s5_w5_1)=1 v(sn_op1_1000_s5_w5_2)=1 v(sn_op1_1000_s5_w5_3)=1 v(vn_op1_1000_s5_w5)=0.45 v(vp_op1_1000_s5_w5)=1.35
.ic v(wbl_op1_1000_s5_w7p5)=0 v(rbl_op1_1000_s5_w7p5)=1.8 v(ref_op1_1000_s5_w7p5)=0 v(sn_op1_1000_s5_w7p5_0)=1 v(sn_op1_1000_s5_w7p5_1)=1 v(sn_op1_1000_s5_w7p5_2)=1
.ic v(sn_op1_1000_s5_w7p5_3)=1 v(vn_op1_1000_s5_w7p5)=0.45 v(vp_op1_1000_s5_w7p5)=1.35 v(wbl_op1_1000_s5_w10)=0 v(rbl_op1_1000_s5_w10)=1.8 v(ref_op1_1000_s5_w10)=0
.ic v(sn_op1_1000_s5_w10_0)=1 v(sn_op1_1000_s5_w10_1)=1 v(sn_op1_1000_s5_w10_2)=1 v(sn_op1_1000_s5_w10_3)=1 v(vn_op1_1000_s5_w10)=0.45 v(vp_op1_1000_s5_w10)=1.35
.ic v(wbl_op1_1000_s5_w15)=0 v(rbl_op1_1000_s5_w15)=1.8 v(ref_op1_1000_s5_w15)=0 v(sn_op1_1000_s5_w15_0)=1 v(sn_op1_1000_s5_w15_1)=1 v(sn_op1_1000_s5_w15_2)=1
.ic v(sn_op1_1000_s5_w15_3)=1 v(vn_op1_1000_s5_w15)=0.45 v(vp_op1_1000_s5_w15)=1.35 v(wbl_op1_1000_s5_w20)=0 v(rbl_op1_1000_s5_w20)=1.8 v(ref_op1_1000_s5_w20)=0
.ic v(sn_op1_1000_s5_w20_0)=1 v(sn_op1_1000_s5_w20_1)=1 v(sn_op1_1000_s5_w20_2)=1 v(sn_op1_1000_s5_w20_3)=1 v(vn_op1_1000_s5_w20)=0.45 v(vp_op1_1000_s5_w20)=1.35
.ic v(wbl_op1_1000_s5_w30)=0 v(rbl_op1_1000_s5_w30)=1.8 v(ref_op1_1000_s5_w30)=0 v(sn_op1_1000_s5_w30_0)=1 v(sn_op1_1000_s5_w30_1)=1 v(sn_op1_1000_s5_w30_2)=1
.ic v(sn_op1_1000_s5_w30_3)=1 v(vn_op1_1000_s5_w30)=0.45 v(vp_op1_1000_s5_w30)=1.35 v(wbl_op1_1000_s5_w50)=0 v(rbl_op1_1000_s5_w50)=1.8 v(ref_op1_1000_s5_w50)=0
.ic v(sn_op1_1000_s5_w50_0)=1 v(sn_op1_1000_s5_w50_1)=1 v(sn_op1_1000_s5_w50_2)=1 v(sn_op1_1000_s5_w50_3)=1 v(vn_op1_1000_s5_w50)=0.45 v(vp_op1_1000_s5_w50)=1.35
.ic v(wbl_op1_1000_s10_w0p2)=0 v(rbl_op1_1000_s10_w0p2)=1.8 v(ref_op1_1000_s10_w0p2)=0 v(sn_op1_1000_s10_w0p2_0)=1 v(sn_op1_1000_s10_w0p2_1)=1 v(sn_op1_1000_s10_w0p2_2)=1
.ic v(sn_op1_1000_s10_w0p2_3)=1 v(vn_op1_1000_s10_w0p2)=0.45 v(vp_op1_1000_s10_w0p2)=1.35 v(wbl_op1_1000_s10_w0p5)=0 v(rbl_op1_1000_s10_w0p5)=1.8 v(ref_op1_1000_s10_w0p5)=0
.ic v(sn_op1_1000_s10_w0p5_0)=1 v(sn_op1_1000_s10_w0p5_1)=1 v(sn_op1_1000_s10_w0p5_2)=1 v(sn_op1_1000_s10_w0p5_3)=1 v(vn_op1_1000_s10_w0p5)=0.45 v(vp_op1_1000_s10_w0p5)=1.35
.ic v(wbl_op1_1000_s10_w1)=0 v(rbl_op1_1000_s10_w1)=1.8 v(ref_op1_1000_s10_w1)=0 v(sn_op1_1000_s10_w1_0)=1 v(sn_op1_1000_s10_w1_1)=1 v(sn_op1_1000_s10_w1_2)=1
.ic v(sn_op1_1000_s10_w1_3)=1 v(vn_op1_1000_s10_w1)=0.45 v(vp_op1_1000_s10_w1)=1.35 v(wbl_op1_1000_s10_w2)=0 v(rbl_op1_1000_s10_w2)=1.8 v(ref_op1_1000_s10_w2)=0
.ic v(sn_op1_1000_s10_w2_0)=1 v(sn_op1_1000_s10_w2_1)=1 v(sn_op1_1000_s10_w2_2)=1 v(sn_op1_1000_s10_w2_3)=1 v(vn_op1_1000_s10_w2)=0.45 v(vp_op1_1000_s10_w2)=1.35
.ic v(wbl_op1_1000_s10_w3)=0 v(rbl_op1_1000_s10_w3)=1.8 v(ref_op1_1000_s10_w3)=0 v(sn_op1_1000_s10_w3_0)=1 v(sn_op1_1000_s10_w3_1)=1 v(sn_op1_1000_s10_w3_2)=1
.ic v(sn_op1_1000_s10_w3_3)=1 v(vn_op1_1000_s10_w3)=0.45 v(vp_op1_1000_s10_w3)=1.35 v(wbl_op1_1000_s10_w5)=0 v(rbl_op1_1000_s10_w5)=1.8 v(ref_op1_1000_s10_w5)=0
.ic v(sn_op1_1000_s10_w5_0)=1 v(sn_op1_1000_s10_w5_1)=1 v(sn_op1_1000_s10_w5_2)=1 v(sn_op1_1000_s10_w5_3)=1 v(vn_op1_1000_s10_w5)=0.45 v(vp_op1_1000_s10_w5)=1.35
.ic v(wbl_op1_1000_s10_w7p5)=0 v(rbl_op1_1000_s10_w7p5)=1.8 v(ref_op1_1000_s10_w7p5)=0 v(sn_op1_1000_s10_w7p5_0)=1 v(sn_op1_1000_s10_w7p5_1)=1 v(sn_op1_1000_s10_w7p5_2)=1
.ic v(sn_op1_1000_s10_w7p5_3)=1 v(vn_op1_1000_s10_w7p5)=0.45 v(vp_op1_1000_s10_w7p5)=1.35 v(wbl_op1_1000_s10_w10)=0 v(rbl_op1_1000_s10_w10)=1.8 v(ref_op1_1000_s10_w10)=0
.ic v(sn_op1_1000_s10_w10_0)=1 v(sn_op1_1000_s10_w10_1)=1 v(sn_op1_1000_s10_w10_2)=1 v(sn_op1_1000_s10_w10_3)=1 v(vn_op1_1000_s10_w10)=0.45 v(vp_op1_1000_s10_w10)=1.35
.ic v(wbl_op1_1000_s10_w15)=0 v(rbl_op1_1000_s10_w15)=1.8 v(ref_op1_1000_s10_w15)=0 v(sn_op1_1000_s10_w15_0)=1 v(sn_op1_1000_s10_w15_1)=1 v(sn_op1_1000_s10_w15_2)=1
.ic v(sn_op1_1000_s10_w15_3)=1 v(vn_op1_1000_s10_w15)=0.45 v(vp_op1_1000_s10_w15)=1.35 v(wbl_op1_1000_s10_w20)=0 v(rbl_op1_1000_s10_w20)=1.8 v(ref_op1_1000_s10_w20)=0
.ic v(sn_op1_1000_s10_w20_0)=1 v(sn_op1_1000_s10_w20_1)=1 v(sn_op1_1000_s10_w20_2)=1 v(sn_op1_1000_s10_w20_3)=1 v(vn_op1_1000_s10_w20)=0.45 v(vp_op1_1000_s10_w20)=1.35
.ic v(wbl_op1_1000_s10_w30)=0 v(rbl_op1_1000_s10_w30)=1.8 v(ref_op1_1000_s10_w30)=0 v(sn_op1_1000_s10_w30_0)=1 v(sn_op1_1000_s10_w30_1)=1 v(sn_op1_1000_s10_w30_2)=1
.ic v(sn_op1_1000_s10_w30_3)=1 v(vn_op1_1000_s10_w30)=0.45 v(vp_op1_1000_s10_w30)=1.35 v(wbl_op1_1000_s10_w50)=0 v(rbl_op1_1000_s10_w50)=1.8 v(ref_op1_1000_s10_w50)=0
.ic v(sn_op1_1000_s10_w50_0)=1 v(sn_op1_1000_s10_w50_1)=1 v(sn_op1_1000_s10_w50_2)=1 v(sn_op1_1000_s10_w50_3)=1 v(vn_op1_1000_s10_w50)=0.45 v(vp_op1_1000_s10_w50)=1.35
.ic v(wbl_op0_n100_s0p5_w0p2)=0 v(rbl_op0_n100_s0p5_w0p2)=1.8 v(ref_op0_n100_s0p5_w0p2)=0 v(sn_op0_n100_s0p5_w0p2_0)=-0.1 v(sn_op0_n100_s0p5_w0p2_1)=-0.1 v(sn_op0_n100_s0p5_w0p2_2)=-0.1
.ic v(sn_op0_n100_s0p5_w0p2_3)=-0.1 v(vn_op0_n100_s0p5_w0p2)=0.45 v(vp_op0_n100_s0p5_w0p2)=1.35 v(wbl_op0_n100_s0p5_w0p5)=0 v(rbl_op0_n100_s0p5_w0p5)=1.8 v(ref_op0_n100_s0p5_w0p5)=0
.ic v(sn_op0_n100_s0p5_w0p5_0)=-0.1 v(sn_op0_n100_s0p5_w0p5_1)=-0.1 v(sn_op0_n100_s0p5_w0p5_2)=-0.1 v(sn_op0_n100_s0p5_w0p5_3)=-0.1 v(vn_op0_n100_s0p5_w0p5)=0.45 v(vp_op0_n100_s0p5_w0p5)=1.35
.ic v(wbl_op0_n100_s0p5_w1)=0 v(rbl_op0_n100_s0p5_w1)=1.8 v(ref_op0_n100_s0p5_w1)=0 v(sn_op0_n100_s0p5_w1_0)=-0.1 v(sn_op0_n100_s0p5_w1_1)=-0.1 v(sn_op0_n100_s0p5_w1_2)=-0.1
.ic v(sn_op0_n100_s0p5_w1_3)=-0.1 v(vn_op0_n100_s0p5_w1)=0.45 v(vp_op0_n100_s0p5_w1)=1.35 v(wbl_op0_n100_s0p5_w2)=0 v(rbl_op0_n100_s0p5_w2)=1.8 v(ref_op0_n100_s0p5_w2)=0
.ic v(sn_op0_n100_s0p5_w2_0)=-0.1 v(sn_op0_n100_s0p5_w2_1)=-0.1 v(sn_op0_n100_s0p5_w2_2)=-0.1 v(sn_op0_n100_s0p5_w2_3)=-0.1 v(vn_op0_n100_s0p5_w2)=0.45 v(vp_op0_n100_s0p5_w2)=1.35
.ic v(wbl_op0_n100_s0p5_w3)=0 v(rbl_op0_n100_s0p5_w3)=1.8 v(ref_op0_n100_s0p5_w3)=0 v(sn_op0_n100_s0p5_w3_0)=-0.1 v(sn_op0_n100_s0p5_w3_1)=-0.1 v(sn_op0_n100_s0p5_w3_2)=-0.1
.ic v(sn_op0_n100_s0p5_w3_3)=-0.1 v(vn_op0_n100_s0p5_w3)=0.45 v(vp_op0_n100_s0p5_w3)=1.35 v(wbl_op0_n100_s0p5_w5)=0 v(rbl_op0_n100_s0p5_w5)=1.8 v(ref_op0_n100_s0p5_w5)=0
.ic v(sn_op0_n100_s0p5_w5_0)=-0.1 v(sn_op0_n100_s0p5_w5_1)=-0.1 v(sn_op0_n100_s0p5_w5_2)=-0.1 v(sn_op0_n100_s0p5_w5_3)=-0.1 v(vn_op0_n100_s0p5_w5)=0.45 v(vp_op0_n100_s0p5_w5)=1.35
.ic v(wbl_op0_n100_s0p5_w7p5)=0 v(rbl_op0_n100_s0p5_w7p5)=1.8 v(ref_op0_n100_s0p5_w7p5)=0 v(sn_op0_n100_s0p5_w7p5_0)=-0.1 v(sn_op0_n100_s0p5_w7p5_1)=-0.1 v(sn_op0_n100_s0p5_w7p5_2)=-0.1
.ic v(sn_op0_n100_s0p5_w7p5_3)=-0.1 v(vn_op0_n100_s0p5_w7p5)=0.45 v(vp_op0_n100_s0p5_w7p5)=1.35 v(wbl_op0_n100_s0p5_w10)=0 v(rbl_op0_n100_s0p5_w10)=1.8 v(ref_op0_n100_s0p5_w10)=0
.ic v(sn_op0_n100_s0p5_w10_0)=-0.1 v(sn_op0_n100_s0p5_w10_1)=-0.1 v(sn_op0_n100_s0p5_w10_2)=-0.1 v(sn_op0_n100_s0p5_w10_3)=-0.1 v(vn_op0_n100_s0p5_w10)=0.45 v(vp_op0_n100_s0p5_w10)=1.35
.ic v(wbl_op0_n100_s0p5_w15)=0 v(rbl_op0_n100_s0p5_w15)=1.8 v(ref_op0_n100_s0p5_w15)=0 v(sn_op0_n100_s0p5_w15_0)=-0.1 v(sn_op0_n100_s0p5_w15_1)=-0.1 v(sn_op0_n100_s0p5_w15_2)=-0.1
.ic v(sn_op0_n100_s0p5_w15_3)=-0.1 v(vn_op0_n100_s0p5_w15)=0.45 v(vp_op0_n100_s0p5_w15)=1.35 v(wbl_op0_n100_s0p5_w20)=0 v(rbl_op0_n100_s0p5_w20)=1.8 v(ref_op0_n100_s0p5_w20)=0
.ic v(sn_op0_n100_s0p5_w20_0)=-0.1 v(sn_op0_n100_s0p5_w20_1)=-0.1 v(sn_op0_n100_s0p5_w20_2)=-0.1 v(sn_op0_n100_s0p5_w20_3)=-0.1 v(vn_op0_n100_s0p5_w20)=0.45 v(vp_op0_n100_s0p5_w20)=1.35
.ic v(wbl_op0_n100_s0p5_w30)=0 v(rbl_op0_n100_s0p5_w30)=1.8 v(ref_op0_n100_s0p5_w30)=0 v(sn_op0_n100_s0p5_w30_0)=-0.1 v(sn_op0_n100_s0p5_w30_1)=-0.1 v(sn_op0_n100_s0p5_w30_2)=-0.1
.ic v(sn_op0_n100_s0p5_w30_3)=-0.1 v(vn_op0_n100_s0p5_w30)=0.45 v(vp_op0_n100_s0p5_w30)=1.35 v(wbl_op0_n100_s0p5_w50)=0 v(rbl_op0_n100_s0p5_w50)=1.8 v(ref_op0_n100_s0p5_w50)=0
.ic v(sn_op0_n100_s0p5_w50_0)=-0.1 v(sn_op0_n100_s0p5_w50_1)=-0.1 v(sn_op0_n100_s0p5_w50_2)=-0.1 v(sn_op0_n100_s0p5_w50_3)=-0.1 v(vn_op0_n100_s0p5_w50)=0.45 v(vp_op0_n100_s0p5_w50)=1.35
.ic v(wbl_op0_n100_s1_w0p2)=0 v(rbl_op0_n100_s1_w0p2)=1.8 v(ref_op0_n100_s1_w0p2)=0 v(sn_op0_n100_s1_w0p2_0)=-0.1 v(sn_op0_n100_s1_w0p2_1)=-0.1 v(sn_op0_n100_s1_w0p2_2)=-0.1
.ic v(sn_op0_n100_s1_w0p2_3)=-0.1 v(vn_op0_n100_s1_w0p2)=0.45 v(vp_op0_n100_s1_w0p2)=1.35 v(wbl_op0_n100_s1_w0p5)=0 v(rbl_op0_n100_s1_w0p5)=1.8 v(ref_op0_n100_s1_w0p5)=0
.ic v(sn_op0_n100_s1_w0p5_0)=-0.1 v(sn_op0_n100_s1_w0p5_1)=-0.1 v(sn_op0_n100_s1_w0p5_2)=-0.1 v(sn_op0_n100_s1_w0p5_3)=-0.1 v(vn_op0_n100_s1_w0p5)=0.45 v(vp_op0_n100_s1_w0p5)=1.35
.ic v(wbl_op0_n100_s1_w1)=0 v(rbl_op0_n100_s1_w1)=1.8 v(ref_op0_n100_s1_w1)=0 v(sn_op0_n100_s1_w1_0)=-0.1 v(sn_op0_n100_s1_w1_1)=-0.1 v(sn_op0_n100_s1_w1_2)=-0.1
.ic v(sn_op0_n100_s1_w1_3)=-0.1 v(vn_op0_n100_s1_w1)=0.45 v(vp_op0_n100_s1_w1)=1.35 v(wbl_op0_n100_s1_w2)=0 v(rbl_op0_n100_s1_w2)=1.8 v(ref_op0_n100_s1_w2)=0
.ic v(sn_op0_n100_s1_w2_0)=-0.1 v(sn_op0_n100_s1_w2_1)=-0.1 v(sn_op0_n100_s1_w2_2)=-0.1 v(sn_op0_n100_s1_w2_3)=-0.1 v(vn_op0_n100_s1_w2)=0.45 v(vp_op0_n100_s1_w2)=1.35
.ic v(wbl_op0_n100_s1_w3)=0 v(rbl_op0_n100_s1_w3)=1.8 v(ref_op0_n100_s1_w3)=0 v(sn_op0_n100_s1_w3_0)=-0.1 v(sn_op0_n100_s1_w3_1)=-0.1 v(sn_op0_n100_s1_w3_2)=-0.1
.ic v(sn_op0_n100_s1_w3_3)=-0.1 v(vn_op0_n100_s1_w3)=0.45 v(vp_op0_n100_s1_w3)=1.35 v(wbl_op0_n100_s1_w5)=0 v(rbl_op0_n100_s1_w5)=1.8 v(ref_op0_n100_s1_w5)=0
.ic v(sn_op0_n100_s1_w5_0)=-0.1 v(sn_op0_n100_s1_w5_1)=-0.1 v(sn_op0_n100_s1_w5_2)=-0.1 v(sn_op0_n100_s1_w5_3)=-0.1 v(vn_op0_n100_s1_w5)=0.45 v(vp_op0_n100_s1_w5)=1.35
.ic v(wbl_op0_n100_s1_w7p5)=0 v(rbl_op0_n100_s1_w7p5)=1.8 v(ref_op0_n100_s1_w7p5)=0 v(sn_op0_n100_s1_w7p5_0)=-0.1 v(sn_op0_n100_s1_w7p5_1)=-0.1 v(sn_op0_n100_s1_w7p5_2)=-0.1
.ic v(sn_op0_n100_s1_w7p5_3)=-0.1 v(vn_op0_n100_s1_w7p5)=0.45 v(vp_op0_n100_s1_w7p5)=1.35 v(wbl_op0_n100_s1_w10)=0 v(rbl_op0_n100_s1_w10)=1.8 v(ref_op0_n100_s1_w10)=0
.ic v(sn_op0_n100_s1_w10_0)=-0.1 v(sn_op0_n100_s1_w10_1)=-0.1 v(sn_op0_n100_s1_w10_2)=-0.1 v(sn_op0_n100_s1_w10_3)=-0.1 v(vn_op0_n100_s1_w10)=0.45 v(vp_op0_n100_s1_w10)=1.35
.ic v(wbl_op0_n100_s1_w15)=0 v(rbl_op0_n100_s1_w15)=1.8 v(ref_op0_n100_s1_w15)=0 v(sn_op0_n100_s1_w15_0)=-0.1 v(sn_op0_n100_s1_w15_1)=-0.1 v(sn_op0_n100_s1_w15_2)=-0.1
.ic v(sn_op0_n100_s1_w15_3)=-0.1 v(vn_op0_n100_s1_w15)=0.45 v(vp_op0_n100_s1_w15)=1.35 v(wbl_op0_n100_s1_w20)=0 v(rbl_op0_n100_s1_w20)=1.8 v(ref_op0_n100_s1_w20)=0
.ic v(sn_op0_n100_s1_w20_0)=-0.1 v(sn_op0_n100_s1_w20_1)=-0.1 v(sn_op0_n100_s1_w20_2)=-0.1 v(sn_op0_n100_s1_w20_3)=-0.1 v(vn_op0_n100_s1_w20)=0.45 v(vp_op0_n100_s1_w20)=1.35
.ic v(wbl_op0_n100_s1_w30)=0 v(rbl_op0_n100_s1_w30)=1.8 v(ref_op0_n100_s1_w30)=0 v(sn_op0_n100_s1_w30_0)=-0.1 v(sn_op0_n100_s1_w30_1)=-0.1 v(sn_op0_n100_s1_w30_2)=-0.1
.ic v(sn_op0_n100_s1_w30_3)=-0.1 v(vn_op0_n100_s1_w30)=0.45 v(vp_op0_n100_s1_w30)=1.35 v(wbl_op0_n100_s1_w50)=0 v(rbl_op0_n100_s1_w50)=1.8 v(ref_op0_n100_s1_w50)=0
.ic v(sn_op0_n100_s1_w50_0)=-0.1 v(sn_op0_n100_s1_w50_1)=-0.1 v(sn_op0_n100_s1_w50_2)=-0.1 v(sn_op0_n100_s1_w50_3)=-0.1 v(vn_op0_n100_s1_w50)=0.45 v(vp_op0_n100_s1_w50)=1.35
.ic v(wbl_op0_n100_s2_w0p2)=0 v(rbl_op0_n100_s2_w0p2)=1.8 v(ref_op0_n100_s2_w0p2)=0 v(sn_op0_n100_s2_w0p2_0)=-0.1 v(sn_op0_n100_s2_w0p2_1)=-0.1 v(sn_op0_n100_s2_w0p2_2)=-0.1
.ic v(sn_op0_n100_s2_w0p2_3)=-0.1 v(vn_op0_n100_s2_w0p2)=0.45 v(vp_op0_n100_s2_w0p2)=1.35 v(wbl_op0_n100_s2_w0p5)=0 v(rbl_op0_n100_s2_w0p5)=1.8 v(ref_op0_n100_s2_w0p5)=0
.ic v(sn_op0_n100_s2_w0p5_0)=-0.1 v(sn_op0_n100_s2_w0p5_1)=-0.1 v(sn_op0_n100_s2_w0p5_2)=-0.1 v(sn_op0_n100_s2_w0p5_3)=-0.1 v(vn_op0_n100_s2_w0p5)=0.45 v(vp_op0_n100_s2_w0p5)=1.35
.ic v(wbl_op0_n100_s2_w1)=0 v(rbl_op0_n100_s2_w1)=1.8 v(ref_op0_n100_s2_w1)=0 v(sn_op0_n100_s2_w1_0)=-0.1 v(sn_op0_n100_s2_w1_1)=-0.1 v(sn_op0_n100_s2_w1_2)=-0.1
.ic v(sn_op0_n100_s2_w1_3)=-0.1 v(vn_op0_n100_s2_w1)=0.45 v(vp_op0_n100_s2_w1)=1.35 v(wbl_op0_n100_s2_w2)=0 v(rbl_op0_n100_s2_w2)=1.8 v(ref_op0_n100_s2_w2)=0
.ic v(sn_op0_n100_s2_w2_0)=-0.1 v(sn_op0_n100_s2_w2_1)=-0.1 v(sn_op0_n100_s2_w2_2)=-0.1 v(sn_op0_n100_s2_w2_3)=-0.1 v(vn_op0_n100_s2_w2)=0.45 v(vp_op0_n100_s2_w2)=1.35
.ic v(wbl_op0_n100_s2_w3)=0 v(rbl_op0_n100_s2_w3)=1.8 v(ref_op0_n100_s2_w3)=0 v(sn_op0_n100_s2_w3_0)=-0.1 v(sn_op0_n100_s2_w3_1)=-0.1 v(sn_op0_n100_s2_w3_2)=-0.1
.ic v(sn_op0_n100_s2_w3_3)=-0.1 v(vn_op0_n100_s2_w3)=0.45 v(vp_op0_n100_s2_w3)=1.35 v(wbl_op0_n100_s2_w5)=0 v(rbl_op0_n100_s2_w5)=1.8 v(ref_op0_n100_s2_w5)=0
.ic v(sn_op0_n100_s2_w5_0)=-0.1 v(sn_op0_n100_s2_w5_1)=-0.1 v(sn_op0_n100_s2_w5_2)=-0.1 v(sn_op0_n100_s2_w5_3)=-0.1 v(vn_op0_n100_s2_w5)=0.45 v(vp_op0_n100_s2_w5)=1.35
.ic v(wbl_op0_n100_s2_w7p5)=0 v(rbl_op0_n100_s2_w7p5)=1.8 v(ref_op0_n100_s2_w7p5)=0 v(sn_op0_n100_s2_w7p5_0)=-0.1 v(sn_op0_n100_s2_w7p5_1)=-0.1 v(sn_op0_n100_s2_w7p5_2)=-0.1
.ic v(sn_op0_n100_s2_w7p5_3)=-0.1 v(vn_op0_n100_s2_w7p5)=0.45 v(vp_op0_n100_s2_w7p5)=1.35 v(wbl_op0_n100_s2_w10)=0 v(rbl_op0_n100_s2_w10)=1.8 v(ref_op0_n100_s2_w10)=0
.ic v(sn_op0_n100_s2_w10_0)=-0.1 v(sn_op0_n100_s2_w10_1)=-0.1 v(sn_op0_n100_s2_w10_2)=-0.1 v(sn_op0_n100_s2_w10_3)=-0.1 v(vn_op0_n100_s2_w10)=0.45 v(vp_op0_n100_s2_w10)=1.35
.ic v(wbl_op0_n100_s2_w15)=0 v(rbl_op0_n100_s2_w15)=1.8 v(ref_op0_n100_s2_w15)=0 v(sn_op0_n100_s2_w15_0)=-0.1 v(sn_op0_n100_s2_w15_1)=-0.1 v(sn_op0_n100_s2_w15_2)=-0.1
.ic v(sn_op0_n100_s2_w15_3)=-0.1 v(vn_op0_n100_s2_w15)=0.45 v(vp_op0_n100_s2_w15)=1.35 v(wbl_op0_n100_s2_w20)=0 v(rbl_op0_n100_s2_w20)=1.8 v(ref_op0_n100_s2_w20)=0
.ic v(sn_op0_n100_s2_w20_0)=-0.1 v(sn_op0_n100_s2_w20_1)=-0.1 v(sn_op0_n100_s2_w20_2)=-0.1 v(sn_op0_n100_s2_w20_3)=-0.1 v(vn_op0_n100_s2_w20)=0.45 v(vp_op0_n100_s2_w20)=1.35
.ic v(wbl_op0_n100_s2_w30)=0 v(rbl_op0_n100_s2_w30)=1.8 v(ref_op0_n100_s2_w30)=0 v(sn_op0_n100_s2_w30_0)=-0.1 v(sn_op0_n100_s2_w30_1)=-0.1 v(sn_op0_n100_s2_w30_2)=-0.1
.ic v(sn_op0_n100_s2_w30_3)=-0.1 v(vn_op0_n100_s2_w30)=0.45 v(vp_op0_n100_s2_w30)=1.35 v(wbl_op0_n100_s2_w50)=0 v(rbl_op0_n100_s2_w50)=1.8 v(ref_op0_n100_s2_w50)=0
.ic v(sn_op0_n100_s2_w50_0)=-0.1 v(sn_op0_n100_s2_w50_1)=-0.1 v(sn_op0_n100_s2_w50_2)=-0.1 v(sn_op0_n100_s2_w50_3)=-0.1 v(vn_op0_n100_s2_w50)=0.45 v(vp_op0_n100_s2_w50)=1.35
.ic v(wbl_op0_n100_s5_w0p2)=0 v(rbl_op0_n100_s5_w0p2)=1.8 v(ref_op0_n100_s5_w0p2)=0 v(sn_op0_n100_s5_w0p2_0)=-0.1 v(sn_op0_n100_s5_w0p2_1)=-0.1 v(sn_op0_n100_s5_w0p2_2)=-0.1
.ic v(sn_op0_n100_s5_w0p2_3)=-0.1 v(vn_op0_n100_s5_w0p2)=0.45 v(vp_op0_n100_s5_w0p2)=1.35 v(wbl_op0_n100_s5_w0p5)=0 v(rbl_op0_n100_s5_w0p5)=1.8 v(ref_op0_n100_s5_w0p5)=0
.ic v(sn_op0_n100_s5_w0p5_0)=-0.1 v(sn_op0_n100_s5_w0p5_1)=-0.1 v(sn_op0_n100_s5_w0p5_2)=-0.1 v(sn_op0_n100_s5_w0p5_3)=-0.1 v(vn_op0_n100_s5_w0p5)=0.45 v(vp_op0_n100_s5_w0p5)=1.35
.ic v(wbl_op0_n100_s5_w1)=0 v(rbl_op0_n100_s5_w1)=1.8 v(ref_op0_n100_s5_w1)=0 v(sn_op0_n100_s5_w1_0)=-0.1 v(sn_op0_n100_s5_w1_1)=-0.1 v(sn_op0_n100_s5_w1_2)=-0.1
.ic v(sn_op0_n100_s5_w1_3)=-0.1 v(vn_op0_n100_s5_w1)=0.45 v(vp_op0_n100_s5_w1)=1.35 v(wbl_op0_n100_s5_w2)=0 v(rbl_op0_n100_s5_w2)=1.8 v(ref_op0_n100_s5_w2)=0
.ic v(sn_op0_n100_s5_w2_0)=-0.1 v(sn_op0_n100_s5_w2_1)=-0.1 v(sn_op0_n100_s5_w2_2)=-0.1 v(sn_op0_n100_s5_w2_3)=-0.1 v(vn_op0_n100_s5_w2)=0.45 v(vp_op0_n100_s5_w2)=1.35
.ic v(wbl_op0_n100_s5_w3)=0 v(rbl_op0_n100_s5_w3)=1.8 v(ref_op0_n100_s5_w3)=0 v(sn_op0_n100_s5_w3_0)=-0.1 v(sn_op0_n100_s5_w3_1)=-0.1 v(sn_op0_n100_s5_w3_2)=-0.1
.ic v(sn_op0_n100_s5_w3_3)=-0.1 v(vn_op0_n100_s5_w3)=0.45 v(vp_op0_n100_s5_w3)=1.35 v(wbl_op0_n100_s5_w5)=0 v(rbl_op0_n100_s5_w5)=1.8 v(ref_op0_n100_s5_w5)=0
.ic v(sn_op0_n100_s5_w5_0)=-0.1 v(sn_op0_n100_s5_w5_1)=-0.1 v(sn_op0_n100_s5_w5_2)=-0.1 v(sn_op0_n100_s5_w5_3)=-0.1 v(vn_op0_n100_s5_w5)=0.45 v(vp_op0_n100_s5_w5)=1.35
.ic v(wbl_op0_n100_s5_w7p5)=0 v(rbl_op0_n100_s5_w7p5)=1.8 v(ref_op0_n100_s5_w7p5)=0 v(sn_op0_n100_s5_w7p5_0)=-0.1 v(sn_op0_n100_s5_w7p5_1)=-0.1 v(sn_op0_n100_s5_w7p5_2)=-0.1
.ic v(sn_op0_n100_s5_w7p5_3)=-0.1 v(vn_op0_n100_s5_w7p5)=0.45 v(vp_op0_n100_s5_w7p5)=1.35 v(wbl_op0_n100_s5_w10)=0 v(rbl_op0_n100_s5_w10)=1.8 v(ref_op0_n100_s5_w10)=0
.ic v(sn_op0_n100_s5_w10_0)=-0.1 v(sn_op0_n100_s5_w10_1)=-0.1 v(sn_op0_n100_s5_w10_2)=-0.1 v(sn_op0_n100_s5_w10_3)=-0.1 v(vn_op0_n100_s5_w10)=0.45 v(vp_op0_n100_s5_w10)=1.35
.ic v(wbl_op0_n100_s5_w15)=0 v(rbl_op0_n100_s5_w15)=1.8 v(ref_op0_n100_s5_w15)=0 v(sn_op0_n100_s5_w15_0)=-0.1 v(sn_op0_n100_s5_w15_1)=-0.1 v(sn_op0_n100_s5_w15_2)=-0.1
.ic v(sn_op0_n100_s5_w15_3)=-0.1 v(vn_op0_n100_s5_w15)=0.45 v(vp_op0_n100_s5_w15)=1.35 v(wbl_op0_n100_s5_w20)=0 v(rbl_op0_n100_s5_w20)=1.8 v(ref_op0_n100_s5_w20)=0
.ic v(sn_op0_n100_s5_w20_0)=-0.1 v(sn_op0_n100_s5_w20_1)=-0.1 v(sn_op0_n100_s5_w20_2)=-0.1 v(sn_op0_n100_s5_w20_3)=-0.1 v(vn_op0_n100_s5_w20)=0.45 v(vp_op0_n100_s5_w20)=1.35
.ic v(wbl_op0_n100_s5_w30)=0 v(rbl_op0_n100_s5_w30)=1.8 v(ref_op0_n100_s5_w30)=0 v(sn_op0_n100_s5_w30_0)=-0.1 v(sn_op0_n100_s5_w30_1)=-0.1 v(sn_op0_n100_s5_w30_2)=-0.1
.ic v(sn_op0_n100_s5_w30_3)=-0.1 v(vn_op0_n100_s5_w30)=0.45 v(vp_op0_n100_s5_w30)=1.35 v(wbl_op0_n100_s5_w50)=0 v(rbl_op0_n100_s5_w50)=1.8 v(ref_op0_n100_s5_w50)=0
.ic v(sn_op0_n100_s5_w50_0)=-0.1 v(sn_op0_n100_s5_w50_1)=-0.1 v(sn_op0_n100_s5_w50_2)=-0.1 v(sn_op0_n100_s5_w50_3)=-0.1 v(vn_op0_n100_s5_w50)=0.45 v(vp_op0_n100_s5_w50)=1.35
.ic v(wbl_op0_n100_s10_w0p2)=0 v(rbl_op0_n100_s10_w0p2)=1.8 v(ref_op0_n100_s10_w0p2)=0 v(sn_op0_n100_s10_w0p2_0)=-0.1 v(sn_op0_n100_s10_w0p2_1)=-0.1 v(sn_op0_n100_s10_w0p2_2)=-0.1
.ic v(sn_op0_n100_s10_w0p2_3)=-0.1 v(vn_op0_n100_s10_w0p2)=0.45 v(vp_op0_n100_s10_w0p2)=1.35 v(wbl_op0_n100_s10_w0p5)=0 v(rbl_op0_n100_s10_w0p5)=1.8 v(ref_op0_n100_s10_w0p5)=0
.ic v(sn_op0_n100_s10_w0p5_0)=-0.1 v(sn_op0_n100_s10_w0p5_1)=-0.1 v(sn_op0_n100_s10_w0p5_2)=-0.1 v(sn_op0_n100_s10_w0p5_3)=-0.1 v(vn_op0_n100_s10_w0p5)=0.45 v(vp_op0_n100_s10_w0p5)=1.35
.ic v(wbl_op0_n100_s10_w1)=0 v(rbl_op0_n100_s10_w1)=1.8 v(ref_op0_n100_s10_w1)=0 v(sn_op0_n100_s10_w1_0)=-0.1 v(sn_op0_n100_s10_w1_1)=-0.1 v(sn_op0_n100_s10_w1_2)=-0.1
.ic v(sn_op0_n100_s10_w1_3)=-0.1 v(vn_op0_n100_s10_w1)=0.45 v(vp_op0_n100_s10_w1)=1.35 v(wbl_op0_n100_s10_w2)=0 v(rbl_op0_n100_s10_w2)=1.8 v(ref_op0_n100_s10_w2)=0
.ic v(sn_op0_n100_s10_w2_0)=-0.1 v(sn_op0_n100_s10_w2_1)=-0.1 v(sn_op0_n100_s10_w2_2)=-0.1 v(sn_op0_n100_s10_w2_3)=-0.1 v(vn_op0_n100_s10_w2)=0.45 v(vp_op0_n100_s10_w2)=1.35
.ic v(wbl_op0_n100_s10_w3)=0 v(rbl_op0_n100_s10_w3)=1.8 v(ref_op0_n100_s10_w3)=0 v(sn_op0_n100_s10_w3_0)=-0.1 v(sn_op0_n100_s10_w3_1)=-0.1 v(sn_op0_n100_s10_w3_2)=-0.1
.ic v(sn_op0_n100_s10_w3_3)=-0.1 v(vn_op0_n100_s10_w3)=0.45 v(vp_op0_n100_s10_w3)=1.35 v(wbl_op0_n100_s10_w5)=0 v(rbl_op0_n100_s10_w5)=1.8 v(ref_op0_n100_s10_w5)=0
.ic v(sn_op0_n100_s10_w5_0)=-0.1 v(sn_op0_n100_s10_w5_1)=-0.1 v(sn_op0_n100_s10_w5_2)=-0.1 v(sn_op0_n100_s10_w5_3)=-0.1 v(vn_op0_n100_s10_w5)=0.45 v(vp_op0_n100_s10_w5)=1.35
.ic v(wbl_op0_n100_s10_w7p5)=0 v(rbl_op0_n100_s10_w7p5)=1.8 v(ref_op0_n100_s10_w7p5)=0 v(sn_op0_n100_s10_w7p5_0)=-0.1 v(sn_op0_n100_s10_w7p5_1)=-0.1 v(sn_op0_n100_s10_w7p5_2)=-0.1
.ic v(sn_op0_n100_s10_w7p5_3)=-0.1 v(vn_op0_n100_s10_w7p5)=0.45 v(vp_op0_n100_s10_w7p5)=1.35 v(wbl_op0_n100_s10_w10)=0 v(rbl_op0_n100_s10_w10)=1.8 v(ref_op0_n100_s10_w10)=0
.ic v(sn_op0_n100_s10_w10_0)=-0.1 v(sn_op0_n100_s10_w10_1)=-0.1 v(sn_op0_n100_s10_w10_2)=-0.1 v(sn_op0_n100_s10_w10_3)=-0.1 v(vn_op0_n100_s10_w10)=0.45 v(vp_op0_n100_s10_w10)=1.35
.ic v(wbl_op0_n100_s10_w15)=0 v(rbl_op0_n100_s10_w15)=1.8 v(ref_op0_n100_s10_w15)=0 v(sn_op0_n100_s10_w15_0)=-0.1 v(sn_op0_n100_s10_w15_1)=-0.1 v(sn_op0_n100_s10_w15_2)=-0.1
.ic v(sn_op0_n100_s10_w15_3)=-0.1 v(vn_op0_n100_s10_w15)=0.45 v(vp_op0_n100_s10_w15)=1.35 v(wbl_op0_n100_s10_w20)=0 v(rbl_op0_n100_s10_w20)=1.8 v(ref_op0_n100_s10_w20)=0
.ic v(sn_op0_n100_s10_w20_0)=-0.1 v(sn_op0_n100_s10_w20_1)=-0.1 v(sn_op0_n100_s10_w20_2)=-0.1 v(sn_op0_n100_s10_w20_3)=-0.1 v(vn_op0_n100_s10_w20)=0.45 v(vp_op0_n100_s10_w20)=1.35
.ic v(wbl_op0_n100_s10_w30)=0 v(rbl_op0_n100_s10_w30)=1.8 v(ref_op0_n100_s10_w30)=0 v(sn_op0_n100_s10_w30_0)=-0.1 v(sn_op0_n100_s10_w30_1)=-0.1 v(sn_op0_n100_s10_w30_2)=-0.1
.ic v(sn_op0_n100_s10_w30_3)=-0.1 v(vn_op0_n100_s10_w30)=0.45 v(vp_op0_n100_s10_w30)=1.35 v(wbl_op0_n100_s10_w50)=0 v(rbl_op0_n100_s10_w50)=1.8 v(ref_op0_n100_s10_w50)=0
.ic v(sn_op0_n100_s10_w50_0)=-0.1 v(sn_op0_n100_s10_w50_1)=-0.1 v(sn_op0_n100_s10_w50_2)=-0.1 v(sn_op0_n100_s10_w50_3)=-0.1 v(vn_op0_n100_s10_w50)=0.45 v(vp_op0_n100_s10_w50)=1.35
.ic v(wbl_op0_0000_s0p5_w0p2)=0 v(rbl_op0_0000_s0p5_w0p2)=1.8 v(ref_op0_0000_s0p5_w0p2)=0 v(sn_op0_0000_s0p5_w0p2_0)=0 v(sn_op0_0000_s0p5_w0p2_1)=0 v(sn_op0_0000_s0p5_w0p2_2)=0
.ic v(sn_op0_0000_s0p5_w0p2_3)=0 v(vn_op0_0000_s0p5_w0p2)=0.45 v(vp_op0_0000_s0p5_w0p2)=1.35 v(wbl_op0_0000_s0p5_w0p5)=0 v(rbl_op0_0000_s0p5_w0p5)=1.8 v(ref_op0_0000_s0p5_w0p5)=0
.ic v(sn_op0_0000_s0p5_w0p5_0)=0 v(sn_op0_0000_s0p5_w0p5_1)=0 v(sn_op0_0000_s0p5_w0p5_2)=0 v(sn_op0_0000_s0p5_w0p5_3)=0 v(vn_op0_0000_s0p5_w0p5)=0.45 v(vp_op0_0000_s0p5_w0p5)=1.35
.ic v(wbl_op0_0000_s0p5_w1)=0 v(rbl_op0_0000_s0p5_w1)=1.8 v(ref_op0_0000_s0p5_w1)=0 v(sn_op0_0000_s0p5_w1_0)=0 v(sn_op0_0000_s0p5_w1_1)=0 v(sn_op0_0000_s0p5_w1_2)=0
.ic v(sn_op0_0000_s0p5_w1_3)=0 v(vn_op0_0000_s0p5_w1)=0.45 v(vp_op0_0000_s0p5_w1)=1.35 v(wbl_op0_0000_s0p5_w2)=0 v(rbl_op0_0000_s0p5_w2)=1.8 v(ref_op0_0000_s0p5_w2)=0
.ic v(sn_op0_0000_s0p5_w2_0)=0 v(sn_op0_0000_s0p5_w2_1)=0 v(sn_op0_0000_s0p5_w2_2)=0 v(sn_op0_0000_s0p5_w2_3)=0 v(vn_op0_0000_s0p5_w2)=0.45 v(vp_op0_0000_s0p5_w2)=1.35
.ic v(wbl_op0_0000_s0p5_w3)=0 v(rbl_op0_0000_s0p5_w3)=1.8 v(ref_op0_0000_s0p5_w3)=0 v(sn_op0_0000_s0p5_w3_0)=0 v(sn_op0_0000_s0p5_w3_1)=0 v(sn_op0_0000_s0p5_w3_2)=0
.ic v(sn_op0_0000_s0p5_w3_3)=0 v(vn_op0_0000_s0p5_w3)=0.45 v(vp_op0_0000_s0p5_w3)=1.35 v(wbl_op0_0000_s0p5_w5)=0 v(rbl_op0_0000_s0p5_w5)=1.8 v(ref_op0_0000_s0p5_w5)=0
.ic v(sn_op0_0000_s0p5_w5_0)=0 v(sn_op0_0000_s0p5_w5_1)=0 v(sn_op0_0000_s0p5_w5_2)=0 v(sn_op0_0000_s0p5_w5_3)=0 v(vn_op0_0000_s0p5_w5)=0.45 v(vp_op0_0000_s0p5_w5)=1.35
.ic v(wbl_op0_0000_s0p5_w7p5)=0 v(rbl_op0_0000_s0p5_w7p5)=1.8 v(ref_op0_0000_s0p5_w7p5)=0 v(sn_op0_0000_s0p5_w7p5_0)=0 v(sn_op0_0000_s0p5_w7p5_1)=0 v(sn_op0_0000_s0p5_w7p5_2)=0
.ic v(sn_op0_0000_s0p5_w7p5_3)=0 v(vn_op0_0000_s0p5_w7p5)=0.45 v(vp_op0_0000_s0p5_w7p5)=1.35 v(wbl_op0_0000_s0p5_w10)=0 v(rbl_op0_0000_s0p5_w10)=1.8 v(ref_op0_0000_s0p5_w10)=0
.ic v(sn_op0_0000_s0p5_w10_0)=0 v(sn_op0_0000_s0p5_w10_1)=0 v(sn_op0_0000_s0p5_w10_2)=0 v(sn_op0_0000_s0p5_w10_3)=0 v(vn_op0_0000_s0p5_w10)=0.45 v(vp_op0_0000_s0p5_w10)=1.35
.ic v(wbl_op0_0000_s0p5_w15)=0 v(rbl_op0_0000_s0p5_w15)=1.8 v(ref_op0_0000_s0p5_w15)=0 v(sn_op0_0000_s0p5_w15_0)=0 v(sn_op0_0000_s0p5_w15_1)=0 v(sn_op0_0000_s0p5_w15_2)=0
.ic v(sn_op0_0000_s0p5_w15_3)=0 v(vn_op0_0000_s0p5_w15)=0.45 v(vp_op0_0000_s0p5_w15)=1.35 v(wbl_op0_0000_s0p5_w20)=0 v(rbl_op0_0000_s0p5_w20)=1.8 v(ref_op0_0000_s0p5_w20)=0
.ic v(sn_op0_0000_s0p5_w20_0)=0 v(sn_op0_0000_s0p5_w20_1)=0 v(sn_op0_0000_s0p5_w20_2)=0 v(sn_op0_0000_s0p5_w20_3)=0 v(vn_op0_0000_s0p5_w20)=0.45 v(vp_op0_0000_s0p5_w20)=1.35
.ic v(wbl_op0_0000_s0p5_w30)=0 v(rbl_op0_0000_s0p5_w30)=1.8 v(ref_op0_0000_s0p5_w30)=0 v(sn_op0_0000_s0p5_w30_0)=0 v(sn_op0_0000_s0p5_w30_1)=0 v(sn_op0_0000_s0p5_w30_2)=0
.ic v(sn_op0_0000_s0p5_w30_3)=0 v(vn_op0_0000_s0p5_w30)=0.45 v(vp_op0_0000_s0p5_w30)=1.35 v(wbl_op0_0000_s0p5_w50)=0 v(rbl_op0_0000_s0p5_w50)=1.8 v(ref_op0_0000_s0p5_w50)=0
.ic v(sn_op0_0000_s0p5_w50_0)=0 v(sn_op0_0000_s0p5_w50_1)=0 v(sn_op0_0000_s0p5_w50_2)=0 v(sn_op0_0000_s0p5_w50_3)=0 v(vn_op0_0000_s0p5_w50)=0.45 v(vp_op0_0000_s0p5_w50)=1.35
.ic v(wbl_op0_0000_s1_w0p2)=0 v(rbl_op0_0000_s1_w0p2)=1.8 v(ref_op0_0000_s1_w0p2)=0 v(sn_op0_0000_s1_w0p2_0)=0 v(sn_op0_0000_s1_w0p2_1)=0 v(sn_op0_0000_s1_w0p2_2)=0
.ic v(sn_op0_0000_s1_w0p2_3)=0 v(vn_op0_0000_s1_w0p2)=0.45 v(vp_op0_0000_s1_w0p2)=1.35 v(wbl_op0_0000_s1_w0p5)=0 v(rbl_op0_0000_s1_w0p5)=1.8 v(ref_op0_0000_s1_w0p5)=0
.ic v(sn_op0_0000_s1_w0p5_0)=0 v(sn_op0_0000_s1_w0p5_1)=0 v(sn_op0_0000_s1_w0p5_2)=0 v(sn_op0_0000_s1_w0p5_3)=0 v(vn_op0_0000_s1_w0p5)=0.45 v(vp_op0_0000_s1_w0p5)=1.35
.ic v(wbl_op0_0000_s1_w1)=0 v(rbl_op0_0000_s1_w1)=1.8 v(ref_op0_0000_s1_w1)=0 v(sn_op0_0000_s1_w1_0)=0 v(sn_op0_0000_s1_w1_1)=0 v(sn_op0_0000_s1_w1_2)=0
.ic v(sn_op0_0000_s1_w1_3)=0 v(vn_op0_0000_s1_w1)=0.45 v(vp_op0_0000_s1_w1)=1.35 v(wbl_op0_0000_s1_w2)=0 v(rbl_op0_0000_s1_w2)=1.8 v(ref_op0_0000_s1_w2)=0
.ic v(sn_op0_0000_s1_w2_0)=0 v(sn_op0_0000_s1_w2_1)=0 v(sn_op0_0000_s1_w2_2)=0 v(sn_op0_0000_s1_w2_3)=0 v(vn_op0_0000_s1_w2)=0.45 v(vp_op0_0000_s1_w2)=1.35
.ic v(wbl_op0_0000_s1_w3)=0 v(rbl_op0_0000_s1_w3)=1.8 v(ref_op0_0000_s1_w3)=0 v(sn_op0_0000_s1_w3_0)=0 v(sn_op0_0000_s1_w3_1)=0 v(sn_op0_0000_s1_w3_2)=0
.ic v(sn_op0_0000_s1_w3_3)=0 v(vn_op0_0000_s1_w3)=0.45 v(vp_op0_0000_s1_w3)=1.35 v(wbl_op0_0000_s1_w5)=0 v(rbl_op0_0000_s1_w5)=1.8 v(ref_op0_0000_s1_w5)=0
.ic v(sn_op0_0000_s1_w5_0)=0 v(sn_op0_0000_s1_w5_1)=0 v(sn_op0_0000_s1_w5_2)=0 v(sn_op0_0000_s1_w5_3)=0 v(vn_op0_0000_s1_w5)=0.45 v(vp_op0_0000_s1_w5)=1.35
.ic v(wbl_op0_0000_s1_w7p5)=0 v(rbl_op0_0000_s1_w7p5)=1.8 v(ref_op0_0000_s1_w7p5)=0 v(sn_op0_0000_s1_w7p5_0)=0 v(sn_op0_0000_s1_w7p5_1)=0 v(sn_op0_0000_s1_w7p5_2)=0
.ic v(sn_op0_0000_s1_w7p5_3)=0 v(vn_op0_0000_s1_w7p5)=0.45 v(vp_op0_0000_s1_w7p5)=1.35 v(wbl_op0_0000_s1_w10)=0 v(rbl_op0_0000_s1_w10)=1.8 v(ref_op0_0000_s1_w10)=0
.ic v(sn_op0_0000_s1_w10_0)=0 v(sn_op0_0000_s1_w10_1)=0 v(sn_op0_0000_s1_w10_2)=0 v(sn_op0_0000_s1_w10_3)=0 v(vn_op0_0000_s1_w10)=0.45 v(vp_op0_0000_s1_w10)=1.35
.ic v(wbl_op0_0000_s1_w15)=0 v(rbl_op0_0000_s1_w15)=1.8 v(ref_op0_0000_s1_w15)=0 v(sn_op0_0000_s1_w15_0)=0 v(sn_op0_0000_s1_w15_1)=0 v(sn_op0_0000_s1_w15_2)=0
.ic v(sn_op0_0000_s1_w15_3)=0 v(vn_op0_0000_s1_w15)=0.45 v(vp_op0_0000_s1_w15)=1.35 v(wbl_op0_0000_s1_w20)=0 v(rbl_op0_0000_s1_w20)=1.8 v(ref_op0_0000_s1_w20)=0
.ic v(sn_op0_0000_s1_w20_0)=0 v(sn_op0_0000_s1_w20_1)=0 v(sn_op0_0000_s1_w20_2)=0 v(sn_op0_0000_s1_w20_3)=0 v(vn_op0_0000_s1_w20)=0.45 v(vp_op0_0000_s1_w20)=1.35
.ic v(wbl_op0_0000_s1_w30)=0 v(rbl_op0_0000_s1_w30)=1.8 v(ref_op0_0000_s1_w30)=0 v(sn_op0_0000_s1_w30_0)=0 v(sn_op0_0000_s1_w30_1)=0 v(sn_op0_0000_s1_w30_2)=0
.ic v(sn_op0_0000_s1_w30_3)=0 v(vn_op0_0000_s1_w30)=0.45 v(vp_op0_0000_s1_w30)=1.35 v(wbl_op0_0000_s1_w50)=0 v(rbl_op0_0000_s1_w50)=1.8 v(ref_op0_0000_s1_w50)=0
.ic v(sn_op0_0000_s1_w50_0)=0 v(sn_op0_0000_s1_w50_1)=0 v(sn_op0_0000_s1_w50_2)=0 v(sn_op0_0000_s1_w50_3)=0 v(vn_op0_0000_s1_w50)=0.45 v(vp_op0_0000_s1_w50)=1.35
.ic v(wbl_op0_0000_s2_w0p2)=0 v(rbl_op0_0000_s2_w0p2)=1.8 v(ref_op0_0000_s2_w0p2)=0 v(sn_op0_0000_s2_w0p2_0)=0 v(sn_op0_0000_s2_w0p2_1)=0 v(sn_op0_0000_s2_w0p2_2)=0
.ic v(sn_op0_0000_s2_w0p2_3)=0 v(vn_op0_0000_s2_w0p2)=0.45 v(vp_op0_0000_s2_w0p2)=1.35 v(wbl_op0_0000_s2_w0p5)=0 v(rbl_op0_0000_s2_w0p5)=1.8 v(ref_op0_0000_s2_w0p5)=0
.ic v(sn_op0_0000_s2_w0p5_0)=0 v(sn_op0_0000_s2_w0p5_1)=0 v(sn_op0_0000_s2_w0p5_2)=0 v(sn_op0_0000_s2_w0p5_3)=0 v(vn_op0_0000_s2_w0p5)=0.45 v(vp_op0_0000_s2_w0p5)=1.35
.ic v(wbl_op0_0000_s2_w1)=0 v(rbl_op0_0000_s2_w1)=1.8 v(ref_op0_0000_s2_w1)=0 v(sn_op0_0000_s2_w1_0)=0 v(sn_op0_0000_s2_w1_1)=0 v(sn_op0_0000_s2_w1_2)=0
.ic v(sn_op0_0000_s2_w1_3)=0 v(vn_op0_0000_s2_w1)=0.45 v(vp_op0_0000_s2_w1)=1.35 v(wbl_op0_0000_s2_w2)=0 v(rbl_op0_0000_s2_w2)=1.8 v(ref_op0_0000_s2_w2)=0
.ic v(sn_op0_0000_s2_w2_0)=0 v(sn_op0_0000_s2_w2_1)=0 v(sn_op0_0000_s2_w2_2)=0 v(sn_op0_0000_s2_w2_3)=0 v(vn_op0_0000_s2_w2)=0.45 v(vp_op0_0000_s2_w2)=1.35
.ic v(wbl_op0_0000_s2_w3)=0 v(rbl_op0_0000_s2_w3)=1.8 v(ref_op0_0000_s2_w3)=0 v(sn_op0_0000_s2_w3_0)=0 v(sn_op0_0000_s2_w3_1)=0 v(sn_op0_0000_s2_w3_2)=0
.ic v(sn_op0_0000_s2_w3_3)=0 v(vn_op0_0000_s2_w3)=0.45 v(vp_op0_0000_s2_w3)=1.35 v(wbl_op0_0000_s2_w5)=0 v(rbl_op0_0000_s2_w5)=1.8 v(ref_op0_0000_s2_w5)=0
.ic v(sn_op0_0000_s2_w5_0)=0 v(sn_op0_0000_s2_w5_1)=0 v(sn_op0_0000_s2_w5_2)=0 v(sn_op0_0000_s2_w5_3)=0 v(vn_op0_0000_s2_w5)=0.45 v(vp_op0_0000_s2_w5)=1.35
.ic v(wbl_op0_0000_s2_w7p5)=0 v(rbl_op0_0000_s2_w7p5)=1.8 v(ref_op0_0000_s2_w7p5)=0 v(sn_op0_0000_s2_w7p5_0)=0 v(sn_op0_0000_s2_w7p5_1)=0 v(sn_op0_0000_s2_w7p5_2)=0
.ic v(sn_op0_0000_s2_w7p5_3)=0 v(vn_op0_0000_s2_w7p5)=0.45 v(vp_op0_0000_s2_w7p5)=1.35 v(wbl_op0_0000_s2_w10)=0 v(rbl_op0_0000_s2_w10)=1.8 v(ref_op0_0000_s2_w10)=0
.ic v(sn_op0_0000_s2_w10_0)=0 v(sn_op0_0000_s2_w10_1)=0 v(sn_op0_0000_s2_w10_2)=0 v(sn_op0_0000_s2_w10_3)=0 v(vn_op0_0000_s2_w10)=0.45 v(vp_op0_0000_s2_w10)=1.35
.ic v(wbl_op0_0000_s2_w15)=0 v(rbl_op0_0000_s2_w15)=1.8 v(ref_op0_0000_s2_w15)=0 v(sn_op0_0000_s2_w15_0)=0 v(sn_op0_0000_s2_w15_1)=0 v(sn_op0_0000_s2_w15_2)=0
.ic v(sn_op0_0000_s2_w15_3)=0 v(vn_op0_0000_s2_w15)=0.45 v(vp_op0_0000_s2_w15)=1.35 v(wbl_op0_0000_s2_w20)=0 v(rbl_op0_0000_s2_w20)=1.8 v(ref_op0_0000_s2_w20)=0
.ic v(sn_op0_0000_s2_w20_0)=0 v(sn_op0_0000_s2_w20_1)=0 v(sn_op0_0000_s2_w20_2)=0 v(sn_op0_0000_s2_w20_3)=0 v(vn_op0_0000_s2_w20)=0.45 v(vp_op0_0000_s2_w20)=1.35
.ic v(wbl_op0_0000_s2_w30)=0 v(rbl_op0_0000_s2_w30)=1.8 v(ref_op0_0000_s2_w30)=0 v(sn_op0_0000_s2_w30_0)=0 v(sn_op0_0000_s2_w30_1)=0 v(sn_op0_0000_s2_w30_2)=0
.ic v(sn_op0_0000_s2_w30_3)=0 v(vn_op0_0000_s2_w30)=0.45 v(vp_op0_0000_s2_w30)=1.35 v(wbl_op0_0000_s2_w50)=0 v(rbl_op0_0000_s2_w50)=1.8 v(ref_op0_0000_s2_w50)=0
.ic v(sn_op0_0000_s2_w50_0)=0 v(sn_op0_0000_s2_w50_1)=0 v(sn_op0_0000_s2_w50_2)=0 v(sn_op0_0000_s2_w50_3)=0 v(vn_op0_0000_s2_w50)=0.45 v(vp_op0_0000_s2_w50)=1.35
.ic v(wbl_op0_0000_s5_w0p2)=0 v(rbl_op0_0000_s5_w0p2)=1.8 v(ref_op0_0000_s5_w0p2)=0 v(sn_op0_0000_s5_w0p2_0)=0 v(sn_op0_0000_s5_w0p2_1)=0 v(sn_op0_0000_s5_w0p2_2)=0
.ic v(sn_op0_0000_s5_w0p2_3)=0 v(vn_op0_0000_s5_w0p2)=0.45 v(vp_op0_0000_s5_w0p2)=1.35 v(wbl_op0_0000_s5_w0p5)=0 v(rbl_op0_0000_s5_w0p5)=1.8 v(ref_op0_0000_s5_w0p5)=0
.ic v(sn_op0_0000_s5_w0p5_0)=0 v(sn_op0_0000_s5_w0p5_1)=0 v(sn_op0_0000_s5_w0p5_2)=0 v(sn_op0_0000_s5_w0p5_3)=0 v(vn_op0_0000_s5_w0p5)=0.45 v(vp_op0_0000_s5_w0p5)=1.35
.ic v(wbl_op0_0000_s5_w1)=0 v(rbl_op0_0000_s5_w1)=1.8 v(ref_op0_0000_s5_w1)=0 v(sn_op0_0000_s5_w1_0)=0 v(sn_op0_0000_s5_w1_1)=0 v(sn_op0_0000_s5_w1_2)=0
.ic v(sn_op0_0000_s5_w1_3)=0 v(vn_op0_0000_s5_w1)=0.45 v(vp_op0_0000_s5_w1)=1.35 v(wbl_op0_0000_s5_w2)=0 v(rbl_op0_0000_s5_w2)=1.8 v(ref_op0_0000_s5_w2)=0
.ic v(sn_op0_0000_s5_w2_0)=0 v(sn_op0_0000_s5_w2_1)=0 v(sn_op0_0000_s5_w2_2)=0 v(sn_op0_0000_s5_w2_3)=0 v(vn_op0_0000_s5_w2)=0.45 v(vp_op0_0000_s5_w2)=1.35
.ic v(wbl_op0_0000_s5_w3)=0 v(rbl_op0_0000_s5_w3)=1.8 v(ref_op0_0000_s5_w3)=0 v(sn_op0_0000_s5_w3_0)=0 v(sn_op0_0000_s5_w3_1)=0 v(sn_op0_0000_s5_w3_2)=0
.ic v(sn_op0_0000_s5_w3_3)=0 v(vn_op0_0000_s5_w3)=0.45 v(vp_op0_0000_s5_w3)=1.35 v(wbl_op0_0000_s5_w5)=0 v(rbl_op0_0000_s5_w5)=1.8 v(ref_op0_0000_s5_w5)=0
.ic v(sn_op0_0000_s5_w5_0)=0 v(sn_op0_0000_s5_w5_1)=0 v(sn_op0_0000_s5_w5_2)=0 v(sn_op0_0000_s5_w5_3)=0 v(vn_op0_0000_s5_w5)=0.45 v(vp_op0_0000_s5_w5)=1.35
.ic v(wbl_op0_0000_s5_w7p5)=0 v(rbl_op0_0000_s5_w7p5)=1.8 v(ref_op0_0000_s5_w7p5)=0 v(sn_op0_0000_s5_w7p5_0)=0 v(sn_op0_0000_s5_w7p5_1)=0 v(sn_op0_0000_s5_w7p5_2)=0
.ic v(sn_op0_0000_s5_w7p5_3)=0 v(vn_op0_0000_s5_w7p5)=0.45 v(vp_op0_0000_s5_w7p5)=1.35 v(wbl_op0_0000_s5_w10)=0 v(rbl_op0_0000_s5_w10)=1.8 v(ref_op0_0000_s5_w10)=0
.ic v(sn_op0_0000_s5_w10_0)=0 v(sn_op0_0000_s5_w10_1)=0 v(sn_op0_0000_s5_w10_2)=0 v(sn_op0_0000_s5_w10_3)=0 v(vn_op0_0000_s5_w10)=0.45 v(vp_op0_0000_s5_w10)=1.35
.ic v(wbl_op0_0000_s5_w15)=0 v(rbl_op0_0000_s5_w15)=1.8 v(ref_op0_0000_s5_w15)=0 v(sn_op0_0000_s5_w15_0)=0 v(sn_op0_0000_s5_w15_1)=0 v(sn_op0_0000_s5_w15_2)=0
.ic v(sn_op0_0000_s5_w15_3)=0 v(vn_op0_0000_s5_w15)=0.45 v(vp_op0_0000_s5_w15)=1.35 v(wbl_op0_0000_s5_w20)=0 v(rbl_op0_0000_s5_w20)=1.8 v(ref_op0_0000_s5_w20)=0
.ic v(sn_op0_0000_s5_w20_0)=0 v(sn_op0_0000_s5_w20_1)=0 v(sn_op0_0000_s5_w20_2)=0 v(sn_op0_0000_s5_w20_3)=0 v(vn_op0_0000_s5_w20)=0.45 v(vp_op0_0000_s5_w20)=1.35
.ic v(wbl_op0_0000_s5_w30)=0 v(rbl_op0_0000_s5_w30)=1.8 v(ref_op0_0000_s5_w30)=0 v(sn_op0_0000_s5_w30_0)=0 v(sn_op0_0000_s5_w30_1)=0 v(sn_op0_0000_s5_w30_2)=0
.ic v(sn_op0_0000_s5_w30_3)=0 v(vn_op0_0000_s5_w30)=0.45 v(vp_op0_0000_s5_w30)=1.35 v(wbl_op0_0000_s5_w50)=0 v(rbl_op0_0000_s5_w50)=1.8 v(ref_op0_0000_s5_w50)=0
.ic v(sn_op0_0000_s5_w50_0)=0 v(sn_op0_0000_s5_w50_1)=0 v(sn_op0_0000_s5_w50_2)=0 v(sn_op0_0000_s5_w50_3)=0 v(vn_op0_0000_s5_w50)=0.45 v(vp_op0_0000_s5_w50)=1.35
.ic v(wbl_op0_0000_s10_w0p2)=0 v(rbl_op0_0000_s10_w0p2)=1.8 v(ref_op0_0000_s10_w0p2)=0 v(sn_op0_0000_s10_w0p2_0)=0 v(sn_op0_0000_s10_w0p2_1)=0 v(sn_op0_0000_s10_w0p2_2)=0
.ic v(sn_op0_0000_s10_w0p2_3)=0 v(vn_op0_0000_s10_w0p2)=0.45 v(vp_op0_0000_s10_w0p2)=1.35 v(wbl_op0_0000_s10_w0p5)=0 v(rbl_op0_0000_s10_w0p5)=1.8 v(ref_op0_0000_s10_w0p5)=0
.ic v(sn_op0_0000_s10_w0p5_0)=0 v(sn_op0_0000_s10_w0p5_1)=0 v(sn_op0_0000_s10_w0p5_2)=0 v(sn_op0_0000_s10_w0p5_3)=0 v(vn_op0_0000_s10_w0p5)=0.45 v(vp_op0_0000_s10_w0p5)=1.35
.ic v(wbl_op0_0000_s10_w1)=0 v(rbl_op0_0000_s10_w1)=1.8 v(ref_op0_0000_s10_w1)=0 v(sn_op0_0000_s10_w1_0)=0 v(sn_op0_0000_s10_w1_1)=0 v(sn_op0_0000_s10_w1_2)=0
.ic v(sn_op0_0000_s10_w1_3)=0 v(vn_op0_0000_s10_w1)=0.45 v(vp_op0_0000_s10_w1)=1.35 v(wbl_op0_0000_s10_w2)=0 v(rbl_op0_0000_s10_w2)=1.8 v(ref_op0_0000_s10_w2)=0
.ic v(sn_op0_0000_s10_w2_0)=0 v(sn_op0_0000_s10_w2_1)=0 v(sn_op0_0000_s10_w2_2)=0 v(sn_op0_0000_s10_w2_3)=0 v(vn_op0_0000_s10_w2)=0.45 v(vp_op0_0000_s10_w2)=1.35
.ic v(wbl_op0_0000_s10_w3)=0 v(rbl_op0_0000_s10_w3)=1.8 v(ref_op0_0000_s10_w3)=0 v(sn_op0_0000_s10_w3_0)=0 v(sn_op0_0000_s10_w3_1)=0 v(sn_op0_0000_s10_w3_2)=0
.ic v(sn_op0_0000_s10_w3_3)=0 v(vn_op0_0000_s10_w3)=0.45 v(vp_op0_0000_s10_w3)=1.35 v(wbl_op0_0000_s10_w5)=0 v(rbl_op0_0000_s10_w5)=1.8 v(ref_op0_0000_s10_w5)=0
.ic v(sn_op0_0000_s10_w5_0)=0 v(sn_op0_0000_s10_w5_1)=0 v(sn_op0_0000_s10_w5_2)=0 v(sn_op0_0000_s10_w5_3)=0 v(vn_op0_0000_s10_w5)=0.45 v(vp_op0_0000_s10_w5)=1.35
.ic v(wbl_op0_0000_s10_w7p5)=0 v(rbl_op0_0000_s10_w7p5)=1.8 v(ref_op0_0000_s10_w7p5)=0 v(sn_op0_0000_s10_w7p5_0)=0 v(sn_op0_0000_s10_w7p5_1)=0 v(sn_op0_0000_s10_w7p5_2)=0
.ic v(sn_op0_0000_s10_w7p5_3)=0 v(vn_op0_0000_s10_w7p5)=0.45 v(vp_op0_0000_s10_w7p5)=1.35 v(wbl_op0_0000_s10_w10)=0 v(rbl_op0_0000_s10_w10)=1.8 v(ref_op0_0000_s10_w10)=0
.ic v(sn_op0_0000_s10_w10_0)=0 v(sn_op0_0000_s10_w10_1)=0 v(sn_op0_0000_s10_w10_2)=0 v(sn_op0_0000_s10_w10_3)=0 v(vn_op0_0000_s10_w10)=0.45 v(vp_op0_0000_s10_w10)=1.35
.ic v(wbl_op0_0000_s10_w15)=0 v(rbl_op0_0000_s10_w15)=1.8 v(ref_op0_0000_s10_w15)=0 v(sn_op0_0000_s10_w15_0)=0 v(sn_op0_0000_s10_w15_1)=0 v(sn_op0_0000_s10_w15_2)=0
.ic v(sn_op0_0000_s10_w15_3)=0 v(vn_op0_0000_s10_w15)=0.45 v(vp_op0_0000_s10_w15)=1.35 v(wbl_op0_0000_s10_w20)=0 v(rbl_op0_0000_s10_w20)=1.8 v(ref_op0_0000_s10_w20)=0
.ic v(sn_op0_0000_s10_w20_0)=0 v(sn_op0_0000_s10_w20_1)=0 v(sn_op0_0000_s10_w20_2)=0 v(sn_op0_0000_s10_w20_3)=0 v(vn_op0_0000_s10_w20)=0.45 v(vp_op0_0000_s10_w20)=1.35
.ic v(wbl_op0_0000_s10_w30)=0 v(rbl_op0_0000_s10_w30)=1.8 v(ref_op0_0000_s10_w30)=0 v(sn_op0_0000_s10_w30_0)=0 v(sn_op0_0000_s10_w30_1)=0 v(sn_op0_0000_s10_w30_2)=0
.ic v(sn_op0_0000_s10_w30_3)=0 v(vn_op0_0000_s10_w30)=0.45 v(vp_op0_0000_s10_w30)=1.35 v(wbl_op0_0000_s10_w50)=0 v(rbl_op0_0000_s10_w50)=1.8 v(ref_op0_0000_s10_w50)=0
.ic v(sn_op0_0000_s10_w50_0)=0 v(sn_op0_0000_s10_w50_1)=0 v(sn_op0_0000_s10_w50_2)=0 v(sn_op0_0000_s10_w50_3)=0 v(vn_op0_0000_s10_w50)=0.45 v(vp_op0_0000_s10_w50)=1.35
.ic v(wbl_refw)=1.8 v(rbl_refw)=1.8 v(ref_refw)=0 v(sn_refw_0)=0 v(sn_refw_1)=0 v(sn_refw_2)=0
.ic v(sn_refw_3)=0 v(vn_refw)=0.45 v(vp_refw)=1.35
