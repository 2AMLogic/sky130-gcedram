* gain_cell_2t_schematic.spice -- bitcell schematic leg for the klt pex
* retention comparison (issue #383). GENERATED by gen_reference_netlists.py; do not edit.
* The two SKY130 device cards are design/gain_cell_2t.spice verbatim
* (sha256:7d1fe877ee5a7789e5b6f4b29788e1ecd927112de99e3156ba246eb2dcb73ad5); the active wrapper's name and ORDERED pin list are the
* committed extraction's own header (gain_cell_2t.extract.parasitics.spice).
* The source's commented wrapper and top-level terminator are omitted.
.SUBCKT gain_cell_2t_layout_0 GND bl rbl rwl sn wl
XM_WR sn wl bl GND sky130_fd_pr__nfet_01v8 L=0.15 W=0.42 nf=1 ad=0.1218 as=0.1218 pd=1.42 ps=1.42 nrd=0.69047619047619
+ nrs=0.69047619047619 sa=0 sb=0 sd=0 mult=1 m=1
XM_RD rbl sn rwl GND sky130_fd_pr__nfet_01v8 L=0.15 W=0.42 nf=1 ad=0.1218 as=0.1218 pd=1.42 ps=1.42 nrd=0.69047619047619
+ nrs=0.69047619047619 sa=0 sb=0 sd=0 mult=1 m=1
.ENDS gain_cell_2t_layout_0
