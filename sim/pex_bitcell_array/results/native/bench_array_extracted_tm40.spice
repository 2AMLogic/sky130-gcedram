* bench_extracted -- write/read/hold transient for the gain_cell_2t_array_4x4_layout_0 extracted leg (issue #383).
* GENERATED by measure_pex_retention.py via pex_bench.build_bench(); do not edit.
* Circuit body for `klt sim`: the PDK .lib / .temp are appended per corner by klt;
* analysis and .meas cards are in the sibling request_*.json.
* Same phase timing / bias as sim/bitcell-transient/bitcell_d1.spice (parsed from
* tb_bitcell_transient.spice.tmpl -- single source of truth). The template's lumped
* extracted c_sn is OMITTED: the fresh extraction supplies
* storage-node wiring capacitance exactly once.
* extracted-leg DUT, inlined verbatim from /home/ubuntu/GitHub/sky130-gcedram/.loom/worktrees/issue-383/sim/pex_bitcell_array/work/array/extracted.spice (sha256:4f22027b55f315929b42939bfee4019d5c31f3a77091abf5d9faf96f00f15c0b).
*
.param VDD    = 1.8
.param VRBL   = 0.9
.param TEDGE       = 1.000000e-10
.param TWL_ON      = 1.000000e-09
.param TWL_OFF     = 2.100000e-08
.param TBL_OFF     = 2.300000e-08
.param TRWL_ON     = 3.000000e-08
.param TRWL_OFF    = 5.000000e-08
.param THOLD_START = 5.500000e-08
.param VBL_DATA = 1.8
.param VSN_INIT = 0
* extracted by klt extract --deck sky130
* parasitic model (--parasitics):
* - capacitance: net-to-ground for every net's own (non-coupled) area/perimeter, plus net-to-net for the vertical-overlap coupling `coupling` describes below -- a coupled net pair gets a direct capacitor between their two hub nodes, not just capacitors to the deck's ground/substrate net
* - coupling: vertical overlap (crossover) unconditionally -- where one net's conductor on an adjacent metal level sits directly over another *distinct* net's conductor, that overlap area is charged between the two nets instead of to ground (issue #760) -- plus lateral (same-layer, sidewall) coupling, but only for a net pair naming one of the caller's declared `--critical-net` nets (issue #976): facing-edge length within that layer's own minimum-spacing lookback is charged between the two nets, *additively* (not deducted from either net's substrate fringe term, unlike the vertical case -- a known simplification). Any same-layer pair with neither side named `--critical-net`, and fringe shielding in general, are still not modelled
* - resistance: single lumped series resistance per net, distributed as a star across that net's device terminals (issue #592) -- not a per-segment, distributed RC ladder, *unless* `--distributed-rc` names this net via `--critical-net` (issue #977, Epic #709 Phase 2b): then the net's terminals are ordered along their approximate physical spread and its total R/C is broken into a chain of per-segment resistors (segment length proportional to inter-terminal distance) with a ground capacitor at each terminal node (proportional to its adjacent segment length/2), instead of one star hub -- still an approximation (terminal position is a device-placement proxy, not true per-segment routing geometry), but a strictly finer-grained one than the single-hub star
* - frequency: quasi-static -- one frequency-independent R and C per net; no skin effect, no distributed transmission-line behavior
* - substrate tie: 1e+12 ohm to ground -- the substrate is capacitively floating in transient analysis (DC reference only); see --substrate-tie-ohms
.GLOBAL vsubs

* cell gain_cell_2t_array_4x4_layout_0
* pin GND
* pin bl_0
* pin bl_1
* pin bl_2
* pin bl_3
* pin rbl_0
* pin rbl_1
* pin rbl_2
* pin rbl_3
* pin rwl_0
* pin rwl_1
* pin rwl_2
* pin rwl_3
* pin sn_0_0
* pin sn_0_1
* pin sn_0_2
* pin sn_0_3
* pin sn_1_0
* pin sn_1_1
* pin sn_1_2
* pin sn_1_3
* pin sn_2_0
* pin sn_2_1
* pin sn_2_2
* pin sn_2_3
* pin sn_3_0
* pin sn_3_1
* pin sn_3_2
* pin sn_3_3
* pin wl_0
* pin wl_1
* pin wl_2
* pin wl_3
.SUBCKT gain_cell_2t_array_4x4_layout_0 GND bl_0 bl_1 bl_2 bl_3 rbl_0 rbl_1
+ rbl_2 rbl_3 rwl_0 rwl_1 rwl_2 rwl_3 sn_0_0 sn_0_1 sn_0_2 sn_0_3 sn_1_0 sn_1_1
+ sn_1_2 sn_1_3 sn_2_0 sn_2_1 sn_2_2 sn_2_3 sn_3_0 sn_3_1 sn_3_2 sn_3_3 wl_0
+ wl_1 wl_2 wl_3
* device instance $1 r0 *1 0.545,0.21 nfet
X$1 sn_0_0__t0 wl_0__t3 bl_0__t1 GND__t0 sky130_fd_pr__nfet_01v8 L=0.15 W=0.42
+ AS=0.1974 AD=0.1974 PS=1.78 PD=1.78
* device instance $2 r0 *1 2.035,0.21 nfet
X$2 rbl_0__t0 sn_0_0__t1 rwl_0__t0 GND__t1 sky130_fd_pr__nfet_01v8 L=0.15
+ W=0.42 AS=0.1974 AD=0.1974 PS=1.78 PD=1.78
* device instance $3 r0 *1 3.525,0.21 nfet
X$3 sn_0_1__t1 wl_0__t0 bl_1__t0 GND__t2 sky130_fd_pr__nfet_01v8 L=0.15 W=0.42
+ AS=0.1974 AD=0.1974 PS=1.78 PD=1.78
* device instance $4 r0 *1 5.015,0.21 nfet
X$4 rbl_1__t0 sn_0_1__t0 rwl_0__t1 GND__t3 sky130_fd_pr__nfet_01v8 L=0.15
+ W=0.42 AS=0.1974 AD=0.1974 PS=1.78 PD=1.78
* device instance $5 r0 *1 6.505,0.21 nfet
X$5 sn_0_2__t1 wl_0__t1 bl_2__t0 GND__t4 sky130_fd_pr__nfet_01v8 L=0.15 W=0.42
+ AS=0.1974 AD=0.1974 PS=1.78 PD=1.78
* device instance $6 r0 *1 7.995,0.21 nfet
X$6 rbl_2__t0 sn_0_2__t0 rwl_0__t2 GND__t5 sky130_fd_pr__nfet_01v8 L=0.15
+ W=0.42 AS=0.1974 AD=0.1974 PS=1.78 PD=1.78
* device instance $7 r0 *1 9.485,0.21 nfet
X$7 sn_0_3__t1 wl_0__t2 bl_3__t0 GND__t6 sky130_fd_pr__nfet_01v8 L=0.15 W=0.42
+ AS=0.1974 AD=0.1974 PS=1.78 PD=1.78
* device instance $8 r0 *1 10.975,0.21 nfet
X$8 rbl_3__t0 sn_0_3__t0 rwl_0__t3 GND__t7 sky130_fd_pr__nfet_01v8 L=0.15
+ W=0.42 AS=0.1974 AD=0.1974 PS=1.78 PD=1.78
* device instance $9 r0 *1 0.545,2.15 nfet
X$9 sn_1_0__t1 wl_1__t0 bl_0__t0 GND__t8 sky130_fd_pr__nfet_01v8 L=0.15 W=0.42
+ AS=0.1974 AD=0.1974 PS=1.78 PD=1.78
* device instance $10 r0 *1 2.035,2.15 nfet
X$10 rbl_0__t1 sn_1_0__t0 rwl_1__t0 GND__t9 sky130_fd_pr__nfet_01v8 L=0.15
+ W=0.42 AS=0.1974 AD=0.1974 PS=1.78 PD=1.78
* device instance $11 r0 *1 3.525,2.15 nfet
X$11 sn_1_1__t1 wl_1__t1 bl_1__t1 GND__t10 sky130_fd_pr__nfet_01v8 L=0.15
+ W=0.42 AS=0.1974 AD=0.1974 PS=1.78 PD=1.78
* device instance $12 r0 *1 5.015,2.15 nfet
X$12 rbl_1__t1 sn_1_1__t0 rwl_1__t1 GND__t11 sky130_fd_pr__nfet_01v8 L=0.15
+ W=0.42 AS=0.1974 AD=0.1974 PS=1.78 PD=1.78
* device instance $13 r0 *1 6.505,2.15 nfet
X$13 sn_1_2__t1 wl_1__t2 bl_2__t1 GND__t12 sky130_fd_pr__nfet_01v8 L=0.15
+ W=0.42 AS=0.1974 AD=0.1974 PS=1.78 PD=1.78
* device instance $14 r0 *1 7.995,2.15 nfet
X$14 rbl_2__t1 sn_1_2__t0 rwl_1__t2 GND__t13 sky130_fd_pr__nfet_01v8 L=0.15
+ W=0.42 AS=0.1974 AD=0.1974 PS=1.78 PD=1.78
* device instance $15 r0 *1 9.485,2.15 nfet
X$15 sn_1_3__t1 wl_1__t3 bl_3__t1 GND__t14 sky130_fd_pr__nfet_01v8 L=0.15
+ W=0.42 AS=0.1974 AD=0.1974 PS=1.78 PD=1.78
* device instance $16 r0 *1 10.975,2.15 nfet
X$16 rbl_3__t1 sn_1_3__t0 rwl_1__t3 GND__t15 sky130_fd_pr__nfet_01v8 L=0.15
+ W=0.42 AS=0.1974 AD=0.1974 PS=1.78 PD=1.78
* device instance $17 r0 *1 0.545,4.09 nfet
X$17 sn_2_0__t1 wl_2__t3 bl_0__t3 GND__t16 sky130_fd_pr__nfet_01v8 L=0.15
+ W=0.42 AS=0.1974 AD=0.1974 PS=1.78 PD=1.78
* device instance $18 r0 *1 2.035,4.09 nfet
X$18 rbl_0__t2 sn_2_0__t0 rwl_2__t0 GND__t17 sky130_fd_pr__nfet_01v8 L=0.15
+ W=0.42 AS=0.1974 AD=0.1974 PS=1.78 PD=1.78
* device instance $19 r0 *1 3.525,4.09 nfet
X$19 sn_2_1__t1 wl_2__t0 bl_1__t2 GND__t18 sky130_fd_pr__nfet_01v8 L=0.15
+ W=0.42 AS=0.1974 AD=0.1974 PS=1.78 PD=1.78
* device instance $20 r0 *1 5.015,4.09 nfet
X$20 rbl_1__t2 sn_2_1__t0 rwl_2__t1 GND__t19 sky130_fd_pr__nfet_01v8 L=0.15
+ W=0.42 AS=0.1974 AD=0.1974 PS=1.78 PD=1.78
* device instance $21 r0 *1 6.505,4.09 nfet
X$21 sn_2_2__t1 wl_2__t1 bl_2__t2 GND__t20 sky130_fd_pr__nfet_01v8 L=0.15
+ W=0.42 AS=0.1974 AD=0.1974 PS=1.78 PD=1.78
* device instance $22 r0 *1 7.995,4.09 nfet
X$22 rbl_2__t2 sn_2_2__t0 rwl_2__t2 GND__t21 sky130_fd_pr__nfet_01v8 L=0.15
+ W=0.42 AS=0.1974 AD=0.1974 PS=1.78 PD=1.78
* device instance $23 r0 *1 9.485,4.09 nfet
X$23 sn_2_3__t1 wl_2__t2 bl_3__t2 GND__t22 sky130_fd_pr__nfet_01v8 L=0.15
+ W=0.42 AS=0.1974 AD=0.1974 PS=1.78 PD=1.78
* device instance $24 r0 *1 10.975,4.09 nfet
X$24 rbl_3__t2 sn_2_3__t0 rwl_2__t3 GND__t23 sky130_fd_pr__nfet_01v8 L=0.15
+ W=0.42 AS=0.1974 AD=0.1974 PS=1.78 PD=1.78
* device instance $25 r0 *1 0.545,6.03 nfet
X$25 sn_3_0__t1 wl_3__t0 bl_0__t2 GND__t24 sky130_fd_pr__nfet_01v8 L=0.15
+ W=0.42 AS=0.1974 AD=0.1974 PS=1.78 PD=1.78
* device instance $26 r0 *1 2.035,6.03 nfet
X$26 rbl_0__t3 sn_3_0__t0 rwl_3__t0 GND__t25 sky130_fd_pr__nfet_01v8 L=0.15
+ W=0.42 AS=0.1974 AD=0.1974 PS=1.78 PD=1.78
* device instance $27 r0 *1 3.525,6.03 nfet
X$27 sn_3_1__t1 wl_3__t1 bl_1__t3 GND__t26 sky130_fd_pr__nfet_01v8 L=0.15
+ W=0.42 AS=0.1974 AD=0.1974 PS=1.78 PD=1.78
* device instance $28 r0 *1 5.015,6.03 nfet
X$28 rbl_1__t3 sn_3_1__t0 rwl_3__t1 GND__t27 sky130_fd_pr__nfet_01v8 L=0.15
+ W=0.42 AS=0.1974 AD=0.1974 PS=1.78 PD=1.78
* device instance $29 r0 *1 6.505,6.03 nfet
X$29 sn_3_2__t1 wl_3__t2 bl_2__t3 GND__t28 sky130_fd_pr__nfet_01v8 L=0.15
+ W=0.42 AS=0.1974 AD=0.1974 PS=1.78 PD=1.78
* device instance $30 r0 *1 7.995,6.03 nfet
X$30 rbl_2__t3 sn_3_2__t0 rwl_3__t2 GND__t29 sky130_fd_pr__nfet_01v8 L=0.15
+ W=0.42 AS=0.1974 AD=0.1974 PS=1.78 PD=1.78
* device instance $31 r0 *1 9.485,6.03 nfet
X$31 sn_3_3__t1 wl_3__t3 bl_3__t3 GND__t30 sky130_fd_pr__nfet_01v8 L=0.15
+ W=0.42 AS=0.1974 AD=0.1974 PS=1.78 PD=1.78
* device instance $32 r0 *1 10.975,6.03 nfet
X$32 rbl_3__t3 sn_3_3__t0 rwl_3__t3 GND__t31 sky130_fd_pr__nfet_01v8 L=0.15
+ W=0.42 AS=0.1974 AD=0.1974 PS=1.78 PD=1.78
* device instance GND_t0 r0 *1 0,0
RGND_t0 GND__t0 GND 66.0174542221
* device instance GND_t1 r0 *1 0,0
RGND_t1 GND__t1 GND 52.2540019765
* device instance GND_t2 r0 *1 0,0
RGND_t2 GND__t2 GND 40.5618666931
* device instance GND_t3 r0 *1 0,0
RGND_t3 GND__t3 GND 33.2062822845
* device instance GND_t4 r0 *1 0,0
RGND_t4 GND__t4 GND 33.2062822845
* device instance GND_t5 r0 *1 0,0
RGND_t5 GND__t5 GND 40.5618666931
* device instance GND_t6 r0 *1 0,0
RGND_t6 GND__t6 GND 52.2540019765
* device instance GND_t7 r0 *1 0,0
RGND_t7 GND__t7 GND 66.0174542221
* device instance GND_t8 r0 *1 0,0
RGND_t8 GND__t8 GND 58.6383347676
* device instance GND_t9 r0 *1 0,0
RGND_t9 GND__t9 GND 42.5515071991
* device instance GND_t10 r0 *1 0,0
RGND_t10 GND__t10 GND 26.933530626
* device instance GND_t11 r0 *1 0,0
RGND_t11 GND__t11 GND 13.520622231
* device instance GND_t12 r0 *1 0,0
RGND_t12 GND__t12 GND 13.520622231
* device instance GND_t13 r0 *1 0,0
RGND_t13 GND__t13 GND 26.933530626
* device instance GND_t14 r0 *1 0,0
RGND_t14 GND__t14 GND 42.5515071991
* device instance GND_t15 r0 *1 0,0
RGND_t15 GND__t15 GND 58.6383347676
* device instance GND_t16 r0 *1 0,0
RGND_t16 GND__t16 GND 58.6383347676
* device instance GND_t17 r0 *1 0,0
RGND_t17 GND__t17 GND 42.5515071991
* device instance GND_t18 r0 *1 0,0
RGND_t18 GND__t18 GND 26.933530626
* device instance GND_t19 r0 *1 0,0
RGND_t19 GND__t19 GND 13.520622231
* device instance GND_t20 r0 *1 0,0
RGND_t20 GND__t20 GND 13.520622231
* device instance GND_t21 r0 *1 0,0
RGND_t21 GND__t21 GND 26.933530626
* device instance GND_t22 r0 *1 0,0
RGND_t22 GND__t22 GND 42.5515071991
* device instance GND_t23 r0 *1 0,0
RGND_t23 GND__t23 GND 58.6383347676
* device instance GND_t24 r0 *1 0,0
RGND_t24 GND__t24 GND 66.0174542221
* device instance GND_t25 r0 *1 0,0
RGND_t25 GND__t25 GND 52.2540019765
* device instance GND_t26 r0 *1 0,0
RGND_t26 GND__t26 GND 40.5618666931
* device instance GND_t27 r0 *1 0,0
RGND_t27 GND__t27 GND 33.2062822845
* device instance GND_t28 r0 *1 0,0
RGND_t28 GND__t28 GND 33.2062822845
* device instance GND_t29 r0 *1 0,0
RGND_t29 GND__t29 GND 40.5618666931
* device instance GND_t30 r0 *1 0,0
RGND_t30 GND__t30 GND 52.2540019765
* device instance GND_t31 r0 *1 0,0
RGND_t31 GND__t31 GND 66.0174542221
* device instance GND r0 *1 0,0
CGND GND vsubs 4.327402e-15
* device instance bl_0_t0 r0 *1 0,0
Rbl_0_t0 bl_0__t0 bl_0 56.4077
* device instance bl_0_t1 r0 *1 0,0
Rbl_0_t1 bl_0__t1 bl_0 169.2231
* device instance bl_0_t2 r0 *1 0,0
Rbl_0_t2 bl_0__t2 bl_0 169.2231
* device instance bl_0_t3 r0 *1 0,0
Rbl_0_t3 bl_0__t3 bl_0 56.4077
* device instance bl_0 r0 *1 0,0
Cbl_0 bl_0 vsubs 6.74997e-16
* device instance bl_1_t0 r0 *1 0,0
Rbl_1_t0 bl_1__t0 bl_1 169.2231
* device instance bl_1_t1 r0 *1 0,0
Rbl_1_t1 bl_1__t1 bl_1 56.4077
* device instance bl_1_t2 r0 *1 0,0
Rbl_1_t2 bl_1__t2 bl_1 56.4077
* device instance bl_1_t3 r0 *1 0,0
Rbl_1_t3 bl_1__t3 bl_1 169.2231
* device instance bl_1 r0 *1 0,0
Cbl_1 bl_1 vsubs 6.6272e-16
* device instance bl_2_t0 r0 *1 0,0
Rbl_2_t0 bl_2__t0 bl_2 169.2231
* device instance bl_2_t1 r0 *1 0,0
Rbl_2_t1 bl_2__t1 bl_2 56.4077
* device instance bl_2_t2 r0 *1 0,0
Rbl_2_t2 bl_2__t2 bl_2 56.4077
* device instance bl_2_t3 r0 *1 0,0
Rbl_2_t3 bl_2__t3 bl_2 169.2231
* device instance bl_2 r0 *1 0,0
Cbl_2 bl_2 vsubs 6.6272e-16
* device instance bl_3_t0 r0 *1 0,0
Rbl_3_t0 bl_3__t0 bl_3 169.2231
* device instance bl_3_t1 r0 *1 0,0
Rbl_3_t1 bl_3__t1 bl_3 56.4077
* device instance bl_3_t2 r0 *1 0,0
Rbl_3_t2 bl_3__t2 bl_3 56.4077
* device instance bl_3_t3 r0 *1 0,0
Rbl_3_t3 bl_3__t3 bl_3 169.2231
* device instance bl_3 r0 *1 0,0
Cbl_3 bl_3 vsubs 6.6272e-16
* device instance rbl_0_t0 r0 *1 0,0
Rrbl_0_t0 rbl_0__t0 rbl_0 169.2231
* device instance rbl_0_t1 r0 *1 0,0
Rrbl_0_t1 rbl_0__t1 rbl_0 56.4077
* device instance rbl_0_t2 r0 *1 0,0
Rrbl_0_t2 rbl_0__t2 rbl_0 56.4077
* device instance rbl_0_t3 r0 *1 0,0
Rrbl_0_t3 rbl_0__t3 rbl_0 169.2231
* device instance rbl_0 r0 *1 0,0
Crbl_0 rbl_0 vsubs 6.6272e-16
* device instance rbl_1_t0 r0 *1 0,0
Rrbl_1_t0 rbl_1__t0 rbl_1 169.2231
* device instance rbl_1_t1 r0 *1 0,0
Rrbl_1_t1 rbl_1__t1 rbl_1 56.4077
* device instance rbl_1_t2 r0 *1 0,0
Rrbl_1_t2 rbl_1__t2 rbl_1 56.4077
* device instance rbl_1_t3 r0 *1 0,0
Rrbl_1_t3 rbl_1__t3 rbl_1 169.2231
* device instance rbl_1 r0 *1 0,0
Crbl_1 rbl_1 vsubs 6.6272e-16
* device instance rbl_2_t0 r0 *1 0,0
Rrbl_2_t0 rbl_2__t0 rbl_2 169.2231
* device instance rbl_2_t1 r0 *1 0,0
Rrbl_2_t1 rbl_2__t1 rbl_2 56.4077
* device instance rbl_2_t2 r0 *1 0,0
Rrbl_2_t2 rbl_2__t2 rbl_2 56.4077
* device instance rbl_2_t3 r0 *1 0,0
Rrbl_2_t3 rbl_2__t3 rbl_2 169.2231
* device instance rbl_2 r0 *1 0,0
Crbl_2 rbl_2 vsubs 6.6272e-16
* device instance rbl_3_t0 r0 *1 0,0
Rrbl_3_t0 rbl_3__t0 rbl_3 169.2231
* device instance rbl_3_t1 r0 *1 0,0
Rrbl_3_t1 rbl_3__t1 rbl_3 56.4077
* device instance rbl_3_t2 r0 *1 0,0
Rrbl_3_t2 rbl_3__t2 rbl_3 56.4077
* device instance rbl_3_t3 r0 *1 0,0
Rrbl_3_t3 rbl_3__t3 rbl_3 169.2231
* device instance rbl_3 r0 *1 0,0
Crbl_3 rbl_3 vsubs 6.74997e-16
* device instance rwl_0_t0 r0 *1 0,0
Rrwl_0_t0 rwl_0__t0 rwl_0 22.0742625
* device instance rwl_0_t1 r0 *1 0,0
Rrwl_0_t1 rwl_0__t1 rwl_0 7.3580875
* device instance rwl_0_t2 r0 *1 0,0
Rrwl_0_t2 rwl_0__t2 rwl_0 7.3580875
* device instance rwl_0_t3 r0 *1 0,0
Rrwl_0_t3 rwl_0__t3 rwl_0 22.0742625
* device instance rwl_0 r0 *1 0,0
Crwl_0 rwl_0 vsubs 1.191798e-15
* device instance rwl_1_t0 r0 *1 0,0
Rrwl_1_t0 rwl_1__t0 rwl_1 22.0742625
* device instance rwl_1_t1 r0 *1 0,0
Rrwl_1_t1 rwl_1__t1 rwl_1 7.3580875
* device instance rwl_1_t2 r0 *1 0,0
Rrwl_1_t2 rwl_1__t2 rwl_1 7.3580875
* device instance rwl_1_t3 r0 *1 0,0
Rrwl_1_t3 rwl_1__t3 rwl_1 22.0742625
* device instance rwl_1 r0 *1 0,0
Crwl_1 rwl_1 vsubs 1.191798e-15
* device instance rwl_2_t0 r0 *1 0,0
Rrwl_2_t0 rwl_2__t0 rwl_2 22.0742625
* device instance rwl_2_t1 r0 *1 0,0
Rrwl_2_t1 rwl_2__t1 rwl_2 7.3580875
* device instance rwl_2_t2 r0 *1 0,0
Rrwl_2_t2 rwl_2__t2 rwl_2 7.3580875
* device instance rwl_2_t3 r0 *1 0,0
Rrwl_2_t3 rwl_2__t3 rwl_2 22.0742625
* device instance rwl_2 r0 *1 0,0
Crwl_2 rwl_2 vsubs 1.191798e-15
* device instance rwl_3_t0 r0 *1 0,0
Rrwl_3_t0 rwl_3__t0 rwl_3 22.0742625
* device instance rwl_3_t1 r0 *1 0,0
Rrwl_3_t1 rwl_3__t1 rwl_3 7.3580875
* device instance rwl_3_t2 r0 *1 0,0
Rrwl_3_t2 rwl_3__t2 rwl_3 7.3580875
* device instance rwl_3_t3 r0 *1 0,0
Rrwl_3_t3 rwl_3__t3 rwl_3 22.0742625
* device instance rwl_3 r0 *1 0,0
Crwl_3 rwl_3 vsubs 1.191798e-15
* device instance sn_0_0_t0 r0 *1 0,0
Rsn_0_0_t0 sn_0_0__t0 sn_0_0 169.49085
* device instance sn_0_0_t1 r0 *1 0,0
Rsn_0_0_t1 sn_0_0__t1 sn_0_0 169.49085
* device instance sn_0_0 r0 *1 0,0
Csn_0_0 sn_0_0 vsubs 5.01634e-16
* device instance sn_0_1_t0 r0 *1 0,0
Rsn_0_1_t0 sn_0_1__t0 sn_0_1 169.49085
* device instance sn_0_1_t1 r0 *1 0,0
Rsn_0_1_t1 sn_0_1__t1 sn_0_1 169.49085
* device instance sn_0_1 r0 *1 0,0
Csn_0_1 sn_0_1 vsubs 4.9907e-16
* device instance sn_0_2_t0 r0 *1 0,0
Rsn_0_2_t0 sn_0_2__t0 sn_0_2 169.49085
* device instance sn_0_2_t1 r0 *1 0,0
Rsn_0_2_t1 sn_0_2__t1 sn_0_2 169.49085
* device instance sn_0_2 r0 *1 0,0
Csn_0_2 sn_0_2 vsubs 4.9907e-16
* device instance sn_0_3_t0 r0 *1 0,0
Rsn_0_3_t0 sn_0_3__t0 sn_0_3 169.49085
* device instance sn_0_3_t1 r0 *1 0,0
Rsn_0_3_t1 sn_0_3__t1 sn_0_3 169.49085
* device instance sn_0_3 r0 *1 0,0
Csn_0_3 sn_0_3 vsubs 5.00779e-16
* device instance sn_1_0_t0 r0 *1 0,0
Rsn_1_0_t0 sn_1_0__t0 sn_1_0 169.49085
* device instance sn_1_0_t1 r0 *1 0,0
Rsn_1_0_t1 sn_1_0__t1 sn_1_0 169.49085
* device instance sn_1_0 r0 *1 0,0
Csn_1_0 sn_1_0 vsubs 5.01634e-16
* device instance sn_1_1_t0 r0 *1 0,0
Rsn_1_1_t0 sn_1_1__t0 sn_1_1 169.49085
* device instance sn_1_1_t1 r0 *1 0,0
Rsn_1_1_t1 sn_1_1__t1 sn_1_1 169.49085
* device instance sn_1_1 r0 *1 0,0
Csn_1_1 sn_1_1 vsubs 4.9907e-16
* device instance sn_1_2_t0 r0 *1 0,0
Rsn_1_2_t0 sn_1_2__t0 sn_1_2 169.49085
* device instance sn_1_2_t1 r0 *1 0,0
Rsn_1_2_t1 sn_1_2__t1 sn_1_2 169.49085
* device instance sn_1_2 r0 *1 0,0
Csn_1_2 sn_1_2 vsubs 4.9907e-16
* device instance sn_1_3_t0 r0 *1 0,0
Rsn_1_3_t0 sn_1_3__t0 sn_1_3 169.49085
* device instance sn_1_3_t1 r0 *1 0,0
Rsn_1_3_t1 sn_1_3__t1 sn_1_3 169.49085
* device instance sn_1_3 r0 *1 0,0
Csn_1_3 sn_1_3 vsubs 5.00779e-16
* device instance sn_2_0_t0 r0 *1 0,0
Rsn_2_0_t0 sn_2_0__t0 sn_2_0 169.49085
* device instance sn_2_0_t1 r0 *1 0,0
Rsn_2_0_t1 sn_2_0__t1 sn_2_0 169.49085
* device instance sn_2_0 r0 *1 0,0
Csn_2_0 sn_2_0 vsubs 5.01634e-16
* device instance sn_2_1_t0 r0 *1 0,0
Rsn_2_1_t0 sn_2_1__t0 sn_2_1 169.49085
* device instance sn_2_1_t1 r0 *1 0,0
Rsn_2_1_t1 sn_2_1__t1 sn_2_1 169.49085
* device instance sn_2_1 r0 *1 0,0
Csn_2_1 sn_2_1 vsubs 4.9907e-16
* device instance sn_2_2_t0 r0 *1 0,0
Rsn_2_2_t0 sn_2_2__t0 sn_2_2 169.49085
* device instance sn_2_2_t1 r0 *1 0,0
Rsn_2_2_t1 sn_2_2__t1 sn_2_2 169.49085
* device instance sn_2_2 r0 *1 0,0
Csn_2_2 sn_2_2 vsubs 4.9907e-16
* device instance sn_2_3_t0 r0 *1 0,0
Rsn_2_3_t0 sn_2_3__t0 sn_2_3 169.49085
* device instance sn_2_3_t1 r0 *1 0,0
Rsn_2_3_t1 sn_2_3__t1 sn_2_3 169.49085
* device instance sn_2_3 r0 *1 0,0
Csn_2_3 sn_2_3 vsubs 5.00779e-16
* device instance sn_3_0_t0 r0 *1 0,0
Rsn_3_0_t0 sn_3_0__t0 sn_3_0 169.49085
* device instance sn_3_0_t1 r0 *1 0,0
Rsn_3_0_t1 sn_3_0__t1 sn_3_0 169.49085
* device instance sn_3_0 r0 *1 0,0
Csn_3_0 sn_3_0 vsubs 5.01634e-16
* device instance sn_3_1_t0 r0 *1 0,0
Rsn_3_1_t0 sn_3_1__t0 sn_3_1 169.49085
* device instance sn_3_1_t1 r0 *1 0,0
Rsn_3_1_t1 sn_3_1__t1 sn_3_1 169.49085
* device instance sn_3_1 r0 *1 0,0
Csn_3_1 sn_3_1 vsubs 4.9907e-16
* device instance sn_3_2_t0 r0 *1 0,0
Rsn_3_2_t0 sn_3_2__t0 sn_3_2 169.49085
* device instance sn_3_2_t1 r0 *1 0,0
Rsn_3_2_t1 sn_3_2__t1 sn_3_2 169.49085
* device instance sn_3_2 r0 *1 0,0
Csn_3_2 sn_3_2 vsubs 4.9907e-16
* device instance sn_3_3_t0 r0 *1 0,0
Rsn_3_3_t0 sn_3_3__t0 sn_3_3 169.49085
* device instance sn_3_3_t1 r0 *1 0,0
Rsn_3_3_t1 sn_3_3__t1 sn_3_3 169.49085
* device instance sn_3_3 r0 *1 0,0
Csn_3_3 sn_3_3 vsubs 5.00779e-16
* device instance wl_0_t0 r0 *1 0,0
Rwl_0_t0 wl_0__t0 wl_0 93.2607125
* device instance wl_0_t1 r0 *1 0,0
Rwl_0_t1 wl_0__t1 wl_0 93.2607125
* device instance wl_0_t2 r0 *1 0,0
Rwl_0_t2 wl_0__t2 wl_0 279.7821375
* device instance wl_0_t3 r0 *1 0,0
Rwl_0_t3 wl_0__t3 wl_0 279.7821375
* device instance wl_0 r0 *1 0,0
Cwl_0 wl_0 vsubs 2.124706e-15
* device instance wl_1_t0 r0 *1 0,0
Rwl_1_t0 wl_1__t0 wl_1 279.7821375
* device instance wl_1_t1 r0 *1 0,0
Rwl_1_t1 wl_1__t1 wl_1 93.2607125
* device instance wl_1_t2 r0 *1 0,0
Rwl_1_t2 wl_1__t2 wl_1 93.2607125
* device instance wl_1_t3 r0 *1 0,0
Rwl_1_t3 wl_1__t3 wl_1 279.7821375
* device instance wl_1 r0 *1 0,0
Cwl_1 wl_1 vsubs 2.124706e-15
* device instance wl_2_t0 r0 *1 0,0
Rwl_2_t0 wl_2__t0 wl_2 93.2607125
* device instance wl_2_t1 r0 *1 0,0
Rwl_2_t1 wl_2__t1 wl_2 93.2607125
* device instance wl_2_t2 r0 *1 0,0
Rwl_2_t2 wl_2__t2 wl_2 279.7821375
* device instance wl_2_t3 r0 *1 0,0
Rwl_2_t3 wl_2__t3 wl_2 279.7821375
* device instance wl_2 r0 *1 0,0
Cwl_2 wl_2 vsubs 2.124706e-15
* device instance wl_3_t0 r0 *1 0,0
Rwl_3_t0 wl_3__t0 wl_3 279.7821375
* device instance wl_3_t1 r0 *1 0,0
Rwl_3_t1 wl_3__t1 wl_3 93.2607125
* device instance wl_3_t2 r0 *1 0,0
Rwl_3_t2 wl_3__t2 wl_3 93.2607125
* device instance wl_3_t3 r0 *1 0,0
Rwl_3_t3 wl_3__t3 wl_3 279.7821375
* device instance wl_3 r0 *1 0,0
Cwl_3 wl_3 vsubs 2.128387e-15
* device instance cc_bl_1_rwl_0 r0 *1 0,0
Ccc_bl_1_rwl_0 bl_1 rwl_0 7.434e-18
* device instance cc_bl_1_rwl_1 r0 *1 0,0
Ccc_bl_1_rwl_1 bl_1 rwl_1 7.434e-18
* device instance cc_bl_1_rwl_2 r0 *1 0,0
Ccc_bl_1_rwl_2 bl_1 rwl_2 7.434e-18
* device instance cc_bl_1_rwl_3 r0 *1 0,0
Ccc_bl_1_rwl_3 bl_1 rwl_3 7.434e-18
* device instance cc_bl_1_wl_0 r0 *1 0,0
Ccc_bl_1_wl_0 bl_1 wl_0 2.718e-18
* device instance cc_bl_1_wl_1 r0 *1 0,0
Ccc_bl_1_wl_1 bl_1 wl_1 2.718e-18
* device instance cc_bl_1_wl_2 r0 *1 0,0
Ccc_bl_1_wl_2 bl_1 wl_2 2.718e-18
* device instance cc_bl_2_rwl_0 r0 *1 0,0
Ccc_bl_2_rwl_0 bl_2 rwl_0 7.434e-18
* device instance cc_bl_2_rwl_1 r0 *1 0,0
Ccc_bl_2_rwl_1 bl_2 rwl_1 7.434e-18
* device instance cc_bl_2_rwl_2 r0 *1 0,0
Ccc_bl_2_rwl_2 bl_2 rwl_2 7.434e-18
* device instance cc_bl_2_rwl_3 r0 *1 0,0
Ccc_bl_2_rwl_3 bl_2 rwl_3 7.434e-18
* device instance cc_bl_2_wl_0 r0 *1 0,0
Ccc_bl_2_wl_0 bl_2 wl_0 2.718e-18
* device instance cc_bl_2_wl_1 r0 *1 0,0
Ccc_bl_2_wl_1 bl_2 wl_1 2.718e-18
* device instance cc_bl_2_wl_2 r0 *1 0,0
Ccc_bl_2_wl_2 bl_2 wl_2 2.718e-18
* device instance cc_bl_3_rwl_0 r0 *1 0,0
Ccc_bl_3_rwl_0 bl_3 rwl_0 7.434e-18
* device instance cc_bl_3_rwl_1 r0 *1 0,0
Ccc_bl_3_rwl_1 bl_3 rwl_1 7.434e-18
* device instance cc_bl_3_rwl_2 r0 *1 0,0
Ccc_bl_3_rwl_2 bl_3 rwl_2 7.434e-18
* device instance cc_bl_3_rwl_3 r0 *1 0,0
Ccc_bl_3_rwl_3 bl_3 rwl_3 7.434e-18
* device instance cc_bl_3_wl_0 r0 *1 0,0
Ccc_bl_3_wl_0 bl_3 wl_0 2.718e-18
* device instance cc_bl_3_wl_1 r0 *1 0,0
Ccc_bl_3_wl_1 bl_3 wl_1 2.718e-18
* device instance cc_bl_3_wl_2 r0 *1 0,0
Ccc_bl_3_wl_2 bl_3 wl_2 2.718e-18
* device instance cc_rbl_0_rwl_0 r0 *1 0,0
Ccc_rbl_0_rwl_0 rbl_0 rwl_0 7.434e-18
* device instance cc_rbl_0_rwl_1 r0 *1 0,0
Ccc_rbl_0_rwl_1 rbl_0 rwl_1 7.434e-18
* device instance cc_rbl_0_rwl_2 r0 *1 0,0
Ccc_rbl_0_rwl_2 rbl_0 rwl_2 7.434e-18
* device instance cc_rbl_0_rwl_3 r0 *1 0,0
Ccc_rbl_0_rwl_3 rbl_0 rwl_3 7.434e-18
* device instance cc_rbl_0_wl_0 r0 *1 0,0
Ccc_rbl_0_wl_0 rbl_0 wl_0 2.718e-18
* device instance cc_rbl_0_wl_1 r0 *1 0,0
Ccc_rbl_0_wl_1 rbl_0 wl_1 2.718e-18
* device instance cc_rbl_0_wl_2 r0 *1 0,0
Ccc_rbl_0_wl_2 rbl_0 wl_2 2.718e-18
* device instance cc_rbl_1_rwl_0 r0 *1 0,0
Ccc_rbl_1_rwl_0 rbl_1 rwl_0 7.434e-18
* device instance cc_rbl_1_rwl_1 r0 *1 0,0
Ccc_rbl_1_rwl_1 rbl_1 rwl_1 7.434e-18
* device instance cc_rbl_1_rwl_2 r0 *1 0,0
Ccc_rbl_1_rwl_2 rbl_1 rwl_2 7.434e-18
* device instance cc_rbl_1_rwl_3 r0 *1 0,0
Ccc_rbl_1_rwl_3 rbl_1 rwl_3 7.434e-18
* device instance cc_rbl_1_wl_0 r0 *1 0,0
Ccc_rbl_1_wl_0 rbl_1 wl_0 2.718e-18
* device instance cc_rbl_1_wl_1 r0 *1 0,0
Ccc_rbl_1_wl_1 rbl_1 wl_1 2.718e-18
* device instance cc_rbl_1_wl_2 r0 *1 0,0
Ccc_rbl_1_wl_2 rbl_1 wl_2 2.718e-18
* device instance cc_rbl_2_rwl_0 r0 *1 0,0
Ccc_rbl_2_rwl_0 rbl_2 rwl_0 7.434e-18
* device instance cc_rbl_2_rwl_1 r0 *1 0,0
Ccc_rbl_2_rwl_1 rbl_2 rwl_1 7.434e-18
* device instance cc_rbl_2_rwl_2 r0 *1 0,0
Ccc_rbl_2_rwl_2 rbl_2 rwl_2 7.434e-18
* device instance cc_rbl_2_rwl_3 r0 *1 0,0
Ccc_rbl_2_rwl_3 rbl_2 rwl_3 7.434e-18
* device instance cc_rbl_2_wl_0 r0 *1 0,0
Ccc_rbl_2_wl_0 rbl_2 wl_0 2.718e-18
* device instance cc_rbl_2_wl_1 r0 *1 0,0
Ccc_rbl_2_wl_1 rbl_2 wl_1 2.718e-18
* device instance cc_rbl_2_wl_2 r0 *1 0,0
Ccc_rbl_2_wl_2 rbl_2 wl_2 2.718e-18
* device instance cc_rwl_0_sn_0_1 r0 *1 0,0
Ccc_rwl_0_sn_0_1 rwl_0 sn_0_1 7.914e-18
* device instance cc_rwl_0_sn_0_2 r0 *1 0,0
Ccc_rwl_0_sn_0_2 rwl_0 sn_0_2 7.914e-18
* device instance cc_rwl_0_sn_0_3 r0 *1 0,0
Ccc_rwl_0_sn_0_3 rwl_0 sn_0_3 7.914e-18
* device instance cc_rwl_1_sn_1_1 r0 *1 0,0
Ccc_rwl_1_sn_1_1 rwl_1 sn_1_1 7.914e-18
* device instance cc_rwl_1_sn_1_2 r0 *1 0,0
Ccc_rwl_1_sn_1_2 rwl_1 sn_1_2 7.914e-18
* device instance cc_rwl_1_sn_1_3 r0 *1 0,0
Ccc_rwl_1_sn_1_3 rwl_1 sn_1_3 7.914e-18
* device instance cc_rwl_2_sn_2_1 r0 *1 0,0
Ccc_rwl_2_sn_2_1 rwl_2 sn_2_1 7.914e-18
* device instance cc_rwl_2_sn_2_2 r0 *1 0,0
Ccc_rwl_2_sn_2_2 rwl_2 sn_2_2 7.914e-18
* device instance cc_rwl_2_sn_2_3 r0 *1 0,0
Ccc_rwl_2_sn_2_3 rwl_2 sn_2_3 7.914e-18
* device instance cc_rwl_3_sn_3_1 r0 *1 0,0
Ccc_rwl_3_sn_3_1 rwl_3 sn_3_1 7.914e-18
* device instance cc_rwl_3_sn_3_2 r0 *1 0,0
Ccc_rwl_3_sn_3_2 rwl_3 sn_3_2 7.914e-18
* device instance cc_rwl_3_sn_3_3 r0 *1 0,0
Ccc_rwl_3_sn_3_3 rwl_3 sn_3_3 7.914e-18
* device instance cc_sn_0_0_wl_0 r0 *1 0,0
Ccc_sn_0_0_wl_0 sn_0_0 wl_0 5.276e-18
* device instance cc_sn_0_1_wl_0 r0 *1 0,0
Ccc_sn_0_1_wl_0 sn_0_1 wl_0 5.276e-18
* device instance cc_sn_0_2_wl_0 r0 *1 0,0
Ccc_sn_0_2_wl_0 sn_0_2 wl_0 5.276e-18
* device instance cc_sn_1_0_wl_1 r0 *1 0,0
Ccc_sn_1_0_wl_1 sn_1_0 wl_1 5.276e-18
* device instance cc_sn_1_1_wl_1 r0 *1 0,0
Ccc_sn_1_1_wl_1 sn_1_1 wl_1 5.276e-18
* device instance cc_sn_1_2_wl_1 r0 *1 0,0
Ccc_sn_1_2_wl_1 sn_1_2 wl_1 5.276e-18
* device instance cc_sn_2_0_wl_2 r0 *1 0,0
Ccc_sn_2_0_wl_2 sn_2_0 wl_2 5.276e-18
* device instance cc_sn_2_1_wl_2 r0 *1 0,0
Ccc_sn_2_1_wl_2 sn_2_1 wl_2 5.276e-18
* device instance cc_sn_2_2_wl_2 r0 *1 0,0
Ccc_sn_2_2_wl_2 sn_2_2 wl_2 5.276e-18
* device instance cc_sn_3_0_wl_3 r0 *1 0,0
Ccc_sn_3_0_wl_3 sn_3_0 wl_3 5.276e-18
* device instance cc_sn_3_1_wl_3 r0 *1 0,0
Ccc_sn_3_1_wl_3 sn_3_1 wl_3 5.276e-18
* device instance cc_sn_3_2_wl_3 r0 *1 0,0
Ccc_sn_3_2_wl_3 sn_3_2 wl_3 5.276e-18
* device instance vsubs_dctie r0 *1 0,0
Rvsubs_dctie vsubs 0 1e+12
.ENDS gain_cell_2t_array_4x4_layout_0

Xdut 0 bl_0 bl_1 bl_2 bl_3 rbl_0 rbl_1 rbl_2 rbl_3 rwl_0 rwl_1 rwl_2 rwl_3 sn_0_0 sn_0_1 sn_0_2 sn_0_3 sn_1_0 sn_1_1 sn_1_2 sn_1_3 sn_2_0 sn_2_1 sn_2_2 sn_2_3 sn_3_0 sn_3_1 sn_3_2 sn_3_3 wl_0 wl_1 wl_2 wl_3 gain_cell_2t_array_4x4_layout_0
* substrate DC reference: the extraction declares .GLOBAL vsubs and ties it
* through 1e12 ohm; an explicit 0 V source anchors it on BOTH legs (a coupling-
* capacitance delta needs a real AC ground, which a 1 Tohm tie is not). On the
* schematic leg the node simply does not exist in the DUT and the source is idle.
Vvsubs vsubs 0 DC 0

* selected row 0 / column 0: the single-cell write/read sequence
vwl_0 wl_0 0 pulse(0 {VDD} {TWL_ON} {TEDGE} {TEDGE} {TWL_OFF-TWL_ON-TEDGE} 1)
vwl_1 wl_1 0 dc 0
vwl_2 wl_2 0 dc 0
vwl_3 wl_3 0 dc 0
vbl_0 bl_0 0 pwl(0 {VBL_DATA} {TBL_OFF} {VBL_DATA} {TBL_OFF+TEDGE} 0)
vbl_1 bl_1 0 dc 0
vbl_2 bl_2 0 dc 0
vbl_3 bl_3 0 dc 0
vrwl_0 rwl_0 0 pwl(0 {VDD} {TRWL_ON} {VDD} {TRWL_ON+TEDGE} 0 {TRWL_OFF} 0 {TRWL_OFF+TEDGE} {VDD})
vrwl_1 rwl_1 0 dc {VDD}
vrwl_2 rwl_2 0 dc {VDD}
vrwl_3 rwl_3 0 dc {VDD}
vrbl_0 rbl_0 0 dc {VRBL}
vrbl_1 rbl_1 0 dc {VRBL}
vrbl_2 rbl_2 0 dc {VRBL}
vrbl_3 rbl_3 0 dc {VRBL}
* every storage node starts empty (stored '0'); sn_0_0 is then written '1'
.ic v(sn_0_0)={VSN_INIT}
.ic v(sn_0_1)={VSN_INIT}
.ic v(sn_0_2)={VSN_INIT}
.ic v(sn_0_3)={VSN_INIT}
.ic v(sn_1_0)={VSN_INIT}
.ic v(sn_1_1)={VSN_INIT}
.ic v(sn_1_2)={VSN_INIT}
.ic v(sn_1_3)={VSN_INIT}
.ic v(sn_2_0)={VSN_INIT}
.ic v(sn_2_1)={VSN_INIT}
.ic v(sn_2_2)={VSN_INIT}
.ic v(sn_2_3)={VSN_INIT}
.ic v(sn_3_0)={VSN_INIT}
.ic v(sn_3_1)={VSN_INIT}
.ic v(sn_3_2)={VSN_INIT}
.ic v(sn_3_3)={VSN_INIT}
* unselected-line biases during hold: wl_*=0, bl_*=0 (write path off), rwl_*=VDD (rows deselected, active-low read), rbl_*=VRBL
