* bench_extracted -- write/read/hold transient for the gain_cell_2t_layout_0 extracted leg (issue #383).
* GENERATED by measure_pex_retention.py via pex_bench.build_bench(); do not edit.
* Circuit body for `klt sim`: the PDK .lib / .temp are appended per corner by klt;
* analysis and .meas cards are in the sibling request_*.json.
* Same phase timing / bias as sim/bitcell-transient/bitcell_d1.spice (parsed from
* tb_bitcell_transient.spice.tmpl -- single source of truth). The template's lumped
* extracted c_sn is OMITTED: the fresh extraction supplies
* storage-node wiring capacitance exactly once.
* extracted-leg DUT, inlined verbatim from /home/ubuntu/GitHub/sky130-gcedram/.loom/worktrees/issue-383/sim/pex_bitcell_array/work/bitcell/extracted.spice (sha256:b3b7908849ddfae5092ad0118300a04062157ca88b40b9356d4654622f417ab6).
*
.param VDD    = 1.8
.param VRBL   = 0.9
.param TEDGE       = 1.000000e-10
.param TWL_ON      = 1.000000e-09
.param TWL_OFF     = 2.100000e-08
.param TBL_OFF     = 2.300000e-08
.param TRWL_ON     = 3.000000e-08
.param TRWL_OFF    = 5.000000e-08
.param THOLD_START = 5.500000e-08
.param VBL_DATA = 1.8
.param VSN_INIT = 0
* extracted by klt extract --deck sky130
* parasitic model (--parasitics):
* - capacitance: net-to-ground for every net's own (non-coupled) area/perimeter, plus net-to-net for the vertical-overlap coupling `coupling` describes below -- a coupled net pair gets a direct capacitor between their two hub nodes, not just capacitors to the deck's ground/substrate net
* - coupling: vertical overlap (crossover) unconditionally -- where one net's conductor on an adjacent metal level sits directly over another *distinct* net's conductor, that overlap area is charged between the two nets instead of to ground (issue #760) -- plus lateral (same-layer, sidewall) coupling, but only for a net pair naming one of the caller's declared `--critical-net` nets (issue #976): facing-edge length within that layer's own minimum-spacing lookback is charged between the two nets, *additively* (not deducted from either net's substrate fringe term, unlike the vertical case -- a known simplification). Any same-layer pair with neither side named `--critical-net`, and fringe shielding in general, are still not modelled
* - resistance: single lumped series resistance per net, distributed as a star across that net's device terminals (issue #592) -- not a per-segment, distributed RC ladder, *unless* `--distributed-rc` names this net via `--critical-net` (issue #977, Epic #709 Phase 2b): then the net's terminals are ordered along their approximate physical spread and its total R/C is broken into a chain of per-segment resistors (segment length proportional to inter-terminal distance) with a ground capacitor at each terminal node (proportional to its adjacent segment length/2), instead of one star hub -- still an approximation (terminal position is a device-placement proxy, not true per-segment routing geometry), but a strictly finer-grained one than the single-hub star
* - frequency: quasi-static -- one frequency-independent R and C per net; no skin effect, no distributed transmission-line behavior
* - substrate tie: 1e+12 ohm to ground -- the substrate is capacitively floating in transient analysis (DC reference only); see --substrate-tie-ohms
.GLOBAL vsubs

* cell gain_cell_2t_layout_0
* pin GND
* pin bl
* pin rbl
* pin rwl
* pin sn
* pin wl
.SUBCKT gain_cell_2t_layout_0 GND bl rbl rwl sn wl
* device instance $1 r0 *1 0.545,0.21 nfet
X$1 sn__t0 wl__t0 bl__t0 GND__t0 sky130_fd_pr__nfet_01v8 L=0.15 W=0.42
+ AS=0.1974 AD=0.1974 PS=1.78 PD=1.78
* device instance $2 r0 *1 2.035,0.21 nfet
X$2 rbl__t0 sn__t1 rwl__t0 GND__t1 sky130_fd_pr__nfet_01v8 L=0.15 W=0.42
+ AS=0.1974 AD=0.1974 PS=1.78 PD=1.78
* device instance GND_t0 r0 *1 0,0
RGND_t0 GND__t0 GND 73.19275
* device instance GND_t1 r0 *1 0,0
RGND_t1 GND__t1 GND 73.19275
* device instance GND r0 *1 0,0
CGND GND vsubs 5.50619e-16
* device instance bl_t0 r0 *1 0,0
Rbl_t0 bl__t0 bl 12.8
* device instance bl r0 *1 0,0
Cbl bl vsubs 7.4903e-17
* device instance rbl_t0 r0 *1 0,0
Rrbl_t0 rbl__t0 rbl 12.8
* device instance rbl r0 *1 0,0
Crbl rbl vsubs 7.4903e-17
* device instance rwl_t0 r0 *1 0,0
Rrwl_t0 rwl__t0 rwl 12.8
* device instance rwl r0 *1 0,0
Crwl rwl vsubs 7.2727e-17
* device instance sn_t0 r0 *1 0,0
Rsn_t0 sn__t0 sn 99.68715
* device instance sn_t1 r0 *1 0,0
Rsn_t1 sn__t1 sn 99.68715
* device instance sn r0 *1 0,0
Csn sn vsubs 6.55316e-16
* device instance wl_t0 r0 *1 0,0
Rwl_t0 wl__t0 wl 184.6069
* device instance wl r0 *1 0,0
Cwl wl vsubs 3.03381e-16
* device instance cc_rwl_sn r0 *1 0,0
Ccc_rwl_sn rwl sn 6.715e-18
* device instance vsubs_dctie r0 *1 0,0
Rvsubs_dctie vsubs 0 1e+12
.ENDS gain_cell_2t_layout_0

Xdut 0 bl rbl rwl sn wl gain_cell_2t_layout_0
* substrate DC reference: the extraction declares .GLOBAL vsubs and ties it
* through 1e12 ohm; an explicit 0 V source anchors it on BOTH legs (a coupling-
* capacitance delta needs a real AC ground, which a 1 Tohm tie is not). On the
* schematic leg the node simply does not exist in the DUT and the source is idle.
Vvsubs vsubs 0 DC 0

vwl  wl  0 pulse(0 {VDD} {TWL_ON} {TEDGE} {TEDGE} {TWL_OFF-TWL_ON-TEDGE} 1)
vbl  bl  0 pwl(0 {VBL_DATA} {TBL_OFF} {VBL_DATA} {TBL_OFF+TEDGE} 0)
vrwl rwl 0 pwl(0 {VDD} {TRWL_ON} {VDD} {TRWL_ON+TEDGE} 0 {TRWL_OFF} 0 {TRWL_OFF+TEDGE} {VDD})
vrbl rbl 0 dc {VRBL}
.ic v(sn)={VSN_INIT}
