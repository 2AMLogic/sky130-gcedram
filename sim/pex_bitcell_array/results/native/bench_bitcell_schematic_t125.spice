* bench_schematic -- write/read/hold transient for the gain_cell_2t_layout_0 schematic leg (issue #383).
* GENERATED by measure_pex_retention.py via pex_bench.build_bench(); do not edit.
* Circuit body for `klt sim`: the PDK .lib / .temp are appended per corner by klt;
* analysis and .meas cards are in the sibling request_*.json.
* Same phase timing / bias as sim/bitcell-transient/bitcell_d1.spice (parsed from
* tb_bitcell_transient.spice.tmpl -- single source of truth). The template's lumped
* extracted c_sn is OMITTED: the pre-layout leg carries no
* storage-node wiring capacitance exactly once.
* schematic-leg DUT, inlined verbatim from /home/ubuntu/GitHub/sky130-gcedram/.loom/worktrees/issue-383/sim/pex_bitcell_array/reference/gain_cell_2t_schematic.spice (sha256:1b2bb9472e709d64cdeb64f33f965dd27fa4a5f5b56026b4fee48ee06f45ee87).
*
.param VDD    = 1.8
.param VRBL   = 0.9
.param TEDGE       = 1.000000e-10
.param TWL_ON      = 1.000000e-09
.param TWL_OFF     = 2.100000e-08
.param TBL_OFF     = 2.300000e-08
.param TRWL_ON     = 3.000000e-08
.param TRWL_OFF    = 5.000000e-08
.param THOLD_START = 5.500000e-08
.param VBL_DATA = 1.8
.param VSN_INIT = 0
* gain_cell_2t_schematic.spice -- bitcell schematic leg for the klt pex
* retention comparison (issue #383). GENERATED by gen_reference_netlists.py; do not edit.
* The two SKY130 device cards are design/gain_cell_2t.spice verbatim
* (sha256:7d1fe877ee5a7789e5b6f4b29788e1ecd927112de99e3156ba246eb2dcb73ad5); the active wrapper's name and ORDERED pin list are the
* committed extraction's own header (gain_cell_2t.extract.parasitics.spice).
* The source's commented wrapper and top-level terminator are omitted.
.SUBCKT gain_cell_2t_layout_0 GND bl rbl rwl sn wl
XM_WR sn wl bl GND sky130_fd_pr__nfet_01v8 L=0.15 W=0.42 nf=1 ad=0.1218 as=0.1218 pd=1.42 ps=1.42 nrd=0.69047619047619
+ nrs=0.69047619047619 sa=0 sb=0 sd=0 mult=1 m=1
XM_RD rbl sn rwl GND sky130_fd_pr__nfet_01v8 L=0.15 W=0.42 nf=1 ad=0.1218 as=0.1218 pd=1.42 ps=1.42 nrd=0.69047619047619
+ nrs=0.69047619047619 sa=0 sb=0 sd=0 mult=1 m=1
.ENDS gain_cell_2t_layout_0

Xdut 0 bl rbl rwl sn wl gain_cell_2t_layout_0
* substrate DC reference: the extraction declares .GLOBAL vsubs and ties it
* through 1e12 ohm; an explicit 0 V source anchors it on BOTH legs (a coupling-
* capacitance delta needs a real AC ground, which a 1 Tohm tie is not). On the
* schematic leg the node simply does not exist in the DUT and the source is idle.
Vvsubs vsubs 0 DC 0

vwl  wl  0 pulse(0 {VDD} {TWL_ON} {TEDGE} {TEDGE} {TWL_OFF-TWL_ON-TEDGE} 1)
vbl  bl  0 pwl(0 {VBL_DATA} {TBL_OFF} {VBL_DATA} {TBL_OFF+TEDGE} 0)
vrwl rwl 0 pwl(0 {VDD} {TRWL_ON} {VDD} {TRWL_ON+TEDGE} 0 {TRWL_OFF} 0 {TRWL_OFF+TEDGE} {VDD})
vrbl rbl 0 dc {VRBL}
.ic v(sn)={VSN_INIT}
