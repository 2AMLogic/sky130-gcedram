* bench_schematic -- write/read/hold transient for the gain_cell_2t_array_4x4_layout_0 schematic leg (issue #383).
* GENERATED by measure_pex_retention.py via pex_bench.build_bench(); do not edit.
* Circuit body for `klt sim`: the PDK .lib / .temp are appended per corner by klt;
* analysis and .meas cards are in the sibling request_*.json.
* Same phase timing / bias as sim/bitcell-transient/bitcell_d1.spice (parsed from
* tb_bitcell_transient.spice.tmpl -- single source of truth). The template's lumped
* extracted c_sn is OMITTED: the pre-layout leg carries no
* storage-node wiring capacitance exactly once.
* schematic-leg DUT, inlined verbatim from /home/ubuntu/GitHub/sky130-gcedram/.loom/worktrees/issue-383/sim/pex_bitcell_array/reference/gain_cell_2t_array_4x4_schematic.spice (sha256:39b89352eef3d19ef005ec2424e949eca0ddcefaf0f450c25efef919f6431da1).
*
.param VDD    = 1.8
.param VRBL   = 0.9
.param TEDGE       = 1.000000e-10
.param TWL_ON      = 1.000000e-09
.param TWL_OFF     = 2.100000e-08
.param TBL_OFF     = 2.300000e-08
.param TRWL_ON     = 3.000000e-08
.param TRWL_OFF    = 5.000000e-08
.param THOLD_START = 5.500000e-08
.param VBL_DATA = 1.8
.param VSN_INIT = 0
* gain_cell_2t_array_4x4_schematic.spice -- 4x4 array schematic leg for the klt pex
* retention comparison (issue #383). GENERATED by gen_reference_netlists.py; do not edit.
* All 32 D/G/S/B tuples come from gain_cell_2t_array.lvs_reference.spice
* (sha256:547d2f6337bc49b61dbfae652ee8295c3b21ea08d7f1e0e2e8b0a49cb665b800); each is instantiated as the source bitcell's
* matching WR/RD SKY130 X card with its schematic geometry from design/gain_cell_2t.spice
* (sha256:7d1fe877ee5a7789e5b6f4b29788e1ecd927112de99e3156ba246eb2dcb73ad5) -- bare-micrometre L/W per the SKY130 subcircuit convention,
* numerically cross-checked against the LVS cards' 0.15U/0.42U. The extracted leg keeps its
* own extracted junction geometry. The wrapper's ORDERED 33-pin header is the committed
* array extraction's own header (gain_cell_2t_array.extract.parasitics.spice).
.SUBCKT gain_cell_2t_array_4x4_layout_0 GND bl_0 bl_1 bl_2 bl_3 rbl_0 rbl_1 rbl_2 rbl_3 rwl_0 rwl_1 rwl_2 rwl_3 sn_0_0 sn_0_1 sn_0_2 sn_0_3 sn_1_0 sn_1_1 sn_1_2 sn_1_3 sn_2_0 sn_2_1 sn_2_2 sn_2_3 sn_3_0 sn_3_1 sn_3_2 sn_3_3 wl_0 wl_1 wl_2 wl_3
X_WR_0_0 sn_0_0 wl_0 bl_0 GND sky130_fd_pr__nfet_01v8 L=0.15 W=0.42 nf=1 ad=0.1218 as=0.1218 pd=1.42 ps=1.42 nrd=0.69047619047619 nrs=0.69047619047619 sa=0 sb=0 sd=0 mult=1 m=1
X_RD_0_0 rbl_0 sn_0_0 rwl_0 GND sky130_fd_pr__nfet_01v8 L=0.15 W=0.42 nf=1 ad=0.1218 as=0.1218 pd=1.42 ps=1.42 nrd=0.69047619047619 nrs=0.69047619047619 sa=0 sb=0 sd=0 mult=1 m=1
X_WR_0_1 sn_0_1 wl_0 bl_1 GND sky130_fd_pr__nfet_01v8 L=0.15 W=0.42 nf=1 ad=0.1218 as=0.1218 pd=1.42 ps=1.42 nrd=0.69047619047619 nrs=0.69047619047619 sa=0 sb=0 sd=0 mult=1 m=1
X_RD_0_1 rbl_1 sn_0_1 rwl_0 GND sky130_fd_pr__nfet_01v8 L=0.15 W=0.42 nf=1 ad=0.1218 as=0.1218 pd=1.42 ps=1.42 nrd=0.69047619047619 nrs=0.69047619047619 sa=0 sb=0 sd=0 mult=1 m=1
X_WR_0_2 sn_0_2 wl_0 bl_2 GND sky130_fd_pr__nfet_01v8 L=0.15 W=0.42 nf=1 ad=0.1218 as=0.1218 pd=1.42 ps=1.42 nrd=0.69047619047619 nrs=0.69047619047619 sa=0 sb=0 sd=0 mult=1 m=1
X_RD_0_2 rbl_2 sn_0_2 rwl_0 GND sky130_fd_pr__nfet_01v8 L=0.15 W=0.42 nf=1 ad=0.1218 as=0.1218 pd=1.42 ps=1.42 nrd=0.69047619047619 nrs=0.69047619047619 sa=0 sb=0 sd=0 mult=1 m=1
X_WR_0_3 sn_0_3 wl_0 bl_3 GND sky130_fd_pr__nfet_01v8 L=0.15 W=0.42 nf=1 ad=0.1218 as=0.1218 pd=1.42 ps=1.42 nrd=0.69047619047619 nrs=0.69047619047619 sa=0 sb=0 sd=0 mult=1 m=1
X_RD_0_3 rbl_3 sn_0_3 rwl_0 GND sky130_fd_pr__nfet_01v8 L=0.15 W=0.42 nf=1 ad=0.1218 as=0.1218 pd=1.42 ps=1.42 nrd=0.69047619047619 nrs=0.69047619047619 sa=0 sb=0 sd=0 mult=1 m=1
X_WR_1_0 sn_1_0 wl_1 bl_0 GND sky130_fd_pr__nfet_01v8 L=0.15 W=0.42 nf=1 ad=0.1218 as=0.1218 pd=1.42 ps=1.42 nrd=0.69047619047619 nrs=0.69047619047619 sa=0 sb=0 sd=0 mult=1 m=1
X_RD_1_0 rbl_0 sn_1_0 rwl_1 GND sky130_fd_pr__nfet_01v8 L=0.15 W=0.42 nf=1 ad=0.1218 as=0.1218 pd=1.42 ps=1.42 nrd=0.69047619047619 nrs=0.69047619047619 sa=0 sb=0 sd=0 mult=1 m=1
X_WR_1_1 sn_1_1 wl_1 bl_1 GND sky130_fd_pr__nfet_01v8 L=0.15 W=0.42 nf=1 ad=0.1218 as=0.1218 pd=1.42 ps=1.42 nrd=0.69047619047619 nrs=0.69047619047619 sa=0 sb=0 sd=0 mult=1 m=1
X_RD_1_1 rbl_1 sn_1_1 rwl_1 GND sky130_fd_pr__nfet_01v8 L=0.15 W=0.42 nf=1 ad=0.1218 as=0.1218 pd=1.42 ps=1.42 nrd=0.69047619047619 nrs=0.69047619047619 sa=0 sb=0 sd=0 mult=1 m=1
X_WR_1_2 sn_1_2 wl_1 bl_2 GND sky130_fd_pr__nfet_01v8 L=0.15 W=0.42 nf=1 ad=0.1218 as=0.1218 pd=1.42 ps=1.42 nrd=0.69047619047619 nrs=0.69047619047619 sa=0 sb=0 sd=0 mult=1 m=1
X_RD_1_2 rbl_2 sn_1_2 rwl_1 GND sky130_fd_pr__nfet_01v8 L=0.15 W=0.42 nf=1 ad=0.1218 as=0.1218 pd=1.42 ps=1.42 nrd=0.69047619047619 nrs=0.69047619047619 sa=0 sb=0 sd=0 mult=1 m=1
X_WR_1_3 sn_1_3 wl_1 bl_3 GND sky130_fd_pr__nfet_01v8 L=0.15 W=0.42 nf=1 ad=0.1218 as=0.1218 pd=1.42 ps=1.42 nrd=0.69047619047619 nrs=0.69047619047619 sa=0 sb=0 sd=0 mult=1 m=1
X_RD_1_3 rbl_3 sn_1_3 rwl_1 GND sky130_fd_pr__nfet_01v8 L=0.15 W=0.42 nf=1 ad=0.1218 as=0.1218 pd=1.42 ps=1.42 nrd=0.69047619047619 nrs=0.69047619047619 sa=0 sb=0 sd=0 mult=1 m=1
X_WR_2_0 sn_2_0 wl_2 bl_0 GND sky130_fd_pr__nfet_01v8 L=0.15 W=0.42 nf=1 ad=0.1218 as=0.1218 pd=1.42 ps=1.42 nrd=0.69047619047619 nrs=0.69047619047619 sa=0 sb=0 sd=0 mult=1 m=1
X_RD_2_0 rbl_0 sn_2_0 rwl_2 GND sky130_fd_pr__nfet_01v8 L=0.15 W=0.42 nf=1 ad=0.1218 as=0.1218 pd=1.42 ps=1.42 nrd=0.69047619047619 nrs=0.69047619047619 sa=0 sb=0 sd=0 mult=1 m=1
X_WR_2_1 sn_2_1 wl_2 bl_1 GND sky130_fd_pr__nfet_01v8 L=0.15 W=0.42 nf=1 ad=0.1218 as=0.1218 pd=1.42 ps=1.42 nrd=0.69047619047619 nrs=0.69047619047619 sa=0 sb=0 sd=0 mult=1 m=1
X_RD_2_1 rbl_1 sn_2_1 rwl_2 GND sky130_fd_pr__nfet_01v8 L=0.15 W=0.42 nf=1 ad=0.1218 as=0.1218 pd=1.42 ps=1.42 nrd=0.69047619047619 nrs=0.69047619047619 sa=0 sb=0 sd=0 mult=1 m=1
X_WR_2_2 sn_2_2 wl_2 bl_2 GND sky130_fd_pr__nfet_01v8 L=0.15 W=0.42 nf=1 ad=0.1218 as=0.1218 pd=1.42 ps=1.42 nrd=0.69047619047619 nrs=0.69047619047619 sa=0 sb=0 sd=0 mult=1 m=1
X_RD_2_2 rbl_2 sn_2_2 rwl_2 GND sky130_fd_pr__nfet_01v8 L=0.15 W=0.42 nf=1 ad=0.1218 as=0.1218 pd=1.42 ps=1.42 nrd=0.69047619047619 nrs=0.69047619047619 sa=0 sb=0 sd=0 mult=1 m=1
X_WR_2_3 sn_2_3 wl_2 bl_3 GND sky130_fd_pr__nfet_01v8 L=0.15 W=0.42 nf=1 ad=0.1218 as=0.1218 pd=1.42 ps=1.42 nrd=0.69047619047619 nrs=0.69047619047619 sa=0 sb=0 sd=0 mult=1 m=1
X_RD_2_3 rbl_3 sn_2_3 rwl_2 GND sky130_fd_pr__nfet_01v8 L=0.15 W=0.42 nf=1 ad=0.1218 as=0.1218 pd=1.42 ps=1.42 nrd=0.69047619047619 nrs=0.69047619047619 sa=0 sb=0 sd=0 mult=1 m=1
X_WR_3_0 sn_3_0 wl_3 bl_0 GND sky130_fd_pr__nfet_01v8 L=0.15 W=0.42 nf=1 ad=0.1218 as=0.1218 pd=1.42 ps=1.42 nrd=0.69047619047619 nrs=0.69047619047619 sa=0 sb=0 sd=0 mult=1 m=1
X_RD_3_0 rbl_0 sn_3_0 rwl_3 GND sky130_fd_pr__nfet_01v8 L=0.15 W=0.42 nf=1 ad=0.1218 as=0.1218 pd=1.42 ps=1.42 nrd=0.69047619047619 nrs=0.69047619047619 sa=0 sb=0 sd=0 mult=1 m=1
X_WR_3_1 sn_3_1 wl_3 bl_1 GND sky130_fd_pr__nfet_01v8 L=0.15 W=0.42 nf=1 ad=0.1218 as=0.1218 pd=1.42 ps=1.42 nrd=0.69047619047619 nrs=0.69047619047619 sa=0 sb=0 sd=0 mult=1 m=1
X_RD_3_1 rbl_1 sn_3_1 rwl_3 GND sky130_fd_pr__nfet_01v8 L=0.15 W=0.42 nf=1 ad=0.1218 as=0.1218 pd=1.42 ps=1.42 nrd=0.69047619047619 nrs=0.69047619047619 sa=0 sb=0 sd=0 mult=1 m=1
X_WR_3_2 sn_3_2 wl_3 bl_2 GND sky130_fd_pr__nfet_01v8 L=0.15 W=0.42 nf=1 ad=0.1218 as=0.1218 pd=1.42 ps=1.42 nrd=0.69047619047619 nrs=0.69047619047619 sa=0 sb=0 sd=0 mult=1 m=1
X_RD_3_2 rbl_2 sn_3_2 rwl_3 GND sky130_fd_pr__nfet_01v8 L=0.15 W=0.42 nf=1 ad=0.1218 as=0.1218 pd=1.42 ps=1.42 nrd=0.69047619047619 nrs=0.69047619047619 sa=0 sb=0 sd=0 mult=1 m=1
X_WR_3_3 sn_3_3 wl_3 bl_3 GND sky130_fd_pr__nfet_01v8 L=0.15 W=0.42 nf=1 ad=0.1218 as=0.1218 pd=1.42 ps=1.42 nrd=0.69047619047619 nrs=0.69047619047619 sa=0 sb=0 sd=0 mult=1 m=1
X_RD_3_3 rbl_3 sn_3_3 rwl_3 GND sky130_fd_pr__nfet_01v8 L=0.15 W=0.42 nf=1 ad=0.1218 as=0.1218 pd=1.42 ps=1.42 nrd=0.69047619047619 nrs=0.69047619047619 sa=0 sb=0 sd=0 mult=1 m=1
.ENDS gain_cell_2t_array_4x4_layout_0

Xdut 0 bl_0 bl_1 bl_2 bl_3 rbl_0 rbl_1 rbl_2 rbl_3 rwl_0 rwl_1 rwl_2 rwl_3 sn_0_0 sn_0_1 sn_0_2 sn_0_3 sn_1_0 sn_1_1 sn_1_2 sn_1_3 sn_2_0 sn_2_1 sn_2_2 sn_2_3 sn_3_0 sn_3_1 sn_3_2 sn_3_3 wl_0 wl_1 wl_2 wl_3 gain_cell_2t_array_4x4_layout_0
* substrate DC reference: the extraction declares .GLOBAL vsubs and ties it
* through 1e12 ohm; an explicit 0 V source anchors it on BOTH legs (a coupling-
* capacitance delta needs a real AC ground, which a 1 Tohm tie is not). On the
* schematic leg the node simply does not exist in the DUT and the source is idle.
Vvsubs vsubs 0 DC 0

* selected row 0 / column 0: the single-cell write/read sequence
vwl_0 wl_0 0 pulse(0 {VDD} {TWL_ON} {TEDGE} {TEDGE} {TWL_OFF-TWL_ON-TEDGE} 1)
vwl_1 wl_1 0 dc 0
vwl_2 wl_2 0 dc 0
vwl_3 wl_3 0 dc 0
vbl_0 bl_0 0 pwl(0 {VBL_DATA} {TBL_OFF} {VBL_DATA} {TBL_OFF+TEDGE} 0)
vbl_1 bl_1 0 dc 0
vbl_2 bl_2 0 dc 0
vbl_3 bl_3 0 dc 0
vrwl_0 rwl_0 0 pwl(0 {VDD} {TRWL_ON} {VDD} {TRWL_ON+TEDGE} 0 {TRWL_OFF} 0 {TRWL_OFF+TEDGE} {VDD})
vrwl_1 rwl_1 0 dc {VDD}
vrwl_2 rwl_2 0 dc {VDD}
vrwl_3 rwl_3 0 dc {VDD}
vrbl_0 rbl_0 0 dc {VRBL}
vrbl_1 rbl_1 0 dc {VRBL}
vrbl_2 rbl_2 0 dc {VRBL}
vrbl_3 rbl_3 0 dc {VRBL}
* every storage node starts empty (stored '0'); sn_0_0 is then written '1'
.ic v(sn_0_0)={VSN_INIT}
.ic v(sn_0_1)={VSN_INIT}
.ic v(sn_0_2)={VSN_INIT}
.ic v(sn_0_3)={VSN_INIT}
.ic v(sn_1_0)={VSN_INIT}
.ic v(sn_1_1)={VSN_INIT}
.ic v(sn_1_2)={VSN_INIT}
.ic v(sn_1_3)={VSN_INIT}
.ic v(sn_2_0)={VSN_INIT}
.ic v(sn_2_1)={VSN_INIT}
.ic v(sn_2_2)={VSN_INIT}
.ic v(sn_2_3)={VSN_INIT}
.ic v(sn_3_0)={VSN_INIT}
.ic v(sn_3_1)={VSN_INIT}
.ic v(sn_3_2)={VSN_INIT}
.ic v(sn_3_3)={VSN_INIT}
* unselected-line biases during hold: wl_*=0, bl_*=0 (write path off), rwl_*=VDD (rows deselected, active-low read), rbl_*=VRBL
