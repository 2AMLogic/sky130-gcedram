* compact_device_c_sn.spice -- device-inclusive storage-node capacitance, compact v2 extracted array (issue #208).
* GENERATED by compact_device_c_sn.py; do not edit.
*
* CIRCUIT BODY for `klt sim`: no .control/.end; the PDK .lib/.temp cards are appended per corner by klt. Flat and
* self-contained (the batch fleet receives only this file + request.json).
*
* Each instance is the committed extracted array layout/compact/gain_cell_2t_v2_array.extract.parasitics.spice
* node-for-node with the instance id appended to every net, generic `nfet` -> sky130_fd_pr__nfet_01v8, GND and
* vsubs tied to ideal ground. Drawn diffusion AD/AS/PD/PS are the extracted ones.
* Instance ids: a_<n> / p_<n> / b_<n> = variant a / p / b probing storage node <n> (see the generator docstring:
*   a = extracted wiring C kept, devices on top (may double count channel poly); p = the node's whole extracted poly
*   ground C removed; b = as a with rbl = rwl = 0 V). rate = limiting node of a at 1/5 the current; ctl = ideal 1 fF.
* Probed node: a known current is drawn from its hub (tanh-gated off below 0.05 V) and the 1.0 ... 0.1 V crossing
* times are measured (.meas WHEN). All other storage nodes are ideal sources (quiet neighbours); wl = bl = 0 V.
* ASSUMPTIONS (labelled; none is a spec value): ideal drivers, stored '1' = 1.0 V, neighbours 1.0 V, no mismatch.

.options gmin=1e-15 abstol=1e-15 chgtol=1e-18 reltol=1e-4
.param VDD = 1.8
vdd  vdd  0 dc {VDD}
vrbl vrbl 0 dc 0.9

* ---- instance a_n7: variant a, probed storage node \$7 ----
xm1_a_n7 rwl_0__t2_a_n7 n7__t0_a_n7 rbl_0__t0_a_n7 gnd__t0_a_n7 sky130_fd_pr__nfet_01v8 L=0.15 W=0.42 nf=1 ad=0.1197 as=0.1197 pd=1.41 ps=1.41 mult=1 m=1
xm2_a_n7 rwl_0__t3_a_n7 n8__t1_a_n7 rbl_1__t1_a_n7 gnd__t1_a_n7 sky130_fd_pr__nfet_01v8 L=0.15 W=0.42 nf=1 ad=0.1197 as=0.1197 pd=1.41 ps=1.41 mult=1 m=1
xm3_a_n7 rwl_0__t1_a_n7 n9__t1_a_n7 rbl_2__t1_a_n7 gnd__t2_a_n7 sky130_fd_pr__nfet_01v8 L=0.15 W=0.42 nf=1 ad=0.1197 as=0.1197 pd=1.41 ps=1.41 mult=1 m=1
xm4_a_n7 rwl_0__t0_a_n7 n10__t1_a_n7 rbl_3__t1_a_n7 gnd__t3_a_n7 sky130_fd_pr__nfet_01v8 L=0.15 W=0.42 nf=1 ad=0.1197 as=0.1197 pd=1.41 ps=1.41 mult=1 m=1
xm5_a_n7 bl_0__t0_a_n7 wl_0__t0_a_n7 n7__t1_a_n7 gnd__t8_a_n7 sky130_fd_pr__nfet_01v8 L=0.15 W=0.42 nf=1 ad=0.0588 as=0.1197 pd=0.7 ps=1.41 mult=1 m=1
xm6_a_n7 n17__t0_a_n7 wl_1__t0_a_n7 bl_0__t1_a_n7 gnd__t20_a_n7 sky130_fd_pr__nfet_01v8 L=0.15 W=0.42 nf=1 ad=0.1197 as=0.0588 pd=1.41 ps=0.7 mult=1 m=1
xm7_a_n7 bl_1__t2_a_n7 wl_0__t3_a_n7 n8__t0_a_n7 gnd__t9_a_n7 sky130_fd_pr__nfet_01v8 L=0.15 W=0.42 nf=1 ad=0.0588 as=0.1197 pd=0.7 ps=1.41 mult=1 m=1
xm8_a_n7 n18__t0_a_n7 wl_1__t1_a_n7 bl_1__t0_a_n7 gnd__t21_a_n7 sky130_fd_pr__nfet_01v8 L=0.15 W=0.42 nf=1 ad=0.1197 as=0.0588 pd=1.41 ps=0.7 mult=1 m=1
xm9_a_n7 bl_2__t2_a_n7 wl_0__t2_a_n7 n9__t0_a_n7 gnd__t10_a_n7 sky130_fd_pr__nfet_01v8 L=0.15 W=0.42 nf=1 ad=0.0588 as=0.1197 pd=0.7 ps=1.41 mult=1 m=1
xm10_a_n7 n19__t0_a_n7 wl_1__t2_a_n7 bl_2__t0_a_n7 gnd__t22_a_n7 sky130_fd_pr__nfet_01v8 L=0.15 W=0.42 nf=1 ad=0.1197 as=0.0588 pd=1.41 ps=0.7 mult=1 m=1
xm11_a_n7 bl_3__t2_a_n7 wl_0__t1_a_n7 n10__t0_a_n7 gnd__t11_a_n7 sky130_fd_pr__nfet_01v8 L=0.15 W=0.42 nf=1 ad=0.0588 as=0.1197 pd=0.7 ps=1.41 mult=1 m=1
xm12_a_n7 n20__t0_a_n7 wl_1__t3_a_n7 bl_3__t1_a_n7 gnd__t23_a_n7 sky130_fd_pr__nfet_01v8 L=0.15 W=0.42 nf=1 ad=0.1197 as=0.0588 pd=1.41 ps=0.7 mult=1 m=1
xm13_a_n7 rbl_0__t3_a_n7 n17__t1_a_n7 rwl_1__t0_a_n7 gnd__t12_a_n7 sky130_fd_pr__nfet_01v8 L=0.15 W=0.42 nf=1 ad=0.0588 as=0.1197 pd=0.7 ps=1.41 mult=1 m=1
xm14_a_n7 rwl_2__t3_a_n7 n22__t0_a_n7 rbl_0__t2_a_n7 gnd__t24_a_n7 sky130_fd_pr__nfet_01v8 L=0.15 W=0.42 nf=1 ad=0.1197 as=0.0588 pd=1.41 ps=0.7 mult=1 m=1
xm15_a_n7 rbl_1__t3_a_n7 n18__t1_a_n7 rwl_1__t1_a_n7 gnd__t13_a_n7 sky130_fd_pr__nfet_01v8 L=0.15 W=0.42 nf=1 ad=0.0588 as=0.1197 pd=0.7 ps=1.41 mult=1 m=1
xm16_a_n7 rwl_2__t0_a_n7 n23__t0_a_n7 rbl_1__t2_a_n7 gnd__t25_a_n7 sky130_fd_pr__nfet_01v8 L=0.15 W=0.42 nf=1 ad=0.1197 as=0.0588 pd=1.41 ps=0.7 mult=1 m=1
xm17_a_n7 rbl_2__t3_a_n7 n19__t1_a_n7 rwl_1__t2_a_n7 gnd__t14_a_n7 sky130_fd_pr__nfet_01v8 L=0.15 W=0.42 nf=1 ad=0.0588 as=0.1197 pd=0.7 ps=1.41 mult=1 m=1
xm18_a_n7 rwl_2__t1_a_n7 n24__t0_a_n7 rbl_2__t2_a_n7 gnd__t26_a_n7 sky130_fd_pr__nfet_01v8 L=0.15 W=0.42 nf=1 ad=0.1197 as=0.0588 pd=1.41 ps=0.7 mult=1 m=1
xm19_a_n7 rbl_3__t3_a_n7 n20__t1_a_n7 rwl_1__t3_a_n7 gnd__t15_a_n7 sky130_fd_pr__nfet_01v8 L=0.15 W=0.42 nf=1 ad=0.0588 as=0.1197 pd=0.7 ps=1.41 mult=1 m=1
xm20_a_n7 rwl_2__t2_a_n7 n25__t0_a_n7 rbl_3__t2_a_n7 gnd__t27_a_n7 sky130_fd_pr__nfet_01v8 L=0.15 W=0.42 nf=1 ad=0.1197 as=0.0588 pd=1.41 ps=0.7 mult=1 m=1
xm21_a_n7 bl_0__t3_a_n7 wl_2__t0_a_n7 n22__t1_a_n7 gnd__t16_a_n7 sky130_fd_pr__nfet_01v8 L=0.15 W=0.42 nf=1 ad=0.0588 as=0.1197 pd=0.7 ps=1.41 mult=1 m=1
xm22_a_n7 n29__t0_a_n7 wl_3__t3_a_n7 bl_0__t2_a_n7 gnd__t28_a_n7 sky130_fd_pr__nfet_01v8 L=0.15 W=0.42 nf=1 ad=0.1197 as=0.0588 pd=1.41 ps=0.7 mult=1 m=1
xm23_a_n7 bl_1__t3_a_n7 wl_2__t1_a_n7 n23__t1_a_n7 gnd__t17_a_n7 sky130_fd_pr__nfet_01v8 L=0.15 W=0.42 nf=1 ad=0.0588 as=0.1197 pd=0.7 ps=1.41 mult=1 m=1
xm24_a_n7 n30__t0_a_n7 wl_3__t2_a_n7 bl_1__t1_a_n7 gnd__t29_a_n7 sky130_fd_pr__nfet_01v8 L=0.15 W=0.42 nf=1 ad=0.1197 as=0.0588 pd=1.41 ps=0.7 mult=1 m=1
xm25_a_n7 bl_2__t3_a_n7 wl_2__t2_a_n7 n24__t1_a_n7 gnd__t18_a_n7 sky130_fd_pr__nfet_01v8 L=0.15 W=0.42 nf=1 ad=0.0588 as=0.1197 pd=0.7 ps=1.41 mult=1 m=1
xm26_a_n7 n31__t0_a_n7 wl_3__t1_a_n7 bl_2__t1_a_n7 gnd__t30_a_n7 sky130_fd_pr__nfet_01v8 L=0.15 W=0.42 nf=1 ad=0.1197 as=0.0588 pd=1.41 ps=0.7 mult=1 m=1
xm27_a_n7 bl_3__t3_a_n7 wl_2__t3_a_n7 n25__t1_a_n7 gnd__t19_a_n7 sky130_fd_pr__nfet_01v8 L=0.15 W=0.42 nf=1 ad=0.0588 as=0.1197 pd=0.7 ps=1.41 mult=1 m=1
xm28_a_n7 n32__t0_a_n7 wl_3__t0_a_n7 bl_3__t0_a_n7 gnd__t31_a_n7 sky130_fd_pr__nfet_01v8 L=0.15 W=0.42 nf=1 ad=0.1197 as=0.0588 pd=1.41 ps=0.7 mult=1 m=1
xm29_a_n7 rbl_0__t1_a_n7 n29__t1_a_n7 rwl_3__t0_a_n7 gnd__t4_a_n7 sky130_fd_pr__nfet_01v8 L=0.15 W=0.42 nf=1 ad=0.1197 as=0.1197 pd=1.41 ps=1.41 mult=1 m=1
xm30_a_n7 rbl_1__t0_a_n7 n30__t1_a_n7 rwl_3__t1_a_n7 gnd__t5_a_n7 sky130_fd_pr__nfet_01v8 L=0.15 W=0.42 nf=1 ad=0.1197 as=0.1197 pd=1.41 ps=1.41 mult=1 m=1
xm31_a_n7 rbl_2__t0_a_n7 n31__t1_a_n7 rwl_3__t2_a_n7 gnd__t6_a_n7 sky130_fd_pr__nfet_01v8 L=0.15 W=0.42 nf=1 ad=0.1197 as=0.1197 pd=1.41 ps=1.41 mult=1 m=1
xm32_a_n7 rbl_3__t0_a_n7 n32__t1_a_n7 rwl_3__t3_a_n7 gnd__t7_a_n7 sky130_fd_pr__nfet_01v8 L=0.15 W=0.42 nf=1 ad=0.1197 as=0.1197 pd=1.41 ps=1.41 mult=1 m=1
r_10_t0_a_n7 n10__t0_a_n7 n10_a_n7 183.071
r_10_t1_a_n7 n10__t1_a_n7 n10_a_n7 183.071
r_17_t0_a_n7 n17__t0_a_n7 n17_a_n7 183.071
r_17_t1_a_n7 n17__t1_a_n7 n17_a_n7 183.071
r_18_t0_a_n7 n18__t0_a_n7 n18_a_n7 183.071
r_18_t1_a_n7 n18__t1_a_n7 n18_a_n7 183.071
r_19_t0_a_n7 n19__t0_a_n7 n19_a_n7 183.071
r_19_t1_a_n7 n19__t1_a_n7 n19_a_n7 183.071
r_20_t0_a_n7 n20__t0_a_n7 n20_a_n7 183.071
r_20_t1_a_n7 n20__t1_a_n7 n20_a_n7 183.071
r_22_t0_a_n7 n22__t0_a_n7 n22_a_n7 183.071
r_22_t1_a_n7 n22__t1_a_n7 n22_a_n7 183.071
r_23_t0_a_n7 n23__t0_a_n7 n23_a_n7 183.071
r_23_t1_a_n7 n23__t1_a_n7 n23_a_n7 183.071
r_24_t0_a_n7 n24__t0_a_n7 n24_a_n7 183.071
r_24_t1_a_n7 n24__t1_a_n7 n24_a_n7 183.071
r_25_t0_a_n7 n25__t0_a_n7 n25_a_n7 183.071
r_25_t1_a_n7 n25__t1_a_n7 n25_a_n7 183.071
r_29_t0_a_n7 n29__t0_a_n7 n29_a_n7 183.071
r_29_t1_a_n7 n29__t1_a_n7 n29_a_n7 183.071
r_30_t0_a_n7 n30__t0_a_n7 n30_a_n7 183.071
r_30_t1_a_n7 n30__t1_a_n7 n30_a_n7 183.071
r_31_t0_a_n7 n31__t0_a_n7 n31_a_n7 183.071
r_31_t1_a_n7 n31__t1_a_n7 n31_a_n7 183.071
r_32_t0_a_n7 n32__t0_a_n7 n32_a_n7 183.071
r_32_t1_a_n7 n32__t1_a_n7 n32_a_n7 183.071
r_7_t0_a_n7 n7__t0_a_n7 n7_a_n7 183.071
r_7_t1_a_n7 n7__t1_a_n7 n7_a_n7 183.071
r_8_t0_a_n7 n8__t0_a_n7 n8_a_n7 183.071
r_8_t1_a_n7 n8__t1_a_n7 n8_a_n7 183.071
r_9_t0_a_n7 n9__t0_a_n7 n9_a_n7 183.071
r_9_t1_a_n7 n9__t1_a_n7 n9_a_n7 183.071
rgnd_t0_a_n7 gnd__t0_a_n7 0 38.2988
rgnd_t1_a_n7 gnd__t1_a_n7 0 33.9576
rgnd_t2_a_n7 gnd__t2_a_n7 0 33.9576
rgnd_t3_a_n7 gnd__t3_a_n7 0 38.2988
rgnd_t4_a_n7 gnd__t4_a_n7 0 38.2988
rgnd_t5_a_n7 gnd__t5_a_n7 0 33.9576
rgnd_t6_a_n7 gnd__t6_a_n7 0 33.9576
rgnd_t7_a_n7 gnd__t7_a_n7 0 38.2988
rgnd_t8_a_n7 gnd__t8_a_n7 0 28.0185
rgnd_t9_a_n7 gnd__t9_a_n7 0 21.7106
rgnd_t10_a_n7 gnd__t10_a_n7 0 21.7106
rgnd_t11_a_n7 gnd__t11_a_n7 0 28.0185
rgnd_t12_a_n7 gnd__t12_a_n7 0 18.9833
rgnd_t13_a_n7 gnd__t13_a_n7 0 6.8325
rgnd_t14_a_n7 gnd__t14_a_n7 0 6.8325
rgnd_t15_a_n7 gnd__t15_a_n7 0 18.9833
rgnd_t16_a_n7 gnd__t16_a_n7 0 24.2409
rgnd_t17_a_n7 gnd__t17_a_n7 0 16.5511
rgnd_t18_a_n7 gnd__t18_a_n7 0 16.5511
rgnd_t19_a_n7 gnd__t19_a_n7 0 24.2409
rgnd_t20_a_n7 gnd__t20_a_n7 0 24.2409
rgnd_t21_a_n7 gnd__t21_a_n7 0 16.5511
rgnd_t22_a_n7 gnd__t22_a_n7 0 16.5511
rgnd_t23_a_n7 gnd__t23_a_n7 0 24.2409
rgnd_t24_a_n7 gnd__t24_a_n7 0 18.9833
rgnd_t25_a_n7 gnd__t25_a_n7 0 6.8325
rgnd_t26_a_n7 gnd__t26_a_n7 0 6.8325
rgnd_t27_a_n7 gnd__t27_a_n7 0 18.9833
rgnd_t28_a_n7 gnd__t28_a_n7 0 28.0185
rgnd_t29_a_n7 gnd__t29_a_n7 0 21.7106
rgnd_t30_a_n7 gnd__t30_a_n7 0 21.7106
rgnd_t31_a_n7 gnd__t31_a_n7 0 28.0185
rbl_0_t0_a_n7 bl_0__t0_a_n7 bl_0_a_n7 14.8304
rbl_0_t1_a_n7 bl_0__t1_a_n7 bl_0_a_n7 10.9301
rbl_0_t2_a_n7 bl_0__t2_a_n7 bl_0_a_n7 14.8304
rbl_0_t3_a_n7 bl_0__t3_a_n7 bl_0_a_n7 10.9301
rbl_1_t0_a_n7 bl_1__t0_a_n7 bl_1_a_n7 10.9301
rbl_1_t1_a_n7 bl_1__t1_a_n7 bl_1_a_n7 14.8304
rbl_1_t2_a_n7 bl_1__t2_a_n7 bl_1_a_n7 14.8304
rbl_1_t3_a_n7 bl_1__t3_a_n7 bl_1_a_n7 10.9301
rbl_2_t0_a_n7 bl_2__t0_a_n7 bl_2_a_n7 10.9301
rbl_2_t1_a_n7 bl_2__t1_a_n7 bl_2_a_n7 14.8304
rbl_2_t2_a_n7 bl_2__t2_a_n7 bl_2_a_n7 14.8304
rbl_2_t3_a_n7 bl_2__t3_a_n7 bl_2_a_n7 10.9301
rbl_3_t0_a_n7 bl_3__t0_a_n7 bl_3_a_n7 14.8304
rbl_3_t1_a_n7 bl_3__t1_a_n7 bl_3_a_n7 10.9301
rbl_3_t2_a_n7 bl_3__t2_a_n7 bl_3_a_n7 14.8304
rbl_3_t3_a_n7 bl_3__t3_a_n7 bl_3_a_n7 10.9301
rrbl_0_t0_a_n7 rbl_0__t0_a_n7 rbl_0_a_n7 36.5601
rrbl_0_t1_a_n7 rbl_0__t1_a_n7 rbl_0_a_n7 36.5601
rrbl_0_t2_a_n7 rbl_0__t2_a_n7 rbl_0_a_n7 2.99444
rrbl_0_t3_a_n7 rbl_0__t3_a_n7 rbl_0_a_n7 2.99444
rrbl_1_t0_a_n7 rbl_1__t0_a_n7 rbl_1_a_n7 36.5601
rrbl_1_t1_a_n7 rbl_1__t1_a_n7 rbl_1_a_n7 36.5601
rrbl_1_t2_a_n7 rbl_1__t2_a_n7 rbl_1_a_n7 2.99444
rrbl_1_t3_a_n7 rbl_1__t3_a_n7 rbl_1_a_n7 2.99444
rrbl_2_t0_a_n7 rbl_2__t0_a_n7 rbl_2_a_n7 36.5601
rrbl_2_t1_a_n7 rbl_2__t1_a_n7 rbl_2_a_n7 36.5601
rrbl_2_t2_a_n7 rbl_2__t2_a_n7 rbl_2_a_n7 2.99444
rrbl_2_t3_a_n7 rbl_2__t3_a_n7 rbl_2_a_n7 2.99444
rrbl_3_t0_a_n7 rbl_3__t0_a_n7 rbl_3_a_n7 36.5601
rrbl_3_t1_a_n7 rbl_3__t1_a_n7 rbl_3_a_n7 36.5601
rrbl_3_t2_a_n7 rbl_3__t2_a_n7 rbl_3_a_n7 2.99444
rrbl_3_t3_a_n7 rbl_3__t3_a_n7 rbl_3_a_n7 2.99444
rrwl_0_t0_a_n7 rwl_0__t0_a_n7 rwl_0_a_n7 38.2618
rrwl_0_t1_a_n7 rwl_0__t1_a_n7 rwl_0_a_n7 12.7539
rrwl_0_t2_a_n7 rwl_0__t2_a_n7 rwl_0_a_n7 38.2618
rrwl_0_t3_a_n7 rwl_0__t3_a_n7 rwl_0_a_n7 12.7539
rrwl_1_t0_a_n7 rwl_1__t0_a_n7 rwl_1_a_n7 38.2618
rrwl_1_t1_a_n7 rwl_1__t1_a_n7 rwl_1_a_n7 12.7539
rrwl_1_t2_a_n7 rwl_1__t2_a_n7 rwl_1_a_n7 12.7539
rrwl_1_t3_a_n7 rwl_1__t3_a_n7 rwl_1_a_n7 38.2618
rrwl_2_t0_a_n7 rwl_2__t0_a_n7 rwl_2_a_n7 12.7539
rrwl_2_t1_a_n7 rwl_2__t1_a_n7 rwl_2_a_n7 12.7539
rrwl_2_t2_a_n7 rwl_2__t2_a_n7 rwl_2_a_n7 38.2618
rrwl_2_t3_a_n7 rwl_2__t3_a_n7 rwl_2_a_n7 38.2618
rrwl_3_t0_a_n7 rwl_3__t0_a_n7 rwl_3_a_n7 38.2618
rrwl_3_t1_a_n7 rwl_3__t1_a_n7 rwl_3_a_n7 12.7539
rrwl_3_t2_a_n7 rwl_3__t2_a_n7 rwl_3_a_n7 12.7539
rrwl_3_t3_a_n7 rwl_3__t3_a_n7 rwl_3_a_n7 38.2618
rwl_0_t0_a_n7 wl_0__t0_a_n7 wl_0_a_n7 245.959
rwl_0_t1_a_n7 wl_0__t1_a_n7 wl_0_a_n7 245.959
rwl_0_t2_a_n7 wl_0__t2_a_n7 wl_0_a_n7 81.9864
rwl_0_t3_a_n7 wl_0__t3_a_n7 wl_0_a_n7 81.9864
rwl_1_t0_a_n7 wl_1__t0_a_n7 wl_1_a_n7 245.959
rwl_1_t1_a_n7 wl_1__t1_a_n7 wl_1_a_n7 81.9864
rwl_1_t2_a_n7 wl_1__t2_a_n7 wl_1_a_n7 81.9864
rwl_1_t3_a_n7 wl_1__t3_a_n7 wl_1_a_n7 245.959
rwl_2_t0_a_n7 wl_2__t0_a_n7 wl_2_a_n7 245.959
rwl_2_t1_a_n7 wl_2__t1_a_n7 wl_2_a_n7 81.9864
rwl_2_t2_a_n7 wl_2__t2_a_n7 wl_2_a_n7 81.9864
rwl_2_t3_a_n7 wl_2__t3_a_n7 wl_2_a_n7 245.959
rwl_3_t0_a_n7 wl_3__t0_a_n7 wl_3_a_n7 245.959
rwl_3_t1_a_n7 wl_3__t1_a_n7 wl_3_a_n7 81.9864
rwl_3_t2_a_n7 wl_3__t2_a_n7 wl_3_a_n7 81.9864
rwl_3_t3_a_n7 wl_3__t3_a_n7 wl_3_a_n7 245.959
c_10_a_n7 n10_a_n7 0 2.91622e-16
c_17_a_n7 n17_a_n7 0 2.91528e-16
c_18_a_n7 n18_a_n7 0 2.91528e-16
c_19_a_n7 n19_a_n7 0 2.91528e-16
c_20_a_n7 n20_a_n7 0 2.91622e-16
c_22_a_n7 n22_a_n7 0 2.91528e-16
c_23_a_n7 n23_a_n7 0 2.91528e-16
c_24_a_n7 n24_a_n7 0 2.91528e-16
c_25_a_n7 n25_a_n7 0 2.91622e-16
c_29_a_n7 n29_a_n7 0 2.91528e-16
c_30_a_n7 n30_a_n7 0 2.91528e-16
c_31_a_n7 n31_a_n7 0 2.91528e-16
c_32_a_n7 n32_a_n7 0 2.91622e-16
c_7_a_n7 n7_a_n7 0 2.91528e-16
c_8_a_n7 n8_a_n7 0 2.91528e-16
c_9_a_n7 n9_a_n7 0 2.91528e-16
cgnd_a_n7 0 0 2.48166e-15
cbl_0_a_n7 bl_0_a_n7 0 4.52661e-16
cbl_1_a_n7 bl_1_a_n7 0 4.52661e-16
cbl_2_a_n7 bl_2_a_n7 0 4.52661e-16
cbl_3_a_n7 bl_3_a_n7 0 4.52661e-16
crbl_0_a_n7 rbl_0_a_n7 0 9.14472e-16
crbl_1_a_n7 rbl_1_a_n7 0 9.14472e-16
crbl_2_a_n7 rbl_2_a_n7 0 9.14472e-16
crbl_3_a_n7 rbl_3_a_n7 0 9.17566e-16
crwl_0_a_n7 rwl_0_a_n7 0 5.19495e-16
crwl_1_a_n7 rwl_1_a_n7 0 5.11719e-16
crwl_2_a_n7 rwl_2_a_n7 0 5.11719e-16
crwl_3_a_n7 rwl_3_a_n7 0 5.19495e-16
cwl_0_a_n7 wl_0_a_n7 0 3.30388e-16
cwl_1_a_n7 wl_1_a_n7 0 3.30388e-16
cwl_2_a_n7 wl_2_a_n7 0 3.30388e-16
cwl_3_a_n7 wl_3_a_n7 0 3.30388e-16
ccc__10__9_a_n7 n10_a_n7 n9_a_n7 1.02e-17
ccc__10_bl_3_a_n7 n10_a_n7 bl_3_a_n7 1.3999e-17
ccc__10_rwl_0_a_n7 n10_a_n7 rwl_0_a_n7 4.335e-18
ccc__17__18_a_n7 n17_a_n7 n18_a_n7 1.02e-17
ccc__17_bl_0_a_n7 n17_a_n7 bl_0_a_n7 8.415e-18
ccc__17_rwl_1_a_n7 n17_a_n7 rwl_1_a_n7 1.3194e-17
ccc__18__19_a_n7 n18_a_n7 n19_a_n7 1.02e-17
ccc__18_bl_1_a_n7 n18_a_n7 bl_1_a_n7 8.415e-18
ccc__18_rwl_1_a_n7 n18_a_n7 rwl_1_a_n7 1.3194e-17
ccc__19__20_a_n7 n19_a_n7 n20_a_n7 1.02e-17
ccc__19_bl_2_a_n7 n19_a_n7 bl_2_a_n7 8.415e-18
ccc__19_rwl_1_a_n7 n19_a_n7 rwl_1_a_n7 1.3194e-17
ccc__20_bl_3_a_n7 n20_a_n7 bl_3_a_n7 8.415e-18
ccc__20_rwl_1_a_n7 n20_a_n7 rwl_1_a_n7 6.655e-18
ccc__22__23_a_n7 n22_a_n7 n23_a_n7 1.02e-17
ccc__22_bl_0_a_n7 n22_a_n7 bl_0_a_n7 8.415e-18
ccc__22_rwl_2_a_n7 n22_a_n7 rwl_2_a_n7 1.3194e-17
ccc__23__24_a_n7 n23_a_n7 n24_a_n7 1.02e-17
ccc__23_bl_1_a_n7 n23_a_n7 bl_1_a_n7 8.415e-18
ccc__23_rwl_2_a_n7 n23_a_n7 rwl_2_a_n7 1.3194e-17
ccc__24__25_a_n7 n24_a_n7 n25_a_n7 1.02e-17
ccc__24_bl_2_a_n7 n24_a_n7 bl_2_a_n7 8.415e-18
ccc__24_rwl_2_a_n7 n24_a_n7 rwl_2_a_n7 1.3194e-17
ccc__25_bl_3_a_n7 n25_a_n7 bl_3_a_n7 8.415e-18
ccc__25_rwl_2_a_n7 n25_a_n7 rwl_2_a_n7 6.655e-18
ccc__29__30_a_n7 n29_a_n7 n30_a_n7 1.02e-17
ccc__29_bl_0_a_n7 n29_a_n7 bl_0_a_n7 8.415e-18
ccc__29_rwl_3_a_n7 n29_a_n7 rwl_3_a_n7 1.3194e-17
ccc__30__31_a_n7 n30_a_n7 n31_a_n7 1.02e-17
ccc__30_bl_1_a_n7 n30_a_n7 bl_1_a_n7 8.415e-18
ccc__30_rwl_3_a_n7 n30_a_n7 rwl_3_a_n7 1.3194e-17
ccc__31__32_a_n7 n31_a_n7 n32_a_n7 1.02e-17
ccc__31_bl_2_a_n7 n31_a_n7 bl_2_a_n7 8.415e-18
ccc__31_rwl_3_a_n7 n31_a_n7 rwl_3_a_n7 1.3194e-17
ccc__32_bl_3_a_n7 n32_a_n7 bl_3_a_n7 8.415e-18
ccc__32_rwl_3_a_n7 n32_a_n7 rwl_3_a_n7 6.655e-18
ccc__7__8_a_n7 n7_a_n7 n8_a_n7 1.02e-17
ccc__7_bl_0_a_n7 n7_a_n7 bl_0_a_n7 1.3999e-17
ccc__7_rwl_0_a_n7 n7_a_n7 rwl_0_a_n7 8.961e-18
ccc__8__9_a_n7 n8_a_n7 n9_a_n7 1.02e-17
ccc__8_bl_1_a_n7 n8_a_n7 bl_1_a_n7 1.3999e-17
ccc__8_rwl_0_a_n7 n8_a_n7 rwl_0_a_n7 8.961e-18
ccc__9_bl_2_a_n7 n9_a_n7 bl_2_a_n7 1.3999e-17
ccc__9_rwl_0_a_n7 n9_a_n7 rwl_0_a_n7 8.961e-18
ccc_bl_0_rbl_0_a_n7 bl_0_a_n7 rbl_0_a_n7 1.88693e-16
ccc_bl_0_rwl_1_a_n7 bl_0_a_n7 rwl_1_a_n7 1.0093e-17
ccc_bl_0_rwl_2_a_n7 bl_0_a_n7 rwl_2_a_n7 1.0093e-17
ccc_bl_1_rbl_0_a_n7 bl_1_a_n7 rbl_0_a_n7 1.633e-16
ccc_bl_1_rbl_1_a_n7 bl_1_a_n7 rbl_1_a_n7 1.88693e-16
ccc_bl_1_rwl_1_a_n7 bl_1_a_n7 rwl_1_a_n7 1.0093e-17
ccc_bl_1_rwl_2_a_n7 bl_1_a_n7 rwl_2_a_n7 1.0093e-17
ccc_bl_2_rbl_1_a_n7 bl_2_a_n7 rbl_1_a_n7 1.633e-16
ccc_bl_2_rbl_2_a_n7 bl_2_a_n7 rbl_2_a_n7 1.88693e-16
ccc_bl_2_rwl_1_a_n7 bl_2_a_n7 rwl_1_a_n7 1.0093e-17
ccc_bl_2_rwl_2_a_n7 bl_2_a_n7 rwl_2_a_n7 1.0093e-17
ccc_bl_3_rbl_2_a_n7 bl_3_a_n7 rbl_2_a_n7 1.633e-16
ccc_bl_3_rbl_3_a_n7 bl_3_a_n7 rbl_3_a_n7 1.88693e-16
ccc_bl_3_rwl_1_a_n7 bl_3_a_n7 rwl_1_a_n7 1.0093e-17
ccc_bl_3_rwl_2_a_n7 bl_3_a_n7 rwl_2_a_n7 1.0093e-17
ccc_rbl_0_rbl_1_a_n7 rbl_0_a_n7 rbl_1_a_n7 3.432e-17
ccc_rbl_0_rwl_0_a_n7 rbl_0_a_n7 rwl_0_a_n7 4.9752e-17
ccc_rbl_0_rwl_1_a_n7 rbl_0_a_n7 rwl_1_a_n7 4.9752e-17
ccc_rbl_0_rwl_2_a_n7 rbl_0_a_n7 rwl_2_a_n7 4.9752e-17
ccc_rbl_0_rwl_3_a_n7 rbl_0_a_n7 rwl_3_a_n7 4.9752e-17
ccc_rbl_1_rbl_2_a_n7 rbl_1_a_n7 rbl_2_a_n7 3.432e-17
ccc_rbl_1_rwl_0_a_n7 rbl_1_a_n7 rwl_0_a_n7 4.9752e-17
ccc_rbl_1_rwl_1_a_n7 rbl_1_a_n7 rwl_1_a_n7 4.9752e-17
ccc_rbl_1_rwl_2_a_n7 rbl_1_a_n7 rwl_2_a_n7 4.9752e-17
ccc_rbl_1_rwl_3_a_n7 rbl_1_a_n7 rwl_3_a_n7 4.9752e-17
ccc_rbl_2_rbl_3_a_n7 rbl_2_a_n7 rbl_3_a_n7 3.432e-17
ccc_rbl_2_rwl_0_a_n7 rbl_2_a_n7 rwl_0_a_n7 4.9752e-17
ccc_rbl_2_rwl_1_a_n7 rbl_2_a_n7 rwl_1_a_n7 4.9752e-17
ccc_rbl_2_rwl_2_a_n7 rbl_2_a_n7 rwl_2_a_n7 4.9752e-17
ccc_rbl_2_rwl_3_a_n7 rbl_2_a_n7 rwl_3_a_n7 4.9752e-17
ccc_rbl_3_rwl_0_a_n7 rbl_3_a_n7 rwl_0_a_n7 3.3407e-17
ccc_rbl_3_rwl_1_a_n7 rbl_3_a_n7 rwl_1_a_n7 3.3407e-17
ccc_rbl_3_rwl_2_a_n7 rbl_3_a_n7 rwl_2_a_n7 3.3407e-17
ccc_rbl_3_rwl_3_a_n7 rbl_3_a_n7 rwl_3_a_n7 3.3407e-17
vdw_a_n7_0 wl_0_a_n7 0 dc 0
vdr_a_n7_0 rwl_0_a_n7 vdd dc 0
vdw_a_n7_1 wl_1_a_n7 0 dc 0
vdr_a_n7_1 rwl_1_a_n7 vdd dc 0
vdw_a_n7_2 wl_2_a_n7 0 dc 0
vdr_a_n7_2 rwl_2_a_n7 vdd dc 0
vdw_a_n7_3 wl_3_a_n7 0 dc 0
vdr_a_n7_3 rwl_3_a_n7 vdd dc 0
vdb_a_n7_0 bl_0_a_n7 0 dc 0
vdp_a_n7_0 rbl_0_a_n7 vrbl dc 0
vdb_a_n7_1 bl_1_a_n7 0 dc 0
vdp_a_n7_1 rbl_1_a_n7 vrbl dc 0
vdb_a_n7_2 bl_2_a_n7 0 dc 0
vdp_a_n7_2 rbl_2_a_n7 vrbl dc 0
vdb_a_n7_3 bl_3_a_n7 0 dc 0
vdp_a_n7_3 rbl_3_a_n7 vrbl dc 0
vdn_a_n7_n8 n8_a_n7 0 dc 1
vdn_a_n7_n9 n9_a_n7 0 dc 1
vdn_a_n7_n10 n10_a_n7 0 dc 1
vdn_a_n7_n17 n17_a_n7 0 dc 1
vdn_a_n7_n18 n18_a_n7 0 dc 1
vdn_a_n7_n19 n19_a_n7 0 dc 1
vdn_a_n7_n20 n20_a_n7 0 dc 1
vdn_a_n7_n22 n22_a_n7 0 dc 1
vdn_a_n7_n23 n23_a_n7 0 dc 1
vdn_a_n7_n24 n24_a_n7 0 dc 1
vdn_a_n7_n25 n25_a_n7 0 dc 1
vdn_a_n7_n29 n29_a_n7 0 dc 1
vdn_a_n7_n30 n30_a_n7 0 dc 1
vdn_a_n7_n31 n31_a_n7 0 dc 1
vdn_a_n7_n32 n32_a_n7 0 dc 1
bdr_a_n7 n7_a_n7 0 i=5e-08*min(1,max(0,(time-1e-09)/0.2n))*0.5*(1+tanh((v(n7_a_n7)-0.05)/0.01))

* ---- instance a_n8: variant a, probed storage node \$8 ----
xm1_a_n8 rwl_0__t2_a_n8 n7__t0_a_n8 rbl_0__t0_a_n8 gnd__t0_a_n8 sky130_fd_pr__nfet_01v8 L=0.15 W=0.42 nf=1 ad=0.1197 as=0.1197 pd=1.41 ps=1.41 mult=1 m=1
xm2_a_n8 rwl_0__t3_a_n8 n8__t1_a_n8 rbl_1__t1_a_n8 gnd__t1_a_n8 sky130_fd_pr__nfet_01v8 L=0.15 W=0.42 nf=1 ad=0.1197 as=0.1197 pd=1.41 ps=1.41 mult=1 m=1
xm3_a_n8 rwl_0__t1_a_n8 n9__t1_a_n8 rbl_2__t1_a_n8 gnd__t2_a_n8 sky130_fd_pr__nfet_01v8 L=0.15 W=0.42 nf=1 ad=0.1197 as=0.1197 pd=1.41 ps=1.41 mult=1 m=1
xm4_a_n8 rwl_0__t0_a_n8 n10__t1_a_n8 rbl_3__t1_a_n8 gnd__t3_a_n8 sky130_fd_pr__nfet_01v8 L=0.15 W=0.42 nf=1 ad=0.1197 as=0.1197 pd=1.41 ps=1.41 mult=1 m=1
xm5_a_n8 bl_0__t0_a_n8 wl_0__t0_a_n8 n7__t1_a_n8 gnd__t8_a_n8 sky130_fd_pr__nfet_01v8 L=0.15 W=0.42 nf=1 ad=0.0588 as=0.1197 pd=0.7 ps=1.41 mult=1 m=1
xm6_a_n8 n17__t0_a_n8 wl_1__t0_a_n8 bl_0__t1_a_n8 gnd__t20_a_n8 sky130_fd_pr__nfet_01v8 L=0.15 W=0.42 nf=1 ad=0.1197 as=0.0588 pd=1.41 ps=0.7 mult=1 m=1
xm7_a_n8 bl_1__t2_a_n8 wl_0__t3_a_n8 n8__t0_a_n8 gnd__t9_a_n8 sky130_fd_pr__nfet_01v8 L=0.15 W=0.42 nf=1 ad=0.0588 as=0.1197 pd=0.7 ps=1.41 mult=1 m=1
xm8_a_n8 n18__t0_a_n8 wl_1__t1_a_n8 bl_1__t0_a_n8 gnd__t21_a_n8 sky130_fd_pr__nfet_01v8 L=0.15 W=0.42 nf=1 ad=0.1197 as=0.0588 pd=1.41 ps=0.7 mult=1 m=1
xm9_a_n8 bl_2__t2_a_n8 wl_0__t2_a_n8 n9__t0_a_n8 gnd__t10_a_n8 sky130_fd_pr__nfet_01v8 L=0.15 W=0.42 nf=1 ad=0.0588 as=0.1197 pd=0.7 ps=1.41 mult=1 m=1
xm10_a_n8 n19__t0_a_n8 wl_1__t2_a_n8 bl_2__t0_a_n8 gnd__t22_a_n8 sky130_fd_pr__nfet_01v8 L=0.15 W=0.42 nf=1 ad=0.1197 as=0.0588 pd=1.41 ps=0.7 mult=1 m=1
xm11_a_n8 bl_3__t2_a_n8 wl_0__t1_a_n8 n10__t0_a_n8 gnd__t11_a_n8 sky130_fd_pr__nfet_01v8 L=0.15 W=0.42 nf=1 ad=0.0588 as=0.1197 pd=0.7 ps=1.41 mult=1 m=1
xm12_a_n8 n20__t0_a_n8 wl_1__t3_a_n8 bl_3__t1_a_n8 gnd__t23_a_n8 sky130_fd_pr__nfet_01v8 L=0.15 W=0.42 nf=1 ad=0.1197 as=0.0588 pd=1.41 ps=0.7 mult=1 m=1
xm13_a_n8 rbl_0__t3_a_n8 n17__t1_a_n8 rwl_1__t0_a_n8 gnd__t12_a_n8 sky130_fd_pr__nfet_01v8 L=0.15 W=0.42 nf=1 ad=0.0588 as=0.1197 pd=0.7 ps=1.41 mult=1 m=1
xm14_a_n8 rwl_2__t3_a_n8 n22__t0_a_n8 rbl_0__t2_a_n8 gnd__t24_a_n8 sky130_fd_pr__nfet_01v8 L=0.15 W=0.42 nf=1 ad=0.1197 as=0.0588 pd=1.41 ps=0.7 mult=1 m=1
xm15_a_n8 rbl_1__t3_a_n8 n18__t1_a_n8 rwl_1__t1_a_n8 gnd__t13_a_n8 sky130_fd_pr__nfet_01v8 L=0.15 W=0.42 nf=1 ad=0.0588 as=0.1197 pd=0.7 ps=1.41 mult=1 m=1
xm16_a_n8 rwl_2__t0_a_n8 n23__t0_a_n8 rbl_1__t2_a_n8 gnd__t25_a_n8 sky130_fd_pr__nfet_01v8 L=0.15 W=0.42 nf=1 ad=0.1197 as=0.0588 pd=1.41 ps=0.7 mult=1 m=1
xm17_a_n8 rbl_2__t3_a_n8 n19__t1_a_n8 rwl_1__t2_a_n8 gnd__t14_a_n8 sky130_fd_pr__nfet_01v8 L=0.15 W=0.42 nf=1 ad=0.0588 as=0.1197 pd=0.7 ps=1.41 mult=1 m=1
xm18_a_n8 rwl_2__t1_a_n8 n24__t0_a_n8 rbl_2__t2_a_n8 gnd__t26_a_n8 sky130_fd_pr__nfet_01v8 L=0.15 W=0.42 nf=1 ad=0.1197 as=0.0588 pd=1.41 ps=0.7 mult=1 m=1
xm19_a_n8 rbl_3__t3_a_n8 n20__t1_a_n8 rwl_1__t3_a_n8 gnd__t15_a_n8 sky130_fd_pr__nfet_01v8 L=0.15 W=0.42 nf=1 ad=0.0588 as=0.1197 pd=0.7 ps=1.41 mult=1 m=1
xm20_a_n8 rwl_2__t2_a_n8 n25__t0_a_n8 rbl_3__t2_a_n8 gnd__t27_a_n8 sky130_fd_pr__nfet_01v8 L=0.15 W=0.42 nf=1 ad=0.1197 as=0.0588 pd=1.41 ps=0.7 mult=1 m=1
xm21_a_n8 bl_0__t3_a_n8 wl_2__t0_a_n8 n22__t1_a_n8 gnd__t16_a_n8 sky130_fd_pr__nfet_01v8 L=0.15 W=0.42 nf=1 ad=0.0588 as=0.1197 pd=0.7 ps=1.41 mult=1 m=1
xm22_a_n8 n29__t0_a_n8 wl_3__t3_a_n8 bl_0__t2_a_n8 gnd__t28_a_n8 sky130_fd_pr__nfet_01v8 L=0.15 W=0.42 nf=1 ad=0.1197 as=0.0588 pd=1.41 ps=0.7 mult=1 m=1
xm23_a_n8 bl_1__t3_a_n8 wl_2__t1_a_n8 n23__t1_a_n8 gnd__t17_a_n8 sky130_fd_pr__nfet_01v8 L=0.15 W=0.42 nf=1 ad=0.0588 as=0.1197 pd=0.7 ps=1.41 mult=1 m=1
xm24_a_n8 n30__t0_a_n8 wl_3__t2_a_n8 bl_1__t1_a_n8 gnd__t29_a_n8 sky130_fd_pr__nfet_01v8 L=0.15 W=0.42 nf=1 ad=0.1197 as=0.0588 pd=1.41 ps=0.7 mult=1 m=1
xm25_a_n8 bl_2__t3_a_n8 wl_2__t2_a_n8 n24__t1_a_n8 gnd__t18_a_n8 sky130_fd_pr__nfet_01v8 L=0.15 W=0.42 nf=1 ad=0.0588 as=0.1197 pd=0.7 ps=1.41 mult=1 m=1
xm26_a_n8 n31__t0_a_n8 wl_3__t1_a_n8 bl_2__t1_a_n8 gnd__t30_a_n8 sky130_fd_pr__nfet_01v8 L=0.15 W=0.42 nf=1 ad=0.1197 as=0.0588 pd=1.41 ps=0.7 mult=1 m=1
xm27_a_n8 bl_3__t3_a_n8 wl_2__t3_a_n8 n25__t1_a_n8 gnd__t19_a_n8 sky130_fd_pr__nfet_01v8 L=0.15 W=0.42 nf=1 ad=0.0588 as=0.1197 pd=0.7 ps=1.41 mult=1 m=1
xm28_a_n8 n32__t0_a_n8 wl_3__t0_a_n8 bl_3__t0_a_n8 gnd__t31_a_n8 sky130_fd_pr__nfet_01v8 L=0.15 W=0.42 nf=1 ad=0.1197 as=0.0588 pd=1.41 ps=0.7 mult=1 m=1
xm29_a_n8 rbl_0__t1_a_n8 n29__t1_a_n8 rwl_3__t0_a_n8 gnd__t4_a_n8 sky130_fd_pr__nfet_01v8 L=0.15 W=0.42 nf=1 ad=0.1197 as=0.1197 pd=1.41 ps=1.41 mult=1 m=1
xm30_a_n8 rbl_1__t0_a_n8 n30__t1_a_n8 rwl_3__t1_a_n8 gnd__t5_a_n8 sky130_fd_pr__nfet_01v8 L=0.15 W=0.42 nf=1 ad=0.1197 as=0.1197 pd=1.41 ps=1.41 mult=1 m=1
xm31_a_n8 rbl_2__t0_a_n8 n31__t1_a_n8 rwl_3__t2_a_n8 gnd__t6_a_n8 sky130_fd_pr__nfet_01v8 L=0.15 W=0.42 nf=1 ad=0.1197 as=0.1197 pd=1.41 ps=1.41 mult=1 m=1
xm32_a_n8 rbl_3__t0_a_n8 n32__t1_a_n8 rwl_3__t3_a_n8 gnd__t7_a_n8 sky130_fd_pr__nfet_01v8 L=0.15 W=0.42 nf=1 ad=0.1197 as=0.1197 pd=1.41 ps=1.41 mult=1 m=1
r_10_t0_a_n8 n10__t0_a_n8 n10_a_n8 183.071
r_10_t1_a_n8 n10__t1_a_n8 n10_a_n8 183.071
r_17_t0_a_n8 n17__t0_a_n8 n17_a_n8 183.071
r_17_t1_a_n8 n17__t1_a_n8 n17_a_n8 183.071
r_18_t0_a_n8 n18__t0_a_n8 n18_a_n8 183.071
r_18_t1_a_n8 n18__t1_a_n8 n18_a_n8 183.071
r_19_t0_a_n8 n19__t0_a_n8 n19_a_n8 183.071
r_19_t1_a_n8 n19__t1_a_n8 n19_a_n8 183.071
r_20_t0_a_n8 n20__t0_a_n8 n20_a_n8 183.071
r_20_t1_a_n8 n20__t1_a_n8 n20_a_n8 183.071
r_22_t0_a_n8 n22__t0_a_n8 n22_a_n8 183.071
r_22_t1_a_n8 n22__t1_a_n8 n22_a_n8 183.071
r_23_t0_a_n8 n23__t0_a_n8 n23_a_n8 183.071
r_23_t1_a_n8 n23__t1_a_n8 n23_a_n8 183.071
r_24_t0_a_n8 n24__t0_a_n8 n24_a_n8 183.071
r_24_t1_a_n8 n24__t1_a_n8 n24_a_n8 183.071
r_25_t0_a_n8 n25__t0_a_n8 n25_a_n8 183.071
r_25_t1_a_n8 n25__t1_a_n8 n25_a_n8 183.071
r_29_t0_a_n8 n29__t0_a_n8 n29_a_n8 183.071
r_29_t1_a_n8 n29__t1_a_n8 n29_a_n8 183.071
r_30_t0_a_n8 n30__t0_a_n8 n30_a_n8 183.071
r_30_t1_a_n8 n30__t1_a_n8 n30_a_n8 183.071
r_31_t0_a_n8 n31__t0_a_n8 n31_a_n8 183.071
r_31_t1_a_n8 n31__t1_a_n8 n31_a_n8 183.071
r_32_t0_a_n8 n32__t0_a_n8 n32_a_n8 183.071
r_32_t1_a_n8 n32__t1_a_n8 n32_a_n8 183.071
r_7_t0_a_n8 n7__t0_a_n8 n7_a_n8 183.071
r_7_t1_a_n8 n7__t1_a_n8 n7_a_n8 183.071
r_8_t0_a_n8 n8__t0_a_n8 n8_a_n8 183.071
r_8_t1_a_n8 n8__t1_a_n8 n8_a_n8 183.071
r_9_t0_a_n8 n9__t0_a_n8 n9_a_n8 183.071
r_9_t1_a_n8 n9__t1_a_n8 n9_a_n8 183.071
rgnd_t0_a_n8 gnd__t0_a_n8 0 38.2988
rgnd_t1_a_n8 gnd__t1_a_n8 0 33.9576
rgnd_t2_a_n8 gnd__t2_a_n8 0 33.9576
rgnd_t3_a_n8 gnd__t3_a_n8 0 38.2988
rgnd_t4_a_n8 gnd__t4_a_n8 0 38.2988
rgnd_t5_a_n8 gnd__t5_a_n8 0 33.9576
rgnd_t6_a_n8 gnd__t6_a_n8 0 33.9576
rgnd_t7_a_n8 gnd__t7_a_n8 0 38.2988
rgnd_t8_a_n8 gnd__t8_a_n8 0 28.0185
rgnd_t9_a_n8 gnd__t9_a_n8 0 21.7106
rgnd_t10_a_n8 gnd__t10_a_n8 0 21.7106
rgnd_t11_a_n8 gnd__t11_a_n8 0 28.0185
rgnd_t12_a_n8 gnd__t12_a_n8 0 18.9833
rgnd_t13_a_n8 gnd__t13_a_n8 0 6.8325
rgnd_t14_a_n8 gnd__t14_a_n8 0 6.8325
rgnd_t15_a_n8 gnd__t15_a_n8 0 18.9833
rgnd_t16_a_n8 gnd__t16_a_n8 0 24.2409
rgnd_t17_a_n8 gnd__t17_a_n8 0 16.5511
rgnd_t18_a_n8 gnd__t18_a_n8 0 16.5511
rgnd_t19_a_n8 gnd__t19_a_n8 0 24.2409
rgnd_t20_a_n8 gnd__t20_a_n8 0 24.2409
rgnd_t21_a_n8 gnd__t21_a_n8 0 16.5511
rgnd_t22_a_n8 gnd__t22_a_n8 0 16.5511
rgnd_t23_a_n8 gnd__t23_a_n8 0 24.2409
rgnd_t24_a_n8 gnd__t24_a_n8 0 18.9833
rgnd_t25_a_n8 gnd__t25_a_n8 0 6.8325
rgnd_t26_a_n8 gnd__t26_a_n8 0 6.8325
rgnd_t27_a_n8 gnd__t27_a_n8 0 18.9833
rgnd_t28_a_n8 gnd__t28_a_n8 0 28.0185
rgnd_t29_a_n8 gnd__t29_a_n8 0 21.7106
rgnd_t30_a_n8 gnd__t30_a_n8 0 21.7106
rgnd_t31_a_n8 gnd__t31_a_n8 0 28.0185
rbl_0_t0_a_n8 bl_0__t0_a_n8 bl_0_a_n8 14.8304
rbl_0_t1_a_n8 bl_0__t1_a_n8 bl_0_a_n8 10.9301
rbl_0_t2_a_n8 bl_0__t2_a_n8 bl_0_a_n8 14.8304
rbl_0_t3_a_n8 bl_0__t3_a_n8 bl_0_a_n8 10.9301
rbl_1_t0_a_n8 bl_1__t0_a_n8 bl_1_a_n8 10.9301
rbl_1_t1_a_n8 bl_1__t1_a_n8 bl_1_a_n8 14.8304
rbl_1_t2_a_n8 bl_1__t2_a_n8 bl_1_a_n8 14.8304
rbl_1_t3_a_n8 bl_1__t3_a_n8 bl_1_a_n8 10.9301
rbl_2_t0_a_n8 bl_2__t0_a_n8 bl_2_a_n8 10.9301
rbl_2_t1_a_n8 bl_2__t1_a_n8 bl_2_a_n8 14.8304
rbl_2_t2_a_n8 bl_2__t2_a_n8 bl_2_a_n8 14.8304
rbl_2_t3_a_n8 bl_2__t3_a_n8 bl_2_a_n8 10.9301
rbl_3_t0_a_n8 bl_3__t0_a_n8 bl_3_a_n8 14.8304
rbl_3_t1_a_n8 bl_3__t1_a_n8 bl_3_a_n8 10.9301
rbl_3_t2_a_n8 bl_3__t2_a_n8 bl_3_a_n8 14.8304
rbl_3_t3_a_n8 bl_3__t3_a_n8 bl_3_a_n8 10.9301
rrbl_0_t0_a_n8 rbl_0__t0_a_n8 rbl_0_a_n8 36.5601
rrbl_0_t1_a_n8 rbl_0__t1_a_n8 rbl_0_a_n8 36.5601
rrbl_0_t2_a_n8 rbl_0__t2_a_n8 rbl_0_a_n8 2.99444
rrbl_0_t3_a_n8 rbl_0__t3_a_n8 rbl_0_a_n8 2.99444
rrbl_1_t0_a_n8 rbl_1__t0_a_n8 rbl_1_a_n8 36.5601
rrbl_1_t1_a_n8 rbl_1__t1_a_n8 rbl_1_a_n8 36.5601
rrbl_1_t2_a_n8 rbl_1__t2_a_n8 rbl_1_a_n8 2.99444
rrbl_1_t3_a_n8 rbl_1__t3_a_n8 rbl_1_a_n8 2.99444
rrbl_2_t0_a_n8 rbl_2__t0_a_n8 rbl_2_a_n8 36.5601
rrbl_2_t1_a_n8 rbl_2__t1_a_n8 rbl_2_a_n8 36.5601
rrbl_2_t2_a_n8 rbl_2__t2_a_n8 rbl_2_a_n8 2.99444
rrbl_2_t3_a_n8 rbl_2__t3_a_n8 rbl_2_a_n8 2.99444
rrbl_3_t0_a_n8 rbl_3__t0_a_n8 rbl_3_a_n8 36.5601
rrbl_3_t1_a_n8 rbl_3__t1_a_n8 rbl_3_a_n8 36.5601
rrbl_3_t2_a_n8 rbl_3__t2_a_n8 rbl_3_a_n8 2.99444
rrbl_3_t3_a_n8 rbl_3__t3_a_n8 rbl_3_a_n8 2.99444
rrwl_0_t0_a_n8 rwl_0__t0_a_n8 rwl_0_a_n8 38.2618
rrwl_0_t1_a_n8 rwl_0__t1_a_n8 rwl_0_a_n8 12.7539
rrwl_0_t2_a_n8 rwl_0__t2_a_n8 rwl_0_a_n8 38.2618
rrwl_0_t3_a_n8 rwl_0__t3_a_n8 rwl_0_a_n8 12.7539
rrwl_1_t0_a_n8 rwl_1__t0_a_n8 rwl_1_a_n8 38.2618
rrwl_1_t1_a_n8 rwl_1__t1_a_n8 rwl_1_a_n8 12.7539
rrwl_1_t2_a_n8 rwl_1__t2_a_n8 rwl_1_a_n8 12.7539
rrwl_1_t3_a_n8 rwl_1__t3_a_n8 rwl_1_a_n8 38.2618
rrwl_2_t0_a_n8 rwl_2__t0_a_n8 rwl_2_a_n8 12.7539
rrwl_2_t1_a_n8 rwl_2__t1_a_n8 rwl_2_a_n8 12.7539
rrwl_2_t2_a_n8 rwl_2__t2_a_n8 rwl_2_a_n8 38.2618
rrwl_2_t3_a_n8 rwl_2__t3_a_n8 rwl_2_a_n8 38.2618
rrwl_3_t0_a_n8 rwl_3__t0_a_n8 rwl_3_a_n8 38.2618
rrwl_3_t1_a_n8 rwl_3__t1_a_n8 rwl_3_a_n8 12.7539
rrwl_3_t2_a_n8 rwl_3__t2_a_n8 rwl_3_a_n8 12.7539
rrwl_3_t3_a_n8 rwl_3__t3_a_n8 rwl_3_a_n8 38.2618
rwl_0_t0_a_n8 wl_0__t0_a_n8 wl_0_a_n8 245.959
rwl_0_t1_a_n8 wl_0__t1_a_n8 wl_0_a_n8 245.959
rwl_0_t2_a_n8 wl_0__t2_a_n8 wl_0_a_n8 81.9864
rwl_0_t3_a_n8 wl_0__t3_a_n8 wl_0_a_n8 81.9864
rwl_1_t0_a_n8 wl_1__t0_a_n8 wl_1_a_n8 245.959
rwl_1_t1_a_n8 wl_1__t1_a_n8 wl_1_a_n8 81.9864
rwl_1_t2_a_n8 wl_1__t2_a_n8 wl_1_a_n8 81.9864
rwl_1_t3_a_n8 wl_1__t3_a_n8 wl_1_a_n8 245.959
rwl_2_t0_a_n8 wl_2__t0_a_n8 wl_2_a_n8 245.959
rwl_2_t1_a_n8 wl_2__t1_a_n8 wl_2_a_n8 81.9864
rwl_2_t2_a_n8 wl_2__t2_a_n8 wl_2_a_n8 81.9864
rwl_2_t3_a_n8 wl_2__t3_a_n8 wl_2_a_n8 245.959
rwl_3_t0_a_n8 wl_3__t0_a_n8 wl_3_a_n8 245.959
rwl_3_t1_a_n8 wl_3__t1_a_n8 wl_3_a_n8 81.9864
rwl_3_t2_a_n8 wl_3__t2_a_n8 wl_3_a_n8 81.9864
rwl_3_t3_a_n8 wl_3__t3_a_n8 wl_3_a_n8 245.959
c_10_a_n8 n10_a_n8 0 2.91622e-16
c_17_a_n8 n17_a_n8 0 2.91528e-16
c_18_a_n8 n18_a_n8 0 2.91528e-16
c_19_a_n8 n19_a_n8 0 2.91528e-16
c_20_a_n8 n20_a_n8 0 2.91622e-16
c_22_a_n8 n22_a_n8 0 2.91528e-16
c_23_a_n8 n23_a_n8 0 2.91528e-16
c_24_a_n8 n24_a_n8 0 2.91528e-16
c_25_a_n8 n25_a_n8 0 2.91622e-16
c_29_a_n8 n29_a_n8 0 2.91528e-16
c_30_a_n8 n30_a_n8 0 2.91528e-16
c_31_a_n8 n31_a_n8 0 2.91528e-16
c_32_a_n8 n32_a_n8 0 2.91622e-16
c_7_a_n8 n7_a_n8 0 2.91528e-16
c_8_a_n8 n8_a_n8 0 2.91528e-16
c_9_a_n8 n9_a_n8 0 2.91528e-16
cgnd_a_n8 0 0 2.48166e-15
cbl_0_a_n8 bl_0_a_n8 0 4.52661e-16
cbl_1_a_n8 bl_1_a_n8 0 4.52661e-16
cbl_2_a_n8 bl_2_a_n8 0 4.52661e-16
cbl_3_a_n8 bl_3_a_n8 0 4.52661e-16
crbl_0_a_n8 rbl_0_a_n8 0 9.14472e-16
crbl_1_a_n8 rbl_1_a_n8 0 9.14472e-16
crbl_2_a_n8 rbl_2_a_n8 0 9.14472e-16
crbl_3_a_n8 rbl_3_a_n8 0 9.17566e-16
crwl_0_a_n8 rwl_0_a_n8 0 5.19495e-16
crwl_1_a_n8 rwl_1_a_n8 0 5.11719e-16
crwl_2_a_n8 rwl_2_a_n8 0 5.11719e-16
crwl_3_a_n8 rwl_3_a_n8 0 5.19495e-16
cwl_0_a_n8 wl_0_a_n8 0 3.30388e-16
cwl_1_a_n8 wl_1_a_n8 0 3.30388e-16
cwl_2_a_n8 wl_2_a_n8 0 3.30388e-16
cwl_3_a_n8 wl_3_a_n8 0 3.30388e-16
ccc__10__9_a_n8 n10_a_n8 n9_a_n8 1.02e-17
ccc__10_bl_3_a_n8 n10_a_n8 bl_3_a_n8 1.3999e-17
ccc__10_rwl_0_a_n8 n10_a_n8 rwl_0_a_n8 4.335e-18
ccc__17__18_a_n8 n17_a_n8 n18_a_n8 1.02e-17
ccc__17_bl_0_a_n8 n17_a_n8 bl_0_a_n8 8.415e-18
ccc__17_rwl_1_a_n8 n17_a_n8 rwl_1_a_n8 1.3194e-17
ccc__18__19_a_n8 n18_a_n8 n19_a_n8 1.02e-17
ccc__18_bl_1_a_n8 n18_a_n8 bl_1_a_n8 8.415e-18
ccc__18_rwl_1_a_n8 n18_a_n8 rwl_1_a_n8 1.3194e-17
ccc__19__20_a_n8 n19_a_n8 n20_a_n8 1.02e-17
ccc__19_bl_2_a_n8 n19_a_n8 bl_2_a_n8 8.415e-18
ccc__19_rwl_1_a_n8 n19_a_n8 rwl_1_a_n8 1.3194e-17
ccc__20_bl_3_a_n8 n20_a_n8 bl_3_a_n8 8.415e-18
ccc__20_rwl_1_a_n8 n20_a_n8 rwl_1_a_n8 6.655e-18
ccc__22__23_a_n8 n22_a_n8 n23_a_n8 1.02e-17
ccc__22_bl_0_a_n8 n22_a_n8 bl_0_a_n8 8.415e-18
ccc__22_rwl_2_a_n8 n22_a_n8 rwl_2_a_n8 1.3194e-17
ccc__23__24_a_n8 n23_a_n8 n24_a_n8 1.02e-17
ccc__23_bl_1_a_n8 n23_a_n8 bl_1_a_n8 8.415e-18
ccc__23_rwl_2_a_n8 n23_a_n8 rwl_2_a_n8 1.3194e-17
ccc__24__25_a_n8 n24_a_n8 n25_a_n8 1.02e-17
ccc__24_bl_2_a_n8 n24_a_n8 bl_2_a_n8 8.415e-18
ccc__24_rwl_2_a_n8 n24_a_n8 rwl_2_a_n8 1.3194e-17
ccc__25_bl_3_a_n8 n25_a_n8 bl_3_a_n8 8.415e-18
ccc__25_rwl_2_a_n8 n25_a_n8 rwl_2_a_n8 6.655e-18
ccc__29__30_a_n8 n29_a_n8 n30_a_n8 1.02e-17
ccc__29_bl_0_a_n8 n29_a_n8 bl_0_a_n8 8.415e-18
ccc__29_rwl_3_a_n8 n29_a_n8 rwl_3_a_n8 1.3194e-17
ccc__30__31_a_n8 n30_a_n8 n31_a_n8 1.02e-17
ccc__30_bl_1_a_n8 n30_a_n8 bl_1_a_n8 8.415e-18
ccc__30_rwl_3_a_n8 n30_a_n8 rwl_3_a_n8 1.3194e-17
ccc__31__32_a_n8 n31_a_n8 n32_a_n8 1.02e-17
ccc__31_bl_2_a_n8 n31_a_n8 bl_2_a_n8 8.415e-18
ccc__31_rwl_3_a_n8 n31_a_n8 rwl_3_a_n8 1.3194e-17
ccc__32_bl_3_a_n8 n32_a_n8 bl_3_a_n8 8.415e-18
ccc__32_rwl_3_a_n8 n32_a_n8 rwl_3_a_n8 6.655e-18
ccc__7__8_a_n8 n7_a_n8 n8_a_n8 1.02e-17
ccc__7_bl_0_a_n8 n7_a_n8 bl_0_a_n8 1.3999e-17
ccc__7_rwl_0_a_n8 n7_a_n8 rwl_0_a_n8 8.961e-18
ccc__8__9_a_n8 n8_a_n8 n9_a_n8 1.02e-17
ccc__8_bl_1_a_n8 n8_a_n8 bl_1_a_n8 1.3999e-17
ccc__8_rwl_0_a_n8 n8_a_n8 rwl_0_a_n8 8.961e-18
ccc__9_bl_2_a_n8 n9_a_n8 bl_2_a_n8 1.3999e-17
ccc__9_rwl_0_a_n8 n9_a_n8 rwl_0_a_n8 8.961e-18
ccc_bl_0_rbl_0_a_n8 bl_0_a_n8 rbl_0_a_n8 1.88693e-16
ccc_bl_0_rwl_1_a_n8 bl_0_a_n8 rwl_1_a_n8 1.0093e-17
ccc_bl_0_rwl_2_a_n8 bl_0_a_n8 rwl_2_a_n8 1.0093e-17
ccc_bl_1_rbl_0_a_n8 bl_1_a_n8 rbl_0_a_n8 1.633e-16
ccc_bl_1_rbl_1_a_n8 bl_1_a_n8 rbl_1_a_n8 1.88693e-16
ccc_bl_1_rwl_1_a_n8 bl_1_a_n8 rwl_1_a_n8 1.0093e-17
ccc_bl_1_rwl_2_a_n8 bl_1_a_n8 rwl_2_a_n8 1.0093e-17
ccc_bl_2_rbl_1_a_n8 bl_2_a_n8 rbl_1_a_n8 1.633e-16
ccc_bl_2_rbl_2_a_n8 bl_2_a_n8 rbl_2_a_n8 1.88693e-16
ccc_bl_2_rwl_1_a_n8 bl_2_a_n8 rwl_1_a_n8 1.0093e-17
ccc_bl_2_rwl_2_a_n8 bl_2_a_n8 rwl_2_a_n8 1.0093e-17
ccc_bl_3_rbl_2_a_n8 bl_3_a_n8 rbl_2_a_n8 1.633e-16
ccc_bl_3_rbl_3_a_n8 bl_3_a_n8 rbl_3_a_n8 1.88693e-16
ccc_bl_3_rwl_1_a_n8 bl_3_a_n8 rwl_1_a_n8 1.0093e-17
ccc_bl_3_rwl_2_a_n8 bl_3_a_n8 rwl_2_a_n8 1.0093e-17
ccc_rbl_0_rbl_1_a_n8 rbl_0_a_n8 rbl_1_a_n8 3.432e-17
ccc_rbl_0_rwl_0_a_n8 rbl_0_a_n8 rwl_0_a_n8 4.9752e-17
ccc_rbl_0_rwl_1_a_n8 rbl_0_a_n8 rwl_1_a_n8 4.9752e-17
ccc_rbl_0_rwl_2_a_n8 rbl_0_a_n8 rwl_2_a_n8 4.9752e-17
ccc_rbl_0_rwl_3_a_n8 rbl_0_a_n8 rwl_3_a_n8 4.9752e-17
ccc_rbl_1_rbl_2_a_n8 rbl_1_a_n8 rbl_2_a_n8 3.432e-17
ccc_rbl_1_rwl_0_a_n8 rbl_1_a_n8 rwl_0_a_n8 4.9752e-17
ccc_rbl_1_rwl_1_a_n8 rbl_1_a_n8 rwl_1_a_n8 4.9752e-17
ccc_rbl_1_rwl_2_a_n8 rbl_1_a_n8 rwl_2_a_n8 4.9752e-17
ccc_rbl_1_rwl_3_a_n8 rbl_1_a_n8 rwl_3_a_n8 4.9752e-17
ccc_rbl_2_rbl_3_a_n8 rbl_2_a_n8 rbl_3_a_n8 3.432e-17
ccc_rbl_2_rwl_0_a_n8 rbl_2_a_n8 rwl_0_a_n8 4.9752e-17
ccc_rbl_2_rwl_1_a_n8 rbl_2_a_n8 rwl_1_a_n8 4.9752e-17
ccc_rbl_2_rwl_2_a_n8 rbl_2_a_n8 rwl_2_a_n8 4.9752e-17
ccc_rbl_2_rwl_3_a_n8 rbl_2_a_n8 rwl_3_a_n8 4.9752e-17
ccc_rbl_3_rwl_0_a_n8 rbl_3_a_n8 rwl_0_a_n8 3.3407e-17
ccc_rbl_3_rwl_1_a_n8 rbl_3_a_n8 rwl_1_a_n8 3.3407e-17
ccc_rbl_3_rwl_2_a_n8 rbl_3_a_n8 rwl_2_a_n8 3.3407e-17
ccc_rbl_3_rwl_3_a_n8 rbl_3_a_n8 rwl_3_a_n8 3.3407e-17
vdw_a_n8_0 wl_0_a_n8 0 dc 0
vdr_a_n8_0 rwl_0_a_n8 vdd dc 0
vdw_a_n8_1 wl_1_a_n8 0 dc 0
vdr_a_n8_1 rwl_1_a_n8 vdd dc 0
vdw_a_n8_2 wl_2_a_n8 0 dc 0
vdr_a_n8_2 rwl_2_a_n8 vdd dc 0
vdw_a_n8_3 wl_3_a_n8 0 dc 0
vdr_a_n8_3 rwl_3_a_n8 vdd dc 0
vdb_a_n8_0 bl_0_a_n8 0 dc 0
vdp_a_n8_0 rbl_0_a_n8 vrbl dc 0
vdb_a_n8_1 bl_1_a_n8 0 dc 0
vdp_a_n8_1 rbl_1_a_n8 vrbl dc 0
vdb_a_n8_2 bl_2_a_n8 0 dc 0
vdp_a_n8_2 rbl_2_a_n8 vrbl dc 0
vdb_a_n8_3 bl_3_a_n8 0 dc 0
vdp_a_n8_3 rbl_3_a_n8 vrbl dc 0
vdn_a_n8_n7 n7_a_n8 0 dc 1
vdn_a_n8_n9 n9_a_n8 0 dc 1
vdn_a_n8_n10 n10_a_n8 0 dc 1
vdn_a_n8_n17 n17_a_n8 0 dc 1
vdn_a_n8_n18 n18_a_n8 0 dc 1
vdn_a_n8_n19 n19_a_n8 0 dc 1
vdn_a_n8_n20 n20_a_n8 0 dc 1
vdn_a_n8_n22 n22_a_n8 0 dc 1
vdn_a_n8_n23 n23_a_n8 0 dc 1
vdn_a_n8_n24 n24_a_n8 0 dc 1
vdn_a_n8_n25 n25_a_n8 0 dc 1
vdn_a_n8_n29 n29_a_n8 0 dc 1
vdn_a_n8_n30 n30_a_n8 0 dc 1
vdn_a_n8_n31 n31_a_n8 0 dc 1
vdn_a_n8_n32 n32_a_n8 0 dc 1
bdr_a_n8 n8_a_n8 0 i=5e-08*min(1,max(0,(time-1e-09)/0.2n))*0.5*(1+tanh((v(n8_a_n8)-0.05)/0.01))

* ---- instance a_n9: variant a, probed storage node \$9 ----
xm1_a_n9 rwl_0__t2_a_n9 n7__t0_a_n9 rbl_0__t0_a_n9 gnd__t0_a_n9 sky130_fd_pr__nfet_01v8 L=0.15 W=0.42 nf=1 ad=0.1197 as=0.1197 pd=1.41 ps=1.41 mult=1 m=1
xm2_a_n9 rwl_0__t3_a_n9 n8__t1_a_n9 rbl_1__t1_a_n9 gnd__t1_a_n9 sky130_fd_pr__nfet_01v8 L=0.15 W=0.42 nf=1 ad=0.1197 as=0.1197 pd=1.41 ps=1.41 mult=1 m=1
xm3_a_n9 rwl_0__t1_a_n9 n9__t1_a_n9 rbl_2__t1_a_n9 gnd__t2_a_n9 sky130_fd_pr__nfet_01v8 L=0.15 W=0.42 nf=1 ad=0.1197 as=0.1197 pd=1.41 ps=1.41 mult=1 m=1
xm4_a_n9 rwl_0__t0_a_n9 n10__t1_a_n9 rbl_3__t1_a_n9 gnd__t3_a_n9 sky130_fd_pr__nfet_01v8 L=0.15 W=0.42 nf=1 ad=0.1197 as=0.1197 pd=1.41 ps=1.41 mult=1 m=1
xm5_a_n9 bl_0__t0_a_n9 wl_0__t0_a_n9 n7__t1_a_n9 gnd__t8_a_n9 sky130_fd_pr__nfet_01v8 L=0.15 W=0.42 nf=1 ad=0.0588 as=0.1197 pd=0.7 ps=1.41 mult=1 m=1
xm6_a_n9 n17__t0_a_n9 wl_1__t0_a_n9 bl_0__t1_a_n9 gnd__t20_a_n9 sky130_fd_pr__nfet_01v8 L=0.15 W=0.42 nf=1 ad=0.1197 as=0.0588 pd=1.41 ps=0.7 mult=1 m=1
xm7_a_n9 bl_1__t2_a_n9 wl_0__t3_a_n9 n8__t0_a_n9 gnd__t9_a_n9 sky130_fd_pr__nfet_01v8 L=0.15 W=0.42 nf=1 ad=0.0588 as=0.1197 pd=0.7 ps=1.41 mult=1 m=1
xm8_a_n9 n18__t0_a_n9 wl_1__t1_a_n9 bl_1__t0_a_n9 gnd__t21_a_n9 sky130_fd_pr__nfet_01v8 L=0.15 W=0.42 nf=1 ad=0.1197 as=0.0588 pd=1.41 ps=0.7 mult=1 m=1
xm9_a_n9 bl_2__t2_a_n9 wl_0__t2_a_n9 n9__t0_a_n9 gnd__t10_a_n9 sky130_fd_pr__nfet_01v8 L=0.15 W=0.42 nf=1 ad=0.0588 as=0.1197 pd=0.7 ps=1.41 mult=1 m=1
xm10_a_n9 n19__t0_a_n9 wl_1__t2_a_n9 bl_2__t0_a_n9 gnd__t22_a_n9 sky130_fd_pr__nfet_01v8 L=0.15 W=0.42 nf=1 ad=0.1197 as=0.0588 pd=1.41 ps=0.7 mult=1 m=1
xm11_a_n9 bl_3__t2_a_n9 wl_0__t1_a_n9 n10__t0_a_n9 gnd__t11_a_n9 sky130_fd_pr__nfet_01v8 L=0.15 W=0.42 nf=1 ad=0.0588 as=0.1197 pd=0.7 ps=1.41 mult=1 m=1
xm12_a_n9 n20__t0_a_n9 wl_1__t3_a_n9 bl_3__t1_a_n9 gnd__t23_a_n9 sky130_fd_pr__nfet_01v8 L=0.15 W=0.42 nf=1 ad=0.1197 as=0.0588 pd=1.41 ps=0.7 mult=1 m=1
xm13_a_n9 rbl_0__t3_a_n9 n17__t1_a_n9 rwl_1__t0_a_n9 gnd__t12_a_n9 sky130_fd_pr__nfet_01v8 L=0.15 W=0.42 nf=1 ad=0.0588 as=0.1197 pd=0.7 ps=1.41 mult=1 m=1
xm14_a_n9 rwl_2__t3_a_n9 n22__t0_a_n9 rbl_0__t2_a_n9 gnd__t24_a_n9 sky130_fd_pr__nfet_01v8 L=0.15 W=0.42 nf=1 ad=0.1197 as=0.0588 pd=1.41 ps=0.7 mult=1 m=1
xm15_a_n9 rbl_1__t3_a_n9 n18__t1_a_n9 rwl_1__t1_a_n9 gnd__t13_a_n9 sky130_fd_pr__nfet_01v8 L=0.15 W=0.42 nf=1 ad=0.0588 as=0.1197 pd=0.7 ps=1.41 mult=1 m=1
xm16_a_n9 rwl_2__t0_a_n9 n23__t0_a_n9 rbl_1__t2_a_n9 gnd__t25_a_n9 sky130_fd_pr__nfet_01v8 L=0.15 W=0.42 nf=1 ad=0.1197 as=0.0588 pd=1.41 ps=0.7 mult=1 m=1
xm17_a_n9 rbl_2__t3_a_n9 n19__t1_a_n9 rwl_1__t2_a_n9 gnd__t14_a_n9 sky130_fd_pr__nfet_01v8 L=0.15 W=0.42 nf=1 ad=0.0588 as=0.1197 pd=0.7 ps=1.41 mult=1 m=1
xm18_a_n9 rwl_2__t1_a_n9 n24__t0_a_n9 rbl_2__t2_a_n9 gnd__t26_a_n9 sky130_fd_pr__nfet_01v8 L=0.15 W=0.42 nf=1 ad=0.1197 as=0.0588 pd=1.41 ps=0.7 mult=1 m=1
xm19_a_n9 rbl_3__t3_a_n9 n20__t1_a_n9 rwl_1__t3_a_n9 gnd__t15_a_n9 sky130_fd_pr__nfet_01v8 L=0.15 W=0.42 nf=1 ad=0.0588 as=0.1197 pd=0.7 ps=1.41 mult=1 m=1
xm20_a_n9 rwl_2__t2_a_n9 n25__t0_a_n9 rbl_3__t2_a_n9 gnd__t27_a_n9 sky130_fd_pr__nfet_01v8 L=0.15 W=0.42 nf=1 ad=0.1197 as=0.0588 pd=1.41 ps=0.7 mult=1 m=1
xm21_a_n9 bl_0__t3_a_n9 wl_2__t0_a_n9 n22__t1_a_n9 gnd__t16_a_n9 sky130_fd_pr__nfet_01v8 L=0.15 W=0.42 nf=1 ad=0.0588 as=0.1197 pd=0.7 ps=1.41 mult=1 m=1
xm22_a_n9 n29__t0_a_n9 wl_3__t3_a_n9 bl_0__t2_a_n9 gnd__t28_a_n9 sky130_fd_pr__nfet_01v8 L=0.15 W=0.42 nf=1 ad=0.1197 as=0.0588 pd=1.41 ps=0.7 mult=1 m=1
xm23_a_n9 bl_1__t3_a_n9 wl_2__t1_a_n9 n23__t1_a_n9 gnd__t17_a_n9 sky130_fd_pr__nfet_01v8 L=0.15 W=0.42 nf=1 ad=0.0588 as=0.1197 pd=0.7 ps=1.41 mult=1 m=1
xm24_a_n9 n30__t0_a_n9 wl_3__t2_a_n9 bl_1__t1_a_n9 gnd__t29_a_n9 sky130_fd_pr__nfet_01v8 L=0.15 W=0.42 nf=1 ad=0.1197 as=0.0588 pd=1.41 ps=0.7 mult=1 m=1
xm25_a_n9 bl_2__t3_a_n9 wl_2__t2_a_n9 n24__t1_a_n9 gnd__t18_a_n9 sky130_fd_pr__nfet_01v8 L=0.15 W=0.42 nf=1 ad=0.0588 as=0.1197 pd=0.7 ps=1.41 mult=1 m=1
xm26_a_n9 n31__t0_a_n9 wl_3__t1_a_n9 bl_2__t1_a_n9 gnd__t30_a_n9 sky130_fd_pr__nfet_01v8 L=0.15 W=0.42 nf=1 ad=0.1197 as=0.0588 pd=1.41 ps=0.7 mult=1 m=1
xm27_a_n9 bl_3__t3_a_n9 wl_2__t3_a_n9 n25__t1_a_n9 gnd__t19_a_n9 sky130_fd_pr__nfet_01v8 L=0.15 W=0.42 nf=1 ad=0.0588 as=0.1197 pd=0.7 ps=1.41 mult=1 m=1
xm28_a_n9 n32__t0_a_n9 wl_3__t0_a_n9 bl_3__t0_a_n9 gnd__t31_a_n9 sky130_fd_pr__nfet_01v8 L=0.15 W=0.42 nf=1 ad=0.1197 as=0.0588 pd=1.41 ps=0.7 mult=1 m=1
xm29_a_n9 rbl_0__t1_a_n9 n29__t1_a_n9 rwl_3__t0_a_n9 gnd__t4_a_n9 sky130_fd_pr__nfet_01v8 L=0.15 W=0.42 nf=1 ad=0.1197 as=0.1197 pd=1.41 ps=1.41 mult=1 m=1
xm30_a_n9 rbl_1__t0_a_n9 n30__t1_a_n9 rwl_3__t1_a_n9 gnd__t5_a_n9 sky130_fd_pr__nfet_01v8 L=0.15 W=0.42 nf=1 ad=0.1197 as=0.1197 pd=1.41 ps=1.41 mult=1 m=1
xm31_a_n9 rbl_2__t0_a_n9 n31__t1_a_n9 rwl_3__t2_a_n9 gnd__t6_a_n9 sky130_fd_pr__nfet_01v8 L=0.15 W=0.42 nf=1 ad=0.1197 as=0.1197 pd=1.41 ps=1.41 mult=1 m=1
xm32_a_n9 rbl_3__t0_a_n9 n32__t1_a_n9 rwl_3__t3_a_n9 gnd__t7_a_n9 sky130_fd_pr__nfet_01v8 L=0.15 W=0.42 nf=1 ad=0.1197 as=0.1197 pd=1.41 ps=1.41 mult=1 m=1
r_10_t0_a_n9 n10__t0_a_n9 n10_a_n9 183.071
r_10_t1_a_n9 n10__t1_a_n9 n10_a_n9 183.071
r_17_t0_a_n9 n17__t0_a_n9 n17_a_n9 183.071
r_17_t1_a_n9 n17__t1_a_n9 n17_a_n9 183.071
r_18_t0_a_n9 n18__t0_a_n9 n18_a_n9 183.071
r_18_t1_a_n9 n18__t1_a_n9 n18_a_n9 183.071
r_19_t0_a_n9 n19__t0_a_n9 n19_a_n9 183.071
r_19_t1_a_n9 n19__t1_a_n9 n19_a_n9 183.071
r_20_t0_a_n9 n20__t0_a_n9 n20_a_n9 183.071
r_20_t1_a_n9 n20__t1_a_n9 n20_a_n9 183.071
r_22_t0_a_n9 n22__t0_a_n9 n22_a_n9 183.071
r_22_t1_a_n9 n22__t1_a_n9 n22_a_n9 183.071
r_23_t0_a_n9 n23__t0_a_n9 n23_a_n9 183.071
r_23_t1_a_n9 n23__t1_a_n9 n23_a_n9 183.071
r_24_t0_a_n9 n24__t0_a_n9 n24_a_n9 183.071
r_24_t1_a_n9 n24__t1_a_n9 n24_a_n9 183.071
r_25_t0_a_n9 n25__t0_a_n9 n25_a_n9 183.071
r_25_t1_a_n9 n25__t1_a_n9 n25_a_n9 183.071
r_29_t0_a_n9 n29__t0_a_n9 n29_a_n9 183.071
r_29_t1_a_n9 n29__t1_a_n9 n29_a_n9 183.071
r_30_t0_a_n9 n30__t0_a_n9 n30_a_n9 183.071
r_30_t1_a_n9 n30__t1_a_n9 n30_a_n9 183.071
r_31_t0_a_n9 n31__t0_a_n9 n31_a_n9 183.071
r_31_t1_a_n9 n31__t1_a_n9 n31_a_n9 183.071
r_32_t0_a_n9 n32__t0_a_n9 n32_a_n9 183.071
r_32_t1_a_n9 n32__t1_a_n9 n32_a_n9 183.071
r_7_t0_a_n9 n7__t0_a_n9 n7_a_n9 183.071
r_7_t1_a_n9 n7__t1_a_n9 n7_a_n9 183.071
r_8_t0_a_n9 n8__t0_a_n9 n8_a_n9 183.071
r_8_t1_a_n9 n8__t1_a_n9 n8_a_n9 183.071
r_9_t0_a_n9 n9__t0_a_n9 n9_a_n9 183.071
r_9_t1_a_n9 n9__t1_a_n9 n9_a_n9 183.071
rgnd_t0_a_n9 gnd__t0_a_n9 0 38.2988
rgnd_t1_a_n9 gnd__t1_a_n9 0 33.9576
rgnd_t2_a_n9 gnd__t2_a_n9 0 33.9576
rgnd_t3_a_n9 gnd__t3_a_n9 0 38.2988
rgnd_t4_a_n9 gnd__t4_a_n9 0 38.2988
rgnd_t5_a_n9 gnd__t5_a_n9 0 33.9576
rgnd_t6_a_n9 gnd__t6_a_n9 0 33.9576
rgnd_t7_a_n9 gnd__t7_a_n9 0 38.2988
rgnd_t8_a_n9 gnd__t8_a_n9 0 28.0185
rgnd_t9_a_n9 gnd__t9_a_n9 0 21.7106
rgnd_t10_a_n9 gnd__t10_a_n9 0 21.7106
rgnd_t11_a_n9 gnd__t11_a_n9 0 28.0185
rgnd_t12_a_n9 gnd__t12_a_n9 0 18.9833
rgnd_t13_a_n9 gnd__t13_a_n9 0 6.8325
rgnd_t14_a_n9 gnd__t14_a_n9 0 6.8325
rgnd_t15_a_n9 gnd__t15_a_n9 0 18.9833
rgnd_t16_a_n9 gnd__t16_a_n9 0 24.2409
rgnd_t17_a_n9 gnd__t17_a_n9 0 16.5511
rgnd_t18_a_n9 gnd__t18_a_n9 0 16.5511
rgnd_t19_a_n9 gnd__t19_a_n9 0 24.2409
rgnd_t20_a_n9 gnd__t20_a_n9 0 24.2409
rgnd_t21_a_n9 gnd__t21_a_n9 0 16.5511
rgnd_t22_a_n9 gnd__t22_a_n9 0 16.5511
rgnd_t23_a_n9 gnd__t23_a_n9 0 24.2409
rgnd_t24_a_n9 gnd__t24_a_n9 0 18.9833
rgnd_t25_a_n9 gnd__t25_a_n9 0 6.8325
rgnd_t26_a_n9 gnd__t26_a_n9 0 6.8325
rgnd_t27_a_n9 gnd__t27_a_n9 0 18.9833
rgnd_t28_a_n9 gnd__t28_a_n9 0 28.0185
rgnd_t29_a_n9 gnd__t29_a_n9 0 21.7106
rgnd_t30_a_n9 gnd__t30_a_n9 0 21.7106
rgnd_t31_a_n9 gnd__t31_a_n9 0 28.0185
rbl_0_t0_a_n9 bl_0__t0_a_n9 bl_0_a_n9 14.8304
rbl_0_t1_a_n9 bl_0__t1_a_n9 bl_0_a_n9 10.9301
rbl_0_t2_a_n9 bl_0__t2_a_n9 bl_0_a_n9 14.8304
rbl_0_t3_a_n9 bl_0__t3_a_n9 bl_0_a_n9 10.9301
rbl_1_t0_a_n9 bl_1__t0_a_n9 bl_1_a_n9 10.9301
rbl_1_t1_a_n9 bl_1__t1_a_n9 bl_1_a_n9 14.8304
rbl_1_t2_a_n9 bl_1__t2_a_n9 bl_1_a_n9 14.8304
rbl_1_t3_a_n9 bl_1__t3_a_n9 bl_1_a_n9 10.9301
rbl_2_t0_a_n9 bl_2__t0_a_n9 bl_2_a_n9 10.9301
rbl_2_t1_a_n9 bl_2__t1_a_n9 bl_2_a_n9 14.8304
rbl_2_t2_a_n9 bl_2__t2_a_n9 bl_2_a_n9 14.8304
rbl_2_t3_a_n9 bl_2__t3_a_n9 bl_2_a_n9 10.9301
rbl_3_t0_a_n9 bl_3__t0_a_n9 bl_3_a_n9 14.8304
rbl_3_t1_a_n9 bl_3__t1_a_n9 bl_3_a_n9 10.9301
rbl_3_t2_a_n9 bl_3__t2_a_n9 bl_3_a_n9 14.8304
rbl_3_t3_a_n9 bl_3__t3_a_n9 bl_3_a_n9 10.9301
rrbl_0_t0_a_n9 rbl_0__t0_a_n9 rbl_0_a_n9 36.5601
rrbl_0_t1_a_n9 rbl_0__t1_a_n9 rbl_0_a_n9 36.5601
rrbl_0_t2_a_n9 rbl_0__t2_a_n9 rbl_0_a_n9 2.99444
rrbl_0_t3_a_n9 rbl_0__t3_a_n9 rbl_0_a_n9 2.99444
rrbl_1_t0_a_n9 rbl_1__t0_a_n9 rbl_1_a_n9 36.5601
rrbl_1_t1_a_n9 rbl_1__t1_a_n9 rbl_1_a_n9 36.5601
rrbl_1_t2_a_n9 rbl_1__t2_a_n9 rbl_1_a_n9 2.99444
rrbl_1_t3_a_n9 rbl_1__t3_a_n9 rbl_1_a_n9 2.99444
rrbl_2_t0_a_n9 rbl_2__t0_a_n9 rbl_2_a_n9 36.5601
rrbl_2_t1_a_n9 rbl_2__t1_a_n9 rbl_2_a_n9 36.5601
rrbl_2_t2_a_n9 rbl_2__t2_a_n9 rbl_2_a_n9 2.99444
rrbl_2_t3_a_n9 rbl_2__t3_a_n9 rbl_2_a_n9 2.99444
rrbl_3_t0_a_n9 rbl_3__t0_a_n9 rbl_3_a_n9 36.5601
rrbl_3_t1_a_n9 rbl_3__t1_a_n9 rbl_3_a_n9 36.5601
rrbl_3_t2_a_n9 rbl_3__t2_a_n9 rbl_3_a_n9 2.99444
rrbl_3_t3_a_n9 rbl_3__t3_a_n9 rbl_3_a_n9 2.99444
rrwl_0_t0_a_n9 rwl_0__t0_a_n9 rwl_0_a_n9 38.2618
rrwl_0_t1_a_n9 rwl_0__t1_a_n9 rwl_0_a_n9 12.7539
rrwl_0_t2_a_n9 rwl_0__t2_a_n9 rwl_0_a_n9 38.2618
rrwl_0_t3_a_n9 rwl_0__t3_a_n9 rwl_0_a_n9 12.7539
rrwl_1_t0_a_n9 rwl_1__t0_a_n9 rwl_1_a_n9 38.2618
rrwl_1_t1_a_n9 rwl_1__t1_a_n9 rwl_1_a_n9 12.7539
rrwl_1_t2_a_n9 rwl_1__t2_a_n9 rwl_1_a_n9 12.7539
rrwl_1_t3_a_n9 rwl_1__t3_a_n9 rwl_1_a_n9 38.2618
rrwl_2_t0_a_n9 rwl_2__t0_a_n9 rwl_2_a_n9 12.7539
rrwl_2_t1_a_n9 rwl_2__t1_a_n9 rwl_2_a_n9 12.7539
rrwl_2_t2_a_n9 rwl_2__t2_a_n9 rwl_2_a_n9 38.2618
rrwl_2_t3_a_n9 rwl_2__t3_a_n9 rwl_2_a_n9 38.2618
rrwl_3_t0_a_n9 rwl_3__t0_a_n9 rwl_3_a_n9 38.2618
rrwl_3_t1_a_n9 rwl_3__t1_a_n9 rwl_3_a_n9 12.7539
rrwl_3_t2_a_n9 rwl_3__t2_a_n9 rwl_3_a_n9 12.7539
rrwl_3_t3_a_n9 rwl_3__t3_a_n9 rwl_3_a_n9 38.2618
rwl_0_t0_a_n9 wl_0__t0_a_n9 wl_0_a_n9 245.959
rwl_0_t1_a_n9 wl_0__t1_a_n9 wl_0_a_n9 245.959
rwl_0_t2_a_n9 wl_0__t2_a_n9 wl_0_a_n9 81.9864
rwl_0_t3_a_n9 wl_0__t3_a_n9 wl_0_a_n9 81.9864
rwl_1_t0_a_n9 wl_1__t0_a_n9 wl_1_a_n9 245.959
rwl_1_t1_a_n9 wl_1__t1_a_n9 wl_1_a_n9 81.9864
rwl_1_t2_a_n9 wl_1__t2_a_n9 wl_1_a_n9 81.9864
rwl_1_t3_a_n9 wl_1__t3_a_n9 wl_1_a_n9 245.959
rwl_2_t0_a_n9 wl_2__t0_a_n9 wl_2_a_n9 245.959
rwl_2_t1_a_n9 wl_2__t1_a_n9 wl_2_a_n9 81.9864
rwl_2_t2_a_n9 wl_2__t2_a_n9 wl_2_a_n9 81.9864
rwl_2_t3_a_n9 wl_2__t3_a_n9 wl_2_a_n9 245.959
rwl_3_t0_a_n9 wl_3__t0_a_n9 wl_3_a_n9 245.959
rwl_3_t1_a_n9 wl_3__t1_a_n9 wl_3_a_n9 81.9864
rwl_3_t2_a_n9 wl_3__t2_a_n9 wl_3_a_n9 81.9864
rwl_3_t3_a_n9 wl_3__t3_a_n9 wl_3_a_n9 245.959
c_10_a_n9 n10_a_n9 0 2.91622e-16
c_17_a_n9 n17_a_n9 0 2.91528e-16
c_18_a_n9 n18_a_n9 0 2.91528e-16
c_19_a_n9 n19_a_n9 0 2.91528e-16
c_20_a_n9 n20_a_n9 0 2.91622e-16
c_22_a_n9 n22_a_n9 0 2.91528e-16
c_23_a_n9 n23_a_n9 0 2.91528e-16
c_24_a_n9 n24_a_n9 0 2.91528e-16
c_25_a_n9 n25_a_n9 0 2.91622e-16
c_29_a_n9 n29_a_n9 0 2.91528e-16
c_30_a_n9 n30_a_n9 0 2.91528e-16
c_31_a_n9 n31_a_n9 0 2.91528e-16
c_32_a_n9 n32_a_n9 0 2.91622e-16
c_7_a_n9 n7_a_n9 0 2.91528e-16
c_8_a_n9 n8_a_n9 0 2.91528e-16
c_9_a_n9 n9_a_n9 0 2.91528e-16
cgnd_a_n9 0 0 2.48166e-15
cbl_0_a_n9 bl_0_a_n9 0 4.52661e-16
cbl_1_a_n9 bl_1_a_n9 0 4.52661e-16
cbl_2_a_n9 bl_2_a_n9 0 4.52661e-16
cbl_3_a_n9 bl_3_a_n9 0 4.52661e-16
crbl_0_a_n9 rbl_0_a_n9 0 9.14472e-16
crbl_1_a_n9 rbl_1_a_n9 0 9.14472e-16
crbl_2_a_n9 rbl_2_a_n9 0 9.14472e-16
crbl_3_a_n9 rbl_3_a_n9 0 9.17566e-16
crwl_0_a_n9 rwl_0_a_n9 0 5.19495e-16
crwl_1_a_n9 rwl_1_a_n9 0 5.11719e-16
crwl_2_a_n9 rwl_2_a_n9 0 5.11719e-16
crwl_3_a_n9 rwl_3_a_n9 0 5.19495e-16
cwl_0_a_n9 wl_0_a_n9 0 3.30388e-16
cwl_1_a_n9 wl_1_a_n9 0 3.30388e-16
cwl_2_a_n9 wl_2_a_n9 0 3.30388e-16
cwl_3_a_n9 wl_3_a_n9 0 3.30388e-16
ccc__10__9_a_n9 n10_a_n9 n9_a_n9 1.02e-17
ccc__10_bl_3_a_n9 n10_a_n9 bl_3_a_n9 1.3999e-17
ccc__10_rwl_0_a_n9 n10_a_n9 rwl_0_a_n9 4.335e-18
ccc__17__18_a_n9 n17_a_n9 n18_a_n9 1.02e-17
ccc__17_bl_0_a_n9 n17_a_n9 bl_0_a_n9 8.415e-18
ccc__17_rwl_1_a_n9 n17_a_n9 rwl_1_a_n9 1.3194e-17
ccc__18__19_a_n9 n18_a_n9 n19_a_n9 1.02e-17
ccc__18_bl_1_a_n9 n18_a_n9 bl_1_a_n9 8.415e-18
ccc__18_rwl_1_a_n9 n18_a_n9 rwl_1_a_n9 1.3194e-17
ccc__19__20_a_n9 n19_a_n9 n20_a_n9 1.02e-17
ccc__19_bl_2_a_n9 n19_a_n9 bl_2_a_n9 8.415e-18
ccc__19_rwl_1_a_n9 n19_a_n9 rwl_1_a_n9 1.3194e-17
ccc__20_bl_3_a_n9 n20_a_n9 bl_3_a_n9 8.415e-18
ccc__20_rwl_1_a_n9 n20_a_n9 rwl_1_a_n9 6.655e-18
ccc__22__23_a_n9 n22_a_n9 n23_a_n9 1.02e-17
ccc__22_bl_0_a_n9 n22_a_n9 bl_0_a_n9 8.415e-18
ccc__22_rwl_2_a_n9 n22_a_n9 rwl_2_a_n9 1.3194e-17
ccc__23__24_a_n9 n23_a_n9 n24_a_n9 1.02e-17
ccc__23_bl_1_a_n9 n23_a_n9 bl_1_a_n9 8.415e-18
ccc__23_rwl_2_a_n9 n23_a_n9 rwl_2_a_n9 1.3194e-17
ccc__24__25_a_n9 n24_a_n9 n25_a_n9 1.02e-17
ccc__24_bl_2_a_n9 n24_a_n9 bl_2_a_n9 8.415e-18
ccc__24_rwl_2_a_n9 n24_a_n9 rwl_2_a_n9 1.3194e-17
ccc__25_bl_3_a_n9 n25_a_n9 bl_3_a_n9 8.415e-18
ccc__25_rwl_2_a_n9 n25_a_n9 rwl_2_a_n9 6.655e-18
ccc__29__30_a_n9 n29_a_n9 n30_a_n9 1.02e-17
ccc__29_bl_0_a_n9 n29_a_n9 bl_0_a_n9 8.415e-18
ccc__29_rwl_3_a_n9 n29_a_n9 rwl_3_a_n9 1.3194e-17
ccc__30__31_a_n9 n30_a_n9 n31_a_n9 1.02e-17
ccc__30_bl_1_a_n9 n30_a_n9 bl_1_a_n9 8.415e-18
ccc__30_rwl_3_a_n9 n30_a_n9 rwl_3_a_n9 1.3194e-17
ccc__31__32_a_n9 n31_a_n9 n32_a_n9 1.02e-17
ccc__31_bl_2_a_n9 n31_a_n9 bl_2_a_n9 8.415e-18
ccc__31_rwl_3_a_n9 n31_a_n9 rwl_3_a_n9 1.3194e-17
ccc__32_bl_3_a_n9 n32_a_n9 bl_3_a_n9 8.415e-18
ccc__32_rwl_3_a_n9 n32_a_n9 rwl_3_a_n9 6.655e-18
ccc__7__8_a_n9 n7_a_n9 n8_a_n9 1.02e-17
ccc__7_bl_0_a_n9 n7_a_n9 bl_0_a_n9 1.3999e-17
ccc__7_rwl_0_a_n9 n7_a_n9 rwl_0_a_n9 8.961e-18
ccc__8__9_a_n9 n8_a_n9 n9_a_n9 1.02e-17
ccc__8_bl_1_a_n9 n8_a_n9 bl_1_a_n9 1.3999e-17
ccc__8_rwl_0_a_n9 n8_a_n9 rwl_0_a_n9 8.961e-18
ccc__9_bl_2_a_n9 n9_a_n9 bl_2_a_n9 1.3999e-17
ccc__9_rwl_0_a_n9 n9_a_n9 rwl_0_a_n9 8.961e-18
ccc_bl_0_rbl_0_a_n9 bl_0_a_n9 rbl_0_a_n9 1.88693e-16
ccc_bl_0_rwl_1_a_n9 bl_0_a_n9 rwl_1_a_n9 1.0093e-17
ccc_bl_0_rwl_2_a_n9 bl_0_a_n9 rwl_2_a_n9 1.0093e-17
ccc_bl_1_rbl_0_a_n9 bl_1_a_n9 rbl_0_a_n9 1.633e-16
ccc_bl_1_rbl_1_a_n9 bl_1_a_n9 rbl_1_a_n9 1.88693e-16
ccc_bl_1_rwl_1_a_n9 bl_1_a_n9 rwl_1_a_n9 1.0093e-17
ccc_bl_1_rwl_2_a_n9 bl_1_a_n9 rwl_2_a_n9 1.0093e-17
ccc_bl_2_rbl_1_a_n9 bl_2_a_n9 rbl_1_a_n9 1.633e-16
ccc_bl_2_rbl_2_a_n9 bl_2_a_n9 rbl_2_a_n9 1.88693e-16
ccc_bl_2_rwl_1_a_n9 bl_2_a_n9 rwl_1_a_n9 1.0093e-17
ccc_bl_2_rwl_2_a_n9 bl_2_a_n9 rwl_2_a_n9 1.0093e-17
ccc_bl_3_rbl_2_a_n9 bl_3_a_n9 rbl_2_a_n9 1.633e-16
ccc_bl_3_rbl_3_a_n9 bl_3_a_n9 rbl_3_a_n9 1.88693e-16
ccc_bl_3_rwl_1_a_n9 bl_3_a_n9 rwl_1_a_n9 1.0093e-17
ccc_bl_3_rwl_2_a_n9 bl_3_a_n9 rwl_2_a_n9 1.0093e-17
ccc_rbl_0_rbl_1_a_n9 rbl_0_a_n9 rbl_1_a_n9 3.432e-17
ccc_rbl_0_rwl_0_a_n9 rbl_0_a_n9 rwl_0_a_n9 4.9752e-17
ccc_rbl_0_rwl_1_a_n9 rbl_0_a_n9 rwl_1_a_n9 4.9752e-17
ccc_rbl_0_rwl_2_a_n9 rbl_0_a_n9 rwl_2_a_n9 4.9752e-17
ccc_rbl_0_rwl_3_a_n9 rbl_0_a_n9 rwl_3_a_n9 4.9752e-17
ccc_rbl_1_rbl_2_a_n9 rbl_1_a_n9 rbl_2_a_n9 3.432e-17
ccc_rbl_1_rwl_0_a_n9 rbl_1_a_n9 rwl_0_a_n9 4.9752e-17
ccc_rbl_1_rwl_1_a_n9 rbl_1_a_n9 rwl_1_a_n9 4.9752e-17
ccc_rbl_1_rwl_2_a_n9 rbl_1_a_n9 rwl_2_a_n9 4.9752e-17
ccc_rbl_1_rwl_3_a_n9 rbl_1_a_n9 rwl_3_a_n9 4.9752e-17
ccc_rbl_2_rbl_3_a_n9 rbl_2_a_n9 rbl_3_a_n9 3.432e-17
ccc_rbl_2_rwl_0_a_n9 rbl_2_a_n9 rwl_0_a_n9 4.9752e-17
ccc_rbl_2_rwl_1_a_n9 rbl_2_a_n9 rwl_1_a_n9 4.9752e-17
ccc_rbl_2_rwl_2_a_n9 rbl_2_a_n9 rwl_2_a_n9 4.9752e-17
ccc_rbl_2_rwl_3_a_n9 rbl_2_a_n9 rwl_3_a_n9 4.9752e-17
ccc_rbl_3_rwl_0_a_n9 rbl_3_a_n9 rwl_0_a_n9 3.3407e-17
ccc_rbl_3_rwl_1_a_n9 rbl_3_a_n9 rwl_1_a_n9 3.3407e-17
ccc_rbl_3_rwl_2_a_n9 rbl_3_a_n9 rwl_2_a_n9 3.3407e-17
ccc_rbl_3_rwl_3_a_n9 rbl_3_a_n9 rwl_3_a_n9 3.3407e-17
vdw_a_n9_0 wl_0_a_n9 0 dc 0
vdr_a_n9_0 rwl_0_a_n9 vdd dc 0
vdw_a_n9_1 wl_1_a_n9 0 dc 0
vdr_a_n9_1 rwl_1_a_n9 vdd dc 0
vdw_a_n9_2 wl_2_a_n9 0 dc 0
vdr_a_n9_2 rwl_2_a_n9 vdd dc 0
vdw_a_n9_3 wl_3_a_n9 0 dc 0
vdr_a_n9_3 rwl_3_a_n9 vdd dc 0
vdb_a_n9_0 bl_0_a_n9 0 dc 0
vdp_a_n9_0 rbl_0_a_n9 vrbl dc 0
vdb_a_n9_1 bl_1_a_n9 0 dc 0
vdp_a_n9_1 rbl_1_a_n9 vrbl dc 0
vdb_a_n9_2 bl_2_a_n9 0 dc 0
vdp_a_n9_2 rbl_2_a_n9 vrbl dc 0
vdb_a_n9_3 bl_3_a_n9 0 dc 0
vdp_a_n9_3 rbl_3_a_n9 vrbl dc 0
vdn_a_n9_n7 n7_a_n9 0 dc 1
vdn_a_n9_n8 n8_a_n9 0 dc 1
vdn_a_n9_n10 n10_a_n9 0 dc 1
vdn_a_n9_n17 n17_a_n9 0 dc 1
vdn_a_n9_n18 n18_a_n9 0 dc 1
vdn_a_n9_n19 n19_a_n9 0 dc 1
vdn_a_n9_n20 n20_a_n9 0 dc 1
vdn_a_n9_n22 n22_a_n9 0 dc 1
vdn_a_n9_n23 n23_a_n9 0 dc 1
vdn_a_n9_n24 n24_a_n9 0 dc 1
vdn_a_n9_n25 n25_a_n9 0 dc 1
vdn_a_n9_n29 n29_a_n9 0 dc 1
vdn_a_n9_n30 n30_a_n9 0 dc 1
vdn_a_n9_n31 n31_a_n9 0 dc 1
vdn_a_n9_n32 n32_a_n9 0 dc 1
bdr_a_n9 n9_a_n9 0 i=5e-08*min(1,max(0,(time-1e-09)/0.2n))*0.5*(1+tanh((v(n9_a_n9)-0.05)/0.01))

* ---- instance a_n10: variant a, probed storage node \$10 ----
xm1_a_n10 rwl_0__t2_a_n10 n7__t0_a_n10 rbl_0__t0_a_n10 gnd__t0_a_n10 sky130_fd_pr__nfet_01v8 L=0.15 W=0.42 nf=1 ad=0.1197 as=0.1197 pd=1.41 ps=1.41 mult=1 m=1
xm2_a_n10 rwl_0__t3_a_n10 n8__t1_a_n10 rbl_1__t1_a_n10 gnd__t1_a_n10 sky130_fd_pr__nfet_01v8 L=0.15 W=0.42 nf=1 ad=0.1197 as=0.1197 pd=1.41 ps=1.41 mult=1 m=1
xm3_a_n10 rwl_0__t1_a_n10 n9__t1_a_n10 rbl_2__t1_a_n10 gnd__t2_a_n10 sky130_fd_pr__nfet_01v8 L=0.15 W=0.42 nf=1 ad=0.1197 as=0.1197 pd=1.41 ps=1.41 mult=1 m=1
xm4_a_n10 rwl_0__t0_a_n10 n10__t1_a_n10 rbl_3__t1_a_n10 gnd__t3_a_n10 sky130_fd_pr__nfet_01v8 L=0.15 W=0.42 nf=1 ad=0.1197 as=0.1197 pd=1.41 ps=1.41 mult=1 m=1
xm5_a_n10 bl_0__t0_a_n10 wl_0__t0_a_n10 n7__t1_a_n10 gnd__t8_a_n10 sky130_fd_pr__nfet_01v8 L=0.15 W=0.42 nf=1 ad=0.0588 as=0.1197 pd=0.7 ps=1.41 mult=1 m=1
xm6_a_n10 n17__t0_a_n10 wl_1__t0_a_n10 bl_0__t1_a_n10 gnd__t20_a_n10 sky130_fd_pr__nfet_01v8 L=0.15 W=0.42 nf=1 ad=0.1197 as=0.0588 pd=1.41 ps=0.7 mult=1 m=1
xm7_a_n10 bl_1__t2_a_n10 wl_0__t3_a_n10 n8__t0_a_n10 gnd__t9_a_n10 sky130_fd_pr__nfet_01v8 L=0.15 W=0.42 nf=1 ad=0.0588 as=0.1197 pd=0.7 ps=1.41 mult=1 m=1
xm8_a_n10 n18__t0_a_n10 wl_1__t1_a_n10 bl_1__t0_a_n10 gnd__t21_a_n10 sky130_fd_pr__nfet_01v8 L=0.15 W=0.42 nf=1 ad=0.1197 as=0.0588 pd=1.41 ps=0.7 mult=1 m=1
xm9_a_n10 bl_2__t2_a_n10 wl_0__t2_a_n10 n9__t0_a_n10 gnd__t10_a_n10 sky130_fd_pr__nfet_01v8 L=0.15 W=0.42 nf=1 ad=0.0588 as=0.1197 pd=0.7 ps=1.41 mult=1 m=1
xm10_a_n10 n19__t0_a_n10 wl_1__t2_a_n10 bl_2__t0_a_n10 gnd__t22_a_n10 sky130_fd_pr__nfet_01v8 L=0.15 W=0.42 nf=1 ad=0.1197 as=0.0588 pd=1.41 ps=0.7 mult=1 m=1
xm11_a_n10 bl_3__t2_a_n10 wl_0__t1_a_n10 n10__t0_a_n10 gnd__t11_a_n10 sky130_fd_pr__nfet_01v8 L=0.15 W=0.42 nf=1 ad=0.0588 as=0.1197 pd=0.7 ps=1.41 mult=1 m=1
xm12_a_n10 n20__t0_a_n10 wl_1__t3_a_n10 bl_3__t1_a_n10 gnd__t23_a_n10 sky130_fd_pr__nfet_01v8 L=0.15 W=0.42 nf=1 ad=0.1197 as=0.0588 pd=1.41 ps=0.7 mult=1 m=1
xm13_a_n10 rbl_0__t3_a_n10 n17__t1_a_n10 rwl_1__t0_a_n10 gnd__t12_a_n10 sky130_fd_pr__nfet_01v8 L=0.15 W=0.42 nf=1 ad=0.0588 as=0.1197 pd=0.7 ps=1.41 mult=1 m=1
xm14_a_n10 rwl_2__t3_a_n10 n22__t0_a_n10 rbl_0__t2_a_n10 gnd__t24_a_n10 sky130_fd_pr__nfet_01v8 L=0.15 W=0.42 nf=1 ad=0.1197 as=0.0588 pd=1.41 ps=0.7 mult=1 m=1
xm15_a_n10 rbl_1__t3_a_n10 n18__t1_a_n10 rwl_1__t1_a_n10 gnd__t13_a_n10 sky130_fd_pr__nfet_01v8 L=0.15 W=0.42 nf=1 ad=0.0588 as=0.1197 pd=0.7 ps=1.41 mult=1 m=1
xm16_a_n10 rwl_2__t0_a_n10 n23__t0_a_n10 rbl_1__t2_a_n10 gnd__t25_a_n10 sky130_fd_pr__nfet_01v8 L=0.15 W=0.42 nf=1 ad=0.1197 as=0.0588 pd=1.41 ps=0.7 mult=1 m=1
xm17_a_n10 rbl_2__t3_a_n10 n19__t1_a_n10 rwl_1__t2_a_n10 gnd__t14_a_n10 sky130_fd_pr__nfet_01v8 L=0.15 W=0.42 nf=1 ad=0.0588 as=0.1197 pd=0.7 ps=1.41 mult=1 m=1
xm18_a_n10 rwl_2__t1_a_n10 n24__t0_a_n10 rbl_2__t2_a_n10 gnd__t26_a_n10 sky130_fd_pr__nfet_01v8 L=0.15 W=0.42 nf=1 ad=0.1197 as=0.0588 pd=1.41 ps=0.7 mult=1 m=1
xm19_a_n10 rbl_3__t3_a_n10 n20__t1_a_n10 rwl_1__t3_a_n10 gnd__t15_a_n10 sky130_fd_pr__nfet_01v8 L=0.15 W=0.42 nf=1 ad=0.0588 as=0.1197 pd=0.7 ps=1.41 mult=1 m=1
xm20_a_n10 rwl_2__t2_a_n10 n25__t0_a_n10 rbl_3__t2_a_n10 gnd__t27_a_n10 sky130_fd_pr__nfet_01v8 L=0.15 W=0.42 nf=1 ad=0.1197 as=0.0588 pd=1.41 ps=0.7 mult=1 m=1
xm21_a_n10 bl_0__t3_a_n10 wl_2__t0_a_n10 n22__t1_a_n10 gnd__t16_a_n10 sky130_fd_pr__nfet_01v8 L=0.15 W=0.42 nf=1 ad=0.0588 as=0.1197 pd=0.7 ps=1.41 mult=1 m=1
xm22_a_n10 n29__t0_a_n10 wl_3__t3_a_n10 bl_0__t2_a_n10 gnd__t28_a_n10 sky130_fd_pr__nfet_01v8 L=0.15 W=0.42 nf=1 ad=0.1197 as=0.0588 pd=1.41 ps=0.7 mult=1 m=1
xm23_a_n10 bl_1__t3_a_n10 wl_2__t1_a_n10 n23__t1_a_n10 gnd__t17_a_n10 sky130_fd_pr__nfet_01v8 L=0.15 W=0.42 nf=1 ad=0.0588 as=0.1197 pd=0.7 ps=1.41 mult=1 m=1
xm24_a_n10 n30__t0_a_n10 wl_3__t2_a_n10 bl_1__t1_a_n10 gnd__t29_a_n10 sky130_fd_pr__nfet_01v8 L=0.15 W=0.42 nf=1 ad=0.1197 as=0.0588 pd=1.41 ps=0.7 mult=1 m=1
xm25_a_n10 bl_2__t3_a_n10 wl_2__t2_a_n10 n24__t1_a_n10 gnd__t18_a_n10 sky130_fd_pr__nfet_01v8 L=0.15 W=0.42 nf=1 ad=0.0588 as=0.1197 pd=0.7 ps=1.41 mult=1 m=1
xm26_a_n10 n31__t0_a_n10 wl_3__t1_a_n10 bl_2__t1_a_n10 gnd__t30_a_n10 sky130_fd_pr__nfet_01v8 L=0.15 W=0.42 nf=1 ad=0.1197 as=0.0588 pd=1.41 ps=0.7 mult=1 m=1
xm27_a_n10 bl_3__t3_a_n10 wl_2__t3_a_n10 n25__t1_a_n10 gnd__t19_a_n10 sky130_fd_pr__nfet_01v8 L=0.15 W=0.42 nf=1 ad=0.0588 as=0.1197 pd=0.7 ps=1.41 mult=1 m=1
xm28_a_n10 n32__t0_a_n10 wl_3__t0_a_n10 bl_3__t0_a_n10 gnd__t31_a_n10 sky130_fd_pr__nfet_01v8 L=0.15 W=0.42 nf=1 ad=0.1197 as=0.0588 pd=1.41 ps=0.7 mult=1 m=1
xm29_a_n10 rbl_0__t1_a_n10 n29__t1_a_n10 rwl_3__t0_a_n10 gnd__t4_a_n10 sky130_fd_pr__nfet_01v8 L=0.15 W=0.42 nf=1 ad=0.1197 as=0.1197 pd=1.41 ps=1.41 mult=1 m=1
xm30_a_n10 rbl_1__t0_a_n10 n30__t1_a_n10 rwl_3__t1_a_n10 gnd__t5_a_n10 sky130_fd_pr__nfet_01v8 L=0.15 W=0.42 nf=1 ad=0.1197 as=0.1197 pd=1.41 ps=1.41 mult=1 m=1
xm31_a_n10 rbl_2__t0_a_n10 n31__t1_a_n10 rwl_3__t2_a_n10 gnd__t6_a_n10 sky130_fd_pr__nfet_01v8 L=0.15 W=0.42 nf=1 ad=0.1197 as=0.1197 pd=1.41 ps=1.41 mult=1 m=1
xm32_a_n10 rbl_3__t0_a_n10 n32__t1_a_n10 rwl_3__t3_a_n10 gnd__t7_a_n10 sky130_fd_pr__nfet_01v8 L=0.15 W=0.42 nf=1 ad=0.1197 as=0.1197 pd=1.41 ps=1.41 mult=1 m=1
r_10_t0_a_n10 n10__t0_a_n10 n10_a_n10 183.071
r_10_t1_a_n10 n10__t1_a_n10 n10_a_n10 183.071
r_17_t0_a_n10 n17__t0_a_n10 n17_a_n10 183.071
r_17_t1_a_n10 n17__t1_a_n10 n17_a_n10 183.071
r_18_t0_a_n10 n18__t0_a_n10 n18_a_n10 183.071
r_18_t1_a_n10 n18__t1_a_n10 n18_a_n10 183.071
r_19_t0_a_n10 n19__t0_a_n10 n19_a_n10 183.071
r_19_t1_a_n10 n19__t1_a_n10 n19_a_n10 183.071
r_20_t0_a_n10 n20__t0_a_n10 n20_a_n10 183.071
r_20_t1_a_n10 n20__t1_a_n10 n20_a_n10 183.071
r_22_t0_a_n10 n22__t0_a_n10 n22_a_n10 183.071
r_22_t1_a_n10 n22__t1_a_n10 n22_a_n10 183.071
r_23_t0_a_n10 n23__t0_a_n10 n23_a_n10 183.071
r_23_t1_a_n10 n23__t1_a_n10 n23_a_n10 183.071
r_24_t0_a_n10 n24__t0_a_n10 n24_a_n10 183.071
r_24_t1_a_n10 n24__t1_a_n10 n24_a_n10 183.071
r_25_t0_a_n10 n25__t0_a_n10 n25_a_n10 183.071
r_25_t1_a_n10 n25__t1_a_n10 n25_a_n10 183.071
r_29_t0_a_n10 n29__t0_a_n10 n29_a_n10 183.071
r_29_t1_a_n10 n29__t1_a_n10 n29_a_n10 183.071
r_30_t0_a_n10 n30__t0_a_n10 n30_a_n10 183.071
r_30_t1_a_n10 n30__t1_a_n10 n30_a_n10 183.071
r_31_t0_a_n10 n31__t0_a_n10 n31_a_n10 183.071
r_31_t1_a_n10 n31__t1_a_n10 n31_a_n10 183.071
r_32_t0_a_n10 n32__t0_a_n10 n32_a_n10 183.071
r_32_t1_a_n10 n32__t1_a_n10 n32_a_n10 183.071
r_7_t0_a_n10 n7__t0_a_n10 n7_a_n10 183.071
r_7_t1_a_n10 n7__t1_a_n10 n7_a_n10 183.071
r_8_t0_a_n10 n8__t0_a_n10 n8_a_n10 183.071
r_8_t1_a_n10 n8__t1_a_n10 n8_a_n10 183.071
r_9_t0_a_n10 n9__t0_a_n10 n9_a_n10 183.071
r_9_t1_a_n10 n9__t1_a_n10 n9_a_n10 183.071
rgnd_t0_a_n10 gnd__t0_a_n10 0 38.2988
rgnd_t1_a_n10 gnd__t1_a_n10 0 33.9576
rgnd_t2_a_n10 gnd__t2_a_n10 0 33.9576
rgnd_t3_a_n10 gnd__t3_a_n10 0 38.2988
rgnd_t4_a_n10 gnd__t4_a_n10 0 38.2988
rgnd_t5_a_n10 gnd__t5_a_n10 0 33.9576
rgnd_t6_a_n10 gnd__t6_a_n10 0 33.9576
rgnd_t7_a_n10 gnd__t7_a_n10 0 38.2988
rgnd_t8_a_n10 gnd__t8_a_n10 0 28.0185
rgnd_t9_a_n10 gnd__t9_a_n10 0 21.7106
rgnd_t10_a_n10 gnd__t10_a_n10 0 21.7106
rgnd_t11_a_n10 gnd__t11_a_n10 0 28.0185
rgnd_t12_a_n10 gnd__t12_a_n10 0 18.9833
rgnd_t13_a_n10 gnd__t13_a_n10 0 6.8325
rgnd_t14_a_n10 gnd__t14_a_n10 0 6.8325
rgnd_t15_a_n10 gnd__t15_a_n10 0 18.9833
rgnd_t16_a_n10 gnd__t16_a_n10 0 24.2409
rgnd_t17_a_n10 gnd__t17_a_n10 0 16.5511
rgnd_t18_a_n10 gnd__t18_a_n10 0 16.5511
rgnd_t19_a_n10 gnd__t19_a_n10 0 24.2409
rgnd_t20_a_n10 gnd__t20_a_n10 0 24.2409
rgnd_t21_a_n10 gnd__t21_a_n10 0 16.5511
rgnd_t22_a_n10 gnd__t22_a_n10 0 16.5511
rgnd_t23_a_n10 gnd__t23_a_n10 0 24.2409
rgnd_t24_a_n10 gnd__t24_a_n10 0 18.9833
rgnd_t25_a_n10 gnd__t25_a_n10 0 6.8325
rgnd_t26_a_n10 gnd__t26_a_n10 0 6.8325
rgnd_t27_a_n10 gnd__t27_a_n10 0 18.9833
rgnd_t28_a_n10 gnd__t28_a_n10 0 28.0185
rgnd_t29_a_n10 gnd__t29_a_n10 0 21.7106
rgnd_t30_a_n10 gnd__t30_a_n10 0 21.7106
rgnd_t31_a_n10 gnd__t31_a_n10 0 28.0185
rbl_0_t0_a_n10 bl_0__t0_a_n10 bl_0_a_n10 14.8304
rbl_0_t1_a_n10 bl_0__t1_a_n10 bl_0_a_n10 10.9301
rbl_0_t2_a_n10 bl_0__t2_a_n10 bl_0_a_n10 14.8304
rbl_0_t3_a_n10 bl_0__t3_a_n10 bl_0_a_n10 10.9301
rbl_1_t0_a_n10 bl_1__t0_a_n10 bl_1_a_n10 10.9301
rbl_1_t1_a_n10 bl_1__t1_a_n10 bl_1_a_n10 14.8304
rbl_1_t2_a_n10 bl_1__t2_a_n10 bl_1_a_n10 14.8304
rbl_1_t3_a_n10 bl_1__t3_a_n10 bl_1_a_n10 10.9301
rbl_2_t0_a_n10 bl_2__t0_a_n10 bl_2_a_n10 10.9301
rbl_2_t1_a_n10 bl_2__t1_a_n10 bl_2_a_n10 14.8304
rbl_2_t2_a_n10 bl_2__t2_a_n10 bl_2_a_n10 14.8304
rbl_2_t3_a_n10 bl_2__t3_a_n10 bl_2_a_n10 10.9301
rbl_3_t0_a_n10 bl_3__t0_a_n10 bl_3_a_n10 14.8304
rbl_3_t1_a_n10 bl_3__t1_a_n10 bl_3_a_n10 10.9301
rbl_3_t2_a_n10 bl_3__t2_a_n10 bl_3_a_n10 14.8304
rbl_3_t3_a_n10 bl_3__t3_a_n10 bl_3_a_n10 10.9301
rrbl_0_t0_a_n10 rbl_0__t0_a_n10 rbl_0_a_n10 36.5601
rrbl_0_t1_a_n10 rbl_0__t1_a_n10 rbl_0_a_n10 36.5601
rrbl_0_t2_a_n10 rbl_0__t2_a_n10 rbl_0_a_n10 2.99444
rrbl_0_t3_a_n10 rbl_0__t3_a_n10 rbl_0_a_n10 2.99444
rrbl_1_t0_a_n10 rbl_1__t0_a_n10 rbl_1_a_n10 36.5601
rrbl_1_t1_a_n10 rbl_1__t1_a_n10 rbl_1_a_n10 36.5601
rrbl_1_t2_a_n10 rbl_1__t2_a_n10 rbl_1_a_n10 2.99444
rrbl_1_t3_a_n10 rbl_1__t3_a_n10 rbl_1_a_n10 2.99444
rrbl_2_t0_a_n10 rbl_2__t0_a_n10 rbl_2_a_n10 36.5601
rrbl_2_t1_a_n10 rbl_2__t1_a_n10 rbl_2_a_n10 36.5601
rrbl_2_t2_a_n10 rbl_2__t2_a_n10 rbl_2_a_n10 2.99444
rrbl_2_t3_a_n10 rbl_2__t3_a_n10 rbl_2_a_n10 2.99444
rrbl_3_t0_a_n10 rbl_3__t0_a_n10 rbl_3_a_n10 36.5601
rrbl_3_t1_a_n10 rbl_3__t1_a_n10 rbl_3_a_n10 36.5601
rrbl_3_t2_a_n10 rbl_3__t2_a_n10 rbl_3_a_n10 2.99444
rrbl_3_t3_a_n10 rbl_3__t3_a_n10 rbl_3_a_n10 2.99444
rrwl_0_t0_a_n10 rwl_0__t0_a_n10 rwl_0_a_n10 38.2618
rrwl_0_t1_a_n10 rwl_0__t1_a_n10 rwl_0_a_n10 12.7539
rrwl_0_t2_a_n10 rwl_0__t2_a_n10 rwl_0_a_n10 38.2618
rrwl_0_t3_a_n10 rwl_0__t3_a_n10 rwl_0_a_n10 12.7539
rrwl_1_t0_a_n10 rwl_1__t0_a_n10 rwl_1_a_n10 38.2618
rrwl_1_t1_a_n10 rwl_1__t1_a_n10 rwl_1_a_n10 12.7539
rrwl_1_t2_a_n10 rwl_1__t2_a_n10 rwl_1_a_n10 12.7539
rrwl_1_t3_a_n10 rwl_1__t3_a_n10 rwl_1_a_n10 38.2618
rrwl_2_t0_a_n10 rwl_2__t0_a_n10 rwl_2_a_n10 12.7539
rrwl_2_t1_a_n10 rwl_2__t1_a_n10 rwl_2_a_n10 12.7539
rrwl_2_t2_a_n10 rwl_2__t2_a_n10 rwl_2_a_n10 38.2618
rrwl_2_t3_a_n10 rwl_2__t3_a_n10 rwl_2_a_n10 38.2618
rrwl_3_t0_a_n10 rwl_3__t0_a_n10 rwl_3_a_n10 38.2618
rrwl_3_t1_a_n10 rwl_3__t1_a_n10 rwl_3_a_n10 12.7539
rrwl_3_t2_a_n10 rwl_3__t2_a_n10 rwl_3_a_n10 12.7539
rrwl_3_t3_a_n10 rwl_3__t3_a_n10 rwl_3_a_n10 38.2618
rwl_0_t0_a_n10 wl_0__t0_a_n10 wl_0_a_n10 245.959
rwl_0_t1_a_n10 wl_0__t1_a_n10 wl_0_a_n10 245.959
rwl_0_t2_a_n10 wl_0__t2_a_n10 wl_0_a_n10 81.9864
rwl_0_t3_a_n10 wl_0__t3_a_n10 wl_0_a_n10 81.9864
rwl_1_t0_a_n10 wl_1__t0_a_n10 wl_1_a_n10 245.959
rwl_1_t1_a_n10 wl_1__t1_a_n10 wl_1_a_n10 81.9864
rwl_1_t2_a_n10 wl_1__t2_a_n10 wl_1_a_n10 81.9864
rwl_1_t3_a_n10 wl_1__t3_a_n10 wl_1_a_n10 245.959
rwl_2_t0_a_n10 wl_2__t0_a_n10 wl_2_a_n10 245.959
rwl_2_t1_a_n10 wl_2__t1_a_n10 wl_2_a_n10 81.9864
rwl_2_t2_a_n10 wl_2__t2_a_n10 wl_2_a_n10 81.9864
rwl_2_t3_a_n10 wl_2__t3_a_n10 wl_2_a_n10 245.959
rwl_3_t0_a_n10 wl_3__t0_a_n10 wl_3_a_n10 245.959
rwl_3_t1_a_n10 wl_3__t1_a_n10 wl_3_a_n10 81.9864
rwl_3_t2_a_n10 wl_3__t2_a_n10 wl_3_a_n10 81.9864
rwl_3_t3_a_n10 wl_3__t3_a_n10 wl_3_a_n10 245.959
c_10_a_n10 n10_a_n10 0 2.91622e-16
c_17_a_n10 n17_a_n10 0 2.91528e-16
c_18_a_n10 n18_a_n10 0 2.91528e-16
c_19_a_n10 n19_a_n10 0 2.91528e-16
c_20_a_n10 n20_a_n10 0 2.91622e-16
c_22_a_n10 n22_a_n10 0 2.91528e-16
c_23_a_n10 n23_a_n10 0 2.91528e-16
c_24_a_n10 n24_a_n10 0 2.91528e-16
c_25_a_n10 n25_a_n10 0 2.91622e-16
c_29_a_n10 n29_a_n10 0 2.91528e-16
c_30_a_n10 n30_a_n10 0 2.91528e-16
c_31_a_n10 n31_a_n10 0 2.91528e-16
c_32_a_n10 n32_a_n10 0 2.91622e-16
c_7_a_n10 n7_a_n10 0 2.91528e-16
c_8_a_n10 n8_a_n10 0 2.91528e-16
c_9_a_n10 n9_a_n10 0 2.91528e-16
cgnd_a_n10 0 0 2.48166e-15
cbl_0_a_n10 bl_0_a_n10 0 4.52661e-16
cbl_1_a_n10 bl_1_a_n10 0 4.52661e-16
cbl_2_a_n10 bl_2_a_n10 0 4.52661e-16
cbl_3_a_n10 bl_3_a_n10 0 4.52661e-16
crbl_0_a_n10 rbl_0_a_n10 0 9.14472e-16
crbl_1_a_n10 rbl_1_a_n10 0 9.14472e-16
crbl_2_a_n10 rbl_2_a_n10 0 9.14472e-16
crbl_3_a_n10 rbl_3_a_n10 0 9.17566e-16
crwl_0_a_n10 rwl_0_a_n10 0 5.19495e-16
crwl_1_a_n10 rwl_1_a_n10 0 5.11719e-16
crwl_2_a_n10 rwl_2_a_n10 0 5.11719e-16
crwl_3_a_n10 rwl_3_a_n10 0 5.19495e-16
cwl_0_a_n10 wl_0_a_n10 0 3.30388e-16
cwl_1_a_n10 wl_1_a_n10 0 3.30388e-16
cwl_2_a_n10 wl_2_a_n10 0 3.30388e-16
cwl_3_a_n10 wl_3_a_n10 0 3.30388e-16
ccc__10__9_a_n10 n10_a_n10 n9_a_n10 1.02e-17
ccc__10_bl_3_a_n10 n10_a_n10 bl_3_a_n10 1.3999e-17
ccc__10_rwl_0_a_n10 n10_a_n10 rwl_0_a_n10 4.335e-18
ccc__17__18_a_n10 n17_a_n10 n18_a_n10 1.02e-17
ccc__17_bl_0_a_n10 n17_a_n10 bl_0_a_n10 8.415e-18
ccc__17_rwl_1_a_n10 n17_a_n10 rwl_1_a_n10 1.3194e-17
ccc__18__19_a_n10 n18_a_n10 n19_a_n10 1.02e-17
ccc__18_bl_1_a_n10 n18_a_n10 bl_1_a_n10 8.415e-18
ccc__18_rwl_1_a_n10 n18_a_n10 rwl_1_a_n10 1.3194e-17
ccc__19__20_a_n10 n19_a_n10 n20_a_n10 1.02e-17
ccc__19_bl_2_a_n10 n19_a_n10 bl_2_a_n10 8.415e-18
ccc__19_rwl_1_a_n10 n19_a_n10 rwl_1_a_n10 1.3194e-17
ccc__20_bl_3_a_n10 n20_a_n10 bl_3_a_n10 8.415e-18
ccc__20_rwl_1_a_n10 n20_a_n10 rwl_1_a_n10 6.655e-18
ccc__22__23_a_n10 n22_a_n10 n23_a_n10 1.02e-17
ccc__22_bl_0_a_n10 n22_a_n10 bl_0_a_n10 8.415e-18
ccc__22_rwl_2_a_n10 n22_a_n10 rwl_2_a_n10 1.3194e-17
ccc__23__24_a_n10 n23_a_n10 n24_a_n10 1.02e-17
ccc__23_bl_1_a_n10 n23_a_n10 bl_1_a_n10 8.415e-18
ccc__23_rwl_2_a_n10 n23_a_n10 rwl_2_a_n10 1.3194e-17
ccc__24__25_a_n10 n24_a_n10 n25_a_n10 1.02e-17
ccc__24_bl_2_a_n10 n24_a_n10 bl_2_a_n10 8.415e-18
ccc__24_rwl_2_a_n10 n24_a_n10 rwl_2_a_n10 1.3194e-17
ccc__25_bl_3_a_n10 n25_a_n10 bl_3_a_n10 8.415e-18
ccc__25_rwl_2_a_n10 n25_a_n10 rwl_2_a_n10 6.655e-18
ccc__29__30_a_n10 n29_a_n10 n30_a_n10 1.02e-17
ccc__29_bl_0_a_n10 n29_a_n10 bl_0_a_n10 8.415e-18
ccc__29_rwl_3_a_n10 n29_a_n10 rwl_3_a_n10 1.3194e-17
ccc__30__31_a_n10 n30_a_n10 n31_a_n10 1.02e-17
ccc__30_bl_1_a_n10 n30_a_n10 bl_1_a_n10 8.415e-18
ccc__30_rwl_3_a_n10 n30_a_n10 rwl_3_a_n10 1.3194e-17
ccc__31__32_a_n10 n31_a_n10 n32_a_n10 1.02e-17
ccc__31_bl_2_a_n10 n31_a_n10 bl_2_a_n10 8.415e-18
ccc__31_rwl_3_a_n10 n31_a_n10 rwl_3_a_n10 1.3194e-17
ccc__32_bl_3_a_n10 n32_a_n10 bl_3_a_n10 8.415e-18
ccc__32_rwl_3_a_n10 n32_a_n10 rwl_3_a_n10 6.655e-18
ccc__7__8_a_n10 n7_a_n10 n8_a_n10 1.02e-17
ccc__7_bl_0_a_n10 n7_a_n10 bl_0_a_n10 1.3999e-17
ccc__7_rwl_0_a_n10 n7_a_n10 rwl_0_a_n10 8.961e-18
ccc__8__9_a_n10 n8_a_n10 n9_a_n10 1.02e-17
ccc__8_bl_1_a_n10 n8_a_n10 bl_1_a_n10 1.3999e-17
ccc__8_rwl_0_a_n10 n8_a_n10 rwl_0_a_n10 8.961e-18
ccc__9_bl_2_a_n10 n9_a_n10 bl_2_a_n10 1.3999e-17
ccc__9_rwl_0_a_n10 n9_a_n10 rwl_0_a_n10 8.961e-18
ccc_bl_0_rbl_0_a_n10 bl_0_a_n10 rbl_0_a_n10 1.88693e-16
ccc_bl_0_rwl_1_a_n10 bl_0_a_n10 rwl_1_a_n10 1.0093e-17
ccc_bl_0_rwl_2_a_n10 bl_0_a_n10 rwl_2_a_n10 1.0093e-17
ccc_bl_1_rbl_0_a_n10 bl_1_a_n10 rbl_0_a_n10 1.633e-16
ccc_bl_1_rbl_1_a_n10 bl_1_a_n10 rbl_1_a_n10 1.88693e-16
ccc_bl_1_rwl_1_a_n10 bl_1_a_n10 rwl_1_a_n10 1.0093e-17
ccc_bl_1_rwl_2_a_n10 bl_1_a_n10 rwl_2_a_n10 1.0093e-17
ccc_bl_2_rbl_1_a_n10 bl_2_a_n10 rbl_1_a_n10 1.633e-16
ccc_bl_2_rbl_2_a_n10 bl_2_a_n10 rbl_2_a_n10 1.88693e-16
ccc_bl_2_rwl_1_a_n10 bl_2_a_n10 rwl_1_a_n10 1.0093e-17
ccc_bl_2_rwl_2_a_n10 bl_2_a_n10 rwl_2_a_n10 1.0093e-17
ccc_bl_3_rbl_2_a_n10 bl_3_a_n10 rbl_2_a_n10 1.633e-16
ccc_bl_3_rbl_3_a_n10 bl_3_a_n10 rbl_3_a_n10 1.88693e-16
ccc_bl_3_rwl_1_a_n10 bl_3_a_n10 rwl_1_a_n10 1.0093e-17
ccc_bl_3_rwl_2_a_n10 bl_3_a_n10 rwl_2_a_n10 1.0093e-17
ccc_rbl_0_rbl_1_a_n10 rbl_0_a_n10 rbl_1_a_n10 3.432e-17
ccc_rbl_0_rwl_0_a_n10 rbl_0_a_n10 rwl_0_a_n10 4.9752e-17
ccc_rbl_0_rwl_1_a_n10 rbl_0_a_n10 rwl_1_a_n10 4.9752e-17
ccc_rbl_0_rwl_2_a_n10 rbl_0_a_n10 rwl_2_a_n10 4.9752e-17
ccc_rbl_0_rwl_3_a_n10 rbl_0_a_n10 rwl_3_a_n10 4.9752e-17
ccc_rbl_1_rbl_2_a_n10 rbl_1_a_n10 rbl_2_a_n10 3.432e-17
ccc_rbl_1_rwl_0_a_n10 rbl_1_a_n10 rwl_0_a_n10 4.9752e-17
ccc_rbl_1_rwl_1_a_n10 rbl_1_a_n10 rwl_1_a_n10 4.9752e-17
ccc_rbl_1_rwl_2_a_n10 rbl_1_a_n10 rwl_2_a_n10 4.9752e-17
ccc_rbl_1_rwl_3_a_n10 rbl_1_a_n10 rwl_3_a_n10 4.9752e-17
ccc_rbl_2_rbl_3_a_n10 rbl_2_a_n10 rbl_3_a_n10 3.432e-17
ccc_rbl_2_rwl_0_a_n10 rbl_2_a_n10 rwl_0_a_n10 4.9752e-17
ccc_rbl_2_rwl_1_a_n10 rbl_2_a_n10 rwl_1_a_n10 4.9752e-17
ccc_rbl_2_rwl_2_a_n10 rbl_2_a_n10 rwl_2_a_n10 4.9752e-17
ccc_rbl_2_rwl_3_a_n10 rbl_2_a_n10 rwl_3_a_n10 4.9752e-17
ccc_rbl_3_rwl_0_a_n10 rbl_3_a_n10 rwl_0_a_n10 3.3407e-17
ccc_rbl_3_rwl_1_a_n10 rbl_3_a_n10 rwl_1_a_n10 3.3407e-17
ccc_rbl_3_rwl_2_a_n10 rbl_3_a_n10 rwl_2_a_n10 3.3407e-17
ccc_rbl_3_rwl_3_a_n10 rbl_3_a_n10 rwl_3_a_n10 3.3407e-17
vdw_a_n10_0 wl_0_a_n10 0 dc 0
vdr_a_n10_0 rwl_0_a_n10 vdd dc 0
vdw_a_n10_1 wl_1_a_n10 0 dc 0
vdr_a_n10_1 rwl_1_a_n10 vdd dc 0
vdw_a_n10_2 wl_2_a_n10 0 dc 0
vdr_a_n10_2 rwl_2_a_n10 vdd dc 0
vdw_a_n10_3 wl_3_a_n10 0 dc 0
vdr_a_n10_3 rwl_3_a_n10 vdd dc 0
vdb_a_n10_0 bl_0_a_n10 0 dc 0
vdp_a_n10_0 rbl_0_a_n10 vrbl dc 0
vdb_a_n10_1 bl_1_a_n10 0 dc 0
vdp_a_n10_1 rbl_1_a_n10 vrbl dc 0
vdb_a_n10_2 bl_2_a_n10 0 dc 0
vdp_a_n10_2 rbl_2_a_n10 vrbl dc 0
vdb_a_n10_3 bl_3_a_n10 0 dc 0
vdp_a_n10_3 rbl_3_a_n10 vrbl dc 0
vdn_a_n10_n7 n7_a_n10 0 dc 1
vdn_a_n10_n8 n8_a_n10 0 dc 1
vdn_a_n10_n9 n9_a_n10 0 dc 1
vdn_a_n10_n17 n17_a_n10 0 dc 1
vdn_a_n10_n18 n18_a_n10 0 dc 1
vdn_a_n10_n19 n19_a_n10 0 dc 1
vdn_a_n10_n20 n20_a_n10 0 dc 1
vdn_a_n10_n22 n22_a_n10 0 dc 1
vdn_a_n10_n23 n23_a_n10 0 dc 1
vdn_a_n10_n24 n24_a_n10 0 dc 1
vdn_a_n10_n25 n25_a_n10 0 dc 1
vdn_a_n10_n29 n29_a_n10 0 dc 1
vdn_a_n10_n30 n30_a_n10 0 dc 1
vdn_a_n10_n31 n31_a_n10 0 dc 1
vdn_a_n10_n32 n32_a_n10 0 dc 1
bdr_a_n10 n10_a_n10 0 i=5e-08*min(1,max(0,(time-1e-09)/0.2n))*0.5*(1+tanh((v(n10_a_n10)-0.05)/0.01))

* ---- instance a_n17: variant a, probed storage node \$17 ----
xm1_a_n17 rwl_0__t2_a_n17 n7__t0_a_n17 rbl_0__t0_a_n17 gnd__t0_a_n17 sky130_fd_pr__nfet_01v8 L=0.15 W=0.42 nf=1 ad=0.1197 as=0.1197 pd=1.41 ps=1.41 mult=1 m=1
xm2_a_n17 rwl_0__t3_a_n17 n8__t1_a_n17 rbl_1__t1_a_n17 gnd__t1_a_n17 sky130_fd_pr__nfet_01v8 L=0.15 W=0.42 nf=1 ad=0.1197 as=0.1197 pd=1.41 ps=1.41 mult=1 m=1
xm3_a_n17 rwl_0__t1_a_n17 n9__t1_a_n17 rbl_2__t1_a_n17 gnd__t2_a_n17 sky130_fd_pr__nfet_01v8 L=0.15 W=0.42 nf=1 ad=0.1197 as=0.1197 pd=1.41 ps=1.41 mult=1 m=1
xm4_a_n17 rwl_0__t0_a_n17 n10__t1_a_n17 rbl_3__t1_a_n17 gnd__t3_a_n17 sky130_fd_pr__nfet_01v8 L=0.15 W=0.42 nf=1 ad=0.1197 as=0.1197 pd=1.41 ps=1.41 mult=1 m=1
xm5_a_n17 bl_0__t0_a_n17 wl_0__t0_a_n17 n7__t1_a_n17 gnd__t8_a_n17 sky130_fd_pr__nfet_01v8 L=0.15 W=0.42 nf=1 ad=0.0588 as=0.1197 pd=0.7 ps=1.41 mult=1 m=1
xm6_a_n17 n17__t0_a_n17 wl_1__t0_a_n17 bl_0__t1_a_n17 gnd__t20_a_n17 sky130_fd_pr__nfet_01v8 L=0.15 W=0.42 nf=1 ad=0.1197 as=0.0588 pd=1.41 ps=0.7 mult=1 m=1
xm7_a_n17 bl_1__t2_a_n17 wl_0__t3_a_n17 n8__t0_a_n17 gnd__t9_a_n17 sky130_fd_pr__nfet_01v8 L=0.15 W=0.42 nf=1 ad=0.0588 as=0.1197 pd=0.7 ps=1.41 mult=1 m=1
xm8_a_n17 n18__t0_a_n17 wl_1__t1_a_n17 bl_1__t0_a_n17 gnd__t21_a_n17 sky130_fd_pr__nfet_01v8 L=0.15 W=0.42 nf=1 ad=0.1197 as=0.0588 pd=1.41 ps=0.7 mult=1 m=1
xm9_a_n17 bl_2__t2_a_n17 wl_0__t2_a_n17 n9__t0_a_n17 gnd__t10_a_n17 sky130_fd_pr__nfet_01v8 L=0.15 W=0.42 nf=1 ad=0.0588 as=0.1197 pd=0.7 ps=1.41 mult=1 m=1
xm10_a_n17 n19__t0_a_n17 wl_1__t2_a_n17 bl_2__t0_a_n17 gnd__t22_a_n17 sky130_fd_pr__nfet_01v8 L=0.15 W=0.42 nf=1 ad=0.1197 as=0.0588 pd=1.41 ps=0.7 mult=1 m=1
xm11_a_n17 bl_3__t2_a_n17 wl_0__t1_a_n17 n10__t0_a_n17 gnd__t11_a_n17 sky130_fd_pr__nfet_01v8 L=0.15 W=0.42 nf=1 ad=0.0588 as=0.1197 pd=0.7 ps=1.41 mult=1 m=1
xm12_a_n17 n20__t0_a_n17 wl_1__t3_a_n17 bl_3__t1_a_n17 gnd__t23_a_n17 sky130_fd_pr__nfet_01v8 L=0.15 W=0.42 nf=1 ad=0.1197 as=0.0588 pd=1.41 ps=0.7 mult=1 m=1
xm13_a_n17 rbl_0__t3_a_n17 n17__t1_a_n17 rwl_1__t0_a_n17 gnd__t12_a_n17 sky130_fd_pr__nfet_01v8 L=0.15 W=0.42 nf=1 ad=0.0588 as=0.1197 pd=0.7 ps=1.41 mult=1 m=1
xm14_a_n17 rwl_2__t3_a_n17 n22__t0_a_n17 rbl_0__t2_a_n17 gnd__t24_a_n17 sky130_fd_pr__nfet_01v8 L=0.15 W=0.42 nf=1 ad=0.1197 as=0.0588 pd=1.41 ps=0.7 mult=1 m=1
xm15_a_n17 rbl_1__t3_a_n17 n18__t1_a_n17 rwl_1__t1_a_n17 gnd__t13_a_n17 sky130_fd_pr__nfet_01v8 L=0.15 W=0.42 nf=1 ad=0.0588 as=0.1197 pd=0.7 ps=1.41 mult=1 m=1
xm16_a_n17 rwl_2__t0_a_n17 n23__t0_a_n17 rbl_1__t2_a_n17 gnd__t25_a_n17 sky130_fd_pr__nfet_01v8 L=0.15 W=0.42 nf=1 ad=0.1197 as=0.0588 pd=1.41 ps=0.7 mult=1 m=1
xm17_a_n17 rbl_2__t3_a_n17 n19__t1_a_n17 rwl_1__t2_a_n17 gnd__t14_a_n17 sky130_fd_pr__nfet_01v8 L=0.15 W=0.42 nf=1 ad=0.0588 as=0.1197 pd=0.7 ps=1.41 mult=1 m=1
xm18_a_n17 rwl_2__t1_a_n17 n24__t0_a_n17 rbl_2__t2_a_n17 gnd__t26_a_n17 sky130_fd_pr__nfet_01v8 L=0.15 W=0.42 nf=1 ad=0.1197 as=0.0588 pd=1.41 ps=0.7 mult=1 m=1
xm19_a_n17 rbl_3__t3_a_n17 n20__t1_a_n17 rwl_1__t3_a_n17 gnd__t15_a_n17 sky130_fd_pr__nfet_01v8 L=0.15 W=0.42 nf=1 ad=0.0588 as=0.1197 pd=0.7 ps=1.41 mult=1 m=1
xm20_a_n17 rwl_2__t2_a_n17 n25__t0_a_n17 rbl_3__t2_a_n17 gnd__t27_a_n17 sky130_fd_pr__nfet_01v8 L=0.15 W=0.42 nf=1 ad=0.1197 as=0.0588 pd=1.41 ps=0.7 mult=1 m=1
xm21_a_n17 bl_0__t3_a_n17 wl_2__t0_a_n17 n22__t1_a_n17 gnd__t16_a_n17 sky130_fd_pr__nfet_01v8 L=0.15 W=0.42 nf=1 ad=0.0588 as=0.1197 pd=0.7 ps=1.41 mult=1 m=1
xm22_a_n17 n29__t0_a_n17 wl_3__t3_a_n17 bl_0__t2_a_n17 gnd__t28_a_n17 sky130_fd_pr__nfet_01v8 L=0.15 W=0.42 nf=1 ad=0.1197 as=0.0588 pd=1.41 ps=0.7 mult=1 m=1
xm23_a_n17 bl_1__t3_a_n17 wl_2__t1_a_n17 n23__t1_a_n17 gnd__t17_a_n17 sky130_fd_pr__nfet_01v8 L=0.15 W=0.42 nf=1 ad=0.0588 as=0.1197 pd=0.7 ps=1.41 mult=1 m=1
xm24_a_n17 n30__t0_a_n17 wl_3__t2_a_n17 bl_1__t1_a_n17 gnd__t29_a_n17 sky130_fd_pr__nfet_01v8 L=0.15 W=0.42 nf=1 ad=0.1197 as=0.0588 pd=1.41 ps=0.7 mult=1 m=1
xm25_a_n17 bl_2__t3_a_n17 wl_2__t2_a_n17 n24__t1_a_n17 gnd__t18_a_n17 sky130_fd_pr__nfet_01v8 L=0.15 W=0.42 nf=1 ad=0.0588 as=0.1197 pd=0.7 ps=1.41 mult=1 m=1
xm26_a_n17 n31__t0_a_n17 wl_3__t1_a_n17 bl_2__t1_a_n17 gnd__t30_a_n17 sky130_fd_pr__nfet_01v8 L=0.15 W=0.42 nf=1 ad=0.1197 as=0.0588 pd=1.41 ps=0.7 mult=1 m=1
xm27_a_n17 bl_3__t3_a_n17 wl_2__t3_a_n17 n25__t1_a_n17 gnd__t19_a_n17 sky130_fd_pr__nfet_01v8 L=0.15 W=0.42 nf=1 ad=0.0588 as=0.1197 pd=0.7 ps=1.41 mult=1 m=1
xm28_a_n17 n32__t0_a_n17 wl_3__t0_a_n17 bl_3__t0_a_n17 gnd__t31_a_n17 sky130_fd_pr__nfet_01v8 L=0.15 W=0.42 nf=1 ad=0.1197 as=0.0588 pd=1.41 ps=0.7 mult=1 m=1
xm29_a_n17 rbl_0__t1_a_n17 n29__t1_a_n17 rwl_3__t0_a_n17 gnd__t4_a_n17 sky130_fd_pr__nfet_01v8 L=0.15 W=0.42 nf=1 ad=0.1197 as=0.1197 pd=1.41 ps=1.41 mult=1 m=1
xm30_a_n17 rbl_1__t0_a_n17 n30__t1_a_n17 rwl_3__t1_a_n17 gnd__t5_a_n17 sky130_fd_pr__nfet_01v8 L=0.15 W=0.42 nf=1 ad=0.1197 as=0.1197 pd=1.41 ps=1.41 mult=1 m=1
xm31_a_n17 rbl_2__t0_a_n17 n31__t1_a_n17 rwl_3__t2_a_n17 gnd__t6_a_n17 sky130_fd_pr__nfet_01v8 L=0.15 W=0.42 nf=1 ad=0.1197 as=0.1197 pd=1.41 ps=1.41 mult=1 m=1
xm32_a_n17 rbl_3__t0_a_n17 n32__t1_a_n17 rwl_3__t3_a_n17 gnd__t7_a_n17 sky130_fd_pr__nfet_01v8 L=0.15 W=0.42 nf=1 ad=0.1197 as=0.1197 pd=1.41 ps=1.41 mult=1 m=1
r_10_t0_a_n17 n10__t0_a_n17 n10_a_n17 183.071
r_10_t1_a_n17 n10__t1_a_n17 n10_a_n17 183.071
r_17_t0_a_n17 n17__t0_a_n17 n17_a_n17 183.071
r_17_t1_a_n17 n17__t1_a_n17 n17_a_n17 183.071
r_18_t0_a_n17 n18__t0_a_n17 n18_a_n17 183.071
r_18_t1_a_n17 n18__t1_a_n17 n18_a_n17 183.071
r_19_t0_a_n17 n19__t0_a_n17 n19_a_n17 183.071
r_19_t1_a_n17 n19__t1_a_n17 n19_a_n17 183.071
r_20_t0_a_n17 n20__t0_a_n17 n20_a_n17 183.071
r_20_t1_a_n17 n20__t1_a_n17 n20_a_n17 183.071
r_22_t0_a_n17 n22__t0_a_n17 n22_a_n17 183.071
r_22_t1_a_n17 n22__t1_a_n17 n22_a_n17 183.071
r_23_t0_a_n17 n23__t0_a_n17 n23_a_n17 183.071
r_23_t1_a_n17 n23__t1_a_n17 n23_a_n17 183.071
r_24_t0_a_n17 n24__t0_a_n17 n24_a_n17 183.071
r_24_t1_a_n17 n24__t1_a_n17 n24_a_n17 183.071
r_25_t0_a_n17 n25__t0_a_n17 n25_a_n17 183.071
r_25_t1_a_n17 n25__t1_a_n17 n25_a_n17 183.071
r_29_t0_a_n17 n29__t0_a_n17 n29_a_n17 183.071
r_29_t1_a_n17 n29__t1_a_n17 n29_a_n17 183.071
r_30_t0_a_n17 n30__t0_a_n17 n30_a_n17 183.071
r_30_t1_a_n17 n30__t1_a_n17 n30_a_n17 183.071
r_31_t0_a_n17 n31__t0_a_n17 n31_a_n17 183.071
r_31_t1_a_n17 n31__t1_a_n17 n31_a_n17 183.071
r_32_t0_a_n17 n32__t0_a_n17 n32_a_n17 183.071
r_32_t1_a_n17 n32__t1_a_n17 n32_a_n17 183.071
r_7_t0_a_n17 n7__t0_a_n17 n7_a_n17 183.071
r_7_t1_a_n17 n7__t1_a_n17 n7_a_n17 183.071
r_8_t0_a_n17 n8__t0_a_n17 n8_a_n17 183.071
r_8_t1_a_n17 n8__t1_a_n17 n8_a_n17 183.071
r_9_t0_a_n17 n9__t0_a_n17 n9_a_n17 183.071
r_9_t1_a_n17 n9__t1_a_n17 n9_a_n17 183.071
rgnd_t0_a_n17 gnd__t0_a_n17 0 38.2988
rgnd_t1_a_n17 gnd__t1_a_n17 0 33.9576
rgnd_t2_a_n17 gnd__t2_a_n17 0 33.9576
rgnd_t3_a_n17 gnd__t3_a_n17 0 38.2988
rgnd_t4_a_n17 gnd__t4_a_n17 0 38.2988
rgnd_t5_a_n17 gnd__t5_a_n17 0 33.9576
rgnd_t6_a_n17 gnd__t6_a_n17 0 33.9576
rgnd_t7_a_n17 gnd__t7_a_n17 0 38.2988
rgnd_t8_a_n17 gnd__t8_a_n17 0 28.0185
rgnd_t9_a_n17 gnd__t9_a_n17 0 21.7106
rgnd_t10_a_n17 gnd__t10_a_n17 0 21.7106
rgnd_t11_a_n17 gnd__t11_a_n17 0 28.0185
rgnd_t12_a_n17 gnd__t12_a_n17 0 18.9833
rgnd_t13_a_n17 gnd__t13_a_n17 0 6.8325
rgnd_t14_a_n17 gnd__t14_a_n17 0 6.8325
rgnd_t15_a_n17 gnd__t15_a_n17 0 18.9833
rgnd_t16_a_n17 gnd__t16_a_n17 0 24.2409
rgnd_t17_a_n17 gnd__t17_a_n17 0 16.5511
rgnd_t18_a_n17 gnd__t18_a_n17 0 16.5511
rgnd_t19_a_n17 gnd__t19_a_n17 0 24.2409
rgnd_t20_a_n17 gnd__t20_a_n17 0 24.2409
rgnd_t21_a_n17 gnd__t21_a_n17 0 16.5511
rgnd_t22_a_n17 gnd__t22_a_n17 0 16.5511
rgnd_t23_a_n17 gnd__t23_a_n17 0 24.2409
rgnd_t24_a_n17 gnd__t24_a_n17 0 18.9833
rgnd_t25_a_n17 gnd__t25_a_n17 0 6.8325
rgnd_t26_a_n17 gnd__t26_a_n17 0 6.8325
rgnd_t27_a_n17 gnd__t27_a_n17 0 18.9833
rgnd_t28_a_n17 gnd__t28_a_n17 0 28.0185
rgnd_t29_a_n17 gnd__t29_a_n17 0 21.7106
rgnd_t30_a_n17 gnd__t30_a_n17 0 21.7106
rgnd_t31_a_n17 gnd__t31_a_n17 0 28.0185
rbl_0_t0_a_n17 bl_0__t0_a_n17 bl_0_a_n17 14.8304
rbl_0_t1_a_n17 bl_0__t1_a_n17 bl_0_a_n17 10.9301
rbl_0_t2_a_n17 bl_0__t2_a_n17 bl_0_a_n17 14.8304
rbl_0_t3_a_n17 bl_0__t3_a_n17 bl_0_a_n17 10.9301
rbl_1_t0_a_n17 bl_1__t0_a_n17 bl_1_a_n17 10.9301
rbl_1_t1_a_n17 bl_1__t1_a_n17 bl_1_a_n17 14.8304
rbl_1_t2_a_n17 bl_1__t2_a_n17 bl_1_a_n17 14.8304
rbl_1_t3_a_n17 bl_1__t3_a_n17 bl_1_a_n17 10.9301
rbl_2_t0_a_n17 bl_2__t0_a_n17 bl_2_a_n17 10.9301
rbl_2_t1_a_n17 bl_2__t1_a_n17 bl_2_a_n17 14.8304
rbl_2_t2_a_n17 bl_2__t2_a_n17 bl_2_a_n17 14.8304
rbl_2_t3_a_n17 bl_2__t3_a_n17 bl_2_a_n17 10.9301
rbl_3_t0_a_n17 bl_3__t0_a_n17 bl_3_a_n17 14.8304
rbl_3_t1_a_n17 bl_3__t1_a_n17 bl_3_a_n17 10.9301
rbl_3_t2_a_n17 bl_3__t2_a_n17 bl_3_a_n17 14.8304
rbl_3_t3_a_n17 bl_3__t3_a_n17 bl_3_a_n17 10.9301
rrbl_0_t0_a_n17 rbl_0__t0_a_n17 rbl_0_a_n17 36.5601
rrbl_0_t1_a_n17 rbl_0__t1_a_n17 rbl_0_a_n17 36.5601
rrbl_0_t2_a_n17 rbl_0__t2_a_n17 rbl_0_a_n17 2.99444
rrbl_0_t3_a_n17 rbl_0__t3_a_n17 rbl_0_a_n17 2.99444
rrbl_1_t0_a_n17 rbl_1__t0_a_n17 rbl_1_a_n17 36.5601
rrbl_1_t1_a_n17 rbl_1__t1_a_n17 rbl_1_a_n17 36.5601
rrbl_1_t2_a_n17 rbl_1__t2_a_n17 rbl_1_a_n17 2.99444
rrbl_1_t3_a_n17 rbl_1__t3_a_n17 rbl_1_a_n17 2.99444
rrbl_2_t0_a_n17 rbl_2__t0_a_n17 rbl_2_a_n17 36.5601
rrbl_2_t1_a_n17 rbl_2__t1_a_n17 rbl_2_a_n17 36.5601
rrbl_2_t2_a_n17 rbl_2__t2_a_n17 rbl_2_a_n17 2.99444
rrbl_2_t3_a_n17 rbl_2__t3_a_n17 rbl_2_a_n17 2.99444
rrbl_3_t0_a_n17 rbl_3__t0_a_n17 rbl_3_a_n17 36.5601
rrbl_3_t1_a_n17 rbl_3__t1_a_n17 rbl_3_a_n17 36.5601
rrbl_3_t2_a_n17 rbl_3__t2_a_n17 rbl_3_a_n17 2.99444
rrbl_3_t3_a_n17 rbl_3__t3_a_n17 rbl_3_a_n17 2.99444
rrwl_0_t0_a_n17 rwl_0__t0_a_n17 rwl_0_a_n17 38.2618
rrwl_0_t1_a_n17 rwl_0__t1_a_n17 rwl_0_a_n17 12.7539
rrwl_0_t2_a_n17 rwl_0__t2_a_n17 rwl_0_a_n17 38.2618
rrwl_0_t3_a_n17 rwl_0__t3_a_n17 rwl_0_a_n17 12.7539
rrwl_1_t0_a_n17 rwl_1__t0_a_n17 rwl_1_a_n17 38.2618
rrwl_1_t1_a_n17 rwl_1__t1_a_n17 rwl_1_a_n17 12.7539
rrwl_1_t2_a_n17 rwl_1__t2_a_n17 rwl_1_a_n17 12.7539
rrwl_1_t3_a_n17 rwl_1__t3_a_n17 rwl_1_a_n17 38.2618
rrwl_2_t0_a_n17 rwl_2__t0_a_n17 rwl_2_a_n17 12.7539
rrwl_2_t1_a_n17 rwl_2__t1_a_n17 rwl_2_a_n17 12.7539
rrwl_2_t2_a_n17 rwl_2__t2_a_n17 rwl_2_a_n17 38.2618
rrwl_2_t3_a_n17 rwl_2__t3_a_n17 rwl_2_a_n17 38.2618
rrwl_3_t0_a_n17 rwl_3__t0_a_n17 rwl_3_a_n17 38.2618
rrwl_3_t1_a_n17 rwl_3__t1_a_n17 rwl_3_a_n17 12.7539
rrwl_3_t2_a_n17 rwl_3__t2_a_n17 rwl_3_a_n17 12.7539
rrwl_3_t3_a_n17 rwl_3__t3_a_n17 rwl_3_a_n17 38.2618
rwl_0_t0_a_n17 wl_0__t0_a_n17 wl_0_a_n17 245.959
rwl_0_t1_a_n17 wl_0__t1_a_n17 wl_0_a_n17 245.959
rwl_0_t2_a_n17 wl_0__t2_a_n17 wl_0_a_n17 81.9864
rwl_0_t3_a_n17 wl_0__t3_a_n17 wl_0_a_n17 81.9864
rwl_1_t0_a_n17 wl_1__t0_a_n17 wl_1_a_n17 245.959
rwl_1_t1_a_n17 wl_1__t1_a_n17 wl_1_a_n17 81.9864
rwl_1_t2_a_n17 wl_1__t2_a_n17 wl_1_a_n17 81.9864
rwl_1_t3_a_n17 wl_1__t3_a_n17 wl_1_a_n17 245.959
rwl_2_t0_a_n17 wl_2__t0_a_n17 wl_2_a_n17 245.959
rwl_2_t1_a_n17 wl_2__t1_a_n17 wl_2_a_n17 81.9864
rwl_2_t2_a_n17 wl_2__t2_a_n17 wl_2_a_n17 81.9864
rwl_2_t3_a_n17 wl_2__t3_a_n17 wl_2_a_n17 245.959
rwl_3_t0_a_n17 wl_3__t0_a_n17 wl_3_a_n17 245.959
rwl_3_t1_a_n17 wl_3__t1_a_n17 wl_3_a_n17 81.9864
rwl_3_t2_a_n17 wl_3__t2_a_n17 wl_3_a_n17 81.9864
rwl_3_t3_a_n17 wl_3__t3_a_n17 wl_3_a_n17 245.959
c_10_a_n17 n10_a_n17 0 2.91622e-16
c_17_a_n17 n17_a_n17 0 2.91528e-16
c_18_a_n17 n18_a_n17 0 2.91528e-16
c_19_a_n17 n19_a_n17 0 2.91528e-16
c_20_a_n17 n20_a_n17 0 2.91622e-16
c_22_a_n17 n22_a_n17 0 2.91528e-16
c_23_a_n17 n23_a_n17 0 2.91528e-16
c_24_a_n17 n24_a_n17 0 2.91528e-16
c_25_a_n17 n25_a_n17 0 2.91622e-16
c_29_a_n17 n29_a_n17 0 2.91528e-16
c_30_a_n17 n30_a_n17 0 2.91528e-16
c_31_a_n17 n31_a_n17 0 2.91528e-16
c_32_a_n17 n32_a_n17 0 2.91622e-16
c_7_a_n17 n7_a_n17 0 2.91528e-16
c_8_a_n17 n8_a_n17 0 2.91528e-16
c_9_a_n17 n9_a_n17 0 2.91528e-16
cgnd_a_n17 0 0 2.48166e-15
cbl_0_a_n17 bl_0_a_n17 0 4.52661e-16
cbl_1_a_n17 bl_1_a_n17 0 4.52661e-16
cbl_2_a_n17 bl_2_a_n17 0 4.52661e-16
cbl_3_a_n17 bl_3_a_n17 0 4.52661e-16
crbl_0_a_n17 rbl_0_a_n17 0 9.14472e-16
crbl_1_a_n17 rbl_1_a_n17 0 9.14472e-16
crbl_2_a_n17 rbl_2_a_n17 0 9.14472e-16
crbl_3_a_n17 rbl_3_a_n17 0 9.17566e-16
crwl_0_a_n17 rwl_0_a_n17 0 5.19495e-16
crwl_1_a_n17 rwl_1_a_n17 0 5.11719e-16
crwl_2_a_n17 rwl_2_a_n17 0 5.11719e-16
crwl_3_a_n17 rwl_3_a_n17 0 5.19495e-16
cwl_0_a_n17 wl_0_a_n17 0 3.30388e-16
cwl_1_a_n17 wl_1_a_n17 0 3.30388e-16
cwl_2_a_n17 wl_2_a_n17 0 3.30388e-16
cwl_3_a_n17 wl_3_a_n17 0 3.30388e-16
ccc__10__9_a_n17 n10_a_n17 n9_a_n17 1.02e-17
ccc__10_bl_3_a_n17 n10_a_n17 bl_3_a_n17 1.3999e-17
ccc__10_rwl_0_a_n17 n10_a_n17 rwl_0_a_n17 4.335e-18
ccc__17__18_a_n17 n17_a_n17 n18_a_n17 1.02e-17
ccc__17_bl_0_a_n17 n17_a_n17 bl_0_a_n17 8.415e-18
ccc__17_rwl_1_a_n17 n17_a_n17 rwl_1_a_n17 1.3194e-17
ccc__18__19_a_n17 n18_a_n17 n19_a_n17 1.02e-17
ccc__18_bl_1_a_n17 n18_a_n17 bl_1_a_n17 8.415e-18
ccc__18_rwl_1_a_n17 n18_a_n17 rwl_1_a_n17 1.3194e-17
ccc__19__20_a_n17 n19_a_n17 n20_a_n17 1.02e-17
ccc__19_bl_2_a_n17 n19_a_n17 bl_2_a_n17 8.415e-18
ccc__19_rwl_1_a_n17 n19_a_n17 rwl_1_a_n17 1.3194e-17
ccc__20_bl_3_a_n17 n20_a_n17 bl_3_a_n17 8.415e-18
ccc__20_rwl_1_a_n17 n20_a_n17 rwl_1_a_n17 6.655e-18
ccc__22__23_a_n17 n22_a_n17 n23_a_n17 1.02e-17
ccc__22_bl_0_a_n17 n22_a_n17 bl_0_a_n17 8.415e-18
ccc__22_rwl_2_a_n17 n22_a_n17 rwl_2_a_n17 1.3194e-17
ccc__23__24_a_n17 n23_a_n17 n24_a_n17 1.02e-17
ccc__23_bl_1_a_n17 n23_a_n17 bl_1_a_n17 8.415e-18
ccc__23_rwl_2_a_n17 n23_a_n17 rwl_2_a_n17 1.3194e-17
ccc__24__25_a_n17 n24_a_n17 n25_a_n17 1.02e-17
ccc__24_bl_2_a_n17 n24_a_n17 bl_2_a_n17 8.415e-18
ccc__24_rwl_2_a_n17 n24_a_n17 rwl_2_a_n17 1.3194e-17
ccc__25_bl_3_a_n17 n25_a_n17 bl_3_a_n17 8.415e-18
ccc__25_rwl_2_a_n17 n25_a_n17 rwl_2_a_n17 6.655e-18
ccc__29__30_a_n17 n29_a_n17 n30_a_n17 1.02e-17
ccc__29_bl_0_a_n17 n29_a_n17 bl_0_a_n17 8.415e-18
ccc__29_rwl_3_a_n17 n29_a_n17 rwl_3_a_n17 1.3194e-17
ccc__30__31_a_n17 n30_a_n17 n31_a_n17 1.02e-17
ccc__30_bl_1_a_n17 n30_a_n17 bl_1_a_n17 8.415e-18
ccc__30_rwl_3_a_n17 n30_a_n17 rwl_3_a_n17 1.3194e-17
ccc__31__32_a_n17 n31_a_n17 n32_a_n17 1.02e-17
ccc__31_bl_2_a_n17 n31_a_n17 bl_2_a_n17 8.415e-18
ccc__31_rwl_3_a_n17 n31_a_n17 rwl_3_a_n17 1.3194e-17
ccc__32_bl_3_a_n17 n32_a_n17 bl_3_a_n17 8.415e-18
ccc__32_rwl_3_a_n17 n32_a_n17 rwl_3_a_n17 6.655e-18
ccc__7__8_a_n17 n7_a_n17 n8_a_n17 1.02e-17
ccc__7_bl_0_a_n17 n7_a_n17 bl_0_a_n17 1.3999e-17
ccc__7_rwl_0_a_n17 n7_a_n17 rwl_0_a_n17 8.961e-18
ccc__8__9_a_n17 n8_a_n17 n9_a_n17 1.02e-17
ccc__8_bl_1_a_n17 n8_a_n17 bl_1_a_n17 1.3999e-17
ccc__8_rwl_0_a_n17 n8_a_n17 rwl_0_a_n17 8.961e-18
ccc__9_bl_2_a_n17 n9_a_n17 bl_2_a_n17 1.3999e-17
ccc__9_rwl_0_a_n17 n9_a_n17 rwl_0_a_n17 8.961e-18
ccc_bl_0_rbl_0_a_n17 bl_0_a_n17 rbl_0_a_n17 1.88693e-16
ccc_bl_0_rwl_1_a_n17 bl_0_a_n17 rwl_1_a_n17 1.0093e-17
ccc_bl_0_rwl_2_a_n17 bl_0_a_n17 rwl_2_a_n17 1.0093e-17
ccc_bl_1_rbl_0_a_n17 bl_1_a_n17 rbl_0_a_n17 1.633e-16
ccc_bl_1_rbl_1_a_n17 bl_1_a_n17 rbl_1_a_n17 1.88693e-16
ccc_bl_1_rwl_1_a_n17 bl_1_a_n17 rwl_1_a_n17 1.0093e-17
ccc_bl_1_rwl_2_a_n17 bl_1_a_n17 rwl_2_a_n17 1.0093e-17
ccc_bl_2_rbl_1_a_n17 bl_2_a_n17 rbl_1_a_n17 1.633e-16
ccc_bl_2_rbl_2_a_n17 bl_2_a_n17 rbl_2_a_n17 1.88693e-16
ccc_bl_2_rwl_1_a_n17 bl_2_a_n17 rwl_1_a_n17 1.0093e-17
ccc_bl_2_rwl_2_a_n17 bl_2_a_n17 rwl_2_a_n17 1.0093e-17
ccc_bl_3_rbl_2_a_n17 bl_3_a_n17 rbl_2_a_n17 1.633e-16
ccc_bl_3_rbl_3_a_n17 bl_3_a_n17 rbl_3_a_n17 1.88693e-16
ccc_bl_3_rwl_1_a_n17 bl_3_a_n17 rwl_1_a_n17 1.0093e-17
ccc_bl_3_rwl_2_a_n17 bl_3_a_n17 rwl_2_a_n17 1.0093e-17
ccc_rbl_0_rbl_1_a_n17 rbl_0_a_n17 rbl_1_a_n17 3.432e-17
ccc_rbl_0_rwl_0_a_n17 rbl_0_a_n17 rwl_0_a_n17 4.9752e-17
ccc_rbl_0_rwl_1_a_n17 rbl_0_a_n17 rwl_1_a_n17 4.9752e-17
ccc_rbl_0_rwl_2_a_n17 rbl_0_a_n17 rwl_2_a_n17 4.9752e-17
ccc_rbl_0_rwl_3_a_n17 rbl_0_a_n17 rwl_3_a_n17 4.9752e-17
ccc_rbl_1_rbl_2_a_n17 rbl_1_a_n17 rbl_2_a_n17 3.432e-17
ccc_rbl_1_rwl_0_a_n17 rbl_1_a_n17 rwl_0_a_n17 4.9752e-17
ccc_rbl_1_rwl_1_a_n17 rbl_1_a_n17 rwl_1_a_n17 4.9752e-17
ccc_rbl_1_rwl_2_a_n17 rbl_1_a_n17 rwl_2_a_n17 4.9752e-17
ccc_rbl_1_rwl_3_a_n17 rbl_1_a_n17 rwl_3_a_n17 4.9752e-17
ccc_rbl_2_rbl_3_a_n17 rbl_2_a_n17 rbl_3_a_n17 3.432e-17
ccc_rbl_2_rwl_0_a_n17 rbl_2_a_n17 rwl_0_a_n17 4.9752e-17
ccc_rbl_2_rwl_1_a_n17 rbl_2_a_n17 rwl_1_a_n17 4.9752e-17
ccc_rbl_2_rwl_2_a_n17 rbl_2_a_n17 rwl_2_a_n17 4.9752e-17
ccc_rbl_2_rwl_3_a_n17 rbl_2_a_n17 rwl_3_a_n17 4.9752e-17
ccc_rbl_3_rwl_0_a_n17 rbl_3_a_n17 rwl_0_a_n17 3.3407e-17
ccc_rbl_3_rwl_1_a_n17 rbl_3_a_n17 rwl_1_a_n17 3.3407e-17
ccc_rbl_3_rwl_2_a_n17 rbl_3_a_n17 rwl_2_a_n17 3.3407e-17
ccc_rbl_3_rwl_3_a_n17 rbl_3_a_n17 rwl_3_a_n17 3.3407e-17
vdw_a_n17_0 wl_0_a_n17 0 dc 0
vdr_a_n17_0 rwl_0_a_n17 vdd dc 0
vdw_a_n17_1 wl_1_a_n17 0 dc 0
vdr_a_n17_1 rwl_1_a_n17 vdd dc 0
vdw_a_n17_2 wl_2_a_n17 0 dc 0
vdr_a_n17_2 rwl_2_a_n17 vdd dc 0
vdw_a_n17_3 wl_3_a_n17 0 dc 0
vdr_a_n17_3 rwl_3_a_n17 vdd dc 0
vdb_a_n17_0 bl_0_a_n17 0 dc 0
vdp_a_n17_0 rbl_0_a_n17 vrbl dc 0
vdb_a_n17_1 bl_1_a_n17 0 dc 0
vdp_a_n17_1 rbl_1_a_n17 vrbl dc 0
vdb_a_n17_2 bl_2_a_n17 0 dc 0
vdp_a_n17_2 rbl_2_a_n17 vrbl dc 0
vdb_a_n17_3 bl_3_a_n17 0 dc 0
vdp_a_n17_3 rbl_3_a_n17 vrbl dc 0
vdn_a_n17_n7 n7_a_n17 0 dc 1
vdn_a_n17_n8 n8_a_n17 0 dc 1
vdn_a_n17_n9 n9_a_n17 0 dc 1
vdn_a_n17_n10 n10_a_n17 0 dc 1
vdn_a_n17_n18 n18_a_n17 0 dc 1
vdn_a_n17_n19 n19_a_n17 0 dc 1
vdn_a_n17_n20 n20_a_n17 0 dc 1
vdn_a_n17_n22 n22_a_n17 0 dc 1
vdn_a_n17_n23 n23_a_n17 0 dc 1
vdn_a_n17_n24 n24_a_n17 0 dc 1
vdn_a_n17_n25 n25_a_n17 0 dc 1
vdn_a_n17_n29 n29_a_n17 0 dc 1
vdn_a_n17_n30 n30_a_n17 0 dc 1
vdn_a_n17_n31 n31_a_n17 0 dc 1
vdn_a_n17_n32 n32_a_n17 0 dc 1
bdr_a_n17 n17_a_n17 0 i=5e-08*min(1,max(0,(time-1e-09)/0.2n))*0.5*(1+tanh((v(n17_a_n17)-0.05)/0.01))

* ---- instance a_n18: variant a, probed storage node \$18 ----
xm1_a_n18 rwl_0__t2_a_n18 n7__t0_a_n18 rbl_0__t0_a_n18 gnd__t0_a_n18 sky130_fd_pr__nfet_01v8 L=0.15 W=0.42 nf=1 ad=0.1197 as=0.1197 pd=1.41 ps=1.41 mult=1 m=1
xm2_a_n18 rwl_0__t3_a_n18 n8__t1_a_n18 rbl_1__t1_a_n18 gnd__t1_a_n18 sky130_fd_pr__nfet_01v8 L=0.15 W=0.42 nf=1 ad=0.1197 as=0.1197 pd=1.41 ps=1.41 mult=1 m=1
xm3_a_n18 rwl_0__t1_a_n18 n9__t1_a_n18 rbl_2__t1_a_n18 gnd__t2_a_n18 sky130_fd_pr__nfet_01v8 L=0.15 W=0.42 nf=1 ad=0.1197 as=0.1197 pd=1.41 ps=1.41 mult=1 m=1
xm4_a_n18 rwl_0__t0_a_n18 n10__t1_a_n18 rbl_3__t1_a_n18 gnd__t3_a_n18 sky130_fd_pr__nfet_01v8 L=0.15 W=0.42 nf=1 ad=0.1197 as=0.1197 pd=1.41 ps=1.41 mult=1 m=1
xm5_a_n18 bl_0__t0_a_n18 wl_0__t0_a_n18 n7__t1_a_n18 gnd__t8_a_n18 sky130_fd_pr__nfet_01v8 L=0.15 W=0.42 nf=1 ad=0.0588 as=0.1197 pd=0.7 ps=1.41 mult=1 m=1
xm6_a_n18 n17__t0_a_n18 wl_1__t0_a_n18 bl_0__t1_a_n18 gnd__t20_a_n18 sky130_fd_pr__nfet_01v8 L=0.15 W=0.42 nf=1 ad=0.1197 as=0.0588 pd=1.41 ps=0.7 mult=1 m=1
xm7_a_n18 bl_1__t2_a_n18 wl_0__t3_a_n18 n8__t0_a_n18 gnd__t9_a_n18 sky130_fd_pr__nfet_01v8 L=0.15 W=0.42 nf=1 ad=0.0588 as=0.1197 pd=0.7 ps=1.41 mult=1 m=1
xm8_a_n18 n18__t0_a_n18 wl_1__t1_a_n18 bl_1__t0_a_n18 gnd__t21_a_n18 sky130_fd_pr__nfet_01v8 L=0.15 W=0.42 nf=1 ad=0.1197 as=0.0588 pd=1.41 ps=0.7 mult=1 m=1
xm9_a_n18 bl_2__t2_a_n18 wl_0__t2_a_n18 n9__t0_a_n18 gnd__t10_a_n18 sky130_fd_pr__nfet_01v8 L=0.15 W=0.42 nf=1 ad=0.0588 as=0.1197 pd=0.7 ps=1.41 mult=1 m=1
xm10_a_n18 n19__t0_a_n18 wl_1__t2_a_n18 bl_2__t0_a_n18 gnd__t22_a_n18 sky130_fd_pr__nfet_01v8 L=0.15 W=0.42 nf=1 ad=0.1197 as=0.0588 pd=1.41 ps=0.7 mult=1 m=1
xm11_a_n18 bl_3__t2_a_n18 wl_0__t1_a_n18 n10__t0_a_n18 gnd__t11_a_n18 sky130_fd_pr__nfet_01v8 L=0.15 W=0.42 nf=1 ad=0.0588 as=0.1197 pd=0.7 ps=1.41 mult=1 m=1
xm12_a_n18 n20__t0_a_n18 wl_1__t3_a_n18 bl_3__t1_a_n18 gnd__t23_a_n18 sky130_fd_pr__nfet_01v8 L=0.15 W=0.42 nf=1 ad=0.1197 as=0.0588 pd=1.41 ps=0.7 mult=1 m=1
xm13_a_n18 rbl_0__t3_a_n18 n17__t1_a_n18 rwl_1__t0_a_n18 gnd__t12_a_n18 sky130_fd_pr__nfet_01v8 L=0.15 W=0.42 nf=1 ad=0.0588 as=0.1197 pd=0.7 ps=1.41 mult=1 m=1
xm14_a_n18 rwl_2__t3_a_n18 n22__t0_a_n18 rbl_0__t2_a_n18 gnd__t24_a_n18 sky130_fd_pr__nfet_01v8 L=0.15 W=0.42 nf=1 ad=0.1197 as=0.0588 pd=1.41 ps=0.7 mult=1 m=1
xm15_a_n18 rbl_1__t3_a_n18 n18__t1_a_n18 rwl_1__t1_a_n18 gnd__t13_a_n18 sky130_fd_pr__nfet_01v8 L=0.15 W=0.42 nf=1 ad=0.0588 as=0.1197 pd=0.7 ps=1.41 mult=1 m=1
xm16_a_n18 rwl_2__t0_a_n18 n23__t0_a_n18 rbl_1__t2_a_n18 gnd__t25_a_n18 sky130_fd_pr__nfet_01v8 L=0.15 W=0.42 nf=1 ad=0.1197 as=0.0588 pd=1.41 ps=0.7 mult=1 m=1
xm17_a_n18 rbl_2__t3_a_n18 n19__t1_a_n18 rwl_1__t2_a_n18 gnd__t14_a_n18 sky130_fd_pr__nfet_01v8 L=0.15 W=0.42 nf=1 ad=0.0588 as=0.1197 pd=0.7 ps=1.41 mult=1 m=1
xm18_a_n18 rwl_2__t1_a_n18 n24__t0_a_n18 rbl_2__t2_a_n18 gnd__t26_a_n18 sky130_fd_pr__nfet_01v8 L=0.15 W=0.42 nf=1 ad=0.1197 as=0.0588 pd=1.41 ps=0.7 mult=1 m=1
xm19_a_n18 rbl_3__t3_a_n18 n20__t1_a_n18 rwl_1__t3_a_n18 gnd__t15_a_n18 sky130_fd_pr__nfet_01v8 L=0.15 W=0.42 nf=1 ad=0.0588 as=0.1197 pd=0.7 ps=1.41 mult=1 m=1
xm20_a_n18 rwl_2__t2_a_n18 n25__t0_a_n18 rbl_3__t2_a_n18 gnd__t27_a_n18 sky130_fd_pr__nfet_01v8 L=0.15 W=0.42 nf=1 ad=0.1197 as=0.0588 pd=1.41 ps=0.7 mult=1 m=1
xm21_a_n18 bl_0__t3_a_n18 wl_2__t0_a_n18 n22__t1_a_n18 gnd__t16_a_n18 sky130_fd_pr__nfet_01v8 L=0.15 W=0.42 nf=1 ad=0.0588 as=0.1197 pd=0.7 ps=1.41 mult=1 m=1
xm22_a_n18 n29__t0_a_n18 wl_3__t3_a_n18 bl_0__t2_a_n18 gnd__t28_a_n18 sky130_fd_pr__nfet_01v8 L=0.15 W=0.42 nf=1 ad=0.1197 as=0.0588 pd=1.41 ps=0.7 mult=1 m=1
xm23_a_n18 bl_1__t3_a_n18 wl_2__t1_a_n18 n23__t1_a_n18 gnd__t17_a_n18 sky130_fd_pr__nfet_01v8 L=0.15 W=0.42 nf=1 ad=0.0588 as=0.1197 pd=0.7 ps=1.41 mult=1 m=1
xm24_a_n18 n30__t0_a_n18 wl_3__t2_a_n18 bl_1__t1_a_n18 gnd__t29_a_n18 sky130_fd_pr__nfet_01v8 L=0.15 W=0.42 nf=1 ad=0.1197 as=0.0588 pd=1.41 ps=0.7 mult=1 m=1
xm25_a_n18 bl_2__t3_a_n18 wl_2__t2_a_n18 n24__t1_a_n18 gnd__t18_a_n18 sky130_fd_pr__nfet_01v8 L=0.15 W=0.42 nf=1 ad=0.0588 as=0.1197 pd=0.7 ps=1.41 mult=1 m=1
xm26_a_n18 n31__t0_a_n18 wl_3__t1_a_n18 bl_2__t1_a_n18 gnd__t30_a_n18 sky130_fd_pr__nfet_01v8 L=0.15 W=0.42 nf=1 ad=0.1197 as=0.0588 pd=1.41 ps=0.7 mult=1 m=1
xm27_a_n18 bl_3__t3_a_n18 wl_2__t3_a_n18 n25__t1_a_n18 gnd__t19_a_n18 sky130_fd_pr__nfet_01v8 L=0.15 W=0.42 nf=1 ad=0.0588 as=0.1197 pd=0.7 ps=1.41 mult=1 m=1
xm28_a_n18 n32__t0_a_n18 wl_3__t0_a_n18 bl_3__t0_a_n18 gnd__t31_a_n18 sky130_fd_pr__nfet_01v8 L=0.15 W=0.42 nf=1 ad=0.1197 as=0.0588 pd=1.41 ps=0.7 mult=1 m=1
xm29_a_n18 rbl_0__t1_a_n18 n29__t1_a_n18 rwl_3__t0_a_n18 gnd__t4_a_n18 sky130_fd_pr__nfet_01v8 L=0.15 W=0.42 nf=1 ad=0.1197 as=0.1197 pd=1.41 ps=1.41 mult=1 m=1
xm30_a_n18 rbl_1__t0_a_n18 n30__t1_a_n18 rwl_3__t1_a_n18 gnd__t5_a_n18 sky130_fd_pr__nfet_01v8 L=0.15 W=0.42 nf=1 ad=0.1197 as=0.1197 pd=1.41 ps=1.41 mult=1 m=1
xm31_a_n18 rbl_2__t0_a_n18 n31__t1_a_n18 rwl_3__t2_a_n18 gnd__t6_a_n18 sky130_fd_pr__nfet_01v8 L=0.15 W=0.42 nf=1 ad=0.1197 as=0.1197 pd=1.41 ps=1.41 mult=1 m=1
xm32_a_n18 rbl_3__t0_a_n18 n32__t1_a_n18 rwl_3__t3_a_n18 gnd__t7_a_n18 sky130_fd_pr__nfet_01v8 L=0.15 W=0.42 nf=1 ad=0.1197 as=0.1197 pd=1.41 ps=1.41 mult=1 m=1
r_10_t0_a_n18 n10__t0_a_n18 n10_a_n18 183.071
r_10_t1_a_n18 n10__t1_a_n18 n10_a_n18 183.071
r_17_t0_a_n18 n17__t0_a_n18 n17_a_n18 183.071
r_17_t1_a_n18 n17__t1_a_n18 n17_a_n18 183.071
r_18_t0_a_n18 n18__t0_a_n18 n18_a_n18 183.071
r_18_t1_a_n18 n18__t1_a_n18 n18_a_n18 183.071
r_19_t0_a_n18 n19__t0_a_n18 n19_a_n18 183.071
r_19_t1_a_n18 n19__t1_a_n18 n19_a_n18 183.071
r_20_t0_a_n18 n20__t0_a_n18 n20_a_n18 183.071
r_20_t1_a_n18 n20__t1_a_n18 n20_a_n18 183.071
r_22_t0_a_n18 n22__t0_a_n18 n22_a_n18 183.071
r_22_t1_a_n18 n22__t1_a_n18 n22_a_n18 183.071
r_23_t0_a_n18 n23__t0_a_n18 n23_a_n18 183.071
r_23_t1_a_n18 n23__t1_a_n18 n23_a_n18 183.071
r_24_t0_a_n18 n24__t0_a_n18 n24_a_n18 183.071
r_24_t1_a_n18 n24__t1_a_n18 n24_a_n18 183.071
r_25_t0_a_n18 n25__t0_a_n18 n25_a_n18 183.071
r_25_t1_a_n18 n25__t1_a_n18 n25_a_n18 183.071
r_29_t0_a_n18 n29__t0_a_n18 n29_a_n18 183.071
r_29_t1_a_n18 n29__t1_a_n18 n29_a_n18 183.071
r_30_t0_a_n18 n30__t0_a_n18 n30_a_n18 183.071
r_30_t1_a_n18 n30__t1_a_n18 n30_a_n18 183.071
r_31_t0_a_n18 n31__t0_a_n18 n31_a_n18 183.071
r_31_t1_a_n18 n31__t1_a_n18 n31_a_n18 183.071
r_32_t0_a_n18 n32__t0_a_n18 n32_a_n18 183.071
r_32_t1_a_n18 n32__t1_a_n18 n32_a_n18 183.071
r_7_t0_a_n18 n7__t0_a_n18 n7_a_n18 183.071
r_7_t1_a_n18 n7__t1_a_n18 n7_a_n18 183.071
r_8_t0_a_n18 n8__t0_a_n18 n8_a_n18 183.071
r_8_t1_a_n18 n8__t1_a_n18 n8_a_n18 183.071
r_9_t0_a_n18 n9__t0_a_n18 n9_a_n18 183.071
r_9_t1_a_n18 n9__t1_a_n18 n9_a_n18 183.071
rgnd_t0_a_n18 gnd__t0_a_n18 0 38.2988
rgnd_t1_a_n18 gnd__t1_a_n18 0 33.9576
rgnd_t2_a_n18 gnd__t2_a_n18 0 33.9576
rgnd_t3_a_n18 gnd__t3_a_n18 0 38.2988
rgnd_t4_a_n18 gnd__t4_a_n18 0 38.2988
rgnd_t5_a_n18 gnd__t5_a_n18 0 33.9576
rgnd_t6_a_n18 gnd__t6_a_n18 0 33.9576
rgnd_t7_a_n18 gnd__t7_a_n18 0 38.2988
rgnd_t8_a_n18 gnd__t8_a_n18 0 28.0185
rgnd_t9_a_n18 gnd__t9_a_n18 0 21.7106
rgnd_t10_a_n18 gnd__t10_a_n18 0 21.7106
rgnd_t11_a_n18 gnd__t11_a_n18 0 28.0185
rgnd_t12_a_n18 gnd__t12_a_n18 0 18.9833
rgnd_t13_a_n18 gnd__t13_a_n18 0 6.8325
rgnd_t14_a_n18 gnd__t14_a_n18 0 6.8325
rgnd_t15_a_n18 gnd__t15_a_n18 0 18.9833
rgnd_t16_a_n18 gnd__t16_a_n18 0 24.2409
rgnd_t17_a_n18 gnd__t17_a_n18 0 16.5511
rgnd_t18_a_n18 gnd__t18_a_n18 0 16.5511
rgnd_t19_a_n18 gnd__t19_a_n18 0 24.2409
rgnd_t20_a_n18 gnd__t20_a_n18 0 24.2409
rgnd_t21_a_n18 gnd__t21_a_n18 0 16.5511
rgnd_t22_a_n18 gnd__t22_a_n18 0 16.5511
rgnd_t23_a_n18 gnd__t23_a_n18 0 24.2409
rgnd_t24_a_n18 gnd__t24_a_n18 0 18.9833
rgnd_t25_a_n18 gnd__t25_a_n18 0 6.8325
rgnd_t26_a_n18 gnd__t26_a_n18 0 6.8325
rgnd_t27_a_n18 gnd__t27_a_n18 0 18.9833
rgnd_t28_a_n18 gnd__t28_a_n18 0 28.0185
rgnd_t29_a_n18 gnd__t29_a_n18 0 21.7106
rgnd_t30_a_n18 gnd__t30_a_n18 0 21.7106
rgnd_t31_a_n18 gnd__t31_a_n18 0 28.0185
rbl_0_t0_a_n18 bl_0__t0_a_n18 bl_0_a_n18 14.8304
rbl_0_t1_a_n18 bl_0__t1_a_n18 bl_0_a_n18 10.9301
rbl_0_t2_a_n18 bl_0__t2_a_n18 bl_0_a_n18 14.8304
rbl_0_t3_a_n18 bl_0__t3_a_n18 bl_0_a_n18 10.9301
rbl_1_t0_a_n18 bl_1__t0_a_n18 bl_1_a_n18 10.9301
rbl_1_t1_a_n18 bl_1__t1_a_n18 bl_1_a_n18 14.8304
rbl_1_t2_a_n18 bl_1__t2_a_n18 bl_1_a_n18 14.8304
rbl_1_t3_a_n18 bl_1__t3_a_n18 bl_1_a_n18 10.9301
rbl_2_t0_a_n18 bl_2__t0_a_n18 bl_2_a_n18 10.9301
rbl_2_t1_a_n18 bl_2__t1_a_n18 bl_2_a_n18 14.8304
rbl_2_t2_a_n18 bl_2__t2_a_n18 bl_2_a_n18 14.8304
rbl_2_t3_a_n18 bl_2__t3_a_n18 bl_2_a_n18 10.9301
rbl_3_t0_a_n18 bl_3__t0_a_n18 bl_3_a_n18 14.8304
rbl_3_t1_a_n18 bl_3__t1_a_n18 bl_3_a_n18 10.9301
rbl_3_t2_a_n18 bl_3__t2_a_n18 bl_3_a_n18 14.8304
rbl_3_t3_a_n18 bl_3__t3_a_n18 bl_3_a_n18 10.9301
rrbl_0_t0_a_n18 rbl_0__t0_a_n18 rbl_0_a_n18 36.5601
rrbl_0_t1_a_n18 rbl_0__t1_a_n18 rbl_0_a_n18 36.5601
rrbl_0_t2_a_n18 rbl_0__t2_a_n18 rbl_0_a_n18 2.99444
rrbl_0_t3_a_n18 rbl_0__t3_a_n18 rbl_0_a_n18 2.99444
rrbl_1_t0_a_n18 rbl_1__t0_a_n18 rbl_1_a_n18 36.5601
rrbl_1_t1_a_n18 rbl_1__t1_a_n18 rbl_1_a_n18 36.5601
rrbl_1_t2_a_n18 rbl_1__t2_a_n18 rbl_1_a_n18 2.99444
rrbl_1_t3_a_n18 rbl_1__t3_a_n18 rbl_1_a_n18 2.99444
rrbl_2_t0_a_n18 rbl_2__t0_a_n18 rbl_2_a_n18 36.5601
rrbl_2_t1_a_n18 rbl_2__t1_a_n18 rbl_2_a_n18 36.5601
rrbl_2_t2_a_n18 rbl_2__t2_a_n18 rbl_2_a_n18 2.99444
rrbl_2_t3_a_n18 rbl_2__t3_a_n18 rbl_2_a_n18 2.99444
rrbl_3_t0_a_n18 rbl_3__t0_a_n18 rbl_3_a_n18 36.5601
rrbl_3_t1_a_n18 rbl_3__t1_a_n18 rbl_3_a_n18 36.5601
rrbl_3_t2_a_n18 rbl_3__t2_a_n18 rbl_3_a_n18 2.99444
rrbl_3_t3_a_n18 rbl_3__t3_a_n18 rbl_3_a_n18 2.99444
rrwl_0_t0_a_n18 rwl_0__t0_a_n18 rwl_0_a_n18 38.2618
rrwl_0_t1_a_n18 rwl_0__t1_a_n18 rwl_0_a_n18 12.7539
rrwl_0_t2_a_n18 rwl_0__t2_a_n18 rwl_0_a_n18 38.2618
rrwl_0_t3_a_n18 rwl_0__t3_a_n18 rwl_0_a_n18 12.7539
rrwl_1_t0_a_n18 rwl_1__t0_a_n18 rwl_1_a_n18 38.2618
rrwl_1_t1_a_n18 rwl_1__t1_a_n18 rwl_1_a_n18 12.7539
rrwl_1_t2_a_n18 rwl_1__t2_a_n18 rwl_1_a_n18 12.7539
rrwl_1_t3_a_n18 rwl_1__t3_a_n18 rwl_1_a_n18 38.2618
rrwl_2_t0_a_n18 rwl_2__t0_a_n18 rwl_2_a_n18 12.7539
rrwl_2_t1_a_n18 rwl_2__t1_a_n18 rwl_2_a_n18 12.7539
rrwl_2_t2_a_n18 rwl_2__t2_a_n18 rwl_2_a_n18 38.2618
rrwl_2_t3_a_n18 rwl_2__t3_a_n18 rwl_2_a_n18 38.2618
rrwl_3_t0_a_n18 rwl_3__t0_a_n18 rwl_3_a_n18 38.2618
rrwl_3_t1_a_n18 rwl_3__t1_a_n18 rwl_3_a_n18 12.7539
rrwl_3_t2_a_n18 rwl_3__t2_a_n18 rwl_3_a_n18 12.7539
rrwl_3_t3_a_n18 rwl_3__t3_a_n18 rwl_3_a_n18 38.2618
rwl_0_t0_a_n18 wl_0__t0_a_n18 wl_0_a_n18 245.959
rwl_0_t1_a_n18 wl_0__t1_a_n18 wl_0_a_n18 245.959
rwl_0_t2_a_n18 wl_0__t2_a_n18 wl_0_a_n18 81.9864
rwl_0_t3_a_n18 wl_0__t3_a_n18 wl_0_a_n18 81.9864
rwl_1_t0_a_n18 wl_1__t0_a_n18 wl_1_a_n18 245.959
rwl_1_t1_a_n18 wl_1__t1_a_n18 wl_1_a_n18 81.9864
rwl_1_t2_a_n18 wl_1__t2_a_n18 wl_1_a_n18 81.9864
rwl_1_t3_a_n18 wl_1__t3_a_n18 wl_1_a_n18 245.959
rwl_2_t0_a_n18 wl_2__t0_a_n18 wl_2_a_n18 245.959
rwl_2_t1_a_n18 wl_2__t1_a_n18 wl_2_a_n18 81.9864
rwl_2_t2_a_n18 wl_2__t2_a_n18 wl_2_a_n18 81.9864
rwl_2_t3_a_n18 wl_2__t3_a_n18 wl_2_a_n18 245.959
rwl_3_t0_a_n18 wl_3__t0_a_n18 wl_3_a_n18 245.959
rwl_3_t1_a_n18 wl_3__t1_a_n18 wl_3_a_n18 81.9864
rwl_3_t2_a_n18 wl_3__t2_a_n18 wl_3_a_n18 81.9864
rwl_3_t3_a_n18 wl_3__t3_a_n18 wl_3_a_n18 245.959
c_10_a_n18 n10_a_n18 0 2.91622e-16
c_17_a_n18 n17_a_n18 0 2.91528e-16
c_18_a_n18 n18_a_n18 0 2.91528e-16
c_19_a_n18 n19_a_n18 0 2.91528e-16
c_20_a_n18 n20_a_n18 0 2.91622e-16
c_22_a_n18 n22_a_n18 0 2.91528e-16
c_23_a_n18 n23_a_n18 0 2.91528e-16
c_24_a_n18 n24_a_n18 0 2.91528e-16
c_25_a_n18 n25_a_n18 0 2.91622e-16
c_29_a_n18 n29_a_n18 0 2.91528e-16
c_30_a_n18 n30_a_n18 0 2.91528e-16
c_31_a_n18 n31_a_n18 0 2.91528e-16
c_32_a_n18 n32_a_n18 0 2.91622e-16
c_7_a_n18 n7_a_n18 0 2.91528e-16
c_8_a_n18 n8_a_n18 0 2.91528e-16
c_9_a_n18 n9_a_n18 0 2.91528e-16
cgnd_a_n18 0 0 2.48166e-15
cbl_0_a_n18 bl_0_a_n18 0 4.52661e-16
cbl_1_a_n18 bl_1_a_n18 0 4.52661e-16
cbl_2_a_n18 bl_2_a_n18 0 4.52661e-16
cbl_3_a_n18 bl_3_a_n18 0 4.52661e-16
crbl_0_a_n18 rbl_0_a_n18 0 9.14472e-16
crbl_1_a_n18 rbl_1_a_n18 0 9.14472e-16
crbl_2_a_n18 rbl_2_a_n18 0 9.14472e-16
crbl_3_a_n18 rbl_3_a_n18 0 9.17566e-16
crwl_0_a_n18 rwl_0_a_n18 0 5.19495e-16
crwl_1_a_n18 rwl_1_a_n18 0 5.11719e-16
crwl_2_a_n18 rwl_2_a_n18 0 5.11719e-16
crwl_3_a_n18 rwl_3_a_n18 0 5.19495e-16
cwl_0_a_n18 wl_0_a_n18 0 3.30388e-16
cwl_1_a_n18 wl_1_a_n18 0 3.30388e-16
cwl_2_a_n18 wl_2_a_n18 0 3.30388e-16
cwl_3_a_n18 wl_3_a_n18 0 3.30388e-16
ccc__10__9_a_n18 n10_a_n18 n9_a_n18 1.02e-17
ccc__10_bl_3_a_n18 n10_a_n18 bl_3_a_n18 1.3999e-17
ccc__10_rwl_0_a_n18 n10_a_n18 rwl_0_a_n18 4.335e-18
ccc__17__18_a_n18 n17_a_n18 n18_a_n18 1.02e-17
ccc__17_bl_0_a_n18 n17_a_n18 bl_0_a_n18 8.415e-18
ccc__17_rwl_1_a_n18 n17_a_n18 rwl_1_a_n18 1.3194e-17
ccc__18__19_a_n18 n18_a_n18 n19_a_n18 1.02e-17
ccc__18_bl_1_a_n18 n18_a_n18 bl_1_a_n18 8.415e-18
ccc__18_rwl_1_a_n18 n18_a_n18 rwl_1_a_n18 1.3194e-17
ccc__19__20_a_n18 n19_a_n18 n20_a_n18 1.02e-17
ccc__19_bl_2_a_n18 n19_a_n18 bl_2_a_n18 8.415e-18
ccc__19_rwl_1_a_n18 n19_a_n18 rwl_1_a_n18 1.3194e-17
ccc__20_bl_3_a_n18 n20_a_n18 bl_3_a_n18 8.415e-18
ccc__20_rwl_1_a_n18 n20_a_n18 rwl_1_a_n18 6.655e-18
ccc__22__23_a_n18 n22_a_n18 n23_a_n18 1.02e-17
ccc__22_bl_0_a_n18 n22_a_n18 bl_0_a_n18 8.415e-18
ccc__22_rwl_2_a_n18 n22_a_n18 rwl_2_a_n18 1.3194e-17
ccc__23__24_a_n18 n23_a_n18 n24_a_n18 1.02e-17
ccc__23_bl_1_a_n18 n23_a_n18 bl_1_a_n18 8.415e-18
ccc__23_rwl_2_a_n18 n23_a_n18 rwl_2_a_n18 1.3194e-17
ccc__24__25_a_n18 n24_a_n18 n25_a_n18 1.02e-17
ccc__24_bl_2_a_n18 n24_a_n18 bl_2_a_n18 8.415e-18
ccc__24_rwl_2_a_n18 n24_a_n18 rwl_2_a_n18 1.3194e-17
ccc__25_bl_3_a_n18 n25_a_n18 bl_3_a_n18 8.415e-18
ccc__25_rwl_2_a_n18 n25_a_n18 rwl_2_a_n18 6.655e-18
ccc__29__30_a_n18 n29_a_n18 n30_a_n18 1.02e-17
ccc__29_bl_0_a_n18 n29_a_n18 bl_0_a_n18 8.415e-18
ccc__29_rwl_3_a_n18 n29_a_n18 rwl_3_a_n18 1.3194e-17
ccc__30__31_a_n18 n30_a_n18 n31_a_n18 1.02e-17
ccc__30_bl_1_a_n18 n30_a_n18 bl_1_a_n18 8.415e-18
ccc__30_rwl_3_a_n18 n30_a_n18 rwl_3_a_n18 1.3194e-17
ccc__31__32_a_n18 n31_a_n18 n32_a_n18 1.02e-17
ccc__31_bl_2_a_n18 n31_a_n18 bl_2_a_n18 8.415e-18
ccc__31_rwl_3_a_n18 n31_a_n18 rwl_3_a_n18 1.3194e-17
ccc__32_bl_3_a_n18 n32_a_n18 bl_3_a_n18 8.415e-18
ccc__32_rwl_3_a_n18 n32_a_n18 rwl_3_a_n18 6.655e-18
ccc__7__8_a_n18 n7_a_n18 n8_a_n18 1.02e-17
ccc__7_bl_0_a_n18 n7_a_n18 bl_0_a_n18 1.3999e-17
ccc__7_rwl_0_a_n18 n7_a_n18 rwl_0_a_n18 8.961e-18
ccc__8__9_a_n18 n8_a_n18 n9_a_n18 1.02e-17
ccc__8_bl_1_a_n18 n8_a_n18 bl_1_a_n18 1.3999e-17
ccc__8_rwl_0_a_n18 n8_a_n18 rwl_0_a_n18 8.961e-18
ccc__9_bl_2_a_n18 n9_a_n18 bl_2_a_n18 1.3999e-17
ccc__9_rwl_0_a_n18 n9_a_n18 rwl_0_a_n18 8.961e-18
ccc_bl_0_rbl_0_a_n18 bl_0_a_n18 rbl_0_a_n18 1.88693e-16
ccc_bl_0_rwl_1_a_n18 bl_0_a_n18 rwl_1_a_n18 1.0093e-17
ccc_bl_0_rwl_2_a_n18 bl_0_a_n18 rwl_2_a_n18 1.0093e-17
ccc_bl_1_rbl_0_a_n18 bl_1_a_n18 rbl_0_a_n18 1.633e-16
ccc_bl_1_rbl_1_a_n18 bl_1_a_n18 rbl_1_a_n18 1.88693e-16
ccc_bl_1_rwl_1_a_n18 bl_1_a_n18 rwl_1_a_n18 1.0093e-17
ccc_bl_1_rwl_2_a_n18 bl_1_a_n18 rwl_2_a_n18 1.0093e-17
ccc_bl_2_rbl_1_a_n18 bl_2_a_n18 rbl_1_a_n18 1.633e-16
ccc_bl_2_rbl_2_a_n18 bl_2_a_n18 rbl_2_a_n18 1.88693e-16
ccc_bl_2_rwl_1_a_n18 bl_2_a_n18 rwl_1_a_n18 1.0093e-17
ccc_bl_2_rwl_2_a_n18 bl_2_a_n18 rwl_2_a_n18 1.0093e-17
ccc_bl_3_rbl_2_a_n18 bl_3_a_n18 rbl_2_a_n18 1.633e-16
ccc_bl_3_rbl_3_a_n18 bl_3_a_n18 rbl_3_a_n18 1.88693e-16
ccc_bl_3_rwl_1_a_n18 bl_3_a_n18 rwl_1_a_n18 1.0093e-17
ccc_bl_3_rwl_2_a_n18 bl_3_a_n18 rwl_2_a_n18 1.0093e-17
ccc_rbl_0_rbl_1_a_n18 rbl_0_a_n18 rbl_1_a_n18 3.432e-17
ccc_rbl_0_rwl_0_a_n18 rbl_0_a_n18 rwl_0_a_n18 4.9752e-17
ccc_rbl_0_rwl_1_a_n18 rbl_0_a_n18 rwl_1_a_n18 4.9752e-17
ccc_rbl_0_rwl_2_a_n18 rbl_0_a_n18 rwl_2_a_n18 4.9752e-17
ccc_rbl_0_rwl_3_a_n18 rbl_0_a_n18 rwl_3_a_n18 4.9752e-17
ccc_rbl_1_rbl_2_a_n18 rbl_1_a_n18 rbl_2_a_n18 3.432e-17
ccc_rbl_1_rwl_0_a_n18 rbl_1_a_n18 rwl_0_a_n18 4.9752e-17
ccc_rbl_1_rwl_1_a_n18 rbl_1_a_n18 rwl_1_a_n18 4.9752e-17
ccc_rbl_1_rwl_2_a_n18 rbl_1_a_n18 rwl_2_a_n18 4.9752e-17
ccc_rbl_1_rwl_3_a_n18 rbl_1_a_n18 rwl_3_a_n18 4.9752e-17
ccc_rbl_2_rbl_3_a_n18 rbl_2_a_n18 rbl_3_a_n18 3.432e-17
ccc_rbl_2_rwl_0_a_n18 rbl_2_a_n18 rwl_0_a_n18 4.9752e-17
ccc_rbl_2_rwl_1_a_n18 rbl_2_a_n18 rwl_1_a_n18 4.9752e-17
ccc_rbl_2_rwl_2_a_n18 rbl_2_a_n18 rwl_2_a_n18 4.9752e-17
ccc_rbl_2_rwl_3_a_n18 rbl_2_a_n18 rwl_3_a_n18 4.9752e-17
ccc_rbl_3_rwl_0_a_n18 rbl_3_a_n18 rwl_0_a_n18 3.3407e-17
ccc_rbl_3_rwl_1_a_n18 rbl_3_a_n18 rwl_1_a_n18 3.3407e-17
ccc_rbl_3_rwl_2_a_n18 rbl_3_a_n18 rwl_2_a_n18 3.3407e-17
ccc_rbl_3_rwl_3_a_n18 rbl_3_a_n18 rwl_3_a_n18 3.3407e-17
vdw_a_n18_0 wl_0_a_n18 0 dc 0
vdr_a_n18_0 rwl_0_a_n18 vdd dc 0
vdw_a_n18_1 wl_1_a_n18 0 dc 0
vdr_a_n18_1 rwl_1_a_n18 vdd dc 0
vdw_a_n18_2 wl_2_a_n18 0 dc 0
vdr_a_n18_2 rwl_2_a_n18 vdd dc 0
vdw_a_n18_3 wl_3_a_n18 0 dc 0
vdr_a_n18_3 rwl_3_a_n18 vdd dc 0
vdb_a_n18_0 bl_0_a_n18 0 dc 0
vdp_a_n18_0 rbl_0_a_n18 vrbl dc 0
vdb_a_n18_1 bl_1_a_n18 0 dc 0
vdp_a_n18_1 rbl_1_a_n18 vrbl dc 0
vdb_a_n18_2 bl_2_a_n18 0 dc 0
vdp_a_n18_2 rbl_2_a_n18 vrbl dc 0
vdb_a_n18_3 bl_3_a_n18 0 dc 0
vdp_a_n18_3 rbl_3_a_n18 vrbl dc 0
vdn_a_n18_n7 n7_a_n18 0 dc 1
vdn_a_n18_n8 n8_a_n18 0 dc 1
vdn_a_n18_n9 n9_a_n18 0 dc 1
vdn_a_n18_n10 n10_a_n18 0 dc 1
vdn_a_n18_n17 n17_a_n18 0 dc 1
vdn_a_n18_n19 n19_a_n18 0 dc 1
vdn_a_n18_n20 n20_a_n18 0 dc 1
vdn_a_n18_n22 n22_a_n18 0 dc 1
vdn_a_n18_n23 n23_a_n18 0 dc 1
vdn_a_n18_n24 n24_a_n18 0 dc 1
vdn_a_n18_n25 n25_a_n18 0 dc 1
vdn_a_n18_n29 n29_a_n18 0 dc 1
vdn_a_n18_n30 n30_a_n18 0 dc 1
vdn_a_n18_n31 n31_a_n18 0 dc 1
vdn_a_n18_n32 n32_a_n18 0 dc 1
bdr_a_n18 n18_a_n18 0 i=5e-08*min(1,max(0,(time-1e-09)/0.2n))*0.5*(1+tanh((v(n18_a_n18)-0.05)/0.01))

* ---- instance a_n19: variant a, probed storage node \$19 ----
xm1_a_n19 rwl_0__t2_a_n19 n7__t0_a_n19 rbl_0__t0_a_n19 gnd__t0_a_n19 sky130_fd_pr__nfet_01v8 L=0.15 W=0.42 nf=1 ad=0.1197 as=0.1197 pd=1.41 ps=1.41 mult=1 m=1
xm2_a_n19 rwl_0__t3_a_n19 n8__t1_a_n19 rbl_1__t1_a_n19 gnd__t1_a_n19 sky130_fd_pr__nfet_01v8 L=0.15 W=0.42 nf=1 ad=0.1197 as=0.1197 pd=1.41 ps=1.41 mult=1 m=1
xm3_a_n19 rwl_0__t1_a_n19 n9__t1_a_n19 rbl_2__t1_a_n19 gnd__t2_a_n19 sky130_fd_pr__nfet_01v8 L=0.15 W=0.42 nf=1 ad=0.1197 as=0.1197 pd=1.41 ps=1.41 mult=1 m=1
xm4_a_n19 rwl_0__t0_a_n19 n10__t1_a_n19 rbl_3__t1_a_n19 gnd__t3_a_n19 sky130_fd_pr__nfet_01v8 L=0.15 W=0.42 nf=1 ad=0.1197 as=0.1197 pd=1.41 ps=1.41 mult=1 m=1
xm5_a_n19 bl_0__t0_a_n19 wl_0__t0_a_n19 n7__t1_a_n19 gnd__t8_a_n19 sky130_fd_pr__nfet_01v8 L=0.15 W=0.42 nf=1 ad=0.0588 as=0.1197 pd=0.7 ps=1.41 mult=1 m=1
xm6_a_n19 n17__t0_a_n19 wl_1__t0_a_n19 bl_0__t1_a_n19 gnd__t20_a_n19 sky130_fd_pr__nfet_01v8 L=0.15 W=0.42 nf=1 ad=0.1197 as=0.0588 pd=1.41 ps=0.7 mult=1 m=1
xm7_a_n19 bl_1__t2_a_n19 wl_0__t3_a_n19 n8__t0_a_n19 gnd__t9_a_n19 sky130_fd_pr__nfet_01v8 L=0.15 W=0.42 nf=1 ad=0.0588 as=0.1197 pd=0.7 ps=1.41 mult=1 m=1
xm8_a_n19 n18__t0_a_n19 wl_1__t1_a_n19 bl_1__t0_a_n19 gnd__t21_a_n19 sky130_fd_pr__nfet_01v8 L=0.15 W=0.42 nf=1 ad=0.1197 as=0.0588 pd=1.41 ps=0.7 mult=1 m=1
xm9_a_n19 bl_2__t2_a_n19 wl_0__t2_a_n19 n9__t0_a_n19 gnd__t10_a_n19 sky130_fd_pr__nfet_01v8 L=0.15 W=0.42 nf=1 ad=0.0588 as=0.1197 pd=0.7 ps=1.41 mult=1 m=1
xm10_a_n19 n19__t0_a_n19 wl_1__t2_a_n19 bl_2__t0_a_n19 gnd__t22_a_n19 sky130_fd_pr__nfet_01v8 L=0.15 W=0.42 nf=1 ad=0.1197 as=0.0588 pd=1.41 ps=0.7 mult=1 m=1
xm11_a_n19 bl_3__t2_a_n19 wl_0__t1_a_n19 n10__t0_a_n19 gnd__t11_a_n19 sky130_fd_pr__nfet_01v8 L=0.15 W=0.42 nf=1 ad=0.0588 as=0.1197 pd=0.7 ps=1.41 mult=1 m=1
xm12_a_n19 n20__t0_a_n19 wl_1__t3_a_n19 bl_3__t1_a_n19 gnd__t23_a_n19 sky130_fd_pr__nfet_01v8 L=0.15 W=0.42 nf=1 ad=0.1197 as=0.0588 pd=1.41 ps=0.7 mult=1 m=1
xm13_a_n19 rbl_0__t3_a_n19 n17__t1_a_n19 rwl_1__t0_a_n19 gnd__t12_a_n19 sky130_fd_pr__nfet_01v8 L=0.15 W=0.42 nf=1 ad=0.0588 as=0.1197 pd=0.7 ps=1.41 mult=1 m=1
xm14_a_n19 rwl_2__t3_a_n19 n22__t0_a_n19 rbl_0__t2_a_n19 gnd__t24_a_n19 sky130_fd_pr__nfet_01v8 L=0.15 W=0.42 nf=1 ad=0.1197 as=0.0588 pd=1.41 ps=0.7 mult=1 m=1
xm15_a_n19 rbl_1__t3_a_n19 n18__t1_a_n19 rwl_1__t1_a_n19 gnd__t13_a_n19 sky130_fd_pr__nfet_01v8 L=0.15 W=0.42 nf=1 ad=0.0588 as=0.1197 pd=0.7 ps=1.41 mult=1 m=1
xm16_a_n19 rwl_2__t0_a_n19 n23__t0_a_n19 rbl_1__t2_a_n19 gnd__t25_a_n19 sky130_fd_pr__nfet_01v8 L=0.15 W=0.42 nf=1 ad=0.1197 as=0.0588 pd=1.41 ps=0.7 mult=1 m=1
xm17_a_n19 rbl_2__t3_a_n19 n19__t1_a_n19 rwl_1__t2_a_n19 gnd__t14_a_n19 sky130_fd_pr__nfet_01v8 L=0.15 W=0.42 nf=1 ad=0.0588 as=0.1197 pd=0.7 ps=1.41 mult=1 m=1
xm18_a_n19 rwl_2__t1_a_n19 n24__t0_a_n19 rbl_2__t2_a_n19 gnd__t26_a_n19 sky130_fd_pr__nfet_01v8 L=0.15 W=0.42 nf=1 ad=0.1197 as=0.0588 pd=1.41 ps=0.7 mult=1 m=1
xm19_a_n19 rbl_3__t3_a_n19 n20__t1_a_n19 rwl_1__t3_a_n19 gnd__t15_a_n19 sky130_fd_pr__nfet_01v8 L=0.15 W=0.42 nf=1 ad=0.0588 as=0.1197 pd=0.7 ps=1.41 mult=1 m=1
xm20_a_n19 rwl_2__t2_a_n19 n25__t0_a_n19 rbl_3__t2_a_n19 gnd__t27_a_n19 sky130_fd_pr__nfet_01v8 L=0.15 W=0.42 nf=1 ad=0.1197 as=0.0588 pd=1.41 ps=0.7 mult=1 m=1
xm21_a_n19 bl_0__t3_a_n19 wl_2__t0_a_n19 n22__t1_a_n19 gnd__t16_a_n19 sky130_fd_pr__nfet_01v8 L=0.15 W=0.42 nf=1 ad=0.0588 as=0.1197 pd=0.7 ps=1.41 mult=1 m=1
xm22_a_n19 n29__t0_a_n19 wl_3__t3_a_n19 bl_0__t2_a_n19 gnd__t28_a_n19 sky130_fd_pr__nfet_01v8 L=0.15 W=0.42 nf=1 ad=0.1197 as=0.0588 pd=1.41 ps=0.7 mult=1 m=1
xm23_a_n19 bl_1__t3_a_n19 wl_2__t1_a_n19 n23__t1_a_n19 gnd__t17_a_n19 sky130_fd_pr__nfet_01v8 L=0.15 W=0.42 nf=1 ad=0.0588 as=0.1197 pd=0.7 ps=1.41 mult=1 m=1
xm24_a_n19 n30__t0_a_n19 wl_3__t2_a_n19 bl_1__t1_a_n19 gnd__t29_a_n19 sky130_fd_pr__nfet_01v8 L=0.15 W=0.42 nf=1 ad=0.1197 as=0.0588 pd=1.41 ps=0.7 mult=1 m=1
xm25_a_n19 bl_2__t3_a_n19 wl_2__t2_a_n19 n24__t1_a_n19 gnd__t18_a_n19 sky130_fd_pr__nfet_01v8 L=0.15 W=0.42 nf=1 ad=0.0588 as=0.1197 pd=0.7 ps=1.41 mult=1 m=1
xm26_a_n19 n31__t0_a_n19 wl_3__t1_a_n19 bl_2__t1_a_n19 gnd__t30_a_n19 sky130_fd_pr__nfet_01v8 L=0.15 W=0.42 nf=1 ad=0.1197 as=0.0588 pd=1.41 ps=0.7 mult=1 m=1
xm27_a_n19 bl_3__t3_a_n19 wl_2__t3_a_n19 n25__t1_a_n19 gnd__t19_a_n19 sky130_fd_pr__nfet_01v8 L=0.15 W=0.42 nf=1 ad=0.0588 as=0.1197 pd=0.7 ps=1.41 mult=1 m=1
xm28_a_n19 n32__t0_a_n19 wl_3__t0_a_n19 bl_3__t0_a_n19 gnd__t31_a_n19 sky130_fd_pr__nfet_01v8 L=0.15 W=0.42 nf=1 ad=0.1197 as=0.0588 pd=1.41 ps=0.7 mult=1 m=1
xm29_a_n19 rbl_0__t1_a_n19 n29__t1_a_n19 rwl_3__t0_a_n19 gnd__t4_a_n19 sky130_fd_pr__nfet_01v8 L=0.15 W=0.42 nf=1 ad=0.1197 as=0.1197 pd=1.41 ps=1.41 mult=1 m=1
xm30_a_n19 rbl_1__t0_a_n19 n30__t1_a_n19 rwl_3__t1_a_n19 gnd__t5_a_n19 sky130_fd_pr__nfet_01v8 L=0.15 W=0.42 nf=1 ad=0.1197 as=0.1197 pd=1.41 ps=1.41 mult=1 m=1
xm31_a_n19 rbl_2__t0_a_n19 n31__t1_a_n19 rwl_3__t2_a_n19 gnd__t6_a_n19 sky130_fd_pr__nfet_01v8 L=0.15 W=0.42 nf=1 ad=0.1197 as=0.1197 pd=1.41 ps=1.41 mult=1 m=1
xm32_a_n19 rbl_3__t0_a_n19 n32__t1_a_n19 rwl_3__t3_a_n19 gnd__t7_a_n19 sky130_fd_pr__nfet_01v8 L=0.15 W=0.42 nf=1 ad=0.1197 as=0.1197 pd=1.41 ps=1.41 mult=1 m=1
r_10_t0_a_n19 n10__t0_a_n19 n10_a_n19 183.071
r_10_t1_a_n19 n10__t1_a_n19 n10_a_n19 183.071
r_17_t0_a_n19 n17__t0_a_n19 n17_a_n19 183.071
r_17_t1_a_n19 n17__t1_a_n19 n17_a_n19 183.071
r_18_t0_a_n19 n18__t0_a_n19 n18_a_n19 183.071
r_18_t1_a_n19 n18__t1_a_n19 n18_a_n19 183.071
r_19_t0_a_n19 n19__t0_a_n19 n19_a_n19 183.071
r_19_t1_a_n19 n19__t1_a_n19 n19_a_n19 183.071
r_20_t0_a_n19 n20__t0_a_n19 n20_a_n19 183.071
r_20_t1_a_n19 n20__t1_a_n19 n20_a_n19 183.071
r_22_t0_a_n19 n22__t0_a_n19 n22_a_n19 183.071
r_22_t1_a_n19 n22__t1_a_n19 n22_a_n19 183.071
r_23_t0_a_n19 n23__t0_a_n19 n23_a_n19 183.071
r_23_t1_a_n19 n23__t1_a_n19 n23_a_n19 183.071
r_24_t0_a_n19 n24__t0_a_n19 n24_a_n19 183.071
r_24_t1_a_n19 n24__t1_a_n19 n24_a_n19 183.071
r_25_t0_a_n19 n25__t0_a_n19 n25_a_n19 183.071
r_25_t1_a_n19 n25__t1_a_n19 n25_a_n19 183.071
r_29_t0_a_n19 n29__t0_a_n19 n29_a_n19 183.071
r_29_t1_a_n19 n29__t1_a_n19 n29_a_n19 183.071
r_30_t0_a_n19 n30__t0_a_n19 n30_a_n19 183.071
r_30_t1_a_n19 n30__t1_a_n19 n30_a_n19 183.071
r_31_t0_a_n19 n31__t0_a_n19 n31_a_n19 183.071
r_31_t1_a_n19 n31__t1_a_n19 n31_a_n19 183.071
r_32_t0_a_n19 n32__t0_a_n19 n32_a_n19 183.071
r_32_t1_a_n19 n32__t1_a_n19 n32_a_n19 183.071
r_7_t0_a_n19 n7__t0_a_n19 n7_a_n19 183.071
r_7_t1_a_n19 n7__t1_a_n19 n7_a_n19 183.071
r_8_t0_a_n19 n8__t0_a_n19 n8_a_n19 183.071
r_8_t1_a_n19 n8__t1_a_n19 n8_a_n19 183.071
r_9_t0_a_n19 n9__t0_a_n19 n9_a_n19 183.071
r_9_t1_a_n19 n9__t1_a_n19 n9_a_n19 183.071
rgnd_t0_a_n19 gnd__t0_a_n19 0 38.2988
rgnd_t1_a_n19 gnd__t1_a_n19 0 33.9576
rgnd_t2_a_n19 gnd__t2_a_n19 0 33.9576
rgnd_t3_a_n19 gnd__t3_a_n19 0 38.2988
rgnd_t4_a_n19 gnd__t4_a_n19 0 38.2988
rgnd_t5_a_n19 gnd__t5_a_n19 0 33.9576
rgnd_t6_a_n19 gnd__t6_a_n19 0 33.9576
rgnd_t7_a_n19 gnd__t7_a_n19 0 38.2988
rgnd_t8_a_n19 gnd__t8_a_n19 0 28.0185
rgnd_t9_a_n19 gnd__t9_a_n19 0 21.7106
rgnd_t10_a_n19 gnd__t10_a_n19 0 21.7106
rgnd_t11_a_n19 gnd__t11_a_n19 0 28.0185
rgnd_t12_a_n19 gnd__t12_a_n19 0 18.9833
rgnd_t13_a_n19 gnd__t13_a_n19 0 6.8325
rgnd_t14_a_n19 gnd__t14_a_n19 0 6.8325
rgnd_t15_a_n19 gnd__t15_a_n19 0 18.9833
rgnd_t16_a_n19 gnd__t16_a_n19 0 24.2409
rgnd_t17_a_n19 gnd__t17_a_n19 0 16.5511
rgnd_t18_a_n19 gnd__t18_a_n19 0 16.5511
rgnd_t19_a_n19 gnd__t19_a_n19 0 24.2409
rgnd_t20_a_n19 gnd__t20_a_n19 0 24.2409
rgnd_t21_a_n19 gnd__t21_a_n19 0 16.5511
rgnd_t22_a_n19 gnd__t22_a_n19 0 16.5511
rgnd_t23_a_n19 gnd__t23_a_n19 0 24.2409
rgnd_t24_a_n19 gnd__t24_a_n19 0 18.9833
rgnd_t25_a_n19 gnd__t25_a_n19 0 6.8325
rgnd_t26_a_n19 gnd__t26_a_n19 0 6.8325
rgnd_t27_a_n19 gnd__t27_a_n19 0 18.9833
rgnd_t28_a_n19 gnd__t28_a_n19 0 28.0185
rgnd_t29_a_n19 gnd__t29_a_n19 0 21.7106
rgnd_t30_a_n19 gnd__t30_a_n19 0 21.7106
rgnd_t31_a_n19 gnd__t31_a_n19 0 28.0185
rbl_0_t0_a_n19 bl_0__t0_a_n19 bl_0_a_n19 14.8304
rbl_0_t1_a_n19 bl_0__t1_a_n19 bl_0_a_n19 10.9301
rbl_0_t2_a_n19 bl_0__t2_a_n19 bl_0_a_n19 14.8304
rbl_0_t3_a_n19 bl_0__t3_a_n19 bl_0_a_n19 10.9301
rbl_1_t0_a_n19 bl_1__t0_a_n19 bl_1_a_n19 10.9301
rbl_1_t1_a_n19 bl_1__t1_a_n19 bl_1_a_n19 14.8304
rbl_1_t2_a_n19 bl_1__t2_a_n19 bl_1_a_n19 14.8304
rbl_1_t3_a_n19 bl_1__t3_a_n19 bl_1_a_n19 10.9301
rbl_2_t0_a_n19 bl_2__t0_a_n19 bl_2_a_n19 10.9301
rbl_2_t1_a_n19 bl_2__t1_a_n19 bl_2_a_n19 14.8304
rbl_2_t2_a_n19 bl_2__t2_a_n19 bl_2_a_n19 14.8304
rbl_2_t3_a_n19 bl_2__t3_a_n19 bl_2_a_n19 10.9301
rbl_3_t0_a_n19 bl_3__t0_a_n19 bl_3_a_n19 14.8304
rbl_3_t1_a_n19 bl_3__t1_a_n19 bl_3_a_n19 10.9301
rbl_3_t2_a_n19 bl_3__t2_a_n19 bl_3_a_n19 14.8304
rbl_3_t3_a_n19 bl_3__t3_a_n19 bl_3_a_n19 10.9301
rrbl_0_t0_a_n19 rbl_0__t0_a_n19 rbl_0_a_n19 36.5601
rrbl_0_t1_a_n19 rbl_0__t1_a_n19 rbl_0_a_n19 36.5601
rrbl_0_t2_a_n19 rbl_0__t2_a_n19 rbl_0_a_n19 2.99444
rrbl_0_t3_a_n19 rbl_0__t3_a_n19 rbl_0_a_n19 2.99444
rrbl_1_t0_a_n19 rbl_1__t0_a_n19 rbl_1_a_n19 36.5601
rrbl_1_t1_a_n19 rbl_1__t1_a_n19 rbl_1_a_n19 36.5601
rrbl_1_t2_a_n19 rbl_1__t2_a_n19 rbl_1_a_n19 2.99444
rrbl_1_t3_a_n19 rbl_1__t3_a_n19 rbl_1_a_n19 2.99444
rrbl_2_t0_a_n19 rbl_2__t0_a_n19 rbl_2_a_n19 36.5601
rrbl_2_t1_a_n19 rbl_2__t1_a_n19 rbl_2_a_n19 36.5601
rrbl_2_t2_a_n19 rbl_2__t2_a_n19 rbl_2_a_n19 2.99444
rrbl_2_t3_a_n19 rbl_2__t3_a_n19 rbl_2_a_n19 2.99444
rrbl_3_t0_a_n19 rbl_3__t0_a_n19 rbl_3_a_n19 36.5601
rrbl_3_t1_a_n19 rbl_3__t1_a_n19 rbl_3_a_n19 36.5601
rrbl_3_t2_a_n19 rbl_3__t2_a_n19 rbl_3_a_n19 2.99444
rrbl_3_t3_a_n19 rbl_3__t3_a_n19 rbl_3_a_n19 2.99444
rrwl_0_t0_a_n19 rwl_0__t0_a_n19 rwl_0_a_n19 38.2618
rrwl_0_t1_a_n19 rwl_0__t1_a_n19 rwl_0_a_n19 12.7539
rrwl_0_t2_a_n19 rwl_0__t2_a_n19 rwl_0_a_n19 38.2618
rrwl_0_t3_a_n19 rwl_0__t3_a_n19 rwl_0_a_n19 12.7539
rrwl_1_t0_a_n19 rwl_1__t0_a_n19 rwl_1_a_n19 38.2618
rrwl_1_t1_a_n19 rwl_1__t1_a_n19 rwl_1_a_n19 12.7539
rrwl_1_t2_a_n19 rwl_1__t2_a_n19 rwl_1_a_n19 12.7539
rrwl_1_t3_a_n19 rwl_1__t3_a_n19 rwl_1_a_n19 38.2618
rrwl_2_t0_a_n19 rwl_2__t0_a_n19 rwl_2_a_n19 12.7539
rrwl_2_t1_a_n19 rwl_2__t1_a_n19 rwl_2_a_n19 12.7539
rrwl_2_t2_a_n19 rwl_2__t2_a_n19 rwl_2_a_n19 38.2618
rrwl_2_t3_a_n19 rwl_2__t3_a_n19 rwl_2_a_n19 38.2618
rrwl_3_t0_a_n19 rwl_3__t0_a_n19 rwl_3_a_n19 38.2618
rrwl_3_t1_a_n19 rwl_3__t1_a_n19 rwl_3_a_n19 12.7539
rrwl_3_t2_a_n19 rwl_3__t2_a_n19 rwl_3_a_n19 12.7539
rrwl_3_t3_a_n19 rwl_3__t3_a_n19 rwl_3_a_n19 38.2618
rwl_0_t0_a_n19 wl_0__t0_a_n19 wl_0_a_n19 245.959
rwl_0_t1_a_n19 wl_0__t1_a_n19 wl_0_a_n19 245.959
rwl_0_t2_a_n19 wl_0__t2_a_n19 wl_0_a_n19 81.9864
rwl_0_t3_a_n19 wl_0__t3_a_n19 wl_0_a_n19 81.9864
rwl_1_t0_a_n19 wl_1__t0_a_n19 wl_1_a_n19 245.959
rwl_1_t1_a_n19 wl_1__t1_a_n19 wl_1_a_n19 81.9864
rwl_1_t2_a_n19 wl_1__t2_a_n19 wl_1_a_n19 81.9864
rwl_1_t3_a_n19 wl_1__t3_a_n19 wl_1_a_n19 245.959
rwl_2_t0_a_n19 wl_2__t0_a_n19 wl_2_a_n19 245.959
rwl_2_t1_a_n19 wl_2__t1_a_n19 wl_2_a_n19 81.9864
rwl_2_t2_a_n19 wl_2__t2_a_n19 wl_2_a_n19 81.9864
rwl_2_t3_a_n19 wl_2__t3_a_n19 wl_2_a_n19 245.959
rwl_3_t0_a_n19 wl_3__t0_a_n19 wl_3_a_n19 245.959
rwl_3_t1_a_n19 wl_3__t1_a_n19 wl_3_a_n19 81.9864
rwl_3_t2_a_n19 wl_3__t2_a_n19 wl_3_a_n19 81.9864
rwl_3_t3_a_n19 wl_3__t3_a_n19 wl_3_a_n19 245.959
c_10_a_n19 n10_a_n19 0 2.91622e-16
c_17_a_n19 n17_a_n19 0 2.91528e-16
c_18_a_n19 n18_a_n19 0 2.91528e-16
c_19_a_n19 n19_a_n19 0 2.91528e-16
c_20_a_n19 n20_a_n19 0 2.91622e-16
c_22_a_n19 n22_a_n19 0 2.91528e-16
c_23_a_n19 n23_a_n19 0 2.91528e-16
c_24_a_n19 n24_a_n19 0 2.91528e-16
c_25_a_n19 n25_a_n19 0 2.91622e-16
c_29_a_n19 n29_a_n19 0 2.91528e-16
c_30_a_n19 n30_a_n19 0 2.91528e-16
c_31_a_n19 n31_a_n19 0 2.91528e-16
c_32_a_n19 n32_a_n19 0 2.91622e-16
c_7_a_n19 n7_a_n19 0 2.91528e-16
c_8_a_n19 n8_a_n19 0 2.91528e-16
c_9_a_n19 n9_a_n19 0 2.91528e-16
cgnd_a_n19 0 0 2.48166e-15
cbl_0_a_n19 bl_0_a_n19 0 4.52661e-16
cbl_1_a_n19 bl_1_a_n19 0 4.52661e-16
cbl_2_a_n19 bl_2_a_n19 0 4.52661e-16
cbl_3_a_n19 bl_3_a_n19 0 4.52661e-16
crbl_0_a_n19 rbl_0_a_n19 0 9.14472e-16
crbl_1_a_n19 rbl_1_a_n19 0 9.14472e-16
crbl_2_a_n19 rbl_2_a_n19 0 9.14472e-16
crbl_3_a_n19 rbl_3_a_n19 0 9.17566e-16
crwl_0_a_n19 rwl_0_a_n19 0 5.19495e-16
crwl_1_a_n19 rwl_1_a_n19 0 5.11719e-16
crwl_2_a_n19 rwl_2_a_n19 0 5.11719e-16
crwl_3_a_n19 rwl_3_a_n19 0 5.19495e-16
cwl_0_a_n19 wl_0_a_n19 0 3.30388e-16
cwl_1_a_n19 wl_1_a_n19 0 3.30388e-16
cwl_2_a_n19 wl_2_a_n19 0 3.30388e-16
cwl_3_a_n19 wl_3_a_n19 0 3.30388e-16
ccc__10__9_a_n19 n10_a_n19 n9_a_n19 1.02e-17
ccc__10_bl_3_a_n19 n10_a_n19 bl_3_a_n19 1.3999e-17
ccc__10_rwl_0_a_n19 n10_a_n19 rwl_0_a_n19 4.335e-18
ccc__17__18_a_n19 n17_a_n19 n18_a_n19 1.02e-17
ccc__17_bl_0_a_n19 n17_a_n19 bl_0_a_n19 8.415e-18
ccc__17_rwl_1_a_n19 n17_a_n19 rwl_1_a_n19 1.3194e-17
ccc__18__19_a_n19 n18_a_n19 n19_a_n19 1.02e-17
ccc__18_bl_1_a_n19 n18_a_n19 bl_1_a_n19 8.415e-18
ccc__18_rwl_1_a_n19 n18_a_n19 rwl_1_a_n19 1.3194e-17
ccc__19__20_a_n19 n19_a_n19 n20_a_n19 1.02e-17
ccc__19_bl_2_a_n19 n19_a_n19 bl_2_a_n19 8.415e-18
ccc__19_rwl_1_a_n19 n19_a_n19 rwl_1_a_n19 1.3194e-17
ccc__20_bl_3_a_n19 n20_a_n19 bl_3_a_n19 8.415e-18
ccc__20_rwl_1_a_n19 n20_a_n19 rwl_1_a_n19 6.655e-18
ccc__22__23_a_n19 n22_a_n19 n23_a_n19 1.02e-17
ccc__22_bl_0_a_n19 n22_a_n19 bl_0_a_n19 8.415e-18
ccc__22_rwl_2_a_n19 n22_a_n19 rwl_2_a_n19 1.3194e-17
ccc__23__24_a_n19 n23_a_n19 n24_a_n19 1.02e-17
ccc__23_bl_1_a_n19 n23_a_n19 bl_1_a_n19 8.415e-18
ccc__23_rwl_2_a_n19 n23_a_n19 rwl_2_a_n19 1.3194e-17
ccc__24__25_a_n19 n24_a_n19 n25_a_n19 1.02e-17
ccc__24_bl_2_a_n19 n24_a_n19 bl_2_a_n19 8.415e-18
ccc__24_rwl_2_a_n19 n24_a_n19 rwl_2_a_n19 1.3194e-17
ccc__25_bl_3_a_n19 n25_a_n19 bl_3_a_n19 8.415e-18
ccc__25_rwl_2_a_n19 n25_a_n19 rwl_2_a_n19 6.655e-18
ccc__29__30_a_n19 n29_a_n19 n30_a_n19 1.02e-17
ccc__29_bl_0_a_n19 n29_a_n19 bl_0_a_n19 8.415e-18
ccc__29_rwl_3_a_n19 n29_a_n19 rwl_3_a_n19 1.3194e-17
ccc__30__31_a_n19 n30_a_n19 n31_a_n19 1.02e-17
ccc__30_bl_1_a_n19 n30_a_n19 bl_1_a_n19 8.415e-18
ccc__30_rwl_3_a_n19 n30_a_n19 rwl_3_a_n19 1.3194e-17
ccc__31__32_a_n19 n31_a_n19 n32_a_n19 1.02e-17
ccc__31_bl_2_a_n19 n31_a_n19 bl_2_a_n19 8.415e-18
ccc__31_rwl_3_a_n19 n31_a_n19 rwl_3_a_n19 1.3194e-17
ccc__32_bl_3_a_n19 n32_a_n19 bl_3_a_n19 8.415e-18
ccc__32_rwl_3_a_n19 n32_a_n19 rwl_3_a_n19 6.655e-18
ccc__7__8_a_n19 n7_a_n19 n8_a_n19 1.02e-17
ccc__7_bl_0_a_n19 n7_a_n19 bl_0_a_n19 1.3999e-17
ccc__7_rwl_0_a_n19 n7_a_n19 rwl_0_a_n19 8.961e-18
ccc__8__9_a_n19 n8_a_n19 n9_a_n19 1.02e-17
ccc__8_bl_1_a_n19 n8_a_n19 bl_1_a_n19 1.3999e-17
ccc__8_rwl_0_a_n19 n8_a_n19 rwl_0_a_n19 8.961e-18
ccc__9_bl_2_a_n19 n9_a_n19 bl_2_a_n19 1.3999e-17
ccc__9_rwl_0_a_n19 n9_a_n19 rwl_0_a_n19 8.961e-18
ccc_bl_0_rbl_0_a_n19 bl_0_a_n19 rbl_0_a_n19 1.88693e-16
ccc_bl_0_rwl_1_a_n19 bl_0_a_n19 rwl_1_a_n19 1.0093e-17
ccc_bl_0_rwl_2_a_n19 bl_0_a_n19 rwl_2_a_n19 1.0093e-17
ccc_bl_1_rbl_0_a_n19 bl_1_a_n19 rbl_0_a_n19 1.633e-16
ccc_bl_1_rbl_1_a_n19 bl_1_a_n19 rbl_1_a_n19 1.88693e-16
ccc_bl_1_rwl_1_a_n19 bl_1_a_n19 rwl_1_a_n19 1.0093e-17
ccc_bl_1_rwl_2_a_n19 bl_1_a_n19 rwl_2_a_n19 1.0093e-17
ccc_bl_2_rbl_1_a_n19 bl_2_a_n19 rbl_1_a_n19 1.633e-16
ccc_bl_2_rbl_2_a_n19 bl_2_a_n19 rbl_2_a_n19 1.88693e-16
ccc_bl_2_rwl_1_a_n19 bl_2_a_n19 rwl_1_a_n19 1.0093e-17
ccc_bl_2_rwl_2_a_n19 bl_2_a_n19 rwl_2_a_n19 1.0093e-17
ccc_bl_3_rbl_2_a_n19 bl_3_a_n19 rbl_2_a_n19 1.633e-16
ccc_bl_3_rbl_3_a_n19 bl_3_a_n19 rbl_3_a_n19 1.88693e-16
ccc_bl_3_rwl_1_a_n19 bl_3_a_n19 rwl_1_a_n19 1.0093e-17
ccc_bl_3_rwl_2_a_n19 bl_3_a_n19 rwl_2_a_n19 1.0093e-17
ccc_rbl_0_rbl_1_a_n19 rbl_0_a_n19 rbl_1_a_n19 3.432e-17
ccc_rbl_0_rwl_0_a_n19 rbl_0_a_n19 rwl_0_a_n19 4.9752e-17
ccc_rbl_0_rwl_1_a_n19 rbl_0_a_n19 rwl_1_a_n19 4.9752e-17
ccc_rbl_0_rwl_2_a_n19 rbl_0_a_n19 rwl_2_a_n19 4.9752e-17
ccc_rbl_0_rwl_3_a_n19 rbl_0_a_n19 rwl_3_a_n19 4.9752e-17
ccc_rbl_1_rbl_2_a_n19 rbl_1_a_n19 rbl_2_a_n19 3.432e-17
ccc_rbl_1_rwl_0_a_n19 rbl_1_a_n19 rwl_0_a_n19 4.9752e-17
ccc_rbl_1_rwl_1_a_n19 rbl_1_a_n19 rwl_1_a_n19 4.9752e-17
ccc_rbl_1_rwl_2_a_n19 rbl_1_a_n19 rwl_2_a_n19 4.9752e-17
ccc_rbl_1_rwl_3_a_n19 rbl_1_a_n19 rwl_3_a_n19 4.9752e-17
ccc_rbl_2_rbl_3_a_n19 rbl_2_a_n19 rbl_3_a_n19 3.432e-17
ccc_rbl_2_rwl_0_a_n19 rbl_2_a_n19 rwl_0_a_n19 4.9752e-17
ccc_rbl_2_rwl_1_a_n19 rbl_2_a_n19 rwl_1_a_n19 4.9752e-17
ccc_rbl_2_rwl_2_a_n19 rbl_2_a_n19 rwl_2_a_n19 4.9752e-17
ccc_rbl_2_rwl_3_a_n19 rbl_2_a_n19 rwl_3_a_n19 4.9752e-17
ccc_rbl_3_rwl_0_a_n19 rbl_3_a_n19 rwl_0_a_n19 3.3407e-17
ccc_rbl_3_rwl_1_a_n19 rbl_3_a_n19 rwl_1_a_n19 3.3407e-17
ccc_rbl_3_rwl_2_a_n19 rbl_3_a_n19 rwl_2_a_n19 3.3407e-17
ccc_rbl_3_rwl_3_a_n19 rbl_3_a_n19 rwl_3_a_n19 3.3407e-17
vdw_a_n19_0 wl_0_a_n19 0 dc 0
vdr_a_n19_0 rwl_0_a_n19 vdd dc 0
vdw_a_n19_1 wl_1_a_n19 0 dc 0
vdr_a_n19_1 rwl_1_a_n19 vdd dc 0
vdw_a_n19_2 wl_2_a_n19 0 dc 0
vdr_a_n19_2 rwl_2_a_n19 vdd dc 0
vdw_a_n19_3 wl_3_a_n19 0 dc 0
vdr_a_n19_3 rwl_3_a_n19 vdd dc 0
vdb_a_n19_0 bl_0_a_n19 0 dc 0
vdp_a_n19_0 rbl_0_a_n19 vrbl dc 0
vdb_a_n19_1 bl_1_a_n19 0 dc 0
vdp_a_n19_1 rbl_1_a_n19 vrbl dc 0
vdb_a_n19_2 bl_2_a_n19 0 dc 0
vdp_a_n19_2 rbl_2_a_n19 vrbl dc 0
vdb_a_n19_3 bl_3_a_n19 0 dc 0
vdp_a_n19_3 rbl_3_a_n19 vrbl dc 0
vdn_a_n19_n7 n7_a_n19 0 dc 1
vdn_a_n19_n8 n8_a_n19 0 dc 1
vdn_a_n19_n9 n9_a_n19 0 dc 1
vdn_a_n19_n10 n10_a_n19 0 dc 1
vdn_a_n19_n17 n17_a_n19 0 dc 1
vdn_a_n19_n18 n18_a_n19 0 dc 1
vdn_a_n19_n20 n20_a_n19 0 dc 1
vdn_a_n19_n22 n22_a_n19 0 dc 1
vdn_a_n19_n23 n23_a_n19 0 dc 1
vdn_a_n19_n24 n24_a_n19 0 dc 1
vdn_a_n19_n25 n25_a_n19 0 dc 1
vdn_a_n19_n29 n29_a_n19 0 dc 1
vdn_a_n19_n30 n30_a_n19 0 dc 1
vdn_a_n19_n31 n31_a_n19 0 dc 1
vdn_a_n19_n32 n32_a_n19 0 dc 1
bdr_a_n19 n19_a_n19 0 i=5e-08*min(1,max(0,(time-1e-09)/0.2n))*0.5*(1+tanh((v(n19_a_n19)-0.05)/0.01))

* ---- instance a_n20: variant a, probed storage node \$20 ----
xm1_a_n20 rwl_0__t2_a_n20 n7__t0_a_n20 rbl_0__t0_a_n20 gnd__t0_a_n20 sky130_fd_pr__nfet_01v8 L=0.15 W=0.42 nf=1 ad=0.1197 as=0.1197 pd=1.41 ps=1.41 mult=1 m=1
xm2_a_n20 rwl_0__t3_a_n20 n8__t1_a_n20 rbl_1__t1_a_n20 gnd__t1_a_n20 sky130_fd_pr__nfet_01v8 L=0.15 W=0.42 nf=1 ad=0.1197 as=0.1197 pd=1.41 ps=1.41 mult=1 m=1
xm3_a_n20 rwl_0__t1_a_n20 n9__t1_a_n20 rbl_2__t1_a_n20 gnd__t2_a_n20 sky130_fd_pr__nfet_01v8 L=0.15 W=0.42 nf=1 ad=0.1197 as=0.1197 pd=1.41 ps=1.41 mult=1 m=1
xm4_a_n20 rwl_0__t0_a_n20 n10__t1_a_n20 rbl_3__t1_a_n20 gnd__t3_a_n20 sky130_fd_pr__nfet_01v8 L=0.15 W=0.42 nf=1 ad=0.1197 as=0.1197 pd=1.41 ps=1.41 mult=1 m=1
xm5_a_n20 bl_0__t0_a_n20 wl_0__t0_a_n20 n7__t1_a_n20 gnd__t8_a_n20 sky130_fd_pr__nfet_01v8 L=0.15 W=0.42 nf=1 ad=0.0588 as=0.1197 pd=0.7 ps=1.41 mult=1 m=1
xm6_a_n20 n17__t0_a_n20 wl_1__t0_a_n20 bl_0__t1_a_n20 gnd__t20_a_n20 sky130_fd_pr__nfet_01v8 L=0.15 W=0.42 nf=1 ad=0.1197 as=0.0588 pd=1.41 ps=0.7 mult=1 m=1
xm7_a_n20 bl_1__t2_a_n20 wl_0__t3_a_n20 n8__t0_a_n20 gnd__t9_a_n20 sky130_fd_pr__nfet_01v8 L=0.15 W=0.42 nf=1 ad=0.0588 as=0.1197 pd=0.7 ps=1.41 mult=1 m=1
xm8_a_n20 n18__t0_a_n20 wl_1__t1_a_n20 bl_1__t0_a_n20 gnd__t21_a_n20 sky130_fd_pr__nfet_01v8 L=0.15 W=0.42 nf=1 ad=0.1197 as=0.0588 pd=1.41 ps=0.7 mult=1 m=1
xm9_a_n20 bl_2__t2_a_n20 wl_0__t2_a_n20 n9__t0_a_n20 gnd__t10_a_n20 sky130_fd_pr__nfet_01v8 L=0.15 W=0.42 nf=1 ad=0.0588 as=0.1197 pd=0.7 ps=1.41 mult=1 m=1
xm10_a_n20 n19__t0_a_n20 wl_1__t2_a_n20 bl_2__t0_a_n20 gnd__t22_a_n20 sky130_fd_pr__nfet_01v8 L=0.15 W=0.42 nf=1 ad=0.1197 as=0.0588 pd=1.41 ps=0.7 mult=1 m=1
xm11_a_n20 bl_3__t2_a_n20 wl_0__t1_a_n20 n10__t0_a_n20 gnd__t11_a_n20 sky130_fd_pr__nfet_01v8 L=0.15 W=0.42 nf=1 ad=0.0588 as=0.1197 pd=0.7 ps=1.41 mult=1 m=1
xm12_a_n20 n20__t0_a_n20 wl_1__t3_a_n20 bl_3__t1_a_n20 gnd__t23_a_n20 sky130_fd_pr__nfet_01v8 L=0.15 W=0.42 nf=1 ad=0.1197 as=0.0588 pd=1.41 ps=0.7 mult=1 m=1
xm13_a_n20 rbl_0__t3_a_n20 n17__t1_a_n20 rwl_1__t0_a_n20 gnd__t12_a_n20 sky130_fd_pr__nfet_01v8 L=0.15 W=0.42 nf=1 ad=0.0588 as=0.1197 pd=0.7 ps=1.41 mult=1 m=1
xm14_a_n20 rwl_2__t3_a_n20 n22__t0_a_n20 rbl_0__t2_a_n20 gnd__t24_a_n20 sky130_fd_pr__nfet_01v8 L=0.15 W=0.42 nf=1 ad=0.1197 as=0.0588 pd=1.41 ps=0.7 mult=1 m=1
xm15_a_n20 rbl_1__t3_a_n20 n18__t1_a_n20 rwl_1__t1_a_n20 gnd__t13_a_n20 sky130_fd_pr__nfet_01v8 L=0.15 W=0.42 nf=1 ad=0.0588 as=0.1197 pd=0.7 ps=1.41 mult=1 m=1
xm16_a_n20 rwl_2__t0_a_n20 n23__t0_a_n20 rbl_1__t2_a_n20 gnd__t25_a_n20 sky130_fd_pr__nfet_01v8 L=0.15 W=0.42 nf=1 ad=0.1197 as=0.0588 pd=1.41 ps=0.7 mult=1 m=1
xm17_a_n20 rbl_2__t3_a_n20 n19__t1_a_n20 rwl_1__t2_a_n20 gnd__t14_a_n20 sky130_fd_pr__nfet_01v8 L=0.15 W=0.42 nf=1 ad=0.0588 as=0.1197 pd=0.7 ps=1.41 mult=1 m=1
xm18_a_n20 rwl_2__t1_a_n20 n24__t0_a_n20 rbl_2__t2_a_n20 gnd__t26_a_n20 sky130_fd_pr__nfet_01v8 L=0.15 W=0.42 nf=1 ad=0.1197 as=0.0588 pd=1.41 ps=0.7 mult=1 m=1
xm19_a_n20 rbl_3__t3_a_n20 n20__t1_a_n20 rwl_1__t3_a_n20 gnd__t15_a_n20 sky130_fd_pr__nfet_01v8 L=0.15 W=0.42 nf=1 ad=0.0588 as=0.1197 pd=0.7 ps=1.41 mult=1 m=1
xm20_a_n20 rwl_2__t2_a_n20 n25__t0_a_n20 rbl_3__t2_a_n20 gnd__t27_a_n20 sky130_fd_pr__nfet_01v8 L=0.15 W=0.42 nf=1 ad=0.1197 as=0.0588 pd=1.41 ps=0.7 mult=1 m=1
xm21_a_n20 bl_0__t3_a_n20 wl_2__t0_a_n20 n22__t1_a_n20 gnd__t16_a_n20 sky130_fd_pr__nfet_01v8 L=0.15 W=0.42 nf=1 ad=0.0588 as=0.1197 pd=0.7 ps=1.41 mult=1 m=1
xm22_a_n20 n29__t0_a_n20 wl_3__t3_a_n20 bl_0__t2_a_n20 gnd__t28_a_n20 sky130_fd_pr__nfet_01v8 L=0.15 W=0.42 nf=1 ad=0.1197 as=0.0588 pd=1.41 ps=0.7 mult=1 m=1
xm23_a_n20 bl_1__t3_a_n20 wl_2__t1_a_n20 n23__t1_a_n20 gnd__t17_a_n20 sky130_fd_pr__nfet_01v8 L=0.15 W=0.42 nf=1 ad=0.0588 as=0.1197 pd=0.7 ps=1.41 mult=1 m=1
xm24_a_n20 n30__t0_a_n20 wl_3__t2_a_n20 bl_1__t1_a_n20 gnd__t29_a_n20 sky130_fd_pr__nfet_01v8 L=0.15 W=0.42 nf=1 ad=0.1197 as=0.0588 pd=1.41 ps=0.7 mult=1 m=1
xm25_a_n20 bl_2__t3_a_n20 wl_2__t2_a_n20 n24__t1_a_n20 gnd__t18_a_n20 sky130_fd_pr__nfet_01v8 L=0.15 W=0.42 nf=1 ad=0.0588 as=0.1197 pd=0.7 ps=1.41 mult=1 m=1
xm26_a_n20 n31__t0_a_n20 wl_3__t1_a_n20 bl_2__t1_a_n20 gnd__t30_a_n20 sky130_fd_pr__nfet_01v8 L=0.15 W=0.42 nf=1 ad=0.1197 as=0.0588 pd=1.41 ps=0.7 mult=1 m=1
xm27_a_n20 bl_3__t3_a_n20 wl_2__t3_a_n20 n25__t1_a_n20 gnd__t19_a_n20 sky130_fd_pr__nfet_01v8 L=0.15 W=0.42 nf=1 ad=0.0588 as=0.1197 pd=0.7 ps=1.41 mult=1 m=1
xm28_a_n20 n32__t0_a_n20 wl_3__t0_a_n20 bl_3__t0_a_n20 gnd__t31_a_n20 sky130_fd_pr__nfet_01v8 L=0.15 W=0.42 nf=1 ad=0.1197 as=0.0588 pd=1.41 ps=0.7 mult=1 m=1
xm29_a_n20 rbl_0__t1_a_n20 n29__t1_a_n20 rwl_3__t0_a_n20 gnd__t4_a_n20 sky130_fd_pr__nfet_01v8 L=0.15 W=0.42 nf=1 ad=0.1197 as=0.1197 pd=1.41 ps=1.41 mult=1 m=1
xm30_a_n20 rbl_1__t0_a_n20 n30__t1_a_n20 rwl_3__t1_a_n20 gnd__t5_a_n20 sky130_fd_pr__nfet_01v8 L=0.15 W=0.42 nf=1 ad=0.1197 as=0.1197 pd=1.41 ps=1.41 mult=1 m=1
xm31_a_n20 rbl_2__t0_a_n20 n31__t1_a_n20 rwl_3__t2_a_n20 gnd__t6_a_n20 sky130_fd_pr__nfet_01v8 L=0.15 W=0.42 nf=1 ad=0.1197 as=0.1197 pd=1.41 ps=1.41 mult=1 m=1
xm32_a_n20 rbl_3__t0_a_n20 n32__t1_a_n20 rwl_3__t3_a_n20 gnd__t7_a_n20 sky130_fd_pr__nfet_01v8 L=0.15 W=0.42 nf=1 ad=0.1197 as=0.1197 pd=1.41 ps=1.41 mult=1 m=1
r_10_t0_a_n20 n10__t0_a_n20 n10_a_n20 183.071
r_10_t1_a_n20 n10__t1_a_n20 n10_a_n20 183.071
r_17_t0_a_n20 n17__t0_a_n20 n17_a_n20 183.071
r_17_t1_a_n20 n17__t1_a_n20 n17_a_n20 183.071
r_18_t0_a_n20 n18__t0_a_n20 n18_a_n20 183.071
r_18_t1_a_n20 n18__t1_a_n20 n18_a_n20 183.071
r_19_t0_a_n20 n19__t0_a_n20 n19_a_n20 183.071
r_19_t1_a_n20 n19__t1_a_n20 n19_a_n20 183.071
r_20_t0_a_n20 n20__t0_a_n20 n20_a_n20 183.071
r_20_t1_a_n20 n20__t1_a_n20 n20_a_n20 183.071
r_22_t0_a_n20 n22__t0_a_n20 n22_a_n20 183.071
r_22_t1_a_n20 n22__t1_a_n20 n22_a_n20 183.071
r_23_t0_a_n20 n23__t0_a_n20 n23_a_n20 183.071
r_23_t1_a_n20 n23__t1_a_n20 n23_a_n20 183.071
r_24_t0_a_n20 n24__t0_a_n20 n24_a_n20 183.071
r_24_t1_a_n20 n24__t1_a_n20 n24_a_n20 183.071
r_25_t0_a_n20 n25__t0_a_n20 n25_a_n20 183.071
r_25_t1_a_n20 n25__t1_a_n20 n25_a_n20 183.071
r_29_t0_a_n20 n29__t0_a_n20 n29_a_n20 183.071
r_29_t1_a_n20 n29__t1_a_n20 n29_a_n20 183.071
r_30_t0_a_n20 n30__t0_a_n20 n30_a_n20 183.071
r_30_t1_a_n20 n30__t1_a_n20 n30_a_n20 183.071
r_31_t0_a_n20 n31__t0_a_n20 n31_a_n20 183.071
r_31_t1_a_n20 n31__t1_a_n20 n31_a_n20 183.071
r_32_t0_a_n20 n32__t0_a_n20 n32_a_n20 183.071
r_32_t1_a_n20 n32__t1_a_n20 n32_a_n20 183.071
r_7_t0_a_n20 n7__t0_a_n20 n7_a_n20 183.071
r_7_t1_a_n20 n7__t1_a_n20 n7_a_n20 183.071
r_8_t0_a_n20 n8__t0_a_n20 n8_a_n20 183.071
r_8_t1_a_n20 n8__t1_a_n20 n8_a_n20 183.071
r_9_t0_a_n20 n9__t0_a_n20 n9_a_n20 183.071
r_9_t1_a_n20 n9__t1_a_n20 n9_a_n20 183.071
rgnd_t0_a_n20 gnd__t0_a_n20 0 38.2988
rgnd_t1_a_n20 gnd__t1_a_n20 0 33.9576
rgnd_t2_a_n20 gnd__t2_a_n20 0 33.9576
rgnd_t3_a_n20 gnd__t3_a_n20 0 38.2988
rgnd_t4_a_n20 gnd__t4_a_n20 0 38.2988
rgnd_t5_a_n20 gnd__t5_a_n20 0 33.9576
rgnd_t6_a_n20 gnd__t6_a_n20 0 33.9576
rgnd_t7_a_n20 gnd__t7_a_n20 0 38.2988
rgnd_t8_a_n20 gnd__t8_a_n20 0 28.0185
rgnd_t9_a_n20 gnd__t9_a_n20 0 21.7106
rgnd_t10_a_n20 gnd__t10_a_n20 0 21.7106
rgnd_t11_a_n20 gnd__t11_a_n20 0 28.0185
rgnd_t12_a_n20 gnd__t12_a_n20 0 18.9833
rgnd_t13_a_n20 gnd__t13_a_n20 0 6.8325
rgnd_t14_a_n20 gnd__t14_a_n20 0 6.8325
rgnd_t15_a_n20 gnd__t15_a_n20 0 18.9833
rgnd_t16_a_n20 gnd__t16_a_n20 0 24.2409
rgnd_t17_a_n20 gnd__t17_a_n20 0 16.5511
rgnd_t18_a_n20 gnd__t18_a_n20 0 16.5511
rgnd_t19_a_n20 gnd__t19_a_n20 0 24.2409
rgnd_t20_a_n20 gnd__t20_a_n20 0 24.2409
rgnd_t21_a_n20 gnd__t21_a_n20 0 16.5511
rgnd_t22_a_n20 gnd__t22_a_n20 0 16.5511
rgnd_t23_a_n20 gnd__t23_a_n20 0 24.2409
rgnd_t24_a_n20 gnd__t24_a_n20 0 18.9833
rgnd_t25_a_n20 gnd__t25_a_n20 0 6.8325
rgnd_t26_a_n20 gnd__t26_a_n20 0 6.8325
rgnd_t27_a_n20 gnd__t27_a_n20 0 18.9833
rgnd_t28_a_n20 gnd__t28_a_n20 0 28.0185
rgnd_t29_a_n20 gnd__t29_a_n20 0 21.7106
rgnd_t30_a_n20 gnd__t30_a_n20 0 21.7106
rgnd_t31_a_n20 gnd__t31_a_n20 0 28.0185
rbl_0_t0_a_n20 bl_0__t0_a_n20 bl_0_a_n20 14.8304
rbl_0_t1_a_n20 bl_0__t1_a_n20 bl_0_a_n20 10.9301
rbl_0_t2_a_n20 bl_0__t2_a_n20 bl_0_a_n20 14.8304
rbl_0_t3_a_n20 bl_0__t3_a_n20 bl_0_a_n20 10.9301
rbl_1_t0_a_n20 bl_1__t0_a_n20 bl_1_a_n20 10.9301
rbl_1_t1_a_n20 bl_1__t1_a_n20 bl_1_a_n20 14.8304
rbl_1_t2_a_n20 bl_1__t2_a_n20 bl_1_a_n20 14.8304
rbl_1_t3_a_n20 bl_1__t3_a_n20 bl_1_a_n20 10.9301
rbl_2_t0_a_n20 bl_2__t0_a_n20 bl_2_a_n20 10.9301
rbl_2_t1_a_n20 bl_2__t1_a_n20 bl_2_a_n20 14.8304
rbl_2_t2_a_n20 bl_2__t2_a_n20 bl_2_a_n20 14.8304
rbl_2_t3_a_n20 bl_2__t3_a_n20 bl_2_a_n20 10.9301
rbl_3_t0_a_n20 bl_3__t0_a_n20 bl_3_a_n20 14.8304
rbl_3_t1_a_n20 bl_3__t1_a_n20 bl_3_a_n20 10.9301
rbl_3_t2_a_n20 bl_3__t2_a_n20 bl_3_a_n20 14.8304
rbl_3_t3_a_n20 bl_3__t3_a_n20 bl_3_a_n20 10.9301
rrbl_0_t0_a_n20 rbl_0__t0_a_n20 rbl_0_a_n20 36.5601
rrbl_0_t1_a_n20 rbl_0__t1_a_n20 rbl_0_a_n20 36.5601
rrbl_0_t2_a_n20 rbl_0__t2_a_n20 rbl_0_a_n20 2.99444
rrbl_0_t3_a_n20 rbl_0__t3_a_n20 rbl_0_a_n20 2.99444
rrbl_1_t0_a_n20 rbl_1__t0_a_n20 rbl_1_a_n20 36.5601
rrbl_1_t1_a_n20 rbl_1__t1_a_n20 rbl_1_a_n20 36.5601
rrbl_1_t2_a_n20 rbl_1__t2_a_n20 rbl_1_a_n20 2.99444
rrbl_1_t3_a_n20 rbl_1__t3_a_n20 rbl_1_a_n20 2.99444
rrbl_2_t0_a_n20 rbl_2__t0_a_n20 rbl_2_a_n20 36.5601
rrbl_2_t1_a_n20 rbl_2__t1_a_n20 rbl_2_a_n20 36.5601
rrbl_2_t2_a_n20 rbl_2__t2_a_n20 rbl_2_a_n20 2.99444
rrbl_2_t3_a_n20 rbl_2__t3_a_n20 rbl_2_a_n20 2.99444
rrbl_3_t0_a_n20 rbl_3__t0_a_n20 rbl_3_a_n20 36.5601
rrbl_3_t1_a_n20 rbl_3__t1_a_n20 rbl_3_a_n20 36.5601
rrbl_3_t2_a_n20 rbl_3__t2_a_n20 rbl_3_a_n20 2.99444
rrbl_3_t3_a_n20 rbl_3__t3_a_n20 rbl_3_a_n20 2.99444
rrwl_0_t0_a_n20 rwl_0__t0_a_n20 rwl_0_a_n20 38.2618
rrwl_0_t1_a_n20 rwl_0__t1_a_n20 rwl_0_a_n20 12.7539
rrwl_0_t2_a_n20 rwl_0__t2_a_n20 rwl_0_a_n20 38.2618
rrwl_0_t3_a_n20 rwl_0__t3_a_n20 rwl_0_a_n20 12.7539
rrwl_1_t0_a_n20 rwl_1__t0_a_n20 rwl_1_a_n20 38.2618
rrwl_1_t1_a_n20 rwl_1__t1_a_n20 rwl_1_a_n20 12.7539
rrwl_1_t2_a_n20 rwl_1__t2_a_n20 rwl_1_a_n20 12.7539
rrwl_1_t3_a_n20 rwl_1__t3_a_n20 rwl_1_a_n20 38.2618
rrwl_2_t0_a_n20 rwl_2__t0_a_n20 rwl_2_a_n20 12.7539
rrwl_2_t1_a_n20 rwl_2__t1_a_n20 rwl_2_a_n20 12.7539
rrwl_2_t2_a_n20 rwl_2__t2_a_n20 rwl_2_a_n20 38.2618
rrwl_2_t3_a_n20 rwl_2__t3_a_n20 rwl_2_a_n20 38.2618
rrwl_3_t0_a_n20 rwl_3__t0_a_n20 rwl_3_a_n20 38.2618
rrwl_3_t1_a_n20 rwl_3__t1_a_n20 rwl_3_a_n20 12.7539
rrwl_3_t2_a_n20 rwl_3__t2_a_n20 rwl_3_a_n20 12.7539
rrwl_3_t3_a_n20 rwl_3__t3_a_n20 rwl_3_a_n20 38.2618
rwl_0_t0_a_n20 wl_0__t0_a_n20 wl_0_a_n20 245.959
rwl_0_t1_a_n20 wl_0__t1_a_n20 wl_0_a_n20 245.959
rwl_0_t2_a_n20 wl_0__t2_a_n20 wl_0_a_n20 81.9864
rwl_0_t3_a_n20 wl_0__t3_a_n20 wl_0_a_n20 81.9864
rwl_1_t0_a_n20 wl_1__t0_a_n20 wl_1_a_n20 245.959
rwl_1_t1_a_n20 wl_1__t1_a_n20 wl_1_a_n20 81.9864
rwl_1_t2_a_n20 wl_1__t2_a_n20 wl_1_a_n20 81.9864
rwl_1_t3_a_n20 wl_1__t3_a_n20 wl_1_a_n20 245.959
rwl_2_t0_a_n20 wl_2__t0_a_n20 wl_2_a_n20 245.959
rwl_2_t1_a_n20 wl_2__t1_a_n20 wl_2_a_n20 81.9864
rwl_2_t2_a_n20 wl_2__t2_a_n20 wl_2_a_n20 81.9864
rwl_2_t3_a_n20 wl_2__t3_a_n20 wl_2_a_n20 245.959
rwl_3_t0_a_n20 wl_3__t0_a_n20 wl_3_a_n20 245.959
rwl_3_t1_a_n20 wl_3__t1_a_n20 wl_3_a_n20 81.9864
rwl_3_t2_a_n20 wl_3__t2_a_n20 wl_3_a_n20 81.9864
rwl_3_t3_a_n20 wl_3__t3_a_n20 wl_3_a_n20 245.959
c_10_a_n20 n10_a_n20 0 2.91622e-16
c_17_a_n20 n17_a_n20 0 2.91528e-16
c_18_a_n20 n18_a_n20 0 2.91528e-16
c_19_a_n20 n19_a_n20 0 2.91528e-16
c_20_a_n20 n20_a_n20 0 2.91622e-16
c_22_a_n20 n22_a_n20 0 2.91528e-16
c_23_a_n20 n23_a_n20 0 2.91528e-16
c_24_a_n20 n24_a_n20 0 2.91528e-16
c_25_a_n20 n25_a_n20 0 2.91622e-16
c_29_a_n20 n29_a_n20 0 2.91528e-16
c_30_a_n20 n30_a_n20 0 2.91528e-16
c_31_a_n20 n31_a_n20 0 2.91528e-16
c_32_a_n20 n32_a_n20 0 2.91622e-16
c_7_a_n20 n7_a_n20 0 2.91528e-16
c_8_a_n20 n8_a_n20 0 2.91528e-16
c_9_a_n20 n9_a_n20 0 2.91528e-16
cgnd_a_n20 0 0 2.48166e-15
cbl_0_a_n20 bl_0_a_n20 0 4.52661e-16
cbl_1_a_n20 bl_1_a_n20 0 4.52661e-16
cbl_2_a_n20 bl_2_a_n20 0 4.52661e-16
cbl_3_a_n20 bl_3_a_n20 0 4.52661e-16
crbl_0_a_n20 rbl_0_a_n20 0 9.14472e-16
crbl_1_a_n20 rbl_1_a_n20 0 9.14472e-16
crbl_2_a_n20 rbl_2_a_n20 0 9.14472e-16
crbl_3_a_n20 rbl_3_a_n20 0 9.17566e-16
crwl_0_a_n20 rwl_0_a_n20 0 5.19495e-16
crwl_1_a_n20 rwl_1_a_n20 0 5.11719e-16
crwl_2_a_n20 rwl_2_a_n20 0 5.11719e-16
crwl_3_a_n20 rwl_3_a_n20 0 5.19495e-16
cwl_0_a_n20 wl_0_a_n20 0 3.30388e-16
cwl_1_a_n20 wl_1_a_n20 0 3.30388e-16
cwl_2_a_n20 wl_2_a_n20 0 3.30388e-16
cwl_3_a_n20 wl_3_a_n20 0 3.30388e-16
ccc__10__9_a_n20 n10_a_n20 n9_a_n20 1.02e-17
ccc__10_bl_3_a_n20 n10_a_n20 bl_3_a_n20 1.3999e-17
ccc__10_rwl_0_a_n20 n10_a_n20 rwl_0_a_n20 4.335e-18
ccc__17__18_a_n20 n17_a_n20 n18_a_n20 1.02e-17
ccc__17_bl_0_a_n20 n17_a_n20 bl_0_a_n20 8.415e-18
ccc__17_rwl_1_a_n20 n17_a_n20 rwl_1_a_n20 1.3194e-17
ccc__18__19_a_n20 n18_a_n20 n19_a_n20 1.02e-17
ccc__18_bl_1_a_n20 n18_a_n20 bl_1_a_n20 8.415e-18
ccc__18_rwl_1_a_n20 n18_a_n20 rwl_1_a_n20 1.3194e-17
ccc__19__20_a_n20 n19_a_n20 n20_a_n20 1.02e-17
ccc__19_bl_2_a_n20 n19_a_n20 bl_2_a_n20 8.415e-18
ccc__19_rwl_1_a_n20 n19_a_n20 rwl_1_a_n20 1.3194e-17
ccc__20_bl_3_a_n20 n20_a_n20 bl_3_a_n20 8.415e-18
ccc__20_rwl_1_a_n20 n20_a_n20 rwl_1_a_n20 6.655e-18
ccc__22__23_a_n20 n22_a_n20 n23_a_n20 1.02e-17
ccc__22_bl_0_a_n20 n22_a_n20 bl_0_a_n20 8.415e-18
ccc__22_rwl_2_a_n20 n22_a_n20 rwl_2_a_n20 1.3194e-17
ccc__23__24_a_n20 n23_a_n20 n24_a_n20 1.02e-17
ccc__23_bl_1_a_n20 n23_a_n20 bl_1_a_n20 8.415e-18
ccc__23_rwl_2_a_n20 n23_a_n20 rwl_2_a_n20 1.3194e-17
ccc__24__25_a_n20 n24_a_n20 n25_a_n20 1.02e-17
ccc__24_bl_2_a_n20 n24_a_n20 bl_2_a_n20 8.415e-18
ccc__24_rwl_2_a_n20 n24_a_n20 rwl_2_a_n20 1.3194e-17
ccc__25_bl_3_a_n20 n25_a_n20 bl_3_a_n20 8.415e-18
ccc__25_rwl_2_a_n20 n25_a_n20 rwl_2_a_n20 6.655e-18
ccc__29__30_a_n20 n29_a_n20 n30_a_n20 1.02e-17
ccc__29_bl_0_a_n20 n29_a_n20 bl_0_a_n20 8.415e-18
ccc__29_rwl_3_a_n20 n29_a_n20 rwl_3_a_n20 1.3194e-17
ccc__30__31_a_n20 n30_a_n20 n31_a_n20 1.02e-17
ccc__30_bl_1_a_n20 n30_a_n20 bl_1_a_n20 8.415e-18
ccc__30_rwl_3_a_n20 n30_a_n20 rwl_3_a_n20 1.3194e-17
ccc__31__32_a_n20 n31_a_n20 n32_a_n20 1.02e-17
ccc__31_bl_2_a_n20 n31_a_n20 bl_2_a_n20 8.415e-18
ccc__31_rwl_3_a_n20 n31_a_n20 rwl_3_a_n20 1.3194e-17
ccc__32_bl_3_a_n20 n32_a_n20 bl_3_a_n20 8.415e-18
ccc__32_rwl_3_a_n20 n32_a_n20 rwl_3_a_n20 6.655e-18
ccc__7__8_a_n20 n7_a_n20 n8_a_n20 1.02e-17
ccc__7_bl_0_a_n20 n7_a_n20 bl_0_a_n20 1.3999e-17
ccc__7_rwl_0_a_n20 n7_a_n20 rwl_0_a_n20 8.961e-18
ccc__8__9_a_n20 n8_a_n20 n9_a_n20 1.02e-17
ccc__8_bl_1_a_n20 n8_a_n20 bl_1_a_n20 1.3999e-17
ccc__8_rwl_0_a_n20 n8_a_n20 rwl_0_a_n20 8.961e-18
ccc__9_bl_2_a_n20 n9_a_n20 bl_2_a_n20 1.3999e-17
ccc__9_rwl_0_a_n20 n9_a_n20 rwl_0_a_n20 8.961e-18
ccc_bl_0_rbl_0_a_n20 bl_0_a_n20 rbl_0_a_n20 1.88693e-16
ccc_bl_0_rwl_1_a_n20 bl_0_a_n20 rwl_1_a_n20 1.0093e-17
ccc_bl_0_rwl_2_a_n20 bl_0_a_n20 rwl_2_a_n20 1.0093e-17
ccc_bl_1_rbl_0_a_n20 bl_1_a_n20 rbl_0_a_n20 1.633e-16
ccc_bl_1_rbl_1_a_n20 bl_1_a_n20 rbl_1_a_n20 1.88693e-16
ccc_bl_1_rwl_1_a_n20 bl_1_a_n20 rwl_1_a_n20 1.0093e-17
ccc_bl_1_rwl_2_a_n20 bl_1_a_n20 rwl_2_a_n20 1.0093e-17
ccc_bl_2_rbl_1_a_n20 bl_2_a_n20 rbl_1_a_n20 1.633e-16
ccc_bl_2_rbl_2_a_n20 bl_2_a_n20 rbl_2_a_n20 1.88693e-16
ccc_bl_2_rwl_1_a_n20 bl_2_a_n20 rwl_1_a_n20 1.0093e-17
ccc_bl_2_rwl_2_a_n20 bl_2_a_n20 rwl_2_a_n20 1.0093e-17
ccc_bl_3_rbl_2_a_n20 bl_3_a_n20 rbl_2_a_n20 1.633e-16
ccc_bl_3_rbl_3_a_n20 bl_3_a_n20 rbl_3_a_n20 1.88693e-16
ccc_bl_3_rwl_1_a_n20 bl_3_a_n20 rwl_1_a_n20 1.0093e-17
ccc_bl_3_rwl_2_a_n20 bl_3_a_n20 rwl_2_a_n20 1.0093e-17
ccc_rbl_0_rbl_1_a_n20 rbl_0_a_n20 rbl_1_a_n20 3.432e-17
ccc_rbl_0_rwl_0_a_n20 rbl_0_a_n20 rwl_0_a_n20 4.9752e-17
ccc_rbl_0_rwl_1_a_n20 rbl_0_a_n20 rwl_1_a_n20 4.9752e-17
ccc_rbl_0_rwl_2_a_n20 rbl_0_a_n20 rwl_2_a_n20 4.9752e-17
ccc_rbl_0_rwl_3_a_n20 rbl_0_a_n20 rwl_3_a_n20 4.9752e-17
ccc_rbl_1_rbl_2_a_n20 rbl_1_a_n20 rbl_2_a_n20 3.432e-17
ccc_rbl_1_rwl_0_a_n20 rbl_1_a_n20 rwl_0_a_n20 4.9752e-17
ccc_rbl_1_rwl_1_a_n20 rbl_1_a_n20 rwl_1_a_n20 4.9752e-17
ccc_rbl_1_rwl_2_a_n20 rbl_1_a_n20 rwl_2_a_n20 4.9752e-17
ccc_rbl_1_rwl_3_a_n20 rbl_1_a_n20 rwl_3_a_n20 4.9752e-17
ccc_rbl_2_rbl_3_a_n20 rbl_2_a_n20 rbl_3_a_n20 3.432e-17
ccc_rbl_2_rwl_0_a_n20 rbl_2_a_n20 rwl_0_a_n20 4.9752e-17
ccc_rbl_2_rwl_1_a_n20 rbl_2_a_n20 rwl_1_a_n20 4.9752e-17
ccc_rbl_2_rwl_2_a_n20 rbl_2_a_n20 rwl_2_a_n20 4.9752e-17
ccc_rbl_2_rwl_3_a_n20 rbl_2_a_n20 rwl_3_a_n20 4.9752e-17
ccc_rbl_3_rwl_0_a_n20 rbl_3_a_n20 rwl_0_a_n20 3.3407e-17
ccc_rbl_3_rwl_1_a_n20 rbl_3_a_n20 rwl_1_a_n20 3.3407e-17
ccc_rbl_3_rwl_2_a_n20 rbl_3_a_n20 rwl_2_a_n20 3.3407e-17
ccc_rbl_3_rwl_3_a_n20 rbl_3_a_n20 rwl_3_a_n20 3.3407e-17
vdw_a_n20_0 wl_0_a_n20 0 dc 0
vdr_a_n20_0 rwl_0_a_n20 vdd dc 0
vdw_a_n20_1 wl_1_a_n20 0 dc 0
vdr_a_n20_1 rwl_1_a_n20 vdd dc 0
vdw_a_n20_2 wl_2_a_n20 0 dc 0
vdr_a_n20_2 rwl_2_a_n20 vdd dc 0
vdw_a_n20_3 wl_3_a_n20 0 dc 0
vdr_a_n20_3 rwl_3_a_n20 vdd dc 0
vdb_a_n20_0 bl_0_a_n20 0 dc 0
vdp_a_n20_0 rbl_0_a_n20 vrbl dc 0
vdb_a_n20_1 bl_1_a_n20 0 dc 0
vdp_a_n20_1 rbl_1_a_n20 vrbl dc 0
vdb_a_n20_2 bl_2_a_n20 0 dc 0
vdp_a_n20_2 rbl_2_a_n20 vrbl dc 0
vdb_a_n20_3 bl_3_a_n20 0 dc 0
vdp_a_n20_3 rbl_3_a_n20 vrbl dc 0
vdn_a_n20_n7 n7_a_n20 0 dc 1
vdn_a_n20_n8 n8_a_n20 0 dc 1
vdn_a_n20_n9 n9_a_n20 0 dc 1
vdn_a_n20_n10 n10_a_n20 0 dc 1
vdn_a_n20_n17 n17_a_n20 0 dc 1
vdn_a_n20_n18 n18_a_n20 0 dc 1
vdn_a_n20_n19 n19_a_n20 0 dc 1
vdn_a_n20_n22 n22_a_n20 0 dc 1
vdn_a_n20_n23 n23_a_n20 0 dc 1
vdn_a_n20_n24 n24_a_n20 0 dc 1
vdn_a_n20_n25 n25_a_n20 0 dc 1
vdn_a_n20_n29 n29_a_n20 0 dc 1
vdn_a_n20_n30 n30_a_n20 0 dc 1
vdn_a_n20_n31 n31_a_n20 0 dc 1
vdn_a_n20_n32 n32_a_n20 0 dc 1
bdr_a_n20 n20_a_n20 0 i=5e-08*min(1,max(0,(time-1e-09)/0.2n))*0.5*(1+tanh((v(n20_a_n20)-0.05)/0.01))

* ---- instance a_n22: variant a, probed storage node \$22 ----
xm1_a_n22 rwl_0__t2_a_n22 n7__t0_a_n22 rbl_0__t0_a_n22 gnd__t0_a_n22 sky130_fd_pr__nfet_01v8 L=0.15 W=0.42 nf=1 ad=0.1197 as=0.1197 pd=1.41 ps=1.41 mult=1 m=1
xm2_a_n22 rwl_0__t3_a_n22 n8__t1_a_n22 rbl_1__t1_a_n22 gnd__t1_a_n22 sky130_fd_pr__nfet_01v8 L=0.15 W=0.42 nf=1 ad=0.1197 as=0.1197 pd=1.41 ps=1.41 mult=1 m=1
xm3_a_n22 rwl_0__t1_a_n22 n9__t1_a_n22 rbl_2__t1_a_n22 gnd__t2_a_n22 sky130_fd_pr__nfet_01v8 L=0.15 W=0.42 nf=1 ad=0.1197 as=0.1197 pd=1.41 ps=1.41 mult=1 m=1
xm4_a_n22 rwl_0__t0_a_n22 n10__t1_a_n22 rbl_3__t1_a_n22 gnd__t3_a_n22 sky130_fd_pr__nfet_01v8 L=0.15 W=0.42 nf=1 ad=0.1197 as=0.1197 pd=1.41 ps=1.41 mult=1 m=1
xm5_a_n22 bl_0__t0_a_n22 wl_0__t0_a_n22 n7__t1_a_n22 gnd__t8_a_n22 sky130_fd_pr__nfet_01v8 L=0.15 W=0.42 nf=1 ad=0.0588 as=0.1197 pd=0.7 ps=1.41 mult=1 m=1
xm6_a_n22 n17__t0_a_n22 wl_1__t0_a_n22 bl_0__t1_a_n22 gnd__t20_a_n22 sky130_fd_pr__nfet_01v8 L=0.15 W=0.42 nf=1 ad=0.1197 as=0.0588 pd=1.41 ps=0.7 mult=1 m=1
xm7_a_n22 bl_1__t2_a_n22 wl_0__t3_a_n22 n8__t0_a_n22 gnd__t9_a_n22 sky130_fd_pr__nfet_01v8 L=0.15 W=0.42 nf=1 ad=0.0588 as=0.1197 pd=0.7 ps=1.41 mult=1 m=1
xm8_a_n22 n18__t0_a_n22 wl_1__t1_a_n22 bl_1__t0_a_n22 gnd__t21_a_n22 sky130_fd_pr__nfet_01v8 L=0.15 W=0.42 nf=1 ad=0.1197 as=0.0588 pd=1.41 ps=0.7 mult=1 m=1
xm9_a_n22 bl_2__t2_a_n22 wl_0__t2_a_n22 n9__t0_a_n22 gnd__t10_a_n22 sky130_fd_pr__nfet_01v8 L=0.15 W=0.42 nf=1 ad=0.0588 as=0.1197 pd=0.7 ps=1.41 mult=1 m=1
xm10_a_n22 n19__t0_a_n22 wl_1__t2_a_n22 bl_2__t0_a_n22 gnd__t22_a_n22 sky130_fd_pr__nfet_01v8 L=0.15 W=0.42 nf=1 ad=0.1197 as=0.0588 pd=1.41 ps=0.7 mult=1 m=1
xm11_a_n22 bl_3__t2_a_n22 wl_0__t1_a_n22 n10__t0_a_n22 gnd__t11_a_n22 sky130_fd_pr__nfet_01v8 L=0.15 W=0.42 nf=1 ad=0.0588 as=0.1197 pd=0.7 ps=1.41 mult=1 m=1
xm12_a_n22 n20__t0_a_n22 wl_1__t3_a_n22 bl_3__t1_a_n22 gnd__t23_a_n22 sky130_fd_pr__nfet_01v8 L=0.15 W=0.42 nf=1 ad=0.1197 as=0.0588 pd=1.41 ps=0.7 mult=1 m=1
xm13_a_n22 rbl_0__t3_a_n22 n17__t1_a_n22 rwl_1__t0_a_n22 gnd__t12_a_n22 sky130_fd_pr__nfet_01v8 L=0.15 W=0.42 nf=1 ad=0.0588 as=0.1197 pd=0.7 ps=1.41 mult=1 m=1
xm14_a_n22 rwl_2__t3_a_n22 n22__t0_a_n22 rbl_0__t2_a_n22 gnd__t24_a_n22 sky130_fd_pr__nfet_01v8 L=0.15 W=0.42 nf=1 ad=0.1197 as=0.0588 pd=1.41 ps=0.7 mult=1 m=1
xm15_a_n22 rbl_1__t3_a_n22 n18__t1_a_n22 rwl_1__t1_a_n22 gnd__t13_a_n22 sky130_fd_pr__nfet_01v8 L=0.15 W=0.42 nf=1 ad=0.0588 as=0.1197 pd=0.7 ps=1.41 mult=1 m=1
xm16_a_n22 rwl_2__t0_a_n22 n23__t0_a_n22 rbl_1__t2_a_n22 gnd__t25_a_n22 sky130_fd_pr__nfet_01v8 L=0.15 W=0.42 nf=1 ad=0.1197 as=0.0588 pd=1.41 ps=0.7 mult=1 m=1
xm17_a_n22 rbl_2__t3_a_n22 n19__t1_a_n22 rwl_1__t2_a_n22 gnd__t14_a_n22 sky130_fd_pr__nfet_01v8 L=0.15 W=0.42 nf=1 ad=0.0588 as=0.1197 pd=0.7 ps=1.41 mult=1 m=1
xm18_a_n22 rwl_2__t1_a_n22 n24__t0_a_n22 rbl_2__t2_a_n22 gnd__t26_a_n22 sky130_fd_pr__nfet_01v8 L=0.15 W=0.42 nf=1 ad=0.1197 as=0.0588 pd=1.41 ps=0.7 mult=1 m=1
xm19_a_n22 rbl_3__t3_a_n22 n20__t1_a_n22 rwl_1__t3_a_n22 gnd__t15_a_n22 sky130_fd_pr__nfet_01v8 L=0.15 W=0.42 nf=1 ad=0.0588 as=0.1197 pd=0.7 ps=1.41 mult=1 m=1
xm20_a_n22 rwl_2__t2_a_n22 n25__t0_a_n22 rbl_3__t2_a_n22 gnd__t27_a_n22 sky130_fd_pr__nfet_01v8 L=0.15 W=0.42 nf=1 ad=0.1197 as=0.0588 pd=1.41 ps=0.7 mult=1 m=1
xm21_a_n22 bl_0__t3_a_n22 wl_2__t0_a_n22 n22__t1_a_n22 gnd__t16_a_n22 sky130_fd_pr__nfet_01v8 L=0.15 W=0.42 nf=1 ad=0.0588 as=0.1197 pd=0.7 ps=1.41 mult=1 m=1
xm22_a_n22 n29__t0_a_n22 wl_3__t3_a_n22 bl_0__t2_a_n22 gnd__t28_a_n22 sky130_fd_pr__nfet_01v8 L=0.15 W=0.42 nf=1 ad=0.1197 as=0.0588 pd=1.41 ps=0.7 mult=1 m=1
xm23_a_n22 bl_1__t3_a_n22 wl_2__t1_a_n22 n23__t1_a_n22 gnd__t17_a_n22 sky130_fd_pr__nfet_01v8 L=0.15 W=0.42 nf=1 ad=0.0588 as=0.1197 pd=0.7 ps=1.41 mult=1 m=1
xm24_a_n22 n30__t0_a_n22 wl_3__t2_a_n22 bl_1__t1_a_n22 gnd__t29_a_n22 sky130_fd_pr__nfet_01v8 L=0.15 W=0.42 nf=1 ad=0.1197 as=0.0588 pd=1.41 ps=0.7 mult=1 m=1
xm25_a_n22 bl_2__t3_a_n22 wl_2__t2_a_n22 n24__t1_a_n22 gnd__t18_a_n22 sky130_fd_pr__nfet_01v8 L=0.15 W=0.42 nf=1 ad=0.0588 as=0.1197 pd=0.7 ps=1.41 mult=1 m=1
xm26_a_n22 n31__t0_a_n22 wl_3__t1_a_n22 bl_2__t1_a_n22 gnd__t30_a_n22 sky130_fd_pr__nfet_01v8 L=0.15 W=0.42 nf=1 ad=0.1197 as=0.0588 pd=1.41 ps=0.7 mult=1 m=1
xm27_a_n22 bl_3__t3_a_n22 wl_2__t3_a_n22 n25__t1_a_n22 gnd__t19_a_n22 sky130_fd_pr__nfet_01v8 L=0.15 W=0.42 nf=1 ad=0.0588 as=0.1197 pd=0.7 ps=1.41 mult=1 m=1
xm28_a_n22 n32__t0_a_n22 wl_3__t0_a_n22 bl_3__t0_a_n22 gnd__t31_a_n22 sky130_fd_pr__nfet_01v8 L=0.15 W=0.42 nf=1 ad=0.1197 as=0.0588 pd=1.41 ps=0.7 mult=1 m=1
xm29_a_n22 rbl_0__t1_a_n22 n29__t1_a_n22 rwl_3__t0_a_n22 gnd__t4_a_n22 sky130_fd_pr__nfet_01v8 L=0.15 W=0.42 nf=1 ad=0.1197 as=0.1197 pd=1.41 ps=1.41 mult=1 m=1
xm30_a_n22 rbl_1__t0_a_n22 n30__t1_a_n22 rwl_3__t1_a_n22 gnd__t5_a_n22 sky130_fd_pr__nfet_01v8 L=0.15 W=0.42 nf=1 ad=0.1197 as=0.1197 pd=1.41 ps=1.41 mult=1 m=1
xm31_a_n22 rbl_2__t0_a_n22 n31__t1_a_n22 rwl_3__t2_a_n22 gnd__t6_a_n22 sky130_fd_pr__nfet_01v8 L=0.15 W=0.42 nf=1 ad=0.1197 as=0.1197 pd=1.41 ps=1.41 mult=1 m=1
xm32_a_n22 rbl_3__t0_a_n22 n32__t1_a_n22 rwl_3__t3_a_n22 gnd__t7_a_n22 sky130_fd_pr__nfet_01v8 L=0.15 W=0.42 nf=1 ad=0.1197 as=0.1197 pd=1.41 ps=1.41 mult=1 m=1
r_10_t0_a_n22 n10__t0_a_n22 n10_a_n22 183.071
r_10_t1_a_n22 n10__t1_a_n22 n10_a_n22 183.071
r_17_t0_a_n22 n17__t0_a_n22 n17_a_n22 183.071
r_17_t1_a_n22 n17__t1_a_n22 n17_a_n22 183.071
r_18_t0_a_n22 n18__t0_a_n22 n18_a_n22 183.071
r_18_t1_a_n22 n18__t1_a_n22 n18_a_n22 183.071
r_19_t0_a_n22 n19__t0_a_n22 n19_a_n22 183.071
r_19_t1_a_n22 n19__t1_a_n22 n19_a_n22 183.071
r_20_t0_a_n22 n20__t0_a_n22 n20_a_n22 183.071
r_20_t1_a_n22 n20__t1_a_n22 n20_a_n22 183.071
r_22_t0_a_n22 n22__t0_a_n22 n22_a_n22 183.071
r_22_t1_a_n22 n22__t1_a_n22 n22_a_n22 183.071
r_23_t0_a_n22 n23__t0_a_n22 n23_a_n22 183.071
r_23_t1_a_n22 n23__t1_a_n22 n23_a_n22 183.071
r_24_t0_a_n22 n24__t0_a_n22 n24_a_n22 183.071
r_24_t1_a_n22 n24__t1_a_n22 n24_a_n22 183.071
r_25_t0_a_n22 n25__t0_a_n22 n25_a_n22 183.071
r_25_t1_a_n22 n25__t1_a_n22 n25_a_n22 183.071
r_29_t0_a_n22 n29__t0_a_n22 n29_a_n22 183.071
r_29_t1_a_n22 n29__t1_a_n22 n29_a_n22 183.071
r_30_t0_a_n22 n30__t0_a_n22 n30_a_n22 183.071
r_30_t1_a_n22 n30__t1_a_n22 n30_a_n22 183.071
r_31_t0_a_n22 n31__t0_a_n22 n31_a_n22 183.071
r_31_t1_a_n22 n31__t1_a_n22 n31_a_n22 183.071
r_32_t0_a_n22 n32__t0_a_n22 n32_a_n22 183.071
r_32_t1_a_n22 n32__t1_a_n22 n32_a_n22 183.071
r_7_t0_a_n22 n7__t0_a_n22 n7_a_n22 183.071
r_7_t1_a_n22 n7__t1_a_n22 n7_a_n22 183.071
r_8_t0_a_n22 n8__t0_a_n22 n8_a_n22 183.071
r_8_t1_a_n22 n8__t1_a_n22 n8_a_n22 183.071
r_9_t0_a_n22 n9__t0_a_n22 n9_a_n22 183.071
r_9_t1_a_n22 n9__t1_a_n22 n9_a_n22 183.071
rgnd_t0_a_n22 gnd__t0_a_n22 0 38.2988
rgnd_t1_a_n22 gnd__t1_a_n22 0 33.9576
rgnd_t2_a_n22 gnd__t2_a_n22 0 33.9576
rgnd_t3_a_n22 gnd__t3_a_n22 0 38.2988
rgnd_t4_a_n22 gnd__t4_a_n22 0 38.2988
rgnd_t5_a_n22 gnd__t5_a_n22 0 33.9576
rgnd_t6_a_n22 gnd__t6_a_n22 0 33.9576
rgnd_t7_a_n22 gnd__t7_a_n22 0 38.2988
rgnd_t8_a_n22 gnd__t8_a_n22 0 28.0185
rgnd_t9_a_n22 gnd__t9_a_n22 0 21.7106
rgnd_t10_a_n22 gnd__t10_a_n22 0 21.7106
rgnd_t11_a_n22 gnd__t11_a_n22 0 28.0185
rgnd_t12_a_n22 gnd__t12_a_n22 0 18.9833
rgnd_t13_a_n22 gnd__t13_a_n22 0 6.8325
rgnd_t14_a_n22 gnd__t14_a_n22 0 6.8325
rgnd_t15_a_n22 gnd__t15_a_n22 0 18.9833
rgnd_t16_a_n22 gnd__t16_a_n22 0 24.2409
rgnd_t17_a_n22 gnd__t17_a_n22 0 16.5511
rgnd_t18_a_n22 gnd__t18_a_n22 0 16.5511
rgnd_t19_a_n22 gnd__t19_a_n22 0 24.2409
rgnd_t20_a_n22 gnd__t20_a_n22 0 24.2409
rgnd_t21_a_n22 gnd__t21_a_n22 0 16.5511
rgnd_t22_a_n22 gnd__t22_a_n22 0 16.5511
rgnd_t23_a_n22 gnd__t23_a_n22 0 24.2409
rgnd_t24_a_n22 gnd__t24_a_n22 0 18.9833
rgnd_t25_a_n22 gnd__t25_a_n22 0 6.8325
rgnd_t26_a_n22 gnd__t26_a_n22 0 6.8325
rgnd_t27_a_n22 gnd__t27_a_n22 0 18.9833
rgnd_t28_a_n22 gnd__t28_a_n22 0 28.0185
rgnd_t29_a_n22 gnd__t29_a_n22 0 21.7106
rgnd_t30_a_n22 gnd__t30_a_n22 0 21.7106
rgnd_t31_a_n22 gnd__t31_a_n22 0 28.0185
rbl_0_t0_a_n22 bl_0__t0_a_n22 bl_0_a_n22 14.8304
rbl_0_t1_a_n22 bl_0__t1_a_n22 bl_0_a_n22 10.9301
rbl_0_t2_a_n22 bl_0__t2_a_n22 bl_0_a_n22 14.8304
rbl_0_t3_a_n22 bl_0__t3_a_n22 bl_0_a_n22 10.9301
rbl_1_t0_a_n22 bl_1__t0_a_n22 bl_1_a_n22 10.9301
rbl_1_t1_a_n22 bl_1__t1_a_n22 bl_1_a_n22 14.8304
rbl_1_t2_a_n22 bl_1__t2_a_n22 bl_1_a_n22 14.8304
rbl_1_t3_a_n22 bl_1__t3_a_n22 bl_1_a_n22 10.9301
rbl_2_t0_a_n22 bl_2__t0_a_n22 bl_2_a_n22 10.9301
rbl_2_t1_a_n22 bl_2__t1_a_n22 bl_2_a_n22 14.8304
rbl_2_t2_a_n22 bl_2__t2_a_n22 bl_2_a_n22 14.8304
rbl_2_t3_a_n22 bl_2__t3_a_n22 bl_2_a_n22 10.9301
rbl_3_t0_a_n22 bl_3__t0_a_n22 bl_3_a_n22 14.8304
rbl_3_t1_a_n22 bl_3__t1_a_n22 bl_3_a_n22 10.9301
rbl_3_t2_a_n22 bl_3__t2_a_n22 bl_3_a_n22 14.8304
rbl_3_t3_a_n22 bl_3__t3_a_n22 bl_3_a_n22 10.9301
rrbl_0_t0_a_n22 rbl_0__t0_a_n22 rbl_0_a_n22 36.5601
rrbl_0_t1_a_n22 rbl_0__t1_a_n22 rbl_0_a_n22 36.5601
rrbl_0_t2_a_n22 rbl_0__t2_a_n22 rbl_0_a_n22 2.99444
rrbl_0_t3_a_n22 rbl_0__t3_a_n22 rbl_0_a_n22 2.99444
rrbl_1_t0_a_n22 rbl_1__t0_a_n22 rbl_1_a_n22 36.5601
rrbl_1_t1_a_n22 rbl_1__t1_a_n22 rbl_1_a_n22 36.5601
rrbl_1_t2_a_n22 rbl_1__t2_a_n22 rbl_1_a_n22 2.99444
rrbl_1_t3_a_n22 rbl_1__t3_a_n22 rbl_1_a_n22 2.99444
rrbl_2_t0_a_n22 rbl_2__t0_a_n22 rbl_2_a_n22 36.5601
rrbl_2_t1_a_n22 rbl_2__t1_a_n22 rbl_2_a_n22 36.5601
rrbl_2_t2_a_n22 rbl_2__t2_a_n22 rbl_2_a_n22 2.99444
rrbl_2_t3_a_n22 rbl_2__t3_a_n22 rbl_2_a_n22 2.99444
rrbl_3_t0_a_n22 rbl_3__t0_a_n22 rbl_3_a_n22 36.5601
rrbl_3_t1_a_n22 rbl_3__t1_a_n22 rbl_3_a_n22 36.5601
rrbl_3_t2_a_n22 rbl_3__t2_a_n22 rbl_3_a_n22 2.99444
rrbl_3_t3_a_n22 rbl_3__t3_a_n22 rbl_3_a_n22 2.99444
rrwl_0_t0_a_n22 rwl_0__t0_a_n22 rwl_0_a_n22 38.2618
rrwl_0_t1_a_n22 rwl_0__t1_a_n22 rwl_0_a_n22 12.7539
rrwl_0_t2_a_n22 rwl_0__t2_a_n22 rwl_0_a_n22 38.2618
rrwl_0_t3_a_n22 rwl_0__t3_a_n22 rwl_0_a_n22 12.7539
rrwl_1_t0_a_n22 rwl_1__t0_a_n22 rwl_1_a_n22 38.2618
rrwl_1_t1_a_n22 rwl_1__t1_a_n22 rwl_1_a_n22 12.7539
rrwl_1_t2_a_n22 rwl_1__t2_a_n22 rwl_1_a_n22 12.7539
rrwl_1_t3_a_n22 rwl_1__t3_a_n22 rwl_1_a_n22 38.2618
rrwl_2_t0_a_n22 rwl_2__t0_a_n22 rwl_2_a_n22 12.7539
rrwl_2_t1_a_n22 rwl_2__t1_a_n22 rwl_2_a_n22 12.7539
rrwl_2_t2_a_n22 rwl_2__t2_a_n22 rwl_2_a_n22 38.2618
rrwl_2_t3_a_n22 rwl_2__t3_a_n22 rwl_2_a_n22 38.2618
rrwl_3_t0_a_n22 rwl_3__t0_a_n22 rwl_3_a_n22 38.2618
rrwl_3_t1_a_n22 rwl_3__t1_a_n22 rwl_3_a_n22 12.7539
rrwl_3_t2_a_n22 rwl_3__t2_a_n22 rwl_3_a_n22 12.7539
rrwl_3_t3_a_n22 rwl_3__t3_a_n22 rwl_3_a_n22 38.2618
rwl_0_t0_a_n22 wl_0__t0_a_n22 wl_0_a_n22 245.959
rwl_0_t1_a_n22 wl_0__t1_a_n22 wl_0_a_n22 245.959
rwl_0_t2_a_n22 wl_0__t2_a_n22 wl_0_a_n22 81.9864
rwl_0_t3_a_n22 wl_0__t3_a_n22 wl_0_a_n22 81.9864
rwl_1_t0_a_n22 wl_1__t0_a_n22 wl_1_a_n22 245.959
rwl_1_t1_a_n22 wl_1__t1_a_n22 wl_1_a_n22 81.9864
rwl_1_t2_a_n22 wl_1__t2_a_n22 wl_1_a_n22 81.9864
rwl_1_t3_a_n22 wl_1__t3_a_n22 wl_1_a_n22 245.959
rwl_2_t0_a_n22 wl_2__t0_a_n22 wl_2_a_n22 245.959
rwl_2_t1_a_n22 wl_2__t1_a_n22 wl_2_a_n22 81.9864
rwl_2_t2_a_n22 wl_2__t2_a_n22 wl_2_a_n22 81.9864
rwl_2_t3_a_n22 wl_2__t3_a_n22 wl_2_a_n22 245.959
rwl_3_t0_a_n22 wl_3__t0_a_n22 wl_3_a_n22 245.959
rwl_3_t1_a_n22 wl_3__t1_a_n22 wl_3_a_n22 81.9864
rwl_3_t2_a_n22 wl_3__t2_a_n22 wl_3_a_n22 81.9864
rwl_3_t3_a_n22 wl_3__t3_a_n22 wl_3_a_n22 245.959
c_10_a_n22 n10_a_n22 0 2.91622e-16
c_17_a_n22 n17_a_n22 0 2.91528e-16
c_18_a_n22 n18_a_n22 0 2.91528e-16
c_19_a_n22 n19_a_n22 0 2.91528e-16
c_20_a_n22 n20_a_n22 0 2.91622e-16
c_22_a_n22 n22_a_n22 0 2.91528e-16
c_23_a_n22 n23_a_n22 0 2.91528e-16
c_24_a_n22 n24_a_n22 0 2.91528e-16
c_25_a_n22 n25_a_n22 0 2.91622e-16
c_29_a_n22 n29_a_n22 0 2.91528e-16
c_30_a_n22 n30_a_n22 0 2.91528e-16
c_31_a_n22 n31_a_n22 0 2.91528e-16
c_32_a_n22 n32_a_n22 0 2.91622e-16
c_7_a_n22 n7_a_n22 0 2.91528e-16
c_8_a_n22 n8_a_n22 0 2.91528e-16
c_9_a_n22 n9_a_n22 0 2.91528e-16
cgnd_a_n22 0 0 2.48166e-15
cbl_0_a_n22 bl_0_a_n22 0 4.52661e-16
cbl_1_a_n22 bl_1_a_n22 0 4.52661e-16
cbl_2_a_n22 bl_2_a_n22 0 4.52661e-16
cbl_3_a_n22 bl_3_a_n22 0 4.52661e-16
crbl_0_a_n22 rbl_0_a_n22 0 9.14472e-16
crbl_1_a_n22 rbl_1_a_n22 0 9.14472e-16
crbl_2_a_n22 rbl_2_a_n22 0 9.14472e-16
crbl_3_a_n22 rbl_3_a_n22 0 9.17566e-16
crwl_0_a_n22 rwl_0_a_n22 0 5.19495e-16
crwl_1_a_n22 rwl_1_a_n22 0 5.11719e-16
crwl_2_a_n22 rwl_2_a_n22 0 5.11719e-16
crwl_3_a_n22 rwl_3_a_n22 0 5.19495e-16
cwl_0_a_n22 wl_0_a_n22 0 3.30388e-16
cwl_1_a_n22 wl_1_a_n22 0 3.30388e-16
cwl_2_a_n22 wl_2_a_n22 0 3.30388e-16
cwl_3_a_n22 wl_3_a_n22 0 3.30388e-16
ccc__10__9_a_n22 n10_a_n22 n9_a_n22 1.02e-17
ccc__10_bl_3_a_n22 n10_a_n22 bl_3_a_n22 1.3999e-17
ccc__10_rwl_0_a_n22 n10_a_n22 rwl_0_a_n22 4.335e-18
ccc__17__18_a_n22 n17_a_n22 n18_a_n22 1.02e-17
ccc__17_bl_0_a_n22 n17_a_n22 bl_0_a_n22 8.415e-18
ccc__17_rwl_1_a_n22 n17_a_n22 rwl_1_a_n22 1.3194e-17
ccc__18__19_a_n22 n18_a_n22 n19_a_n22 1.02e-17
ccc__18_bl_1_a_n22 n18_a_n22 bl_1_a_n22 8.415e-18
ccc__18_rwl_1_a_n22 n18_a_n22 rwl_1_a_n22 1.3194e-17
ccc__19__20_a_n22 n19_a_n22 n20_a_n22 1.02e-17
ccc__19_bl_2_a_n22 n19_a_n22 bl_2_a_n22 8.415e-18
ccc__19_rwl_1_a_n22 n19_a_n22 rwl_1_a_n22 1.3194e-17
ccc__20_bl_3_a_n22 n20_a_n22 bl_3_a_n22 8.415e-18
ccc__20_rwl_1_a_n22 n20_a_n22 rwl_1_a_n22 6.655e-18
ccc__22__23_a_n22 n22_a_n22 n23_a_n22 1.02e-17
ccc__22_bl_0_a_n22 n22_a_n22 bl_0_a_n22 8.415e-18
ccc__22_rwl_2_a_n22 n22_a_n22 rwl_2_a_n22 1.3194e-17
ccc__23__24_a_n22 n23_a_n22 n24_a_n22 1.02e-17
ccc__23_bl_1_a_n22 n23_a_n22 bl_1_a_n22 8.415e-18
ccc__23_rwl_2_a_n22 n23_a_n22 rwl_2_a_n22 1.3194e-17
ccc__24__25_a_n22 n24_a_n22 n25_a_n22 1.02e-17
ccc__24_bl_2_a_n22 n24_a_n22 bl_2_a_n22 8.415e-18
ccc__24_rwl_2_a_n22 n24_a_n22 rwl_2_a_n22 1.3194e-17
ccc__25_bl_3_a_n22 n25_a_n22 bl_3_a_n22 8.415e-18
ccc__25_rwl_2_a_n22 n25_a_n22 rwl_2_a_n22 6.655e-18
ccc__29__30_a_n22 n29_a_n22 n30_a_n22 1.02e-17
ccc__29_bl_0_a_n22 n29_a_n22 bl_0_a_n22 8.415e-18
ccc__29_rwl_3_a_n22 n29_a_n22 rwl_3_a_n22 1.3194e-17
ccc__30__31_a_n22 n30_a_n22 n31_a_n22 1.02e-17
ccc__30_bl_1_a_n22 n30_a_n22 bl_1_a_n22 8.415e-18
ccc__30_rwl_3_a_n22 n30_a_n22 rwl_3_a_n22 1.3194e-17
ccc__31__32_a_n22 n31_a_n22 n32_a_n22 1.02e-17
ccc__31_bl_2_a_n22 n31_a_n22 bl_2_a_n22 8.415e-18
ccc__31_rwl_3_a_n22 n31_a_n22 rwl_3_a_n22 1.3194e-17
ccc__32_bl_3_a_n22 n32_a_n22 bl_3_a_n22 8.415e-18
ccc__32_rwl_3_a_n22 n32_a_n22 rwl_3_a_n22 6.655e-18
ccc__7__8_a_n22 n7_a_n22 n8_a_n22 1.02e-17
ccc__7_bl_0_a_n22 n7_a_n22 bl_0_a_n22 1.3999e-17
ccc__7_rwl_0_a_n22 n7_a_n22 rwl_0_a_n22 8.961e-18
ccc__8__9_a_n22 n8_a_n22 n9_a_n22 1.02e-17
ccc__8_bl_1_a_n22 n8_a_n22 bl_1_a_n22 1.3999e-17
ccc__8_rwl_0_a_n22 n8_a_n22 rwl_0_a_n22 8.961e-18
ccc__9_bl_2_a_n22 n9_a_n22 bl_2_a_n22 1.3999e-17
ccc__9_rwl_0_a_n22 n9_a_n22 rwl_0_a_n22 8.961e-18
ccc_bl_0_rbl_0_a_n22 bl_0_a_n22 rbl_0_a_n22 1.88693e-16
ccc_bl_0_rwl_1_a_n22 bl_0_a_n22 rwl_1_a_n22 1.0093e-17
ccc_bl_0_rwl_2_a_n22 bl_0_a_n22 rwl_2_a_n22 1.0093e-17
ccc_bl_1_rbl_0_a_n22 bl_1_a_n22 rbl_0_a_n22 1.633e-16
ccc_bl_1_rbl_1_a_n22 bl_1_a_n22 rbl_1_a_n22 1.88693e-16
ccc_bl_1_rwl_1_a_n22 bl_1_a_n22 rwl_1_a_n22 1.0093e-17
ccc_bl_1_rwl_2_a_n22 bl_1_a_n22 rwl_2_a_n22 1.0093e-17
ccc_bl_2_rbl_1_a_n22 bl_2_a_n22 rbl_1_a_n22 1.633e-16
ccc_bl_2_rbl_2_a_n22 bl_2_a_n22 rbl_2_a_n22 1.88693e-16
ccc_bl_2_rwl_1_a_n22 bl_2_a_n22 rwl_1_a_n22 1.0093e-17
ccc_bl_2_rwl_2_a_n22 bl_2_a_n22 rwl_2_a_n22 1.0093e-17
ccc_bl_3_rbl_2_a_n22 bl_3_a_n22 rbl_2_a_n22 1.633e-16
ccc_bl_3_rbl_3_a_n22 bl_3_a_n22 rbl_3_a_n22 1.88693e-16
ccc_bl_3_rwl_1_a_n22 bl_3_a_n22 rwl_1_a_n22 1.0093e-17
ccc_bl_3_rwl_2_a_n22 bl_3_a_n22 rwl_2_a_n22 1.0093e-17
ccc_rbl_0_rbl_1_a_n22 rbl_0_a_n22 rbl_1_a_n22 3.432e-17
ccc_rbl_0_rwl_0_a_n22 rbl_0_a_n22 rwl_0_a_n22 4.9752e-17
ccc_rbl_0_rwl_1_a_n22 rbl_0_a_n22 rwl_1_a_n22 4.9752e-17
ccc_rbl_0_rwl_2_a_n22 rbl_0_a_n22 rwl_2_a_n22 4.9752e-17
ccc_rbl_0_rwl_3_a_n22 rbl_0_a_n22 rwl_3_a_n22 4.9752e-17
ccc_rbl_1_rbl_2_a_n22 rbl_1_a_n22 rbl_2_a_n22 3.432e-17
ccc_rbl_1_rwl_0_a_n22 rbl_1_a_n22 rwl_0_a_n22 4.9752e-17
ccc_rbl_1_rwl_1_a_n22 rbl_1_a_n22 rwl_1_a_n22 4.9752e-17
ccc_rbl_1_rwl_2_a_n22 rbl_1_a_n22 rwl_2_a_n22 4.9752e-17
ccc_rbl_1_rwl_3_a_n22 rbl_1_a_n22 rwl_3_a_n22 4.9752e-17
ccc_rbl_2_rbl_3_a_n22 rbl_2_a_n22 rbl_3_a_n22 3.432e-17
ccc_rbl_2_rwl_0_a_n22 rbl_2_a_n22 rwl_0_a_n22 4.9752e-17
ccc_rbl_2_rwl_1_a_n22 rbl_2_a_n22 rwl_1_a_n22 4.9752e-17
ccc_rbl_2_rwl_2_a_n22 rbl_2_a_n22 rwl_2_a_n22 4.9752e-17
ccc_rbl_2_rwl_3_a_n22 rbl_2_a_n22 rwl_3_a_n22 4.9752e-17
ccc_rbl_3_rwl_0_a_n22 rbl_3_a_n22 rwl_0_a_n22 3.3407e-17
ccc_rbl_3_rwl_1_a_n22 rbl_3_a_n22 rwl_1_a_n22 3.3407e-17
ccc_rbl_3_rwl_2_a_n22 rbl_3_a_n22 rwl_2_a_n22 3.3407e-17
ccc_rbl_3_rwl_3_a_n22 rbl_3_a_n22 rwl_3_a_n22 3.3407e-17
vdw_a_n22_0 wl_0_a_n22 0 dc 0
vdr_a_n22_0 rwl_0_a_n22 vdd dc 0
vdw_a_n22_1 wl_1_a_n22 0 dc 0
vdr_a_n22_1 rwl_1_a_n22 vdd dc 0
vdw_a_n22_2 wl_2_a_n22 0 dc 0
vdr_a_n22_2 rwl_2_a_n22 vdd dc 0
vdw_a_n22_3 wl_3_a_n22 0 dc 0
vdr_a_n22_3 rwl_3_a_n22 vdd dc 0
vdb_a_n22_0 bl_0_a_n22 0 dc 0
vdp_a_n22_0 rbl_0_a_n22 vrbl dc 0
vdb_a_n22_1 bl_1_a_n22 0 dc 0
vdp_a_n22_1 rbl_1_a_n22 vrbl dc 0
vdb_a_n22_2 bl_2_a_n22 0 dc 0
vdp_a_n22_2 rbl_2_a_n22 vrbl dc 0
vdb_a_n22_3 bl_3_a_n22 0 dc 0
vdp_a_n22_3 rbl_3_a_n22 vrbl dc 0
vdn_a_n22_n7 n7_a_n22 0 dc 1
vdn_a_n22_n8 n8_a_n22 0 dc 1
vdn_a_n22_n9 n9_a_n22 0 dc 1
vdn_a_n22_n10 n10_a_n22 0 dc 1
vdn_a_n22_n17 n17_a_n22 0 dc 1
vdn_a_n22_n18 n18_a_n22 0 dc 1
vdn_a_n22_n19 n19_a_n22 0 dc 1
vdn_a_n22_n20 n20_a_n22 0 dc 1
vdn_a_n22_n23 n23_a_n22 0 dc 1
vdn_a_n22_n24 n24_a_n22 0 dc 1
vdn_a_n22_n25 n25_a_n22 0 dc 1
vdn_a_n22_n29 n29_a_n22 0 dc 1
vdn_a_n22_n30 n30_a_n22 0 dc 1
vdn_a_n22_n31 n31_a_n22 0 dc 1
vdn_a_n22_n32 n32_a_n22 0 dc 1
bdr_a_n22 n22_a_n22 0 i=5e-08*min(1,max(0,(time-1e-09)/0.2n))*0.5*(1+tanh((v(n22_a_n22)-0.05)/0.01))

* ---- instance a_n23: variant a, probed storage node \$23 ----
xm1_a_n23 rwl_0__t2_a_n23 n7__t0_a_n23 rbl_0__t0_a_n23 gnd__t0_a_n23 sky130_fd_pr__nfet_01v8 L=0.15 W=0.42 nf=1 ad=0.1197 as=0.1197 pd=1.41 ps=1.41 mult=1 m=1
xm2_a_n23 rwl_0__t3_a_n23 n8__t1_a_n23 rbl_1__t1_a_n23 gnd__t1_a_n23 sky130_fd_pr__nfet_01v8 L=0.15 W=0.42 nf=1 ad=0.1197 as=0.1197 pd=1.41 ps=1.41 mult=1 m=1
xm3_a_n23 rwl_0__t1_a_n23 n9__t1_a_n23 rbl_2__t1_a_n23 gnd__t2_a_n23 sky130_fd_pr__nfet_01v8 L=0.15 W=0.42 nf=1 ad=0.1197 as=0.1197 pd=1.41 ps=1.41 mult=1 m=1
xm4_a_n23 rwl_0__t0_a_n23 n10__t1_a_n23 rbl_3__t1_a_n23 gnd__t3_a_n23 sky130_fd_pr__nfet_01v8 L=0.15 W=0.42 nf=1 ad=0.1197 as=0.1197 pd=1.41 ps=1.41 mult=1 m=1
xm5_a_n23 bl_0__t0_a_n23 wl_0__t0_a_n23 n7__t1_a_n23 gnd__t8_a_n23 sky130_fd_pr__nfet_01v8 L=0.15 W=0.42 nf=1 ad=0.0588 as=0.1197 pd=0.7 ps=1.41 mult=1 m=1
xm6_a_n23 n17__t0_a_n23 wl_1__t0_a_n23 bl_0__t1_a_n23 gnd__t20_a_n23 sky130_fd_pr__nfet_01v8 L=0.15 W=0.42 nf=1 ad=0.1197 as=0.0588 pd=1.41 ps=0.7 mult=1 m=1
xm7_a_n23 bl_1__t2_a_n23 wl_0__t3_a_n23 n8__t0_a_n23 gnd__t9_a_n23 sky130_fd_pr__nfet_01v8 L=0.15 W=0.42 nf=1 ad=0.0588 as=0.1197 pd=0.7 ps=1.41 mult=1 m=1
xm8_a_n23 n18__t0_a_n23 wl_1__t1_a_n23 bl_1__t0_a_n23 gnd__t21_a_n23 sky130_fd_pr__nfet_01v8 L=0.15 W=0.42 nf=1 ad=0.1197 as=0.0588 pd=1.41 ps=0.7 mult=1 m=1
xm9_a_n23 bl_2__t2_a_n23 wl_0__t2_a_n23 n9__t0_a_n23 gnd__t10_a_n23 sky130_fd_pr__nfet_01v8 L=0.15 W=0.42 nf=1 ad=0.0588 as=0.1197 pd=0.7 ps=1.41 mult=1 m=1
xm10_a_n23 n19__t0_a_n23 wl_1__t2_a_n23 bl_2__t0_a_n23 gnd__t22_a_n23 sky130_fd_pr__nfet_01v8 L=0.15 W=0.42 nf=1 ad=0.1197 as=0.0588 pd=1.41 ps=0.7 mult=1 m=1
xm11_a_n23 bl_3__t2_a_n23 wl_0__t1_a_n23 n10__t0_a_n23 gnd__t11_a_n23 sky130_fd_pr__nfet_01v8 L=0.15 W=0.42 nf=1 ad=0.0588 as=0.1197 pd=0.7 ps=1.41 mult=1 m=1
xm12_a_n23 n20__t0_a_n23 wl_1__t3_a_n23 bl_3__t1_a_n23 gnd__t23_a_n23 sky130_fd_pr__nfet_01v8 L=0.15 W=0.42 nf=1 ad=0.1197 as=0.0588 pd=1.41 ps=0.7 mult=1 m=1
xm13_a_n23 rbl_0__t3_a_n23 n17__t1_a_n23 rwl_1__t0_a_n23 gnd__t12_a_n23 sky130_fd_pr__nfet_01v8 L=0.15 W=0.42 nf=1 ad=0.0588 as=0.1197 pd=0.7 ps=1.41 mult=1 m=1
xm14_a_n23 rwl_2__t3_a_n23 n22__t0_a_n23 rbl_0__t2_a_n23 gnd__t24_a_n23 sky130_fd_pr__nfet_01v8 L=0.15 W=0.42 nf=1 ad=0.1197 as=0.0588 pd=1.41 ps=0.7 mult=1 m=1
xm15_a_n23 rbl_1__t3_a_n23 n18__t1_a_n23 rwl_1__t1_a_n23 gnd__t13_a_n23 sky130_fd_pr__nfet_01v8 L=0.15 W=0.42 nf=1 ad=0.0588 as=0.1197 pd=0.7 ps=1.41 mult=1 m=1
xm16_a_n23 rwl_2__t0_a_n23 n23__t0_a_n23 rbl_1__t2_a_n23 gnd__t25_a_n23 sky130_fd_pr__nfet_01v8 L=0.15 W=0.42 nf=1 ad=0.1197 as=0.0588 pd=1.41 ps=0.7 mult=1 m=1
xm17_a_n23 rbl_2__t3_a_n23 n19__t1_a_n23 rwl_1__t2_a_n23 gnd__t14_a_n23 sky130_fd_pr__nfet_01v8 L=0.15 W=0.42 nf=1 ad=0.0588 as=0.1197 pd=0.7 ps=1.41 mult=1 m=1
xm18_a_n23 rwl_2__t1_a_n23 n24__t0_a_n23 rbl_2__t2_a_n23 gnd__t26_a_n23 sky130_fd_pr__nfet_01v8 L=0.15 W=0.42 nf=1 ad=0.1197 as=0.0588 pd=1.41 ps=0.7 mult=1 m=1
xm19_a_n23 rbl_3__t3_a_n23 n20__t1_a_n23 rwl_1__t3_a_n23 gnd__t15_a_n23 sky130_fd_pr__nfet_01v8 L=0.15 W=0.42 nf=1 ad=0.0588 as=0.1197 pd=0.7 ps=1.41 mult=1 m=1
xm20_a_n23 rwl_2__t2_a_n23 n25__t0_a_n23 rbl_3__t2_a_n23 gnd__t27_a_n23 sky130_fd_pr__nfet_01v8 L=0.15 W=0.42 nf=1 ad=0.1197 as=0.0588 pd=1.41 ps=0.7 mult=1 m=1
xm21_a_n23 bl_0__t3_a_n23 wl_2__t0_a_n23 n22__t1_a_n23 gnd__t16_a_n23 sky130_fd_pr__nfet_01v8 L=0.15 W=0.42 nf=1 ad=0.0588 as=0.1197 pd=0.7 ps=1.41 mult=1 m=1
xm22_a_n23 n29__t0_a_n23 wl_3__t3_a_n23 bl_0__t2_a_n23 gnd__t28_a_n23 sky130_fd_pr__nfet_01v8 L=0.15 W=0.42 nf=1 ad=0.1197 as=0.0588 pd=1.41 ps=0.7 mult=1 m=1
xm23_a_n23 bl_1__t3_a_n23 wl_2__t1_a_n23 n23__t1_a_n23 gnd__t17_a_n23 sky130_fd_pr__nfet_01v8 L=0.15 W=0.42 nf=1 ad=0.0588 as=0.1197 pd=0.7 ps=1.41 mult=1 m=1
xm24_a_n23 n30__t0_a_n23 wl_3__t2_a_n23 bl_1__t1_a_n23 gnd__t29_a_n23 sky130_fd_pr__nfet_01v8 L=0.15 W=0.42 nf=1 ad=0.1197 as=0.0588 pd=1.41 ps=0.7 mult=1 m=1
xm25_a_n23 bl_2__t3_a_n23 wl_2__t2_a_n23 n24__t1_a_n23 gnd__t18_a_n23 sky130_fd_pr__nfet_01v8 L=0.15 W=0.42 nf=1 ad=0.0588 as=0.1197 pd=0.7 ps=1.41 mult=1 m=1
xm26_a_n23 n31__t0_a_n23 wl_3__t1_a_n23 bl_2__t1_a_n23 gnd__t30_a_n23 sky130_fd_pr__nfet_01v8 L=0.15 W=0.42 nf=1 ad=0.1197 as=0.0588 pd=1.41 ps=0.7 mult=1 m=1
xm27_a_n23 bl_3__t3_a_n23 wl_2__t3_a_n23 n25__t1_a_n23 gnd__t19_a_n23 sky130_fd_pr__nfet_01v8 L=0.15 W=0.42 nf=1 ad=0.0588 as=0.1197 pd=0.7 ps=1.41 mult=1 m=1
xm28_a_n23 n32__t0_a_n23 wl_3__t0_a_n23 bl_3__t0_a_n23 gnd__t31_a_n23 sky130_fd_pr__nfet_01v8 L=0.15 W=0.42 nf=1 ad=0.1197 as=0.0588 pd=1.41 ps=0.7 mult=1 m=1
xm29_a_n23 rbl_0__t1_a_n23 n29__t1_a_n23 rwl_3__t0_a_n23 gnd__t4_a_n23 sky130_fd_pr__nfet_01v8 L=0.15 W=0.42 nf=1 ad=0.1197 as=0.1197 pd=1.41 ps=1.41 mult=1 m=1
xm30_a_n23 rbl_1__t0_a_n23 n30__t1_a_n23 rwl_3__t1_a_n23 gnd__t5_a_n23 sky130_fd_pr__nfet_01v8 L=0.15 W=0.42 nf=1 ad=0.1197 as=0.1197 pd=1.41 ps=1.41 mult=1 m=1
xm31_a_n23 rbl_2__t0_a_n23 n31__t1_a_n23 rwl_3__t2_a_n23 gnd__t6_a_n23 sky130_fd_pr__nfet_01v8 L=0.15 W=0.42 nf=1 ad=0.1197 as=0.1197 pd=1.41 ps=1.41 mult=1 m=1
xm32_a_n23 rbl_3__t0_a_n23 n32__t1_a_n23 rwl_3__t3_a_n23 gnd__t7_a_n23 sky130_fd_pr__nfet_01v8 L=0.15 W=0.42 nf=1 ad=0.1197 as=0.1197 pd=1.41 ps=1.41 mult=1 m=1
r_10_t0_a_n23 n10__t0_a_n23 n10_a_n23 183.071
r_10_t1_a_n23 n10__t1_a_n23 n10_a_n23 183.071
r_17_t0_a_n23 n17__t0_a_n23 n17_a_n23 183.071
r_17_t1_a_n23 n17__t1_a_n23 n17_a_n23 183.071
r_18_t0_a_n23 n18__t0_a_n23 n18_a_n23 183.071
r_18_t1_a_n23 n18__t1_a_n23 n18_a_n23 183.071
r_19_t0_a_n23 n19__t0_a_n23 n19_a_n23 183.071
r_19_t1_a_n23 n19__t1_a_n23 n19_a_n23 183.071
r_20_t0_a_n23 n20__t0_a_n23 n20_a_n23 183.071
r_20_t1_a_n23 n20__t1_a_n23 n20_a_n23 183.071
r_22_t0_a_n23 n22__t0_a_n23 n22_a_n23 183.071
r_22_t1_a_n23 n22__t1_a_n23 n22_a_n23 183.071
r_23_t0_a_n23 n23__t0_a_n23 n23_a_n23 183.071
r_23_t1_a_n23 n23__t1_a_n23 n23_a_n23 183.071
r_24_t0_a_n23 n24__t0_a_n23 n24_a_n23 183.071
r_24_t1_a_n23 n24__t1_a_n23 n24_a_n23 183.071
r_25_t0_a_n23 n25__t0_a_n23 n25_a_n23 183.071
r_25_t1_a_n23 n25__t1_a_n23 n25_a_n23 183.071
r_29_t0_a_n23 n29__t0_a_n23 n29_a_n23 183.071
r_29_t1_a_n23 n29__t1_a_n23 n29_a_n23 183.071
r_30_t0_a_n23 n30__t0_a_n23 n30_a_n23 183.071
r_30_t1_a_n23 n30__t1_a_n23 n30_a_n23 183.071
r_31_t0_a_n23 n31__t0_a_n23 n31_a_n23 183.071
r_31_t1_a_n23 n31__t1_a_n23 n31_a_n23 183.071
r_32_t0_a_n23 n32__t0_a_n23 n32_a_n23 183.071
r_32_t1_a_n23 n32__t1_a_n23 n32_a_n23 183.071
r_7_t0_a_n23 n7__t0_a_n23 n7_a_n23 183.071
r_7_t1_a_n23 n7__t1_a_n23 n7_a_n23 183.071
r_8_t0_a_n23 n8__t0_a_n23 n8_a_n23 183.071
r_8_t1_a_n23 n8__t1_a_n23 n8_a_n23 183.071
r_9_t0_a_n23 n9__t0_a_n23 n9_a_n23 183.071
r_9_t1_a_n23 n9__t1_a_n23 n9_a_n23 183.071
rgnd_t0_a_n23 gnd__t0_a_n23 0 38.2988
rgnd_t1_a_n23 gnd__t1_a_n23 0 33.9576
rgnd_t2_a_n23 gnd__t2_a_n23 0 33.9576
rgnd_t3_a_n23 gnd__t3_a_n23 0 38.2988
rgnd_t4_a_n23 gnd__t4_a_n23 0 38.2988
rgnd_t5_a_n23 gnd__t5_a_n23 0 33.9576
rgnd_t6_a_n23 gnd__t6_a_n23 0 33.9576
rgnd_t7_a_n23 gnd__t7_a_n23 0 38.2988
rgnd_t8_a_n23 gnd__t8_a_n23 0 28.0185
rgnd_t9_a_n23 gnd__t9_a_n23 0 21.7106
rgnd_t10_a_n23 gnd__t10_a_n23 0 21.7106
rgnd_t11_a_n23 gnd__t11_a_n23 0 28.0185
rgnd_t12_a_n23 gnd__t12_a_n23 0 18.9833
rgnd_t13_a_n23 gnd__t13_a_n23 0 6.8325
rgnd_t14_a_n23 gnd__t14_a_n23 0 6.8325
rgnd_t15_a_n23 gnd__t15_a_n23 0 18.9833
rgnd_t16_a_n23 gnd__t16_a_n23 0 24.2409
rgnd_t17_a_n23 gnd__t17_a_n23 0 16.5511
rgnd_t18_a_n23 gnd__t18_a_n23 0 16.5511
rgnd_t19_a_n23 gnd__t19_a_n23 0 24.2409
rgnd_t20_a_n23 gnd__t20_a_n23 0 24.2409
rgnd_t21_a_n23 gnd__t21_a_n23 0 16.5511
rgnd_t22_a_n23 gnd__t22_a_n23 0 16.5511
rgnd_t23_a_n23 gnd__t23_a_n23 0 24.2409
rgnd_t24_a_n23 gnd__t24_a_n23 0 18.9833
rgnd_t25_a_n23 gnd__t25_a_n23 0 6.8325
rgnd_t26_a_n23 gnd__t26_a_n23 0 6.8325
rgnd_t27_a_n23 gnd__t27_a_n23 0 18.9833
rgnd_t28_a_n23 gnd__t28_a_n23 0 28.0185
rgnd_t29_a_n23 gnd__t29_a_n23 0 21.7106
rgnd_t30_a_n23 gnd__t30_a_n23 0 21.7106
rgnd_t31_a_n23 gnd__t31_a_n23 0 28.0185
rbl_0_t0_a_n23 bl_0__t0_a_n23 bl_0_a_n23 14.8304
rbl_0_t1_a_n23 bl_0__t1_a_n23 bl_0_a_n23 10.9301
rbl_0_t2_a_n23 bl_0__t2_a_n23 bl_0_a_n23 14.8304
rbl_0_t3_a_n23 bl_0__t3_a_n23 bl_0_a_n23 10.9301
rbl_1_t0_a_n23 bl_1__t0_a_n23 bl_1_a_n23 10.9301
rbl_1_t1_a_n23 bl_1__t1_a_n23 bl_1_a_n23 14.8304
rbl_1_t2_a_n23 bl_1__t2_a_n23 bl_1_a_n23 14.8304
rbl_1_t3_a_n23 bl_1__t3_a_n23 bl_1_a_n23 10.9301
rbl_2_t0_a_n23 bl_2__t0_a_n23 bl_2_a_n23 10.9301
rbl_2_t1_a_n23 bl_2__t1_a_n23 bl_2_a_n23 14.8304
rbl_2_t2_a_n23 bl_2__t2_a_n23 bl_2_a_n23 14.8304
rbl_2_t3_a_n23 bl_2__t3_a_n23 bl_2_a_n23 10.9301
rbl_3_t0_a_n23 bl_3__t0_a_n23 bl_3_a_n23 14.8304
rbl_3_t1_a_n23 bl_3__t1_a_n23 bl_3_a_n23 10.9301
rbl_3_t2_a_n23 bl_3__t2_a_n23 bl_3_a_n23 14.8304
rbl_3_t3_a_n23 bl_3__t3_a_n23 bl_3_a_n23 10.9301
rrbl_0_t0_a_n23 rbl_0__t0_a_n23 rbl_0_a_n23 36.5601
rrbl_0_t1_a_n23 rbl_0__t1_a_n23 rbl_0_a_n23 36.5601
rrbl_0_t2_a_n23 rbl_0__t2_a_n23 rbl_0_a_n23 2.99444
rrbl_0_t3_a_n23 rbl_0__t3_a_n23 rbl_0_a_n23 2.99444
rrbl_1_t0_a_n23 rbl_1__t0_a_n23 rbl_1_a_n23 36.5601
rrbl_1_t1_a_n23 rbl_1__t1_a_n23 rbl_1_a_n23 36.5601
rrbl_1_t2_a_n23 rbl_1__t2_a_n23 rbl_1_a_n23 2.99444
rrbl_1_t3_a_n23 rbl_1__t3_a_n23 rbl_1_a_n23 2.99444
rrbl_2_t0_a_n23 rbl_2__t0_a_n23 rbl_2_a_n23 36.5601
rrbl_2_t1_a_n23 rbl_2__t1_a_n23 rbl_2_a_n23 36.5601
rrbl_2_t2_a_n23 rbl_2__t2_a_n23 rbl_2_a_n23 2.99444
rrbl_2_t3_a_n23 rbl_2__t3_a_n23 rbl_2_a_n23 2.99444
rrbl_3_t0_a_n23 rbl_3__t0_a_n23 rbl_3_a_n23 36.5601
rrbl_3_t1_a_n23 rbl_3__t1_a_n23 rbl_3_a_n23 36.5601
rrbl_3_t2_a_n23 rbl_3__t2_a_n23 rbl_3_a_n23 2.99444
rrbl_3_t3_a_n23 rbl_3__t3_a_n23 rbl_3_a_n23 2.99444
rrwl_0_t0_a_n23 rwl_0__t0_a_n23 rwl_0_a_n23 38.2618
rrwl_0_t1_a_n23 rwl_0__t1_a_n23 rwl_0_a_n23 12.7539
rrwl_0_t2_a_n23 rwl_0__t2_a_n23 rwl_0_a_n23 38.2618
rrwl_0_t3_a_n23 rwl_0__t3_a_n23 rwl_0_a_n23 12.7539
rrwl_1_t0_a_n23 rwl_1__t0_a_n23 rwl_1_a_n23 38.2618
rrwl_1_t1_a_n23 rwl_1__t1_a_n23 rwl_1_a_n23 12.7539
rrwl_1_t2_a_n23 rwl_1__t2_a_n23 rwl_1_a_n23 12.7539
rrwl_1_t3_a_n23 rwl_1__t3_a_n23 rwl_1_a_n23 38.2618
rrwl_2_t0_a_n23 rwl_2__t0_a_n23 rwl_2_a_n23 12.7539
rrwl_2_t1_a_n23 rwl_2__t1_a_n23 rwl_2_a_n23 12.7539
rrwl_2_t2_a_n23 rwl_2__t2_a_n23 rwl_2_a_n23 38.2618
rrwl_2_t3_a_n23 rwl_2__t3_a_n23 rwl_2_a_n23 38.2618
rrwl_3_t0_a_n23 rwl_3__t0_a_n23 rwl_3_a_n23 38.2618
rrwl_3_t1_a_n23 rwl_3__t1_a_n23 rwl_3_a_n23 12.7539
rrwl_3_t2_a_n23 rwl_3__t2_a_n23 rwl_3_a_n23 12.7539
rrwl_3_t3_a_n23 rwl_3__t3_a_n23 rwl_3_a_n23 38.2618
rwl_0_t0_a_n23 wl_0__t0_a_n23 wl_0_a_n23 245.959
rwl_0_t1_a_n23 wl_0__t1_a_n23 wl_0_a_n23 245.959
rwl_0_t2_a_n23 wl_0__t2_a_n23 wl_0_a_n23 81.9864
rwl_0_t3_a_n23 wl_0__t3_a_n23 wl_0_a_n23 81.9864
rwl_1_t0_a_n23 wl_1__t0_a_n23 wl_1_a_n23 245.959
rwl_1_t1_a_n23 wl_1__t1_a_n23 wl_1_a_n23 81.9864
rwl_1_t2_a_n23 wl_1__t2_a_n23 wl_1_a_n23 81.9864
rwl_1_t3_a_n23 wl_1__t3_a_n23 wl_1_a_n23 245.959
rwl_2_t0_a_n23 wl_2__t0_a_n23 wl_2_a_n23 245.959
rwl_2_t1_a_n23 wl_2__t1_a_n23 wl_2_a_n23 81.9864
rwl_2_t2_a_n23 wl_2__t2_a_n23 wl_2_a_n23 81.9864
rwl_2_t3_a_n23 wl_2__t3_a_n23 wl_2_a_n23 245.959
rwl_3_t0_a_n23 wl_3__t0_a_n23 wl_3_a_n23 245.959
rwl_3_t1_a_n23 wl_3__t1_a_n23 wl_3_a_n23 81.9864
rwl_3_t2_a_n23 wl_3__t2_a_n23 wl_3_a_n23 81.9864
rwl_3_t3_a_n23 wl_3__t3_a_n23 wl_3_a_n23 245.959
c_10_a_n23 n10_a_n23 0 2.91622e-16
c_17_a_n23 n17_a_n23 0 2.91528e-16
c_18_a_n23 n18_a_n23 0 2.91528e-16
c_19_a_n23 n19_a_n23 0 2.91528e-16
c_20_a_n23 n20_a_n23 0 2.91622e-16
c_22_a_n23 n22_a_n23 0 2.91528e-16
c_23_a_n23 n23_a_n23 0 2.91528e-16
c_24_a_n23 n24_a_n23 0 2.91528e-16
c_25_a_n23 n25_a_n23 0 2.91622e-16
c_29_a_n23 n29_a_n23 0 2.91528e-16
c_30_a_n23 n30_a_n23 0 2.91528e-16
c_31_a_n23 n31_a_n23 0 2.91528e-16
c_32_a_n23 n32_a_n23 0 2.91622e-16
c_7_a_n23 n7_a_n23 0 2.91528e-16
c_8_a_n23 n8_a_n23 0 2.91528e-16
c_9_a_n23 n9_a_n23 0 2.91528e-16
cgnd_a_n23 0 0 2.48166e-15
cbl_0_a_n23 bl_0_a_n23 0 4.52661e-16
cbl_1_a_n23 bl_1_a_n23 0 4.52661e-16
cbl_2_a_n23 bl_2_a_n23 0 4.52661e-16
cbl_3_a_n23 bl_3_a_n23 0 4.52661e-16
crbl_0_a_n23 rbl_0_a_n23 0 9.14472e-16
crbl_1_a_n23 rbl_1_a_n23 0 9.14472e-16
crbl_2_a_n23 rbl_2_a_n23 0 9.14472e-16
crbl_3_a_n23 rbl_3_a_n23 0 9.17566e-16
crwl_0_a_n23 rwl_0_a_n23 0 5.19495e-16
crwl_1_a_n23 rwl_1_a_n23 0 5.11719e-16
crwl_2_a_n23 rwl_2_a_n23 0 5.11719e-16
crwl_3_a_n23 rwl_3_a_n23 0 5.19495e-16
cwl_0_a_n23 wl_0_a_n23 0 3.30388e-16
cwl_1_a_n23 wl_1_a_n23 0 3.30388e-16
cwl_2_a_n23 wl_2_a_n23 0 3.30388e-16
cwl_3_a_n23 wl_3_a_n23 0 3.30388e-16
ccc__10__9_a_n23 n10_a_n23 n9_a_n23 1.02e-17
ccc__10_bl_3_a_n23 n10_a_n23 bl_3_a_n23 1.3999e-17
ccc__10_rwl_0_a_n23 n10_a_n23 rwl_0_a_n23 4.335e-18
ccc__17__18_a_n23 n17_a_n23 n18_a_n23 1.02e-17
ccc__17_bl_0_a_n23 n17_a_n23 bl_0_a_n23 8.415e-18
ccc__17_rwl_1_a_n23 n17_a_n23 rwl_1_a_n23 1.3194e-17
ccc__18__19_a_n23 n18_a_n23 n19_a_n23 1.02e-17
ccc__18_bl_1_a_n23 n18_a_n23 bl_1_a_n23 8.415e-18
ccc__18_rwl_1_a_n23 n18_a_n23 rwl_1_a_n23 1.3194e-17
ccc__19__20_a_n23 n19_a_n23 n20_a_n23 1.02e-17
ccc__19_bl_2_a_n23 n19_a_n23 bl_2_a_n23 8.415e-18
ccc__19_rwl_1_a_n23 n19_a_n23 rwl_1_a_n23 1.3194e-17
ccc__20_bl_3_a_n23 n20_a_n23 bl_3_a_n23 8.415e-18
ccc__20_rwl_1_a_n23 n20_a_n23 rwl_1_a_n23 6.655e-18
ccc__22__23_a_n23 n22_a_n23 n23_a_n23 1.02e-17
ccc__22_bl_0_a_n23 n22_a_n23 bl_0_a_n23 8.415e-18
ccc__22_rwl_2_a_n23 n22_a_n23 rwl_2_a_n23 1.3194e-17
ccc__23__24_a_n23 n23_a_n23 n24_a_n23 1.02e-17
ccc__23_bl_1_a_n23 n23_a_n23 bl_1_a_n23 8.415e-18
ccc__23_rwl_2_a_n23 n23_a_n23 rwl_2_a_n23 1.3194e-17
ccc__24__25_a_n23 n24_a_n23 n25_a_n23 1.02e-17
ccc__24_bl_2_a_n23 n24_a_n23 bl_2_a_n23 8.415e-18
ccc__24_rwl_2_a_n23 n24_a_n23 rwl_2_a_n23 1.3194e-17
ccc__25_bl_3_a_n23 n25_a_n23 bl_3_a_n23 8.415e-18
ccc__25_rwl_2_a_n23 n25_a_n23 rwl_2_a_n23 6.655e-18
ccc__29__30_a_n23 n29_a_n23 n30_a_n23 1.02e-17
ccc__29_bl_0_a_n23 n29_a_n23 bl_0_a_n23 8.415e-18
ccc__29_rwl_3_a_n23 n29_a_n23 rwl_3_a_n23 1.3194e-17
ccc__30__31_a_n23 n30_a_n23 n31_a_n23 1.02e-17
ccc__30_bl_1_a_n23 n30_a_n23 bl_1_a_n23 8.415e-18
ccc__30_rwl_3_a_n23 n30_a_n23 rwl_3_a_n23 1.3194e-17
ccc__31__32_a_n23 n31_a_n23 n32_a_n23 1.02e-17
ccc__31_bl_2_a_n23 n31_a_n23 bl_2_a_n23 8.415e-18
ccc__31_rwl_3_a_n23 n31_a_n23 rwl_3_a_n23 1.3194e-17
ccc__32_bl_3_a_n23 n32_a_n23 bl_3_a_n23 8.415e-18
ccc__32_rwl_3_a_n23 n32_a_n23 rwl_3_a_n23 6.655e-18
ccc__7__8_a_n23 n7_a_n23 n8_a_n23 1.02e-17
ccc__7_bl_0_a_n23 n7_a_n23 bl_0_a_n23 1.3999e-17
ccc__7_rwl_0_a_n23 n7_a_n23 rwl_0_a_n23 8.961e-18
ccc__8__9_a_n23 n8_a_n23 n9_a_n23 1.02e-17
ccc__8_bl_1_a_n23 n8_a_n23 bl_1_a_n23 1.3999e-17
ccc__8_rwl_0_a_n23 n8_a_n23 rwl_0_a_n23 8.961e-18
ccc__9_bl_2_a_n23 n9_a_n23 bl_2_a_n23 1.3999e-17
ccc__9_rwl_0_a_n23 n9_a_n23 rwl_0_a_n23 8.961e-18
ccc_bl_0_rbl_0_a_n23 bl_0_a_n23 rbl_0_a_n23 1.88693e-16
ccc_bl_0_rwl_1_a_n23 bl_0_a_n23 rwl_1_a_n23 1.0093e-17
ccc_bl_0_rwl_2_a_n23 bl_0_a_n23 rwl_2_a_n23 1.0093e-17
ccc_bl_1_rbl_0_a_n23 bl_1_a_n23 rbl_0_a_n23 1.633e-16
ccc_bl_1_rbl_1_a_n23 bl_1_a_n23 rbl_1_a_n23 1.88693e-16
ccc_bl_1_rwl_1_a_n23 bl_1_a_n23 rwl_1_a_n23 1.0093e-17
ccc_bl_1_rwl_2_a_n23 bl_1_a_n23 rwl_2_a_n23 1.0093e-17
ccc_bl_2_rbl_1_a_n23 bl_2_a_n23 rbl_1_a_n23 1.633e-16
ccc_bl_2_rbl_2_a_n23 bl_2_a_n23 rbl_2_a_n23 1.88693e-16
ccc_bl_2_rwl_1_a_n23 bl_2_a_n23 rwl_1_a_n23 1.0093e-17
ccc_bl_2_rwl_2_a_n23 bl_2_a_n23 rwl_2_a_n23 1.0093e-17
ccc_bl_3_rbl_2_a_n23 bl_3_a_n23 rbl_2_a_n23 1.633e-16
ccc_bl_3_rbl_3_a_n23 bl_3_a_n23 rbl_3_a_n23 1.88693e-16
ccc_bl_3_rwl_1_a_n23 bl_3_a_n23 rwl_1_a_n23 1.0093e-17
ccc_bl_3_rwl_2_a_n23 bl_3_a_n23 rwl_2_a_n23 1.0093e-17
ccc_rbl_0_rbl_1_a_n23 rbl_0_a_n23 rbl_1_a_n23 3.432e-17
ccc_rbl_0_rwl_0_a_n23 rbl_0_a_n23 rwl_0_a_n23 4.9752e-17
ccc_rbl_0_rwl_1_a_n23 rbl_0_a_n23 rwl_1_a_n23 4.9752e-17
ccc_rbl_0_rwl_2_a_n23 rbl_0_a_n23 rwl_2_a_n23 4.9752e-17
ccc_rbl_0_rwl_3_a_n23 rbl_0_a_n23 rwl_3_a_n23 4.9752e-17
ccc_rbl_1_rbl_2_a_n23 rbl_1_a_n23 rbl_2_a_n23 3.432e-17
ccc_rbl_1_rwl_0_a_n23 rbl_1_a_n23 rwl_0_a_n23 4.9752e-17
ccc_rbl_1_rwl_1_a_n23 rbl_1_a_n23 rwl_1_a_n23 4.9752e-17
ccc_rbl_1_rwl_2_a_n23 rbl_1_a_n23 rwl_2_a_n23 4.9752e-17
ccc_rbl_1_rwl_3_a_n23 rbl_1_a_n23 rwl_3_a_n23 4.9752e-17
ccc_rbl_2_rbl_3_a_n23 rbl_2_a_n23 rbl_3_a_n23 3.432e-17
ccc_rbl_2_rwl_0_a_n23 rbl_2_a_n23 rwl_0_a_n23 4.9752e-17
ccc_rbl_2_rwl_1_a_n23 rbl_2_a_n23 rwl_1_a_n23 4.9752e-17
ccc_rbl_2_rwl_2_a_n23 rbl_2_a_n23 rwl_2_a_n23 4.9752e-17
ccc_rbl_2_rwl_3_a_n23 rbl_2_a_n23 rwl_3_a_n23 4.9752e-17
ccc_rbl_3_rwl_0_a_n23 rbl_3_a_n23 rwl_0_a_n23 3.3407e-17
ccc_rbl_3_rwl_1_a_n23 rbl_3_a_n23 rwl_1_a_n23 3.3407e-17
ccc_rbl_3_rwl_2_a_n23 rbl_3_a_n23 rwl_2_a_n23 3.3407e-17
ccc_rbl_3_rwl_3_a_n23 rbl_3_a_n23 rwl_3_a_n23 3.3407e-17
vdw_a_n23_0 wl_0_a_n23 0 dc 0
vdr_a_n23_0 rwl_0_a_n23 vdd dc 0
vdw_a_n23_1 wl_1_a_n23 0 dc 0
vdr_a_n23_1 rwl_1_a_n23 vdd dc 0
vdw_a_n23_2 wl_2_a_n23 0 dc 0
vdr_a_n23_2 rwl_2_a_n23 vdd dc 0
vdw_a_n23_3 wl_3_a_n23 0 dc 0
vdr_a_n23_3 rwl_3_a_n23 vdd dc 0
vdb_a_n23_0 bl_0_a_n23 0 dc 0
vdp_a_n23_0 rbl_0_a_n23 vrbl dc 0
vdb_a_n23_1 bl_1_a_n23 0 dc 0
vdp_a_n23_1 rbl_1_a_n23 vrbl dc 0
vdb_a_n23_2 bl_2_a_n23 0 dc 0
vdp_a_n23_2 rbl_2_a_n23 vrbl dc 0
vdb_a_n23_3 bl_3_a_n23 0 dc 0
vdp_a_n23_3 rbl_3_a_n23 vrbl dc 0
vdn_a_n23_n7 n7_a_n23 0 dc 1
vdn_a_n23_n8 n8_a_n23 0 dc 1
vdn_a_n23_n9 n9_a_n23 0 dc 1
vdn_a_n23_n10 n10_a_n23 0 dc 1
vdn_a_n23_n17 n17_a_n23 0 dc 1
vdn_a_n23_n18 n18_a_n23 0 dc 1
vdn_a_n23_n19 n19_a_n23 0 dc 1
vdn_a_n23_n20 n20_a_n23 0 dc 1
vdn_a_n23_n22 n22_a_n23 0 dc 1
vdn_a_n23_n24 n24_a_n23 0 dc 1
vdn_a_n23_n25 n25_a_n23 0 dc 1
vdn_a_n23_n29 n29_a_n23 0 dc 1
vdn_a_n23_n30 n30_a_n23 0 dc 1
vdn_a_n23_n31 n31_a_n23 0 dc 1
vdn_a_n23_n32 n32_a_n23 0 dc 1
bdr_a_n23 n23_a_n23 0 i=5e-08*min(1,max(0,(time-1e-09)/0.2n))*0.5*(1+tanh((v(n23_a_n23)-0.05)/0.01))

* ---- instance a_n24: variant a, probed storage node \$24 ----
xm1_a_n24 rwl_0__t2_a_n24 n7__t0_a_n24 rbl_0__t0_a_n24 gnd__t0_a_n24 sky130_fd_pr__nfet_01v8 L=0.15 W=0.42 nf=1 ad=0.1197 as=0.1197 pd=1.41 ps=1.41 mult=1 m=1
xm2_a_n24 rwl_0__t3_a_n24 n8__t1_a_n24 rbl_1__t1_a_n24 gnd__t1_a_n24 sky130_fd_pr__nfet_01v8 L=0.15 W=0.42 nf=1 ad=0.1197 as=0.1197 pd=1.41 ps=1.41 mult=1 m=1
xm3_a_n24 rwl_0__t1_a_n24 n9__t1_a_n24 rbl_2__t1_a_n24 gnd__t2_a_n24 sky130_fd_pr__nfet_01v8 L=0.15 W=0.42 nf=1 ad=0.1197 as=0.1197 pd=1.41 ps=1.41 mult=1 m=1
xm4_a_n24 rwl_0__t0_a_n24 n10__t1_a_n24 rbl_3__t1_a_n24 gnd__t3_a_n24 sky130_fd_pr__nfet_01v8 L=0.15 W=0.42 nf=1 ad=0.1197 as=0.1197 pd=1.41 ps=1.41 mult=1 m=1
xm5_a_n24 bl_0__t0_a_n24 wl_0__t0_a_n24 n7__t1_a_n24 gnd__t8_a_n24 sky130_fd_pr__nfet_01v8 L=0.15 W=0.42 nf=1 ad=0.0588 as=0.1197 pd=0.7 ps=1.41 mult=1 m=1
xm6_a_n24 n17__t0_a_n24 wl_1__t0_a_n24 bl_0__t1_a_n24 gnd__t20_a_n24 sky130_fd_pr__nfet_01v8 L=0.15 W=0.42 nf=1 ad=0.1197 as=0.0588 pd=1.41 ps=0.7 mult=1 m=1
xm7_a_n24 bl_1__t2_a_n24 wl_0__t3_a_n24 n8__t0_a_n24 gnd__t9_a_n24 sky130_fd_pr__nfet_01v8 L=0.15 W=0.42 nf=1 ad=0.0588 as=0.1197 pd=0.7 ps=1.41 mult=1 m=1
xm8_a_n24 n18__t0_a_n24 wl_1__t1_a_n24 bl_1__t0_a_n24 gnd__t21_a_n24 sky130_fd_pr__nfet_01v8 L=0.15 W=0.42 nf=1 ad=0.1197 as=0.0588 pd=1.41 ps=0.7 mult=1 m=1
xm9_a_n24 bl_2__t2_a_n24 wl_0__t2_a_n24 n9__t0_a_n24 gnd__t10_a_n24 sky130_fd_pr__nfet_01v8 L=0.15 W=0.42 nf=1 ad=0.0588 as=0.1197 pd=0.7 ps=1.41 mult=1 m=1
xm10_a_n24 n19__t0_a_n24 wl_1__t2_a_n24 bl_2__t0_a_n24 gnd__t22_a_n24 sky130_fd_pr__nfet_01v8 L=0.15 W=0.42 nf=1 ad=0.1197 as=0.0588 pd=1.41 ps=0.7 mult=1 m=1
xm11_a_n24 bl_3__t2_a_n24 wl_0__t1_a_n24 n10__t0_a_n24 gnd__t11_a_n24 sky130_fd_pr__nfet_01v8 L=0.15 W=0.42 nf=1 ad=0.0588 as=0.1197 pd=0.7 ps=1.41 mult=1 m=1
xm12_a_n24 n20__t0_a_n24 wl_1__t3_a_n24 bl_3__t1_a_n24 gnd__t23_a_n24 sky130_fd_pr__nfet_01v8 L=0.15 W=0.42 nf=1 ad=0.1197 as=0.0588 pd=1.41 ps=0.7 mult=1 m=1
xm13_a_n24 rbl_0__t3_a_n24 n17__t1_a_n24 rwl_1__t0_a_n24 gnd__t12_a_n24 sky130_fd_pr__nfet_01v8 L=0.15 W=0.42 nf=1 ad=0.0588 as=0.1197 pd=0.7 ps=1.41 mult=1 m=1
xm14_a_n24 rwl_2__t3_a_n24 n22__t0_a_n24 rbl_0__t2_a_n24 gnd__t24_a_n24 sky130_fd_pr__nfet_01v8 L=0.15 W=0.42 nf=1 ad=0.1197 as=0.0588 pd=1.41 ps=0.7 mult=1 m=1
xm15_a_n24 rbl_1__t3_a_n24 n18__t1_a_n24 rwl_1__t1_a_n24 gnd__t13_a_n24 sky130_fd_pr__nfet_01v8 L=0.15 W=0.42 nf=1 ad=0.0588 as=0.1197 pd=0.7 ps=1.41 mult=1 m=1
xm16_a_n24 rwl_2__t0_a_n24 n23__t0_a_n24 rbl_1__t2_a_n24 gnd__t25_a_n24 sky130_fd_pr__nfet_01v8 L=0.15 W=0.42 nf=1 ad=0.1197 as=0.0588 pd=1.41 ps=0.7 mult=1 m=1
xm17_a_n24 rbl_2__t3_a_n24 n19__t1_a_n24 rwl_1__t2_a_n24 gnd__t14_a_n24 sky130_fd_pr__nfet_01v8 L=0.15 W=0.42 nf=1 ad=0.0588 as=0.1197 pd=0.7 ps=1.41 mult=1 m=1
xm18_a_n24 rwl_2__t1_a_n24 n24__t0_a_n24 rbl_2__t2_a_n24 gnd__t26_a_n24 sky130_fd_pr__nfet_01v8 L=0.15 W=0.42 nf=1 ad=0.1197 as=0.0588 pd=1.41 ps=0.7 mult=1 m=1
xm19_a_n24 rbl_3__t3_a_n24 n20__t1_a_n24 rwl_1__t3_a_n24 gnd__t15_a_n24 sky130_fd_pr__nfet_01v8 L=0.15 W=0.42 nf=1 ad=0.0588 as=0.1197 pd=0.7 ps=1.41 mult=1 m=1
xm20_a_n24 rwl_2__t2_a_n24 n25__t0_a_n24 rbl_3__t2_a_n24 gnd__t27_a_n24 sky130_fd_pr__nfet_01v8 L=0.15 W=0.42 nf=1 ad=0.1197 as=0.0588 pd=1.41 ps=0.7 mult=1 m=1
xm21_a_n24 bl_0__t3_a_n24 wl_2__t0_a_n24 n22__t1_a_n24 gnd__t16_a_n24 sky130_fd_pr__nfet_01v8 L=0.15 W=0.42 nf=1 ad=0.0588 as=0.1197 pd=0.7 ps=1.41 mult=1 m=1
xm22_a_n24 n29__t0_a_n24 wl_3__t3_a_n24 bl_0__t2_a_n24 gnd__t28_a_n24 sky130_fd_pr__nfet_01v8 L=0.15 W=0.42 nf=1 ad=0.1197 as=0.0588 pd=1.41 ps=0.7 mult=1 m=1
xm23_a_n24 bl_1__t3_a_n24 wl_2__t1_a_n24 n23__t1_a_n24 gnd__t17_a_n24 sky130_fd_pr__nfet_01v8 L=0.15 W=0.42 nf=1 ad=0.0588 as=0.1197 pd=0.7 ps=1.41 mult=1 m=1
xm24_a_n24 n30__t0_a_n24 wl_3__t2_a_n24 bl_1__t1_a_n24 gnd__t29_a_n24 sky130_fd_pr__nfet_01v8 L=0.15 W=0.42 nf=1 ad=0.1197 as=0.0588 pd=1.41 ps=0.7 mult=1 m=1
xm25_a_n24 bl_2__t3_a_n24 wl_2__t2_a_n24 n24__t1_a_n24 gnd__t18_a_n24 sky130_fd_pr__nfet_01v8 L=0.15 W=0.42 nf=1 ad=0.0588 as=0.1197 pd=0.7 ps=1.41 mult=1 m=1
xm26_a_n24 n31__t0_a_n24 wl_3__t1_a_n24 bl_2__t1_a_n24 gnd__t30_a_n24 sky130_fd_pr__nfet_01v8 L=0.15 W=0.42 nf=1 ad=0.1197 as=0.0588 pd=1.41 ps=0.7 mult=1 m=1
xm27_a_n24 bl_3__t3_a_n24 wl_2__t3_a_n24 n25__t1_a_n24 gnd__t19_a_n24 sky130_fd_pr__nfet_01v8 L=0.15 W=0.42 nf=1 ad=0.0588 as=0.1197 pd=0.7 ps=1.41 mult=1 m=1
xm28_a_n24 n32__t0_a_n24 wl_3__t0_a_n24 bl_3__t0_a_n24 gnd__t31_a_n24 sky130_fd_pr__nfet_01v8 L=0.15 W=0.42 nf=1 ad=0.1197 as=0.0588 pd=1.41 ps=0.7 mult=1 m=1
xm29_a_n24 rbl_0__t1_a_n24 n29__t1_a_n24 rwl_3__t0_a_n24 gnd__t4_a_n24 sky130_fd_pr__nfet_01v8 L=0.15 W=0.42 nf=1 ad=0.1197 as=0.1197 pd=1.41 ps=1.41 mult=1 m=1
xm30_a_n24 rbl_1__t0_a_n24 n30__t1_a_n24 rwl_3__t1_a_n24 gnd__t5_a_n24 sky130_fd_pr__nfet_01v8 L=0.15 W=0.42 nf=1 ad=0.1197 as=0.1197 pd=1.41 ps=1.41 mult=1 m=1
xm31_a_n24 rbl_2__t0_a_n24 n31__t1_a_n24 rwl_3__t2_a_n24 gnd__t6_a_n24 sky130_fd_pr__nfet_01v8 L=0.15 W=0.42 nf=1 ad=0.1197 as=0.1197 pd=1.41 ps=1.41 mult=1 m=1
xm32_a_n24 rbl_3__t0_a_n24 n32__t1_a_n24 rwl_3__t3_a_n24 gnd__t7_a_n24 sky130_fd_pr__nfet_01v8 L=0.15 W=0.42 nf=1 ad=0.1197 as=0.1197 pd=1.41 ps=1.41 mult=1 m=1
r_10_t0_a_n24 n10__t0_a_n24 n10_a_n24 183.071
r_10_t1_a_n24 n10__t1_a_n24 n10_a_n24 183.071
r_17_t0_a_n24 n17__t0_a_n24 n17_a_n24 183.071
r_17_t1_a_n24 n17__t1_a_n24 n17_a_n24 183.071
r_18_t0_a_n24 n18__t0_a_n24 n18_a_n24 183.071
r_18_t1_a_n24 n18__t1_a_n24 n18_a_n24 183.071
r_19_t0_a_n24 n19__t0_a_n24 n19_a_n24 183.071
r_19_t1_a_n24 n19__t1_a_n24 n19_a_n24 183.071
r_20_t0_a_n24 n20__t0_a_n24 n20_a_n24 183.071
r_20_t1_a_n24 n20__t1_a_n24 n20_a_n24 183.071
r_22_t0_a_n24 n22__t0_a_n24 n22_a_n24 183.071
r_22_t1_a_n24 n22__t1_a_n24 n22_a_n24 183.071
r_23_t0_a_n24 n23__t0_a_n24 n23_a_n24 183.071
r_23_t1_a_n24 n23__t1_a_n24 n23_a_n24 183.071
r_24_t0_a_n24 n24__t0_a_n24 n24_a_n24 183.071
r_24_t1_a_n24 n24__t1_a_n24 n24_a_n24 183.071
r_25_t0_a_n24 n25__t0_a_n24 n25_a_n24 183.071
r_25_t1_a_n24 n25__t1_a_n24 n25_a_n24 183.071
r_29_t0_a_n24 n29__t0_a_n24 n29_a_n24 183.071
r_29_t1_a_n24 n29__t1_a_n24 n29_a_n24 183.071
r_30_t0_a_n24 n30__t0_a_n24 n30_a_n24 183.071
r_30_t1_a_n24 n30__t1_a_n24 n30_a_n24 183.071
r_31_t0_a_n24 n31__t0_a_n24 n31_a_n24 183.071
r_31_t1_a_n24 n31__t1_a_n24 n31_a_n24 183.071
r_32_t0_a_n24 n32__t0_a_n24 n32_a_n24 183.071
r_32_t1_a_n24 n32__t1_a_n24 n32_a_n24 183.071
r_7_t0_a_n24 n7__t0_a_n24 n7_a_n24 183.071
r_7_t1_a_n24 n7__t1_a_n24 n7_a_n24 183.071
r_8_t0_a_n24 n8__t0_a_n24 n8_a_n24 183.071
r_8_t1_a_n24 n8__t1_a_n24 n8_a_n24 183.071
r_9_t0_a_n24 n9__t0_a_n24 n9_a_n24 183.071
r_9_t1_a_n24 n9__t1_a_n24 n9_a_n24 183.071
rgnd_t0_a_n24 gnd__t0_a_n24 0 38.2988
rgnd_t1_a_n24 gnd__t1_a_n24 0 33.9576
rgnd_t2_a_n24 gnd__t2_a_n24 0 33.9576
rgnd_t3_a_n24 gnd__t3_a_n24 0 38.2988
rgnd_t4_a_n24 gnd__t4_a_n24 0 38.2988
rgnd_t5_a_n24 gnd__t5_a_n24 0 33.9576
rgnd_t6_a_n24 gnd__t6_a_n24 0 33.9576
rgnd_t7_a_n24 gnd__t7_a_n24 0 38.2988
rgnd_t8_a_n24 gnd__t8_a_n24 0 28.0185
rgnd_t9_a_n24 gnd__t9_a_n24 0 21.7106
rgnd_t10_a_n24 gnd__t10_a_n24 0 21.7106
rgnd_t11_a_n24 gnd__t11_a_n24 0 28.0185
rgnd_t12_a_n24 gnd__t12_a_n24 0 18.9833
rgnd_t13_a_n24 gnd__t13_a_n24 0 6.8325
rgnd_t14_a_n24 gnd__t14_a_n24 0 6.8325
rgnd_t15_a_n24 gnd__t15_a_n24 0 18.9833
rgnd_t16_a_n24 gnd__t16_a_n24 0 24.2409
rgnd_t17_a_n24 gnd__t17_a_n24 0 16.5511
rgnd_t18_a_n24 gnd__t18_a_n24 0 16.5511
rgnd_t19_a_n24 gnd__t19_a_n24 0 24.2409
rgnd_t20_a_n24 gnd__t20_a_n24 0 24.2409
rgnd_t21_a_n24 gnd__t21_a_n24 0 16.5511
rgnd_t22_a_n24 gnd__t22_a_n24 0 16.5511
rgnd_t23_a_n24 gnd__t23_a_n24 0 24.2409
rgnd_t24_a_n24 gnd__t24_a_n24 0 18.9833
rgnd_t25_a_n24 gnd__t25_a_n24 0 6.8325
rgnd_t26_a_n24 gnd__t26_a_n24 0 6.8325
rgnd_t27_a_n24 gnd__t27_a_n24 0 18.9833
rgnd_t28_a_n24 gnd__t28_a_n24 0 28.0185
rgnd_t29_a_n24 gnd__t29_a_n24 0 21.7106
rgnd_t30_a_n24 gnd__t30_a_n24 0 21.7106
rgnd_t31_a_n24 gnd__t31_a_n24 0 28.0185
rbl_0_t0_a_n24 bl_0__t0_a_n24 bl_0_a_n24 14.8304
rbl_0_t1_a_n24 bl_0__t1_a_n24 bl_0_a_n24 10.9301
rbl_0_t2_a_n24 bl_0__t2_a_n24 bl_0_a_n24 14.8304
rbl_0_t3_a_n24 bl_0__t3_a_n24 bl_0_a_n24 10.9301
rbl_1_t0_a_n24 bl_1__t0_a_n24 bl_1_a_n24 10.9301
rbl_1_t1_a_n24 bl_1__t1_a_n24 bl_1_a_n24 14.8304
rbl_1_t2_a_n24 bl_1__t2_a_n24 bl_1_a_n24 14.8304
rbl_1_t3_a_n24 bl_1__t3_a_n24 bl_1_a_n24 10.9301
rbl_2_t0_a_n24 bl_2__t0_a_n24 bl_2_a_n24 10.9301
rbl_2_t1_a_n24 bl_2__t1_a_n24 bl_2_a_n24 14.8304
rbl_2_t2_a_n24 bl_2__t2_a_n24 bl_2_a_n24 14.8304
rbl_2_t3_a_n24 bl_2__t3_a_n24 bl_2_a_n24 10.9301
rbl_3_t0_a_n24 bl_3__t0_a_n24 bl_3_a_n24 14.8304
rbl_3_t1_a_n24 bl_3__t1_a_n24 bl_3_a_n24 10.9301
rbl_3_t2_a_n24 bl_3__t2_a_n24 bl_3_a_n24 14.8304
rbl_3_t3_a_n24 bl_3__t3_a_n24 bl_3_a_n24 10.9301
rrbl_0_t0_a_n24 rbl_0__t0_a_n24 rbl_0_a_n24 36.5601
rrbl_0_t1_a_n24 rbl_0__t1_a_n24 rbl_0_a_n24 36.5601
rrbl_0_t2_a_n24 rbl_0__t2_a_n24 rbl_0_a_n24 2.99444
rrbl_0_t3_a_n24 rbl_0__t3_a_n24 rbl_0_a_n24 2.99444
rrbl_1_t0_a_n24 rbl_1__t0_a_n24 rbl_1_a_n24 36.5601
rrbl_1_t1_a_n24 rbl_1__t1_a_n24 rbl_1_a_n24 36.5601
rrbl_1_t2_a_n24 rbl_1__t2_a_n24 rbl_1_a_n24 2.99444
rrbl_1_t3_a_n24 rbl_1__t3_a_n24 rbl_1_a_n24 2.99444
rrbl_2_t0_a_n24 rbl_2__t0_a_n24 rbl_2_a_n24 36.5601
rrbl_2_t1_a_n24 rbl_2__t1_a_n24 rbl_2_a_n24 36.5601
rrbl_2_t2_a_n24 rbl_2__t2_a_n24 rbl_2_a_n24 2.99444
rrbl_2_t3_a_n24 rbl_2__t3_a_n24 rbl_2_a_n24 2.99444
rrbl_3_t0_a_n24 rbl_3__t0_a_n24 rbl_3_a_n24 36.5601
rrbl_3_t1_a_n24 rbl_3__t1_a_n24 rbl_3_a_n24 36.5601
rrbl_3_t2_a_n24 rbl_3__t2_a_n24 rbl_3_a_n24 2.99444
rrbl_3_t3_a_n24 rbl_3__t3_a_n24 rbl_3_a_n24 2.99444
rrwl_0_t0_a_n24 rwl_0__t0_a_n24 rwl_0_a_n24 38.2618
rrwl_0_t1_a_n24 rwl_0__t1_a_n24 rwl_0_a_n24 12.7539
rrwl_0_t2_a_n24 rwl_0__t2_a_n24 rwl_0_a_n24 38.2618
rrwl_0_t3_a_n24 rwl_0__t3_a_n24 rwl_0_a_n24 12.7539
rrwl_1_t0_a_n24 rwl_1__t0_a_n24 rwl_1_a_n24 38.2618
rrwl_1_t1_a_n24 rwl_1__t1_a_n24 rwl_1_a_n24 12.7539
rrwl_1_t2_a_n24 rwl_1__t2_a_n24 rwl_1_a_n24 12.7539
rrwl_1_t3_a_n24 rwl_1__t3_a_n24 rwl_1_a_n24 38.2618
rrwl_2_t0_a_n24 rwl_2__t0_a_n24 rwl_2_a_n24 12.7539
rrwl_2_t1_a_n24 rwl_2__t1_a_n24 rwl_2_a_n24 12.7539
rrwl_2_t2_a_n24 rwl_2__t2_a_n24 rwl_2_a_n24 38.2618
rrwl_2_t3_a_n24 rwl_2__t3_a_n24 rwl_2_a_n24 38.2618
rrwl_3_t0_a_n24 rwl_3__t0_a_n24 rwl_3_a_n24 38.2618
rrwl_3_t1_a_n24 rwl_3__t1_a_n24 rwl_3_a_n24 12.7539
rrwl_3_t2_a_n24 rwl_3__t2_a_n24 rwl_3_a_n24 12.7539
rrwl_3_t3_a_n24 rwl_3__t3_a_n24 rwl_3_a_n24 38.2618
rwl_0_t0_a_n24 wl_0__t0_a_n24 wl_0_a_n24 245.959
rwl_0_t1_a_n24 wl_0__t1_a_n24 wl_0_a_n24 245.959
rwl_0_t2_a_n24 wl_0__t2_a_n24 wl_0_a_n24 81.9864
rwl_0_t3_a_n24 wl_0__t3_a_n24 wl_0_a_n24 81.9864
rwl_1_t0_a_n24 wl_1__t0_a_n24 wl_1_a_n24 245.959
rwl_1_t1_a_n24 wl_1__t1_a_n24 wl_1_a_n24 81.9864
rwl_1_t2_a_n24 wl_1__t2_a_n24 wl_1_a_n24 81.9864
rwl_1_t3_a_n24 wl_1__t3_a_n24 wl_1_a_n24 245.959
rwl_2_t0_a_n24 wl_2__t0_a_n24 wl_2_a_n24 245.959
rwl_2_t1_a_n24 wl_2__t1_a_n24 wl_2_a_n24 81.9864
rwl_2_t2_a_n24 wl_2__t2_a_n24 wl_2_a_n24 81.9864
rwl_2_t3_a_n24 wl_2__t3_a_n24 wl_2_a_n24 245.959
rwl_3_t0_a_n24 wl_3__t0_a_n24 wl_3_a_n24 245.959
rwl_3_t1_a_n24 wl_3__t1_a_n24 wl_3_a_n24 81.9864
rwl_3_t2_a_n24 wl_3__t2_a_n24 wl_3_a_n24 81.9864
rwl_3_t3_a_n24 wl_3__t3_a_n24 wl_3_a_n24 245.959
c_10_a_n24 n10_a_n24 0 2.91622e-16
c_17_a_n24 n17_a_n24 0 2.91528e-16
c_18_a_n24 n18_a_n24 0 2.91528e-16
c_19_a_n24 n19_a_n24 0 2.91528e-16
c_20_a_n24 n20_a_n24 0 2.91622e-16
c_22_a_n24 n22_a_n24 0 2.91528e-16
c_23_a_n24 n23_a_n24 0 2.91528e-16
c_24_a_n24 n24_a_n24 0 2.91528e-16
c_25_a_n24 n25_a_n24 0 2.91622e-16
c_29_a_n24 n29_a_n24 0 2.91528e-16
c_30_a_n24 n30_a_n24 0 2.91528e-16
c_31_a_n24 n31_a_n24 0 2.91528e-16
c_32_a_n24 n32_a_n24 0 2.91622e-16
c_7_a_n24 n7_a_n24 0 2.91528e-16
c_8_a_n24 n8_a_n24 0 2.91528e-16
c_9_a_n24 n9_a_n24 0 2.91528e-16
cgnd_a_n24 0 0 2.48166e-15
cbl_0_a_n24 bl_0_a_n24 0 4.52661e-16
cbl_1_a_n24 bl_1_a_n24 0 4.52661e-16
cbl_2_a_n24 bl_2_a_n24 0 4.52661e-16
cbl_3_a_n24 bl_3_a_n24 0 4.52661e-16
crbl_0_a_n24 rbl_0_a_n24 0 9.14472e-16
crbl_1_a_n24 rbl_1_a_n24 0 9.14472e-16
crbl_2_a_n24 rbl_2_a_n24 0 9.14472e-16
crbl_3_a_n24 rbl_3_a_n24 0 9.17566e-16
crwl_0_a_n24 rwl_0_a_n24 0 5.19495e-16
crwl_1_a_n24 rwl_1_a_n24 0 5.11719e-16
crwl_2_a_n24 rwl_2_a_n24 0 5.11719e-16
crwl_3_a_n24 rwl_3_a_n24 0 5.19495e-16
cwl_0_a_n24 wl_0_a_n24 0 3.30388e-16
cwl_1_a_n24 wl_1_a_n24 0 3.30388e-16
cwl_2_a_n24 wl_2_a_n24 0 3.30388e-16
cwl_3_a_n24 wl_3_a_n24 0 3.30388e-16
ccc__10__9_a_n24 n10_a_n24 n9_a_n24 1.02e-17
ccc__10_bl_3_a_n24 n10_a_n24 bl_3_a_n24 1.3999e-17
ccc__10_rwl_0_a_n24 n10_a_n24 rwl_0_a_n24 4.335e-18
ccc__17__18_a_n24 n17_a_n24 n18_a_n24 1.02e-17
ccc__17_bl_0_a_n24 n17_a_n24 bl_0_a_n24 8.415e-18
ccc__17_rwl_1_a_n24 n17_a_n24 rwl_1_a_n24 1.3194e-17
ccc__18__19_a_n24 n18_a_n24 n19_a_n24 1.02e-17
ccc__18_bl_1_a_n24 n18_a_n24 bl_1_a_n24 8.415e-18
ccc__18_rwl_1_a_n24 n18_a_n24 rwl_1_a_n24 1.3194e-17
ccc__19__20_a_n24 n19_a_n24 n20_a_n24 1.02e-17
ccc__19_bl_2_a_n24 n19_a_n24 bl_2_a_n24 8.415e-18
ccc__19_rwl_1_a_n24 n19_a_n24 rwl_1_a_n24 1.3194e-17
ccc__20_bl_3_a_n24 n20_a_n24 bl_3_a_n24 8.415e-18
ccc__20_rwl_1_a_n24 n20_a_n24 rwl_1_a_n24 6.655e-18
ccc__22__23_a_n24 n22_a_n24 n23_a_n24 1.02e-17
ccc__22_bl_0_a_n24 n22_a_n24 bl_0_a_n24 8.415e-18
ccc__22_rwl_2_a_n24 n22_a_n24 rwl_2_a_n24 1.3194e-17
ccc__23__24_a_n24 n23_a_n24 n24_a_n24 1.02e-17
ccc__23_bl_1_a_n24 n23_a_n24 bl_1_a_n24 8.415e-18
ccc__23_rwl_2_a_n24 n23_a_n24 rwl_2_a_n24 1.3194e-17
ccc__24__25_a_n24 n24_a_n24 n25_a_n24 1.02e-17
ccc__24_bl_2_a_n24 n24_a_n24 bl_2_a_n24 8.415e-18
ccc__24_rwl_2_a_n24 n24_a_n24 rwl_2_a_n24 1.3194e-17
ccc__25_bl_3_a_n24 n25_a_n24 bl_3_a_n24 8.415e-18
ccc__25_rwl_2_a_n24 n25_a_n24 rwl_2_a_n24 6.655e-18
ccc__29__30_a_n24 n29_a_n24 n30_a_n24 1.02e-17
ccc__29_bl_0_a_n24 n29_a_n24 bl_0_a_n24 8.415e-18
ccc__29_rwl_3_a_n24 n29_a_n24 rwl_3_a_n24 1.3194e-17
ccc__30__31_a_n24 n30_a_n24 n31_a_n24 1.02e-17
ccc__30_bl_1_a_n24 n30_a_n24 bl_1_a_n24 8.415e-18
ccc__30_rwl_3_a_n24 n30_a_n24 rwl_3_a_n24 1.3194e-17
ccc__31__32_a_n24 n31_a_n24 n32_a_n24 1.02e-17
ccc__31_bl_2_a_n24 n31_a_n24 bl_2_a_n24 8.415e-18
ccc__31_rwl_3_a_n24 n31_a_n24 rwl_3_a_n24 1.3194e-17
ccc__32_bl_3_a_n24 n32_a_n24 bl_3_a_n24 8.415e-18
ccc__32_rwl_3_a_n24 n32_a_n24 rwl_3_a_n24 6.655e-18
ccc__7__8_a_n24 n7_a_n24 n8_a_n24 1.02e-17
ccc__7_bl_0_a_n24 n7_a_n24 bl_0_a_n24 1.3999e-17
ccc__7_rwl_0_a_n24 n7_a_n24 rwl_0_a_n24 8.961e-18
ccc__8__9_a_n24 n8_a_n24 n9_a_n24 1.02e-17
ccc__8_bl_1_a_n24 n8_a_n24 bl_1_a_n24 1.3999e-17
ccc__8_rwl_0_a_n24 n8_a_n24 rwl_0_a_n24 8.961e-18
ccc__9_bl_2_a_n24 n9_a_n24 bl_2_a_n24 1.3999e-17
ccc__9_rwl_0_a_n24 n9_a_n24 rwl_0_a_n24 8.961e-18
ccc_bl_0_rbl_0_a_n24 bl_0_a_n24 rbl_0_a_n24 1.88693e-16
ccc_bl_0_rwl_1_a_n24 bl_0_a_n24 rwl_1_a_n24 1.0093e-17
ccc_bl_0_rwl_2_a_n24 bl_0_a_n24 rwl_2_a_n24 1.0093e-17
ccc_bl_1_rbl_0_a_n24 bl_1_a_n24 rbl_0_a_n24 1.633e-16
ccc_bl_1_rbl_1_a_n24 bl_1_a_n24 rbl_1_a_n24 1.88693e-16
ccc_bl_1_rwl_1_a_n24 bl_1_a_n24 rwl_1_a_n24 1.0093e-17
ccc_bl_1_rwl_2_a_n24 bl_1_a_n24 rwl_2_a_n24 1.0093e-17
ccc_bl_2_rbl_1_a_n24 bl_2_a_n24 rbl_1_a_n24 1.633e-16
ccc_bl_2_rbl_2_a_n24 bl_2_a_n24 rbl_2_a_n24 1.88693e-16
ccc_bl_2_rwl_1_a_n24 bl_2_a_n24 rwl_1_a_n24 1.0093e-17
ccc_bl_2_rwl_2_a_n24 bl_2_a_n24 rwl_2_a_n24 1.0093e-17
ccc_bl_3_rbl_2_a_n24 bl_3_a_n24 rbl_2_a_n24 1.633e-16
ccc_bl_3_rbl_3_a_n24 bl_3_a_n24 rbl_3_a_n24 1.88693e-16
ccc_bl_3_rwl_1_a_n24 bl_3_a_n24 rwl_1_a_n24 1.0093e-17
ccc_bl_3_rwl_2_a_n24 bl_3_a_n24 rwl_2_a_n24 1.0093e-17
ccc_rbl_0_rbl_1_a_n24 rbl_0_a_n24 rbl_1_a_n24 3.432e-17
ccc_rbl_0_rwl_0_a_n24 rbl_0_a_n24 rwl_0_a_n24 4.9752e-17
ccc_rbl_0_rwl_1_a_n24 rbl_0_a_n24 rwl_1_a_n24 4.9752e-17
ccc_rbl_0_rwl_2_a_n24 rbl_0_a_n24 rwl_2_a_n24 4.9752e-17
ccc_rbl_0_rwl_3_a_n24 rbl_0_a_n24 rwl_3_a_n24 4.9752e-17
ccc_rbl_1_rbl_2_a_n24 rbl_1_a_n24 rbl_2_a_n24 3.432e-17
ccc_rbl_1_rwl_0_a_n24 rbl_1_a_n24 rwl_0_a_n24 4.9752e-17
ccc_rbl_1_rwl_1_a_n24 rbl_1_a_n24 rwl_1_a_n24 4.9752e-17
ccc_rbl_1_rwl_2_a_n24 rbl_1_a_n24 rwl_2_a_n24 4.9752e-17
ccc_rbl_1_rwl_3_a_n24 rbl_1_a_n24 rwl_3_a_n24 4.9752e-17
ccc_rbl_2_rbl_3_a_n24 rbl_2_a_n24 rbl_3_a_n24 3.432e-17
ccc_rbl_2_rwl_0_a_n24 rbl_2_a_n24 rwl_0_a_n24 4.9752e-17
ccc_rbl_2_rwl_1_a_n24 rbl_2_a_n24 rwl_1_a_n24 4.9752e-17
ccc_rbl_2_rwl_2_a_n24 rbl_2_a_n24 rwl_2_a_n24 4.9752e-17
ccc_rbl_2_rwl_3_a_n24 rbl_2_a_n24 rwl_3_a_n24 4.9752e-17
ccc_rbl_3_rwl_0_a_n24 rbl_3_a_n24 rwl_0_a_n24 3.3407e-17
ccc_rbl_3_rwl_1_a_n24 rbl_3_a_n24 rwl_1_a_n24 3.3407e-17
ccc_rbl_3_rwl_2_a_n24 rbl_3_a_n24 rwl_2_a_n24 3.3407e-17
ccc_rbl_3_rwl_3_a_n24 rbl_3_a_n24 rwl_3_a_n24 3.3407e-17
vdw_a_n24_0 wl_0_a_n24 0 dc 0
vdr_a_n24_0 rwl_0_a_n24 vdd dc 0
vdw_a_n24_1 wl_1_a_n24 0 dc 0
vdr_a_n24_1 rwl_1_a_n24 vdd dc 0
vdw_a_n24_2 wl_2_a_n24 0 dc 0
vdr_a_n24_2 rwl_2_a_n24 vdd dc 0
vdw_a_n24_3 wl_3_a_n24 0 dc 0
vdr_a_n24_3 rwl_3_a_n24 vdd dc 0
vdb_a_n24_0 bl_0_a_n24 0 dc 0
vdp_a_n24_0 rbl_0_a_n24 vrbl dc 0
vdb_a_n24_1 bl_1_a_n24 0 dc 0
vdp_a_n24_1 rbl_1_a_n24 vrbl dc 0
vdb_a_n24_2 bl_2_a_n24 0 dc 0
vdp_a_n24_2 rbl_2_a_n24 vrbl dc 0
vdb_a_n24_3 bl_3_a_n24 0 dc 0
vdp_a_n24_3 rbl_3_a_n24 vrbl dc 0
vdn_a_n24_n7 n7_a_n24 0 dc 1
vdn_a_n24_n8 n8_a_n24 0 dc 1
vdn_a_n24_n9 n9_a_n24 0 dc 1
vdn_a_n24_n10 n10_a_n24 0 dc 1
vdn_a_n24_n17 n17_a_n24 0 dc 1
vdn_a_n24_n18 n18_a_n24 0 dc 1
vdn_a_n24_n19 n19_a_n24 0 dc 1
vdn_a_n24_n20 n20_a_n24 0 dc 1
vdn_a_n24_n22 n22_a_n24 0 dc 1
vdn_a_n24_n23 n23_a_n24 0 dc 1
vdn_a_n24_n25 n25_a_n24 0 dc 1
vdn_a_n24_n29 n29_a_n24 0 dc 1
vdn_a_n24_n30 n30_a_n24 0 dc 1
vdn_a_n24_n31 n31_a_n24 0 dc 1
vdn_a_n24_n32 n32_a_n24 0 dc 1
bdr_a_n24 n24_a_n24 0 i=5e-08*min(1,max(0,(time-1e-09)/0.2n))*0.5*(1+tanh((v(n24_a_n24)-0.05)/0.01))

* ---- instance a_n25: variant a, probed storage node \$25 ----
xm1_a_n25 rwl_0__t2_a_n25 n7__t0_a_n25 rbl_0__t0_a_n25 gnd__t0_a_n25 sky130_fd_pr__nfet_01v8 L=0.15 W=0.42 nf=1 ad=0.1197 as=0.1197 pd=1.41 ps=1.41 mult=1 m=1
xm2_a_n25 rwl_0__t3_a_n25 n8__t1_a_n25 rbl_1__t1_a_n25 gnd__t1_a_n25 sky130_fd_pr__nfet_01v8 L=0.15 W=0.42 nf=1 ad=0.1197 as=0.1197 pd=1.41 ps=1.41 mult=1 m=1
xm3_a_n25 rwl_0__t1_a_n25 n9__t1_a_n25 rbl_2__t1_a_n25 gnd__t2_a_n25 sky130_fd_pr__nfet_01v8 L=0.15 W=0.42 nf=1 ad=0.1197 as=0.1197 pd=1.41 ps=1.41 mult=1 m=1
xm4_a_n25 rwl_0__t0_a_n25 n10__t1_a_n25 rbl_3__t1_a_n25 gnd__t3_a_n25 sky130_fd_pr__nfet_01v8 L=0.15 W=0.42 nf=1 ad=0.1197 as=0.1197 pd=1.41 ps=1.41 mult=1 m=1
xm5_a_n25 bl_0__t0_a_n25 wl_0__t0_a_n25 n7__t1_a_n25 gnd__t8_a_n25 sky130_fd_pr__nfet_01v8 L=0.15 W=0.42 nf=1 ad=0.0588 as=0.1197 pd=0.7 ps=1.41 mult=1 m=1
xm6_a_n25 n17__t0_a_n25 wl_1__t0_a_n25 bl_0__t1_a_n25 gnd__t20_a_n25 sky130_fd_pr__nfet_01v8 L=0.15 W=0.42 nf=1 ad=0.1197 as=0.0588 pd=1.41 ps=0.7 mult=1 m=1
xm7_a_n25 bl_1__t2_a_n25 wl_0__t3_a_n25 n8__t0_a_n25 gnd__t9_a_n25 sky130_fd_pr__nfet_01v8 L=0.15 W=0.42 nf=1 ad=0.0588 as=0.1197 pd=0.7 ps=1.41 mult=1 m=1
xm8_a_n25 n18__t0_a_n25 wl_1__t1_a_n25 bl_1__t0_a_n25 gnd__t21_a_n25 sky130_fd_pr__nfet_01v8 L=0.15 W=0.42 nf=1 ad=0.1197 as=0.0588 pd=1.41 ps=0.7 mult=1 m=1
xm9_a_n25 bl_2__t2_a_n25 wl_0__t2_a_n25 n9__t0_a_n25 gnd__t10_a_n25 sky130_fd_pr__nfet_01v8 L=0.15 W=0.42 nf=1 ad=0.0588 as=0.1197 pd=0.7 ps=1.41 mult=1 m=1
xm10_a_n25 n19__t0_a_n25 wl_1__t2_a_n25 bl_2__t0_a_n25 gnd__t22_a_n25 sky130_fd_pr__nfet_01v8 L=0.15 W=0.42 nf=1 ad=0.1197 as=0.0588 pd=1.41 ps=0.7 mult=1 m=1
xm11_a_n25 bl_3__t2_a_n25 wl_0__t1_a_n25 n10__t0_a_n25 gnd__t11_a_n25 sky130_fd_pr__nfet_01v8 L=0.15 W=0.42 nf=1 ad=0.0588 as=0.1197 pd=0.7 ps=1.41 mult=1 m=1
xm12_a_n25 n20__t0_a_n25 wl_1__t3_a_n25 bl_3__t1_a_n25 gnd__t23_a_n25 sky130_fd_pr__nfet_01v8 L=0.15 W=0.42 nf=1 ad=0.1197 as=0.0588 pd=1.41 ps=0.7 mult=1 m=1
xm13_a_n25 rbl_0__t3_a_n25 n17__t1_a_n25 rwl_1__t0_a_n25 gnd__t12_a_n25 sky130_fd_pr__nfet_01v8 L=0.15 W=0.42 nf=1 ad=0.0588 as=0.1197 pd=0.7 ps=1.41 mult=1 m=1
xm14_a_n25 rwl_2__t3_a_n25 n22__t0_a_n25 rbl_0__t2_a_n25 gnd__t24_a_n25 sky130_fd_pr__nfet_01v8 L=0.15 W=0.42 nf=1 ad=0.1197 as=0.0588 pd=1.41 ps=0.7 mult=1 m=1
xm15_a_n25 rbl_1__t3_a_n25 n18__t1_a_n25 rwl_1__t1_a_n25 gnd__t13_a_n25 sky130_fd_pr__nfet_01v8 L=0.15 W=0.42 nf=1 ad=0.0588 as=0.1197 pd=0.7 ps=1.41 mult=1 m=1
xm16_a_n25 rwl_2__t0_a_n25 n23__t0_a_n25 rbl_1__t2_a_n25 gnd__t25_a_n25 sky130_fd_pr__nfet_01v8 L=0.15 W=0.42 nf=1 ad=0.1197 as=0.0588 pd=1.41 ps=0.7 mult=1 m=1
xm17_a_n25 rbl_2__t3_a_n25 n19__t1_a_n25 rwl_1__t2_a_n25 gnd__t14_a_n25 sky130_fd_pr__nfet_01v8 L=0.15 W=0.42 nf=1 ad=0.0588 as=0.1197 pd=0.7 ps=1.41 mult=1 m=1
xm18_a_n25 rwl_2__t1_a_n25 n24__t0_a_n25 rbl_2__t2_a_n25 gnd__t26_a_n25 sky130_fd_pr__nfet_01v8 L=0.15 W=0.42 nf=1 ad=0.1197 as=0.0588 pd=1.41 ps=0.7 mult=1 m=1
xm19_a_n25 rbl_3__t3_a_n25 n20__t1_a_n25 rwl_1__t3_a_n25 gnd__t15_a_n25 sky130_fd_pr__nfet_01v8 L=0.15 W=0.42 nf=1 ad=0.0588 as=0.1197 pd=0.7 ps=1.41 mult=1 m=1
xm20_a_n25 rwl_2__t2_a_n25 n25__t0_a_n25 rbl_3__t2_a_n25 gnd__t27_a_n25 sky130_fd_pr__nfet_01v8 L=0.15 W=0.42 nf=1 ad=0.1197 as=0.0588 pd=1.41 ps=0.7 mult=1 m=1
xm21_a_n25 bl_0__t3_a_n25 wl_2__t0_a_n25 n22__t1_a_n25 gnd__t16_a_n25 sky130_fd_pr__nfet_01v8 L=0.15 W=0.42 nf=1 ad=0.0588 as=0.1197 pd=0.7 ps=1.41 mult=1 m=1
xm22_a_n25 n29__t0_a_n25 wl_3__t3_a_n25 bl_0__t2_a_n25 gnd__t28_a_n25 sky130_fd_pr__nfet_01v8 L=0.15 W=0.42 nf=1 ad=0.1197 as=0.0588 pd=1.41 ps=0.7 mult=1 m=1
xm23_a_n25 bl_1__t3_a_n25 wl_2__t1_a_n25 n23__t1_a_n25 gnd__t17_a_n25 sky130_fd_pr__nfet_01v8 L=0.15 W=0.42 nf=1 ad=0.0588 as=0.1197 pd=0.7 ps=1.41 mult=1 m=1
xm24_a_n25 n30__t0_a_n25 wl_3__t2_a_n25 bl_1__t1_a_n25 gnd__t29_a_n25 sky130_fd_pr__nfet_01v8 L=0.15 W=0.42 nf=1 ad=0.1197 as=0.0588 pd=1.41 ps=0.7 mult=1 m=1
xm25_a_n25 bl_2__t3_a_n25 wl_2__t2_a_n25 n24__t1_a_n25 gnd__t18_a_n25 sky130_fd_pr__nfet_01v8 L=0.15 W=0.42 nf=1 ad=0.0588 as=0.1197 pd=0.7 ps=1.41 mult=1 m=1
xm26_a_n25 n31__t0_a_n25 wl_3__t1_a_n25 bl_2__t1_a_n25 gnd__t30_a_n25 sky130_fd_pr__nfet_01v8 L=0.15 W=0.42 nf=1 ad=0.1197 as=0.0588 pd=1.41 ps=0.7 mult=1 m=1
xm27_a_n25 bl_3__t3_a_n25 wl_2__t3_a_n25 n25__t1_a_n25 gnd__t19_a_n25 sky130_fd_pr__nfet_01v8 L=0.15 W=0.42 nf=1 ad=0.0588 as=0.1197 pd=0.7 ps=1.41 mult=1 m=1
xm28_a_n25 n32__t0_a_n25 wl_3__t0_a_n25 bl_3__t0_a_n25 gnd__t31_a_n25 sky130_fd_pr__nfet_01v8 L=0.15 W=0.42 nf=1 ad=0.1197 as=0.0588 pd=1.41 ps=0.7 mult=1 m=1
xm29_a_n25 rbl_0__t1_a_n25 n29__t1_a_n25 rwl_3__t0_a_n25 gnd__t4_a_n25 sky130_fd_pr__nfet_01v8 L=0.15 W=0.42 nf=1 ad=0.1197 as=0.1197 pd=1.41 ps=1.41 mult=1 m=1
xm30_a_n25 rbl_1__t0_a_n25 n30__t1_a_n25 rwl_3__t1_a_n25 gnd__t5_a_n25 sky130_fd_pr__nfet_01v8 L=0.15 W=0.42 nf=1 ad=0.1197 as=0.1197 pd=1.41 ps=1.41 mult=1 m=1
xm31_a_n25 rbl_2__t0_a_n25 n31__t1_a_n25 rwl_3__t2_a_n25 gnd__t6_a_n25 sky130_fd_pr__nfet_01v8 L=0.15 W=0.42 nf=1 ad=0.1197 as=0.1197 pd=1.41 ps=1.41 mult=1 m=1
xm32_a_n25 rbl_3__t0_a_n25 n32__t1_a_n25 rwl_3__t3_a_n25 gnd__t7_a_n25 sky130_fd_pr__nfet_01v8 L=0.15 W=0.42 nf=1 ad=0.1197 as=0.1197 pd=1.41 ps=1.41 mult=1 m=1
r_10_t0_a_n25 n10__t0_a_n25 n10_a_n25 183.071
r_10_t1_a_n25 n10__t1_a_n25 n10_a_n25 183.071
r_17_t0_a_n25 n17__t0_a_n25 n17_a_n25 183.071
r_17_t1_a_n25 n17__t1_a_n25 n17_a_n25 183.071
r_18_t0_a_n25 n18__t0_a_n25 n18_a_n25 183.071
r_18_t1_a_n25 n18__t1_a_n25 n18_a_n25 183.071
r_19_t0_a_n25 n19__t0_a_n25 n19_a_n25 183.071
r_19_t1_a_n25 n19__t1_a_n25 n19_a_n25 183.071
r_20_t0_a_n25 n20__t0_a_n25 n20_a_n25 183.071
r_20_t1_a_n25 n20__t1_a_n25 n20_a_n25 183.071
r_22_t0_a_n25 n22__t0_a_n25 n22_a_n25 183.071
r_22_t1_a_n25 n22__t1_a_n25 n22_a_n25 183.071
r_23_t0_a_n25 n23__t0_a_n25 n23_a_n25 183.071
r_23_t1_a_n25 n23__t1_a_n25 n23_a_n25 183.071
r_24_t0_a_n25 n24__t0_a_n25 n24_a_n25 183.071
r_24_t1_a_n25 n24__t1_a_n25 n24_a_n25 183.071
r_25_t0_a_n25 n25__t0_a_n25 n25_a_n25 183.071
r_25_t1_a_n25 n25__t1_a_n25 n25_a_n25 183.071
r_29_t0_a_n25 n29__t0_a_n25 n29_a_n25 183.071
r_29_t1_a_n25 n29__t1_a_n25 n29_a_n25 183.071
r_30_t0_a_n25 n30__t0_a_n25 n30_a_n25 183.071
r_30_t1_a_n25 n30__t1_a_n25 n30_a_n25 183.071
r_31_t0_a_n25 n31__t0_a_n25 n31_a_n25 183.071
r_31_t1_a_n25 n31__t1_a_n25 n31_a_n25 183.071
r_32_t0_a_n25 n32__t0_a_n25 n32_a_n25 183.071
r_32_t1_a_n25 n32__t1_a_n25 n32_a_n25 183.071
r_7_t0_a_n25 n7__t0_a_n25 n7_a_n25 183.071
r_7_t1_a_n25 n7__t1_a_n25 n7_a_n25 183.071
r_8_t0_a_n25 n8__t0_a_n25 n8_a_n25 183.071
r_8_t1_a_n25 n8__t1_a_n25 n8_a_n25 183.071
r_9_t0_a_n25 n9__t0_a_n25 n9_a_n25 183.071
r_9_t1_a_n25 n9__t1_a_n25 n9_a_n25 183.071
rgnd_t0_a_n25 gnd__t0_a_n25 0 38.2988
rgnd_t1_a_n25 gnd__t1_a_n25 0 33.9576
rgnd_t2_a_n25 gnd__t2_a_n25 0 33.9576
rgnd_t3_a_n25 gnd__t3_a_n25 0 38.2988
rgnd_t4_a_n25 gnd__t4_a_n25 0 38.2988
rgnd_t5_a_n25 gnd__t5_a_n25 0 33.9576
rgnd_t6_a_n25 gnd__t6_a_n25 0 33.9576
rgnd_t7_a_n25 gnd__t7_a_n25 0 38.2988
rgnd_t8_a_n25 gnd__t8_a_n25 0 28.0185
rgnd_t9_a_n25 gnd__t9_a_n25 0 21.7106
rgnd_t10_a_n25 gnd__t10_a_n25 0 21.7106
rgnd_t11_a_n25 gnd__t11_a_n25 0 28.0185
rgnd_t12_a_n25 gnd__t12_a_n25 0 18.9833
rgnd_t13_a_n25 gnd__t13_a_n25 0 6.8325
rgnd_t14_a_n25 gnd__t14_a_n25 0 6.8325
rgnd_t15_a_n25 gnd__t15_a_n25 0 18.9833
rgnd_t16_a_n25 gnd__t16_a_n25 0 24.2409
rgnd_t17_a_n25 gnd__t17_a_n25 0 16.5511
rgnd_t18_a_n25 gnd__t18_a_n25 0 16.5511
rgnd_t19_a_n25 gnd__t19_a_n25 0 24.2409
rgnd_t20_a_n25 gnd__t20_a_n25 0 24.2409
rgnd_t21_a_n25 gnd__t21_a_n25 0 16.5511
rgnd_t22_a_n25 gnd__t22_a_n25 0 16.5511
rgnd_t23_a_n25 gnd__t23_a_n25 0 24.2409
rgnd_t24_a_n25 gnd__t24_a_n25 0 18.9833
rgnd_t25_a_n25 gnd__t25_a_n25 0 6.8325
rgnd_t26_a_n25 gnd__t26_a_n25 0 6.8325
rgnd_t27_a_n25 gnd__t27_a_n25 0 18.9833
rgnd_t28_a_n25 gnd__t28_a_n25 0 28.0185
rgnd_t29_a_n25 gnd__t29_a_n25 0 21.7106
rgnd_t30_a_n25 gnd__t30_a_n25 0 21.7106
rgnd_t31_a_n25 gnd__t31_a_n25 0 28.0185
rbl_0_t0_a_n25 bl_0__t0_a_n25 bl_0_a_n25 14.8304
rbl_0_t1_a_n25 bl_0__t1_a_n25 bl_0_a_n25 10.9301
rbl_0_t2_a_n25 bl_0__t2_a_n25 bl_0_a_n25 14.8304
rbl_0_t3_a_n25 bl_0__t3_a_n25 bl_0_a_n25 10.9301
rbl_1_t0_a_n25 bl_1__t0_a_n25 bl_1_a_n25 10.9301
rbl_1_t1_a_n25 bl_1__t1_a_n25 bl_1_a_n25 14.8304
rbl_1_t2_a_n25 bl_1__t2_a_n25 bl_1_a_n25 14.8304
rbl_1_t3_a_n25 bl_1__t3_a_n25 bl_1_a_n25 10.9301
rbl_2_t0_a_n25 bl_2__t0_a_n25 bl_2_a_n25 10.9301
rbl_2_t1_a_n25 bl_2__t1_a_n25 bl_2_a_n25 14.8304
rbl_2_t2_a_n25 bl_2__t2_a_n25 bl_2_a_n25 14.8304
rbl_2_t3_a_n25 bl_2__t3_a_n25 bl_2_a_n25 10.9301
rbl_3_t0_a_n25 bl_3__t0_a_n25 bl_3_a_n25 14.8304
rbl_3_t1_a_n25 bl_3__t1_a_n25 bl_3_a_n25 10.9301
rbl_3_t2_a_n25 bl_3__t2_a_n25 bl_3_a_n25 14.8304
rbl_3_t3_a_n25 bl_3__t3_a_n25 bl_3_a_n25 10.9301
rrbl_0_t0_a_n25 rbl_0__t0_a_n25 rbl_0_a_n25 36.5601
rrbl_0_t1_a_n25 rbl_0__t1_a_n25 rbl_0_a_n25 36.5601
rrbl_0_t2_a_n25 rbl_0__t2_a_n25 rbl_0_a_n25 2.99444
rrbl_0_t3_a_n25 rbl_0__t3_a_n25 rbl_0_a_n25 2.99444
rrbl_1_t0_a_n25 rbl_1__t0_a_n25 rbl_1_a_n25 36.5601
rrbl_1_t1_a_n25 rbl_1__t1_a_n25 rbl_1_a_n25 36.5601
rrbl_1_t2_a_n25 rbl_1__t2_a_n25 rbl_1_a_n25 2.99444
rrbl_1_t3_a_n25 rbl_1__t3_a_n25 rbl_1_a_n25 2.99444
rrbl_2_t0_a_n25 rbl_2__t0_a_n25 rbl_2_a_n25 36.5601
rrbl_2_t1_a_n25 rbl_2__t1_a_n25 rbl_2_a_n25 36.5601
rrbl_2_t2_a_n25 rbl_2__t2_a_n25 rbl_2_a_n25 2.99444
rrbl_2_t3_a_n25 rbl_2__t3_a_n25 rbl_2_a_n25 2.99444
rrbl_3_t0_a_n25 rbl_3__t0_a_n25 rbl_3_a_n25 36.5601
rrbl_3_t1_a_n25 rbl_3__t1_a_n25 rbl_3_a_n25 36.5601
rrbl_3_t2_a_n25 rbl_3__t2_a_n25 rbl_3_a_n25 2.99444
rrbl_3_t3_a_n25 rbl_3__t3_a_n25 rbl_3_a_n25 2.99444
rrwl_0_t0_a_n25 rwl_0__t0_a_n25 rwl_0_a_n25 38.2618
rrwl_0_t1_a_n25 rwl_0__t1_a_n25 rwl_0_a_n25 12.7539
rrwl_0_t2_a_n25 rwl_0__t2_a_n25 rwl_0_a_n25 38.2618
rrwl_0_t3_a_n25 rwl_0__t3_a_n25 rwl_0_a_n25 12.7539
rrwl_1_t0_a_n25 rwl_1__t0_a_n25 rwl_1_a_n25 38.2618
rrwl_1_t1_a_n25 rwl_1__t1_a_n25 rwl_1_a_n25 12.7539
rrwl_1_t2_a_n25 rwl_1__t2_a_n25 rwl_1_a_n25 12.7539
rrwl_1_t3_a_n25 rwl_1__t3_a_n25 rwl_1_a_n25 38.2618
rrwl_2_t0_a_n25 rwl_2__t0_a_n25 rwl_2_a_n25 12.7539
rrwl_2_t1_a_n25 rwl_2__t1_a_n25 rwl_2_a_n25 12.7539
rrwl_2_t2_a_n25 rwl_2__t2_a_n25 rwl_2_a_n25 38.2618
rrwl_2_t3_a_n25 rwl_2__t3_a_n25 rwl_2_a_n25 38.2618
rrwl_3_t0_a_n25 rwl_3__t0_a_n25 rwl_3_a_n25 38.2618
rrwl_3_t1_a_n25 rwl_3__t1_a_n25 rwl_3_a_n25 12.7539
rrwl_3_t2_a_n25 rwl_3__t2_a_n25 rwl_3_a_n25 12.7539
rrwl_3_t3_a_n25 rwl_3__t3_a_n25 rwl_3_a_n25 38.2618
rwl_0_t0_a_n25 wl_0__t0_a_n25 wl_0_a_n25 245.959
rwl_0_t1_a_n25 wl_0__t1_a_n25 wl_0_a_n25 245.959
rwl_0_t2_a_n25 wl_0__t2_a_n25 wl_0_a_n25 81.9864
rwl_0_t3_a_n25 wl_0__t3_a_n25 wl_0_a_n25 81.9864
rwl_1_t0_a_n25 wl_1__t0_a_n25 wl_1_a_n25 245.959
rwl_1_t1_a_n25 wl_1__t1_a_n25 wl_1_a_n25 81.9864
rwl_1_t2_a_n25 wl_1__t2_a_n25 wl_1_a_n25 81.9864
rwl_1_t3_a_n25 wl_1__t3_a_n25 wl_1_a_n25 245.959
rwl_2_t0_a_n25 wl_2__t0_a_n25 wl_2_a_n25 245.959
rwl_2_t1_a_n25 wl_2__t1_a_n25 wl_2_a_n25 81.9864
rwl_2_t2_a_n25 wl_2__t2_a_n25 wl_2_a_n25 81.9864
rwl_2_t3_a_n25 wl_2__t3_a_n25 wl_2_a_n25 245.959
rwl_3_t0_a_n25 wl_3__t0_a_n25 wl_3_a_n25 245.959
rwl_3_t1_a_n25 wl_3__t1_a_n25 wl_3_a_n25 81.9864
rwl_3_t2_a_n25 wl_3__t2_a_n25 wl_3_a_n25 81.9864
rwl_3_t3_a_n25 wl_3__t3_a_n25 wl_3_a_n25 245.959
c_10_a_n25 n10_a_n25 0 2.91622e-16
c_17_a_n25 n17_a_n25 0 2.91528e-16
c_18_a_n25 n18_a_n25 0 2.91528e-16
c_19_a_n25 n19_a_n25 0 2.91528e-16
c_20_a_n25 n20_a_n25 0 2.91622e-16
c_22_a_n25 n22_a_n25 0 2.91528e-16
c_23_a_n25 n23_a_n25 0 2.91528e-16
c_24_a_n25 n24_a_n25 0 2.91528e-16
c_25_a_n25 n25_a_n25 0 2.91622e-16
c_29_a_n25 n29_a_n25 0 2.91528e-16
c_30_a_n25 n30_a_n25 0 2.91528e-16
c_31_a_n25 n31_a_n25 0 2.91528e-16
c_32_a_n25 n32_a_n25 0 2.91622e-16
c_7_a_n25 n7_a_n25 0 2.91528e-16
c_8_a_n25 n8_a_n25 0 2.91528e-16
c_9_a_n25 n9_a_n25 0 2.91528e-16
cgnd_a_n25 0 0 2.48166e-15
cbl_0_a_n25 bl_0_a_n25 0 4.52661e-16
cbl_1_a_n25 bl_1_a_n25 0 4.52661e-16
cbl_2_a_n25 bl_2_a_n25 0 4.52661e-16
cbl_3_a_n25 bl_3_a_n25 0 4.52661e-16
crbl_0_a_n25 rbl_0_a_n25 0 9.14472e-16
crbl_1_a_n25 rbl_1_a_n25 0 9.14472e-16
crbl_2_a_n25 rbl_2_a_n25 0 9.14472e-16
crbl_3_a_n25 rbl_3_a_n25 0 9.17566e-16
crwl_0_a_n25 rwl_0_a_n25 0 5.19495e-16
crwl_1_a_n25 rwl_1_a_n25 0 5.11719e-16
crwl_2_a_n25 rwl_2_a_n25 0 5.11719e-16
crwl_3_a_n25 rwl_3_a_n25 0 5.19495e-16
cwl_0_a_n25 wl_0_a_n25 0 3.30388e-16
cwl_1_a_n25 wl_1_a_n25 0 3.30388e-16
cwl_2_a_n25 wl_2_a_n25 0 3.30388e-16
cwl_3_a_n25 wl_3_a_n25 0 3.30388e-16
ccc__10__9_a_n25 n10_a_n25 n9_a_n25 1.02e-17
ccc__10_bl_3_a_n25 n10_a_n25 bl_3_a_n25 1.3999e-17
ccc__10_rwl_0_a_n25 n10_a_n25 rwl_0_a_n25 4.335e-18
ccc__17__18_a_n25 n17_a_n25 n18_a_n25 1.02e-17
ccc__17_bl_0_a_n25 n17_a_n25 bl_0_a_n25 8.415e-18
ccc__17_rwl_1_a_n25 n17_a_n25 rwl_1_a_n25 1.3194e-17
ccc__18__19_a_n25 n18_a_n25 n19_a_n25 1.02e-17
ccc__18_bl_1_a_n25 n18_a_n25 bl_1_a_n25 8.415e-18
ccc__18_rwl_1_a_n25 n18_a_n25 rwl_1_a_n25 1.3194e-17
ccc__19__20_a_n25 n19_a_n25 n20_a_n25 1.02e-17
ccc__19_bl_2_a_n25 n19_a_n25 bl_2_a_n25 8.415e-18
ccc__19_rwl_1_a_n25 n19_a_n25 rwl_1_a_n25 1.3194e-17
ccc__20_bl_3_a_n25 n20_a_n25 bl_3_a_n25 8.415e-18
ccc__20_rwl_1_a_n25 n20_a_n25 rwl_1_a_n25 6.655e-18
ccc__22__23_a_n25 n22_a_n25 n23_a_n25 1.02e-17
ccc__22_bl_0_a_n25 n22_a_n25 bl_0_a_n25 8.415e-18
ccc__22_rwl_2_a_n25 n22_a_n25 rwl_2_a_n25 1.3194e-17
ccc__23__24_a_n25 n23_a_n25 n24_a_n25 1.02e-17
ccc__23_bl_1_a_n25 n23_a_n25 bl_1_a_n25 8.415e-18
ccc__23_rwl_2_a_n25 n23_a_n25 rwl_2_a_n25 1.3194e-17
ccc__24__25_a_n25 n24_a_n25 n25_a_n25 1.02e-17
ccc__24_bl_2_a_n25 n24_a_n25 bl_2_a_n25 8.415e-18
ccc__24_rwl_2_a_n25 n24_a_n25 rwl_2_a_n25 1.3194e-17
ccc__25_bl_3_a_n25 n25_a_n25 bl_3_a_n25 8.415e-18
ccc__25_rwl_2_a_n25 n25_a_n25 rwl_2_a_n25 6.655e-18
ccc__29__30_a_n25 n29_a_n25 n30_a_n25 1.02e-17
ccc__29_bl_0_a_n25 n29_a_n25 bl_0_a_n25 8.415e-18
ccc__29_rwl_3_a_n25 n29_a_n25 rwl_3_a_n25 1.3194e-17
ccc__30__31_a_n25 n30_a_n25 n31_a_n25 1.02e-17
ccc__30_bl_1_a_n25 n30_a_n25 bl_1_a_n25 8.415e-18
ccc__30_rwl_3_a_n25 n30_a_n25 rwl_3_a_n25 1.3194e-17
ccc__31__32_a_n25 n31_a_n25 n32_a_n25 1.02e-17
ccc__31_bl_2_a_n25 n31_a_n25 bl_2_a_n25 8.415e-18
ccc__31_rwl_3_a_n25 n31_a_n25 rwl_3_a_n25 1.3194e-17
ccc__32_bl_3_a_n25 n32_a_n25 bl_3_a_n25 8.415e-18
ccc__32_rwl_3_a_n25 n32_a_n25 rwl_3_a_n25 6.655e-18
ccc__7__8_a_n25 n7_a_n25 n8_a_n25 1.02e-17
ccc__7_bl_0_a_n25 n7_a_n25 bl_0_a_n25 1.3999e-17
ccc__7_rwl_0_a_n25 n7_a_n25 rwl_0_a_n25 8.961e-18
ccc__8__9_a_n25 n8_a_n25 n9_a_n25 1.02e-17
ccc__8_bl_1_a_n25 n8_a_n25 bl_1_a_n25 1.3999e-17
ccc__8_rwl_0_a_n25 n8_a_n25 rwl_0_a_n25 8.961e-18
ccc__9_bl_2_a_n25 n9_a_n25 bl_2_a_n25 1.3999e-17
ccc__9_rwl_0_a_n25 n9_a_n25 rwl_0_a_n25 8.961e-18
ccc_bl_0_rbl_0_a_n25 bl_0_a_n25 rbl_0_a_n25 1.88693e-16
ccc_bl_0_rwl_1_a_n25 bl_0_a_n25 rwl_1_a_n25 1.0093e-17
ccc_bl_0_rwl_2_a_n25 bl_0_a_n25 rwl_2_a_n25 1.0093e-17
ccc_bl_1_rbl_0_a_n25 bl_1_a_n25 rbl_0_a_n25 1.633e-16
ccc_bl_1_rbl_1_a_n25 bl_1_a_n25 rbl_1_a_n25 1.88693e-16
ccc_bl_1_rwl_1_a_n25 bl_1_a_n25 rwl_1_a_n25 1.0093e-17
ccc_bl_1_rwl_2_a_n25 bl_1_a_n25 rwl_2_a_n25 1.0093e-17
ccc_bl_2_rbl_1_a_n25 bl_2_a_n25 rbl_1_a_n25 1.633e-16
ccc_bl_2_rbl_2_a_n25 bl_2_a_n25 rbl_2_a_n25 1.88693e-16
ccc_bl_2_rwl_1_a_n25 bl_2_a_n25 rwl_1_a_n25 1.0093e-17
ccc_bl_2_rwl_2_a_n25 bl_2_a_n25 rwl_2_a_n25 1.0093e-17
ccc_bl_3_rbl_2_a_n25 bl_3_a_n25 rbl_2_a_n25 1.633e-16
ccc_bl_3_rbl_3_a_n25 bl_3_a_n25 rbl_3_a_n25 1.88693e-16
ccc_bl_3_rwl_1_a_n25 bl_3_a_n25 rwl_1_a_n25 1.0093e-17
ccc_bl_3_rwl_2_a_n25 bl_3_a_n25 rwl_2_a_n25 1.0093e-17
ccc_rbl_0_rbl_1_a_n25 rbl_0_a_n25 rbl_1_a_n25 3.432e-17
ccc_rbl_0_rwl_0_a_n25 rbl_0_a_n25 rwl_0_a_n25 4.9752e-17
ccc_rbl_0_rwl_1_a_n25 rbl_0_a_n25 rwl_1_a_n25 4.9752e-17
ccc_rbl_0_rwl_2_a_n25 rbl_0_a_n25 rwl_2_a_n25 4.9752e-17
ccc_rbl_0_rwl_3_a_n25 rbl_0_a_n25 rwl_3_a_n25 4.9752e-17
ccc_rbl_1_rbl_2_a_n25 rbl_1_a_n25 rbl_2_a_n25 3.432e-17
ccc_rbl_1_rwl_0_a_n25 rbl_1_a_n25 rwl_0_a_n25 4.9752e-17
ccc_rbl_1_rwl_1_a_n25 rbl_1_a_n25 rwl_1_a_n25 4.9752e-17
ccc_rbl_1_rwl_2_a_n25 rbl_1_a_n25 rwl_2_a_n25 4.9752e-17
ccc_rbl_1_rwl_3_a_n25 rbl_1_a_n25 rwl_3_a_n25 4.9752e-17
ccc_rbl_2_rbl_3_a_n25 rbl_2_a_n25 rbl_3_a_n25 3.432e-17
ccc_rbl_2_rwl_0_a_n25 rbl_2_a_n25 rwl_0_a_n25 4.9752e-17
ccc_rbl_2_rwl_1_a_n25 rbl_2_a_n25 rwl_1_a_n25 4.9752e-17
ccc_rbl_2_rwl_2_a_n25 rbl_2_a_n25 rwl_2_a_n25 4.9752e-17
ccc_rbl_2_rwl_3_a_n25 rbl_2_a_n25 rwl_3_a_n25 4.9752e-17
ccc_rbl_3_rwl_0_a_n25 rbl_3_a_n25 rwl_0_a_n25 3.3407e-17
ccc_rbl_3_rwl_1_a_n25 rbl_3_a_n25 rwl_1_a_n25 3.3407e-17
ccc_rbl_3_rwl_2_a_n25 rbl_3_a_n25 rwl_2_a_n25 3.3407e-17
ccc_rbl_3_rwl_3_a_n25 rbl_3_a_n25 rwl_3_a_n25 3.3407e-17
vdw_a_n25_0 wl_0_a_n25 0 dc 0
vdr_a_n25_0 rwl_0_a_n25 vdd dc 0
vdw_a_n25_1 wl_1_a_n25 0 dc 0
vdr_a_n25_1 rwl_1_a_n25 vdd dc 0
vdw_a_n25_2 wl_2_a_n25 0 dc 0
vdr_a_n25_2 rwl_2_a_n25 vdd dc 0
vdw_a_n25_3 wl_3_a_n25 0 dc 0
vdr_a_n25_3 rwl_3_a_n25 vdd dc 0
vdb_a_n25_0 bl_0_a_n25 0 dc 0
vdp_a_n25_0 rbl_0_a_n25 vrbl dc 0
vdb_a_n25_1 bl_1_a_n25 0 dc 0
vdp_a_n25_1 rbl_1_a_n25 vrbl dc 0
vdb_a_n25_2 bl_2_a_n25 0 dc 0
vdp_a_n25_2 rbl_2_a_n25 vrbl dc 0
vdb_a_n25_3 bl_3_a_n25 0 dc 0
vdp_a_n25_3 rbl_3_a_n25 vrbl dc 0
vdn_a_n25_n7 n7_a_n25 0 dc 1
vdn_a_n25_n8 n8_a_n25 0 dc 1
vdn_a_n25_n9 n9_a_n25 0 dc 1
vdn_a_n25_n10 n10_a_n25 0 dc 1
vdn_a_n25_n17 n17_a_n25 0 dc 1
vdn_a_n25_n18 n18_a_n25 0 dc 1
vdn_a_n25_n19 n19_a_n25 0 dc 1
vdn_a_n25_n20 n20_a_n25 0 dc 1
vdn_a_n25_n22 n22_a_n25 0 dc 1
vdn_a_n25_n23 n23_a_n25 0 dc 1
vdn_a_n25_n24 n24_a_n25 0 dc 1
vdn_a_n25_n29 n29_a_n25 0 dc 1
vdn_a_n25_n30 n30_a_n25 0 dc 1
vdn_a_n25_n31 n31_a_n25 0 dc 1
vdn_a_n25_n32 n32_a_n25 0 dc 1
bdr_a_n25 n25_a_n25 0 i=5e-08*min(1,max(0,(time-1e-09)/0.2n))*0.5*(1+tanh((v(n25_a_n25)-0.05)/0.01))

* ---- instance a_n29: variant a, probed storage node \$29 ----
xm1_a_n29 rwl_0__t2_a_n29 n7__t0_a_n29 rbl_0__t0_a_n29 gnd__t0_a_n29 sky130_fd_pr__nfet_01v8 L=0.15 W=0.42 nf=1 ad=0.1197 as=0.1197 pd=1.41 ps=1.41 mult=1 m=1
xm2_a_n29 rwl_0__t3_a_n29 n8__t1_a_n29 rbl_1__t1_a_n29 gnd__t1_a_n29 sky130_fd_pr__nfet_01v8 L=0.15 W=0.42 nf=1 ad=0.1197 as=0.1197 pd=1.41 ps=1.41 mult=1 m=1
xm3_a_n29 rwl_0__t1_a_n29 n9__t1_a_n29 rbl_2__t1_a_n29 gnd__t2_a_n29 sky130_fd_pr__nfet_01v8 L=0.15 W=0.42 nf=1 ad=0.1197 as=0.1197 pd=1.41 ps=1.41 mult=1 m=1
xm4_a_n29 rwl_0__t0_a_n29 n10__t1_a_n29 rbl_3__t1_a_n29 gnd__t3_a_n29 sky130_fd_pr__nfet_01v8 L=0.15 W=0.42 nf=1 ad=0.1197 as=0.1197 pd=1.41 ps=1.41 mult=1 m=1
xm5_a_n29 bl_0__t0_a_n29 wl_0__t0_a_n29 n7__t1_a_n29 gnd__t8_a_n29 sky130_fd_pr__nfet_01v8 L=0.15 W=0.42 nf=1 ad=0.0588 as=0.1197 pd=0.7 ps=1.41 mult=1 m=1
xm6_a_n29 n17__t0_a_n29 wl_1__t0_a_n29 bl_0__t1_a_n29 gnd__t20_a_n29 sky130_fd_pr__nfet_01v8 L=0.15 W=0.42 nf=1 ad=0.1197 as=0.0588 pd=1.41 ps=0.7 mult=1 m=1
xm7_a_n29 bl_1__t2_a_n29 wl_0__t3_a_n29 n8__t0_a_n29 gnd__t9_a_n29 sky130_fd_pr__nfet_01v8 L=0.15 W=0.42 nf=1 ad=0.0588 as=0.1197 pd=0.7 ps=1.41 mult=1 m=1
xm8_a_n29 n18__t0_a_n29 wl_1__t1_a_n29 bl_1__t0_a_n29 gnd__t21_a_n29 sky130_fd_pr__nfet_01v8 L=0.15 W=0.42 nf=1 ad=0.1197 as=0.0588 pd=1.41 ps=0.7 mult=1 m=1
xm9_a_n29 bl_2__t2_a_n29 wl_0__t2_a_n29 n9__t0_a_n29 gnd__t10_a_n29 sky130_fd_pr__nfet_01v8 L=0.15 W=0.42 nf=1 ad=0.0588 as=0.1197 pd=0.7 ps=1.41 mult=1 m=1
xm10_a_n29 n19__t0_a_n29 wl_1__t2_a_n29 bl_2__t0_a_n29 gnd__t22_a_n29 sky130_fd_pr__nfet_01v8 L=0.15 W=0.42 nf=1 ad=0.1197 as=0.0588 pd=1.41 ps=0.7 mult=1 m=1
xm11_a_n29 bl_3__t2_a_n29 wl_0__t1_a_n29 n10__t0_a_n29 gnd__t11_a_n29 sky130_fd_pr__nfet_01v8 L=0.15 W=0.42 nf=1 ad=0.0588 as=0.1197 pd=0.7 ps=1.41 mult=1 m=1
xm12_a_n29 n20__t0_a_n29 wl_1__t3_a_n29 bl_3__t1_a_n29 gnd__t23_a_n29 sky130_fd_pr__nfet_01v8 L=0.15 W=0.42 nf=1 ad=0.1197 as=0.0588 pd=1.41 ps=0.7 mult=1 m=1
xm13_a_n29 rbl_0__t3_a_n29 n17__t1_a_n29 rwl_1__t0_a_n29 gnd__t12_a_n29 sky130_fd_pr__nfet_01v8 L=0.15 W=0.42 nf=1 ad=0.0588 as=0.1197 pd=0.7 ps=1.41 mult=1 m=1
xm14_a_n29 rwl_2__t3_a_n29 n22__t0_a_n29 rbl_0__t2_a_n29 gnd__t24_a_n29 sky130_fd_pr__nfet_01v8 L=0.15 W=0.42 nf=1 ad=0.1197 as=0.0588 pd=1.41 ps=0.7 mult=1 m=1
xm15_a_n29 rbl_1__t3_a_n29 n18__t1_a_n29 rwl_1__t1_a_n29 gnd__t13_a_n29 sky130_fd_pr__nfet_01v8 L=0.15 W=0.42 nf=1 ad=0.0588 as=0.1197 pd=0.7 ps=1.41 mult=1 m=1
xm16_a_n29 rwl_2__t0_a_n29 n23__t0_a_n29 rbl_1__t2_a_n29 gnd__t25_a_n29 sky130_fd_pr__nfet_01v8 L=0.15 W=0.42 nf=1 ad=0.1197 as=0.0588 pd=1.41 ps=0.7 mult=1 m=1
xm17_a_n29 rbl_2__t3_a_n29 n19__t1_a_n29 rwl_1__t2_a_n29 gnd__t14_a_n29 sky130_fd_pr__nfet_01v8 L=0.15 W=0.42 nf=1 ad=0.0588 as=0.1197 pd=0.7 ps=1.41 mult=1 m=1
xm18_a_n29 rwl_2__t1_a_n29 n24__t0_a_n29 rbl_2__t2_a_n29 gnd__t26_a_n29 sky130_fd_pr__nfet_01v8 L=0.15 W=0.42 nf=1 ad=0.1197 as=0.0588 pd=1.41 ps=0.7 mult=1 m=1
xm19_a_n29 rbl_3__t3_a_n29 n20__t1_a_n29 rwl_1__t3_a_n29 gnd__t15_a_n29 sky130_fd_pr__nfet_01v8 L=0.15 W=0.42 nf=1 ad=0.0588 as=0.1197 pd=0.7 ps=1.41 mult=1 m=1
xm20_a_n29 rwl_2__t2_a_n29 n25__t0_a_n29 rbl_3__t2_a_n29 gnd__t27_a_n29 sky130_fd_pr__nfet_01v8 L=0.15 W=0.42 nf=1 ad=0.1197 as=0.0588 pd=1.41 ps=0.7 mult=1 m=1
xm21_a_n29 bl_0__t3_a_n29 wl_2__t0_a_n29 n22__t1_a_n29 gnd__t16_a_n29 sky130_fd_pr__nfet_01v8 L=0.15 W=0.42 nf=1 ad=0.0588 as=0.1197 pd=0.7 ps=1.41 mult=1 m=1
xm22_a_n29 n29__t0_a_n29 wl_3__t3_a_n29 bl_0__t2_a_n29 gnd__t28_a_n29 sky130_fd_pr__nfet_01v8 L=0.15 W=0.42 nf=1 ad=0.1197 as=0.0588 pd=1.41 ps=0.7 mult=1 m=1
xm23_a_n29 bl_1__t3_a_n29 wl_2__t1_a_n29 n23__t1_a_n29 gnd__t17_a_n29 sky130_fd_pr__nfet_01v8 L=0.15 W=0.42 nf=1 ad=0.0588 as=0.1197 pd=0.7 ps=1.41 mult=1 m=1
xm24_a_n29 n30__t0_a_n29 wl_3__t2_a_n29 bl_1__t1_a_n29 gnd__t29_a_n29 sky130_fd_pr__nfet_01v8 L=0.15 W=0.42 nf=1 ad=0.1197 as=0.0588 pd=1.41 ps=0.7 mult=1 m=1
xm25_a_n29 bl_2__t3_a_n29 wl_2__t2_a_n29 n24__t1_a_n29 gnd__t18_a_n29 sky130_fd_pr__nfet_01v8 L=0.15 W=0.42 nf=1 ad=0.0588 as=0.1197 pd=0.7 ps=1.41 mult=1 m=1
xm26_a_n29 n31__t0_a_n29 wl_3__t1_a_n29 bl_2__t1_a_n29 gnd__t30_a_n29 sky130_fd_pr__nfet_01v8 L=0.15 W=0.42 nf=1 ad=0.1197 as=0.0588 pd=1.41 ps=0.7 mult=1 m=1
xm27_a_n29 bl_3__t3_a_n29 wl_2__t3_a_n29 n25__t1_a_n29 gnd__t19_a_n29 sky130_fd_pr__nfet_01v8 L=0.15 W=0.42 nf=1 ad=0.0588 as=0.1197 pd=0.7 ps=1.41 mult=1 m=1
xm28_a_n29 n32__t0_a_n29 wl_3__t0_a_n29 bl_3__t0_a_n29 gnd__t31_a_n29 sky130_fd_pr__nfet_01v8 L=0.15 W=0.42 nf=1 ad=0.1197 as=0.0588 pd=1.41 ps=0.7 mult=1 m=1
xm29_a_n29 rbl_0__t1_a_n29 n29__t1_a_n29 rwl_3__t0_a_n29 gnd__t4_a_n29 sky130_fd_pr__nfet_01v8 L=0.15 W=0.42 nf=1 ad=0.1197 as=0.1197 pd=1.41 ps=1.41 mult=1 m=1
xm30_a_n29 rbl_1__t0_a_n29 n30__t1_a_n29 rwl_3__t1_a_n29 gnd__t5_a_n29 sky130_fd_pr__nfet_01v8 L=0.15 W=0.42 nf=1 ad=0.1197 as=0.1197 pd=1.41 ps=1.41 mult=1 m=1
xm31_a_n29 rbl_2__t0_a_n29 n31__t1_a_n29 rwl_3__t2_a_n29 gnd__t6_a_n29 sky130_fd_pr__nfet_01v8 L=0.15 W=0.42 nf=1 ad=0.1197 as=0.1197 pd=1.41 ps=1.41 mult=1 m=1
xm32_a_n29 rbl_3__t0_a_n29 n32__t1_a_n29 rwl_3__t3_a_n29 gnd__t7_a_n29 sky130_fd_pr__nfet_01v8 L=0.15 W=0.42 nf=1 ad=0.1197 as=0.1197 pd=1.41 ps=1.41 mult=1 m=1
r_10_t0_a_n29 n10__t0_a_n29 n10_a_n29 183.071
r_10_t1_a_n29 n10__t1_a_n29 n10_a_n29 183.071
r_17_t0_a_n29 n17__t0_a_n29 n17_a_n29 183.071
r_17_t1_a_n29 n17__t1_a_n29 n17_a_n29 183.071
r_18_t0_a_n29 n18__t0_a_n29 n18_a_n29 183.071
r_18_t1_a_n29 n18__t1_a_n29 n18_a_n29 183.071
r_19_t0_a_n29 n19__t0_a_n29 n19_a_n29 183.071
r_19_t1_a_n29 n19__t1_a_n29 n19_a_n29 183.071
r_20_t0_a_n29 n20__t0_a_n29 n20_a_n29 183.071
r_20_t1_a_n29 n20__t1_a_n29 n20_a_n29 183.071
r_22_t0_a_n29 n22__t0_a_n29 n22_a_n29 183.071
r_22_t1_a_n29 n22__t1_a_n29 n22_a_n29 183.071
r_23_t0_a_n29 n23__t0_a_n29 n23_a_n29 183.071
r_23_t1_a_n29 n23__t1_a_n29 n23_a_n29 183.071
r_24_t0_a_n29 n24__t0_a_n29 n24_a_n29 183.071
r_24_t1_a_n29 n24__t1_a_n29 n24_a_n29 183.071
r_25_t0_a_n29 n25__t0_a_n29 n25_a_n29 183.071
r_25_t1_a_n29 n25__t1_a_n29 n25_a_n29 183.071
r_29_t0_a_n29 n29__t0_a_n29 n29_a_n29 183.071
r_29_t1_a_n29 n29__t1_a_n29 n29_a_n29 183.071
r_30_t0_a_n29 n30__t0_a_n29 n30_a_n29 183.071
r_30_t1_a_n29 n30__t1_a_n29 n30_a_n29 183.071
r_31_t0_a_n29 n31__t0_a_n29 n31_a_n29 183.071
r_31_t1_a_n29 n31__t1_a_n29 n31_a_n29 183.071
r_32_t0_a_n29 n32__t0_a_n29 n32_a_n29 183.071
r_32_t1_a_n29 n32__t1_a_n29 n32_a_n29 183.071
r_7_t0_a_n29 n7__t0_a_n29 n7_a_n29 183.071
r_7_t1_a_n29 n7__t1_a_n29 n7_a_n29 183.071
r_8_t0_a_n29 n8__t0_a_n29 n8_a_n29 183.071
r_8_t1_a_n29 n8__t1_a_n29 n8_a_n29 183.071
r_9_t0_a_n29 n9__t0_a_n29 n9_a_n29 183.071
r_9_t1_a_n29 n9__t1_a_n29 n9_a_n29 183.071
rgnd_t0_a_n29 gnd__t0_a_n29 0 38.2988
rgnd_t1_a_n29 gnd__t1_a_n29 0 33.9576
rgnd_t2_a_n29 gnd__t2_a_n29 0 33.9576
rgnd_t3_a_n29 gnd__t3_a_n29 0 38.2988
rgnd_t4_a_n29 gnd__t4_a_n29 0 38.2988
rgnd_t5_a_n29 gnd__t5_a_n29 0 33.9576
rgnd_t6_a_n29 gnd__t6_a_n29 0 33.9576
rgnd_t7_a_n29 gnd__t7_a_n29 0 38.2988
rgnd_t8_a_n29 gnd__t8_a_n29 0 28.0185
rgnd_t9_a_n29 gnd__t9_a_n29 0 21.7106
rgnd_t10_a_n29 gnd__t10_a_n29 0 21.7106
rgnd_t11_a_n29 gnd__t11_a_n29 0 28.0185
rgnd_t12_a_n29 gnd__t12_a_n29 0 18.9833
rgnd_t13_a_n29 gnd__t13_a_n29 0 6.8325
rgnd_t14_a_n29 gnd__t14_a_n29 0 6.8325
rgnd_t15_a_n29 gnd__t15_a_n29 0 18.9833
rgnd_t16_a_n29 gnd__t16_a_n29 0 24.2409
rgnd_t17_a_n29 gnd__t17_a_n29 0 16.5511
rgnd_t18_a_n29 gnd__t18_a_n29 0 16.5511
rgnd_t19_a_n29 gnd__t19_a_n29 0 24.2409
rgnd_t20_a_n29 gnd__t20_a_n29 0 24.2409
rgnd_t21_a_n29 gnd__t21_a_n29 0 16.5511
rgnd_t22_a_n29 gnd__t22_a_n29 0 16.5511
rgnd_t23_a_n29 gnd__t23_a_n29 0 24.2409
rgnd_t24_a_n29 gnd__t24_a_n29 0 18.9833
rgnd_t25_a_n29 gnd__t25_a_n29 0 6.8325
rgnd_t26_a_n29 gnd__t26_a_n29 0 6.8325
rgnd_t27_a_n29 gnd__t27_a_n29 0 18.9833
rgnd_t28_a_n29 gnd__t28_a_n29 0 28.0185
rgnd_t29_a_n29 gnd__t29_a_n29 0 21.7106
rgnd_t30_a_n29 gnd__t30_a_n29 0 21.7106
rgnd_t31_a_n29 gnd__t31_a_n29 0 28.0185
rbl_0_t0_a_n29 bl_0__t0_a_n29 bl_0_a_n29 14.8304
rbl_0_t1_a_n29 bl_0__t1_a_n29 bl_0_a_n29 10.9301
rbl_0_t2_a_n29 bl_0__t2_a_n29 bl_0_a_n29 14.8304
rbl_0_t3_a_n29 bl_0__t3_a_n29 bl_0_a_n29 10.9301
rbl_1_t0_a_n29 bl_1__t0_a_n29 bl_1_a_n29 10.9301
rbl_1_t1_a_n29 bl_1__t1_a_n29 bl_1_a_n29 14.8304
rbl_1_t2_a_n29 bl_1__t2_a_n29 bl_1_a_n29 14.8304
rbl_1_t3_a_n29 bl_1__t3_a_n29 bl_1_a_n29 10.9301
rbl_2_t0_a_n29 bl_2__t0_a_n29 bl_2_a_n29 10.9301
rbl_2_t1_a_n29 bl_2__t1_a_n29 bl_2_a_n29 14.8304
rbl_2_t2_a_n29 bl_2__t2_a_n29 bl_2_a_n29 14.8304
rbl_2_t3_a_n29 bl_2__t3_a_n29 bl_2_a_n29 10.9301
rbl_3_t0_a_n29 bl_3__t0_a_n29 bl_3_a_n29 14.8304
rbl_3_t1_a_n29 bl_3__t1_a_n29 bl_3_a_n29 10.9301
rbl_3_t2_a_n29 bl_3__t2_a_n29 bl_3_a_n29 14.8304
rbl_3_t3_a_n29 bl_3__t3_a_n29 bl_3_a_n29 10.9301
rrbl_0_t0_a_n29 rbl_0__t0_a_n29 rbl_0_a_n29 36.5601
rrbl_0_t1_a_n29 rbl_0__t1_a_n29 rbl_0_a_n29 36.5601
rrbl_0_t2_a_n29 rbl_0__t2_a_n29 rbl_0_a_n29 2.99444
rrbl_0_t3_a_n29 rbl_0__t3_a_n29 rbl_0_a_n29 2.99444
rrbl_1_t0_a_n29 rbl_1__t0_a_n29 rbl_1_a_n29 36.5601
rrbl_1_t1_a_n29 rbl_1__t1_a_n29 rbl_1_a_n29 36.5601
rrbl_1_t2_a_n29 rbl_1__t2_a_n29 rbl_1_a_n29 2.99444
rrbl_1_t3_a_n29 rbl_1__t3_a_n29 rbl_1_a_n29 2.99444
rrbl_2_t0_a_n29 rbl_2__t0_a_n29 rbl_2_a_n29 36.5601
rrbl_2_t1_a_n29 rbl_2__t1_a_n29 rbl_2_a_n29 36.5601
rrbl_2_t2_a_n29 rbl_2__t2_a_n29 rbl_2_a_n29 2.99444
rrbl_2_t3_a_n29 rbl_2__t3_a_n29 rbl_2_a_n29 2.99444
rrbl_3_t0_a_n29 rbl_3__t0_a_n29 rbl_3_a_n29 36.5601
rrbl_3_t1_a_n29 rbl_3__t1_a_n29 rbl_3_a_n29 36.5601
rrbl_3_t2_a_n29 rbl_3__t2_a_n29 rbl_3_a_n29 2.99444
rrbl_3_t3_a_n29 rbl_3__t3_a_n29 rbl_3_a_n29 2.99444
rrwl_0_t0_a_n29 rwl_0__t0_a_n29 rwl_0_a_n29 38.2618
rrwl_0_t1_a_n29 rwl_0__t1_a_n29 rwl_0_a_n29 12.7539
rrwl_0_t2_a_n29 rwl_0__t2_a_n29 rwl_0_a_n29 38.2618
rrwl_0_t3_a_n29 rwl_0__t3_a_n29 rwl_0_a_n29 12.7539
rrwl_1_t0_a_n29 rwl_1__t0_a_n29 rwl_1_a_n29 38.2618
rrwl_1_t1_a_n29 rwl_1__t1_a_n29 rwl_1_a_n29 12.7539
rrwl_1_t2_a_n29 rwl_1__t2_a_n29 rwl_1_a_n29 12.7539
rrwl_1_t3_a_n29 rwl_1__t3_a_n29 rwl_1_a_n29 38.2618
rrwl_2_t0_a_n29 rwl_2__t0_a_n29 rwl_2_a_n29 12.7539
rrwl_2_t1_a_n29 rwl_2__t1_a_n29 rwl_2_a_n29 12.7539
rrwl_2_t2_a_n29 rwl_2__t2_a_n29 rwl_2_a_n29 38.2618
rrwl_2_t3_a_n29 rwl_2__t3_a_n29 rwl_2_a_n29 38.2618
rrwl_3_t0_a_n29 rwl_3__t0_a_n29 rwl_3_a_n29 38.2618
rrwl_3_t1_a_n29 rwl_3__t1_a_n29 rwl_3_a_n29 12.7539
rrwl_3_t2_a_n29 rwl_3__t2_a_n29 rwl_3_a_n29 12.7539
rrwl_3_t3_a_n29 rwl_3__t3_a_n29 rwl_3_a_n29 38.2618
rwl_0_t0_a_n29 wl_0__t0_a_n29 wl_0_a_n29 245.959
rwl_0_t1_a_n29 wl_0__t1_a_n29 wl_0_a_n29 245.959
rwl_0_t2_a_n29 wl_0__t2_a_n29 wl_0_a_n29 81.9864
rwl_0_t3_a_n29 wl_0__t3_a_n29 wl_0_a_n29 81.9864
rwl_1_t0_a_n29 wl_1__t0_a_n29 wl_1_a_n29 245.959
rwl_1_t1_a_n29 wl_1__t1_a_n29 wl_1_a_n29 81.9864
rwl_1_t2_a_n29 wl_1__t2_a_n29 wl_1_a_n29 81.9864
rwl_1_t3_a_n29 wl_1__t3_a_n29 wl_1_a_n29 245.959
rwl_2_t0_a_n29 wl_2__t0_a_n29 wl_2_a_n29 245.959
rwl_2_t1_a_n29 wl_2__t1_a_n29 wl_2_a_n29 81.9864
rwl_2_t2_a_n29 wl_2__t2_a_n29 wl_2_a_n29 81.9864
rwl_2_t3_a_n29 wl_2__t3_a_n29 wl_2_a_n29 245.959
rwl_3_t0_a_n29 wl_3__t0_a_n29 wl_3_a_n29 245.959
rwl_3_t1_a_n29 wl_3__t1_a_n29 wl_3_a_n29 81.9864
rwl_3_t2_a_n29 wl_3__t2_a_n29 wl_3_a_n29 81.9864
rwl_3_t3_a_n29 wl_3__t3_a_n29 wl_3_a_n29 245.959
c_10_a_n29 n10_a_n29 0 2.91622e-16
c_17_a_n29 n17_a_n29 0 2.91528e-16
c_18_a_n29 n18_a_n29 0 2.91528e-16
c_19_a_n29 n19_a_n29 0 2.91528e-16
c_20_a_n29 n20_a_n29 0 2.91622e-16
c_22_a_n29 n22_a_n29 0 2.91528e-16
c_23_a_n29 n23_a_n29 0 2.91528e-16
c_24_a_n29 n24_a_n29 0 2.91528e-16
c_25_a_n29 n25_a_n29 0 2.91622e-16
c_29_a_n29 n29_a_n29 0 2.91528e-16
c_30_a_n29 n30_a_n29 0 2.91528e-16
c_31_a_n29 n31_a_n29 0 2.91528e-16
c_32_a_n29 n32_a_n29 0 2.91622e-16
c_7_a_n29 n7_a_n29 0 2.91528e-16
c_8_a_n29 n8_a_n29 0 2.91528e-16
c_9_a_n29 n9_a_n29 0 2.91528e-16
cgnd_a_n29 0 0 2.48166e-15
cbl_0_a_n29 bl_0_a_n29 0 4.52661e-16
cbl_1_a_n29 bl_1_a_n29 0 4.52661e-16
cbl_2_a_n29 bl_2_a_n29 0 4.52661e-16
cbl_3_a_n29 bl_3_a_n29 0 4.52661e-16
crbl_0_a_n29 rbl_0_a_n29 0 9.14472e-16
crbl_1_a_n29 rbl_1_a_n29 0 9.14472e-16
crbl_2_a_n29 rbl_2_a_n29 0 9.14472e-16
crbl_3_a_n29 rbl_3_a_n29 0 9.17566e-16
crwl_0_a_n29 rwl_0_a_n29 0 5.19495e-16
crwl_1_a_n29 rwl_1_a_n29 0 5.11719e-16
crwl_2_a_n29 rwl_2_a_n29 0 5.11719e-16
crwl_3_a_n29 rwl_3_a_n29 0 5.19495e-16
cwl_0_a_n29 wl_0_a_n29 0 3.30388e-16
cwl_1_a_n29 wl_1_a_n29 0 3.30388e-16
cwl_2_a_n29 wl_2_a_n29 0 3.30388e-16
cwl_3_a_n29 wl_3_a_n29 0 3.30388e-16
ccc__10__9_a_n29 n10_a_n29 n9_a_n29 1.02e-17
ccc__10_bl_3_a_n29 n10_a_n29 bl_3_a_n29 1.3999e-17
ccc__10_rwl_0_a_n29 n10_a_n29 rwl_0_a_n29 4.335e-18
ccc__17__18_a_n29 n17_a_n29 n18_a_n29 1.02e-17
ccc__17_bl_0_a_n29 n17_a_n29 bl_0_a_n29 8.415e-18
ccc__17_rwl_1_a_n29 n17_a_n29 rwl_1_a_n29 1.3194e-17
ccc__18__19_a_n29 n18_a_n29 n19_a_n29 1.02e-17
ccc__18_bl_1_a_n29 n18_a_n29 bl_1_a_n29 8.415e-18
ccc__18_rwl_1_a_n29 n18_a_n29 rwl_1_a_n29 1.3194e-17
ccc__19__20_a_n29 n19_a_n29 n20_a_n29 1.02e-17
ccc__19_bl_2_a_n29 n19_a_n29 bl_2_a_n29 8.415e-18
ccc__19_rwl_1_a_n29 n19_a_n29 rwl_1_a_n29 1.3194e-17
ccc__20_bl_3_a_n29 n20_a_n29 bl_3_a_n29 8.415e-18
ccc__20_rwl_1_a_n29 n20_a_n29 rwl_1_a_n29 6.655e-18
ccc__22__23_a_n29 n22_a_n29 n23_a_n29 1.02e-17
ccc__22_bl_0_a_n29 n22_a_n29 bl_0_a_n29 8.415e-18
ccc__22_rwl_2_a_n29 n22_a_n29 rwl_2_a_n29 1.3194e-17
ccc__23__24_a_n29 n23_a_n29 n24_a_n29 1.02e-17
ccc__23_bl_1_a_n29 n23_a_n29 bl_1_a_n29 8.415e-18
ccc__23_rwl_2_a_n29 n23_a_n29 rwl_2_a_n29 1.3194e-17
ccc__24__25_a_n29 n24_a_n29 n25_a_n29 1.02e-17
ccc__24_bl_2_a_n29 n24_a_n29 bl_2_a_n29 8.415e-18
ccc__24_rwl_2_a_n29 n24_a_n29 rwl_2_a_n29 1.3194e-17
ccc__25_bl_3_a_n29 n25_a_n29 bl_3_a_n29 8.415e-18
ccc__25_rwl_2_a_n29 n25_a_n29 rwl_2_a_n29 6.655e-18
ccc__29__30_a_n29 n29_a_n29 n30_a_n29 1.02e-17
ccc__29_bl_0_a_n29 n29_a_n29 bl_0_a_n29 8.415e-18
ccc__29_rwl_3_a_n29 n29_a_n29 rwl_3_a_n29 1.3194e-17
ccc__30__31_a_n29 n30_a_n29 n31_a_n29 1.02e-17
ccc__30_bl_1_a_n29 n30_a_n29 bl_1_a_n29 8.415e-18
ccc__30_rwl_3_a_n29 n30_a_n29 rwl_3_a_n29 1.3194e-17
ccc__31__32_a_n29 n31_a_n29 n32_a_n29 1.02e-17
ccc__31_bl_2_a_n29 n31_a_n29 bl_2_a_n29 8.415e-18
ccc__31_rwl_3_a_n29 n31_a_n29 rwl_3_a_n29 1.3194e-17
ccc__32_bl_3_a_n29 n32_a_n29 bl_3_a_n29 8.415e-18
ccc__32_rwl_3_a_n29 n32_a_n29 rwl_3_a_n29 6.655e-18
ccc__7__8_a_n29 n7_a_n29 n8_a_n29 1.02e-17
ccc__7_bl_0_a_n29 n7_a_n29 bl_0_a_n29 1.3999e-17
ccc__7_rwl_0_a_n29 n7_a_n29 rwl_0_a_n29 8.961e-18
ccc__8__9_a_n29 n8_a_n29 n9_a_n29 1.02e-17
ccc__8_bl_1_a_n29 n8_a_n29 bl_1_a_n29 1.3999e-17
ccc__8_rwl_0_a_n29 n8_a_n29 rwl_0_a_n29 8.961e-18
ccc__9_bl_2_a_n29 n9_a_n29 bl_2_a_n29 1.3999e-17
ccc__9_rwl_0_a_n29 n9_a_n29 rwl_0_a_n29 8.961e-18
ccc_bl_0_rbl_0_a_n29 bl_0_a_n29 rbl_0_a_n29 1.88693e-16
ccc_bl_0_rwl_1_a_n29 bl_0_a_n29 rwl_1_a_n29 1.0093e-17
ccc_bl_0_rwl_2_a_n29 bl_0_a_n29 rwl_2_a_n29 1.0093e-17
ccc_bl_1_rbl_0_a_n29 bl_1_a_n29 rbl_0_a_n29 1.633e-16
ccc_bl_1_rbl_1_a_n29 bl_1_a_n29 rbl_1_a_n29 1.88693e-16
ccc_bl_1_rwl_1_a_n29 bl_1_a_n29 rwl_1_a_n29 1.0093e-17
ccc_bl_1_rwl_2_a_n29 bl_1_a_n29 rwl_2_a_n29 1.0093e-17
ccc_bl_2_rbl_1_a_n29 bl_2_a_n29 rbl_1_a_n29 1.633e-16
ccc_bl_2_rbl_2_a_n29 bl_2_a_n29 rbl_2_a_n29 1.88693e-16
ccc_bl_2_rwl_1_a_n29 bl_2_a_n29 rwl_1_a_n29 1.0093e-17
ccc_bl_2_rwl_2_a_n29 bl_2_a_n29 rwl_2_a_n29 1.0093e-17
ccc_bl_3_rbl_2_a_n29 bl_3_a_n29 rbl_2_a_n29 1.633e-16
ccc_bl_3_rbl_3_a_n29 bl_3_a_n29 rbl_3_a_n29 1.88693e-16
ccc_bl_3_rwl_1_a_n29 bl_3_a_n29 rwl_1_a_n29 1.0093e-17
ccc_bl_3_rwl_2_a_n29 bl_3_a_n29 rwl_2_a_n29 1.0093e-17
ccc_rbl_0_rbl_1_a_n29 rbl_0_a_n29 rbl_1_a_n29 3.432e-17
ccc_rbl_0_rwl_0_a_n29 rbl_0_a_n29 rwl_0_a_n29 4.9752e-17
ccc_rbl_0_rwl_1_a_n29 rbl_0_a_n29 rwl_1_a_n29 4.9752e-17
ccc_rbl_0_rwl_2_a_n29 rbl_0_a_n29 rwl_2_a_n29 4.9752e-17
ccc_rbl_0_rwl_3_a_n29 rbl_0_a_n29 rwl_3_a_n29 4.9752e-17
ccc_rbl_1_rbl_2_a_n29 rbl_1_a_n29 rbl_2_a_n29 3.432e-17
ccc_rbl_1_rwl_0_a_n29 rbl_1_a_n29 rwl_0_a_n29 4.9752e-17
ccc_rbl_1_rwl_1_a_n29 rbl_1_a_n29 rwl_1_a_n29 4.9752e-17
ccc_rbl_1_rwl_2_a_n29 rbl_1_a_n29 rwl_2_a_n29 4.9752e-17
ccc_rbl_1_rwl_3_a_n29 rbl_1_a_n29 rwl_3_a_n29 4.9752e-17
ccc_rbl_2_rbl_3_a_n29 rbl_2_a_n29 rbl_3_a_n29 3.432e-17
ccc_rbl_2_rwl_0_a_n29 rbl_2_a_n29 rwl_0_a_n29 4.9752e-17
ccc_rbl_2_rwl_1_a_n29 rbl_2_a_n29 rwl_1_a_n29 4.9752e-17
ccc_rbl_2_rwl_2_a_n29 rbl_2_a_n29 rwl_2_a_n29 4.9752e-17
ccc_rbl_2_rwl_3_a_n29 rbl_2_a_n29 rwl_3_a_n29 4.9752e-17
ccc_rbl_3_rwl_0_a_n29 rbl_3_a_n29 rwl_0_a_n29 3.3407e-17
ccc_rbl_3_rwl_1_a_n29 rbl_3_a_n29 rwl_1_a_n29 3.3407e-17
ccc_rbl_3_rwl_2_a_n29 rbl_3_a_n29 rwl_2_a_n29 3.3407e-17
ccc_rbl_3_rwl_3_a_n29 rbl_3_a_n29 rwl_3_a_n29 3.3407e-17
vdw_a_n29_0 wl_0_a_n29 0 dc 0
vdr_a_n29_0 rwl_0_a_n29 vdd dc 0
vdw_a_n29_1 wl_1_a_n29 0 dc 0
vdr_a_n29_1 rwl_1_a_n29 vdd dc 0
vdw_a_n29_2 wl_2_a_n29 0 dc 0
vdr_a_n29_2 rwl_2_a_n29 vdd dc 0
vdw_a_n29_3 wl_3_a_n29 0 dc 0
vdr_a_n29_3 rwl_3_a_n29 vdd dc 0
vdb_a_n29_0 bl_0_a_n29 0 dc 0
vdp_a_n29_0 rbl_0_a_n29 vrbl dc 0
vdb_a_n29_1 bl_1_a_n29 0 dc 0
vdp_a_n29_1 rbl_1_a_n29 vrbl dc 0
vdb_a_n29_2 bl_2_a_n29 0 dc 0
vdp_a_n29_2 rbl_2_a_n29 vrbl dc 0
vdb_a_n29_3 bl_3_a_n29 0 dc 0
vdp_a_n29_3 rbl_3_a_n29 vrbl dc 0
vdn_a_n29_n7 n7_a_n29 0 dc 1
vdn_a_n29_n8 n8_a_n29 0 dc 1
vdn_a_n29_n9 n9_a_n29 0 dc 1
vdn_a_n29_n10 n10_a_n29 0 dc 1
vdn_a_n29_n17 n17_a_n29 0 dc 1
vdn_a_n29_n18 n18_a_n29 0 dc 1
vdn_a_n29_n19 n19_a_n29 0 dc 1
vdn_a_n29_n20 n20_a_n29 0 dc 1
vdn_a_n29_n22 n22_a_n29 0 dc 1
vdn_a_n29_n23 n23_a_n29 0 dc 1
vdn_a_n29_n24 n24_a_n29 0 dc 1
vdn_a_n29_n25 n25_a_n29 0 dc 1
vdn_a_n29_n30 n30_a_n29 0 dc 1
vdn_a_n29_n31 n31_a_n29 0 dc 1
vdn_a_n29_n32 n32_a_n29 0 dc 1
bdr_a_n29 n29_a_n29 0 i=5e-08*min(1,max(0,(time-1e-09)/0.2n))*0.5*(1+tanh((v(n29_a_n29)-0.05)/0.01))

* ---- instance a_n30: variant a, probed storage node \$30 ----
xm1_a_n30 rwl_0__t2_a_n30 n7__t0_a_n30 rbl_0__t0_a_n30 gnd__t0_a_n30 sky130_fd_pr__nfet_01v8 L=0.15 W=0.42 nf=1 ad=0.1197 as=0.1197 pd=1.41 ps=1.41 mult=1 m=1
xm2_a_n30 rwl_0__t3_a_n30 n8__t1_a_n30 rbl_1__t1_a_n30 gnd__t1_a_n30 sky130_fd_pr__nfet_01v8 L=0.15 W=0.42 nf=1 ad=0.1197 as=0.1197 pd=1.41 ps=1.41 mult=1 m=1
xm3_a_n30 rwl_0__t1_a_n30 n9__t1_a_n30 rbl_2__t1_a_n30 gnd__t2_a_n30 sky130_fd_pr__nfet_01v8 L=0.15 W=0.42 nf=1 ad=0.1197 as=0.1197 pd=1.41 ps=1.41 mult=1 m=1
xm4_a_n30 rwl_0__t0_a_n30 n10__t1_a_n30 rbl_3__t1_a_n30 gnd__t3_a_n30 sky130_fd_pr__nfet_01v8 L=0.15 W=0.42 nf=1 ad=0.1197 as=0.1197 pd=1.41 ps=1.41 mult=1 m=1
xm5_a_n30 bl_0__t0_a_n30 wl_0__t0_a_n30 n7__t1_a_n30 gnd__t8_a_n30 sky130_fd_pr__nfet_01v8 L=0.15 W=0.42 nf=1 ad=0.0588 as=0.1197 pd=0.7 ps=1.41 mult=1 m=1
xm6_a_n30 n17__t0_a_n30 wl_1__t0_a_n30 bl_0__t1_a_n30 gnd__t20_a_n30 sky130_fd_pr__nfet_01v8 L=0.15 W=0.42 nf=1 ad=0.1197 as=0.0588 pd=1.41 ps=0.7 mult=1 m=1
xm7_a_n30 bl_1__t2_a_n30 wl_0__t3_a_n30 n8__t0_a_n30 gnd__t9_a_n30 sky130_fd_pr__nfet_01v8 L=0.15 W=0.42 nf=1 ad=0.0588 as=0.1197 pd=0.7 ps=1.41 mult=1 m=1
xm8_a_n30 n18__t0_a_n30 wl_1__t1_a_n30 bl_1__t0_a_n30 gnd__t21_a_n30 sky130_fd_pr__nfet_01v8 L=0.15 W=0.42 nf=1 ad=0.1197 as=0.0588 pd=1.41 ps=0.7 mult=1 m=1
xm9_a_n30 bl_2__t2_a_n30 wl_0__t2_a_n30 n9__t0_a_n30 gnd__t10_a_n30 sky130_fd_pr__nfet_01v8 L=0.15 W=0.42 nf=1 ad=0.0588 as=0.1197 pd=0.7 ps=1.41 mult=1 m=1
xm10_a_n30 n19__t0_a_n30 wl_1__t2_a_n30 bl_2__t0_a_n30 gnd__t22_a_n30 sky130_fd_pr__nfet_01v8 L=0.15 W=0.42 nf=1 ad=0.1197 as=0.0588 pd=1.41 ps=0.7 mult=1 m=1
xm11_a_n30 bl_3__t2_a_n30 wl_0__t1_a_n30 n10__t0_a_n30 gnd__t11_a_n30 sky130_fd_pr__nfet_01v8 L=0.15 W=0.42 nf=1 ad=0.0588 as=0.1197 pd=0.7 ps=1.41 mult=1 m=1
xm12_a_n30 n20__t0_a_n30 wl_1__t3_a_n30 bl_3__t1_a_n30 gnd__t23_a_n30 sky130_fd_pr__nfet_01v8 L=0.15 W=0.42 nf=1 ad=0.1197 as=0.0588 pd=1.41 ps=0.7 mult=1 m=1
xm13_a_n30 rbl_0__t3_a_n30 n17__t1_a_n30 rwl_1__t0_a_n30 gnd__t12_a_n30 sky130_fd_pr__nfet_01v8 L=0.15 W=0.42 nf=1 ad=0.0588 as=0.1197 pd=0.7 ps=1.41 mult=1 m=1
xm14_a_n30 rwl_2__t3_a_n30 n22__t0_a_n30 rbl_0__t2_a_n30 gnd__t24_a_n30 sky130_fd_pr__nfet_01v8 L=0.15 W=0.42 nf=1 ad=0.1197 as=0.0588 pd=1.41 ps=0.7 mult=1 m=1
xm15_a_n30 rbl_1__t3_a_n30 n18__t1_a_n30 rwl_1__t1_a_n30 gnd__t13_a_n30 sky130_fd_pr__nfet_01v8 L=0.15 W=0.42 nf=1 ad=0.0588 as=0.1197 pd=0.7 ps=1.41 mult=1 m=1
xm16_a_n30 rwl_2__t0_a_n30 n23__t0_a_n30 rbl_1__t2_a_n30 gnd__t25_a_n30 sky130_fd_pr__nfet_01v8 L=0.15 W=0.42 nf=1 ad=0.1197 as=0.0588 pd=1.41 ps=0.7 mult=1 m=1
xm17_a_n30 rbl_2__t3_a_n30 n19__t1_a_n30 rwl_1__t2_a_n30 gnd__t14_a_n30 sky130_fd_pr__nfet_01v8 L=0.15 W=0.42 nf=1 ad=0.0588 as=0.1197 pd=0.7 ps=1.41 mult=1 m=1
xm18_a_n30 rwl_2__t1_a_n30 n24__t0_a_n30 rbl_2__t2_a_n30 gnd__t26_a_n30 sky130_fd_pr__nfet_01v8 L=0.15 W=0.42 nf=1 ad=0.1197 as=0.0588 pd=1.41 ps=0.7 mult=1 m=1
xm19_a_n30 rbl_3__t3_a_n30 n20__t1_a_n30 rwl_1__t3_a_n30 gnd__t15_a_n30 sky130_fd_pr__nfet_01v8 L=0.15 W=0.42 nf=1 ad=0.0588 as=0.1197 pd=0.7 ps=1.41 mult=1 m=1
xm20_a_n30 rwl_2__t2_a_n30 n25__t0_a_n30 rbl_3__t2_a_n30 gnd__t27_a_n30 sky130_fd_pr__nfet_01v8 L=0.15 W=0.42 nf=1 ad=0.1197 as=0.0588 pd=1.41 ps=0.7 mult=1 m=1
xm21_a_n30 bl_0__t3_a_n30 wl_2__t0_a_n30 n22__t1_a_n30 gnd__t16_a_n30 sky130_fd_pr__nfet_01v8 L=0.15 W=0.42 nf=1 ad=0.0588 as=0.1197 pd=0.7 ps=1.41 mult=1 m=1
xm22_a_n30 n29__t0_a_n30 wl_3__t3_a_n30 bl_0__t2_a_n30 gnd__t28_a_n30 sky130_fd_pr__nfet_01v8 L=0.15 W=0.42 nf=1 ad=0.1197 as=0.0588 pd=1.41 ps=0.7 mult=1 m=1
xm23_a_n30 bl_1__t3_a_n30 wl_2__t1_a_n30 n23__t1_a_n30 gnd__t17_a_n30 sky130_fd_pr__nfet_01v8 L=0.15 W=0.42 nf=1 ad=0.0588 as=0.1197 pd=0.7 ps=1.41 mult=1 m=1
xm24_a_n30 n30__t0_a_n30 wl_3__t2_a_n30 bl_1__t1_a_n30 gnd__t29_a_n30 sky130_fd_pr__nfet_01v8 L=0.15 W=0.42 nf=1 ad=0.1197 as=0.0588 pd=1.41 ps=0.7 mult=1 m=1
xm25_a_n30 bl_2__t3_a_n30 wl_2__t2_a_n30 n24__t1_a_n30 gnd__t18_a_n30 sky130_fd_pr__nfet_01v8 L=0.15 W=0.42 nf=1 ad=0.0588 as=0.1197 pd=0.7 ps=1.41 mult=1 m=1
xm26_a_n30 n31__t0_a_n30 wl_3__t1_a_n30 bl_2__t1_a_n30 gnd__t30_a_n30 sky130_fd_pr__nfet_01v8 L=0.15 W=0.42 nf=1 ad=0.1197 as=0.0588 pd=1.41 ps=0.7 mult=1 m=1
xm27_a_n30 bl_3__t3_a_n30 wl_2__t3_a_n30 n25__t1_a_n30 gnd__t19_a_n30 sky130_fd_pr__nfet_01v8 L=0.15 W=0.42 nf=1 ad=0.0588 as=0.1197 pd=0.7 ps=1.41 mult=1 m=1
xm28_a_n30 n32__t0_a_n30 wl_3__t0_a_n30 bl_3__t0_a_n30 gnd__t31_a_n30 sky130_fd_pr__nfet_01v8 L=0.15 W=0.42 nf=1 ad=0.1197 as=0.0588 pd=1.41 ps=0.7 mult=1 m=1
xm29_a_n30 rbl_0__t1_a_n30 n29__t1_a_n30 rwl_3__t0_a_n30 gnd__t4_a_n30 sky130_fd_pr__nfet_01v8 L=0.15 W=0.42 nf=1 ad=0.1197 as=0.1197 pd=1.41 ps=1.41 mult=1 m=1
xm30_a_n30 rbl_1__t0_a_n30 n30__t1_a_n30 rwl_3__t1_a_n30 gnd__t5_a_n30 sky130_fd_pr__nfet_01v8 L=0.15 W=0.42 nf=1 ad=0.1197 as=0.1197 pd=1.41 ps=1.41 mult=1 m=1
xm31_a_n30 rbl_2__t0_a_n30 n31__t1_a_n30 rwl_3__t2_a_n30 gnd__t6_a_n30 sky130_fd_pr__nfet_01v8 L=0.15 W=0.42 nf=1 ad=0.1197 as=0.1197 pd=1.41 ps=1.41 mult=1 m=1
xm32_a_n30 rbl_3__t0_a_n30 n32__t1_a_n30 rwl_3__t3_a_n30 gnd__t7_a_n30 sky130_fd_pr__nfet_01v8 L=0.15 W=0.42 nf=1 ad=0.1197 as=0.1197 pd=1.41 ps=1.41 mult=1 m=1
r_10_t0_a_n30 n10__t0_a_n30 n10_a_n30 183.071
r_10_t1_a_n30 n10__t1_a_n30 n10_a_n30 183.071
r_17_t0_a_n30 n17__t0_a_n30 n17_a_n30 183.071
r_17_t1_a_n30 n17__t1_a_n30 n17_a_n30 183.071
r_18_t0_a_n30 n18__t0_a_n30 n18_a_n30 183.071
r_18_t1_a_n30 n18__t1_a_n30 n18_a_n30 183.071
r_19_t0_a_n30 n19__t0_a_n30 n19_a_n30 183.071
r_19_t1_a_n30 n19__t1_a_n30 n19_a_n30 183.071
r_20_t0_a_n30 n20__t0_a_n30 n20_a_n30 183.071
r_20_t1_a_n30 n20__t1_a_n30 n20_a_n30 183.071
r_22_t0_a_n30 n22__t0_a_n30 n22_a_n30 183.071
r_22_t1_a_n30 n22__t1_a_n30 n22_a_n30 183.071
r_23_t0_a_n30 n23__t0_a_n30 n23_a_n30 183.071
r_23_t1_a_n30 n23__t1_a_n30 n23_a_n30 183.071
r_24_t0_a_n30 n24__t0_a_n30 n24_a_n30 183.071
r_24_t1_a_n30 n24__t1_a_n30 n24_a_n30 183.071
r_25_t0_a_n30 n25__t0_a_n30 n25_a_n30 183.071
r_25_t1_a_n30 n25__t1_a_n30 n25_a_n30 183.071
r_29_t0_a_n30 n29__t0_a_n30 n29_a_n30 183.071
r_29_t1_a_n30 n29__t1_a_n30 n29_a_n30 183.071
r_30_t0_a_n30 n30__t0_a_n30 n30_a_n30 183.071
r_30_t1_a_n30 n30__t1_a_n30 n30_a_n30 183.071
r_31_t0_a_n30 n31__t0_a_n30 n31_a_n30 183.071
r_31_t1_a_n30 n31__t1_a_n30 n31_a_n30 183.071
r_32_t0_a_n30 n32__t0_a_n30 n32_a_n30 183.071
r_32_t1_a_n30 n32__t1_a_n30 n32_a_n30 183.071
r_7_t0_a_n30 n7__t0_a_n30 n7_a_n30 183.071
r_7_t1_a_n30 n7__t1_a_n30 n7_a_n30 183.071
r_8_t0_a_n30 n8__t0_a_n30 n8_a_n30 183.071
r_8_t1_a_n30 n8__t1_a_n30 n8_a_n30 183.071
r_9_t0_a_n30 n9__t0_a_n30 n9_a_n30 183.071
r_9_t1_a_n30 n9__t1_a_n30 n9_a_n30 183.071
rgnd_t0_a_n30 gnd__t0_a_n30 0 38.2988
rgnd_t1_a_n30 gnd__t1_a_n30 0 33.9576
rgnd_t2_a_n30 gnd__t2_a_n30 0 33.9576
rgnd_t3_a_n30 gnd__t3_a_n30 0 38.2988
rgnd_t4_a_n30 gnd__t4_a_n30 0 38.2988
rgnd_t5_a_n30 gnd__t5_a_n30 0 33.9576
rgnd_t6_a_n30 gnd__t6_a_n30 0 33.9576
rgnd_t7_a_n30 gnd__t7_a_n30 0 38.2988
rgnd_t8_a_n30 gnd__t8_a_n30 0 28.0185
rgnd_t9_a_n30 gnd__t9_a_n30 0 21.7106
rgnd_t10_a_n30 gnd__t10_a_n30 0 21.7106
rgnd_t11_a_n30 gnd__t11_a_n30 0 28.0185
rgnd_t12_a_n30 gnd__t12_a_n30 0 18.9833
rgnd_t13_a_n30 gnd__t13_a_n30 0 6.8325
rgnd_t14_a_n30 gnd__t14_a_n30 0 6.8325
rgnd_t15_a_n30 gnd__t15_a_n30 0 18.9833
rgnd_t16_a_n30 gnd__t16_a_n30 0 24.2409
rgnd_t17_a_n30 gnd__t17_a_n30 0 16.5511
rgnd_t18_a_n30 gnd__t18_a_n30 0 16.5511
rgnd_t19_a_n30 gnd__t19_a_n30 0 24.2409
rgnd_t20_a_n30 gnd__t20_a_n30 0 24.2409
rgnd_t21_a_n30 gnd__t21_a_n30 0 16.5511
rgnd_t22_a_n30 gnd__t22_a_n30 0 16.5511
rgnd_t23_a_n30 gnd__t23_a_n30 0 24.2409
rgnd_t24_a_n30 gnd__t24_a_n30 0 18.9833
rgnd_t25_a_n30 gnd__t25_a_n30 0 6.8325
rgnd_t26_a_n30 gnd__t26_a_n30 0 6.8325
rgnd_t27_a_n30 gnd__t27_a_n30 0 18.9833
rgnd_t28_a_n30 gnd__t28_a_n30 0 28.0185
rgnd_t29_a_n30 gnd__t29_a_n30 0 21.7106
rgnd_t30_a_n30 gnd__t30_a_n30 0 21.7106
rgnd_t31_a_n30 gnd__t31_a_n30 0 28.0185
rbl_0_t0_a_n30 bl_0__t0_a_n30 bl_0_a_n30 14.8304
rbl_0_t1_a_n30 bl_0__t1_a_n30 bl_0_a_n30 10.9301
rbl_0_t2_a_n30 bl_0__t2_a_n30 bl_0_a_n30 14.8304
rbl_0_t3_a_n30 bl_0__t3_a_n30 bl_0_a_n30 10.9301
rbl_1_t0_a_n30 bl_1__t0_a_n30 bl_1_a_n30 10.9301
rbl_1_t1_a_n30 bl_1__t1_a_n30 bl_1_a_n30 14.8304
rbl_1_t2_a_n30 bl_1__t2_a_n30 bl_1_a_n30 14.8304
rbl_1_t3_a_n30 bl_1__t3_a_n30 bl_1_a_n30 10.9301
rbl_2_t0_a_n30 bl_2__t0_a_n30 bl_2_a_n30 10.9301
rbl_2_t1_a_n30 bl_2__t1_a_n30 bl_2_a_n30 14.8304
rbl_2_t2_a_n30 bl_2__t2_a_n30 bl_2_a_n30 14.8304
rbl_2_t3_a_n30 bl_2__t3_a_n30 bl_2_a_n30 10.9301
rbl_3_t0_a_n30 bl_3__t0_a_n30 bl_3_a_n30 14.8304
rbl_3_t1_a_n30 bl_3__t1_a_n30 bl_3_a_n30 10.9301
rbl_3_t2_a_n30 bl_3__t2_a_n30 bl_3_a_n30 14.8304
rbl_3_t3_a_n30 bl_3__t3_a_n30 bl_3_a_n30 10.9301
rrbl_0_t0_a_n30 rbl_0__t0_a_n30 rbl_0_a_n30 36.5601
rrbl_0_t1_a_n30 rbl_0__t1_a_n30 rbl_0_a_n30 36.5601
rrbl_0_t2_a_n30 rbl_0__t2_a_n30 rbl_0_a_n30 2.99444
rrbl_0_t3_a_n30 rbl_0__t3_a_n30 rbl_0_a_n30 2.99444
rrbl_1_t0_a_n30 rbl_1__t0_a_n30 rbl_1_a_n30 36.5601
rrbl_1_t1_a_n30 rbl_1__t1_a_n30 rbl_1_a_n30 36.5601
rrbl_1_t2_a_n30 rbl_1__t2_a_n30 rbl_1_a_n30 2.99444
rrbl_1_t3_a_n30 rbl_1__t3_a_n30 rbl_1_a_n30 2.99444
rrbl_2_t0_a_n30 rbl_2__t0_a_n30 rbl_2_a_n30 36.5601
rrbl_2_t1_a_n30 rbl_2__t1_a_n30 rbl_2_a_n30 36.5601
rrbl_2_t2_a_n30 rbl_2__t2_a_n30 rbl_2_a_n30 2.99444
rrbl_2_t3_a_n30 rbl_2__t3_a_n30 rbl_2_a_n30 2.99444
rrbl_3_t0_a_n30 rbl_3__t0_a_n30 rbl_3_a_n30 36.5601
rrbl_3_t1_a_n30 rbl_3__t1_a_n30 rbl_3_a_n30 36.5601
rrbl_3_t2_a_n30 rbl_3__t2_a_n30 rbl_3_a_n30 2.99444
rrbl_3_t3_a_n30 rbl_3__t3_a_n30 rbl_3_a_n30 2.99444
rrwl_0_t0_a_n30 rwl_0__t0_a_n30 rwl_0_a_n30 38.2618
rrwl_0_t1_a_n30 rwl_0__t1_a_n30 rwl_0_a_n30 12.7539
rrwl_0_t2_a_n30 rwl_0__t2_a_n30 rwl_0_a_n30 38.2618
rrwl_0_t3_a_n30 rwl_0__t3_a_n30 rwl_0_a_n30 12.7539
rrwl_1_t0_a_n30 rwl_1__t0_a_n30 rwl_1_a_n30 38.2618
rrwl_1_t1_a_n30 rwl_1__t1_a_n30 rwl_1_a_n30 12.7539
rrwl_1_t2_a_n30 rwl_1__t2_a_n30 rwl_1_a_n30 12.7539
rrwl_1_t3_a_n30 rwl_1__t3_a_n30 rwl_1_a_n30 38.2618
rrwl_2_t0_a_n30 rwl_2__t0_a_n30 rwl_2_a_n30 12.7539
rrwl_2_t1_a_n30 rwl_2__t1_a_n30 rwl_2_a_n30 12.7539
rrwl_2_t2_a_n30 rwl_2__t2_a_n30 rwl_2_a_n30 38.2618
rrwl_2_t3_a_n30 rwl_2__t3_a_n30 rwl_2_a_n30 38.2618
rrwl_3_t0_a_n30 rwl_3__t0_a_n30 rwl_3_a_n30 38.2618
rrwl_3_t1_a_n30 rwl_3__t1_a_n30 rwl_3_a_n30 12.7539
rrwl_3_t2_a_n30 rwl_3__t2_a_n30 rwl_3_a_n30 12.7539
rrwl_3_t3_a_n30 rwl_3__t3_a_n30 rwl_3_a_n30 38.2618
rwl_0_t0_a_n30 wl_0__t0_a_n30 wl_0_a_n30 245.959
rwl_0_t1_a_n30 wl_0__t1_a_n30 wl_0_a_n30 245.959
rwl_0_t2_a_n30 wl_0__t2_a_n30 wl_0_a_n30 81.9864
rwl_0_t3_a_n30 wl_0__t3_a_n30 wl_0_a_n30 81.9864
rwl_1_t0_a_n30 wl_1__t0_a_n30 wl_1_a_n30 245.959
rwl_1_t1_a_n30 wl_1__t1_a_n30 wl_1_a_n30 81.9864
rwl_1_t2_a_n30 wl_1__t2_a_n30 wl_1_a_n30 81.9864
rwl_1_t3_a_n30 wl_1__t3_a_n30 wl_1_a_n30 245.959
rwl_2_t0_a_n30 wl_2__t0_a_n30 wl_2_a_n30 245.959
rwl_2_t1_a_n30 wl_2__t1_a_n30 wl_2_a_n30 81.9864
rwl_2_t2_a_n30 wl_2__t2_a_n30 wl_2_a_n30 81.9864
rwl_2_t3_a_n30 wl_2__t3_a_n30 wl_2_a_n30 245.959
rwl_3_t0_a_n30 wl_3__t0_a_n30 wl_3_a_n30 245.959
rwl_3_t1_a_n30 wl_3__t1_a_n30 wl_3_a_n30 81.9864
rwl_3_t2_a_n30 wl_3__t2_a_n30 wl_3_a_n30 81.9864
rwl_3_t3_a_n30 wl_3__t3_a_n30 wl_3_a_n30 245.959
c_10_a_n30 n10_a_n30 0 2.91622e-16
c_17_a_n30 n17_a_n30 0 2.91528e-16
c_18_a_n30 n18_a_n30 0 2.91528e-16
c_19_a_n30 n19_a_n30 0 2.91528e-16
c_20_a_n30 n20_a_n30 0 2.91622e-16
c_22_a_n30 n22_a_n30 0 2.91528e-16
c_23_a_n30 n23_a_n30 0 2.91528e-16
c_24_a_n30 n24_a_n30 0 2.91528e-16
c_25_a_n30 n25_a_n30 0 2.91622e-16
c_29_a_n30 n29_a_n30 0 2.91528e-16
c_30_a_n30 n30_a_n30 0 2.91528e-16
c_31_a_n30 n31_a_n30 0 2.91528e-16
c_32_a_n30 n32_a_n30 0 2.91622e-16
c_7_a_n30 n7_a_n30 0 2.91528e-16
c_8_a_n30 n8_a_n30 0 2.91528e-16
c_9_a_n30 n9_a_n30 0 2.91528e-16
cgnd_a_n30 0 0 2.48166e-15
cbl_0_a_n30 bl_0_a_n30 0 4.52661e-16
cbl_1_a_n30 bl_1_a_n30 0 4.52661e-16
cbl_2_a_n30 bl_2_a_n30 0 4.52661e-16
cbl_3_a_n30 bl_3_a_n30 0 4.52661e-16
crbl_0_a_n30 rbl_0_a_n30 0 9.14472e-16
crbl_1_a_n30 rbl_1_a_n30 0 9.14472e-16
crbl_2_a_n30 rbl_2_a_n30 0 9.14472e-16
crbl_3_a_n30 rbl_3_a_n30 0 9.17566e-16
crwl_0_a_n30 rwl_0_a_n30 0 5.19495e-16
crwl_1_a_n30 rwl_1_a_n30 0 5.11719e-16
crwl_2_a_n30 rwl_2_a_n30 0 5.11719e-16
crwl_3_a_n30 rwl_3_a_n30 0 5.19495e-16
cwl_0_a_n30 wl_0_a_n30 0 3.30388e-16
cwl_1_a_n30 wl_1_a_n30 0 3.30388e-16
cwl_2_a_n30 wl_2_a_n30 0 3.30388e-16
cwl_3_a_n30 wl_3_a_n30 0 3.30388e-16
ccc__10__9_a_n30 n10_a_n30 n9_a_n30 1.02e-17
ccc__10_bl_3_a_n30 n10_a_n30 bl_3_a_n30 1.3999e-17
ccc__10_rwl_0_a_n30 n10_a_n30 rwl_0_a_n30 4.335e-18
ccc__17__18_a_n30 n17_a_n30 n18_a_n30 1.02e-17
ccc__17_bl_0_a_n30 n17_a_n30 bl_0_a_n30 8.415e-18
ccc__17_rwl_1_a_n30 n17_a_n30 rwl_1_a_n30 1.3194e-17
ccc__18__19_a_n30 n18_a_n30 n19_a_n30 1.02e-17
ccc__18_bl_1_a_n30 n18_a_n30 bl_1_a_n30 8.415e-18
ccc__18_rwl_1_a_n30 n18_a_n30 rwl_1_a_n30 1.3194e-17
ccc__19__20_a_n30 n19_a_n30 n20_a_n30 1.02e-17
ccc__19_bl_2_a_n30 n19_a_n30 bl_2_a_n30 8.415e-18
ccc__19_rwl_1_a_n30 n19_a_n30 rwl_1_a_n30 1.3194e-17
ccc__20_bl_3_a_n30 n20_a_n30 bl_3_a_n30 8.415e-18
ccc__20_rwl_1_a_n30 n20_a_n30 rwl_1_a_n30 6.655e-18
ccc__22__23_a_n30 n22_a_n30 n23_a_n30 1.02e-17
ccc__22_bl_0_a_n30 n22_a_n30 bl_0_a_n30 8.415e-18
ccc__22_rwl_2_a_n30 n22_a_n30 rwl_2_a_n30 1.3194e-17
ccc__23__24_a_n30 n23_a_n30 n24_a_n30 1.02e-17
ccc__23_bl_1_a_n30 n23_a_n30 bl_1_a_n30 8.415e-18
ccc__23_rwl_2_a_n30 n23_a_n30 rwl_2_a_n30 1.3194e-17
ccc__24__25_a_n30 n24_a_n30 n25_a_n30 1.02e-17
ccc__24_bl_2_a_n30 n24_a_n30 bl_2_a_n30 8.415e-18
ccc__24_rwl_2_a_n30 n24_a_n30 rwl_2_a_n30 1.3194e-17
ccc__25_bl_3_a_n30 n25_a_n30 bl_3_a_n30 8.415e-18
ccc__25_rwl_2_a_n30 n25_a_n30 rwl_2_a_n30 6.655e-18
ccc__29__30_a_n30 n29_a_n30 n30_a_n30 1.02e-17
ccc__29_bl_0_a_n30 n29_a_n30 bl_0_a_n30 8.415e-18
ccc__29_rwl_3_a_n30 n29_a_n30 rwl_3_a_n30 1.3194e-17
ccc__30__31_a_n30 n30_a_n30 n31_a_n30 1.02e-17
ccc__30_bl_1_a_n30 n30_a_n30 bl_1_a_n30 8.415e-18
ccc__30_rwl_3_a_n30 n30_a_n30 rwl_3_a_n30 1.3194e-17
ccc__31__32_a_n30 n31_a_n30 n32_a_n30 1.02e-17
ccc__31_bl_2_a_n30 n31_a_n30 bl_2_a_n30 8.415e-18
ccc__31_rwl_3_a_n30 n31_a_n30 rwl_3_a_n30 1.3194e-17
ccc__32_bl_3_a_n30 n32_a_n30 bl_3_a_n30 8.415e-18
ccc__32_rwl_3_a_n30 n32_a_n30 rwl_3_a_n30 6.655e-18
ccc__7__8_a_n30 n7_a_n30 n8_a_n30 1.02e-17
ccc__7_bl_0_a_n30 n7_a_n30 bl_0_a_n30 1.3999e-17
ccc__7_rwl_0_a_n30 n7_a_n30 rwl_0_a_n30 8.961e-18
ccc__8__9_a_n30 n8_a_n30 n9_a_n30 1.02e-17
ccc__8_bl_1_a_n30 n8_a_n30 bl_1_a_n30 1.3999e-17
ccc__8_rwl_0_a_n30 n8_a_n30 rwl_0_a_n30 8.961e-18
ccc__9_bl_2_a_n30 n9_a_n30 bl_2_a_n30 1.3999e-17
ccc__9_rwl_0_a_n30 n9_a_n30 rwl_0_a_n30 8.961e-18
ccc_bl_0_rbl_0_a_n30 bl_0_a_n30 rbl_0_a_n30 1.88693e-16
ccc_bl_0_rwl_1_a_n30 bl_0_a_n30 rwl_1_a_n30 1.0093e-17
ccc_bl_0_rwl_2_a_n30 bl_0_a_n30 rwl_2_a_n30 1.0093e-17
ccc_bl_1_rbl_0_a_n30 bl_1_a_n30 rbl_0_a_n30 1.633e-16
ccc_bl_1_rbl_1_a_n30 bl_1_a_n30 rbl_1_a_n30 1.88693e-16
ccc_bl_1_rwl_1_a_n30 bl_1_a_n30 rwl_1_a_n30 1.0093e-17
ccc_bl_1_rwl_2_a_n30 bl_1_a_n30 rwl_2_a_n30 1.0093e-17
ccc_bl_2_rbl_1_a_n30 bl_2_a_n30 rbl_1_a_n30 1.633e-16
ccc_bl_2_rbl_2_a_n30 bl_2_a_n30 rbl_2_a_n30 1.88693e-16
ccc_bl_2_rwl_1_a_n30 bl_2_a_n30 rwl_1_a_n30 1.0093e-17
ccc_bl_2_rwl_2_a_n30 bl_2_a_n30 rwl_2_a_n30 1.0093e-17
ccc_bl_3_rbl_2_a_n30 bl_3_a_n30 rbl_2_a_n30 1.633e-16
ccc_bl_3_rbl_3_a_n30 bl_3_a_n30 rbl_3_a_n30 1.88693e-16
ccc_bl_3_rwl_1_a_n30 bl_3_a_n30 rwl_1_a_n30 1.0093e-17
ccc_bl_3_rwl_2_a_n30 bl_3_a_n30 rwl_2_a_n30 1.0093e-17
ccc_rbl_0_rbl_1_a_n30 rbl_0_a_n30 rbl_1_a_n30 3.432e-17
ccc_rbl_0_rwl_0_a_n30 rbl_0_a_n30 rwl_0_a_n30 4.9752e-17
ccc_rbl_0_rwl_1_a_n30 rbl_0_a_n30 rwl_1_a_n30 4.9752e-17
ccc_rbl_0_rwl_2_a_n30 rbl_0_a_n30 rwl_2_a_n30 4.9752e-17
ccc_rbl_0_rwl_3_a_n30 rbl_0_a_n30 rwl_3_a_n30 4.9752e-17
ccc_rbl_1_rbl_2_a_n30 rbl_1_a_n30 rbl_2_a_n30 3.432e-17
ccc_rbl_1_rwl_0_a_n30 rbl_1_a_n30 rwl_0_a_n30 4.9752e-17
ccc_rbl_1_rwl_1_a_n30 rbl_1_a_n30 rwl_1_a_n30 4.9752e-17
ccc_rbl_1_rwl_2_a_n30 rbl_1_a_n30 rwl_2_a_n30 4.9752e-17
ccc_rbl_1_rwl_3_a_n30 rbl_1_a_n30 rwl_3_a_n30 4.9752e-17
ccc_rbl_2_rbl_3_a_n30 rbl_2_a_n30 rbl_3_a_n30 3.432e-17
ccc_rbl_2_rwl_0_a_n30 rbl_2_a_n30 rwl_0_a_n30 4.9752e-17
ccc_rbl_2_rwl_1_a_n30 rbl_2_a_n30 rwl_1_a_n30 4.9752e-17
ccc_rbl_2_rwl_2_a_n30 rbl_2_a_n30 rwl_2_a_n30 4.9752e-17
ccc_rbl_2_rwl_3_a_n30 rbl_2_a_n30 rwl_3_a_n30 4.9752e-17
ccc_rbl_3_rwl_0_a_n30 rbl_3_a_n30 rwl_0_a_n30 3.3407e-17
ccc_rbl_3_rwl_1_a_n30 rbl_3_a_n30 rwl_1_a_n30 3.3407e-17
ccc_rbl_3_rwl_2_a_n30 rbl_3_a_n30 rwl_2_a_n30 3.3407e-17
ccc_rbl_3_rwl_3_a_n30 rbl_3_a_n30 rwl_3_a_n30 3.3407e-17
vdw_a_n30_0 wl_0_a_n30 0 dc 0
vdr_a_n30_0 rwl_0_a_n30 vdd dc 0
vdw_a_n30_1 wl_1_a_n30 0 dc 0
vdr_a_n30_1 rwl_1_a_n30 vdd dc 0
vdw_a_n30_2 wl_2_a_n30 0 dc 0
vdr_a_n30_2 rwl_2_a_n30 vdd dc 0
vdw_a_n30_3 wl_3_a_n30 0 dc 0
vdr_a_n30_3 rwl_3_a_n30 vdd dc 0
vdb_a_n30_0 bl_0_a_n30 0 dc 0
vdp_a_n30_0 rbl_0_a_n30 vrbl dc 0
vdb_a_n30_1 bl_1_a_n30 0 dc 0
vdp_a_n30_1 rbl_1_a_n30 vrbl dc 0
vdb_a_n30_2 bl_2_a_n30 0 dc 0
vdp_a_n30_2 rbl_2_a_n30 vrbl dc 0
vdb_a_n30_3 bl_3_a_n30 0 dc 0
vdp_a_n30_3 rbl_3_a_n30 vrbl dc 0
vdn_a_n30_n7 n7_a_n30 0 dc 1
vdn_a_n30_n8 n8_a_n30 0 dc 1
vdn_a_n30_n9 n9_a_n30 0 dc 1
vdn_a_n30_n10 n10_a_n30 0 dc 1
vdn_a_n30_n17 n17_a_n30 0 dc 1
vdn_a_n30_n18 n18_a_n30 0 dc 1
vdn_a_n30_n19 n19_a_n30 0 dc 1
vdn_a_n30_n20 n20_a_n30 0 dc 1
vdn_a_n30_n22 n22_a_n30 0 dc 1
vdn_a_n30_n23 n23_a_n30 0 dc 1
vdn_a_n30_n24 n24_a_n30 0 dc 1
vdn_a_n30_n25 n25_a_n30 0 dc 1
vdn_a_n30_n29 n29_a_n30 0 dc 1
vdn_a_n30_n31 n31_a_n30 0 dc 1
vdn_a_n30_n32 n32_a_n30 0 dc 1
bdr_a_n30 n30_a_n30 0 i=5e-08*min(1,max(0,(time-1e-09)/0.2n))*0.5*(1+tanh((v(n30_a_n30)-0.05)/0.01))

* ---- instance a_n31: variant a, probed storage node \$31 ----
xm1_a_n31 rwl_0__t2_a_n31 n7__t0_a_n31 rbl_0__t0_a_n31 gnd__t0_a_n31 sky130_fd_pr__nfet_01v8 L=0.15 W=0.42 nf=1 ad=0.1197 as=0.1197 pd=1.41 ps=1.41 mult=1 m=1
xm2_a_n31 rwl_0__t3_a_n31 n8__t1_a_n31 rbl_1__t1_a_n31 gnd__t1_a_n31 sky130_fd_pr__nfet_01v8 L=0.15 W=0.42 nf=1 ad=0.1197 as=0.1197 pd=1.41 ps=1.41 mult=1 m=1
xm3_a_n31 rwl_0__t1_a_n31 n9__t1_a_n31 rbl_2__t1_a_n31 gnd__t2_a_n31 sky130_fd_pr__nfet_01v8 L=0.15 W=0.42 nf=1 ad=0.1197 as=0.1197 pd=1.41 ps=1.41 mult=1 m=1
xm4_a_n31 rwl_0__t0_a_n31 n10__t1_a_n31 rbl_3__t1_a_n31 gnd__t3_a_n31 sky130_fd_pr__nfet_01v8 L=0.15 W=0.42 nf=1 ad=0.1197 as=0.1197 pd=1.41 ps=1.41 mult=1 m=1
xm5_a_n31 bl_0__t0_a_n31 wl_0__t0_a_n31 n7__t1_a_n31 gnd__t8_a_n31 sky130_fd_pr__nfet_01v8 L=0.15 W=0.42 nf=1 ad=0.0588 as=0.1197 pd=0.7 ps=1.41 mult=1 m=1
xm6_a_n31 n17__t0_a_n31 wl_1__t0_a_n31 bl_0__t1_a_n31 gnd__t20_a_n31 sky130_fd_pr__nfet_01v8 L=0.15 W=0.42 nf=1 ad=0.1197 as=0.0588 pd=1.41 ps=0.7 mult=1 m=1
xm7_a_n31 bl_1__t2_a_n31 wl_0__t3_a_n31 n8__t0_a_n31 gnd__t9_a_n31 sky130_fd_pr__nfet_01v8 L=0.15 W=0.42 nf=1 ad=0.0588 as=0.1197 pd=0.7 ps=1.41 mult=1 m=1
xm8_a_n31 n18__t0_a_n31 wl_1__t1_a_n31 bl_1__t0_a_n31 gnd__t21_a_n31 sky130_fd_pr__nfet_01v8 L=0.15 W=0.42 nf=1 ad=0.1197 as=0.0588 pd=1.41 ps=0.7 mult=1 m=1
xm9_a_n31 bl_2__t2_a_n31 wl_0__t2_a_n31 n9__t0_a_n31 gnd__t10_a_n31 sky130_fd_pr__nfet_01v8 L=0.15 W=0.42 nf=1 ad=0.0588 as=0.1197 pd=0.7 ps=1.41 mult=1 m=1
xm10_a_n31 n19__t0_a_n31 wl_1__t2_a_n31 bl_2__t0_a_n31 gnd__t22_a_n31 sky130_fd_pr__nfet_01v8 L=0.15 W=0.42 nf=1 ad=0.1197 as=0.0588 pd=1.41 ps=0.7 mult=1 m=1
xm11_a_n31 bl_3__t2_a_n31 wl_0__t1_a_n31 n10__t0_a_n31 gnd__t11_a_n31 sky130_fd_pr__nfet_01v8 L=0.15 W=0.42 nf=1 ad=0.0588 as=0.1197 pd=0.7 ps=1.41 mult=1 m=1
xm12_a_n31 n20__t0_a_n31 wl_1__t3_a_n31 bl_3__t1_a_n31 gnd__t23_a_n31 sky130_fd_pr__nfet_01v8 L=0.15 W=0.42 nf=1 ad=0.1197 as=0.0588 pd=1.41 ps=0.7 mult=1 m=1
xm13_a_n31 rbl_0__t3_a_n31 n17__t1_a_n31 rwl_1__t0_a_n31 gnd__t12_a_n31 sky130_fd_pr__nfet_01v8 L=0.15 W=0.42 nf=1 ad=0.0588 as=0.1197 pd=0.7 ps=1.41 mult=1 m=1
xm14_a_n31 rwl_2__t3_a_n31 n22__t0_a_n31 rbl_0__t2_a_n31 gnd__t24_a_n31 sky130_fd_pr__nfet_01v8 L=0.15 W=0.42 nf=1 ad=0.1197 as=0.0588 pd=1.41 ps=0.7 mult=1 m=1
xm15_a_n31 rbl_1__t3_a_n31 n18__t1_a_n31 rwl_1__t1_a_n31 gnd__t13_a_n31 sky130_fd_pr__nfet_01v8 L=0.15 W=0.42 nf=1 ad=0.0588 as=0.1197 pd=0.7 ps=1.41 mult=1 m=1
xm16_a_n31 rwl_2__t0_a_n31 n23__t0_a_n31 rbl_1__t2_a_n31 gnd__t25_a_n31 sky130_fd_pr__nfet_01v8 L=0.15 W=0.42 nf=1 ad=0.1197 as=0.0588 pd=1.41 ps=0.7 mult=1 m=1
xm17_a_n31 rbl_2__t3_a_n31 n19__t1_a_n31 rwl_1__t2_a_n31 gnd__t14_a_n31 sky130_fd_pr__nfet_01v8 L=0.15 W=0.42 nf=1 ad=0.0588 as=0.1197 pd=0.7 ps=1.41 mult=1 m=1
xm18_a_n31 rwl_2__t1_a_n31 n24__t0_a_n31 rbl_2__t2_a_n31 gnd__t26_a_n31 sky130_fd_pr__nfet_01v8 L=0.15 W=0.42 nf=1 ad=0.1197 as=0.0588 pd=1.41 ps=0.7 mult=1 m=1
xm19_a_n31 rbl_3__t3_a_n31 n20__t1_a_n31 rwl_1__t3_a_n31 gnd__t15_a_n31 sky130_fd_pr__nfet_01v8 L=0.15 W=0.42 nf=1 ad=0.0588 as=0.1197 pd=0.7 ps=1.41 mult=1 m=1
xm20_a_n31 rwl_2__t2_a_n31 n25__t0_a_n31 rbl_3__t2_a_n31 gnd__t27_a_n31 sky130_fd_pr__nfet_01v8 L=0.15 W=0.42 nf=1 ad=0.1197 as=0.0588 pd=1.41 ps=0.7 mult=1 m=1
xm21_a_n31 bl_0__t3_a_n31 wl_2__t0_a_n31 n22__t1_a_n31 gnd__t16_a_n31 sky130_fd_pr__nfet_01v8 L=0.15 W=0.42 nf=1 ad=0.0588 as=0.1197 pd=0.7 ps=1.41 mult=1 m=1
xm22_a_n31 n29__t0_a_n31 wl_3__t3_a_n31 bl_0__t2_a_n31 gnd__t28_a_n31 sky130_fd_pr__nfet_01v8 L=0.15 W=0.42 nf=1 ad=0.1197 as=0.0588 pd=1.41 ps=0.7 mult=1 m=1
xm23_a_n31 bl_1__t3_a_n31 wl_2__t1_a_n31 n23__t1_a_n31 gnd__t17_a_n31 sky130_fd_pr__nfet_01v8 L=0.15 W=0.42 nf=1 ad=0.0588 as=0.1197 pd=0.7 ps=1.41 mult=1 m=1
xm24_a_n31 n30__t0_a_n31 wl_3__t2_a_n31 bl_1__t1_a_n31 gnd__t29_a_n31 sky130_fd_pr__nfet_01v8 L=0.15 W=0.42 nf=1 ad=0.1197 as=0.0588 pd=1.41 ps=0.7 mult=1 m=1
xm25_a_n31 bl_2__t3_a_n31 wl_2__t2_a_n31 n24__t1_a_n31 gnd__t18_a_n31 sky130_fd_pr__nfet_01v8 L=0.15 W=0.42 nf=1 ad=0.0588 as=0.1197 pd=0.7 ps=1.41 mult=1 m=1
xm26_a_n31 n31__t0_a_n31 wl_3__t1_a_n31 bl_2__t1_a_n31 gnd__t30_a_n31 sky130_fd_pr__nfet_01v8 L=0.15 W=0.42 nf=1 ad=0.1197 as=0.0588 pd=1.41 ps=0.7 mult=1 m=1
xm27_a_n31 bl_3__t3_a_n31 wl_2__t3_a_n31 n25__t1_a_n31 gnd__t19_a_n31 sky130_fd_pr__nfet_01v8 L=0.15 W=0.42 nf=1 ad=0.0588 as=0.1197 pd=0.7 ps=1.41 mult=1 m=1
xm28_a_n31 n32__t0_a_n31 wl_3__t0_a_n31 bl_3__t0_a_n31 gnd__t31_a_n31 sky130_fd_pr__nfet_01v8 L=0.15 W=0.42 nf=1 ad=0.1197 as=0.0588 pd=1.41 ps=0.7 mult=1 m=1
xm29_a_n31 rbl_0__t1_a_n31 n29__t1_a_n31 rwl_3__t0_a_n31 gnd__t4_a_n31 sky130_fd_pr__nfet_01v8 L=0.15 W=0.42 nf=1 ad=0.1197 as=0.1197 pd=1.41 ps=1.41 mult=1 m=1
xm30_a_n31 rbl_1__t0_a_n31 n30__t1_a_n31 rwl_3__t1_a_n31 gnd__t5_a_n31 sky130_fd_pr__nfet_01v8 L=0.15 W=0.42 nf=1 ad=0.1197 as=0.1197 pd=1.41 ps=1.41 mult=1 m=1
xm31_a_n31 rbl_2__t0_a_n31 n31__t1_a_n31 rwl_3__t2_a_n31 gnd__t6_a_n31 sky130_fd_pr__nfet_01v8 L=0.15 W=0.42 nf=1 ad=0.1197 as=0.1197 pd=1.41 ps=1.41 mult=1 m=1
xm32_a_n31 rbl_3__t0_a_n31 n32__t1_a_n31 rwl_3__t3_a_n31 gnd__t7_a_n31 sky130_fd_pr__nfet_01v8 L=0.15 W=0.42 nf=1 ad=0.1197 as=0.1197 pd=1.41 ps=1.41 mult=1 m=1
r_10_t0_a_n31 n10__t0_a_n31 n10_a_n31 183.071
r_10_t1_a_n31 n10__t1_a_n31 n10_a_n31 183.071
r_17_t0_a_n31 n17__t0_a_n31 n17_a_n31 183.071
r_17_t1_a_n31 n17__t1_a_n31 n17_a_n31 183.071
r_18_t0_a_n31 n18__t0_a_n31 n18_a_n31 183.071
r_18_t1_a_n31 n18__t1_a_n31 n18_a_n31 183.071
r_19_t0_a_n31 n19__t0_a_n31 n19_a_n31 183.071
r_19_t1_a_n31 n19__t1_a_n31 n19_a_n31 183.071
r_20_t0_a_n31 n20__t0_a_n31 n20_a_n31 183.071
r_20_t1_a_n31 n20__t1_a_n31 n20_a_n31 183.071
r_22_t0_a_n31 n22__t0_a_n31 n22_a_n31 183.071
r_22_t1_a_n31 n22__t1_a_n31 n22_a_n31 183.071
r_23_t0_a_n31 n23__t0_a_n31 n23_a_n31 183.071
r_23_t1_a_n31 n23__t1_a_n31 n23_a_n31 183.071
r_24_t0_a_n31 n24__t0_a_n31 n24_a_n31 183.071
r_24_t1_a_n31 n24__t1_a_n31 n24_a_n31 183.071
r_25_t0_a_n31 n25__t0_a_n31 n25_a_n31 183.071
r_25_t1_a_n31 n25__t1_a_n31 n25_a_n31 183.071
r_29_t0_a_n31 n29__t0_a_n31 n29_a_n31 183.071
r_29_t1_a_n31 n29__t1_a_n31 n29_a_n31 183.071
r_30_t0_a_n31 n30__t0_a_n31 n30_a_n31 183.071
r_30_t1_a_n31 n30__t1_a_n31 n30_a_n31 183.071
r_31_t0_a_n31 n31__t0_a_n31 n31_a_n31 183.071
r_31_t1_a_n31 n31__t1_a_n31 n31_a_n31 183.071
r_32_t0_a_n31 n32__t0_a_n31 n32_a_n31 183.071
r_32_t1_a_n31 n32__t1_a_n31 n32_a_n31 183.071
r_7_t0_a_n31 n7__t0_a_n31 n7_a_n31 183.071
r_7_t1_a_n31 n7__t1_a_n31 n7_a_n31 183.071
r_8_t0_a_n31 n8__t0_a_n31 n8_a_n31 183.071
r_8_t1_a_n31 n8__t1_a_n31 n8_a_n31 183.071
r_9_t0_a_n31 n9__t0_a_n31 n9_a_n31 183.071
r_9_t1_a_n31 n9__t1_a_n31 n9_a_n31 183.071
rgnd_t0_a_n31 gnd__t0_a_n31 0 38.2988
rgnd_t1_a_n31 gnd__t1_a_n31 0 33.9576
rgnd_t2_a_n31 gnd__t2_a_n31 0 33.9576
rgnd_t3_a_n31 gnd__t3_a_n31 0 38.2988
rgnd_t4_a_n31 gnd__t4_a_n31 0 38.2988
rgnd_t5_a_n31 gnd__t5_a_n31 0 33.9576
rgnd_t6_a_n31 gnd__t6_a_n31 0 33.9576
rgnd_t7_a_n31 gnd__t7_a_n31 0 38.2988
rgnd_t8_a_n31 gnd__t8_a_n31 0 28.0185
rgnd_t9_a_n31 gnd__t9_a_n31 0 21.7106
rgnd_t10_a_n31 gnd__t10_a_n31 0 21.7106
rgnd_t11_a_n31 gnd__t11_a_n31 0 28.0185
rgnd_t12_a_n31 gnd__t12_a_n31 0 18.9833
rgnd_t13_a_n31 gnd__t13_a_n31 0 6.8325
rgnd_t14_a_n31 gnd__t14_a_n31 0 6.8325
rgnd_t15_a_n31 gnd__t15_a_n31 0 18.9833
rgnd_t16_a_n31 gnd__t16_a_n31 0 24.2409
rgnd_t17_a_n31 gnd__t17_a_n31 0 16.5511
rgnd_t18_a_n31 gnd__t18_a_n31 0 16.5511
rgnd_t19_a_n31 gnd__t19_a_n31 0 24.2409
rgnd_t20_a_n31 gnd__t20_a_n31 0 24.2409
rgnd_t21_a_n31 gnd__t21_a_n31 0 16.5511
rgnd_t22_a_n31 gnd__t22_a_n31 0 16.5511
rgnd_t23_a_n31 gnd__t23_a_n31 0 24.2409
rgnd_t24_a_n31 gnd__t24_a_n31 0 18.9833
rgnd_t25_a_n31 gnd__t25_a_n31 0 6.8325
rgnd_t26_a_n31 gnd__t26_a_n31 0 6.8325
rgnd_t27_a_n31 gnd__t27_a_n31 0 18.9833
rgnd_t28_a_n31 gnd__t28_a_n31 0 28.0185
rgnd_t29_a_n31 gnd__t29_a_n31 0 21.7106
rgnd_t30_a_n31 gnd__t30_a_n31 0 21.7106
rgnd_t31_a_n31 gnd__t31_a_n31 0 28.0185
rbl_0_t0_a_n31 bl_0__t0_a_n31 bl_0_a_n31 14.8304
rbl_0_t1_a_n31 bl_0__t1_a_n31 bl_0_a_n31 10.9301
rbl_0_t2_a_n31 bl_0__t2_a_n31 bl_0_a_n31 14.8304
rbl_0_t3_a_n31 bl_0__t3_a_n31 bl_0_a_n31 10.9301
rbl_1_t0_a_n31 bl_1__t0_a_n31 bl_1_a_n31 10.9301
rbl_1_t1_a_n31 bl_1__t1_a_n31 bl_1_a_n31 14.8304
rbl_1_t2_a_n31 bl_1__t2_a_n31 bl_1_a_n31 14.8304
rbl_1_t3_a_n31 bl_1__t3_a_n31 bl_1_a_n31 10.9301
rbl_2_t0_a_n31 bl_2__t0_a_n31 bl_2_a_n31 10.9301
rbl_2_t1_a_n31 bl_2__t1_a_n31 bl_2_a_n31 14.8304
rbl_2_t2_a_n31 bl_2__t2_a_n31 bl_2_a_n31 14.8304
rbl_2_t3_a_n31 bl_2__t3_a_n31 bl_2_a_n31 10.9301
rbl_3_t0_a_n31 bl_3__t0_a_n31 bl_3_a_n31 14.8304
rbl_3_t1_a_n31 bl_3__t1_a_n31 bl_3_a_n31 10.9301
rbl_3_t2_a_n31 bl_3__t2_a_n31 bl_3_a_n31 14.8304
rbl_3_t3_a_n31 bl_3__t3_a_n31 bl_3_a_n31 10.9301
rrbl_0_t0_a_n31 rbl_0__t0_a_n31 rbl_0_a_n31 36.5601
rrbl_0_t1_a_n31 rbl_0__t1_a_n31 rbl_0_a_n31 36.5601
rrbl_0_t2_a_n31 rbl_0__t2_a_n31 rbl_0_a_n31 2.99444
rrbl_0_t3_a_n31 rbl_0__t3_a_n31 rbl_0_a_n31 2.99444
rrbl_1_t0_a_n31 rbl_1__t0_a_n31 rbl_1_a_n31 36.5601
rrbl_1_t1_a_n31 rbl_1__t1_a_n31 rbl_1_a_n31 36.5601
rrbl_1_t2_a_n31 rbl_1__t2_a_n31 rbl_1_a_n31 2.99444
rrbl_1_t3_a_n31 rbl_1__t3_a_n31 rbl_1_a_n31 2.99444
rrbl_2_t0_a_n31 rbl_2__t0_a_n31 rbl_2_a_n31 36.5601
rrbl_2_t1_a_n31 rbl_2__t1_a_n31 rbl_2_a_n31 36.5601
rrbl_2_t2_a_n31 rbl_2__t2_a_n31 rbl_2_a_n31 2.99444
rrbl_2_t3_a_n31 rbl_2__t3_a_n31 rbl_2_a_n31 2.99444
rrbl_3_t0_a_n31 rbl_3__t0_a_n31 rbl_3_a_n31 36.5601
rrbl_3_t1_a_n31 rbl_3__t1_a_n31 rbl_3_a_n31 36.5601
rrbl_3_t2_a_n31 rbl_3__t2_a_n31 rbl_3_a_n31 2.99444
rrbl_3_t3_a_n31 rbl_3__t3_a_n31 rbl_3_a_n31 2.99444
rrwl_0_t0_a_n31 rwl_0__t0_a_n31 rwl_0_a_n31 38.2618
rrwl_0_t1_a_n31 rwl_0__t1_a_n31 rwl_0_a_n31 12.7539
rrwl_0_t2_a_n31 rwl_0__t2_a_n31 rwl_0_a_n31 38.2618
rrwl_0_t3_a_n31 rwl_0__t3_a_n31 rwl_0_a_n31 12.7539
rrwl_1_t0_a_n31 rwl_1__t0_a_n31 rwl_1_a_n31 38.2618
rrwl_1_t1_a_n31 rwl_1__t1_a_n31 rwl_1_a_n31 12.7539
rrwl_1_t2_a_n31 rwl_1__t2_a_n31 rwl_1_a_n31 12.7539
rrwl_1_t3_a_n31 rwl_1__t3_a_n31 rwl_1_a_n31 38.2618
rrwl_2_t0_a_n31 rwl_2__t0_a_n31 rwl_2_a_n31 12.7539
rrwl_2_t1_a_n31 rwl_2__t1_a_n31 rwl_2_a_n31 12.7539
rrwl_2_t2_a_n31 rwl_2__t2_a_n31 rwl_2_a_n31 38.2618
rrwl_2_t3_a_n31 rwl_2__t3_a_n31 rwl_2_a_n31 38.2618
rrwl_3_t0_a_n31 rwl_3__t0_a_n31 rwl_3_a_n31 38.2618
rrwl_3_t1_a_n31 rwl_3__t1_a_n31 rwl_3_a_n31 12.7539
rrwl_3_t2_a_n31 rwl_3__t2_a_n31 rwl_3_a_n31 12.7539
rrwl_3_t3_a_n31 rwl_3__t3_a_n31 rwl_3_a_n31 38.2618
rwl_0_t0_a_n31 wl_0__t0_a_n31 wl_0_a_n31 245.959
rwl_0_t1_a_n31 wl_0__t1_a_n31 wl_0_a_n31 245.959
rwl_0_t2_a_n31 wl_0__t2_a_n31 wl_0_a_n31 81.9864
rwl_0_t3_a_n31 wl_0__t3_a_n31 wl_0_a_n31 81.9864
rwl_1_t0_a_n31 wl_1__t0_a_n31 wl_1_a_n31 245.959
rwl_1_t1_a_n31 wl_1__t1_a_n31 wl_1_a_n31 81.9864
rwl_1_t2_a_n31 wl_1__t2_a_n31 wl_1_a_n31 81.9864
rwl_1_t3_a_n31 wl_1__t3_a_n31 wl_1_a_n31 245.959
rwl_2_t0_a_n31 wl_2__t0_a_n31 wl_2_a_n31 245.959
rwl_2_t1_a_n31 wl_2__t1_a_n31 wl_2_a_n31 81.9864
rwl_2_t2_a_n31 wl_2__t2_a_n31 wl_2_a_n31 81.9864
rwl_2_t3_a_n31 wl_2__t3_a_n31 wl_2_a_n31 245.959
rwl_3_t0_a_n31 wl_3__t0_a_n31 wl_3_a_n31 245.959
rwl_3_t1_a_n31 wl_3__t1_a_n31 wl_3_a_n31 81.9864
rwl_3_t2_a_n31 wl_3__t2_a_n31 wl_3_a_n31 81.9864
rwl_3_t3_a_n31 wl_3__t3_a_n31 wl_3_a_n31 245.959
c_10_a_n31 n10_a_n31 0 2.91622e-16
c_17_a_n31 n17_a_n31 0 2.91528e-16
c_18_a_n31 n18_a_n31 0 2.91528e-16
c_19_a_n31 n19_a_n31 0 2.91528e-16
c_20_a_n31 n20_a_n31 0 2.91622e-16
c_22_a_n31 n22_a_n31 0 2.91528e-16
c_23_a_n31 n23_a_n31 0 2.91528e-16
c_24_a_n31 n24_a_n31 0 2.91528e-16
c_25_a_n31 n25_a_n31 0 2.91622e-16
c_29_a_n31 n29_a_n31 0 2.91528e-16
c_30_a_n31 n30_a_n31 0 2.91528e-16
c_31_a_n31 n31_a_n31 0 2.91528e-16
c_32_a_n31 n32_a_n31 0 2.91622e-16
c_7_a_n31 n7_a_n31 0 2.91528e-16
c_8_a_n31 n8_a_n31 0 2.91528e-16
c_9_a_n31 n9_a_n31 0 2.91528e-16
cgnd_a_n31 0 0 2.48166e-15
cbl_0_a_n31 bl_0_a_n31 0 4.52661e-16
cbl_1_a_n31 bl_1_a_n31 0 4.52661e-16
cbl_2_a_n31 bl_2_a_n31 0 4.52661e-16
cbl_3_a_n31 bl_3_a_n31 0 4.52661e-16
crbl_0_a_n31 rbl_0_a_n31 0 9.14472e-16
crbl_1_a_n31 rbl_1_a_n31 0 9.14472e-16
crbl_2_a_n31 rbl_2_a_n31 0 9.14472e-16
crbl_3_a_n31 rbl_3_a_n31 0 9.17566e-16
crwl_0_a_n31 rwl_0_a_n31 0 5.19495e-16
crwl_1_a_n31 rwl_1_a_n31 0 5.11719e-16
crwl_2_a_n31 rwl_2_a_n31 0 5.11719e-16
crwl_3_a_n31 rwl_3_a_n31 0 5.19495e-16
cwl_0_a_n31 wl_0_a_n31 0 3.30388e-16
cwl_1_a_n31 wl_1_a_n31 0 3.30388e-16
cwl_2_a_n31 wl_2_a_n31 0 3.30388e-16
cwl_3_a_n31 wl_3_a_n31 0 3.30388e-16
ccc__10__9_a_n31 n10_a_n31 n9_a_n31 1.02e-17
ccc__10_bl_3_a_n31 n10_a_n31 bl_3_a_n31 1.3999e-17
ccc__10_rwl_0_a_n31 n10_a_n31 rwl_0_a_n31 4.335e-18
ccc__17__18_a_n31 n17_a_n31 n18_a_n31 1.02e-17
ccc__17_bl_0_a_n31 n17_a_n31 bl_0_a_n31 8.415e-18
ccc__17_rwl_1_a_n31 n17_a_n31 rwl_1_a_n31 1.3194e-17
ccc__18__19_a_n31 n18_a_n31 n19_a_n31 1.02e-17
ccc__18_bl_1_a_n31 n18_a_n31 bl_1_a_n31 8.415e-18
ccc__18_rwl_1_a_n31 n18_a_n31 rwl_1_a_n31 1.3194e-17
ccc__19__20_a_n31 n19_a_n31 n20_a_n31 1.02e-17
ccc__19_bl_2_a_n31 n19_a_n31 bl_2_a_n31 8.415e-18
ccc__19_rwl_1_a_n31 n19_a_n31 rwl_1_a_n31 1.3194e-17
ccc__20_bl_3_a_n31 n20_a_n31 bl_3_a_n31 8.415e-18
ccc__20_rwl_1_a_n31 n20_a_n31 rwl_1_a_n31 6.655e-18
ccc__22__23_a_n31 n22_a_n31 n23_a_n31 1.02e-17
ccc__22_bl_0_a_n31 n22_a_n31 bl_0_a_n31 8.415e-18
ccc__22_rwl_2_a_n31 n22_a_n31 rwl_2_a_n31 1.3194e-17
ccc__23__24_a_n31 n23_a_n31 n24_a_n31 1.02e-17
ccc__23_bl_1_a_n31 n23_a_n31 bl_1_a_n31 8.415e-18
ccc__23_rwl_2_a_n31 n23_a_n31 rwl_2_a_n31 1.3194e-17
ccc__24__25_a_n31 n24_a_n31 n25_a_n31 1.02e-17
ccc__24_bl_2_a_n31 n24_a_n31 bl_2_a_n31 8.415e-18
ccc__24_rwl_2_a_n31 n24_a_n31 rwl_2_a_n31 1.3194e-17
ccc__25_bl_3_a_n31 n25_a_n31 bl_3_a_n31 8.415e-18
ccc__25_rwl_2_a_n31 n25_a_n31 rwl_2_a_n31 6.655e-18
ccc__29__30_a_n31 n29_a_n31 n30_a_n31 1.02e-17
ccc__29_bl_0_a_n31 n29_a_n31 bl_0_a_n31 8.415e-18
ccc__29_rwl_3_a_n31 n29_a_n31 rwl_3_a_n31 1.3194e-17
ccc__30__31_a_n31 n30_a_n31 n31_a_n31 1.02e-17
ccc__30_bl_1_a_n31 n30_a_n31 bl_1_a_n31 8.415e-18
ccc__30_rwl_3_a_n31 n30_a_n31 rwl_3_a_n31 1.3194e-17
ccc__31__32_a_n31 n31_a_n31 n32_a_n31 1.02e-17
ccc__31_bl_2_a_n31 n31_a_n31 bl_2_a_n31 8.415e-18
ccc__31_rwl_3_a_n31 n31_a_n31 rwl_3_a_n31 1.3194e-17
ccc__32_bl_3_a_n31 n32_a_n31 bl_3_a_n31 8.415e-18
ccc__32_rwl_3_a_n31 n32_a_n31 rwl_3_a_n31 6.655e-18
ccc__7__8_a_n31 n7_a_n31 n8_a_n31 1.02e-17
ccc__7_bl_0_a_n31 n7_a_n31 bl_0_a_n31 1.3999e-17
ccc__7_rwl_0_a_n31 n7_a_n31 rwl_0_a_n31 8.961e-18
ccc__8__9_a_n31 n8_a_n31 n9_a_n31 1.02e-17
ccc__8_bl_1_a_n31 n8_a_n31 bl_1_a_n31 1.3999e-17
ccc__8_rwl_0_a_n31 n8_a_n31 rwl_0_a_n31 8.961e-18
ccc__9_bl_2_a_n31 n9_a_n31 bl_2_a_n31 1.3999e-17
ccc__9_rwl_0_a_n31 n9_a_n31 rwl_0_a_n31 8.961e-18
ccc_bl_0_rbl_0_a_n31 bl_0_a_n31 rbl_0_a_n31 1.88693e-16
ccc_bl_0_rwl_1_a_n31 bl_0_a_n31 rwl_1_a_n31 1.0093e-17
ccc_bl_0_rwl_2_a_n31 bl_0_a_n31 rwl_2_a_n31 1.0093e-17
ccc_bl_1_rbl_0_a_n31 bl_1_a_n31 rbl_0_a_n31 1.633e-16
ccc_bl_1_rbl_1_a_n31 bl_1_a_n31 rbl_1_a_n31 1.88693e-16
ccc_bl_1_rwl_1_a_n31 bl_1_a_n31 rwl_1_a_n31 1.0093e-17
ccc_bl_1_rwl_2_a_n31 bl_1_a_n31 rwl_2_a_n31 1.0093e-17
ccc_bl_2_rbl_1_a_n31 bl_2_a_n31 rbl_1_a_n31 1.633e-16
ccc_bl_2_rbl_2_a_n31 bl_2_a_n31 rbl_2_a_n31 1.88693e-16
ccc_bl_2_rwl_1_a_n31 bl_2_a_n31 rwl_1_a_n31 1.0093e-17
ccc_bl_2_rwl_2_a_n31 bl_2_a_n31 rwl_2_a_n31 1.0093e-17
ccc_bl_3_rbl_2_a_n31 bl_3_a_n31 rbl_2_a_n31 1.633e-16
ccc_bl_3_rbl_3_a_n31 bl_3_a_n31 rbl_3_a_n31 1.88693e-16
ccc_bl_3_rwl_1_a_n31 bl_3_a_n31 rwl_1_a_n31 1.0093e-17
ccc_bl_3_rwl_2_a_n31 bl_3_a_n31 rwl_2_a_n31 1.0093e-17
ccc_rbl_0_rbl_1_a_n31 rbl_0_a_n31 rbl_1_a_n31 3.432e-17
ccc_rbl_0_rwl_0_a_n31 rbl_0_a_n31 rwl_0_a_n31 4.9752e-17
ccc_rbl_0_rwl_1_a_n31 rbl_0_a_n31 rwl_1_a_n31 4.9752e-17
ccc_rbl_0_rwl_2_a_n31 rbl_0_a_n31 rwl_2_a_n31 4.9752e-17
ccc_rbl_0_rwl_3_a_n31 rbl_0_a_n31 rwl_3_a_n31 4.9752e-17
ccc_rbl_1_rbl_2_a_n31 rbl_1_a_n31 rbl_2_a_n31 3.432e-17
ccc_rbl_1_rwl_0_a_n31 rbl_1_a_n31 rwl_0_a_n31 4.9752e-17
ccc_rbl_1_rwl_1_a_n31 rbl_1_a_n31 rwl_1_a_n31 4.9752e-17
ccc_rbl_1_rwl_2_a_n31 rbl_1_a_n31 rwl_2_a_n31 4.9752e-17
ccc_rbl_1_rwl_3_a_n31 rbl_1_a_n31 rwl_3_a_n31 4.9752e-17
ccc_rbl_2_rbl_3_a_n31 rbl_2_a_n31 rbl_3_a_n31 3.432e-17
ccc_rbl_2_rwl_0_a_n31 rbl_2_a_n31 rwl_0_a_n31 4.9752e-17
ccc_rbl_2_rwl_1_a_n31 rbl_2_a_n31 rwl_1_a_n31 4.9752e-17
ccc_rbl_2_rwl_2_a_n31 rbl_2_a_n31 rwl_2_a_n31 4.9752e-17
ccc_rbl_2_rwl_3_a_n31 rbl_2_a_n31 rwl_3_a_n31 4.9752e-17
ccc_rbl_3_rwl_0_a_n31 rbl_3_a_n31 rwl_0_a_n31 3.3407e-17
ccc_rbl_3_rwl_1_a_n31 rbl_3_a_n31 rwl_1_a_n31 3.3407e-17
ccc_rbl_3_rwl_2_a_n31 rbl_3_a_n31 rwl_2_a_n31 3.3407e-17
ccc_rbl_3_rwl_3_a_n31 rbl_3_a_n31 rwl_3_a_n31 3.3407e-17
vdw_a_n31_0 wl_0_a_n31 0 dc 0
vdr_a_n31_0 rwl_0_a_n31 vdd dc 0
vdw_a_n31_1 wl_1_a_n31 0 dc 0
vdr_a_n31_1 rwl_1_a_n31 vdd dc 0
vdw_a_n31_2 wl_2_a_n31 0 dc 0
vdr_a_n31_2 rwl_2_a_n31 vdd dc 0
vdw_a_n31_3 wl_3_a_n31 0 dc 0
vdr_a_n31_3 rwl_3_a_n31 vdd dc 0
vdb_a_n31_0 bl_0_a_n31 0 dc 0
vdp_a_n31_0 rbl_0_a_n31 vrbl dc 0
vdb_a_n31_1 bl_1_a_n31 0 dc 0
vdp_a_n31_1 rbl_1_a_n31 vrbl dc 0
vdb_a_n31_2 bl_2_a_n31 0 dc 0
vdp_a_n31_2 rbl_2_a_n31 vrbl dc 0
vdb_a_n31_3 bl_3_a_n31 0 dc 0
vdp_a_n31_3 rbl_3_a_n31 vrbl dc 0
vdn_a_n31_n7 n7_a_n31 0 dc 1
vdn_a_n31_n8 n8_a_n31 0 dc 1
vdn_a_n31_n9 n9_a_n31 0 dc 1
vdn_a_n31_n10 n10_a_n31 0 dc 1
vdn_a_n31_n17 n17_a_n31 0 dc 1
vdn_a_n31_n18 n18_a_n31 0 dc 1
vdn_a_n31_n19 n19_a_n31 0 dc 1
vdn_a_n31_n20 n20_a_n31 0 dc 1
vdn_a_n31_n22 n22_a_n31 0 dc 1
vdn_a_n31_n23 n23_a_n31 0 dc 1
vdn_a_n31_n24 n24_a_n31 0 dc 1
vdn_a_n31_n25 n25_a_n31 0 dc 1
vdn_a_n31_n29 n29_a_n31 0 dc 1
vdn_a_n31_n30 n30_a_n31 0 dc 1
vdn_a_n31_n32 n32_a_n31 0 dc 1
bdr_a_n31 n31_a_n31 0 i=5e-08*min(1,max(0,(time-1e-09)/0.2n))*0.5*(1+tanh((v(n31_a_n31)-0.05)/0.01))

* ---- instance a_n32: variant a, probed storage node \$32 ----
xm1_a_n32 rwl_0__t2_a_n32 n7__t0_a_n32 rbl_0__t0_a_n32 gnd__t0_a_n32 sky130_fd_pr__nfet_01v8 L=0.15 W=0.42 nf=1 ad=0.1197 as=0.1197 pd=1.41 ps=1.41 mult=1 m=1
xm2_a_n32 rwl_0__t3_a_n32 n8__t1_a_n32 rbl_1__t1_a_n32 gnd__t1_a_n32 sky130_fd_pr__nfet_01v8 L=0.15 W=0.42 nf=1 ad=0.1197 as=0.1197 pd=1.41 ps=1.41 mult=1 m=1
xm3_a_n32 rwl_0__t1_a_n32 n9__t1_a_n32 rbl_2__t1_a_n32 gnd__t2_a_n32 sky130_fd_pr__nfet_01v8 L=0.15 W=0.42 nf=1 ad=0.1197 as=0.1197 pd=1.41 ps=1.41 mult=1 m=1
xm4_a_n32 rwl_0__t0_a_n32 n10__t1_a_n32 rbl_3__t1_a_n32 gnd__t3_a_n32 sky130_fd_pr__nfet_01v8 L=0.15 W=0.42 nf=1 ad=0.1197 as=0.1197 pd=1.41 ps=1.41 mult=1 m=1
xm5_a_n32 bl_0__t0_a_n32 wl_0__t0_a_n32 n7__t1_a_n32 gnd__t8_a_n32 sky130_fd_pr__nfet_01v8 L=0.15 W=0.42 nf=1 ad=0.0588 as=0.1197 pd=0.7 ps=1.41 mult=1 m=1
xm6_a_n32 n17__t0_a_n32 wl_1__t0_a_n32 bl_0__t1_a_n32 gnd__t20_a_n32 sky130_fd_pr__nfet_01v8 L=0.15 W=0.42 nf=1 ad=0.1197 as=0.0588 pd=1.41 ps=0.7 mult=1 m=1
xm7_a_n32 bl_1__t2_a_n32 wl_0__t3_a_n32 n8__t0_a_n32 gnd__t9_a_n32 sky130_fd_pr__nfet_01v8 L=0.15 W=0.42 nf=1 ad=0.0588 as=0.1197 pd=0.7 ps=1.41 mult=1 m=1
xm8_a_n32 n18__t0_a_n32 wl_1__t1_a_n32 bl_1__t0_a_n32 gnd__t21_a_n32 sky130_fd_pr__nfet_01v8 L=0.15 W=0.42 nf=1 ad=0.1197 as=0.0588 pd=1.41 ps=0.7 mult=1 m=1
xm9_a_n32 bl_2__t2_a_n32 wl_0__t2_a_n32 n9__t0_a_n32 gnd__t10_a_n32 sky130_fd_pr__nfet_01v8 L=0.15 W=0.42 nf=1 ad=0.0588 as=0.1197 pd=0.7 ps=1.41 mult=1 m=1
xm10_a_n32 n19__t0_a_n32 wl_1__t2_a_n32 bl_2__t0_a_n32 gnd__t22_a_n32 sky130_fd_pr__nfet_01v8 L=0.15 W=0.42 nf=1 ad=0.1197 as=0.0588 pd=1.41 ps=0.7 mult=1 m=1
xm11_a_n32 bl_3__t2_a_n32 wl_0__t1_a_n32 n10__t0_a_n32 gnd__t11_a_n32 sky130_fd_pr__nfet_01v8 L=0.15 W=0.42 nf=1 ad=0.0588 as=0.1197 pd=0.7 ps=1.41 mult=1 m=1
xm12_a_n32 n20__t0_a_n32 wl_1__t3_a_n32 bl_3__t1_a_n32 gnd__t23_a_n32 sky130_fd_pr__nfet_01v8 L=0.15 W=0.42 nf=1 ad=0.1197 as=0.0588 pd=1.41 ps=0.7 mult=1 m=1
xm13_a_n32 rbl_0__t3_a_n32 n17__t1_a_n32 rwl_1__t0_a_n32 gnd__t12_a_n32 sky130_fd_pr__nfet_01v8 L=0.15 W=0.42 nf=1 ad=0.0588 as=0.1197 pd=0.7 ps=1.41 mult=1 m=1
xm14_a_n32 rwl_2__t3_a_n32 n22__t0_a_n32 rbl_0__t2_a_n32 gnd__t24_a_n32 sky130_fd_pr__nfet_01v8 L=0.15 W=0.42 nf=1 ad=0.1197 as=0.0588 pd=1.41 ps=0.7 mult=1 m=1
xm15_a_n32 rbl_1__t3_a_n32 n18__t1_a_n32 rwl_1__t1_a_n32 gnd__t13_a_n32 sky130_fd_pr__nfet_01v8 L=0.15 W=0.42 nf=1 ad=0.0588 as=0.1197 pd=0.7 ps=1.41 mult=1 m=1
xm16_a_n32 rwl_2__t0_a_n32 n23__t0_a_n32 rbl_1__t2_a_n32 gnd__t25_a_n32 sky130_fd_pr__nfet_01v8 L=0.15 W=0.42 nf=1 ad=0.1197 as=0.0588 pd=1.41 ps=0.7 mult=1 m=1
xm17_a_n32 rbl_2__t3_a_n32 n19__t1_a_n32 rwl_1__t2_a_n32 gnd__t14_a_n32 sky130_fd_pr__nfet_01v8 L=0.15 W=0.42 nf=1 ad=0.0588 as=0.1197 pd=0.7 ps=1.41 mult=1 m=1
xm18_a_n32 rwl_2__t1_a_n32 n24__t0_a_n32 rbl_2__t2_a_n32 gnd__t26_a_n32 sky130_fd_pr__nfet_01v8 L=0.15 W=0.42 nf=1 ad=0.1197 as=0.0588 pd=1.41 ps=0.7 mult=1 m=1
xm19_a_n32 rbl_3__t3_a_n32 n20__t1_a_n32 rwl_1__t3_a_n32 gnd__t15_a_n32 sky130_fd_pr__nfet_01v8 L=0.15 W=0.42 nf=1 ad=0.0588 as=0.1197 pd=0.7 ps=1.41 mult=1 m=1
xm20_a_n32 rwl_2__t2_a_n32 n25__t0_a_n32 rbl_3__t2_a_n32 gnd__t27_a_n32 sky130_fd_pr__nfet_01v8 L=0.15 W=0.42 nf=1 ad=0.1197 as=0.0588 pd=1.41 ps=0.7 mult=1 m=1
xm21_a_n32 bl_0__t3_a_n32 wl_2__t0_a_n32 n22__t1_a_n32 gnd__t16_a_n32 sky130_fd_pr__nfet_01v8 L=0.15 W=0.42 nf=1 ad=0.0588 as=0.1197 pd=0.7 ps=1.41 mult=1 m=1
xm22_a_n32 n29__t0_a_n32 wl_3__t3_a_n32 bl_0__t2_a_n32 gnd__t28_a_n32 sky130_fd_pr__nfet_01v8 L=0.15 W=0.42 nf=1 ad=0.1197 as=0.0588 pd=1.41 ps=0.7 mult=1 m=1
xm23_a_n32 bl_1__t3_a_n32 wl_2__t1_a_n32 n23__t1_a_n32 gnd__t17_a_n32 sky130_fd_pr__nfet_01v8 L=0.15 W=0.42 nf=1 ad=0.0588 as=0.1197 pd=0.7 ps=1.41 mult=1 m=1
xm24_a_n32 n30__t0_a_n32 wl_3__t2_a_n32 bl_1__t1_a_n32 gnd__t29_a_n32 sky130_fd_pr__nfet_01v8 L=0.15 W=0.42 nf=1 ad=0.1197 as=0.0588 pd=1.41 ps=0.7 mult=1 m=1
xm25_a_n32 bl_2__t3_a_n32 wl_2__t2_a_n32 n24__t1_a_n32 gnd__t18_a_n32 sky130_fd_pr__nfet_01v8 L=0.15 W=0.42 nf=1 ad=0.0588 as=0.1197 pd=0.7 ps=1.41 mult=1 m=1
xm26_a_n32 n31__t0_a_n32 wl_3__t1_a_n32 bl_2__t1_a_n32 gnd__t30_a_n32 sky130_fd_pr__nfet_01v8 L=0.15 W=0.42 nf=1 ad=0.1197 as=0.0588 pd=1.41 ps=0.7 mult=1 m=1
xm27_a_n32 bl_3__t3_a_n32 wl_2__t3_a_n32 n25__t1_a_n32 gnd__t19_a_n32 sky130_fd_pr__nfet_01v8 L=0.15 W=0.42 nf=1 ad=0.0588 as=0.1197 pd=0.7 ps=1.41 mult=1 m=1
xm28_a_n32 n32__t0_a_n32 wl_3__t0_a_n32 bl_3__t0_a_n32 gnd__t31_a_n32 sky130_fd_pr__nfet_01v8 L=0.15 W=0.42 nf=1 ad=0.1197 as=0.0588 pd=1.41 ps=0.7 mult=1 m=1
xm29_a_n32 rbl_0__t1_a_n32 n29__t1_a_n32 rwl_3__t0_a_n32 gnd__t4_a_n32 sky130_fd_pr__nfet_01v8 L=0.15 W=0.42 nf=1 ad=0.1197 as=0.1197 pd=1.41 ps=1.41 mult=1 m=1
xm30_a_n32 rbl_1__t0_a_n32 n30__t1_a_n32 rwl_3__t1_a_n32 gnd__t5_a_n32 sky130_fd_pr__nfet_01v8 L=0.15 W=0.42 nf=1 ad=0.1197 as=0.1197 pd=1.41 ps=1.41 mult=1 m=1
xm31_a_n32 rbl_2__t0_a_n32 n31__t1_a_n32 rwl_3__t2_a_n32 gnd__t6_a_n32 sky130_fd_pr__nfet_01v8 L=0.15 W=0.42 nf=1 ad=0.1197 as=0.1197 pd=1.41 ps=1.41 mult=1 m=1
xm32_a_n32 rbl_3__t0_a_n32 n32__t1_a_n32 rwl_3__t3_a_n32 gnd__t7_a_n32 sky130_fd_pr__nfet_01v8 L=0.15 W=0.42 nf=1 ad=0.1197 as=0.1197 pd=1.41 ps=1.41 mult=1 m=1
r_10_t0_a_n32 n10__t0_a_n32 n10_a_n32 183.071
r_10_t1_a_n32 n10__t1_a_n32 n10_a_n32 183.071
r_17_t0_a_n32 n17__t0_a_n32 n17_a_n32 183.071
r_17_t1_a_n32 n17__t1_a_n32 n17_a_n32 183.071
r_18_t0_a_n32 n18__t0_a_n32 n18_a_n32 183.071
r_18_t1_a_n32 n18__t1_a_n32 n18_a_n32 183.071
r_19_t0_a_n32 n19__t0_a_n32 n19_a_n32 183.071
r_19_t1_a_n32 n19__t1_a_n32 n19_a_n32 183.071
r_20_t0_a_n32 n20__t0_a_n32 n20_a_n32 183.071
r_20_t1_a_n32 n20__t1_a_n32 n20_a_n32 183.071
r_22_t0_a_n32 n22__t0_a_n32 n22_a_n32 183.071
r_22_t1_a_n32 n22__t1_a_n32 n22_a_n32 183.071
r_23_t0_a_n32 n23__t0_a_n32 n23_a_n32 183.071
r_23_t1_a_n32 n23__t1_a_n32 n23_a_n32 183.071
r_24_t0_a_n32 n24__t0_a_n32 n24_a_n32 183.071
r_24_t1_a_n32 n24__t1_a_n32 n24_a_n32 183.071
r_25_t0_a_n32 n25__t0_a_n32 n25_a_n32 183.071
r_25_t1_a_n32 n25__t1_a_n32 n25_a_n32 183.071
r_29_t0_a_n32 n29__t0_a_n32 n29_a_n32 183.071
r_29_t1_a_n32 n29__t1_a_n32 n29_a_n32 183.071
r_30_t0_a_n32 n30__t0_a_n32 n30_a_n32 183.071
r_30_t1_a_n32 n30__t1_a_n32 n30_a_n32 183.071
r_31_t0_a_n32 n31__t0_a_n32 n31_a_n32 183.071
r_31_t1_a_n32 n31__t1_a_n32 n31_a_n32 183.071
r_32_t0_a_n32 n32__t0_a_n32 n32_a_n32 183.071
r_32_t1_a_n32 n32__t1_a_n32 n32_a_n32 183.071
r_7_t0_a_n32 n7__t0_a_n32 n7_a_n32 183.071
r_7_t1_a_n32 n7__t1_a_n32 n7_a_n32 183.071
r_8_t0_a_n32 n8__t0_a_n32 n8_a_n32 183.071
r_8_t1_a_n32 n8__t1_a_n32 n8_a_n32 183.071
r_9_t0_a_n32 n9__t0_a_n32 n9_a_n32 183.071
r_9_t1_a_n32 n9__t1_a_n32 n9_a_n32 183.071
rgnd_t0_a_n32 gnd__t0_a_n32 0 38.2988
rgnd_t1_a_n32 gnd__t1_a_n32 0 33.9576
rgnd_t2_a_n32 gnd__t2_a_n32 0 33.9576
rgnd_t3_a_n32 gnd__t3_a_n32 0 38.2988
rgnd_t4_a_n32 gnd__t4_a_n32 0 38.2988
rgnd_t5_a_n32 gnd__t5_a_n32 0 33.9576
rgnd_t6_a_n32 gnd__t6_a_n32 0 33.9576
rgnd_t7_a_n32 gnd__t7_a_n32 0 38.2988
rgnd_t8_a_n32 gnd__t8_a_n32 0 28.0185
rgnd_t9_a_n32 gnd__t9_a_n32 0 21.7106
rgnd_t10_a_n32 gnd__t10_a_n32 0 21.7106
rgnd_t11_a_n32 gnd__t11_a_n32 0 28.0185
rgnd_t12_a_n32 gnd__t12_a_n32 0 18.9833
rgnd_t13_a_n32 gnd__t13_a_n32 0 6.8325
rgnd_t14_a_n32 gnd__t14_a_n32 0 6.8325
rgnd_t15_a_n32 gnd__t15_a_n32 0 18.9833
rgnd_t16_a_n32 gnd__t16_a_n32 0 24.2409
rgnd_t17_a_n32 gnd__t17_a_n32 0 16.5511
rgnd_t18_a_n32 gnd__t18_a_n32 0 16.5511
rgnd_t19_a_n32 gnd__t19_a_n32 0 24.2409
rgnd_t20_a_n32 gnd__t20_a_n32 0 24.2409
rgnd_t21_a_n32 gnd__t21_a_n32 0 16.5511
rgnd_t22_a_n32 gnd__t22_a_n32 0 16.5511
rgnd_t23_a_n32 gnd__t23_a_n32 0 24.2409
rgnd_t24_a_n32 gnd__t24_a_n32 0 18.9833
rgnd_t25_a_n32 gnd__t25_a_n32 0 6.8325
rgnd_t26_a_n32 gnd__t26_a_n32 0 6.8325
rgnd_t27_a_n32 gnd__t27_a_n32 0 18.9833
rgnd_t28_a_n32 gnd__t28_a_n32 0 28.0185
rgnd_t29_a_n32 gnd__t29_a_n32 0 21.7106
rgnd_t30_a_n32 gnd__t30_a_n32 0 21.7106
rgnd_t31_a_n32 gnd__t31_a_n32 0 28.0185
rbl_0_t0_a_n32 bl_0__t0_a_n32 bl_0_a_n32 14.8304
rbl_0_t1_a_n32 bl_0__t1_a_n32 bl_0_a_n32 10.9301
rbl_0_t2_a_n32 bl_0__t2_a_n32 bl_0_a_n32 14.8304
rbl_0_t3_a_n32 bl_0__t3_a_n32 bl_0_a_n32 10.9301
rbl_1_t0_a_n32 bl_1__t0_a_n32 bl_1_a_n32 10.9301
rbl_1_t1_a_n32 bl_1__t1_a_n32 bl_1_a_n32 14.8304
rbl_1_t2_a_n32 bl_1__t2_a_n32 bl_1_a_n32 14.8304
rbl_1_t3_a_n32 bl_1__t3_a_n32 bl_1_a_n32 10.9301
rbl_2_t0_a_n32 bl_2__t0_a_n32 bl_2_a_n32 10.9301
rbl_2_t1_a_n32 bl_2__t1_a_n32 bl_2_a_n32 14.8304
rbl_2_t2_a_n32 bl_2__t2_a_n32 bl_2_a_n32 14.8304
rbl_2_t3_a_n32 bl_2__t3_a_n32 bl_2_a_n32 10.9301
rbl_3_t0_a_n32 bl_3__t0_a_n32 bl_3_a_n32 14.8304
rbl_3_t1_a_n32 bl_3__t1_a_n32 bl_3_a_n32 10.9301
rbl_3_t2_a_n32 bl_3__t2_a_n32 bl_3_a_n32 14.8304
rbl_3_t3_a_n32 bl_3__t3_a_n32 bl_3_a_n32 10.9301
rrbl_0_t0_a_n32 rbl_0__t0_a_n32 rbl_0_a_n32 36.5601
rrbl_0_t1_a_n32 rbl_0__t1_a_n32 rbl_0_a_n32 36.5601
rrbl_0_t2_a_n32 rbl_0__t2_a_n32 rbl_0_a_n32 2.99444
rrbl_0_t3_a_n32 rbl_0__t3_a_n32 rbl_0_a_n32 2.99444
rrbl_1_t0_a_n32 rbl_1__t0_a_n32 rbl_1_a_n32 36.5601
rrbl_1_t1_a_n32 rbl_1__t1_a_n32 rbl_1_a_n32 36.5601
rrbl_1_t2_a_n32 rbl_1__t2_a_n32 rbl_1_a_n32 2.99444
rrbl_1_t3_a_n32 rbl_1__t3_a_n32 rbl_1_a_n32 2.99444
rrbl_2_t0_a_n32 rbl_2__t0_a_n32 rbl_2_a_n32 36.5601
rrbl_2_t1_a_n32 rbl_2__t1_a_n32 rbl_2_a_n32 36.5601
rrbl_2_t2_a_n32 rbl_2__t2_a_n32 rbl_2_a_n32 2.99444
rrbl_2_t3_a_n32 rbl_2__t3_a_n32 rbl_2_a_n32 2.99444
rrbl_3_t0_a_n32 rbl_3__t0_a_n32 rbl_3_a_n32 36.5601
rrbl_3_t1_a_n32 rbl_3__t1_a_n32 rbl_3_a_n32 36.5601
rrbl_3_t2_a_n32 rbl_3__t2_a_n32 rbl_3_a_n32 2.99444
rrbl_3_t3_a_n32 rbl_3__t3_a_n32 rbl_3_a_n32 2.99444
rrwl_0_t0_a_n32 rwl_0__t0_a_n32 rwl_0_a_n32 38.2618
rrwl_0_t1_a_n32 rwl_0__t1_a_n32 rwl_0_a_n32 12.7539
rrwl_0_t2_a_n32 rwl_0__t2_a_n32 rwl_0_a_n32 38.2618
rrwl_0_t3_a_n32 rwl_0__t3_a_n32 rwl_0_a_n32 12.7539
rrwl_1_t0_a_n32 rwl_1__t0_a_n32 rwl_1_a_n32 38.2618
rrwl_1_t1_a_n32 rwl_1__t1_a_n32 rwl_1_a_n32 12.7539
rrwl_1_t2_a_n32 rwl_1__t2_a_n32 rwl_1_a_n32 12.7539
rrwl_1_t3_a_n32 rwl_1__t3_a_n32 rwl_1_a_n32 38.2618
rrwl_2_t0_a_n32 rwl_2__t0_a_n32 rwl_2_a_n32 12.7539
rrwl_2_t1_a_n32 rwl_2__t1_a_n32 rwl_2_a_n32 12.7539
rrwl_2_t2_a_n32 rwl_2__t2_a_n32 rwl_2_a_n32 38.2618
rrwl_2_t3_a_n32 rwl_2__t3_a_n32 rwl_2_a_n32 38.2618
rrwl_3_t0_a_n32 rwl_3__t0_a_n32 rwl_3_a_n32 38.2618
rrwl_3_t1_a_n32 rwl_3__t1_a_n32 rwl_3_a_n32 12.7539
rrwl_3_t2_a_n32 rwl_3__t2_a_n32 rwl_3_a_n32 12.7539
rrwl_3_t3_a_n32 rwl_3__t3_a_n32 rwl_3_a_n32 38.2618
rwl_0_t0_a_n32 wl_0__t0_a_n32 wl_0_a_n32 245.959
rwl_0_t1_a_n32 wl_0__t1_a_n32 wl_0_a_n32 245.959
rwl_0_t2_a_n32 wl_0__t2_a_n32 wl_0_a_n32 81.9864
rwl_0_t3_a_n32 wl_0__t3_a_n32 wl_0_a_n32 81.9864
rwl_1_t0_a_n32 wl_1__t0_a_n32 wl_1_a_n32 245.959
rwl_1_t1_a_n32 wl_1__t1_a_n32 wl_1_a_n32 81.9864
rwl_1_t2_a_n32 wl_1__t2_a_n32 wl_1_a_n32 81.9864
rwl_1_t3_a_n32 wl_1__t3_a_n32 wl_1_a_n32 245.959
rwl_2_t0_a_n32 wl_2__t0_a_n32 wl_2_a_n32 245.959
rwl_2_t1_a_n32 wl_2__t1_a_n32 wl_2_a_n32 81.9864
rwl_2_t2_a_n32 wl_2__t2_a_n32 wl_2_a_n32 81.9864
rwl_2_t3_a_n32 wl_2__t3_a_n32 wl_2_a_n32 245.959
rwl_3_t0_a_n32 wl_3__t0_a_n32 wl_3_a_n32 245.959
rwl_3_t1_a_n32 wl_3__t1_a_n32 wl_3_a_n32 81.9864
rwl_3_t2_a_n32 wl_3__t2_a_n32 wl_3_a_n32 81.9864
rwl_3_t3_a_n32 wl_3__t3_a_n32 wl_3_a_n32 245.959
c_10_a_n32 n10_a_n32 0 2.91622e-16
c_17_a_n32 n17_a_n32 0 2.91528e-16
c_18_a_n32 n18_a_n32 0 2.91528e-16
c_19_a_n32 n19_a_n32 0 2.91528e-16
c_20_a_n32 n20_a_n32 0 2.91622e-16
c_22_a_n32 n22_a_n32 0 2.91528e-16
c_23_a_n32 n23_a_n32 0 2.91528e-16
c_24_a_n32 n24_a_n32 0 2.91528e-16
c_25_a_n32 n25_a_n32 0 2.91622e-16
c_29_a_n32 n29_a_n32 0 2.91528e-16
c_30_a_n32 n30_a_n32 0 2.91528e-16
c_31_a_n32 n31_a_n32 0 2.91528e-16
c_32_a_n32 n32_a_n32 0 2.91622e-16
c_7_a_n32 n7_a_n32 0 2.91528e-16
c_8_a_n32 n8_a_n32 0 2.91528e-16
c_9_a_n32 n9_a_n32 0 2.91528e-16
cgnd_a_n32 0 0 2.48166e-15
cbl_0_a_n32 bl_0_a_n32 0 4.52661e-16
cbl_1_a_n32 bl_1_a_n32 0 4.52661e-16
cbl_2_a_n32 bl_2_a_n32 0 4.52661e-16
cbl_3_a_n32 bl_3_a_n32 0 4.52661e-16
crbl_0_a_n32 rbl_0_a_n32 0 9.14472e-16
crbl_1_a_n32 rbl_1_a_n32 0 9.14472e-16
crbl_2_a_n32 rbl_2_a_n32 0 9.14472e-16
crbl_3_a_n32 rbl_3_a_n32 0 9.17566e-16
crwl_0_a_n32 rwl_0_a_n32 0 5.19495e-16
crwl_1_a_n32 rwl_1_a_n32 0 5.11719e-16
crwl_2_a_n32 rwl_2_a_n32 0 5.11719e-16
crwl_3_a_n32 rwl_3_a_n32 0 5.19495e-16
cwl_0_a_n32 wl_0_a_n32 0 3.30388e-16
cwl_1_a_n32 wl_1_a_n32 0 3.30388e-16
cwl_2_a_n32 wl_2_a_n32 0 3.30388e-16
cwl_3_a_n32 wl_3_a_n32 0 3.30388e-16
ccc__10__9_a_n32 n10_a_n32 n9_a_n32 1.02e-17
ccc__10_bl_3_a_n32 n10_a_n32 bl_3_a_n32 1.3999e-17
ccc__10_rwl_0_a_n32 n10_a_n32 rwl_0_a_n32 4.335e-18
ccc__17__18_a_n32 n17_a_n32 n18_a_n32 1.02e-17
ccc__17_bl_0_a_n32 n17_a_n32 bl_0_a_n32 8.415e-18
ccc__17_rwl_1_a_n32 n17_a_n32 rwl_1_a_n32 1.3194e-17
ccc__18__19_a_n32 n18_a_n32 n19_a_n32 1.02e-17
ccc__18_bl_1_a_n32 n18_a_n32 bl_1_a_n32 8.415e-18
ccc__18_rwl_1_a_n32 n18_a_n32 rwl_1_a_n32 1.3194e-17
ccc__19__20_a_n32 n19_a_n32 n20_a_n32 1.02e-17
ccc__19_bl_2_a_n32 n19_a_n32 bl_2_a_n32 8.415e-18
ccc__19_rwl_1_a_n32 n19_a_n32 rwl_1_a_n32 1.3194e-17
ccc__20_bl_3_a_n32 n20_a_n32 bl_3_a_n32 8.415e-18
ccc__20_rwl_1_a_n32 n20_a_n32 rwl_1_a_n32 6.655e-18
ccc__22__23_a_n32 n22_a_n32 n23_a_n32 1.02e-17
ccc__22_bl_0_a_n32 n22_a_n32 bl_0_a_n32 8.415e-18
ccc__22_rwl_2_a_n32 n22_a_n32 rwl_2_a_n32 1.3194e-17
ccc__23__24_a_n32 n23_a_n32 n24_a_n32 1.02e-17
ccc__23_bl_1_a_n32 n23_a_n32 bl_1_a_n32 8.415e-18
ccc__23_rwl_2_a_n32 n23_a_n32 rwl_2_a_n32 1.3194e-17
ccc__24__25_a_n32 n24_a_n32 n25_a_n32 1.02e-17
ccc__24_bl_2_a_n32 n24_a_n32 bl_2_a_n32 8.415e-18
ccc__24_rwl_2_a_n32 n24_a_n32 rwl_2_a_n32 1.3194e-17
ccc__25_bl_3_a_n32 n25_a_n32 bl_3_a_n32 8.415e-18
ccc__25_rwl_2_a_n32 n25_a_n32 rwl_2_a_n32 6.655e-18
ccc__29__30_a_n32 n29_a_n32 n30_a_n32 1.02e-17
ccc__29_bl_0_a_n32 n29_a_n32 bl_0_a_n32 8.415e-18
ccc__29_rwl_3_a_n32 n29_a_n32 rwl_3_a_n32 1.3194e-17
ccc__30__31_a_n32 n30_a_n32 n31_a_n32 1.02e-17
ccc__30_bl_1_a_n32 n30_a_n32 bl_1_a_n32 8.415e-18
ccc__30_rwl_3_a_n32 n30_a_n32 rwl_3_a_n32 1.3194e-17
ccc__31__32_a_n32 n31_a_n32 n32_a_n32 1.02e-17
ccc__31_bl_2_a_n32 n31_a_n32 bl_2_a_n32 8.415e-18
ccc__31_rwl_3_a_n32 n31_a_n32 rwl_3_a_n32 1.3194e-17
ccc__32_bl_3_a_n32 n32_a_n32 bl_3_a_n32 8.415e-18
ccc__32_rwl_3_a_n32 n32_a_n32 rwl_3_a_n32 6.655e-18
ccc__7__8_a_n32 n7_a_n32 n8_a_n32 1.02e-17
ccc__7_bl_0_a_n32 n7_a_n32 bl_0_a_n32 1.3999e-17
ccc__7_rwl_0_a_n32 n7_a_n32 rwl_0_a_n32 8.961e-18
ccc__8__9_a_n32 n8_a_n32 n9_a_n32 1.02e-17
ccc__8_bl_1_a_n32 n8_a_n32 bl_1_a_n32 1.3999e-17
ccc__8_rwl_0_a_n32 n8_a_n32 rwl_0_a_n32 8.961e-18
ccc__9_bl_2_a_n32 n9_a_n32 bl_2_a_n32 1.3999e-17
ccc__9_rwl_0_a_n32 n9_a_n32 rwl_0_a_n32 8.961e-18
ccc_bl_0_rbl_0_a_n32 bl_0_a_n32 rbl_0_a_n32 1.88693e-16
ccc_bl_0_rwl_1_a_n32 bl_0_a_n32 rwl_1_a_n32 1.0093e-17
ccc_bl_0_rwl_2_a_n32 bl_0_a_n32 rwl_2_a_n32 1.0093e-17
ccc_bl_1_rbl_0_a_n32 bl_1_a_n32 rbl_0_a_n32 1.633e-16
ccc_bl_1_rbl_1_a_n32 bl_1_a_n32 rbl_1_a_n32 1.88693e-16
ccc_bl_1_rwl_1_a_n32 bl_1_a_n32 rwl_1_a_n32 1.0093e-17
ccc_bl_1_rwl_2_a_n32 bl_1_a_n32 rwl_2_a_n32 1.0093e-17
ccc_bl_2_rbl_1_a_n32 bl_2_a_n32 rbl_1_a_n32 1.633e-16
ccc_bl_2_rbl_2_a_n32 bl_2_a_n32 rbl_2_a_n32 1.88693e-16
ccc_bl_2_rwl_1_a_n32 bl_2_a_n32 rwl_1_a_n32 1.0093e-17
ccc_bl_2_rwl_2_a_n32 bl_2_a_n32 rwl_2_a_n32 1.0093e-17
ccc_bl_3_rbl_2_a_n32 bl_3_a_n32 rbl_2_a_n32 1.633e-16
ccc_bl_3_rbl_3_a_n32 bl_3_a_n32 rbl_3_a_n32 1.88693e-16
ccc_bl_3_rwl_1_a_n32 bl_3_a_n32 rwl_1_a_n32 1.0093e-17
ccc_bl_3_rwl_2_a_n32 bl_3_a_n32 rwl_2_a_n32 1.0093e-17
ccc_rbl_0_rbl_1_a_n32 rbl_0_a_n32 rbl_1_a_n32 3.432e-17
ccc_rbl_0_rwl_0_a_n32 rbl_0_a_n32 rwl_0_a_n32 4.9752e-17
ccc_rbl_0_rwl_1_a_n32 rbl_0_a_n32 rwl_1_a_n32 4.9752e-17
ccc_rbl_0_rwl_2_a_n32 rbl_0_a_n32 rwl_2_a_n32 4.9752e-17
ccc_rbl_0_rwl_3_a_n32 rbl_0_a_n32 rwl_3_a_n32 4.9752e-17
ccc_rbl_1_rbl_2_a_n32 rbl_1_a_n32 rbl_2_a_n32 3.432e-17
ccc_rbl_1_rwl_0_a_n32 rbl_1_a_n32 rwl_0_a_n32 4.9752e-17
ccc_rbl_1_rwl_1_a_n32 rbl_1_a_n32 rwl_1_a_n32 4.9752e-17
ccc_rbl_1_rwl_2_a_n32 rbl_1_a_n32 rwl_2_a_n32 4.9752e-17
ccc_rbl_1_rwl_3_a_n32 rbl_1_a_n32 rwl_3_a_n32 4.9752e-17
ccc_rbl_2_rbl_3_a_n32 rbl_2_a_n32 rbl_3_a_n32 3.432e-17
ccc_rbl_2_rwl_0_a_n32 rbl_2_a_n32 rwl_0_a_n32 4.9752e-17
ccc_rbl_2_rwl_1_a_n32 rbl_2_a_n32 rwl_1_a_n32 4.9752e-17
ccc_rbl_2_rwl_2_a_n32 rbl_2_a_n32 rwl_2_a_n32 4.9752e-17
ccc_rbl_2_rwl_3_a_n32 rbl_2_a_n32 rwl_3_a_n32 4.9752e-17
ccc_rbl_3_rwl_0_a_n32 rbl_3_a_n32 rwl_0_a_n32 3.3407e-17
ccc_rbl_3_rwl_1_a_n32 rbl_3_a_n32 rwl_1_a_n32 3.3407e-17
ccc_rbl_3_rwl_2_a_n32 rbl_3_a_n32 rwl_2_a_n32 3.3407e-17
ccc_rbl_3_rwl_3_a_n32 rbl_3_a_n32 rwl_3_a_n32 3.3407e-17
vdw_a_n32_0 wl_0_a_n32 0 dc 0
vdr_a_n32_0 rwl_0_a_n32 vdd dc 0
vdw_a_n32_1 wl_1_a_n32 0 dc 0
vdr_a_n32_1 rwl_1_a_n32 vdd dc 0
vdw_a_n32_2 wl_2_a_n32 0 dc 0
vdr_a_n32_2 rwl_2_a_n32 vdd dc 0
vdw_a_n32_3 wl_3_a_n32 0 dc 0
vdr_a_n32_3 rwl_3_a_n32 vdd dc 0
vdb_a_n32_0 bl_0_a_n32 0 dc 0
vdp_a_n32_0 rbl_0_a_n32 vrbl dc 0
vdb_a_n32_1 bl_1_a_n32 0 dc 0
vdp_a_n32_1 rbl_1_a_n32 vrbl dc 0
vdb_a_n32_2 bl_2_a_n32 0 dc 0
vdp_a_n32_2 rbl_2_a_n32 vrbl dc 0
vdb_a_n32_3 bl_3_a_n32 0 dc 0
vdp_a_n32_3 rbl_3_a_n32 vrbl dc 0
vdn_a_n32_n7 n7_a_n32 0 dc 1
vdn_a_n32_n8 n8_a_n32 0 dc 1
vdn_a_n32_n9 n9_a_n32 0 dc 1
vdn_a_n32_n10 n10_a_n32 0 dc 1
vdn_a_n32_n17 n17_a_n32 0 dc 1
vdn_a_n32_n18 n18_a_n32 0 dc 1
vdn_a_n32_n19 n19_a_n32 0 dc 1
vdn_a_n32_n20 n20_a_n32 0 dc 1
vdn_a_n32_n22 n22_a_n32 0 dc 1
vdn_a_n32_n23 n23_a_n32 0 dc 1
vdn_a_n32_n24 n24_a_n32 0 dc 1
vdn_a_n32_n25 n25_a_n32 0 dc 1
vdn_a_n32_n29 n29_a_n32 0 dc 1
vdn_a_n32_n30 n30_a_n32 0 dc 1
vdn_a_n32_n31 n31_a_n32 0 dc 1
bdr_a_n32 n32_a_n32 0 i=5e-08*min(1,max(0,(time-1e-09)/0.2n))*0.5*(1+tanh((v(n32_a_n32)-0.05)/0.01))

* ---- instance p_n7: variant p, probed storage node \$7 ----
xm1_p_n7 rwl_0__t2_p_n7 n7__t0_p_n7 rbl_0__t0_p_n7 gnd__t0_p_n7 sky130_fd_pr__nfet_01v8 L=0.15 W=0.42 nf=1 ad=0.1197 as=0.1197 pd=1.41 ps=1.41 mult=1 m=1
xm2_p_n7 rwl_0__t3_p_n7 n8__t1_p_n7 rbl_1__t1_p_n7 gnd__t1_p_n7 sky130_fd_pr__nfet_01v8 L=0.15 W=0.42 nf=1 ad=0.1197 as=0.1197 pd=1.41 ps=1.41 mult=1 m=1
xm3_p_n7 rwl_0__t1_p_n7 n9__t1_p_n7 rbl_2__t1_p_n7 gnd__t2_p_n7 sky130_fd_pr__nfet_01v8 L=0.15 W=0.42 nf=1 ad=0.1197 as=0.1197 pd=1.41 ps=1.41 mult=1 m=1
xm4_p_n7 rwl_0__t0_p_n7 n10__t1_p_n7 rbl_3__t1_p_n7 gnd__t3_p_n7 sky130_fd_pr__nfet_01v8 L=0.15 W=0.42 nf=1 ad=0.1197 as=0.1197 pd=1.41 ps=1.41 mult=1 m=1
xm5_p_n7 bl_0__t0_p_n7 wl_0__t0_p_n7 n7__t1_p_n7 gnd__t8_p_n7 sky130_fd_pr__nfet_01v8 L=0.15 W=0.42 nf=1 ad=0.0588 as=0.1197 pd=0.7 ps=1.41 mult=1 m=1
xm6_p_n7 n17__t0_p_n7 wl_1__t0_p_n7 bl_0__t1_p_n7 gnd__t20_p_n7 sky130_fd_pr__nfet_01v8 L=0.15 W=0.42 nf=1 ad=0.1197 as=0.0588 pd=1.41 ps=0.7 mult=1 m=1
xm7_p_n7 bl_1__t2_p_n7 wl_0__t3_p_n7 n8__t0_p_n7 gnd__t9_p_n7 sky130_fd_pr__nfet_01v8 L=0.15 W=0.42 nf=1 ad=0.0588 as=0.1197 pd=0.7 ps=1.41 mult=1 m=1
xm8_p_n7 n18__t0_p_n7 wl_1__t1_p_n7 bl_1__t0_p_n7 gnd__t21_p_n7 sky130_fd_pr__nfet_01v8 L=0.15 W=0.42 nf=1 ad=0.1197 as=0.0588 pd=1.41 ps=0.7 mult=1 m=1
xm9_p_n7 bl_2__t2_p_n7 wl_0__t2_p_n7 n9__t0_p_n7 gnd__t10_p_n7 sky130_fd_pr__nfet_01v8 L=0.15 W=0.42 nf=1 ad=0.0588 as=0.1197 pd=0.7 ps=1.41 mult=1 m=1
xm10_p_n7 n19__t0_p_n7 wl_1__t2_p_n7 bl_2__t0_p_n7 gnd__t22_p_n7 sky130_fd_pr__nfet_01v8 L=0.15 W=0.42 nf=1 ad=0.1197 as=0.0588 pd=1.41 ps=0.7 mult=1 m=1
xm11_p_n7 bl_3__t2_p_n7 wl_0__t1_p_n7 n10__t0_p_n7 gnd__t11_p_n7 sky130_fd_pr__nfet_01v8 L=0.15 W=0.42 nf=1 ad=0.0588 as=0.1197 pd=0.7 ps=1.41 mult=1 m=1
xm12_p_n7 n20__t0_p_n7 wl_1__t3_p_n7 bl_3__t1_p_n7 gnd__t23_p_n7 sky130_fd_pr__nfet_01v8 L=0.15 W=0.42 nf=1 ad=0.1197 as=0.0588 pd=1.41 ps=0.7 mult=1 m=1
xm13_p_n7 rbl_0__t3_p_n7 n17__t1_p_n7 rwl_1__t0_p_n7 gnd__t12_p_n7 sky130_fd_pr__nfet_01v8 L=0.15 W=0.42 nf=1 ad=0.0588 as=0.1197 pd=0.7 ps=1.41 mult=1 m=1
xm14_p_n7 rwl_2__t3_p_n7 n22__t0_p_n7 rbl_0__t2_p_n7 gnd__t24_p_n7 sky130_fd_pr__nfet_01v8 L=0.15 W=0.42 nf=1 ad=0.1197 as=0.0588 pd=1.41 ps=0.7 mult=1 m=1
xm15_p_n7 rbl_1__t3_p_n7 n18__t1_p_n7 rwl_1__t1_p_n7 gnd__t13_p_n7 sky130_fd_pr__nfet_01v8 L=0.15 W=0.42 nf=1 ad=0.0588 as=0.1197 pd=0.7 ps=1.41 mult=1 m=1
xm16_p_n7 rwl_2__t0_p_n7 n23__t0_p_n7 rbl_1__t2_p_n7 gnd__t25_p_n7 sky130_fd_pr__nfet_01v8 L=0.15 W=0.42 nf=1 ad=0.1197 as=0.0588 pd=1.41 ps=0.7 mult=1 m=1
xm17_p_n7 rbl_2__t3_p_n7 n19__t1_p_n7 rwl_1__t2_p_n7 gnd__t14_p_n7 sky130_fd_pr__nfet_01v8 L=0.15 W=0.42 nf=1 ad=0.0588 as=0.1197 pd=0.7 ps=1.41 mult=1 m=1
xm18_p_n7 rwl_2__t1_p_n7 n24__t0_p_n7 rbl_2__t2_p_n7 gnd__t26_p_n7 sky130_fd_pr__nfet_01v8 L=0.15 W=0.42 nf=1 ad=0.1197 as=0.0588 pd=1.41 ps=0.7 mult=1 m=1
xm19_p_n7 rbl_3__t3_p_n7 n20__t1_p_n7 rwl_1__t3_p_n7 gnd__t15_p_n7 sky130_fd_pr__nfet_01v8 L=0.15 W=0.42 nf=1 ad=0.0588 as=0.1197 pd=0.7 ps=1.41 mult=1 m=1
xm20_p_n7 rwl_2__t2_p_n7 n25__t0_p_n7 rbl_3__t2_p_n7 gnd__t27_p_n7 sky130_fd_pr__nfet_01v8 L=0.15 W=0.42 nf=1 ad=0.1197 as=0.0588 pd=1.41 ps=0.7 mult=1 m=1
xm21_p_n7 bl_0__t3_p_n7 wl_2__t0_p_n7 n22__t1_p_n7 gnd__t16_p_n7 sky130_fd_pr__nfet_01v8 L=0.15 W=0.42 nf=1 ad=0.0588 as=0.1197 pd=0.7 ps=1.41 mult=1 m=1
xm22_p_n7 n29__t0_p_n7 wl_3__t3_p_n7 bl_0__t2_p_n7 gnd__t28_p_n7 sky130_fd_pr__nfet_01v8 L=0.15 W=0.42 nf=1 ad=0.1197 as=0.0588 pd=1.41 ps=0.7 mult=1 m=1
xm23_p_n7 bl_1__t3_p_n7 wl_2__t1_p_n7 n23__t1_p_n7 gnd__t17_p_n7 sky130_fd_pr__nfet_01v8 L=0.15 W=0.42 nf=1 ad=0.0588 as=0.1197 pd=0.7 ps=1.41 mult=1 m=1
xm24_p_n7 n30__t0_p_n7 wl_3__t2_p_n7 bl_1__t1_p_n7 gnd__t29_p_n7 sky130_fd_pr__nfet_01v8 L=0.15 W=0.42 nf=1 ad=0.1197 as=0.0588 pd=1.41 ps=0.7 mult=1 m=1
xm25_p_n7 bl_2__t3_p_n7 wl_2__t2_p_n7 n24__t1_p_n7 gnd__t18_p_n7 sky130_fd_pr__nfet_01v8 L=0.15 W=0.42 nf=1 ad=0.0588 as=0.1197 pd=0.7 ps=1.41 mult=1 m=1
xm26_p_n7 n31__t0_p_n7 wl_3__t1_p_n7 bl_2__t1_p_n7 gnd__t30_p_n7 sky130_fd_pr__nfet_01v8 L=0.15 W=0.42 nf=1 ad=0.1197 as=0.0588 pd=1.41 ps=0.7 mult=1 m=1
xm27_p_n7 bl_3__t3_p_n7 wl_2__t3_p_n7 n25__t1_p_n7 gnd__t19_p_n7 sky130_fd_pr__nfet_01v8 L=0.15 W=0.42 nf=1 ad=0.0588 as=0.1197 pd=0.7 ps=1.41 mult=1 m=1
xm28_p_n7 n32__t0_p_n7 wl_3__t0_p_n7 bl_3__t0_p_n7 gnd__t31_p_n7 sky130_fd_pr__nfet_01v8 L=0.15 W=0.42 nf=1 ad=0.1197 as=0.0588 pd=1.41 ps=0.7 mult=1 m=1
xm29_p_n7 rbl_0__t1_p_n7 n29__t1_p_n7 rwl_3__t0_p_n7 gnd__t4_p_n7 sky130_fd_pr__nfet_01v8 L=0.15 W=0.42 nf=1 ad=0.1197 as=0.1197 pd=1.41 ps=1.41 mult=1 m=1
xm30_p_n7 rbl_1__t0_p_n7 n30__t1_p_n7 rwl_3__t1_p_n7 gnd__t5_p_n7 sky130_fd_pr__nfet_01v8 L=0.15 W=0.42 nf=1 ad=0.1197 as=0.1197 pd=1.41 ps=1.41 mult=1 m=1
xm31_p_n7 rbl_2__t0_p_n7 n31__t1_p_n7 rwl_3__t2_p_n7 gnd__t6_p_n7 sky130_fd_pr__nfet_01v8 L=0.15 W=0.42 nf=1 ad=0.1197 as=0.1197 pd=1.41 ps=1.41 mult=1 m=1
xm32_p_n7 rbl_3__t0_p_n7 n32__t1_p_n7 rwl_3__t3_p_n7 gnd__t7_p_n7 sky130_fd_pr__nfet_01v8 L=0.15 W=0.42 nf=1 ad=0.1197 as=0.1197 pd=1.41 ps=1.41 mult=1 m=1
r_10_t0_p_n7 n10__t0_p_n7 n10_p_n7 183.071
r_10_t1_p_n7 n10__t1_p_n7 n10_p_n7 183.071
r_17_t0_p_n7 n17__t0_p_n7 n17_p_n7 183.071
r_17_t1_p_n7 n17__t1_p_n7 n17_p_n7 183.071
r_18_t0_p_n7 n18__t0_p_n7 n18_p_n7 183.071
r_18_t1_p_n7 n18__t1_p_n7 n18_p_n7 183.071
r_19_t0_p_n7 n19__t0_p_n7 n19_p_n7 183.071
r_19_t1_p_n7 n19__t1_p_n7 n19_p_n7 183.071
r_20_t0_p_n7 n20__t0_p_n7 n20_p_n7 183.071
r_20_t1_p_n7 n20__t1_p_n7 n20_p_n7 183.071
r_22_t0_p_n7 n22__t0_p_n7 n22_p_n7 183.071
r_22_t1_p_n7 n22__t1_p_n7 n22_p_n7 183.071
r_23_t0_p_n7 n23__t0_p_n7 n23_p_n7 183.071
r_23_t1_p_n7 n23__t1_p_n7 n23_p_n7 183.071
r_24_t0_p_n7 n24__t0_p_n7 n24_p_n7 183.071
r_24_t1_p_n7 n24__t1_p_n7 n24_p_n7 183.071
r_25_t0_p_n7 n25__t0_p_n7 n25_p_n7 183.071
r_25_t1_p_n7 n25__t1_p_n7 n25_p_n7 183.071
r_29_t0_p_n7 n29__t0_p_n7 n29_p_n7 183.071
r_29_t1_p_n7 n29__t1_p_n7 n29_p_n7 183.071
r_30_t0_p_n7 n30__t0_p_n7 n30_p_n7 183.071
r_30_t1_p_n7 n30__t1_p_n7 n30_p_n7 183.071
r_31_t0_p_n7 n31__t0_p_n7 n31_p_n7 183.071
r_31_t1_p_n7 n31__t1_p_n7 n31_p_n7 183.071
r_32_t0_p_n7 n32__t0_p_n7 n32_p_n7 183.071
r_32_t1_p_n7 n32__t1_p_n7 n32_p_n7 183.071
r_7_t0_p_n7 n7__t0_p_n7 n7_p_n7 183.071
r_7_t1_p_n7 n7__t1_p_n7 n7_p_n7 183.071
r_8_t0_p_n7 n8__t0_p_n7 n8_p_n7 183.071
r_8_t1_p_n7 n8__t1_p_n7 n8_p_n7 183.071
r_9_t0_p_n7 n9__t0_p_n7 n9_p_n7 183.071
r_9_t1_p_n7 n9__t1_p_n7 n9_p_n7 183.071
rgnd_t0_p_n7 gnd__t0_p_n7 0 38.2988
rgnd_t1_p_n7 gnd__t1_p_n7 0 33.9576
rgnd_t2_p_n7 gnd__t2_p_n7 0 33.9576
rgnd_t3_p_n7 gnd__t3_p_n7 0 38.2988
rgnd_t4_p_n7 gnd__t4_p_n7 0 38.2988
rgnd_t5_p_n7 gnd__t5_p_n7 0 33.9576
rgnd_t6_p_n7 gnd__t6_p_n7 0 33.9576
rgnd_t7_p_n7 gnd__t7_p_n7 0 38.2988
rgnd_t8_p_n7 gnd__t8_p_n7 0 28.0185
rgnd_t9_p_n7 gnd__t9_p_n7 0 21.7106
rgnd_t10_p_n7 gnd__t10_p_n7 0 21.7106
rgnd_t11_p_n7 gnd__t11_p_n7 0 28.0185
rgnd_t12_p_n7 gnd__t12_p_n7 0 18.9833
rgnd_t13_p_n7 gnd__t13_p_n7 0 6.8325
rgnd_t14_p_n7 gnd__t14_p_n7 0 6.8325
rgnd_t15_p_n7 gnd__t15_p_n7 0 18.9833
rgnd_t16_p_n7 gnd__t16_p_n7 0 24.2409
rgnd_t17_p_n7 gnd__t17_p_n7 0 16.5511
rgnd_t18_p_n7 gnd__t18_p_n7 0 16.5511
rgnd_t19_p_n7 gnd__t19_p_n7 0 24.2409
rgnd_t20_p_n7 gnd__t20_p_n7 0 24.2409
rgnd_t21_p_n7 gnd__t21_p_n7 0 16.5511
rgnd_t22_p_n7 gnd__t22_p_n7 0 16.5511
rgnd_t23_p_n7 gnd__t23_p_n7 0 24.2409
rgnd_t24_p_n7 gnd__t24_p_n7 0 18.9833
rgnd_t25_p_n7 gnd__t25_p_n7 0 6.8325
rgnd_t26_p_n7 gnd__t26_p_n7 0 6.8325
rgnd_t27_p_n7 gnd__t27_p_n7 0 18.9833
rgnd_t28_p_n7 gnd__t28_p_n7 0 28.0185
rgnd_t29_p_n7 gnd__t29_p_n7 0 21.7106
rgnd_t30_p_n7 gnd__t30_p_n7 0 21.7106
rgnd_t31_p_n7 gnd__t31_p_n7 0 28.0185
rbl_0_t0_p_n7 bl_0__t0_p_n7 bl_0_p_n7 14.8304
rbl_0_t1_p_n7 bl_0__t1_p_n7 bl_0_p_n7 10.9301
rbl_0_t2_p_n7 bl_0__t2_p_n7 bl_0_p_n7 14.8304
rbl_0_t3_p_n7 bl_0__t3_p_n7 bl_0_p_n7 10.9301
rbl_1_t0_p_n7 bl_1__t0_p_n7 bl_1_p_n7 10.9301
rbl_1_t1_p_n7 bl_1__t1_p_n7 bl_1_p_n7 14.8304
rbl_1_t2_p_n7 bl_1__t2_p_n7 bl_1_p_n7 14.8304
rbl_1_t3_p_n7 bl_1__t3_p_n7 bl_1_p_n7 10.9301
rbl_2_t0_p_n7 bl_2__t0_p_n7 bl_2_p_n7 10.9301
rbl_2_t1_p_n7 bl_2__t1_p_n7 bl_2_p_n7 14.8304
rbl_2_t2_p_n7 bl_2__t2_p_n7 bl_2_p_n7 14.8304
rbl_2_t3_p_n7 bl_2__t3_p_n7 bl_2_p_n7 10.9301
rbl_3_t0_p_n7 bl_3__t0_p_n7 bl_3_p_n7 14.8304
rbl_3_t1_p_n7 bl_3__t1_p_n7 bl_3_p_n7 10.9301
rbl_3_t2_p_n7 bl_3__t2_p_n7 bl_3_p_n7 14.8304
rbl_3_t3_p_n7 bl_3__t3_p_n7 bl_3_p_n7 10.9301
rrbl_0_t0_p_n7 rbl_0__t0_p_n7 rbl_0_p_n7 36.5601
rrbl_0_t1_p_n7 rbl_0__t1_p_n7 rbl_0_p_n7 36.5601
rrbl_0_t2_p_n7 rbl_0__t2_p_n7 rbl_0_p_n7 2.99444
rrbl_0_t3_p_n7 rbl_0__t3_p_n7 rbl_0_p_n7 2.99444
rrbl_1_t0_p_n7 rbl_1__t0_p_n7 rbl_1_p_n7 36.5601
rrbl_1_t1_p_n7 rbl_1__t1_p_n7 rbl_1_p_n7 36.5601
rrbl_1_t2_p_n7 rbl_1__t2_p_n7 rbl_1_p_n7 2.99444
rrbl_1_t3_p_n7 rbl_1__t3_p_n7 rbl_1_p_n7 2.99444
rrbl_2_t0_p_n7 rbl_2__t0_p_n7 rbl_2_p_n7 36.5601
rrbl_2_t1_p_n7 rbl_2__t1_p_n7 rbl_2_p_n7 36.5601
rrbl_2_t2_p_n7 rbl_2__t2_p_n7 rbl_2_p_n7 2.99444
rrbl_2_t3_p_n7 rbl_2__t3_p_n7 rbl_2_p_n7 2.99444
rrbl_3_t0_p_n7 rbl_3__t0_p_n7 rbl_3_p_n7 36.5601
rrbl_3_t1_p_n7 rbl_3__t1_p_n7 rbl_3_p_n7 36.5601
rrbl_3_t2_p_n7 rbl_3__t2_p_n7 rbl_3_p_n7 2.99444
rrbl_3_t3_p_n7 rbl_3__t3_p_n7 rbl_3_p_n7 2.99444
rrwl_0_t0_p_n7 rwl_0__t0_p_n7 rwl_0_p_n7 38.2618
rrwl_0_t1_p_n7 rwl_0__t1_p_n7 rwl_0_p_n7 12.7539
rrwl_0_t2_p_n7 rwl_0__t2_p_n7 rwl_0_p_n7 38.2618
rrwl_0_t3_p_n7 rwl_0__t3_p_n7 rwl_0_p_n7 12.7539
rrwl_1_t0_p_n7 rwl_1__t0_p_n7 rwl_1_p_n7 38.2618
rrwl_1_t1_p_n7 rwl_1__t1_p_n7 rwl_1_p_n7 12.7539
rrwl_1_t2_p_n7 rwl_1__t2_p_n7 rwl_1_p_n7 12.7539
rrwl_1_t3_p_n7 rwl_1__t3_p_n7 rwl_1_p_n7 38.2618
rrwl_2_t0_p_n7 rwl_2__t0_p_n7 rwl_2_p_n7 12.7539
rrwl_2_t1_p_n7 rwl_2__t1_p_n7 rwl_2_p_n7 12.7539
rrwl_2_t2_p_n7 rwl_2__t2_p_n7 rwl_2_p_n7 38.2618
rrwl_2_t3_p_n7 rwl_2__t3_p_n7 rwl_2_p_n7 38.2618
rrwl_3_t0_p_n7 rwl_3__t0_p_n7 rwl_3_p_n7 38.2618
rrwl_3_t1_p_n7 rwl_3__t1_p_n7 rwl_3_p_n7 12.7539
rrwl_3_t2_p_n7 rwl_3__t2_p_n7 rwl_3_p_n7 12.7539
rrwl_3_t3_p_n7 rwl_3__t3_p_n7 rwl_3_p_n7 38.2618
rwl_0_t0_p_n7 wl_0__t0_p_n7 wl_0_p_n7 245.959
rwl_0_t1_p_n7 wl_0__t1_p_n7 wl_0_p_n7 245.959
rwl_0_t2_p_n7 wl_0__t2_p_n7 wl_0_p_n7 81.9864
rwl_0_t3_p_n7 wl_0__t3_p_n7 wl_0_p_n7 81.9864
rwl_1_t0_p_n7 wl_1__t0_p_n7 wl_1_p_n7 245.959
rwl_1_t1_p_n7 wl_1__t1_p_n7 wl_1_p_n7 81.9864
rwl_1_t2_p_n7 wl_1__t2_p_n7 wl_1_p_n7 81.9864
rwl_1_t3_p_n7 wl_1__t3_p_n7 wl_1_p_n7 245.959
rwl_2_t0_p_n7 wl_2__t0_p_n7 wl_2_p_n7 245.959
rwl_2_t1_p_n7 wl_2__t1_p_n7 wl_2_p_n7 81.9864
rwl_2_t2_p_n7 wl_2__t2_p_n7 wl_2_p_n7 81.9864
rwl_2_t3_p_n7 wl_2__t3_p_n7 wl_2_p_n7 245.959
rwl_3_t0_p_n7 wl_3__t0_p_n7 wl_3_p_n7 245.959
rwl_3_t1_p_n7 wl_3__t1_p_n7 wl_3_p_n7 81.9864
rwl_3_t2_p_n7 wl_3__t2_p_n7 wl_3_p_n7 81.9864
rwl_3_t3_p_n7 wl_3__t3_p_n7 wl_3_p_n7 245.959
c_10_p_n7 n10_p_n7 0 2.91622e-16
c_17_p_n7 n17_p_n7 0 2.91528e-16
c_18_p_n7 n18_p_n7 0 2.91528e-16
c_19_p_n7 n19_p_n7 0 2.91528e-16
c_20_p_n7 n20_p_n7 0 2.91622e-16
c_22_p_n7 n22_p_n7 0 2.91528e-16
c_23_p_n7 n23_p_n7 0 2.91528e-16
c_24_p_n7 n24_p_n7 0 2.91528e-16
c_25_p_n7 n25_p_n7 0 2.91622e-16
c_29_p_n7 n29_p_n7 0 2.91528e-16
c_30_p_n7 n30_p_n7 0 2.91528e-16
c_31_p_n7 n31_p_n7 0 2.91528e-16
c_32_p_n7 n32_p_n7 0 2.91622e-16
c_7_p_n7 n7_p_n7 0 1.1371e-16
c_8_p_n7 n8_p_n7 0 2.91528e-16
c_9_p_n7 n9_p_n7 0 2.91528e-16
cgnd_p_n7 0 0 2.48166e-15
cbl_0_p_n7 bl_0_p_n7 0 4.52661e-16
cbl_1_p_n7 bl_1_p_n7 0 4.52661e-16
cbl_2_p_n7 bl_2_p_n7 0 4.52661e-16
cbl_3_p_n7 bl_3_p_n7 0 4.52661e-16
crbl_0_p_n7 rbl_0_p_n7 0 9.14472e-16
crbl_1_p_n7 rbl_1_p_n7 0 9.14472e-16
crbl_2_p_n7 rbl_2_p_n7 0 9.14472e-16
crbl_3_p_n7 rbl_3_p_n7 0 9.17566e-16
crwl_0_p_n7 rwl_0_p_n7 0 5.19495e-16
crwl_1_p_n7 rwl_1_p_n7 0 5.11719e-16
crwl_2_p_n7 rwl_2_p_n7 0 5.11719e-16
crwl_3_p_n7 rwl_3_p_n7 0 5.19495e-16
cwl_0_p_n7 wl_0_p_n7 0 3.30388e-16
cwl_1_p_n7 wl_1_p_n7 0 3.30388e-16
cwl_2_p_n7 wl_2_p_n7 0 3.30388e-16
cwl_3_p_n7 wl_3_p_n7 0 3.30388e-16
ccc__10__9_p_n7 n10_p_n7 n9_p_n7 1.02e-17
ccc__10_bl_3_p_n7 n10_p_n7 bl_3_p_n7 1.3999e-17
ccc__10_rwl_0_p_n7 n10_p_n7 rwl_0_p_n7 4.335e-18
ccc__17__18_p_n7 n17_p_n7 n18_p_n7 1.02e-17
ccc__17_bl_0_p_n7 n17_p_n7 bl_0_p_n7 8.415e-18
ccc__17_rwl_1_p_n7 n17_p_n7 rwl_1_p_n7 1.3194e-17
ccc__18__19_p_n7 n18_p_n7 n19_p_n7 1.02e-17
ccc__18_bl_1_p_n7 n18_p_n7 bl_1_p_n7 8.415e-18
ccc__18_rwl_1_p_n7 n18_p_n7 rwl_1_p_n7 1.3194e-17
ccc__19__20_p_n7 n19_p_n7 n20_p_n7 1.02e-17
ccc__19_bl_2_p_n7 n19_p_n7 bl_2_p_n7 8.415e-18
ccc__19_rwl_1_p_n7 n19_p_n7 rwl_1_p_n7 1.3194e-17
ccc__20_bl_3_p_n7 n20_p_n7 bl_3_p_n7 8.415e-18
ccc__20_rwl_1_p_n7 n20_p_n7 rwl_1_p_n7 6.655e-18
ccc__22__23_p_n7 n22_p_n7 n23_p_n7 1.02e-17
ccc__22_bl_0_p_n7 n22_p_n7 bl_0_p_n7 8.415e-18
ccc__22_rwl_2_p_n7 n22_p_n7 rwl_2_p_n7 1.3194e-17
ccc__23__24_p_n7 n23_p_n7 n24_p_n7 1.02e-17
ccc__23_bl_1_p_n7 n23_p_n7 bl_1_p_n7 8.415e-18
ccc__23_rwl_2_p_n7 n23_p_n7 rwl_2_p_n7 1.3194e-17
ccc__24__25_p_n7 n24_p_n7 n25_p_n7 1.02e-17
ccc__24_bl_2_p_n7 n24_p_n7 bl_2_p_n7 8.415e-18
ccc__24_rwl_2_p_n7 n24_p_n7 rwl_2_p_n7 1.3194e-17
ccc__25_bl_3_p_n7 n25_p_n7 bl_3_p_n7 8.415e-18
ccc__25_rwl_2_p_n7 n25_p_n7 rwl_2_p_n7 6.655e-18
ccc__29__30_p_n7 n29_p_n7 n30_p_n7 1.02e-17
ccc__29_bl_0_p_n7 n29_p_n7 bl_0_p_n7 8.415e-18
ccc__29_rwl_3_p_n7 n29_p_n7 rwl_3_p_n7 1.3194e-17
ccc__30__31_p_n7 n30_p_n7 n31_p_n7 1.02e-17
ccc__30_bl_1_p_n7 n30_p_n7 bl_1_p_n7 8.415e-18
ccc__30_rwl_3_p_n7 n30_p_n7 rwl_3_p_n7 1.3194e-17
ccc__31__32_p_n7 n31_p_n7 n32_p_n7 1.02e-17
ccc__31_bl_2_p_n7 n31_p_n7 bl_2_p_n7 8.415e-18
ccc__31_rwl_3_p_n7 n31_p_n7 rwl_3_p_n7 1.3194e-17
ccc__32_bl_3_p_n7 n32_p_n7 bl_3_p_n7 8.415e-18
ccc__32_rwl_3_p_n7 n32_p_n7 rwl_3_p_n7 6.655e-18
ccc__7__8_p_n7 n7_p_n7 n8_p_n7 1.02e-17
ccc__7_bl_0_p_n7 n7_p_n7 bl_0_p_n7 1.3999e-17
ccc__7_rwl_0_p_n7 n7_p_n7 rwl_0_p_n7 8.961e-18
ccc__8__9_p_n7 n8_p_n7 n9_p_n7 1.02e-17
ccc__8_bl_1_p_n7 n8_p_n7 bl_1_p_n7 1.3999e-17
ccc__8_rwl_0_p_n7 n8_p_n7 rwl_0_p_n7 8.961e-18
ccc__9_bl_2_p_n7 n9_p_n7 bl_2_p_n7 1.3999e-17
ccc__9_rwl_0_p_n7 n9_p_n7 rwl_0_p_n7 8.961e-18
ccc_bl_0_rbl_0_p_n7 bl_0_p_n7 rbl_0_p_n7 1.88693e-16
ccc_bl_0_rwl_1_p_n7 bl_0_p_n7 rwl_1_p_n7 1.0093e-17
ccc_bl_0_rwl_2_p_n7 bl_0_p_n7 rwl_2_p_n7 1.0093e-17
ccc_bl_1_rbl_0_p_n7 bl_1_p_n7 rbl_0_p_n7 1.633e-16
ccc_bl_1_rbl_1_p_n7 bl_1_p_n7 rbl_1_p_n7 1.88693e-16
ccc_bl_1_rwl_1_p_n7 bl_1_p_n7 rwl_1_p_n7 1.0093e-17
ccc_bl_1_rwl_2_p_n7 bl_1_p_n7 rwl_2_p_n7 1.0093e-17
ccc_bl_2_rbl_1_p_n7 bl_2_p_n7 rbl_1_p_n7 1.633e-16
ccc_bl_2_rbl_2_p_n7 bl_2_p_n7 rbl_2_p_n7 1.88693e-16
ccc_bl_2_rwl_1_p_n7 bl_2_p_n7 rwl_1_p_n7 1.0093e-17
ccc_bl_2_rwl_2_p_n7 bl_2_p_n7 rwl_2_p_n7 1.0093e-17
ccc_bl_3_rbl_2_p_n7 bl_3_p_n7 rbl_2_p_n7 1.633e-16
ccc_bl_3_rbl_3_p_n7 bl_3_p_n7 rbl_3_p_n7 1.88693e-16
ccc_bl_3_rwl_1_p_n7 bl_3_p_n7 rwl_1_p_n7 1.0093e-17
ccc_bl_3_rwl_2_p_n7 bl_3_p_n7 rwl_2_p_n7 1.0093e-17
ccc_rbl_0_rbl_1_p_n7 rbl_0_p_n7 rbl_1_p_n7 3.432e-17
ccc_rbl_0_rwl_0_p_n7 rbl_0_p_n7 rwl_0_p_n7 4.9752e-17
ccc_rbl_0_rwl_1_p_n7 rbl_0_p_n7 rwl_1_p_n7 4.9752e-17
ccc_rbl_0_rwl_2_p_n7 rbl_0_p_n7 rwl_2_p_n7 4.9752e-17
ccc_rbl_0_rwl_3_p_n7 rbl_0_p_n7 rwl_3_p_n7 4.9752e-17
ccc_rbl_1_rbl_2_p_n7 rbl_1_p_n7 rbl_2_p_n7 3.432e-17
ccc_rbl_1_rwl_0_p_n7 rbl_1_p_n7 rwl_0_p_n7 4.9752e-17
ccc_rbl_1_rwl_1_p_n7 rbl_1_p_n7 rwl_1_p_n7 4.9752e-17
ccc_rbl_1_rwl_2_p_n7 rbl_1_p_n7 rwl_2_p_n7 4.9752e-17
ccc_rbl_1_rwl_3_p_n7 rbl_1_p_n7 rwl_3_p_n7 4.9752e-17
ccc_rbl_2_rbl_3_p_n7 rbl_2_p_n7 rbl_3_p_n7 3.432e-17
ccc_rbl_2_rwl_0_p_n7 rbl_2_p_n7 rwl_0_p_n7 4.9752e-17
ccc_rbl_2_rwl_1_p_n7 rbl_2_p_n7 rwl_1_p_n7 4.9752e-17
ccc_rbl_2_rwl_2_p_n7 rbl_2_p_n7 rwl_2_p_n7 4.9752e-17
ccc_rbl_2_rwl_3_p_n7 rbl_2_p_n7 rwl_3_p_n7 4.9752e-17
ccc_rbl_3_rwl_0_p_n7 rbl_3_p_n7 rwl_0_p_n7 3.3407e-17
ccc_rbl_3_rwl_1_p_n7 rbl_3_p_n7 rwl_1_p_n7 3.3407e-17
ccc_rbl_3_rwl_2_p_n7 rbl_3_p_n7 rwl_2_p_n7 3.3407e-17
ccc_rbl_3_rwl_3_p_n7 rbl_3_p_n7 rwl_3_p_n7 3.3407e-17
vdw_p_n7_0 wl_0_p_n7 0 dc 0
vdr_p_n7_0 rwl_0_p_n7 vdd dc 0
vdw_p_n7_1 wl_1_p_n7 0 dc 0
vdr_p_n7_1 rwl_1_p_n7 vdd dc 0
vdw_p_n7_2 wl_2_p_n7 0 dc 0
vdr_p_n7_2 rwl_2_p_n7 vdd dc 0
vdw_p_n7_3 wl_3_p_n7 0 dc 0
vdr_p_n7_3 rwl_3_p_n7 vdd dc 0
vdb_p_n7_0 bl_0_p_n7 0 dc 0
vdp_p_n7_0 rbl_0_p_n7 vrbl dc 0
vdb_p_n7_1 bl_1_p_n7 0 dc 0
vdp_p_n7_1 rbl_1_p_n7 vrbl dc 0
vdb_p_n7_2 bl_2_p_n7 0 dc 0
vdp_p_n7_2 rbl_2_p_n7 vrbl dc 0
vdb_p_n7_3 bl_3_p_n7 0 dc 0
vdp_p_n7_3 rbl_3_p_n7 vrbl dc 0
vdn_p_n7_n8 n8_p_n7 0 dc 1
vdn_p_n7_n9 n9_p_n7 0 dc 1
vdn_p_n7_n10 n10_p_n7 0 dc 1
vdn_p_n7_n17 n17_p_n7 0 dc 1
vdn_p_n7_n18 n18_p_n7 0 dc 1
vdn_p_n7_n19 n19_p_n7 0 dc 1
vdn_p_n7_n20 n20_p_n7 0 dc 1
vdn_p_n7_n22 n22_p_n7 0 dc 1
vdn_p_n7_n23 n23_p_n7 0 dc 1
vdn_p_n7_n24 n24_p_n7 0 dc 1
vdn_p_n7_n25 n25_p_n7 0 dc 1
vdn_p_n7_n29 n29_p_n7 0 dc 1
vdn_p_n7_n30 n30_p_n7 0 dc 1
vdn_p_n7_n31 n31_p_n7 0 dc 1
vdn_p_n7_n32 n32_p_n7 0 dc 1
bdr_p_n7 n7_p_n7 0 i=5e-08*min(1,max(0,(time-1e-09)/0.2n))*0.5*(1+tanh((v(n7_p_n7)-0.05)/0.01))

* ---- instance p_n8: variant p, probed storage node \$8 ----
xm1_p_n8 rwl_0__t2_p_n8 n7__t0_p_n8 rbl_0__t0_p_n8 gnd__t0_p_n8 sky130_fd_pr__nfet_01v8 L=0.15 W=0.42 nf=1 ad=0.1197 as=0.1197 pd=1.41 ps=1.41 mult=1 m=1
xm2_p_n8 rwl_0__t3_p_n8 n8__t1_p_n8 rbl_1__t1_p_n8 gnd__t1_p_n8 sky130_fd_pr__nfet_01v8 L=0.15 W=0.42 nf=1 ad=0.1197 as=0.1197 pd=1.41 ps=1.41 mult=1 m=1
xm3_p_n8 rwl_0__t1_p_n8 n9__t1_p_n8 rbl_2__t1_p_n8 gnd__t2_p_n8 sky130_fd_pr__nfet_01v8 L=0.15 W=0.42 nf=1 ad=0.1197 as=0.1197 pd=1.41 ps=1.41 mult=1 m=1
xm4_p_n8 rwl_0__t0_p_n8 n10__t1_p_n8 rbl_3__t1_p_n8 gnd__t3_p_n8 sky130_fd_pr__nfet_01v8 L=0.15 W=0.42 nf=1 ad=0.1197 as=0.1197 pd=1.41 ps=1.41 mult=1 m=1
xm5_p_n8 bl_0__t0_p_n8 wl_0__t0_p_n8 n7__t1_p_n8 gnd__t8_p_n8 sky130_fd_pr__nfet_01v8 L=0.15 W=0.42 nf=1 ad=0.0588 as=0.1197 pd=0.7 ps=1.41 mult=1 m=1
xm6_p_n8 n17__t0_p_n8 wl_1__t0_p_n8 bl_0__t1_p_n8 gnd__t20_p_n8 sky130_fd_pr__nfet_01v8 L=0.15 W=0.42 nf=1 ad=0.1197 as=0.0588 pd=1.41 ps=0.7 mult=1 m=1
xm7_p_n8 bl_1__t2_p_n8 wl_0__t3_p_n8 n8__t0_p_n8 gnd__t9_p_n8 sky130_fd_pr__nfet_01v8 L=0.15 W=0.42 nf=1 ad=0.0588 as=0.1197 pd=0.7 ps=1.41 mult=1 m=1
xm8_p_n8 n18__t0_p_n8 wl_1__t1_p_n8 bl_1__t0_p_n8 gnd__t21_p_n8 sky130_fd_pr__nfet_01v8 L=0.15 W=0.42 nf=1 ad=0.1197 as=0.0588 pd=1.41 ps=0.7 mult=1 m=1
xm9_p_n8 bl_2__t2_p_n8 wl_0__t2_p_n8 n9__t0_p_n8 gnd__t10_p_n8 sky130_fd_pr__nfet_01v8 L=0.15 W=0.42 nf=1 ad=0.0588 as=0.1197 pd=0.7 ps=1.41 mult=1 m=1
xm10_p_n8 n19__t0_p_n8 wl_1__t2_p_n8 bl_2__t0_p_n8 gnd__t22_p_n8 sky130_fd_pr__nfet_01v8 L=0.15 W=0.42 nf=1 ad=0.1197 as=0.0588 pd=1.41 ps=0.7 mult=1 m=1
xm11_p_n8 bl_3__t2_p_n8 wl_0__t1_p_n8 n10__t0_p_n8 gnd__t11_p_n8 sky130_fd_pr__nfet_01v8 L=0.15 W=0.42 nf=1 ad=0.0588 as=0.1197 pd=0.7 ps=1.41 mult=1 m=1
xm12_p_n8 n20__t0_p_n8 wl_1__t3_p_n8 bl_3__t1_p_n8 gnd__t23_p_n8 sky130_fd_pr__nfet_01v8 L=0.15 W=0.42 nf=1 ad=0.1197 as=0.0588 pd=1.41 ps=0.7 mult=1 m=1
xm13_p_n8 rbl_0__t3_p_n8 n17__t1_p_n8 rwl_1__t0_p_n8 gnd__t12_p_n8 sky130_fd_pr__nfet_01v8 L=0.15 W=0.42 nf=1 ad=0.0588 as=0.1197 pd=0.7 ps=1.41 mult=1 m=1
xm14_p_n8 rwl_2__t3_p_n8 n22__t0_p_n8 rbl_0__t2_p_n8 gnd__t24_p_n8 sky130_fd_pr__nfet_01v8 L=0.15 W=0.42 nf=1 ad=0.1197 as=0.0588 pd=1.41 ps=0.7 mult=1 m=1
xm15_p_n8 rbl_1__t3_p_n8 n18__t1_p_n8 rwl_1__t1_p_n8 gnd__t13_p_n8 sky130_fd_pr__nfet_01v8 L=0.15 W=0.42 nf=1 ad=0.0588 as=0.1197 pd=0.7 ps=1.41 mult=1 m=1
xm16_p_n8 rwl_2__t0_p_n8 n23__t0_p_n8 rbl_1__t2_p_n8 gnd__t25_p_n8 sky130_fd_pr__nfet_01v8 L=0.15 W=0.42 nf=1 ad=0.1197 as=0.0588 pd=1.41 ps=0.7 mult=1 m=1
xm17_p_n8 rbl_2__t3_p_n8 n19__t1_p_n8 rwl_1__t2_p_n8 gnd__t14_p_n8 sky130_fd_pr__nfet_01v8 L=0.15 W=0.42 nf=1 ad=0.0588 as=0.1197 pd=0.7 ps=1.41 mult=1 m=1
xm18_p_n8 rwl_2__t1_p_n8 n24__t0_p_n8 rbl_2__t2_p_n8 gnd__t26_p_n8 sky130_fd_pr__nfet_01v8 L=0.15 W=0.42 nf=1 ad=0.1197 as=0.0588 pd=1.41 ps=0.7 mult=1 m=1
xm19_p_n8 rbl_3__t3_p_n8 n20__t1_p_n8 rwl_1__t3_p_n8 gnd__t15_p_n8 sky130_fd_pr__nfet_01v8 L=0.15 W=0.42 nf=1 ad=0.0588 as=0.1197 pd=0.7 ps=1.41 mult=1 m=1
xm20_p_n8 rwl_2__t2_p_n8 n25__t0_p_n8 rbl_3__t2_p_n8 gnd__t27_p_n8 sky130_fd_pr__nfet_01v8 L=0.15 W=0.42 nf=1 ad=0.1197 as=0.0588 pd=1.41 ps=0.7 mult=1 m=1
xm21_p_n8 bl_0__t3_p_n8 wl_2__t0_p_n8 n22__t1_p_n8 gnd__t16_p_n8 sky130_fd_pr__nfet_01v8 L=0.15 W=0.42 nf=1 ad=0.0588 as=0.1197 pd=0.7 ps=1.41 mult=1 m=1
xm22_p_n8 n29__t0_p_n8 wl_3__t3_p_n8 bl_0__t2_p_n8 gnd__t28_p_n8 sky130_fd_pr__nfet_01v8 L=0.15 W=0.42 nf=1 ad=0.1197 as=0.0588 pd=1.41 ps=0.7 mult=1 m=1
xm23_p_n8 bl_1__t3_p_n8 wl_2__t1_p_n8 n23__t1_p_n8 gnd__t17_p_n8 sky130_fd_pr__nfet_01v8 L=0.15 W=0.42 nf=1 ad=0.0588 as=0.1197 pd=0.7 ps=1.41 mult=1 m=1
xm24_p_n8 n30__t0_p_n8 wl_3__t2_p_n8 bl_1__t1_p_n8 gnd__t29_p_n8 sky130_fd_pr__nfet_01v8 L=0.15 W=0.42 nf=1 ad=0.1197 as=0.0588 pd=1.41 ps=0.7 mult=1 m=1
xm25_p_n8 bl_2__t3_p_n8 wl_2__t2_p_n8 n24__t1_p_n8 gnd__t18_p_n8 sky130_fd_pr__nfet_01v8 L=0.15 W=0.42 nf=1 ad=0.0588 as=0.1197 pd=0.7 ps=1.41 mult=1 m=1
xm26_p_n8 n31__t0_p_n8 wl_3__t1_p_n8 bl_2__t1_p_n8 gnd__t30_p_n8 sky130_fd_pr__nfet_01v8 L=0.15 W=0.42 nf=1 ad=0.1197 as=0.0588 pd=1.41 ps=0.7 mult=1 m=1
xm27_p_n8 bl_3__t3_p_n8 wl_2__t3_p_n8 n25__t1_p_n8 gnd__t19_p_n8 sky130_fd_pr__nfet_01v8 L=0.15 W=0.42 nf=1 ad=0.0588 as=0.1197 pd=0.7 ps=1.41 mult=1 m=1
xm28_p_n8 n32__t0_p_n8 wl_3__t0_p_n8 bl_3__t0_p_n8 gnd__t31_p_n8 sky130_fd_pr__nfet_01v8 L=0.15 W=0.42 nf=1 ad=0.1197 as=0.0588 pd=1.41 ps=0.7 mult=1 m=1
xm29_p_n8 rbl_0__t1_p_n8 n29__t1_p_n8 rwl_3__t0_p_n8 gnd__t4_p_n8 sky130_fd_pr__nfet_01v8 L=0.15 W=0.42 nf=1 ad=0.1197 as=0.1197 pd=1.41 ps=1.41 mult=1 m=1
xm30_p_n8 rbl_1__t0_p_n8 n30__t1_p_n8 rwl_3__t1_p_n8 gnd__t5_p_n8 sky130_fd_pr__nfet_01v8 L=0.15 W=0.42 nf=1 ad=0.1197 as=0.1197 pd=1.41 ps=1.41 mult=1 m=1
xm31_p_n8 rbl_2__t0_p_n8 n31__t1_p_n8 rwl_3__t2_p_n8 gnd__t6_p_n8 sky130_fd_pr__nfet_01v8 L=0.15 W=0.42 nf=1 ad=0.1197 as=0.1197 pd=1.41 ps=1.41 mult=1 m=1
xm32_p_n8 rbl_3__t0_p_n8 n32__t1_p_n8 rwl_3__t3_p_n8 gnd__t7_p_n8 sky130_fd_pr__nfet_01v8 L=0.15 W=0.42 nf=1 ad=0.1197 as=0.1197 pd=1.41 ps=1.41 mult=1 m=1
r_10_t0_p_n8 n10__t0_p_n8 n10_p_n8 183.071
r_10_t1_p_n8 n10__t1_p_n8 n10_p_n8 183.071
r_17_t0_p_n8 n17__t0_p_n8 n17_p_n8 183.071
r_17_t1_p_n8 n17__t1_p_n8 n17_p_n8 183.071
r_18_t0_p_n8 n18__t0_p_n8 n18_p_n8 183.071
r_18_t1_p_n8 n18__t1_p_n8 n18_p_n8 183.071
r_19_t0_p_n8 n19__t0_p_n8 n19_p_n8 183.071
r_19_t1_p_n8 n19__t1_p_n8 n19_p_n8 183.071
r_20_t0_p_n8 n20__t0_p_n8 n20_p_n8 183.071
r_20_t1_p_n8 n20__t1_p_n8 n20_p_n8 183.071
r_22_t0_p_n8 n22__t0_p_n8 n22_p_n8 183.071
r_22_t1_p_n8 n22__t1_p_n8 n22_p_n8 183.071
r_23_t0_p_n8 n23__t0_p_n8 n23_p_n8 183.071
r_23_t1_p_n8 n23__t1_p_n8 n23_p_n8 183.071
r_24_t0_p_n8 n24__t0_p_n8 n24_p_n8 183.071
r_24_t1_p_n8 n24__t1_p_n8 n24_p_n8 183.071
r_25_t0_p_n8 n25__t0_p_n8 n25_p_n8 183.071
r_25_t1_p_n8 n25__t1_p_n8 n25_p_n8 183.071
r_29_t0_p_n8 n29__t0_p_n8 n29_p_n8 183.071
r_29_t1_p_n8 n29__t1_p_n8 n29_p_n8 183.071
r_30_t0_p_n8 n30__t0_p_n8 n30_p_n8 183.071
r_30_t1_p_n8 n30__t1_p_n8 n30_p_n8 183.071
r_31_t0_p_n8 n31__t0_p_n8 n31_p_n8 183.071
r_31_t1_p_n8 n31__t1_p_n8 n31_p_n8 183.071
r_32_t0_p_n8 n32__t0_p_n8 n32_p_n8 183.071
r_32_t1_p_n8 n32__t1_p_n8 n32_p_n8 183.071
r_7_t0_p_n8 n7__t0_p_n8 n7_p_n8 183.071
r_7_t1_p_n8 n7__t1_p_n8 n7_p_n8 183.071
r_8_t0_p_n8 n8__t0_p_n8 n8_p_n8 183.071
r_8_t1_p_n8 n8__t1_p_n8 n8_p_n8 183.071
r_9_t0_p_n8 n9__t0_p_n8 n9_p_n8 183.071
r_9_t1_p_n8 n9__t1_p_n8 n9_p_n8 183.071
rgnd_t0_p_n8 gnd__t0_p_n8 0 38.2988
rgnd_t1_p_n8 gnd__t1_p_n8 0 33.9576
rgnd_t2_p_n8 gnd__t2_p_n8 0 33.9576
rgnd_t3_p_n8 gnd__t3_p_n8 0 38.2988
rgnd_t4_p_n8 gnd__t4_p_n8 0 38.2988
rgnd_t5_p_n8 gnd__t5_p_n8 0 33.9576
rgnd_t6_p_n8 gnd__t6_p_n8 0 33.9576
rgnd_t7_p_n8 gnd__t7_p_n8 0 38.2988
rgnd_t8_p_n8 gnd__t8_p_n8 0 28.0185
rgnd_t9_p_n8 gnd__t9_p_n8 0 21.7106
rgnd_t10_p_n8 gnd__t10_p_n8 0 21.7106
rgnd_t11_p_n8 gnd__t11_p_n8 0 28.0185
rgnd_t12_p_n8 gnd__t12_p_n8 0 18.9833
rgnd_t13_p_n8 gnd__t13_p_n8 0 6.8325
rgnd_t14_p_n8 gnd__t14_p_n8 0 6.8325
rgnd_t15_p_n8 gnd__t15_p_n8 0 18.9833
rgnd_t16_p_n8 gnd__t16_p_n8 0 24.2409
rgnd_t17_p_n8 gnd__t17_p_n8 0 16.5511
rgnd_t18_p_n8 gnd__t18_p_n8 0 16.5511
rgnd_t19_p_n8 gnd__t19_p_n8 0 24.2409
rgnd_t20_p_n8 gnd__t20_p_n8 0 24.2409
rgnd_t21_p_n8 gnd__t21_p_n8 0 16.5511
rgnd_t22_p_n8 gnd__t22_p_n8 0 16.5511
rgnd_t23_p_n8 gnd__t23_p_n8 0 24.2409
rgnd_t24_p_n8 gnd__t24_p_n8 0 18.9833
rgnd_t25_p_n8 gnd__t25_p_n8 0 6.8325
rgnd_t26_p_n8 gnd__t26_p_n8 0 6.8325
rgnd_t27_p_n8 gnd__t27_p_n8 0 18.9833
rgnd_t28_p_n8 gnd__t28_p_n8 0 28.0185
rgnd_t29_p_n8 gnd__t29_p_n8 0 21.7106
rgnd_t30_p_n8 gnd__t30_p_n8 0 21.7106
rgnd_t31_p_n8 gnd__t31_p_n8 0 28.0185
rbl_0_t0_p_n8 bl_0__t0_p_n8 bl_0_p_n8 14.8304
rbl_0_t1_p_n8 bl_0__t1_p_n8 bl_0_p_n8 10.9301
rbl_0_t2_p_n8 bl_0__t2_p_n8 bl_0_p_n8 14.8304
rbl_0_t3_p_n8 bl_0__t3_p_n8 bl_0_p_n8 10.9301
rbl_1_t0_p_n8 bl_1__t0_p_n8 bl_1_p_n8 10.9301
rbl_1_t1_p_n8 bl_1__t1_p_n8 bl_1_p_n8 14.8304
rbl_1_t2_p_n8 bl_1__t2_p_n8 bl_1_p_n8 14.8304
rbl_1_t3_p_n8 bl_1__t3_p_n8 bl_1_p_n8 10.9301
rbl_2_t0_p_n8 bl_2__t0_p_n8 bl_2_p_n8 10.9301
rbl_2_t1_p_n8 bl_2__t1_p_n8 bl_2_p_n8 14.8304
rbl_2_t2_p_n8 bl_2__t2_p_n8 bl_2_p_n8 14.8304
rbl_2_t3_p_n8 bl_2__t3_p_n8 bl_2_p_n8 10.9301
rbl_3_t0_p_n8 bl_3__t0_p_n8 bl_3_p_n8 14.8304
rbl_3_t1_p_n8 bl_3__t1_p_n8 bl_3_p_n8 10.9301
rbl_3_t2_p_n8 bl_3__t2_p_n8 bl_3_p_n8 14.8304
rbl_3_t3_p_n8 bl_3__t3_p_n8 bl_3_p_n8 10.9301
rrbl_0_t0_p_n8 rbl_0__t0_p_n8 rbl_0_p_n8 36.5601
rrbl_0_t1_p_n8 rbl_0__t1_p_n8 rbl_0_p_n8 36.5601
rrbl_0_t2_p_n8 rbl_0__t2_p_n8 rbl_0_p_n8 2.99444
rrbl_0_t3_p_n8 rbl_0__t3_p_n8 rbl_0_p_n8 2.99444
rrbl_1_t0_p_n8 rbl_1__t0_p_n8 rbl_1_p_n8 36.5601
rrbl_1_t1_p_n8 rbl_1__t1_p_n8 rbl_1_p_n8 36.5601
rrbl_1_t2_p_n8 rbl_1__t2_p_n8 rbl_1_p_n8 2.99444
rrbl_1_t3_p_n8 rbl_1__t3_p_n8 rbl_1_p_n8 2.99444
rrbl_2_t0_p_n8 rbl_2__t0_p_n8 rbl_2_p_n8 36.5601
rrbl_2_t1_p_n8 rbl_2__t1_p_n8 rbl_2_p_n8 36.5601
rrbl_2_t2_p_n8 rbl_2__t2_p_n8 rbl_2_p_n8 2.99444
rrbl_2_t3_p_n8 rbl_2__t3_p_n8 rbl_2_p_n8 2.99444
rrbl_3_t0_p_n8 rbl_3__t0_p_n8 rbl_3_p_n8 36.5601
rrbl_3_t1_p_n8 rbl_3__t1_p_n8 rbl_3_p_n8 36.5601
rrbl_3_t2_p_n8 rbl_3__t2_p_n8 rbl_3_p_n8 2.99444
rrbl_3_t3_p_n8 rbl_3__t3_p_n8 rbl_3_p_n8 2.99444
rrwl_0_t0_p_n8 rwl_0__t0_p_n8 rwl_0_p_n8 38.2618
rrwl_0_t1_p_n8 rwl_0__t1_p_n8 rwl_0_p_n8 12.7539
rrwl_0_t2_p_n8 rwl_0__t2_p_n8 rwl_0_p_n8 38.2618
rrwl_0_t3_p_n8 rwl_0__t3_p_n8 rwl_0_p_n8 12.7539
rrwl_1_t0_p_n8 rwl_1__t0_p_n8 rwl_1_p_n8 38.2618
rrwl_1_t1_p_n8 rwl_1__t1_p_n8 rwl_1_p_n8 12.7539
rrwl_1_t2_p_n8 rwl_1__t2_p_n8 rwl_1_p_n8 12.7539
rrwl_1_t3_p_n8 rwl_1__t3_p_n8 rwl_1_p_n8 38.2618
rrwl_2_t0_p_n8 rwl_2__t0_p_n8 rwl_2_p_n8 12.7539
rrwl_2_t1_p_n8 rwl_2__t1_p_n8 rwl_2_p_n8 12.7539
rrwl_2_t2_p_n8 rwl_2__t2_p_n8 rwl_2_p_n8 38.2618
rrwl_2_t3_p_n8 rwl_2__t3_p_n8 rwl_2_p_n8 38.2618
rrwl_3_t0_p_n8 rwl_3__t0_p_n8 rwl_3_p_n8 38.2618
rrwl_3_t1_p_n8 rwl_3__t1_p_n8 rwl_3_p_n8 12.7539
rrwl_3_t2_p_n8 rwl_3__t2_p_n8 rwl_3_p_n8 12.7539
rrwl_3_t3_p_n8 rwl_3__t3_p_n8 rwl_3_p_n8 38.2618
rwl_0_t0_p_n8 wl_0__t0_p_n8 wl_0_p_n8 245.959
rwl_0_t1_p_n8 wl_0__t1_p_n8 wl_0_p_n8 245.959
rwl_0_t2_p_n8 wl_0__t2_p_n8 wl_0_p_n8 81.9864
rwl_0_t3_p_n8 wl_0__t3_p_n8 wl_0_p_n8 81.9864
rwl_1_t0_p_n8 wl_1__t0_p_n8 wl_1_p_n8 245.959
rwl_1_t1_p_n8 wl_1__t1_p_n8 wl_1_p_n8 81.9864
rwl_1_t2_p_n8 wl_1__t2_p_n8 wl_1_p_n8 81.9864
rwl_1_t3_p_n8 wl_1__t3_p_n8 wl_1_p_n8 245.959
rwl_2_t0_p_n8 wl_2__t0_p_n8 wl_2_p_n8 245.959
rwl_2_t1_p_n8 wl_2__t1_p_n8 wl_2_p_n8 81.9864
rwl_2_t2_p_n8 wl_2__t2_p_n8 wl_2_p_n8 81.9864
rwl_2_t3_p_n8 wl_2__t3_p_n8 wl_2_p_n8 245.959
rwl_3_t0_p_n8 wl_3__t0_p_n8 wl_3_p_n8 245.959
rwl_3_t1_p_n8 wl_3__t1_p_n8 wl_3_p_n8 81.9864
rwl_3_t2_p_n8 wl_3__t2_p_n8 wl_3_p_n8 81.9864
rwl_3_t3_p_n8 wl_3__t3_p_n8 wl_3_p_n8 245.959
c_10_p_n8 n10_p_n8 0 2.91622e-16
c_17_p_n8 n17_p_n8 0 2.91528e-16
c_18_p_n8 n18_p_n8 0 2.91528e-16
c_19_p_n8 n19_p_n8 0 2.91528e-16
c_20_p_n8 n20_p_n8 0 2.91622e-16
c_22_p_n8 n22_p_n8 0 2.91528e-16
c_23_p_n8 n23_p_n8 0 2.91528e-16
c_24_p_n8 n24_p_n8 0 2.91528e-16
c_25_p_n8 n25_p_n8 0 2.91622e-16
c_29_p_n8 n29_p_n8 0 2.91528e-16
c_30_p_n8 n30_p_n8 0 2.91528e-16
c_31_p_n8 n31_p_n8 0 2.91528e-16
c_32_p_n8 n32_p_n8 0 2.91622e-16
c_7_p_n8 n7_p_n8 0 2.91528e-16
c_8_p_n8 n8_p_n8 0 1.1371e-16
c_9_p_n8 n9_p_n8 0 2.91528e-16
cgnd_p_n8 0 0 2.48166e-15
cbl_0_p_n8 bl_0_p_n8 0 4.52661e-16
cbl_1_p_n8 bl_1_p_n8 0 4.52661e-16
cbl_2_p_n8 bl_2_p_n8 0 4.52661e-16
cbl_3_p_n8 bl_3_p_n8 0 4.52661e-16
crbl_0_p_n8 rbl_0_p_n8 0 9.14472e-16
crbl_1_p_n8 rbl_1_p_n8 0 9.14472e-16
crbl_2_p_n8 rbl_2_p_n8 0 9.14472e-16
crbl_3_p_n8 rbl_3_p_n8 0 9.17566e-16
crwl_0_p_n8 rwl_0_p_n8 0 5.19495e-16
crwl_1_p_n8 rwl_1_p_n8 0 5.11719e-16
crwl_2_p_n8 rwl_2_p_n8 0 5.11719e-16
crwl_3_p_n8 rwl_3_p_n8 0 5.19495e-16
cwl_0_p_n8 wl_0_p_n8 0 3.30388e-16
cwl_1_p_n8 wl_1_p_n8 0 3.30388e-16
cwl_2_p_n8 wl_2_p_n8 0 3.30388e-16
cwl_3_p_n8 wl_3_p_n8 0 3.30388e-16
ccc__10__9_p_n8 n10_p_n8 n9_p_n8 1.02e-17
ccc__10_bl_3_p_n8 n10_p_n8 bl_3_p_n8 1.3999e-17
ccc__10_rwl_0_p_n8 n10_p_n8 rwl_0_p_n8 4.335e-18
ccc__17__18_p_n8 n17_p_n8 n18_p_n8 1.02e-17
ccc__17_bl_0_p_n8 n17_p_n8 bl_0_p_n8 8.415e-18
ccc__17_rwl_1_p_n8 n17_p_n8 rwl_1_p_n8 1.3194e-17
ccc__18__19_p_n8 n18_p_n8 n19_p_n8 1.02e-17
ccc__18_bl_1_p_n8 n18_p_n8 bl_1_p_n8 8.415e-18
ccc__18_rwl_1_p_n8 n18_p_n8 rwl_1_p_n8 1.3194e-17
ccc__19__20_p_n8 n19_p_n8 n20_p_n8 1.02e-17
ccc__19_bl_2_p_n8 n19_p_n8 bl_2_p_n8 8.415e-18
ccc__19_rwl_1_p_n8 n19_p_n8 rwl_1_p_n8 1.3194e-17
ccc__20_bl_3_p_n8 n20_p_n8 bl_3_p_n8 8.415e-18
ccc__20_rwl_1_p_n8 n20_p_n8 rwl_1_p_n8 6.655e-18
ccc__22__23_p_n8 n22_p_n8 n23_p_n8 1.02e-17
ccc__22_bl_0_p_n8 n22_p_n8 bl_0_p_n8 8.415e-18
ccc__22_rwl_2_p_n8 n22_p_n8 rwl_2_p_n8 1.3194e-17
ccc__23__24_p_n8 n23_p_n8 n24_p_n8 1.02e-17
ccc__23_bl_1_p_n8 n23_p_n8 bl_1_p_n8 8.415e-18
ccc__23_rwl_2_p_n8 n23_p_n8 rwl_2_p_n8 1.3194e-17
ccc__24__25_p_n8 n24_p_n8 n25_p_n8 1.02e-17
ccc__24_bl_2_p_n8 n24_p_n8 bl_2_p_n8 8.415e-18
ccc__24_rwl_2_p_n8 n24_p_n8 rwl_2_p_n8 1.3194e-17
ccc__25_bl_3_p_n8 n25_p_n8 bl_3_p_n8 8.415e-18
ccc__25_rwl_2_p_n8 n25_p_n8 rwl_2_p_n8 6.655e-18
ccc__29__30_p_n8 n29_p_n8 n30_p_n8 1.02e-17
ccc__29_bl_0_p_n8 n29_p_n8 bl_0_p_n8 8.415e-18
ccc__29_rwl_3_p_n8 n29_p_n8 rwl_3_p_n8 1.3194e-17
ccc__30__31_p_n8 n30_p_n8 n31_p_n8 1.02e-17
ccc__30_bl_1_p_n8 n30_p_n8 bl_1_p_n8 8.415e-18
ccc__30_rwl_3_p_n8 n30_p_n8 rwl_3_p_n8 1.3194e-17
ccc__31__32_p_n8 n31_p_n8 n32_p_n8 1.02e-17
ccc__31_bl_2_p_n8 n31_p_n8 bl_2_p_n8 8.415e-18
ccc__31_rwl_3_p_n8 n31_p_n8 rwl_3_p_n8 1.3194e-17
ccc__32_bl_3_p_n8 n32_p_n8 bl_3_p_n8 8.415e-18
ccc__32_rwl_3_p_n8 n32_p_n8 rwl_3_p_n8 6.655e-18
ccc__7__8_p_n8 n7_p_n8 n8_p_n8 1.02e-17
ccc__7_bl_0_p_n8 n7_p_n8 bl_0_p_n8 1.3999e-17
ccc__7_rwl_0_p_n8 n7_p_n8 rwl_0_p_n8 8.961e-18
ccc__8__9_p_n8 n8_p_n8 n9_p_n8 1.02e-17
ccc__8_bl_1_p_n8 n8_p_n8 bl_1_p_n8 1.3999e-17
ccc__8_rwl_0_p_n8 n8_p_n8 rwl_0_p_n8 8.961e-18
ccc__9_bl_2_p_n8 n9_p_n8 bl_2_p_n8 1.3999e-17
ccc__9_rwl_0_p_n8 n9_p_n8 rwl_0_p_n8 8.961e-18
ccc_bl_0_rbl_0_p_n8 bl_0_p_n8 rbl_0_p_n8 1.88693e-16
ccc_bl_0_rwl_1_p_n8 bl_0_p_n8 rwl_1_p_n8 1.0093e-17
ccc_bl_0_rwl_2_p_n8 bl_0_p_n8 rwl_2_p_n8 1.0093e-17
ccc_bl_1_rbl_0_p_n8 bl_1_p_n8 rbl_0_p_n8 1.633e-16
ccc_bl_1_rbl_1_p_n8 bl_1_p_n8 rbl_1_p_n8 1.88693e-16
ccc_bl_1_rwl_1_p_n8 bl_1_p_n8 rwl_1_p_n8 1.0093e-17
ccc_bl_1_rwl_2_p_n8 bl_1_p_n8 rwl_2_p_n8 1.0093e-17
ccc_bl_2_rbl_1_p_n8 bl_2_p_n8 rbl_1_p_n8 1.633e-16
ccc_bl_2_rbl_2_p_n8 bl_2_p_n8 rbl_2_p_n8 1.88693e-16
ccc_bl_2_rwl_1_p_n8 bl_2_p_n8 rwl_1_p_n8 1.0093e-17
ccc_bl_2_rwl_2_p_n8 bl_2_p_n8 rwl_2_p_n8 1.0093e-17
ccc_bl_3_rbl_2_p_n8 bl_3_p_n8 rbl_2_p_n8 1.633e-16
ccc_bl_3_rbl_3_p_n8 bl_3_p_n8 rbl_3_p_n8 1.88693e-16
ccc_bl_3_rwl_1_p_n8 bl_3_p_n8 rwl_1_p_n8 1.0093e-17
ccc_bl_3_rwl_2_p_n8 bl_3_p_n8 rwl_2_p_n8 1.0093e-17
ccc_rbl_0_rbl_1_p_n8 rbl_0_p_n8 rbl_1_p_n8 3.432e-17
ccc_rbl_0_rwl_0_p_n8 rbl_0_p_n8 rwl_0_p_n8 4.9752e-17
ccc_rbl_0_rwl_1_p_n8 rbl_0_p_n8 rwl_1_p_n8 4.9752e-17
ccc_rbl_0_rwl_2_p_n8 rbl_0_p_n8 rwl_2_p_n8 4.9752e-17
ccc_rbl_0_rwl_3_p_n8 rbl_0_p_n8 rwl_3_p_n8 4.9752e-17
ccc_rbl_1_rbl_2_p_n8 rbl_1_p_n8 rbl_2_p_n8 3.432e-17
ccc_rbl_1_rwl_0_p_n8 rbl_1_p_n8 rwl_0_p_n8 4.9752e-17
ccc_rbl_1_rwl_1_p_n8 rbl_1_p_n8 rwl_1_p_n8 4.9752e-17
ccc_rbl_1_rwl_2_p_n8 rbl_1_p_n8 rwl_2_p_n8 4.9752e-17
ccc_rbl_1_rwl_3_p_n8 rbl_1_p_n8 rwl_3_p_n8 4.9752e-17
ccc_rbl_2_rbl_3_p_n8 rbl_2_p_n8 rbl_3_p_n8 3.432e-17
ccc_rbl_2_rwl_0_p_n8 rbl_2_p_n8 rwl_0_p_n8 4.9752e-17
ccc_rbl_2_rwl_1_p_n8 rbl_2_p_n8 rwl_1_p_n8 4.9752e-17
ccc_rbl_2_rwl_2_p_n8 rbl_2_p_n8 rwl_2_p_n8 4.9752e-17
ccc_rbl_2_rwl_3_p_n8 rbl_2_p_n8 rwl_3_p_n8 4.9752e-17
ccc_rbl_3_rwl_0_p_n8 rbl_3_p_n8 rwl_0_p_n8 3.3407e-17
ccc_rbl_3_rwl_1_p_n8 rbl_3_p_n8 rwl_1_p_n8 3.3407e-17
ccc_rbl_3_rwl_2_p_n8 rbl_3_p_n8 rwl_2_p_n8 3.3407e-17
ccc_rbl_3_rwl_3_p_n8 rbl_3_p_n8 rwl_3_p_n8 3.3407e-17
vdw_p_n8_0 wl_0_p_n8 0 dc 0
vdr_p_n8_0 rwl_0_p_n8 vdd dc 0
vdw_p_n8_1 wl_1_p_n8 0 dc 0
vdr_p_n8_1 rwl_1_p_n8 vdd dc 0
vdw_p_n8_2 wl_2_p_n8 0 dc 0
vdr_p_n8_2 rwl_2_p_n8 vdd dc 0
vdw_p_n8_3 wl_3_p_n8 0 dc 0
vdr_p_n8_3 rwl_3_p_n8 vdd dc 0
vdb_p_n8_0 bl_0_p_n8 0 dc 0
vdp_p_n8_0 rbl_0_p_n8 vrbl dc 0
vdb_p_n8_1 bl_1_p_n8 0 dc 0
vdp_p_n8_1 rbl_1_p_n8 vrbl dc 0
vdb_p_n8_2 bl_2_p_n8 0 dc 0
vdp_p_n8_2 rbl_2_p_n8 vrbl dc 0
vdb_p_n8_3 bl_3_p_n8 0 dc 0
vdp_p_n8_3 rbl_3_p_n8 vrbl dc 0
vdn_p_n8_n7 n7_p_n8 0 dc 1
vdn_p_n8_n9 n9_p_n8 0 dc 1
vdn_p_n8_n10 n10_p_n8 0 dc 1
vdn_p_n8_n17 n17_p_n8 0 dc 1
vdn_p_n8_n18 n18_p_n8 0 dc 1
vdn_p_n8_n19 n19_p_n8 0 dc 1
vdn_p_n8_n20 n20_p_n8 0 dc 1
vdn_p_n8_n22 n22_p_n8 0 dc 1
vdn_p_n8_n23 n23_p_n8 0 dc 1
vdn_p_n8_n24 n24_p_n8 0 dc 1
vdn_p_n8_n25 n25_p_n8 0 dc 1
vdn_p_n8_n29 n29_p_n8 0 dc 1
vdn_p_n8_n30 n30_p_n8 0 dc 1
vdn_p_n8_n31 n31_p_n8 0 dc 1
vdn_p_n8_n32 n32_p_n8 0 dc 1
bdr_p_n8 n8_p_n8 0 i=5e-08*min(1,max(0,(time-1e-09)/0.2n))*0.5*(1+tanh((v(n8_p_n8)-0.05)/0.01))

* ---- instance p_n9: variant p, probed storage node \$9 ----
xm1_p_n9 rwl_0__t2_p_n9 n7__t0_p_n9 rbl_0__t0_p_n9 gnd__t0_p_n9 sky130_fd_pr__nfet_01v8 L=0.15 W=0.42 nf=1 ad=0.1197 as=0.1197 pd=1.41 ps=1.41 mult=1 m=1
xm2_p_n9 rwl_0__t3_p_n9 n8__t1_p_n9 rbl_1__t1_p_n9 gnd__t1_p_n9 sky130_fd_pr__nfet_01v8 L=0.15 W=0.42 nf=1 ad=0.1197 as=0.1197 pd=1.41 ps=1.41 mult=1 m=1
xm3_p_n9 rwl_0__t1_p_n9 n9__t1_p_n9 rbl_2__t1_p_n9 gnd__t2_p_n9 sky130_fd_pr__nfet_01v8 L=0.15 W=0.42 nf=1 ad=0.1197 as=0.1197 pd=1.41 ps=1.41 mult=1 m=1
xm4_p_n9 rwl_0__t0_p_n9 n10__t1_p_n9 rbl_3__t1_p_n9 gnd__t3_p_n9 sky130_fd_pr__nfet_01v8 L=0.15 W=0.42 nf=1 ad=0.1197 as=0.1197 pd=1.41 ps=1.41 mult=1 m=1
xm5_p_n9 bl_0__t0_p_n9 wl_0__t0_p_n9 n7__t1_p_n9 gnd__t8_p_n9 sky130_fd_pr__nfet_01v8 L=0.15 W=0.42 nf=1 ad=0.0588 as=0.1197 pd=0.7 ps=1.41 mult=1 m=1
xm6_p_n9 n17__t0_p_n9 wl_1__t0_p_n9 bl_0__t1_p_n9 gnd__t20_p_n9 sky130_fd_pr__nfet_01v8 L=0.15 W=0.42 nf=1 ad=0.1197 as=0.0588 pd=1.41 ps=0.7 mult=1 m=1
xm7_p_n9 bl_1__t2_p_n9 wl_0__t3_p_n9 n8__t0_p_n9 gnd__t9_p_n9 sky130_fd_pr__nfet_01v8 L=0.15 W=0.42 nf=1 ad=0.0588 as=0.1197 pd=0.7 ps=1.41 mult=1 m=1
xm8_p_n9 n18__t0_p_n9 wl_1__t1_p_n9 bl_1__t0_p_n9 gnd__t21_p_n9 sky130_fd_pr__nfet_01v8 L=0.15 W=0.42 nf=1 ad=0.1197 as=0.0588 pd=1.41 ps=0.7 mult=1 m=1
xm9_p_n9 bl_2__t2_p_n9 wl_0__t2_p_n9 n9__t0_p_n9 gnd__t10_p_n9 sky130_fd_pr__nfet_01v8 L=0.15 W=0.42 nf=1 ad=0.0588 as=0.1197 pd=0.7 ps=1.41 mult=1 m=1
xm10_p_n9 n19__t0_p_n9 wl_1__t2_p_n9 bl_2__t0_p_n9 gnd__t22_p_n9 sky130_fd_pr__nfet_01v8 L=0.15 W=0.42 nf=1 ad=0.1197 as=0.0588 pd=1.41 ps=0.7 mult=1 m=1
xm11_p_n9 bl_3__t2_p_n9 wl_0__t1_p_n9 n10__t0_p_n9 gnd__t11_p_n9 sky130_fd_pr__nfet_01v8 L=0.15 W=0.42 nf=1 ad=0.0588 as=0.1197 pd=0.7 ps=1.41 mult=1 m=1
xm12_p_n9 n20__t0_p_n9 wl_1__t3_p_n9 bl_3__t1_p_n9 gnd__t23_p_n9 sky130_fd_pr__nfet_01v8 L=0.15 W=0.42 nf=1 ad=0.1197 as=0.0588 pd=1.41 ps=0.7 mult=1 m=1
xm13_p_n9 rbl_0__t3_p_n9 n17__t1_p_n9 rwl_1__t0_p_n9 gnd__t12_p_n9 sky130_fd_pr__nfet_01v8 L=0.15 W=0.42 nf=1 ad=0.0588 as=0.1197 pd=0.7 ps=1.41 mult=1 m=1
xm14_p_n9 rwl_2__t3_p_n9 n22__t0_p_n9 rbl_0__t2_p_n9 gnd__t24_p_n9 sky130_fd_pr__nfet_01v8 L=0.15 W=0.42 nf=1 ad=0.1197 as=0.0588 pd=1.41 ps=0.7 mult=1 m=1
xm15_p_n9 rbl_1__t3_p_n9 n18__t1_p_n9 rwl_1__t1_p_n9 gnd__t13_p_n9 sky130_fd_pr__nfet_01v8 L=0.15 W=0.42 nf=1 ad=0.0588 as=0.1197 pd=0.7 ps=1.41 mult=1 m=1
xm16_p_n9 rwl_2__t0_p_n9 n23__t0_p_n9 rbl_1__t2_p_n9 gnd__t25_p_n9 sky130_fd_pr__nfet_01v8 L=0.15 W=0.42 nf=1 ad=0.1197 as=0.0588 pd=1.41 ps=0.7 mult=1 m=1
xm17_p_n9 rbl_2__t3_p_n9 n19__t1_p_n9 rwl_1__t2_p_n9 gnd__t14_p_n9 sky130_fd_pr__nfet_01v8 L=0.15 W=0.42 nf=1 ad=0.0588 as=0.1197 pd=0.7 ps=1.41 mult=1 m=1
xm18_p_n9 rwl_2__t1_p_n9 n24__t0_p_n9 rbl_2__t2_p_n9 gnd__t26_p_n9 sky130_fd_pr__nfet_01v8 L=0.15 W=0.42 nf=1 ad=0.1197 as=0.0588 pd=1.41 ps=0.7 mult=1 m=1
xm19_p_n9 rbl_3__t3_p_n9 n20__t1_p_n9 rwl_1__t3_p_n9 gnd__t15_p_n9 sky130_fd_pr__nfet_01v8 L=0.15 W=0.42 nf=1 ad=0.0588 as=0.1197 pd=0.7 ps=1.41 mult=1 m=1
xm20_p_n9 rwl_2__t2_p_n9 n25__t0_p_n9 rbl_3__t2_p_n9 gnd__t27_p_n9 sky130_fd_pr__nfet_01v8 L=0.15 W=0.42 nf=1 ad=0.1197 as=0.0588 pd=1.41 ps=0.7 mult=1 m=1
xm21_p_n9 bl_0__t3_p_n9 wl_2__t0_p_n9 n22__t1_p_n9 gnd__t16_p_n9 sky130_fd_pr__nfet_01v8 L=0.15 W=0.42 nf=1 ad=0.0588 as=0.1197 pd=0.7 ps=1.41 mult=1 m=1
xm22_p_n9 n29__t0_p_n9 wl_3__t3_p_n9 bl_0__t2_p_n9 gnd__t28_p_n9 sky130_fd_pr__nfet_01v8 L=0.15 W=0.42 nf=1 ad=0.1197 as=0.0588 pd=1.41 ps=0.7 mult=1 m=1
xm23_p_n9 bl_1__t3_p_n9 wl_2__t1_p_n9 n23__t1_p_n9 gnd__t17_p_n9 sky130_fd_pr__nfet_01v8 L=0.15 W=0.42 nf=1 ad=0.0588 as=0.1197 pd=0.7 ps=1.41 mult=1 m=1
xm24_p_n9 n30__t0_p_n9 wl_3__t2_p_n9 bl_1__t1_p_n9 gnd__t29_p_n9 sky130_fd_pr__nfet_01v8 L=0.15 W=0.42 nf=1 ad=0.1197 as=0.0588 pd=1.41 ps=0.7 mult=1 m=1
xm25_p_n9 bl_2__t3_p_n9 wl_2__t2_p_n9 n24__t1_p_n9 gnd__t18_p_n9 sky130_fd_pr__nfet_01v8 L=0.15 W=0.42 nf=1 ad=0.0588 as=0.1197 pd=0.7 ps=1.41 mult=1 m=1
xm26_p_n9 n31__t0_p_n9 wl_3__t1_p_n9 bl_2__t1_p_n9 gnd__t30_p_n9 sky130_fd_pr__nfet_01v8 L=0.15 W=0.42 nf=1 ad=0.1197 as=0.0588 pd=1.41 ps=0.7 mult=1 m=1
xm27_p_n9 bl_3__t3_p_n9 wl_2__t3_p_n9 n25__t1_p_n9 gnd__t19_p_n9 sky130_fd_pr__nfet_01v8 L=0.15 W=0.42 nf=1 ad=0.0588 as=0.1197 pd=0.7 ps=1.41 mult=1 m=1
xm28_p_n9 n32__t0_p_n9 wl_3__t0_p_n9 bl_3__t0_p_n9 gnd__t31_p_n9 sky130_fd_pr__nfet_01v8 L=0.15 W=0.42 nf=1 ad=0.1197 as=0.0588 pd=1.41 ps=0.7 mult=1 m=1
xm29_p_n9 rbl_0__t1_p_n9 n29__t1_p_n9 rwl_3__t0_p_n9 gnd__t4_p_n9 sky130_fd_pr__nfet_01v8 L=0.15 W=0.42 nf=1 ad=0.1197 as=0.1197 pd=1.41 ps=1.41 mult=1 m=1
xm30_p_n9 rbl_1__t0_p_n9 n30__t1_p_n9 rwl_3__t1_p_n9 gnd__t5_p_n9 sky130_fd_pr__nfet_01v8 L=0.15 W=0.42 nf=1 ad=0.1197 as=0.1197 pd=1.41 ps=1.41 mult=1 m=1
xm31_p_n9 rbl_2__t0_p_n9 n31__t1_p_n9 rwl_3__t2_p_n9 gnd__t6_p_n9 sky130_fd_pr__nfet_01v8 L=0.15 W=0.42 nf=1 ad=0.1197 as=0.1197 pd=1.41 ps=1.41 mult=1 m=1
xm32_p_n9 rbl_3__t0_p_n9 n32__t1_p_n9 rwl_3__t3_p_n9 gnd__t7_p_n9 sky130_fd_pr__nfet_01v8 L=0.15 W=0.42 nf=1 ad=0.1197 as=0.1197 pd=1.41 ps=1.41 mult=1 m=1
r_10_t0_p_n9 n10__t0_p_n9 n10_p_n9 183.071
r_10_t1_p_n9 n10__t1_p_n9 n10_p_n9 183.071
r_17_t0_p_n9 n17__t0_p_n9 n17_p_n9 183.071
r_17_t1_p_n9 n17__t1_p_n9 n17_p_n9 183.071
r_18_t0_p_n9 n18__t0_p_n9 n18_p_n9 183.071
r_18_t1_p_n9 n18__t1_p_n9 n18_p_n9 183.071
r_19_t0_p_n9 n19__t0_p_n9 n19_p_n9 183.071
r_19_t1_p_n9 n19__t1_p_n9 n19_p_n9 183.071
r_20_t0_p_n9 n20__t0_p_n9 n20_p_n9 183.071
r_20_t1_p_n9 n20__t1_p_n9 n20_p_n9 183.071
r_22_t0_p_n9 n22__t0_p_n9 n22_p_n9 183.071
r_22_t1_p_n9 n22__t1_p_n9 n22_p_n9 183.071
r_23_t0_p_n9 n23__t0_p_n9 n23_p_n9 183.071
r_23_t1_p_n9 n23__t1_p_n9 n23_p_n9 183.071
r_24_t0_p_n9 n24__t0_p_n9 n24_p_n9 183.071
r_24_t1_p_n9 n24__t1_p_n9 n24_p_n9 183.071
r_25_t0_p_n9 n25__t0_p_n9 n25_p_n9 183.071
r_25_t1_p_n9 n25__t1_p_n9 n25_p_n9 183.071
r_29_t0_p_n9 n29__t0_p_n9 n29_p_n9 183.071
r_29_t1_p_n9 n29__t1_p_n9 n29_p_n9 183.071
r_30_t0_p_n9 n30__t0_p_n9 n30_p_n9 183.071
r_30_t1_p_n9 n30__t1_p_n9 n30_p_n9 183.071
r_31_t0_p_n9 n31__t0_p_n9 n31_p_n9 183.071
r_31_t1_p_n9 n31__t1_p_n9 n31_p_n9 183.071
r_32_t0_p_n9 n32__t0_p_n9 n32_p_n9 183.071
r_32_t1_p_n9 n32__t1_p_n9 n32_p_n9 183.071
r_7_t0_p_n9 n7__t0_p_n9 n7_p_n9 183.071
r_7_t1_p_n9 n7__t1_p_n9 n7_p_n9 183.071
r_8_t0_p_n9 n8__t0_p_n9 n8_p_n9 183.071
r_8_t1_p_n9 n8__t1_p_n9 n8_p_n9 183.071
r_9_t0_p_n9 n9__t0_p_n9 n9_p_n9 183.071
r_9_t1_p_n9 n9__t1_p_n9 n9_p_n9 183.071
rgnd_t0_p_n9 gnd__t0_p_n9 0 38.2988
rgnd_t1_p_n9 gnd__t1_p_n9 0 33.9576
rgnd_t2_p_n9 gnd__t2_p_n9 0 33.9576
rgnd_t3_p_n9 gnd__t3_p_n9 0 38.2988
rgnd_t4_p_n9 gnd__t4_p_n9 0 38.2988
rgnd_t5_p_n9 gnd__t5_p_n9 0 33.9576
rgnd_t6_p_n9 gnd__t6_p_n9 0 33.9576
rgnd_t7_p_n9 gnd__t7_p_n9 0 38.2988
rgnd_t8_p_n9 gnd__t8_p_n9 0 28.0185
rgnd_t9_p_n9 gnd__t9_p_n9 0 21.7106
rgnd_t10_p_n9 gnd__t10_p_n9 0 21.7106
rgnd_t11_p_n9 gnd__t11_p_n9 0 28.0185
rgnd_t12_p_n9 gnd__t12_p_n9 0 18.9833
rgnd_t13_p_n9 gnd__t13_p_n9 0 6.8325
rgnd_t14_p_n9 gnd__t14_p_n9 0 6.8325
rgnd_t15_p_n9 gnd__t15_p_n9 0 18.9833
rgnd_t16_p_n9 gnd__t16_p_n9 0 24.2409
rgnd_t17_p_n9 gnd__t17_p_n9 0 16.5511
rgnd_t18_p_n9 gnd__t18_p_n9 0 16.5511
rgnd_t19_p_n9 gnd__t19_p_n9 0 24.2409
rgnd_t20_p_n9 gnd__t20_p_n9 0 24.2409
rgnd_t21_p_n9 gnd__t21_p_n9 0 16.5511
rgnd_t22_p_n9 gnd__t22_p_n9 0 16.5511
rgnd_t23_p_n9 gnd__t23_p_n9 0 24.2409
rgnd_t24_p_n9 gnd__t24_p_n9 0 18.9833
rgnd_t25_p_n9 gnd__t25_p_n9 0 6.8325
rgnd_t26_p_n9 gnd__t26_p_n9 0 6.8325
rgnd_t27_p_n9 gnd__t27_p_n9 0 18.9833
rgnd_t28_p_n9 gnd__t28_p_n9 0 28.0185
rgnd_t29_p_n9 gnd__t29_p_n9 0 21.7106
rgnd_t30_p_n9 gnd__t30_p_n9 0 21.7106
rgnd_t31_p_n9 gnd__t31_p_n9 0 28.0185
rbl_0_t0_p_n9 bl_0__t0_p_n9 bl_0_p_n9 14.8304
rbl_0_t1_p_n9 bl_0__t1_p_n9 bl_0_p_n9 10.9301
rbl_0_t2_p_n9 bl_0__t2_p_n9 bl_0_p_n9 14.8304
rbl_0_t3_p_n9 bl_0__t3_p_n9 bl_0_p_n9 10.9301
rbl_1_t0_p_n9 bl_1__t0_p_n9 bl_1_p_n9 10.9301
rbl_1_t1_p_n9 bl_1__t1_p_n9 bl_1_p_n9 14.8304
rbl_1_t2_p_n9 bl_1__t2_p_n9 bl_1_p_n9 14.8304
rbl_1_t3_p_n9 bl_1__t3_p_n9 bl_1_p_n9 10.9301
rbl_2_t0_p_n9 bl_2__t0_p_n9 bl_2_p_n9 10.9301
rbl_2_t1_p_n9 bl_2__t1_p_n9 bl_2_p_n9 14.8304
rbl_2_t2_p_n9 bl_2__t2_p_n9 bl_2_p_n9 14.8304
rbl_2_t3_p_n9 bl_2__t3_p_n9 bl_2_p_n9 10.9301
rbl_3_t0_p_n9 bl_3__t0_p_n9 bl_3_p_n9 14.8304
rbl_3_t1_p_n9 bl_3__t1_p_n9 bl_3_p_n9 10.9301
rbl_3_t2_p_n9 bl_3__t2_p_n9 bl_3_p_n9 14.8304
rbl_3_t3_p_n9 bl_3__t3_p_n9 bl_3_p_n9 10.9301
rrbl_0_t0_p_n9 rbl_0__t0_p_n9 rbl_0_p_n9 36.5601
rrbl_0_t1_p_n9 rbl_0__t1_p_n9 rbl_0_p_n9 36.5601
rrbl_0_t2_p_n9 rbl_0__t2_p_n9 rbl_0_p_n9 2.99444
rrbl_0_t3_p_n9 rbl_0__t3_p_n9 rbl_0_p_n9 2.99444
rrbl_1_t0_p_n9 rbl_1__t0_p_n9 rbl_1_p_n9 36.5601
rrbl_1_t1_p_n9 rbl_1__t1_p_n9 rbl_1_p_n9 36.5601
rrbl_1_t2_p_n9 rbl_1__t2_p_n9 rbl_1_p_n9 2.99444
rrbl_1_t3_p_n9 rbl_1__t3_p_n9 rbl_1_p_n9 2.99444
rrbl_2_t0_p_n9 rbl_2__t0_p_n9 rbl_2_p_n9 36.5601
rrbl_2_t1_p_n9 rbl_2__t1_p_n9 rbl_2_p_n9 36.5601
rrbl_2_t2_p_n9 rbl_2__t2_p_n9 rbl_2_p_n9 2.99444
rrbl_2_t3_p_n9 rbl_2__t3_p_n9 rbl_2_p_n9 2.99444
rrbl_3_t0_p_n9 rbl_3__t0_p_n9 rbl_3_p_n9 36.5601
rrbl_3_t1_p_n9 rbl_3__t1_p_n9 rbl_3_p_n9 36.5601
rrbl_3_t2_p_n9 rbl_3__t2_p_n9 rbl_3_p_n9 2.99444
rrbl_3_t3_p_n9 rbl_3__t3_p_n9 rbl_3_p_n9 2.99444
rrwl_0_t0_p_n9 rwl_0__t0_p_n9 rwl_0_p_n9 38.2618
rrwl_0_t1_p_n9 rwl_0__t1_p_n9 rwl_0_p_n9 12.7539
rrwl_0_t2_p_n9 rwl_0__t2_p_n9 rwl_0_p_n9 38.2618
rrwl_0_t3_p_n9 rwl_0__t3_p_n9 rwl_0_p_n9 12.7539
rrwl_1_t0_p_n9 rwl_1__t0_p_n9 rwl_1_p_n9 38.2618
rrwl_1_t1_p_n9 rwl_1__t1_p_n9 rwl_1_p_n9 12.7539
rrwl_1_t2_p_n9 rwl_1__t2_p_n9 rwl_1_p_n9 12.7539
rrwl_1_t3_p_n9 rwl_1__t3_p_n9 rwl_1_p_n9 38.2618
rrwl_2_t0_p_n9 rwl_2__t0_p_n9 rwl_2_p_n9 12.7539
rrwl_2_t1_p_n9 rwl_2__t1_p_n9 rwl_2_p_n9 12.7539
rrwl_2_t2_p_n9 rwl_2__t2_p_n9 rwl_2_p_n9 38.2618
rrwl_2_t3_p_n9 rwl_2__t3_p_n9 rwl_2_p_n9 38.2618
rrwl_3_t0_p_n9 rwl_3__t0_p_n9 rwl_3_p_n9 38.2618
rrwl_3_t1_p_n9 rwl_3__t1_p_n9 rwl_3_p_n9 12.7539
rrwl_3_t2_p_n9 rwl_3__t2_p_n9 rwl_3_p_n9 12.7539
rrwl_3_t3_p_n9 rwl_3__t3_p_n9 rwl_3_p_n9 38.2618
rwl_0_t0_p_n9 wl_0__t0_p_n9 wl_0_p_n9 245.959
rwl_0_t1_p_n9 wl_0__t1_p_n9 wl_0_p_n9 245.959
rwl_0_t2_p_n9 wl_0__t2_p_n9 wl_0_p_n9 81.9864
rwl_0_t3_p_n9 wl_0__t3_p_n9 wl_0_p_n9 81.9864
rwl_1_t0_p_n9 wl_1__t0_p_n9 wl_1_p_n9 245.959
rwl_1_t1_p_n9 wl_1__t1_p_n9 wl_1_p_n9 81.9864
rwl_1_t2_p_n9 wl_1__t2_p_n9 wl_1_p_n9 81.9864
rwl_1_t3_p_n9 wl_1__t3_p_n9 wl_1_p_n9 245.959
rwl_2_t0_p_n9 wl_2__t0_p_n9 wl_2_p_n9 245.959
rwl_2_t1_p_n9 wl_2__t1_p_n9 wl_2_p_n9 81.9864
rwl_2_t2_p_n9 wl_2__t2_p_n9 wl_2_p_n9 81.9864
rwl_2_t3_p_n9 wl_2__t3_p_n9 wl_2_p_n9 245.959
rwl_3_t0_p_n9 wl_3__t0_p_n9 wl_3_p_n9 245.959
rwl_3_t1_p_n9 wl_3__t1_p_n9 wl_3_p_n9 81.9864
rwl_3_t2_p_n9 wl_3__t2_p_n9 wl_3_p_n9 81.9864
rwl_3_t3_p_n9 wl_3__t3_p_n9 wl_3_p_n9 245.959
c_10_p_n9 n10_p_n9 0 2.91622e-16
c_17_p_n9 n17_p_n9 0 2.91528e-16
c_18_p_n9 n18_p_n9 0 2.91528e-16
c_19_p_n9 n19_p_n9 0 2.91528e-16
c_20_p_n9 n20_p_n9 0 2.91622e-16
c_22_p_n9 n22_p_n9 0 2.91528e-16
c_23_p_n9 n23_p_n9 0 2.91528e-16
c_24_p_n9 n24_p_n9 0 2.91528e-16
c_25_p_n9 n25_p_n9 0 2.91622e-16
c_29_p_n9 n29_p_n9 0 2.91528e-16
c_30_p_n9 n30_p_n9 0 2.91528e-16
c_31_p_n9 n31_p_n9 0 2.91528e-16
c_32_p_n9 n32_p_n9 0 2.91622e-16
c_7_p_n9 n7_p_n9 0 2.91528e-16
c_8_p_n9 n8_p_n9 0 2.91528e-16
c_9_p_n9 n9_p_n9 0 1.1371e-16
cgnd_p_n9 0 0 2.48166e-15
cbl_0_p_n9 bl_0_p_n9 0 4.52661e-16
cbl_1_p_n9 bl_1_p_n9 0 4.52661e-16
cbl_2_p_n9 bl_2_p_n9 0 4.52661e-16
cbl_3_p_n9 bl_3_p_n9 0 4.52661e-16
crbl_0_p_n9 rbl_0_p_n9 0 9.14472e-16
crbl_1_p_n9 rbl_1_p_n9 0 9.14472e-16
crbl_2_p_n9 rbl_2_p_n9 0 9.14472e-16
crbl_3_p_n9 rbl_3_p_n9 0 9.17566e-16
crwl_0_p_n9 rwl_0_p_n9 0 5.19495e-16
crwl_1_p_n9 rwl_1_p_n9 0 5.11719e-16
crwl_2_p_n9 rwl_2_p_n9 0 5.11719e-16
crwl_3_p_n9 rwl_3_p_n9 0 5.19495e-16
cwl_0_p_n9 wl_0_p_n9 0 3.30388e-16
cwl_1_p_n9 wl_1_p_n9 0 3.30388e-16
cwl_2_p_n9 wl_2_p_n9 0 3.30388e-16
cwl_3_p_n9 wl_3_p_n9 0 3.30388e-16
ccc__10__9_p_n9 n10_p_n9 n9_p_n9 1.02e-17
ccc__10_bl_3_p_n9 n10_p_n9 bl_3_p_n9 1.3999e-17
ccc__10_rwl_0_p_n9 n10_p_n9 rwl_0_p_n9 4.335e-18
ccc__17__18_p_n9 n17_p_n9 n18_p_n9 1.02e-17
ccc__17_bl_0_p_n9 n17_p_n9 bl_0_p_n9 8.415e-18
ccc__17_rwl_1_p_n9 n17_p_n9 rwl_1_p_n9 1.3194e-17
ccc__18__19_p_n9 n18_p_n9 n19_p_n9 1.02e-17
ccc__18_bl_1_p_n9 n18_p_n9 bl_1_p_n9 8.415e-18
ccc__18_rwl_1_p_n9 n18_p_n9 rwl_1_p_n9 1.3194e-17
ccc__19__20_p_n9 n19_p_n9 n20_p_n9 1.02e-17
ccc__19_bl_2_p_n9 n19_p_n9 bl_2_p_n9 8.415e-18
ccc__19_rwl_1_p_n9 n19_p_n9 rwl_1_p_n9 1.3194e-17
ccc__20_bl_3_p_n9 n20_p_n9 bl_3_p_n9 8.415e-18
ccc__20_rwl_1_p_n9 n20_p_n9 rwl_1_p_n9 6.655e-18
ccc__22__23_p_n9 n22_p_n9 n23_p_n9 1.02e-17
ccc__22_bl_0_p_n9 n22_p_n9 bl_0_p_n9 8.415e-18
ccc__22_rwl_2_p_n9 n22_p_n9 rwl_2_p_n9 1.3194e-17
ccc__23__24_p_n9 n23_p_n9 n24_p_n9 1.02e-17
ccc__23_bl_1_p_n9 n23_p_n9 bl_1_p_n9 8.415e-18
ccc__23_rwl_2_p_n9 n23_p_n9 rwl_2_p_n9 1.3194e-17
ccc__24__25_p_n9 n24_p_n9 n25_p_n9 1.02e-17
ccc__24_bl_2_p_n9 n24_p_n9 bl_2_p_n9 8.415e-18
ccc__24_rwl_2_p_n9 n24_p_n9 rwl_2_p_n9 1.3194e-17
ccc__25_bl_3_p_n9 n25_p_n9 bl_3_p_n9 8.415e-18
ccc__25_rwl_2_p_n9 n25_p_n9 rwl_2_p_n9 6.655e-18
ccc__29__30_p_n9 n29_p_n9 n30_p_n9 1.02e-17
ccc__29_bl_0_p_n9 n29_p_n9 bl_0_p_n9 8.415e-18
ccc__29_rwl_3_p_n9 n29_p_n9 rwl_3_p_n9 1.3194e-17
ccc__30__31_p_n9 n30_p_n9 n31_p_n9 1.02e-17
ccc__30_bl_1_p_n9 n30_p_n9 bl_1_p_n9 8.415e-18
ccc__30_rwl_3_p_n9 n30_p_n9 rwl_3_p_n9 1.3194e-17
ccc__31__32_p_n9 n31_p_n9 n32_p_n9 1.02e-17
ccc__31_bl_2_p_n9 n31_p_n9 bl_2_p_n9 8.415e-18
ccc__31_rwl_3_p_n9 n31_p_n9 rwl_3_p_n9 1.3194e-17
ccc__32_bl_3_p_n9 n32_p_n9 bl_3_p_n9 8.415e-18
ccc__32_rwl_3_p_n9 n32_p_n9 rwl_3_p_n9 6.655e-18
ccc__7__8_p_n9 n7_p_n9 n8_p_n9 1.02e-17
ccc__7_bl_0_p_n9 n7_p_n9 bl_0_p_n9 1.3999e-17
ccc__7_rwl_0_p_n9 n7_p_n9 rwl_0_p_n9 8.961e-18
ccc__8__9_p_n9 n8_p_n9 n9_p_n9 1.02e-17
ccc__8_bl_1_p_n9 n8_p_n9 bl_1_p_n9 1.3999e-17
ccc__8_rwl_0_p_n9 n8_p_n9 rwl_0_p_n9 8.961e-18
ccc__9_bl_2_p_n9 n9_p_n9 bl_2_p_n9 1.3999e-17
ccc__9_rwl_0_p_n9 n9_p_n9 rwl_0_p_n9 8.961e-18
ccc_bl_0_rbl_0_p_n9 bl_0_p_n9 rbl_0_p_n9 1.88693e-16
ccc_bl_0_rwl_1_p_n9 bl_0_p_n9 rwl_1_p_n9 1.0093e-17
ccc_bl_0_rwl_2_p_n9 bl_0_p_n9 rwl_2_p_n9 1.0093e-17
ccc_bl_1_rbl_0_p_n9 bl_1_p_n9 rbl_0_p_n9 1.633e-16
ccc_bl_1_rbl_1_p_n9 bl_1_p_n9 rbl_1_p_n9 1.88693e-16
ccc_bl_1_rwl_1_p_n9 bl_1_p_n9 rwl_1_p_n9 1.0093e-17
ccc_bl_1_rwl_2_p_n9 bl_1_p_n9 rwl_2_p_n9 1.0093e-17
ccc_bl_2_rbl_1_p_n9 bl_2_p_n9 rbl_1_p_n9 1.633e-16
ccc_bl_2_rbl_2_p_n9 bl_2_p_n9 rbl_2_p_n9 1.88693e-16
ccc_bl_2_rwl_1_p_n9 bl_2_p_n9 rwl_1_p_n9 1.0093e-17
ccc_bl_2_rwl_2_p_n9 bl_2_p_n9 rwl_2_p_n9 1.0093e-17
ccc_bl_3_rbl_2_p_n9 bl_3_p_n9 rbl_2_p_n9 1.633e-16
ccc_bl_3_rbl_3_p_n9 bl_3_p_n9 rbl_3_p_n9 1.88693e-16
ccc_bl_3_rwl_1_p_n9 bl_3_p_n9 rwl_1_p_n9 1.0093e-17
ccc_bl_3_rwl_2_p_n9 bl_3_p_n9 rwl_2_p_n9 1.0093e-17
ccc_rbl_0_rbl_1_p_n9 rbl_0_p_n9 rbl_1_p_n9 3.432e-17
ccc_rbl_0_rwl_0_p_n9 rbl_0_p_n9 rwl_0_p_n9 4.9752e-17
ccc_rbl_0_rwl_1_p_n9 rbl_0_p_n9 rwl_1_p_n9 4.9752e-17
ccc_rbl_0_rwl_2_p_n9 rbl_0_p_n9 rwl_2_p_n9 4.9752e-17
ccc_rbl_0_rwl_3_p_n9 rbl_0_p_n9 rwl_3_p_n9 4.9752e-17
ccc_rbl_1_rbl_2_p_n9 rbl_1_p_n9 rbl_2_p_n9 3.432e-17
ccc_rbl_1_rwl_0_p_n9 rbl_1_p_n9 rwl_0_p_n9 4.9752e-17
ccc_rbl_1_rwl_1_p_n9 rbl_1_p_n9 rwl_1_p_n9 4.9752e-17
ccc_rbl_1_rwl_2_p_n9 rbl_1_p_n9 rwl_2_p_n9 4.9752e-17
ccc_rbl_1_rwl_3_p_n9 rbl_1_p_n9 rwl_3_p_n9 4.9752e-17
ccc_rbl_2_rbl_3_p_n9 rbl_2_p_n9 rbl_3_p_n9 3.432e-17
ccc_rbl_2_rwl_0_p_n9 rbl_2_p_n9 rwl_0_p_n9 4.9752e-17
ccc_rbl_2_rwl_1_p_n9 rbl_2_p_n9 rwl_1_p_n9 4.9752e-17
ccc_rbl_2_rwl_2_p_n9 rbl_2_p_n9 rwl_2_p_n9 4.9752e-17
ccc_rbl_2_rwl_3_p_n9 rbl_2_p_n9 rwl_3_p_n9 4.9752e-17
ccc_rbl_3_rwl_0_p_n9 rbl_3_p_n9 rwl_0_p_n9 3.3407e-17
ccc_rbl_3_rwl_1_p_n9 rbl_3_p_n9 rwl_1_p_n9 3.3407e-17
ccc_rbl_3_rwl_2_p_n9 rbl_3_p_n9 rwl_2_p_n9 3.3407e-17
ccc_rbl_3_rwl_3_p_n9 rbl_3_p_n9 rwl_3_p_n9 3.3407e-17
vdw_p_n9_0 wl_0_p_n9 0 dc 0
vdr_p_n9_0 rwl_0_p_n9 vdd dc 0
vdw_p_n9_1 wl_1_p_n9 0 dc 0
vdr_p_n9_1 rwl_1_p_n9 vdd dc 0
vdw_p_n9_2 wl_2_p_n9 0 dc 0
vdr_p_n9_2 rwl_2_p_n9 vdd dc 0
vdw_p_n9_3 wl_3_p_n9 0 dc 0
vdr_p_n9_3 rwl_3_p_n9 vdd dc 0
vdb_p_n9_0 bl_0_p_n9 0 dc 0
vdp_p_n9_0 rbl_0_p_n9 vrbl dc 0
vdb_p_n9_1 bl_1_p_n9 0 dc 0
vdp_p_n9_1 rbl_1_p_n9 vrbl dc 0
vdb_p_n9_2 bl_2_p_n9 0 dc 0
vdp_p_n9_2 rbl_2_p_n9 vrbl dc 0
vdb_p_n9_3 bl_3_p_n9 0 dc 0
vdp_p_n9_3 rbl_3_p_n9 vrbl dc 0
vdn_p_n9_n7 n7_p_n9 0 dc 1
vdn_p_n9_n8 n8_p_n9 0 dc 1
vdn_p_n9_n10 n10_p_n9 0 dc 1
vdn_p_n9_n17 n17_p_n9 0 dc 1
vdn_p_n9_n18 n18_p_n9 0 dc 1
vdn_p_n9_n19 n19_p_n9 0 dc 1
vdn_p_n9_n20 n20_p_n9 0 dc 1
vdn_p_n9_n22 n22_p_n9 0 dc 1
vdn_p_n9_n23 n23_p_n9 0 dc 1
vdn_p_n9_n24 n24_p_n9 0 dc 1
vdn_p_n9_n25 n25_p_n9 0 dc 1
vdn_p_n9_n29 n29_p_n9 0 dc 1
vdn_p_n9_n30 n30_p_n9 0 dc 1
vdn_p_n9_n31 n31_p_n9 0 dc 1
vdn_p_n9_n32 n32_p_n9 0 dc 1
bdr_p_n9 n9_p_n9 0 i=5e-08*min(1,max(0,(time-1e-09)/0.2n))*0.5*(1+tanh((v(n9_p_n9)-0.05)/0.01))

* ---- instance p_n10: variant p, probed storage node \$10 ----
xm1_p_n10 rwl_0__t2_p_n10 n7__t0_p_n10 rbl_0__t0_p_n10 gnd__t0_p_n10 sky130_fd_pr__nfet_01v8 L=0.15 W=0.42 nf=1 ad=0.1197 as=0.1197 pd=1.41 ps=1.41 mult=1 m=1
xm2_p_n10 rwl_0__t3_p_n10 n8__t1_p_n10 rbl_1__t1_p_n10 gnd__t1_p_n10 sky130_fd_pr__nfet_01v8 L=0.15 W=0.42 nf=1 ad=0.1197 as=0.1197 pd=1.41 ps=1.41 mult=1 m=1
xm3_p_n10 rwl_0__t1_p_n10 n9__t1_p_n10 rbl_2__t1_p_n10 gnd__t2_p_n10 sky130_fd_pr__nfet_01v8 L=0.15 W=0.42 nf=1 ad=0.1197 as=0.1197 pd=1.41 ps=1.41 mult=1 m=1
xm4_p_n10 rwl_0__t0_p_n10 n10__t1_p_n10 rbl_3__t1_p_n10 gnd__t3_p_n10 sky130_fd_pr__nfet_01v8 L=0.15 W=0.42 nf=1 ad=0.1197 as=0.1197 pd=1.41 ps=1.41 mult=1 m=1
xm5_p_n10 bl_0__t0_p_n10 wl_0__t0_p_n10 n7__t1_p_n10 gnd__t8_p_n10 sky130_fd_pr__nfet_01v8 L=0.15 W=0.42 nf=1 ad=0.0588 as=0.1197 pd=0.7 ps=1.41 mult=1 m=1
xm6_p_n10 n17__t0_p_n10 wl_1__t0_p_n10 bl_0__t1_p_n10 gnd__t20_p_n10 sky130_fd_pr__nfet_01v8 L=0.15 W=0.42 nf=1 ad=0.1197 as=0.0588 pd=1.41 ps=0.7 mult=1 m=1
xm7_p_n10 bl_1__t2_p_n10 wl_0__t3_p_n10 n8__t0_p_n10 gnd__t9_p_n10 sky130_fd_pr__nfet_01v8 L=0.15 W=0.42 nf=1 ad=0.0588 as=0.1197 pd=0.7 ps=1.41 mult=1 m=1
xm8_p_n10 n18__t0_p_n10 wl_1__t1_p_n10 bl_1__t0_p_n10 gnd__t21_p_n10 sky130_fd_pr__nfet_01v8 L=0.15 W=0.42 nf=1 ad=0.1197 as=0.0588 pd=1.41 ps=0.7 mult=1 m=1
xm9_p_n10 bl_2__t2_p_n10 wl_0__t2_p_n10 n9__t0_p_n10 gnd__t10_p_n10 sky130_fd_pr__nfet_01v8 L=0.15 W=0.42 nf=1 ad=0.0588 as=0.1197 pd=0.7 ps=1.41 mult=1 m=1
xm10_p_n10 n19__t0_p_n10 wl_1__t2_p_n10 bl_2__t0_p_n10 gnd__t22_p_n10 sky130_fd_pr__nfet_01v8 L=0.15 W=0.42 nf=1 ad=0.1197 as=0.0588 pd=1.41 ps=0.7 mult=1 m=1
xm11_p_n10 bl_3__t2_p_n10 wl_0__t1_p_n10 n10__t0_p_n10 gnd__t11_p_n10 sky130_fd_pr__nfet_01v8 L=0.15 W=0.42 nf=1 ad=0.0588 as=0.1197 pd=0.7 ps=1.41 mult=1 m=1
xm12_p_n10 n20__t0_p_n10 wl_1__t3_p_n10 bl_3__t1_p_n10 gnd__t23_p_n10 sky130_fd_pr__nfet_01v8 L=0.15 W=0.42 nf=1 ad=0.1197 as=0.0588 pd=1.41 ps=0.7 mult=1 m=1
xm13_p_n10 rbl_0__t3_p_n10 n17__t1_p_n10 rwl_1__t0_p_n10 gnd__t12_p_n10 sky130_fd_pr__nfet_01v8 L=0.15 W=0.42 nf=1 ad=0.0588 as=0.1197 pd=0.7 ps=1.41 mult=1 m=1
xm14_p_n10 rwl_2__t3_p_n10 n22__t0_p_n10 rbl_0__t2_p_n10 gnd__t24_p_n10 sky130_fd_pr__nfet_01v8 L=0.15 W=0.42 nf=1 ad=0.1197 as=0.0588 pd=1.41 ps=0.7 mult=1 m=1
xm15_p_n10 rbl_1__t3_p_n10 n18__t1_p_n10 rwl_1__t1_p_n10 gnd__t13_p_n10 sky130_fd_pr__nfet_01v8 L=0.15 W=0.42 nf=1 ad=0.0588 as=0.1197 pd=0.7 ps=1.41 mult=1 m=1
xm16_p_n10 rwl_2__t0_p_n10 n23__t0_p_n10 rbl_1__t2_p_n10 gnd__t25_p_n10 sky130_fd_pr__nfet_01v8 L=0.15 W=0.42 nf=1 ad=0.1197 as=0.0588 pd=1.41 ps=0.7 mult=1 m=1
xm17_p_n10 rbl_2__t3_p_n10 n19__t1_p_n10 rwl_1__t2_p_n10 gnd__t14_p_n10 sky130_fd_pr__nfet_01v8 L=0.15 W=0.42 nf=1 ad=0.0588 as=0.1197 pd=0.7 ps=1.41 mult=1 m=1
xm18_p_n10 rwl_2__t1_p_n10 n24__t0_p_n10 rbl_2__t2_p_n10 gnd__t26_p_n10 sky130_fd_pr__nfet_01v8 L=0.15 W=0.42 nf=1 ad=0.1197 as=0.0588 pd=1.41 ps=0.7 mult=1 m=1
xm19_p_n10 rbl_3__t3_p_n10 n20__t1_p_n10 rwl_1__t3_p_n10 gnd__t15_p_n10 sky130_fd_pr__nfet_01v8 L=0.15 W=0.42 nf=1 ad=0.0588 as=0.1197 pd=0.7 ps=1.41 mult=1 m=1
xm20_p_n10 rwl_2__t2_p_n10 n25__t0_p_n10 rbl_3__t2_p_n10 gnd__t27_p_n10 sky130_fd_pr__nfet_01v8 L=0.15 W=0.42 nf=1 ad=0.1197 as=0.0588 pd=1.41 ps=0.7 mult=1 m=1
xm21_p_n10 bl_0__t3_p_n10 wl_2__t0_p_n10 n22__t1_p_n10 gnd__t16_p_n10 sky130_fd_pr__nfet_01v8 L=0.15 W=0.42 nf=1 ad=0.0588 as=0.1197 pd=0.7 ps=1.41 mult=1 m=1
xm22_p_n10 n29__t0_p_n10 wl_3__t3_p_n10 bl_0__t2_p_n10 gnd__t28_p_n10 sky130_fd_pr__nfet_01v8 L=0.15 W=0.42 nf=1 ad=0.1197 as=0.0588 pd=1.41 ps=0.7 mult=1 m=1
xm23_p_n10 bl_1__t3_p_n10 wl_2__t1_p_n10 n23__t1_p_n10 gnd__t17_p_n10 sky130_fd_pr__nfet_01v8 L=0.15 W=0.42 nf=1 ad=0.0588 as=0.1197 pd=0.7 ps=1.41 mult=1 m=1
xm24_p_n10 n30__t0_p_n10 wl_3__t2_p_n10 bl_1__t1_p_n10 gnd__t29_p_n10 sky130_fd_pr__nfet_01v8 L=0.15 W=0.42 nf=1 ad=0.1197 as=0.0588 pd=1.41 ps=0.7 mult=1 m=1
xm25_p_n10 bl_2__t3_p_n10 wl_2__t2_p_n10 n24__t1_p_n10 gnd__t18_p_n10 sky130_fd_pr__nfet_01v8 L=0.15 W=0.42 nf=1 ad=0.0588 as=0.1197 pd=0.7 ps=1.41 mult=1 m=1
xm26_p_n10 n31__t0_p_n10 wl_3__t1_p_n10 bl_2__t1_p_n10 gnd__t30_p_n10 sky130_fd_pr__nfet_01v8 L=0.15 W=0.42 nf=1 ad=0.1197 as=0.0588 pd=1.41 ps=0.7 mult=1 m=1
xm27_p_n10 bl_3__t3_p_n10 wl_2__t3_p_n10 n25__t1_p_n10 gnd__t19_p_n10 sky130_fd_pr__nfet_01v8 L=0.15 W=0.42 nf=1 ad=0.0588 as=0.1197 pd=0.7 ps=1.41 mult=1 m=1
xm28_p_n10 n32__t0_p_n10 wl_3__t0_p_n10 bl_3__t0_p_n10 gnd__t31_p_n10 sky130_fd_pr__nfet_01v8 L=0.15 W=0.42 nf=1 ad=0.1197 as=0.0588 pd=1.41 ps=0.7 mult=1 m=1
xm29_p_n10 rbl_0__t1_p_n10 n29__t1_p_n10 rwl_3__t0_p_n10 gnd__t4_p_n10 sky130_fd_pr__nfet_01v8 L=0.15 W=0.42 nf=1 ad=0.1197 as=0.1197 pd=1.41 ps=1.41 mult=1 m=1
xm30_p_n10 rbl_1__t0_p_n10 n30__t1_p_n10 rwl_3__t1_p_n10 gnd__t5_p_n10 sky130_fd_pr__nfet_01v8 L=0.15 W=0.42 nf=1 ad=0.1197 as=0.1197 pd=1.41 ps=1.41 mult=1 m=1
xm31_p_n10 rbl_2__t0_p_n10 n31__t1_p_n10 rwl_3__t2_p_n10 gnd__t6_p_n10 sky130_fd_pr__nfet_01v8 L=0.15 W=0.42 nf=1 ad=0.1197 as=0.1197 pd=1.41 ps=1.41 mult=1 m=1
xm32_p_n10 rbl_3__t0_p_n10 n32__t1_p_n10 rwl_3__t3_p_n10 gnd__t7_p_n10 sky130_fd_pr__nfet_01v8 L=0.15 W=0.42 nf=1 ad=0.1197 as=0.1197 pd=1.41 ps=1.41 mult=1 m=1
r_10_t0_p_n10 n10__t0_p_n10 n10_p_n10 183.071
r_10_t1_p_n10 n10__t1_p_n10 n10_p_n10 183.071
r_17_t0_p_n10 n17__t0_p_n10 n17_p_n10 183.071
r_17_t1_p_n10 n17__t1_p_n10 n17_p_n10 183.071
r_18_t0_p_n10 n18__t0_p_n10 n18_p_n10 183.071
r_18_t1_p_n10 n18__t1_p_n10 n18_p_n10 183.071
r_19_t0_p_n10 n19__t0_p_n10 n19_p_n10 183.071
r_19_t1_p_n10 n19__t1_p_n10 n19_p_n10 183.071
r_20_t0_p_n10 n20__t0_p_n10 n20_p_n10 183.071
r_20_t1_p_n10 n20__t1_p_n10 n20_p_n10 183.071
r_22_t0_p_n10 n22__t0_p_n10 n22_p_n10 183.071
r_22_t1_p_n10 n22__t1_p_n10 n22_p_n10 183.071
r_23_t0_p_n10 n23__t0_p_n10 n23_p_n10 183.071
r_23_t1_p_n10 n23__t1_p_n10 n23_p_n10 183.071
r_24_t0_p_n10 n24__t0_p_n10 n24_p_n10 183.071
r_24_t1_p_n10 n24__t1_p_n10 n24_p_n10 183.071
r_25_t0_p_n10 n25__t0_p_n10 n25_p_n10 183.071
r_25_t1_p_n10 n25__t1_p_n10 n25_p_n10 183.071
r_29_t0_p_n10 n29__t0_p_n10 n29_p_n10 183.071
r_29_t1_p_n10 n29__t1_p_n10 n29_p_n10 183.071
r_30_t0_p_n10 n30__t0_p_n10 n30_p_n10 183.071
r_30_t1_p_n10 n30__t1_p_n10 n30_p_n10 183.071
r_31_t0_p_n10 n31__t0_p_n10 n31_p_n10 183.071
r_31_t1_p_n10 n31__t1_p_n10 n31_p_n10 183.071
r_32_t0_p_n10 n32__t0_p_n10 n32_p_n10 183.071
r_32_t1_p_n10 n32__t1_p_n10 n32_p_n10 183.071
r_7_t0_p_n10 n7__t0_p_n10 n7_p_n10 183.071
r_7_t1_p_n10 n7__t1_p_n10 n7_p_n10 183.071
r_8_t0_p_n10 n8__t0_p_n10 n8_p_n10 183.071
r_8_t1_p_n10 n8__t1_p_n10 n8_p_n10 183.071
r_9_t0_p_n10 n9__t0_p_n10 n9_p_n10 183.071
r_9_t1_p_n10 n9__t1_p_n10 n9_p_n10 183.071
rgnd_t0_p_n10 gnd__t0_p_n10 0 38.2988
rgnd_t1_p_n10 gnd__t1_p_n10 0 33.9576
rgnd_t2_p_n10 gnd__t2_p_n10 0 33.9576
rgnd_t3_p_n10 gnd__t3_p_n10 0 38.2988
rgnd_t4_p_n10 gnd__t4_p_n10 0 38.2988
rgnd_t5_p_n10 gnd__t5_p_n10 0 33.9576
rgnd_t6_p_n10 gnd__t6_p_n10 0 33.9576
rgnd_t7_p_n10 gnd__t7_p_n10 0 38.2988
rgnd_t8_p_n10 gnd__t8_p_n10 0 28.0185
rgnd_t9_p_n10 gnd__t9_p_n10 0 21.7106
rgnd_t10_p_n10 gnd__t10_p_n10 0 21.7106
rgnd_t11_p_n10 gnd__t11_p_n10 0 28.0185
rgnd_t12_p_n10 gnd__t12_p_n10 0 18.9833
rgnd_t13_p_n10 gnd__t13_p_n10 0 6.8325
rgnd_t14_p_n10 gnd__t14_p_n10 0 6.8325
rgnd_t15_p_n10 gnd__t15_p_n10 0 18.9833
rgnd_t16_p_n10 gnd__t16_p_n10 0 24.2409
rgnd_t17_p_n10 gnd__t17_p_n10 0 16.5511
rgnd_t18_p_n10 gnd__t18_p_n10 0 16.5511
rgnd_t19_p_n10 gnd__t19_p_n10 0 24.2409
rgnd_t20_p_n10 gnd__t20_p_n10 0 24.2409
rgnd_t21_p_n10 gnd__t21_p_n10 0 16.5511
rgnd_t22_p_n10 gnd__t22_p_n10 0 16.5511
rgnd_t23_p_n10 gnd__t23_p_n10 0 24.2409
rgnd_t24_p_n10 gnd__t24_p_n10 0 18.9833
rgnd_t25_p_n10 gnd__t25_p_n10 0 6.8325
rgnd_t26_p_n10 gnd__t26_p_n10 0 6.8325
rgnd_t27_p_n10 gnd__t27_p_n10 0 18.9833
rgnd_t28_p_n10 gnd__t28_p_n10 0 28.0185
rgnd_t29_p_n10 gnd__t29_p_n10 0 21.7106
rgnd_t30_p_n10 gnd__t30_p_n10 0 21.7106
rgnd_t31_p_n10 gnd__t31_p_n10 0 28.0185
rbl_0_t0_p_n10 bl_0__t0_p_n10 bl_0_p_n10 14.8304
rbl_0_t1_p_n10 bl_0__t1_p_n10 bl_0_p_n10 10.9301
rbl_0_t2_p_n10 bl_0__t2_p_n10 bl_0_p_n10 14.8304
rbl_0_t3_p_n10 bl_0__t3_p_n10 bl_0_p_n10 10.9301
rbl_1_t0_p_n10 bl_1__t0_p_n10 bl_1_p_n10 10.9301
rbl_1_t1_p_n10 bl_1__t1_p_n10 bl_1_p_n10 14.8304
rbl_1_t2_p_n10 bl_1__t2_p_n10 bl_1_p_n10 14.8304
rbl_1_t3_p_n10 bl_1__t3_p_n10 bl_1_p_n10 10.9301
rbl_2_t0_p_n10 bl_2__t0_p_n10 bl_2_p_n10 10.9301
rbl_2_t1_p_n10 bl_2__t1_p_n10 bl_2_p_n10 14.8304
rbl_2_t2_p_n10 bl_2__t2_p_n10 bl_2_p_n10 14.8304
rbl_2_t3_p_n10 bl_2__t3_p_n10 bl_2_p_n10 10.9301
rbl_3_t0_p_n10 bl_3__t0_p_n10 bl_3_p_n10 14.8304
rbl_3_t1_p_n10 bl_3__t1_p_n10 bl_3_p_n10 10.9301
rbl_3_t2_p_n10 bl_3__t2_p_n10 bl_3_p_n10 14.8304
rbl_3_t3_p_n10 bl_3__t3_p_n10 bl_3_p_n10 10.9301
rrbl_0_t0_p_n10 rbl_0__t0_p_n10 rbl_0_p_n10 36.5601
rrbl_0_t1_p_n10 rbl_0__t1_p_n10 rbl_0_p_n10 36.5601
rrbl_0_t2_p_n10 rbl_0__t2_p_n10 rbl_0_p_n10 2.99444
rrbl_0_t3_p_n10 rbl_0__t3_p_n10 rbl_0_p_n10 2.99444
rrbl_1_t0_p_n10 rbl_1__t0_p_n10 rbl_1_p_n10 36.5601
rrbl_1_t1_p_n10 rbl_1__t1_p_n10 rbl_1_p_n10 36.5601
rrbl_1_t2_p_n10 rbl_1__t2_p_n10 rbl_1_p_n10 2.99444
rrbl_1_t3_p_n10 rbl_1__t3_p_n10 rbl_1_p_n10 2.99444
rrbl_2_t0_p_n10 rbl_2__t0_p_n10 rbl_2_p_n10 36.5601
rrbl_2_t1_p_n10 rbl_2__t1_p_n10 rbl_2_p_n10 36.5601
rrbl_2_t2_p_n10 rbl_2__t2_p_n10 rbl_2_p_n10 2.99444
rrbl_2_t3_p_n10 rbl_2__t3_p_n10 rbl_2_p_n10 2.99444
rrbl_3_t0_p_n10 rbl_3__t0_p_n10 rbl_3_p_n10 36.5601
rrbl_3_t1_p_n10 rbl_3__t1_p_n10 rbl_3_p_n10 36.5601
rrbl_3_t2_p_n10 rbl_3__t2_p_n10 rbl_3_p_n10 2.99444
rrbl_3_t3_p_n10 rbl_3__t3_p_n10 rbl_3_p_n10 2.99444
rrwl_0_t0_p_n10 rwl_0__t0_p_n10 rwl_0_p_n10 38.2618
rrwl_0_t1_p_n10 rwl_0__t1_p_n10 rwl_0_p_n10 12.7539
rrwl_0_t2_p_n10 rwl_0__t2_p_n10 rwl_0_p_n10 38.2618
rrwl_0_t3_p_n10 rwl_0__t3_p_n10 rwl_0_p_n10 12.7539
rrwl_1_t0_p_n10 rwl_1__t0_p_n10 rwl_1_p_n10 38.2618
rrwl_1_t1_p_n10 rwl_1__t1_p_n10 rwl_1_p_n10 12.7539
rrwl_1_t2_p_n10 rwl_1__t2_p_n10 rwl_1_p_n10 12.7539
rrwl_1_t3_p_n10 rwl_1__t3_p_n10 rwl_1_p_n10 38.2618
rrwl_2_t0_p_n10 rwl_2__t0_p_n10 rwl_2_p_n10 12.7539
rrwl_2_t1_p_n10 rwl_2__t1_p_n10 rwl_2_p_n10 12.7539
rrwl_2_t2_p_n10 rwl_2__t2_p_n10 rwl_2_p_n10 38.2618
rrwl_2_t3_p_n10 rwl_2__t3_p_n10 rwl_2_p_n10 38.2618
rrwl_3_t0_p_n10 rwl_3__t0_p_n10 rwl_3_p_n10 38.2618
rrwl_3_t1_p_n10 rwl_3__t1_p_n10 rwl_3_p_n10 12.7539
rrwl_3_t2_p_n10 rwl_3__t2_p_n10 rwl_3_p_n10 12.7539
rrwl_3_t3_p_n10 rwl_3__t3_p_n10 rwl_3_p_n10 38.2618
rwl_0_t0_p_n10 wl_0__t0_p_n10 wl_0_p_n10 245.959
rwl_0_t1_p_n10 wl_0__t1_p_n10 wl_0_p_n10 245.959
rwl_0_t2_p_n10 wl_0__t2_p_n10 wl_0_p_n10 81.9864
rwl_0_t3_p_n10 wl_0__t3_p_n10 wl_0_p_n10 81.9864
rwl_1_t0_p_n10 wl_1__t0_p_n10 wl_1_p_n10 245.959
rwl_1_t1_p_n10 wl_1__t1_p_n10 wl_1_p_n10 81.9864
rwl_1_t2_p_n10 wl_1__t2_p_n10 wl_1_p_n10 81.9864
rwl_1_t3_p_n10 wl_1__t3_p_n10 wl_1_p_n10 245.959
rwl_2_t0_p_n10 wl_2__t0_p_n10 wl_2_p_n10 245.959
rwl_2_t1_p_n10 wl_2__t1_p_n10 wl_2_p_n10 81.9864
rwl_2_t2_p_n10 wl_2__t2_p_n10 wl_2_p_n10 81.9864
rwl_2_t3_p_n10 wl_2__t3_p_n10 wl_2_p_n10 245.959
rwl_3_t0_p_n10 wl_3__t0_p_n10 wl_3_p_n10 245.959
rwl_3_t1_p_n10 wl_3__t1_p_n10 wl_3_p_n10 81.9864
rwl_3_t2_p_n10 wl_3__t2_p_n10 wl_3_p_n10 81.9864
rwl_3_t3_p_n10 wl_3__t3_p_n10 wl_3_p_n10 245.959
c_10_p_n10 n10_p_n10 0 1.13804e-16
c_17_p_n10 n17_p_n10 0 2.91528e-16
c_18_p_n10 n18_p_n10 0 2.91528e-16
c_19_p_n10 n19_p_n10 0 2.91528e-16
c_20_p_n10 n20_p_n10 0 2.91622e-16
c_22_p_n10 n22_p_n10 0 2.91528e-16
c_23_p_n10 n23_p_n10 0 2.91528e-16
c_24_p_n10 n24_p_n10 0 2.91528e-16
c_25_p_n10 n25_p_n10 0 2.91622e-16
c_29_p_n10 n29_p_n10 0 2.91528e-16
c_30_p_n10 n30_p_n10 0 2.91528e-16
c_31_p_n10 n31_p_n10 0 2.91528e-16
c_32_p_n10 n32_p_n10 0 2.91622e-16
c_7_p_n10 n7_p_n10 0 2.91528e-16
c_8_p_n10 n8_p_n10 0 2.91528e-16
c_9_p_n10 n9_p_n10 0 2.91528e-16
cgnd_p_n10 0 0 2.48166e-15
cbl_0_p_n10 bl_0_p_n10 0 4.52661e-16
cbl_1_p_n10 bl_1_p_n10 0 4.52661e-16
cbl_2_p_n10 bl_2_p_n10 0 4.52661e-16
cbl_3_p_n10 bl_3_p_n10 0 4.52661e-16
crbl_0_p_n10 rbl_0_p_n10 0 9.14472e-16
crbl_1_p_n10 rbl_1_p_n10 0 9.14472e-16
crbl_2_p_n10 rbl_2_p_n10 0 9.14472e-16
crbl_3_p_n10 rbl_3_p_n10 0 9.17566e-16
crwl_0_p_n10 rwl_0_p_n10 0 5.19495e-16
crwl_1_p_n10 rwl_1_p_n10 0 5.11719e-16
crwl_2_p_n10 rwl_2_p_n10 0 5.11719e-16
crwl_3_p_n10 rwl_3_p_n10 0 5.19495e-16
cwl_0_p_n10 wl_0_p_n10 0 3.30388e-16
cwl_1_p_n10 wl_1_p_n10 0 3.30388e-16
cwl_2_p_n10 wl_2_p_n10 0 3.30388e-16
cwl_3_p_n10 wl_3_p_n10 0 3.30388e-16
ccc__10__9_p_n10 n10_p_n10 n9_p_n10 1.02e-17
ccc__10_bl_3_p_n10 n10_p_n10 bl_3_p_n10 1.3999e-17
ccc__10_rwl_0_p_n10 n10_p_n10 rwl_0_p_n10 4.335e-18
ccc__17__18_p_n10 n17_p_n10 n18_p_n10 1.02e-17
ccc__17_bl_0_p_n10 n17_p_n10 bl_0_p_n10 8.415e-18
ccc__17_rwl_1_p_n10 n17_p_n10 rwl_1_p_n10 1.3194e-17
ccc__18__19_p_n10 n18_p_n10 n19_p_n10 1.02e-17
ccc__18_bl_1_p_n10 n18_p_n10 bl_1_p_n10 8.415e-18
ccc__18_rwl_1_p_n10 n18_p_n10 rwl_1_p_n10 1.3194e-17
ccc__19__20_p_n10 n19_p_n10 n20_p_n10 1.02e-17
ccc__19_bl_2_p_n10 n19_p_n10 bl_2_p_n10 8.415e-18
ccc__19_rwl_1_p_n10 n19_p_n10 rwl_1_p_n10 1.3194e-17
ccc__20_bl_3_p_n10 n20_p_n10 bl_3_p_n10 8.415e-18
ccc__20_rwl_1_p_n10 n20_p_n10 rwl_1_p_n10 6.655e-18
ccc__22__23_p_n10 n22_p_n10 n23_p_n10 1.02e-17
ccc__22_bl_0_p_n10 n22_p_n10 bl_0_p_n10 8.415e-18
ccc__22_rwl_2_p_n10 n22_p_n10 rwl_2_p_n10 1.3194e-17
ccc__23__24_p_n10 n23_p_n10 n24_p_n10 1.02e-17
ccc__23_bl_1_p_n10 n23_p_n10 bl_1_p_n10 8.415e-18
ccc__23_rwl_2_p_n10 n23_p_n10 rwl_2_p_n10 1.3194e-17
ccc__24__25_p_n10 n24_p_n10 n25_p_n10 1.02e-17
ccc__24_bl_2_p_n10 n24_p_n10 bl_2_p_n10 8.415e-18
ccc__24_rwl_2_p_n10 n24_p_n10 rwl_2_p_n10 1.3194e-17
ccc__25_bl_3_p_n10 n25_p_n10 bl_3_p_n10 8.415e-18
ccc__25_rwl_2_p_n10 n25_p_n10 rwl_2_p_n10 6.655e-18
ccc__29__30_p_n10 n29_p_n10 n30_p_n10 1.02e-17
ccc__29_bl_0_p_n10 n29_p_n10 bl_0_p_n10 8.415e-18
ccc__29_rwl_3_p_n10 n29_p_n10 rwl_3_p_n10 1.3194e-17
ccc__30__31_p_n10 n30_p_n10 n31_p_n10 1.02e-17
ccc__30_bl_1_p_n10 n30_p_n10 bl_1_p_n10 8.415e-18
ccc__30_rwl_3_p_n10 n30_p_n10 rwl_3_p_n10 1.3194e-17
ccc__31__32_p_n10 n31_p_n10 n32_p_n10 1.02e-17
ccc__31_bl_2_p_n10 n31_p_n10 bl_2_p_n10 8.415e-18
ccc__31_rwl_3_p_n10 n31_p_n10 rwl_3_p_n10 1.3194e-17
ccc__32_bl_3_p_n10 n32_p_n10 bl_3_p_n10 8.415e-18
ccc__32_rwl_3_p_n10 n32_p_n10 rwl_3_p_n10 6.655e-18
ccc__7__8_p_n10 n7_p_n10 n8_p_n10 1.02e-17
ccc__7_bl_0_p_n10 n7_p_n10 bl_0_p_n10 1.3999e-17
ccc__7_rwl_0_p_n10 n7_p_n10 rwl_0_p_n10 8.961e-18
ccc__8__9_p_n10 n8_p_n10 n9_p_n10 1.02e-17
ccc__8_bl_1_p_n10 n8_p_n10 bl_1_p_n10 1.3999e-17
ccc__8_rwl_0_p_n10 n8_p_n10 rwl_0_p_n10 8.961e-18
ccc__9_bl_2_p_n10 n9_p_n10 bl_2_p_n10 1.3999e-17
ccc__9_rwl_0_p_n10 n9_p_n10 rwl_0_p_n10 8.961e-18
ccc_bl_0_rbl_0_p_n10 bl_0_p_n10 rbl_0_p_n10 1.88693e-16
ccc_bl_0_rwl_1_p_n10 bl_0_p_n10 rwl_1_p_n10 1.0093e-17
ccc_bl_0_rwl_2_p_n10 bl_0_p_n10 rwl_2_p_n10 1.0093e-17
ccc_bl_1_rbl_0_p_n10 bl_1_p_n10 rbl_0_p_n10 1.633e-16
ccc_bl_1_rbl_1_p_n10 bl_1_p_n10 rbl_1_p_n10 1.88693e-16
ccc_bl_1_rwl_1_p_n10 bl_1_p_n10 rwl_1_p_n10 1.0093e-17
ccc_bl_1_rwl_2_p_n10 bl_1_p_n10 rwl_2_p_n10 1.0093e-17
ccc_bl_2_rbl_1_p_n10 bl_2_p_n10 rbl_1_p_n10 1.633e-16
ccc_bl_2_rbl_2_p_n10 bl_2_p_n10 rbl_2_p_n10 1.88693e-16
ccc_bl_2_rwl_1_p_n10 bl_2_p_n10 rwl_1_p_n10 1.0093e-17
ccc_bl_2_rwl_2_p_n10 bl_2_p_n10 rwl_2_p_n10 1.0093e-17
ccc_bl_3_rbl_2_p_n10 bl_3_p_n10 rbl_2_p_n10 1.633e-16
ccc_bl_3_rbl_3_p_n10 bl_3_p_n10 rbl_3_p_n10 1.88693e-16
ccc_bl_3_rwl_1_p_n10 bl_3_p_n10 rwl_1_p_n10 1.0093e-17
ccc_bl_3_rwl_2_p_n10 bl_3_p_n10 rwl_2_p_n10 1.0093e-17
ccc_rbl_0_rbl_1_p_n10 rbl_0_p_n10 rbl_1_p_n10 3.432e-17
ccc_rbl_0_rwl_0_p_n10 rbl_0_p_n10 rwl_0_p_n10 4.9752e-17
ccc_rbl_0_rwl_1_p_n10 rbl_0_p_n10 rwl_1_p_n10 4.9752e-17
ccc_rbl_0_rwl_2_p_n10 rbl_0_p_n10 rwl_2_p_n10 4.9752e-17
ccc_rbl_0_rwl_3_p_n10 rbl_0_p_n10 rwl_3_p_n10 4.9752e-17
ccc_rbl_1_rbl_2_p_n10 rbl_1_p_n10 rbl_2_p_n10 3.432e-17
ccc_rbl_1_rwl_0_p_n10 rbl_1_p_n10 rwl_0_p_n10 4.9752e-17
ccc_rbl_1_rwl_1_p_n10 rbl_1_p_n10 rwl_1_p_n10 4.9752e-17
ccc_rbl_1_rwl_2_p_n10 rbl_1_p_n10 rwl_2_p_n10 4.9752e-17
ccc_rbl_1_rwl_3_p_n10 rbl_1_p_n10 rwl_3_p_n10 4.9752e-17
ccc_rbl_2_rbl_3_p_n10 rbl_2_p_n10 rbl_3_p_n10 3.432e-17
ccc_rbl_2_rwl_0_p_n10 rbl_2_p_n10 rwl_0_p_n10 4.9752e-17
ccc_rbl_2_rwl_1_p_n10 rbl_2_p_n10 rwl_1_p_n10 4.9752e-17
ccc_rbl_2_rwl_2_p_n10 rbl_2_p_n10 rwl_2_p_n10 4.9752e-17
ccc_rbl_2_rwl_3_p_n10 rbl_2_p_n10 rwl_3_p_n10 4.9752e-17
ccc_rbl_3_rwl_0_p_n10 rbl_3_p_n10 rwl_0_p_n10 3.3407e-17
ccc_rbl_3_rwl_1_p_n10 rbl_3_p_n10 rwl_1_p_n10 3.3407e-17
ccc_rbl_3_rwl_2_p_n10 rbl_3_p_n10 rwl_2_p_n10 3.3407e-17
ccc_rbl_3_rwl_3_p_n10 rbl_3_p_n10 rwl_3_p_n10 3.3407e-17
vdw_p_n10_0 wl_0_p_n10 0 dc 0
vdr_p_n10_0 rwl_0_p_n10 vdd dc 0
vdw_p_n10_1 wl_1_p_n10 0 dc 0
vdr_p_n10_1 rwl_1_p_n10 vdd dc 0
vdw_p_n10_2 wl_2_p_n10 0 dc 0
vdr_p_n10_2 rwl_2_p_n10 vdd dc 0
vdw_p_n10_3 wl_3_p_n10 0 dc 0
vdr_p_n10_3 rwl_3_p_n10 vdd dc 0
vdb_p_n10_0 bl_0_p_n10 0 dc 0
vdp_p_n10_0 rbl_0_p_n10 vrbl dc 0
vdb_p_n10_1 bl_1_p_n10 0 dc 0
vdp_p_n10_1 rbl_1_p_n10 vrbl dc 0
vdb_p_n10_2 bl_2_p_n10 0 dc 0
vdp_p_n10_2 rbl_2_p_n10 vrbl dc 0
vdb_p_n10_3 bl_3_p_n10 0 dc 0
vdp_p_n10_3 rbl_3_p_n10 vrbl dc 0
vdn_p_n10_n7 n7_p_n10 0 dc 1
vdn_p_n10_n8 n8_p_n10 0 dc 1
vdn_p_n10_n9 n9_p_n10 0 dc 1
vdn_p_n10_n17 n17_p_n10 0 dc 1
vdn_p_n10_n18 n18_p_n10 0 dc 1
vdn_p_n10_n19 n19_p_n10 0 dc 1
vdn_p_n10_n20 n20_p_n10 0 dc 1
vdn_p_n10_n22 n22_p_n10 0 dc 1
vdn_p_n10_n23 n23_p_n10 0 dc 1
vdn_p_n10_n24 n24_p_n10 0 dc 1
vdn_p_n10_n25 n25_p_n10 0 dc 1
vdn_p_n10_n29 n29_p_n10 0 dc 1
vdn_p_n10_n30 n30_p_n10 0 dc 1
vdn_p_n10_n31 n31_p_n10 0 dc 1
vdn_p_n10_n32 n32_p_n10 0 dc 1
bdr_p_n10 n10_p_n10 0 i=5e-08*min(1,max(0,(time-1e-09)/0.2n))*0.5*(1+tanh((v(n10_p_n10)-0.05)/0.01))

* ---- instance p_n17: variant p, probed storage node \$17 ----
xm1_p_n17 rwl_0__t2_p_n17 n7__t0_p_n17 rbl_0__t0_p_n17 gnd__t0_p_n17 sky130_fd_pr__nfet_01v8 L=0.15 W=0.42 nf=1 ad=0.1197 as=0.1197 pd=1.41 ps=1.41 mult=1 m=1
xm2_p_n17 rwl_0__t3_p_n17 n8__t1_p_n17 rbl_1__t1_p_n17 gnd__t1_p_n17 sky130_fd_pr__nfet_01v8 L=0.15 W=0.42 nf=1 ad=0.1197 as=0.1197 pd=1.41 ps=1.41 mult=1 m=1
xm3_p_n17 rwl_0__t1_p_n17 n9__t1_p_n17 rbl_2__t1_p_n17 gnd__t2_p_n17 sky130_fd_pr__nfet_01v8 L=0.15 W=0.42 nf=1 ad=0.1197 as=0.1197 pd=1.41 ps=1.41 mult=1 m=1
xm4_p_n17 rwl_0__t0_p_n17 n10__t1_p_n17 rbl_3__t1_p_n17 gnd__t3_p_n17 sky130_fd_pr__nfet_01v8 L=0.15 W=0.42 nf=1 ad=0.1197 as=0.1197 pd=1.41 ps=1.41 mult=1 m=1
xm5_p_n17 bl_0__t0_p_n17 wl_0__t0_p_n17 n7__t1_p_n17 gnd__t8_p_n17 sky130_fd_pr__nfet_01v8 L=0.15 W=0.42 nf=1 ad=0.0588 as=0.1197 pd=0.7 ps=1.41 mult=1 m=1
xm6_p_n17 n17__t0_p_n17 wl_1__t0_p_n17 bl_0__t1_p_n17 gnd__t20_p_n17 sky130_fd_pr__nfet_01v8 L=0.15 W=0.42 nf=1 ad=0.1197 as=0.0588 pd=1.41 ps=0.7 mult=1 m=1
xm7_p_n17 bl_1__t2_p_n17 wl_0__t3_p_n17 n8__t0_p_n17 gnd__t9_p_n17 sky130_fd_pr__nfet_01v8 L=0.15 W=0.42 nf=1 ad=0.0588 as=0.1197 pd=0.7 ps=1.41 mult=1 m=1
xm8_p_n17 n18__t0_p_n17 wl_1__t1_p_n17 bl_1__t0_p_n17 gnd__t21_p_n17 sky130_fd_pr__nfet_01v8 L=0.15 W=0.42 nf=1 ad=0.1197 as=0.0588 pd=1.41 ps=0.7 mult=1 m=1
xm9_p_n17 bl_2__t2_p_n17 wl_0__t2_p_n17 n9__t0_p_n17 gnd__t10_p_n17 sky130_fd_pr__nfet_01v8 L=0.15 W=0.42 nf=1 ad=0.0588 as=0.1197 pd=0.7 ps=1.41 mult=1 m=1
xm10_p_n17 n19__t0_p_n17 wl_1__t2_p_n17 bl_2__t0_p_n17 gnd__t22_p_n17 sky130_fd_pr__nfet_01v8 L=0.15 W=0.42 nf=1 ad=0.1197 as=0.0588 pd=1.41 ps=0.7 mult=1 m=1
xm11_p_n17 bl_3__t2_p_n17 wl_0__t1_p_n17 n10__t0_p_n17 gnd__t11_p_n17 sky130_fd_pr__nfet_01v8 L=0.15 W=0.42 nf=1 ad=0.0588 as=0.1197 pd=0.7 ps=1.41 mult=1 m=1
xm12_p_n17 n20__t0_p_n17 wl_1__t3_p_n17 bl_3__t1_p_n17 gnd__t23_p_n17 sky130_fd_pr__nfet_01v8 L=0.15 W=0.42 nf=1 ad=0.1197 as=0.0588 pd=1.41 ps=0.7 mult=1 m=1
xm13_p_n17 rbl_0__t3_p_n17 n17__t1_p_n17 rwl_1__t0_p_n17 gnd__t12_p_n17 sky130_fd_pr__nfet_01v8 L=0.15 W=0.42 nf=1 ad=0.0588 as=0.1197 pd=0.7 ps=1.41 mult=1 m=1
xm14_p_n17 rwl_2__t3_p_n17 n22__t0_p_n17 rbl_0__t2_p_n17 gnd__t24_p_n17 sky130_fd_pr__nfet_01v8 L=0.15 W=0.42 nf=1 ad=0.1197 as=0.0588 pd=1.41 ps=0.7 mult=1 m=1
xm15_p_n17 rbl_1__t3_p_n17 n18__t1_p_n17 rwl_1__t1_p_n17 gnd__t13_p_n17 sky130_fd_pr__nfet_01v8 L=0.15 W=0.42 nf=1 ad=0.0588 as=0.1197 pd=0.7 ps=1.41 mult=1 m=1
xm16_p_n17 rwl_2__t0_p_n17 n23__t0_p_n17 rbl_1__t2_p_n17 gnd__t25_p_n17 sky130_fd_pr__nfet_01v8 L=0.15 W=0.42 nf=1 ad=0.1197 as=0.0588 pd=1.41 ps=0.7 mult=1 m=1
xm17_p_n17 rbl_2__t3_p_n17 n19__t1_p_n17 rwl_1__t2_p_n17 gnd__t14_p_n17 sky130_fd_pr__nfet_01v8 L=0.15 W=0.42 nf=1 ad=0.0588 as=0.1197 pd=0.7 ps=1.41 mult=1 m=1
xm18_p_n17 rwl_2__t1_p_n17 n24__t0_p_n17 rbl_2__t2_p_n17 gnd__t26_p_n17 sky130_fd_pr__nfet_01v8 L=0.15 W=0.42 nf=1 ad=0.1197 as=0.0588 pd=1.41 ps=0.7 mult=1 m=1
xm19_p_n17 rbl_3__t3_p_n17 n20__t1_p_n17 rwl_1__t3_p_n17 gnd__t15_p_n17 sky130_fd_pr__nfet_01v8 L=0.15 W=0.42 nf=1 ad=0.0588 as=0.1197 pd=0.7 ps=1.41 mult=1 m=1
xm20_p_n17 rwl_2__t2_p_n17 n25__t0_p_n17 rbl_3__t2_p_n17 gnd__t27_p_n17 sky130_fd_pr__nfet_01v8 L=0.15 W=0.42 nf=1 ad=0.1197 as=0.0588 pd=1.41 ps=0.7 mult=1 m=1
xm21_p_n17 bl_0__t3_p_n17 wl_2__t0_p_n17 n22__t1_p_n17 gnd__t16_p_n17 sky130_fd_pr__nfet_01v8 L=0.15 W=0.42 nf=1 ad=0.0588 as=0.1197 pd=0.7 ps=1.41 mult=1 m=1
xm22_p_n17 n29__t0_p_n17 wl_3__t3_p_n17 bl_0__t2_p_n17 gnd__t28_p_n17 sky130_fd_pr__nfet_01v8 L=0.15 W=0.42 nf=1 ad=0.1197 as=0.0588 pd=1.41 ps=0.7 mult=1 m=1
xm23_p_n17 bl_1__t3_p_n17 wl_2__t1_p_n17 n23__t1_p_n17 gnd__t17_p_n17 sky130_fd_pr__nfet_01v8 L=0.15 W=0.42 nf=1 ad=0.0588 as=0.1197 pd=0.7 ps=1.41 mult=1 m=1
xm24_p_n17 n30__t0_p_n17 wl_3__t2_p_n17 bl_1__t1_p_n17 gnd__t29_p_n17 sky130_fd_pr__nfet_01v8 L=0.15 W=0.42 nf=1 ad=0.1197 as=0.0588 pd=1.41 ps=0.7 mult=1 m=1
xm25_p_n17 bl_2__t3_p_n17 wl_2__t2_p_n17 n24__t1_p_n17 gnd__t18_p_n17 sky130_fd_pr__nfet_01v8 L=0.15 W=0.42 nf=1 ad=0.0588 as=0.1197 pd=0.7 ps=1.41 mult=1 m=1
xm26_p_n17 n31__t0_p_n17 wl_3__t1_p_n17 bl_2__t1_p_n17 gnd__t30_p_n17 sky130_fd_pr__nfet_01v8 L=0.15 W=0.42 nf=1 ad=0.1197 as=0.0588 pd=1.41 ps=0.7 mult=1 m=1
xm27_p_n17 bl_3__t3_p_n17 wl_2__t3_p_n17 n25__t1_p_n17 gnd__t19_p_n17 sky130_fd_pr__nfet_01v8 L=0.15 W=0.42 nf=1 ad=0.0588 as=0.1197 pd=0.7 ps=1.41 mult=1 m=1
xm28_p_n17 n32__t0_p_n17 wl_3__t0_p_n17 bl_3__t0_p_n17 gnd__t31_p_n17 sky130_fd_pr__nfet_01v8 L=0.15 W=0.42 nf=1 ad=0.1197 as=0.0588 pd=1.41 ps=0.7 mult=1 m=1
xm29_p_n17 rbl_0__t1_p_n17 n29__t1_p_n17 rwl_3__t0_p_n17 gnd__t4_p_n17 sky130_fd_pr__nfet_01v8 L=0.15 W=0.42 nf=1 ad=0.1197 as=0.1197 pd=1.41 ps=1.41 mult=1 m=1
xm30_p_n17 rbl_1__t0_p_n17 n30__t1_p_n17 rwl_3__t1_p_n17 gnd__t5_p_n17 sky130_fd_pr__nfet_01v8 L=0.15 W=0.42 nf=1 ad=0.1197 as=0.1197 pd=1.41 ps=1.41 mult=1 m=1
xm31_p_n17 rbl_2__t0_p_n17 n31__t1_p_n17 rwl_3__t2_p_n17 gnd__t6_p_n17 sky130_fd_pr__nfet_01v8 L=0.15 W=0.42 nf=1 ad=0.1197 as=0.1197 pd=1.41 ps=1.41 mult=1 m=1
xm32_p_n17 rbl_3__t0_p_n17 n32__t1_p_n17 rwl_3__t3_p_n17 gnd__t7_p_n17 sky130_fd_pr__nfet_01v8 L=0.15 W=0.42 nf=1 ad=0.1197 as=0.1197 pd=1.41 ps=1.41 mult=1 m=1
r_10_t0_p_n17 n10__t0_p_n17 n10_p_n17 183.071
r_10_t1_p_n17 n10__t1_p_n17 n10_p_n17 183.071
r_17_t0_p_n17 n17__t0_p_n17 n17_p_n17 183.071
r_17_t1_p_n17 n17__t1_p_n17 n17_p_n17 183.071
r_18_t0_p_n17 n18__t0_p_n17 n18_p_n17 183.071
r_18_t1_p_n17 n18__t1_p_n17 n18_p_n17 183.071
r_19_t0_p_n17 n19__t0_p_n17 n19_p_n17 183.071
r_19_t1_p_n17 n19__t1_p_n17 n19_p_n17 183.071
r_20_t0_p_n17 n20__t0_p_n17 n20_p_n17 183.071
r_20_t1_p_n17 n20__t1_p_n17 n20_p_n17 183.071
r_22_t0_p_n17 n22__t0_p_n17 n22_p_n17 183.071
r_22_t1_p_n17 n22__t1_p_n17 n22_p_n17 183.071
r_23_t0_p_n17 n23__t0_p_n17 n23_p_n17 183.071
r_23_t1_p_n17 n23__t1_p_n17 n23_p_n17 183.071
r_24_t0_p_n17 n24__t0_p_n17 n24_p_n17 183.071
r_24_t1_p_n17 n24__t1_p_n17 n24_p_n17 183.071
r_25_t0_p_n17 n25__t0_p_n17 n25_p_n17 183.071
r_25_t1_p_n17 n25__t1_p_n17 n25_p_n17 183.071
r_29_t0_p_n17 n29__t0_p_n17 n29_p_n17 183.071
r_29_t1_p_n17 n29__t1_p_n17 n29_p_n17 183.071
r_30_t0_p_n17 n30__t0_p_n17 n30_p_n17 183.071
r_30_t1_p_n17 n30__t1_p_n17 n30_p_n17 183.071
r_31_t0_p_n17 n31__t0_p_n17 n31_p_n17 183.071
r_31_t1_p_n17 n31__t1_p_n17 n31_p_n17 183.071
r_32_t0_p_n17 n32__t0_p_n17 n32_p_n17 183.071
r_32_t1_p_n17 n32__t1_p_n17 n32_p_n17 183.071
r_7_t0_p_n17 n7__t0_p_n17 n7_p_n17 183.071
r_7_t1_p_n17 n7__t1_p_n17 n7_p_n17 183.071
r_8_t0_p_n17 n8__t0_p_n17 n8_p_n17 183.071
r_8_t1_p_n17 n8__t1_p_n17 n8_p_n17 183.071
r_9_t0_p_n17 n9__t0_p_n17 n9_p_n17 183.071
r_9_t1_p_n17 n9__t1_p_n17 n9_p_n17 183.071
rgnd_t0_p_n17 gnd__t0_p_n17 0 38.2988
rgnd_t1_p_n17 gnd__t1_p_n17 0 33.9576
rgnd_t2_p_n17 gnd__t2_p_n17 0 33.9576
rgnd_t3_p_n17 gnd__t3_p_n17 0 38.2988
rgnd_t4_p_n17 gnd__t4_p_n17 0 38.2988
rgnd_t5_p_n17 gnd__t5_p_n17 0 33.9576
rgnd_t6_p_n17 gnd__t6_p_n17 0 33.9576
rgnd_t7_p_n17 gnd__t7_p_n17 0 38.2988
rgnd_t8_p_n17 gnd__t8_p_n17 0 28.0185
rgnd_t9_p_n17 gnd__t9_p_n17 0 21.7106
rgnd_t10_p_n17 gnd__t10_p_n17 0 21.7106
rgnd_t11_p_n17 gnd__t11_p_n17 0 28.0185
rgnd_t12_p_n17 gnd__t12_p_n17 0 18.9833
rgnd_t13_p_n17 gnd__t13_p_n17 0 6.8325
rgnd_t14_p_n17 gnd__t14_p_n17 0 6.8325
rgnd_t15_p_n17 gnd__t15_p_n17 0 18.9833
rgnd_t16_p_n17 gnd__t16_p_n17 0 24.2409
rgnd_t17_p_n17 gnd__t17_p_n17 0 16.5511
rgnd_t18_p_n17 gnd__t18_p_n17 0 16.5511
rgnd_t19_p_n17 gnd__t19_p_n17 0 24.2409
rgnd_t20_p_n17 gnd__t20_p_n17 0 24.2409
rgnd_t21_p_n17 gnd__t21_p_n17 0 16.5511
rgnd_t22_p_n17 gnd__t22_p_n17 0 16.5511
rgnd_t23_p_n17 gnd__t23_p_n17 0 24.2409
rgnd_t24_p_n17 gnd__t24_p_n17 0 18.9833
rgnd_t25_p_n17 gnd__t25_p_n17 0 6.8325
rgnd_t26_p_n17 gnd__t26_p_n17 0 6.8325
rgnd_t27_p_n17 gnd__t27_p_n17 0 18.9833
rgnd_t28_p_n17 gnd__t28_p_n17 0 28.0185
rgnd_t29_p_n17 gnd__t29_p_n17 0 21.7106
rgnd_t30_p_n17 gnd__t30_p_n17 0 21.7106
rgnd_t31_p_n17 gnd__t31_p_n17 0 28.0185
rbl_0_t0_p_n17 bl_0__t0_p_n17 bl_0_p_n17 14.8304
rbl_0_t1_p_n17 bl_0__t1_p_n17 bl_0_p_n17 10.9301
rbl_0_t2_p_n17 bl_0__t2_p_n17 bl_0_p_n17 14.8304
rbl_0_t3_p_n17 bl_0__t3_p_n17 bl_0_p_n17 10.9301
rbl_1_t0_p_n17 bl_1__t0_p_n17 bl_1_p_n17 10.9301
rbl_1_t1_p_n17 bl_1__t1_p_n17 bl_1_p_n17 14.8304
rbl_1_t2_p_n17 bl_1__t2_p_n17 bl_1_p_n17 14.8304
rbl_1_t3_p_n17 bl_1__t3_p_n17 bl_1_p_n17 10.9301
rbl_2_t0_p_n17 bl_2__t0_p_n17 bl_2_p_n17 10.9301
rbl_2_t1_p_n17 bl_2__t1_p_n17 bl_2_p_n17 14.8304
rbl_2_t2_p_n17 bl_2__t2_p_n17 bl_2_p_n17 14.8304
rbl_2_t3_p_n17 bl_2__t3_p_n17 bl_2_p_n17 10.9301
rbl_3_t0_p_n17 bl_3__t0_p_n17 bl_3_p_n17 14.8304
rbl_3_t1_p_n17 bl_3__t1_p_n17 bl_3_p_n17 10.9301
rbl_3_t2_p_n17 bl_3__t2_p_n17 bl_3_p_n17 14.8304
rbl_3_t3_p_n17 bl_3__t3_p_n17 bl_3_p_n17 10.9301
rrbl_0_t0_p_n17 rbl_0__t0_p_n17 rbl_0_p_n17 36.5601
rrbl_0_t1_p_n17 rbl_0__t1_p_n17 rbl_0_p_n17 36.5601
rrbl_0_t2_p_n17 rbl_0__t2_p_n17 rbl_0_p_n17 2.99444
rrbl_0_t3_p_n17 rbl_0__t3_p_n17 rbl_0_p_n17 2.99444
rrbl_1_t0_p_n17 rbl_1__t0_p_n17 rbl_1_p_n17 36.5601
rrbl_1_t1_p_n17 rbl_1__t1_p_n17 rbl_1_p_n17 36.5601
rrbl_1_t2_p_n17 rbl_1__t2_p_n17 rbl_1_p_n17 2.99444
rrbl_1_t3_p_n17 rbl_1__t3_p_n17 rbl_1_p_n17 2.99444
rrbl_2_t0_p_n17 rbl_2__t0_p_n17 rbl_2_p_n17 36.5601
rrbl_2_t1_p_n17 rbl_2__t1_p_n17 rbl_2_p_n17 36.5601
rrbl_2_t2_p_n17 rbl_2__t2_p_n17 rbl_2_p_n17 2.99444
rrbl_2_t3_p_n17 rbl_2__t3_p_n17 rbl_2_p_n17 2.99444
rrbl_3_t0_p_n17 rbl_3__t0_p_n17 rbl_3_p_n17 36.5601
rrbl_3_t1_p_n17 rbl_3__t1_p_n17 rbl_3_p_n17 36.5601
rrbl_3_t2_p_n17 rbl_3__t2_p_n17 rbl_3_p_n17 2.99444
rrbl_3_t3_p_n17 rbl_3__t3_p_n17 rbl_3_p_n17 2.99444
rrwl_0_t0_p_n17 rwl_0__t0_p_n17 rwl_0_p_n17 38.2618
rrwl_0_t1_p_n17 rwl_0__t1_p_n17 rwl_0_p_n17 12.7539
rrwl_0_t2_p_n17 rwl_0__t2_p_n17 rwl_0_p_n17 38.2618
rrwl_0_t3_p_n17 rwl_0__t3_p_n17 rwl_0_p_n17 12.7539
rrwl_1_t0_p_n17 rwl_1__t0_p_n17 rwl_1_p_n17 38.2618
rrwl_1_t1_p_n17 rwl_1__t1_p_n17 rwl_1_p_n17 12.7539
rrwl_1_t2_p_n17 rwl_1__t2_p_n17 rwl_1_p_n17 12.7539
rrwl_1_t3_p_n17 rwl_1__t3_p_n17 rwl_1_p_n17 38.2618
rrwl_2_t0_p_n17 rwl_2__t0_p_n17 rwl_2_p_n17 12.7539
rrwl_2_t1_p_n17 rwl_2__t1_p_n17 rwl_2_p_n17 12.7539
rrwl_2_t2_p_n17 rwl_2__t2_p_n17 rwl_2_p_n17 38.2618
rrwl_2_t3_p_n17 rwl_2__t3_p_n17 rwl_2_p_n17 38.2618
rrwl_3_t0_p_n17 rwl_3__t0_p_n17 rwl_3_p_n17 38.2618
rrwl_3_t1_p_n17 rwl_3__t1_p_n17 rwl_3_p_n17 12.7539
rrwl_3_t2_p_n17 rwl_3__t2_p_n17 rwl_3_p_n17 12.7539
rrwl_3_t3_p_n17 rwl_3__t3_p_n17 rwl_3_p_n17 38.2618
rwl_0_t0_p_n17 wl_0__t0_p_n17 wl_0_p_n17 245.959
rwl_0_t1_p_n17 wl_0__t1_p_n17 wl_0_p_n17 245.959
rwl_0_t2_p_n17 wl_0__t2_p_n17 wl_0_p_n17 81.9864
rwl_0_t3_p_n17 wl_0__t3_p_n17 wl_0_p_n17 81.9864
rwl_1_t0_p_n17 wl_1__t0_p_n17 wl_1_p_n17 245.959
rwl_1_t1_p_n17 wl_1__t1_p_n17 wl_1_p_n17 81.9864
rwl_1_t2_p_n17 wl_1__t2_p_n17 wl_1_p_n17 81.9864
rwl_1_t3_p_n17 wl_1__t3_p_n17 wl_1_p_n17 245.959
rwl_2_t0_p_n17 wl_2__t0_p_n17 wl_2_p_n17 245.959
rwl_2_t1_p_n17 wl_2__t1_p_n17 wl_2_p_n17 81.9864
rwl_2_t2_p_n17 wl_2__t2_p_n17 wl_2_p_n17 81.9864
rwl_2_t3_p_n17 wl_2__t3_p_n17 wl_2_p_n17 245.959
rwl_3_t0_p_n17 wl_3__t0_p_n17 wl_3_p_n17 245.959
rwl_3_t1_p_n17 wl_3__t1_p_n17 wl_3_p_n17 81.9864
rwl_3_t2_p_n17 wl_3__t2_p_n17 wl_3_p_n17 81.9864
rwl_3_t3_p_n17 wl_3__t3_p_n17 wl_3_p_n17 245.959
c_10_p_n17 n10_p_n17 0 2.91622e-16
c_17_p_n17 n17_p_n17 0 1.1371e-16
c_18_p_n17 n18_p_n17 0 2.91528e-16
c_19_p_n17 n19_p_n17 0 2.91528e-16
c_20_p_n17 n20_p_n17 0 2.91622e-16
c_22_p_n17 n22_p_n17 0 2.91528e-16
c_23_p_n17 n23_p_n17 0 2.91528e-16
c_24_p_n17 n24_p_n17 0 2.91528e-16
c_25_p_n17 n25_p_n17 0 2.91622e-16
c_29_p_n17 n29_p_n17 0 2.91528e-16
c_30_p_n17 n30_p_n17 0 2.91528e-16
c_31_p_n17 n31_p_n17 0 2.91528e-16
c_32_p_n17 n32_p_n17 0 2.91622e-16
c_7_p_n17 n7_p_n17 0 2.91528e-16
c_8_p_n17 n8_p_n17 0 2.91528e-16
c_9_p_n17 n9_p_n17 0 2.91528e-16
cgnd_p_n17 0 0 2.48166e-15
cbl_0_p_n17 bl_0_p_n17 0 4.52661e-16
cbl_1_p_n17 bl_1_p_n17 0 4.52661e-16
cbl_2_p_n17 bl_2_p_n17 0 4.52661e-16
cbl_3_p_n17 bl_3_p_n17 0 4.52661e-16
crbl_0_p_n17 rbl_0_p_n17 0 9.14472e-16
crbl_1_p_n17 rbl_1_p_n17 0 9.14472e-16
crbl_2_p_n17 rbl_2_p_n17 0 9.14472e-16
crbl_3_p_n17 rbl_3_p_n17 0 9.17566e-16
crwl_0_p_n17 rwl_0_p_n17 0 5.19495e-16
crwl_1_p_n17 rwl_1_p_n17 0 5.11719e-16
crwl_2_p_n17 rwl_2_p_n17 0 5.11719e-16
crwl_3_p_n17 rwl_3_p_n17 0 5.19495e-16
cwl_0_p_n17 wl_0_p_n17 0 3.30388e-16
cwl_1_p_n17 wl_1_p_n17 0 3.30388e-16
cwl_2_p_n17 wl_2_p_n17 0 3.30388e-16
cwl_3_p_n17 wl_3_p_n17 0 3.30388e-16
ccc__10__9_p_n17 n10_p_n17 n9_p_n17 1.02e-17
ccc__10_bl_3_p_n17 n10_p_n17 bl_3_p_n17 1.3999e-17
ccc__10_rwl_0_p_n17 n10_p_n17 rwl_0_p_n17 4.335e-18
ccc__17__18_p_n17 n17_p_n17 n18_p_n17 1.02e-17
ccc__17_bl_0_p_n17 n17_p_n17 bl_0_p_n17 8.415e-18
ccc__17_rwl_1_p_n17 n17_p_n17 rwl_1_p_n17 1.3194e-17
ccc__18__19_p_n17 n18_p_n17 n19_p_n17 1.02e-17
ccc__18_bl_1_p_n17 n18_p_n17 bl_1_p_n17 8.415e-18
ccc__18_rwl_1_p_n17 n18_p_n17 rwl_1_p_n17 1.3194e-17
ccc__19__20_p_n17 n19_p_n17 n20_p_n17 1.02e-17
ccc__19_bl_2_p_n17 n19_p_n17 bl_2_p_n17 8.415e-18
ccc__19_rwl_1_p_n17 n19_p_n17 rwl_1_p_n17 1.3194e-17
ccc__20_bl_3_p_n17 n20_p_n17 bl_3_p_n17 8.415e-18
ccc__20_rwl_1_p_n17 n20_p_n17 rwl_1_p_n17 6.655e-18
ccc__22__23_p_n17 n22_p_n17 n23_p_n17 1.02e-17
ccc__22_bl_0_p_n17 n22_p_n17 bl_0_p_n17 8.415e-18
ccc__22_rwl_2_p_n17 n22_p_n17 rwl_2_p_n17 1.3194e-17
ccc__23__24_p_n17 n23_p_n17 n24_p_n17 1.02e-17
ccc__23_bl_1_p_n17 n23_p_n17 bl_1_p_n17 8.415e-18
ccc__23_rwl_2_p_n17 n23_p_n17 rwl_2_p_n17 1.3194e-17
ccc__24__25_p_n17 n24_p_n17 n25_p_n17 1.02e-17
ccc__24_bl_2_p_n17 n24_p_n17 bl_2_p_n17 8.415e-18
ccc__24_rwl_2_p_n17 n24_p_n17 rwl_2_p_n17 1.3194e-17
ccc__25_bl_3_p_n17 n25_p_n17 bl_3_p_n17 8.415e-18
ccc__25_rwl_2_p_n17 n25_p_n17 rwl_2_p_n17 6.655e-18
ccc__29__30_p_n17 n29_p_n17 n30_p_n17 1.02e-17
ccc__29_bl_0_p_n17 n29_p_n17 bl_0_p_n17 8.415e-18
ccc__29_rwl_3_p_n17 n29_p_n17 rwl_3_p_n17 1.3194e-17
ccc__30__31_p_n17 n30_p_n17 n31_p_n17 1.02e-17
ccc__30_bl_1_p_n17 n30_p_n17 bl_1_p_n17 8.415e-18
ccc__30_rwl_3_p_n17 n30_p_n17 rwl_3_p_n17 1.3194e-17
ccc__31__32_p_n17 n31_p_n17 n32_p_n17 1.02e-17
ccc__31_bl_2_p_n17 n31_p_n17 bl_2_p_n17 8.415e-18
ccc__31_rwl_3_p_n17 n31_p_n17 rwl_3_p_n17 1.3194e-17
ccc__32_bl_3_p_n17 n32_p_n17 bl_3_p_n17 8.415e-18
ccc__32_rwl_3_p_n17 n32_p_n17 rwl_3_p_n17 6.655e-18
ccc__7__8_p_n17 n7_p_n17 n8_p_n17 1.02e-17
ccc__7_bl_0_p_n17 n7_p_n17 bl_0_p_n17 1.3999e-17
ccc__7_rwl_0_p_n17 n7_p_n17 rwl_0_p_n17 8.961e-18
ccc__8__9_p_n17 n8_p_n17 n9_p_n17 1.02e-17
ccc__8_bl_1_p_n17 n8_p_n17 bl_1_p_n17 1.3999e-17
ccc__8_rwl_0_p_n17 n8_p_n17 rwl_0_p_n17 8.961e-18
ccc__9_bl_2_p_n17 n9_p_n17 bl_2_p_n17 1.3999e-17
ccc__9_rwl_0_p_n17 n9_p_n17 rwl_0_p_n17 8.961e-18
ccc_bl_0_rbl_0_p_n17 bl_0_p_n17 rbl_0_p_n17 1.88693e-16
ccc_bl_0_rwl_1_p_n17 bl_0_p_n17 rwl_1_p_n17 1.0093e-17
ccc_bl_0_rwl_2_p_n17 bl_0_p_n17 rwl_2_p_n17 1.0093e-17
ccc_bl_1_rbl_0_p_n17 bl_1_p_n17 rbl_0_p_n17 1.633e-16
ccc_bl_1_rbl_1_p_n17 bl_1_p_n17 rbl_1_p_n17 1.88693e-16
ccc_bl_1_rwl_1_p_n17 bl_1_p_n17 rwl_1_p_n17 1.0093e-17
ccc_bl_1_rwl_2_p_n17 bl_1_p_n17 rwl_2_p_n17 1.0093e-17
ccc_bl_2_rbl_1_p_n17 bl_2_p_n17 rbl_1_p_n17 1.633e-16
ccc_bl_2_rbl_2_p_n17 bl_2_p_n17 rbl_2_p_n17 1.88693e-16
ccc_bl_2_rwl_1_p_n17 bl_2_p_n17 rwl_1_p_n17 1.0093e-17
ccc_bl_2_rwl_2_p_n17 bl_2_p_n17 rwl_2_p_n17 1.0093e-17
ccc_bl_3_rbl_2_p_n17 bl_3_p_n17 rbl_2_p_n17 1.633e-16
ccc_bl_3_rbl_3_p_n17 bl_3_p_n17 rbl_3_p_n17 1.88693e-16
ccc_bl_3_rwl_1_p_n17 bl_3_p_n17 rwl_1_p_n17 1.0093e-17
ccc_bl_3_rwl_2_p_n17 bl_3_p_n17 rwl_2_p_n17 1.0093e-17
ccc_rbl_0_rbl_1_p_n17 rbl_0_p_n17 rbl_1_p_n17 3.432e-17
ccc_rbl_0_rwl_0_p_n17 rbl_0_p_n17 rwl_0_p_n17 4.9752e-17
ccc_rbl_0_rwl_1_p_n17 rbl_0_p_n17 rwl_1_p_n17 4.9752e-17
ccc_rbl_0_rwl_2_p_n17 rbl_0_p_n17 rwl_2_p_n17 4.9752e-17
ccc_rbl_0_rwl_3_p_n17 rbl_0_p_n17 rwl_3_p_n17 4.9752e-17
ccc_rbl_1_rbl_2_p_n17 rbl_1_p_n17 rbl_2_p_n17 3.432e-17
ccc_rbl_1_rwl_0_p_n17 rbl_1_p_n17 rwl_0_p_n17 4.9752e-17
ccc_rbl_1_rwl_1_p_n17 rbl_1_p_n17 rwl_1_p_n17 4.9752e-17
ccc_rbl_1_rwl_2_p_n17 rbl_1_p_n17 rwl_2_p_n17 4.9752e-17
ccc_rbl_1_rwl_3_p_n17 rbl_1_p_n17 rwl_3_p_n17 4.9752e-17
ccc_rbl_2_rbl_3_p_n17 rbl_2_p_n17 rbl_3_p_n17 3.432e-17
ccc_rbl_2_rwl_0_p_n17 rbl_2_p_n17 rwl_0_p_n17 4.9752e-17
ccc_rbl_2_rwl_1_p_n17 rbl_2_p_n17 rwl_1_p_n17 4.9752e-17
ccc_rbl_2_rwl_2_p_n17 rbl_2_p_n17 rwl_2_p_n17 4.9752e-17
ccc_rbl_2_rwl_3_p_n17 rbl_2_p_n17 rwl_3_p_n17 4.9752e-17
ccc_rbl_3_rwl_0_p_n17 rbl_3_p_n17 rwl_0_p_n17 3.3407e-17
ccc_rbl_3_rwl_1_p_n17 rbl_3_p_n17 rwl_1_p_n17 3.3407e-17
ccc_rbl_3_rwl_2_p_n17 rbl_3_p_n17 rwl_2_p_n17 3.3407e-17
ccc_rbl_3_rwl_3_p_n17 rbl_3_p_n17 rwl_3_p_n17 3.3407e-17
vdw_p_n17_0 wl_0_p_n17 0 dc 0
vdr_p_n17_0 rwl_0_p_n17 vdd dc 0
vdw_p_n17_1 wl_1_p_n17 0 dc 0
vdr_p_n17_1 rwl_1_p_n17 vdd dc 0
vdw_p_n17_2 wl_2_p_n17 0 dc 0
vdr_p_n17_2 rwl_2_p_n17 vdd dc 0
vdw_p_n17_3 wl_3_p_n17 0 dc 0
vdr_p_n17_3 rwl_3_p_n17 vdd dc 0
vdb_p_n17_0 bl_0_p_n17 0 dc 0
vdp_p_n17_0 rbl_0_p_n17 vrbl dc 0
vdb_p_n17_1 bl_1_p_n17 0 dc 0
vdp_p_n17_1 rbl_1_p_n17 vrbl dc 0
vdb_p_n17_2 bl_2_p_n17 0 dc 0
vdp_p_n17_2 rbl_2_p_n17 vrbl dc 0
vdb_p_n17_3 bl_3_p_n17 0 dc 0
vdp_p_n17_3 rbl_3_p_n17 vrbl dc 0
vdn_p_n17_n7 n7_p_n17 0 dc 1
vdn_p_n17_n8 n8_p_n17 0 dc 1
vdn_p_n17_n9 n9_p_n17 0 dc 1
vdn_p_n17_n10 n10_p_n17 0 dc 1
vdn_p_n17_n18 n18_p_n17 0 dc 1
vdn_p_n17_n19 n19_p_n17 0 dc 1
vdn_p_n17_n20 n20_p_n17 0 dc 1
vdn_p_n17_n22 n22_p_n17 0 dc 1
vdn_p_n17_n23 n23_p_n17 0 dc 1
vdn_p_n17_n24 n24_p_n17 0 dc 1
vdn_p_n17_n25 n25_p_n17 0 dc 1
vdn_p_n17_n29 n29_p_n17 0 dc 1
vdn_p_n17_n30 n30_p_n17 0 dc 1
vdn_p_n17_n31 n31_p_n17 0 dc 1
vdn_p_n17_n32 n32_p_n17 0 dc 1
bdr_p_n17 n17_p_n17 0 i=5e-08*min(1,max(0,(time-1e-09)/0.2n))*0.5*(1+tanh((v(n17_p_n17)-0.05)/0.01))

* ---- instance p_n18: variant p, probed storage node \$18 ----
xm1_p_n18 rwl_0__t2_p_n18 n7__t0_p_n18 rbl_0__t0_p_n18 gnd__t0_p_n18 sky130_fd_pr__nfet_01v8 L=0.15 W=0.42 nf=1 ad=0.1197 as=0.1197 pd=1.41 ps=1.41 mult=1 m=1
xm2_p_n18 rwl_0__t3_p_n18 n8__t1_p_n18 rbl_1__t1_p_n18 gnd__t1_p_n18 sky130_fd_pr__nfet_01v8 L=0.15 W=0.42 nf=1 ad=0.1197 as=0.1197 pd=1.41 ps=1.41 mult=1 m=1
xm3_p_n18 rwl_0__t1_p_n18 n9__t1_p_n18 rbl_2__t1_p_n18 gnd__t2_p_n18 sky130_fd_pr__nfet_01v8 L=0.15 W=0.42 nf=1 ad=0.1197 as=0.1197 pd=1.41 ps=1.41 mult=1 m=1
xm4_p_n18 rwl_0__t0_p_n18 n10__t1_p_n18 rbl_3__t1_p_n18 gnd__t3_p_n18 sky130_fd_pr__nfet_01v8 L=0.15 W=0.42 nf=1 ad=0.1197 as=0.1197 pd=1.41 ps=1.41 mult=1 m=1
xm5_p_n18 bl_0__t0_p_n18 wl_0__t0_p_n18 n7__t1_p_n18 gnd__t8_p_n18 sky130_fd_pr__nfet_01v8 L=0.15 W=0.42 nf=1 ad=0.0588 as=0.1197 pd=0.7 ps=1.41 mult=1 m=1
xm6_p_n18 n17__t0_p_n18 wl_1__t0_p_n18 bl_0__t1_p_n18 gnd__t20_p_n18 sky130_fd_pr__nfet_01v8 L=0.15 W=0.42 nf=1 ad=0.1197 as=0.0588 pd=1.41 ps=0.7 mult=1 m=1
xm7_p_n18 bl_1__t2_p_n18 wl_0__t3_p_n18 n8__t0_p_n18 gnd__t9_p_n18 sky130_fd_pr__nfet_01v8 L=0.15 W=0.42 nf=1 ad=0.0588 as=0.1197 pd=0.7 ps=1.41 mult=1 m=1
xm8_p_n18 n18__t0_p_n18 wl_1__t1_p_n18 bl_1__t0_p_n18 gnd__t21_p_n18 sky130_fd_pr__nfet_01v8 L=0.15 W=0.42 nf=1 ad=0.1197 as=0.0588 pd=1.41 ps=0.7 mult=1 m=1
xm9_p_n18 bl_2__t2_p_n18 wl_0__t2_p_n18 n9__t0_p_n18 gnd__t10_p_n18 sky130_fd_pr__nfet_01v8 L=0.15 W=0.42 nf=1 ad=0.0588 as=0.1197 pd=0.7 ps=1.41 mult=1 m=1
xm10_p_n18 n19__t0_p_n18 wl_1__t2_p_n18 bl_2__t0_p_n18 gnd__t22_p_n18 sky130_fd_pr__nfet_01v8 L=0.15 W=0.42 nf=1 ad=0.1197 as=0.0588 pd=1.41 ps=0.7 mult=1 m=1
xm11_p_n18 bl_3__t2_p_n18 wl_0__t1_p_n18 n10__t0_p_n18 gnd__t11_p_n18 sky130_fd_pr__nfet_01v8 L=0.15 W=0.42 nf=1 ad=0.0588 as=0.1197 pd=0.7 ps=1.41 mult=1 m=1
xm12_p_n18 n20__t0_p_n18 wl_1__t3_p_n18 bl_3__t1_p_n18 gnd__t23_p_n18 sky130_fd_pr__nfet_01v8 L=0.15 W=0.42 nf=1 ad=0.1197 as=0.0588 pd=1.41 ps=0.7 mult=1 m=1
xm13_p_n18 rbl_0__t3_p_n18 n17__t1_p_n18 rwl_1__t0_p_n18 gnd__t12_p_n18 sky130_fd_pr__nfet_01v8 L=0.15 W=0.42 nf=1 ad=0.0588 as=0.1197 pd=0.7 ps=1.41 mult=1 m=1
xm14_p_n18 rwl_2__t3_p_n18 n22__t0_p_n18 rbl_0__t2_p_n18 gnd__t24_p_n18 sky130_fd_pr__nfet_01v8 L=0.15 W=0.42 nf=1 ad=0.1197 as=0.0588 pd=1.41 ps=0.7 mult=1 m=1
xm15_p_n18 rbl_1__t3_p_n18 n18__t1_p_n18 rwl_1__t1_p_n18 gnd__t13_p_n18 sky130_fd_pr__nfet_01v8 L=0.15 W=0.42 nf=1 ad=0.0588 as=0.1197 pd=0.7 ps=1.41 mult=1 m=1
xm16_p_n18 rwl_2__t0_p_n18 n23__t0_p_n18 rbl_1__t2_p_n18 gnd__t25_p_n18 sky130_fd_pr__nfet_01v8 L=0.15 W=0.42 nf=1 ad=0.1197 as=0.0588 pd=1.41 ps=0.7 mult=1 m=1
xm17_p_n18 rbl_2__t3_p_n18 n19__t1_p_n18 rwl_1__t2_p_n18 gnd__t14_p_n18 sky130_fd_pr__nfet_01v8 L=0.15 W=0.42 nf=1 ad=0.0588 as=0.1197 pd=0.7 ps=1.41 mult=1 m=1
xm18_p_n18 rwl_2__t1_p_n18 n24__t0_p_n18 rbl_2__t2_p_n18 gnd__t26_p_n18 sky130_fd_pr__nfet_01v8 L=0.15 W=0.42 nf=1 ad=0.1197 as=0.0588 pd=1.41 ps=0.7 mult=1 m=1
xm19_p_n18 rbl_3__t3_p_n18 n20__t1_p_n18 rwl_1__t3_p_n18 gnd__t15_p_n18 sky130_fd_pr__nfet_01v8 L=0.15 W=0.42 nf=1 ad=0.0588 as=0.1197 pd=0.7 ps=1.41 mult=1 m=1
xm20_p_n18 rwl_2__t2_p_n18 n25__t0_p_n18 rbl_3__t2_p_n18 gnd__t27_p_n18 sky130_fd_pr__nfet_01v8 L=0.15 W=0.42 nf=1 ad=0.1197 as=0.0588 pd=1.41 ps=0.7 mult=1 m=1
xm21_p_n18 bl_0__t3_p_n18 wl_2__t0_p_n18 n22__t1_p_n18 gnd__t16_p_n18 sky130_fd_pr__nfet_01v8 L=0.15 W=0.42 nf=1 ad=0.0588 as=0.1197 pd=0.7 ps=1.41 mult=1 m=1
xm22_p_n18 n29__t0_p_n18 wl_3__t3_p_n18 bl_0__t2_p_n18 gnd__t28_p_n18 sky130_fd_pr__nfet_01v8 L=0.15 W=0.42 nf=1 ad=0.1197 as=0.0588 pd=1.41 ps=0.7 mult=1 m=1
xm23_p_n18 bl_1__t3_p_n18 wl_2__t1_p_n18 n23__t1_p_n18 gnd__t17_p_n18 sky130_fd_pr__nfet_01v8 L=0.15 W=0.42 nf=1 ad=0.0588 as=0.1197 pd=0.7 ps=1.41 mult=1 m=1
xm24_p_n18 n30__t0_p_n18 wl_3__t2_p_n18 bl_1__t1_p_n18 gnd__t29_p_n18 sky130_fd_pr__nfet_01v8 L=0.15 W=0.42 nf=1 ad=0.1197 as=0.0588 pd=1.41 ps=0.7 mult=1 m=1
xm25_p_n18 bl_2__t3_p_n18 wl_2__t2_p_n18 n24__t1_p_n18 gnd__t18_p_n18 sky130_fd_pr__nfet_01v8 L=0.15 W=0.42 nf=1 ad=0.0588 as=0.1197 pd=0.7 ps=1.41 mult=1 m=1
xm26_p_n18 n31__t0_p_n18 wl_3__t1_p_n18 bl_2__t1_p_n18 gnd__t30_p_n18 sky130_fd_pr__nfet_01v8 L=0.15 W=0.42 nf=1 ad=0.1197 as=0.0588 pd=1.41 ps=0.7 mult=1 m=1
xm27_p_n18 bl_3__t3_p_n18 wl_2__t3_p_n18 n25__t1_p_n18 gnd__t19_p_n18 sky130_fd_pr__nfet_01v8 L=0.15 W=0.42 nf=1 ad=0.0588 as=0.1197 pd=0.7 ps=1.41 mult=1 m=1
xm28_p_n18 n32__t0_p_n18 wl_3__t0_p_n18 bl_3__t0_p_n18 gnd__t31_p_n18 sky130_fd_pr__nfet_01v8 L=0.15 W=0.42 nf=1 ad=0.1197 as=0.0588 pd=1.41 ps=0.7 mult=1 m=1
xm29_p_n18 rbl_0__t1_p_n18 n29__t1_p_n18 rwl_3__t0_p_n18 gnd__t4_p_n18 sky130_fd_pr__nfet_01v8 L=0.15 W=0.42 nf=1 ad=0.1197 as=0.1197 pd=1.41 ps=1.41 mult=1 m=1
xm30_p_n18 rbl_1__t0_p_n18 n30__t1_p_n18 rwl_3__t1_p_n18 gnd__t5_p_n18 sky130_fd_pr__nfet_01v8 L=0.15 W=0.42 nf=1 ad=0.1197 as=0.1197 pd=1.41 ps=1.41 mult=1 m=1
xm31_p_n18 rbl_2__t0_p_n18 n31__t1_p_n18 rwl_3__t2_p_n18 gnd__t6_p_n18 sky130_fd_pr__nfet_01v8 L=0.15 W=0.42 nf=1 ad=0.1197 as=0.1197 pd=1.41 ps=1.41 mult=1 m=1
xm32_p_n18 rbl_3__t0_p_n18 n32__t1_p_n18 rwl_3__t3_p_n18 gnd__t7_p_n18 sky130_fd_pr__nfet_01v8 L=0.15 W=0.42 nf=1 ad=0.1197 as=0.1197 pd=1.41 ps=1.41 mult=1 m=1
r_10_t0_p_n18 n10__t0_p_n18 n10_p_n18 183.071
r_10_t1_p_n18 n10__t1_p_n18 n10_p_n18 183.071
r_17_t0_p_n18 n17__t0_p_n18 n17_p_n18 183.071
r_17_t1_p_n18 n17__t1_p_n18 n17_p_n18 183.071
r_18_t0_p_n18 n18__t0_p_n18 n18_p_n18 183.071
r_18_t1_p_n18 n18__t1_p_n18 n18_p_n18 183.071
r_19_t0_p_n18 n19__t0_p_n18 n19_p_n18 183.071
r_19_t1_p_n18 n19__t1_p_n18 n19_p_n18 183.071
r_20_t0_p_n18 n20__t0_p_n18 n20_p_n18 183.071
r_20_t1_p_n18 n20__t1_p_n18 n20_p_n18 183.071
r_22_t0_p_n18 n22__t0_p_n18 n22_p_n18 183.071
r_22_t1_p_n18 n22__t1_p_n18 n22_p_n18 183.071
r_23_t0_p_n18 n23__t0_p_n18 n23_p_n18 183.071
r_23_t1_p_n18 n23__t1_p_n18 n23_p_n18 183.071
r_24_t0_p_n18 n24__t0_p_n18 n24_p_n18 183.071
r_24_t1_p_n18 n24__t1_p_n18 n24_p_n18 183.071
r_25_t0_p_n18 n25__t0_p_n18 n25_p_n18 183.071
r_25_t1_p_n18 n25__t1_p_n18 n25_p_n18 183.071
r_29_t0_p_n18 n29__t0_p_n18 n29_p_n18 183.071
r_29_t1_p_n18 n29__t1_p_n18 n29_p_n18 183.071
r_30_t0_p_n18 n30__t0_p_n18 n30_p_n18 183.071
r_30_t1_p_n18 n30__t1_p_n18 n30_p_n18 183.071
r_31_t0_p_n18 n31__t0_p_n18 n31_p_n18 183.071
r_31_t1_p_n18 n31__t1_p_n18 n31_p_n18 183.071
r_32_t0_p_n18 n32__t0_p_n18 n32_p_n18 183.071
r_32_t1_p_n18 n32__t1_p_n18 n32_p_n18 183.071
r_7_t0_p_n18 n7__t0_p_n18 n7_p_n18 183.071
r_7_t1_p_n18 n7__t1_p_n18 n7_p_n18 183.071
r_8_t0_p_n18 n8__t0_p_n18 n8_p_n18 183.071
r_8_t1_p_n18 n8__t1_p_n18 n8_p_n18 183.071
r_9_t0_p_n18 n9__t0_p_n18 n9_p_n18 183.071
r_9_t1_p_n18 n9__t1_p_n18 n9_p_n18 183.071
rgnd_t0_p_n18 gnd__t0_p_n18 0 38.2988
rgnd_t1_p_n18 gnd__t1_p_n18 0 33.9576
rgnd_t2_p_n18 gnd__t2_p_n18 0 33.9576
rgnd_t3_p_n18 gnd__t3_p_n18 0 38.2988
rgnd_t4_p_n18 gnd__t4_p_n18 0 38.2988
rgnd_t5_p_n18 gnd__t5_p_n18 0 33.9576
rgnd_t6_p_n18 gnd__t6_p_n18 0 33.9576
rgnd_t7_p_n18 gnd__t7_p_n18 0 38.2988
rgnd_t8_p_n18 gnd__t8_p_n18 0 28.0185
rgnd_t9_p_n18 gnd__t9_p_n18 0 21.7106
rgnd_t10_p_n18 gnd__t10_p_n18 0 21.7106
rgnd_t11_p_n18 gnd__t11_p_n18 0 28.0185
rgnd_t12_p_n18 gnd__t12_p_n18 0 18.9833
rgnd_t13_p_n18 gnd__t13_p_n18 0 6.8325
rgnd_t14_p_n18 gnd__t14_p_n18 0 6.8325
rgnd_t15_p_n18 gnd__t15_p_n18 0 18.9833
rgnd_t16_p_n18 gnd__t16_p_n18 0 24.2409
rgnd_t17_p_n18 gnd__t17_p_n18 0 16.5511
rgnd_t18_p_n18 gnd__t18_p_n18 0 16.5511
rgnd_t19_p_n18 gnd__t19_p_n18 0 24.2409
rgnd_t20_p_n18 gnd__t20_p_n18 0 24.2409
rgnd_t21_p_n18 gnd__t21_p_n18 0 16.5511
rgnd_t22_p_n18 gnd__t22_p_n18 0 16.5511
rgnd_t23_p_n18 gnd__t23_p_n18 0 24.2409
rgnd_t24_p_n18 gnd__t24_p_n18 0 18.9833
rgnd_t25_p_n18 gnd__t25_p_n18 0 6.8325
rgnd_t26_p_n18 gnd__t26_p_n18 0 6.8325
rgnd_t27_p_n18 gnd__t27_p_n18 0 18.9833
rgnd_t28_p_n18 gnd__t28_p_n18 0 28.0185
rgnd_t29_p_n18 gnd__t29_p_n18 0 21.7106
rgnd_t30_p_n18 gnd__t30_p_n18 0 21.7106
rgnd_t31_p_n18 gnd__t31_p_n18 0 28.0185
rbl_0_t0_p_n18 bl_0__t0_p_n18 bl_0_p_n18 14.8304
rbl_0_t1_p_n18 bl_0__t1_p_n18 bl_0_p_n18 10.9301
rbl_0_t2_p_n18 bl_0__t2_p_n18 bl_0_p_n18 14.8304
rbl_0_t3_p_n18 bl_0__t3_p_n18 bl_0_p_n18 10.9301
rbl_1_t0_p_n18 bl_1__t0_p_n18 bl_1_p_n18 10.9301
rbl_1_t1_p_n18 bl_1__t1_p_n18 bl_1_p_n18 14.8304
rbl_1_t2_p_n18 bl_1__t2_p_n18 bl_1_p_n18 14.8304
rbl_1_t3_p_n18 bl_1__t3_p_n18 bl_1_p_n18 10.9301
rbl_2_t0_p_n18 bl_2__t0_p_n18 bl_2_p_n18 10.9301
rbl_2_t1_p_n18 bl_2__t1_p_n18 bl_2_p_n18 14.8304
rbl_2_t2_p_n18 bl_2__t2_p_n18 bl_2_p_n18 14.8304
rbl_2_t3_p_n18 bl_2__t3_p_n18 bl_2_p_n18 10.9301
rbl_3_t0_p_n18 bl_3__t0_p_n18 bl_3_p_n18 14.8304
rbl_3_t1_p_n18 bl_3__t1_p_n18 bl_3_p_n18 10.9301
rbl_3_t2_p_n18 bl_3__t2_p_n18 bl_3_p_n18 14.8304
rbl_3_t3_p_n18 bl_3__t3_p_n18 bl_3_p_n18 10.9301
rrbl_0_t0_p_n18 rbl_0__t0_p_n18 rbl_0_p_n18 36.5601
rrbl_0_t1_p_n18 rbl_0__t1_p_n18 rbl_0_p_n18 36.5601
rrbl_0_t2_p_n18 rbl_0__t2_p_n18 rbl_0_p_n18 2.99444
rrbl_0_t3_p_n18 rbl_0__t3_p_n18 rbl_0_p_n18 2.99444
rrbl_1_t0_p_n18 rbl_1__t0_p_n18 rbl_1_p_n18 36.5601
rrbl_1_t1_p_n18 rbl_1__t1_p_n18 rbl_1_p_n18 36.5601
rrbl_1_t2_p_n18 rbl_1__t2_p_n18 rbl_1_p_n18 2.99444
rrbl_1_t3_p_n18 rbl_1__t3_p_n18 rbl_1_p_n18 2.99444
rrbl_2_t0_p_n18 rbl_2__t0_p_n18 rbl_2_p_n18 36.5601
rrbl_2_t1_p_n18 rbl_2__t1_p_n18 rbl_2_p_n18 36.5601
rrbl_2_t2_p_n18 rbl_2__t2_p_n18 rbl_2_p_n18 2.99444
rrbl_2_t3_p_n18 rbl_2__t3_p_n18 rbl_2_p_n18 2.99444
rrbl_3_t0_p_n18 rbl_3__t0_p_n18 rbl_3_p_n18 36.5601
rrbl_3_t1_p_n18 rbl_3__t1_p_n18 rbl_3_p_n18 36.5601
rrbl_3_t2_p_n18 rbl_3__t2_p_n18 rbl_3_p_n18 2.99444
rrbl_3_t3_p_n18 rbl_3__t3_p_n18 rbl_3_p_n18 2.99444
rrwl_0_t0_p_n18 rwl_0__t0_p_n18 rwl_0_p_n18 38.2618
rrwl_0_t1_p_n18 rwl_0__t1_p_n18 rwl_0_p_n18 12.7539
rrwl_0_t2_p_n18 rwl_0__t2_p_n18 rwl_0_p_n18 38.2618
rrwl_0_t3_p_n18 rwl_0__t3_p_n18 rwl_0_p_n18 12.7539
rrwl_1_t0_p_n18 rwl_1__t0_p_n18 rwl_1_p_n18 38.2618
rrwl_1_t1_p_n18 rwl_1__t1_p_n18 rwl_1_p_n18 12.7539
rrwl_1_t2_p_n18 rwl_1__t2_p_n18 rwl_1_p_n18 12.7539
rrwl_1_t3_p_n18 rwl_1__t3_p_n18 rwl_1_p_n18 38.2618
rrwl_2_t0_p_n18 rwl_2__t0_p_n18 rwl_2_p_n18 12.7539
rrwl_2_t1_p_n18 rwl_2__t1_p_n18 rwl_2_p_n18 12.7539
rrwl_2_t2_p_n18 rwl_2__t2_p_n18 rwl_2_p_n18 38.2618
rrwl_2_t3_p_n18 rwl_2__t3_p_n18 rwl_2_p_n18 38.2618
rrwl_3_t0_p_n18 rwl_3__t0_p_n18 rwl_3_p_n18 38.2618
rrwl_3_t1_p_n18 rwl_3__t1_p_n18 rwl_3_p_n18 12.7539
rrwl_3_t2_p_n18 rwl_3__t2_p_n18 rwl_3_p_n18 12.7539
rrwl_3_t3_p_n18 rwl_3__t3_p_n18 rwl_3_p_n18 38.2618
rwl_0_t0_p_n18 wl_0__t0_p_n18 wl_0_p_n18 245.959
rwl_0_t1_p_n18 wl_0__t1_p_n18 wl_0_p_n18 245.959
rwl_0_t2_p_n18 wl_0__t2_p_n18 wl_0_p_n18 81.9864
rwl_0_t3_p_n18 wl_0__t3_p_n18 wl_0_p_n18 81.9864
rwl_1_t0_p_n18 wl_1__t0_p_n18 wl_1_p_n18 245.959
rwl_1_t1_p_n18 wl_1__t1_p_n18 wl_1_p_n18 81.9864
rwl_1_t2_p_n18 wl_1__t2_p_n18 wl_1_p_n18 81.9864
rwl_1_t3_p_n18 wl_1__t3_p_n18 wl_1_p_n18 245.959
rwl_2_t0_p_n18 wl_2__t0_p_n18 wl_2_p_n18 245.959
rwl_2_t1_p_n18 wl_2__t1_p_n18 wl_2_p_n18 81.9864
rwl_2_t2_p_n18 wl_2__t2_p_n18 wl_2_p_n18 81.9864
rwl_2_t3_p_n18 wl_2__t3_p_n18 wl_2_p_n18 245.959
rwl_3_t0_p_n18 wl_3__t0_p_n18 wl_3_p_n18 245.959
rwl_3_t1_p_n18 wl_3__t1_p_n18 wl_3_p_n18 81.9864
rwl_3_t2_p_n18 wl_3__t2_p_n18 wl_3_p_n18 81.9864
rwl_3_t3_p_n18 wl_3__t3_p_n18 wl_3_p_n18 245.959
c_10_p_n18 n10_p_n18 0 2.91622e-16
c_17_p_n18 n17_p_n18 0 2.91528e-16
c_18_p_n18 n18_p_n18 0 1.1371e-16
c_19_p_n18 n19_p_n18 0 2.91528e-16
c_20_p_n18 n20_p_n18 0 2.91622e-16
c_22_p_n18 n22_p_n18 0 2.91528e-16
c_23_p_n18 n23_p_n18 0 2.91528e-16
c_24_p_n18 n24_p_n18 0 2.91528e-16
c_25_p_n18 n25_p_n18 0 2.91622e-16
c_29_p_n18 n29_p_n18 0 2.91528e-16
c_30_p_n18 n30_p_n18 0 2.91528e-16
c_31_p_n18 n31_p_n18 0 2.91528e-16
c_32_p_n18 n32_p_n18 0 2.91622e-16
c_7_p_n18 n7_p_n18 0 2.91528e-16
c_8_p_n18 n8_p_n18 0 2.91528e-16
c_9_p_n18 n9_p_n18 0 2.91528e-16
cgnd_p_n18 0 0 2.48166e-15
cbl_0_p_n18 bl_0_p_n18 0 4.52661e-16
cbl_1_p_n18 bl_1_p_n18 0 4.52661e-16
cbl_2_p_n18 bl_2_p_n18 0 4.52661e-16
cbl_3_p_n18 bl_3_p_n18 0 4.52661e-16
crbl_0_p_n18 rbl_0_p_n18 0 9.14472e-16
crbl_1_p_n18 rbl_1_p_n18 0 9.14472e-16
crbl_2_p_n18 rbl_2_p_n18 0 9.14472e-16
crbl_3_p_n18 rbl_3_p_n18 0 9.17566e-16
crwl_0_p_n18 rwl_0_p_n18 0 5.19495e-16
crwl_1_p_n18 rwl_1_p_n18 0 5.11719e-16
crwl_2_p_n18 rwl_2_p_n18 0 5.11719e-16
crwl_3_p_n18 rwl_3_p_n18 0 5.19495e-16
cwl_0_p_n18 wl_0_p_n18 0 3.30388e-16
cwl_1_p_n18 wl_1_p_n18 0 3.30388e-16
cwl_2_p_n18 wl_2_p_n18 0 3.30388e-16
cwl_3_p_n18 wl_3_p_n18 0 3.30388e-16
ccc__10__9_p_n18 n10_p_n18 n9_p_n18 1.02e-17
ccc__10_bl_3_p_n18 n10_p_n18 bl_3_p_n18 1.3999e-17
ccc__10_rwl_0_p_n18 n10_p_n18 rwl_0_p_n18 4.335e-18
ccc__17__18_p_n18 n17_p_n18 n18_p_n18 1.02e-17
ccc__17_bl_0_p_n18 n17_p_n18 bl_0_p_n18 8.415e-18
ccc__17_rwl_1_p_n18 n17_p_n18 rwl_1_p_n18 1.3194e-17
ccc__18__19_p_n18 n18_p_n18 n19_p_n18 1.02e-17
ccc__18_bl_1_p_n18 n18_p_n18 bl_1_p_n18 8.415e-18
ccc__18_rwl_1_p_n18 n18_p_n18 rwl_1_p_n18 1.3194e-17
ccc__19__20_p_n18 n19_p_n18 n20_p_n18 1.02e-17
ccc__19_bl_2_p_n18 n19_p_n18 bl_2_p_n18 8.415e-18
ccc__19_rwl_1_p_n18 n19_p_n18 rwl_1_p_n18 1.3194e-17
ccc__20_bl_3_p_n18 n20_p_n18 bl_3_p_n18 8.415e-18
ccc__20_rwl_1_p_n18 n20_p_n18 rwl_1_p_n18 6.655e-18
ccc__22__23_p_n18 n22_p_n18 n23_p_n18 1.02e-17
ccc__22_bl_0_p_n18 n22_p_n18 bl_0_p_n18 8.415e-18
ccc__22_rwl_2_p_n18 n22_p_n18 rwl_2_p_n18 1.3194e-17
ccc__23__24_p_n18 n23_p_n18 n24_p_n18 1.02e-17
ccc__23_bl_1_p_n18 n23_p_n18 bl_1_p_n18 8.415e-18
ccc__23_rwl_2_p_n18 n23_p_n18 rwl_2_p_n18 1.3194e-17
ccc__24__25_p_n18 n24_p_n18 n25_p_n18 1.02e-17
ccc__24_bl_2_p_n18 n24_p_n18 bl_2_p_n18 8.415e-18
ccc__24_rwl_2_p_n18 n24_p_n18 rwl_2_p_n18 1.3194e-17
ccc__25_bl_3_p_n18 n25_p_n18 bl_3_p_n18 8.415e-18
ccc__25_rwl_2_p_n18 n25_p_n18 rwl_2_p_n18 6.655e-18
ccc__29__30_p_n18 n29_p_n18 n30_p_n18 1.02e-17
ccc__29_bl_0_p_n18 n29_p_n18 bl_0_p_n18 8.415e-18
ccc__29_rwl_3_p_n18 n29_p_n18 rwl_3_p_n18 1.3194e-17
ccc__30__31_p_n18 n30_p_n18 n31_p_n18 1.02e-17
ccc__30_bl_1_p_n18 n30_p_n18 bl_1_p_n18 8.415e-18
ccc__30_rwl_3_p_n18 n30_p_n18 rwl_3_p_n18 1.3194e-17
ccc__31__32_p_n18 n31_p_n18 n32_p_n18 1.02e-17
ccc__31_bl_2_p_n18 n31_p_n18 bl_2_p_n18 8.415e-18
ccc__31_rwl_3_p_n18 n31_p_n18 rwl_3_p_n18 1.3194e-17
ccc__32_bl_3_p_n18 n32_p_n18 bl_3_p_n18 8.415e-18
ccc__32_rwl_3_p_n18 n32_p_n18 rwl_3_p_n18 6.655e-18
ccc__7__8_p_n18 n7_p_n18 n8_p_n18 1.02e-17
ccc__7_bl_0_p_n18 n7_p_n18 bl_0_p_n18 1.3999e-17
ccc__7_rwl_0_p_n18 n7_p_n18 rwl_0_p_n18 8.961e-18
ccc__8__9_p_n18 n8_p_n18 n9_p_n18 1.02e-17
ccc__8_bl_1_p_n18 n8_p_n18 bl_1_p_n18 1.3999e-17
ccc__8_rwl_0_p_n18 n8_p_n18 rwl_0_p_n18 8.961e-18
ccc__9_bl_2_p_n18 n9_p_n18 bl_2_p_n18 1.3999e-17
ccc__9_rwl_0_p_n18 n9_p_n18 rwl_0_p_n18 8.961e-18
ccc_bl_0_rbl_0_p_n18 bl_0_p_n18 rbl_0_p_n18 1.88693e-16
ccc_bl_0_rwl_1_p_n18 bl_0_p_n18 rwl_1_p_n18 1.0093e-17
ccc_bl_0_rwl_2_p_n18 bl_0_p_n18 rwl_2_p_n18 1.0093e-17
ccc_bl_1_rbl_0_p_n18 bl_1_p_n18 rbl_0_p_n18 1.633e-16
ccc_bl_1_rbl_1_p_n18 bl_1_p_n18 rbl_1_p_n18 1.88693e-16
ccc_bl_1_rwl_1_p_n18 bl_1_p_n18 rwl_1_p_n18 1.0093e-17
ccc_bl_1_rwl_2_p_n18 bl_1_p_n18 rwl_2_p_n18 1.0093e-17
ccc_bl_2_rbl_1_p_n18 bl_2_p_n18 rbl_1_p_n18 1.633e-16
ccc_bl_2_rbl_2_p_n18 bl_2_p_n18 rbl_2_p_n18 1.88693e-16
ccc_bl_2_rwl_1_p_n18 bl_2_p_n18 rwl_1_p_n18 1.0093e-17
ccc_bl_2_rwl_2_p_n18 bl_2_p_n18 rwl_2_p_n18 1.0093e-17
ccc_bl_3_rbl_2_p_n18 bl_3_p_n18 rbl_2_p_n18 1.633e-16
ccc_bl_3_rbl_3_p_n18 bl_3_p_n18 rbl_3_p_n18 1.88693e-16
ccc_bl_3_rwl_1_p_n18 bl_3_p_n18 rwl_1_p_n18 1.0093e-17
ccc_bl_3_rwl_2_p_n18 bl_3_p_n18 rwl_2_p_n18 1.0093e-17
ccc_rbl_0_rbl_1_p_n18 rbl_0_p_n18 rbl_1_p_n18 3.432e-17
ccc_rbl_0_rwl_0_p_n18 rbl_0_p_n18 rwl_0_p_n18 4.9752e-17
ccc_rbl_0_rwl_1_p_n18 rbl_0_p_n18 rwl_1_p_n18 4.9752e-17
ccc_rbl_0_rwl_2_p_n18 rbl_0_p_n18 rwl_2_p_n18 4.9752e-17
ccc_rbl_0_rwl_3_p_n18 rbl_0_p_n18 rwl_3_p_n18 4.9752e-17
ccc_rbl_1_rbl_2_p_n18 rbl_1_p_n18 rbl_2_p_n18 3.432e-17
ccc_rbl_1_rwl_0_p_n18 rbl_1_p_n18 rwl_0_p_n18 4.9752e-17
ccc_rbl_1_rwl_1_p_n18 rbl_1_p_n18 rwl_1_p_n18 4.9752e-17
ccc_rbl_1_rwl_2_p_n18 rbl_1_p_n18 rwl_2_p_n18 4.9752e-17
ccc_rbl_1_rwl_3_p_n18 rbl_1_p_n18 rwl_3_p_n18 4.9752e-17
ccc_rbl_2_rbl_3_p_n18 rbl_2_p_n18 rbl_3_p_n18 3.432e-17
ccc_rbl_2_rwl_0_p_n18 rbl_2_p_n18 rwl_0_p_n18 4.9752e-17
ccc_rbl_2_rwl_1_p_n18 rbl_2_p_n18 rwl_1_p_n18 4.9752e-17
ccc_rbl_2_rwl_2_p_n18 rbl_2_p_n18 rwl_2_p_n18 4.9752e-17
ccc_rbl_2_rwl_3_p_n18 rbl_2_p_n18 rwl_3_p_n18 4.9752e-17
ccc_rbl_3_rwl_0_p_n18 rbl_3_p_n18 rwl_0_p_n18 3.3407e-17
ccc_rbl_3_rwl_1_p_n18 rbl_3_p_n18 rwl_1_p_n18 3.3407e-17
ccc_rbl_3_rwl_2_p_n18 rbl_3_p_n18 rwl_2_p_n18 3.3407e-17
ccc_rbl_3_rwl_3_p_n18 rbl_3_p_n18 rwl_3_p_n18 3.3407e-17
vdw_p_n18_0 wl_0_p_n18 0 dc 0
vdr_p_n18_0 rwl_0_p_n18 vdd dc 0
vdw_p_n18_1 wl_1_p_n18 0 dc 0
vdr_p_n18_1 rwl_1_p_n18 vdd dc 0
vdw_p_n18_2 wl_2_p_n18 0 dc 0
vdr_p_n18_2 rwl_2_p_n18 vdd dc 0
vdw_p_n18_3 wl_3_p_n18 0 dc 0
vdr_p_n18_3 rwl_3_p_n18 vdd dc 0
vdb_p_n18_0 bl_0_p_n18 0 dc 0
vdp_p_n18_0 rbl_0_p_n18 vrbl dc 0
vdb_p_n18_1 bl_1_p_n18 0 dc 0
vdp_p_n18_1 rbl_1_p_n18 vrbl dc 0
vdb_p_n18_2 bl_2_p_n18 0 dc 0
vdp_p_n18_2 rbl_2_p_n18 vrbl dc 0
vdb_p_n18_3 bl_3_p_n18 0 dc 0
vdp_p_n18_3 rbl_3_p_n18 vrbl dc 0
vdn_p_n18_n7 n7_p_n18 0 dc 1
vdn_p_n18_n8 n8_p_n18 0 dc 1
vdn_p_n18_n9 n9_p_n18 0 dc 1
vdn_p_n18_n10 n10_p_n18 0 dc 1
vdn_p_n18_n17 n17_p_n18 0 dc 1
vdn_p_n18_n19 n19_p_n18 0 dc 1
vdn_p_n18_n20 n20_p_n18 0 dc 1
vdn_p_n18_n22 n22_p_n18 0 dc 1
vdn_p_n18_n23 n23_p_n18 0 dc 1
vdn_p_n18_n24 n24_p_n18 0 dc 1
vdn_p_n18_n25 n25_p_n18 0 dc 1
vdn_p_n18_n29 n29_p_n18 0 dc 1
vdn_p_n18_n30 n30_p_n18 0 dc 1
vdn_p_n18_n31 n31_p_n18 0 dc 1
vdn_p_n18_n32 n32_p_n18 0 dc 1
bdr_p_n18 n18_p_n18 0 i=5e-08*min(1,max(0,(time-1e-09)/0.2n))*0.5*(1+tanh((v(n18_p_n18)-0.05)/0.01))

* ---- instance p_n19: variant p, probed storage node \$19 ----
xm1_p_n19 rwl_0__t2_p_n19 n7__t0_p_n19 rbl_0__t0_p_n19 gnd__t0_p_n19 sky130_fd_pr__nfet_01v8 L=0.15 W=0.42 nf=1 ad=0.1197 as=0.1197 pd=1.41 ps=1.41 mult=1 m=1
xm2_p_n19 rwl_0__t3_p_n19 n8__t1_p_n19 rbl_1__t1_p_n19 gnd__t1_p_n19 sky130_fd_pr__nfet_01v8 L=0.15 W=0.42 nf=1 ad=0.1197 as=0.1197 pd=1.41 ps=1.41 mult=1 m=1
xm3_p_n19 rwl_0__t1_p_n19 n9__t1_p_n19 rbl_2__t1_p_n19 gnd__t2_p_n19 sky130_fd_pr__nfet_01v8 L=0.15 W=0.42 nf=1 ad=0.1197 as=0.1197 pd=1.41 ps=1.41 mult=1 m=1
xm4_p_n19 rwl_0__t0_p_n19 n10__t1_p_n19 rbl_3__t1_p_n19 gnd__t3_p_n19 sky130_fd_pr__nfet_01v8 L=0.15 W=0.42 nf=1 ad=0.1197 as=0.1197 pd=1.41 ps=1.41 mult=1 m=1
xm5_p_n19 bl_0__t0_p_n19 wl_0__t0_p_n19 n7__t1_p_n19 gnd__t8_p_n19 sky130_fd_pr__nfet_01v8 L=0.15 W=0.42 nf=1 ad=0.0588 as=0.1197 pd=0.7 ps=1.41 mult=1 m=1
xm6_p_n19 n17__t0_p_n19 wl_1__t0_p_n19 bl_0__t1_p_n19 gnd__t20_p_n19 sky130_fd_pr__nfet_01v8 L=0.15 W=0.42 nf=1 ad=0.1197 as=0.0588 pd=1.41 ps=0.7 mult=1 m=1
xm7_p_n19 bl_1__t2_p_n19 wl_0__t3_p_n19 n8__t0_p_n19 gnd__t9_p_n19 sky130_fd_pr__nfet_01v8 L=0.15 W=0.42 nf=1 ad=0.0588 as=0.1197 pd=0.7 ps=1.41 mult=1 m=1
xm8_p_n19 n18__t0_p_n19 wl_1__t1_p_n19 bl_1__t0_p_n19 gnd__t21_p_n19 sky130_fd_pr__nfet_01v8 L=0.15 W=0.42 nf=1 ad=0.1197 as=0.0588 pd=1.41 ps=0.7 mult=1 m=1
xm9_p_n19 bl_2__t2_p_n19 wl_0__t2_p_n19 n9__t0_p_n19 gnd__t10_p_n19 sky130_fd_pr__nfet_01v8 L=0.15 W=0.42 nf=1 ad=0.0588 as=0.1197 pd=0.7 ps=1.41 mult=1 m=1
xm10_p_n19 n19__t0_p_n19 wl_1__t2_p_n19 bl_2__t0_p_n19 gnd__t22_p_n19 sky130_fd_pr__nfet_01v8 L=0.15 W=0.42 nf=1 ad=0.1197 as=0.0588 pd=1.41 ps=0.7 mult=1 m=1
xm11_p_n19 bl_3__t2_p_n19 wl_0__t1_p_n19 n10__t0_p_n19 gnd__t11_p_n19 sky130_fd_pr__nfet_01v8 L=0.15 W=0.42 nf=1 ad=0.0588 as=0.1197 pd=0.7 ps=1.41 mult=1 m=1
xm12_p_n19 n20__t0_p_n19 wl_1__t3_p_n19 bl_3__t1_p_n19 gnd__t23_p_n19 sky130_fd_pr__nfet_01v8 L=0.15 W=0.42 nf=1 ad=0.1197 as=0.0588 pd=1.41 ps=0.7 mult=1 m=1
xm13_p_n19 rbl_0__t3_p_n19 n17__t1_p_n19 rwl_1__t0_p_n19 gnd__t12_p_n19 sky130_fd_pr__nfet_01v8 L=0.15 W=0.42 nf=1 ad=0.0588 as=0.1197 pd=0.7 ps=1.41 mult=1 m=1
xm14_p_n19 rwl_2__t3_p_n19 n22__t0_p_n19 rbl_0__t2_p_n19 gnd__t24_p_n19 sky130_fd_pr__nfet_01v8 L=0.15 W=0.42 nf=1 ad=0.1197 as=0.0588 pd=1.41 ps=0.7 mult=1 m=1
xm15_p_n19 rbl_1__t3_p_n19 n18__t1_p_n19 rwl_1__t1_p_n19 gnd__t13_p_n19 sky130_fd_pr__nfet_01v8 L=0.15 W=0.42 nf=1 ad=0.0588 as=0.1197 pd=0.7 ps=1.41 mult=1 m=1
xm16_p_n19 rwl_2__t0_p_n19 n23__t0_p_n19 rbl_1__t2_p_n19 gnd__t25_p_n19 sky130_fd_pr__nfet_01v8 L=0.15 W=0.42 nf=1 ad=0.1197 as=0.0588 pd=1.41 ps=0.7 mult=1 m=1
xm17_p_n19 rbl_2__t3_p_n19 n19__t1_p_n19 rwl_1__t2_p_n19 gnd__t14_p_n19 sky130_fd_pr__nfet_01v8 L=0.15 W=0.42 nf=1 ad=0.0588 as=0.1197 pd=0.7 ps=1.41 mult=1 m=1
xm18_p_n19 rwl_2__t1_p_n19 n24__t0_p_n19 rbl_2__t2_p_n19 gnd__t26_p_n19 sky130_fd_pr__nfet_01v8 L=0.15 W=0.42 nf=1 ad=0.1197 as=0.0588 pd=1.41 ps=0.7 mult=1 m=1
xm19_p_n19 rbl_3__t3_p_n19 n20__t1_p_n19 rwl_1__t3_p_n19 gnd__t15_p_n19 sky130_fd_pr__nfet_01v8 L=0.15 W=0.42 nf=1 ad=0.0588 as=0.1197 pd=0.7 ps=1.41 mult=1 m=1
xm20_p_n19 rwl_2__t2_p_n19 n25__t0_p_n19 rbl_3__t2_p_n19 gnd__t27_p_n19 sky130_fd_pr__nfet_01v8 L=0.15 W=0.42 nf=1 ad=0.1197 as=0.0588 pd=1.41 ps=0.7 mult=1 m=1
xm21_p_n19 bl_0__t3_p_n19 wl_2__t0_p_n19 n22__t1_p_n19 gnd__t16_p_n19 sky130_fd_pr__nfet_01v8 L=0.15 W=0.42 nf=1 ad=0.0588 as=0.1197 pd=0.7 ps=1.41 mult=1 m=1
xm22_p_n19 n29__t0_p_n19 wl_3__t3_p_n19 bl_0__t2_p_n19 gnd__t28_p_n19 sky130_fd_pr__nfet_01v8 L=0.15 W=0.42 nf=1 ad=0.1197 as=0.0588 pd=1.41 ps=0.7 mult=1 m=1
xm23_p_n19 bl_1__t3_p_n19 wl_2__t1_p_n19 n23__t1_p_n19 gnd__t17_p_n19 sky130_fd_pr__nfet_01v8 L=0.15 W=0.42 nf=1 ad=0.0588 as=0.1197 pd=0.7 ps=1.41 mult=1 m=1
xm24_p_n19 n30__t0_p_n19 wl_3__t2_p_n19 bl_1__t1_p_n19 gnd__t29_p_n19 sky130_fd_pr__nfet_01v8 L=0.15 W=0.42 nf=1 ad=0.1197 as=0.0588 pd=1.41 ps=0.7 mult=1 m=1
xm25_p_n19 bl_2__t3_p_n19 wl_2__t2_p_n19 n24__t1_p_n19 gnd__t18_p_n19 sky130_fd_pr__nfet_01v8 L=0.15 W=0.42 nf=1 ad=0.0588 as=0.1197 pd=0.7 ps=1.41 mult=1 m=1
xm26_p_n19 n31__t0_p_n19 wl_3__t1_p_n19 bl_2__t1_p_n19 gnd__t30_p_n19 sky130_fd_pr__nfet_01v8 L=0.15 W=0.42 nf=1 ad=0.1197 as=0.0588 pd=1.41 ps=0.7 mult=1 m=1
xm27_p_n19 bl_3__t3_p_n19 wl_2__t3_p_n19 n25__t1_p_n19 gnd__t19_p_n19 sky130_fd_pr__nfet_01v8 L=0.15 W=0.42 nf=1 ad=0.0588 as=0.1197 pd=0.7 ps=1.41 mult=1 m=1
xm28_p_n19 n32__t0_p_n19 wl_3__t0_p_n19 bl_3__t0_p_n19 gnd__t31_p_n19 sky130_fd_pr__nfet_01v8 L=0.15 W=0.42 nf=1 ad=0.1197 as=0.0588 pd=1.41 ps=0.7 mult=1 m=1
xm29_p_n19 rbl_0__t1_p_n19 n29__t1_p_n19 rwl_3__t0_p_n19 gnd__t4_p_n19 sky130_fd_pr__nfet_01v8 L=0.15 W=0.42 nf=1 ad=0.1197 as=0.1197 pd=1.41 ps=1.41 mult=1 m=1
xm30_p_n19 rbl_1__t0_p_n19 n30__t1_p_n19 rwl_3__t1_p_n19 gnd__t5_p_n19 sky130_fd_pr__nfet_01v8 L=0.15 W=0.42 nf=1 ad=0.1197 as=0.1197 pd=1.41 ps=1.41 mult=1 m=1
xm31_p_n19 rbl_2__t0_p_n19 n31__t1_p_n19 rwl_3__t2_p_n19 gnd__t6_p_n19 sky130_fd_pr__nfet_01v8 L=0.15 W=0.42 nf=1 ad=0.1197 as=0.1197 pd=1.41 ps=1.41 mult=1 m=1
xm32_p_n19 rbl_3__t0_p_n19 n32__t1_p_n19 rwl_3__t3_p_n19 gnd__t7_p_n19 sky130_fd_pr__nfet_01v8 L=0.15 W=0.42 nf=1 ad=0.1197 as=0.1197 pd=1.41 ps=1.41 mult=1 m=1
r_10_t0_p_n19 n10__t0_p_n19 n10_p_n19 183.071
r_10_t1_p_n19 n10__t1_p_n19 n10_p_n19 183.071
r_17_t0_p_n19 n17__t0_p_n19 n17_p_n19 183.071
r_17_t1_p_n19 n17__t1_p_n19 n17_p_n19 183.071
r_18_t0_p_n19 n18__t0_p_n19 n18_p_n19 183.071
r_18_t1_p_n19 n18__t1_p_n19 n18_p_n19 183.071
r_19_t0_p_n19 n19__t0_p_n19 n19_p_n19 183.071
r_19_t1_p_n19 n19__t1_p_n19 n19_p_n19 183.071
r_20_t0_p_n19 n20__t0_p_n19 n20_p_n19 183.071
r_20_t1_p_n19 n20__t1_p_n19 n20_p_n19 183.071
r_22_t0_p_n19 n22__t0_p_n19 n22_p_n19 183.071
r_22_t1_p_n19 n22__t1_p_n19 n22_p_n19 183.071
r_23_t0_p_n19 n23__t0_p_n19 n23_p_n19 183.071
r_23_t1_p_n19 n23__t1_p_n19 n23_p_n19 183.071
r_24_t0_p_n19 n24__t0_p_n19 n24_p_n19 183.071
r_24_t1_p_n19 n24__t1_p_n19 n24_p_n19 183.071
r_25_t0_p_n19 n25__t0_p_n19 n25_p_n19 183.071
r_25_t1_p_n19 n25__t1_p_n19 n25_p_n19 183.071
r_29_t0_p_n19 n29__t0_p_n19 n29_p_n19 183.071
r_29_t1_p_n19 n29__t1_p_n19 n29_p_n19 183.071
r_30_t0_p_n19 n30__t0_p_n19 n30_p_n19 183.071
r_30_t1_p_n19 n30__t1_p_n19 n30_p_n19 183.071
r_31_t0_p_n19 n31__t0_p_n19 n31_p_n19 183.071
r_31_t1_p_n19 n31__t1_p_n19 n31_p_n19 183.071
r_32_t0_p_n19 n32__t0_p_n19 n32_p_n19 183.071
r_32_t1_p_n19 n32__t1_p_n19 n32_p_n19 183.071
r_7_t0_p_n19 n7__t0_p_n19 n7_p_n19 183.071
r_7_t1_p_n19 n7__t1_p_n19 n7_p_n19 183.071
r_8_t0_p_n19 n8__t0_p_n19 n8_p_n19 183.071
r_8_t1_p_n19 n8__t1_p_n19 n8_p_n19 183.071
r_9_t0_p_n19 n9__t0_p_n19 n9_p_n19 183.071
r_9_t1_p_n19 n9__t1_p_n19 n9_p_n19 183.071
rgnd_t0_p_n19 gnd__t0_p_n19 0 38.2988
rgnd_t1_p_n19 gnd__t1_p_n19 0 33.9576
rgnd_t2_p_n19 gnd__t2_p_n19 0 33.9576
rgnd_t3_p_n19 gnd__t3_p_n19 0 38.2988
rgnd_t4_p_n19 gnd__t4_p_n19 0 38.2988
rgnd_t5_p_n19 gnd__t5_p_n19 0 33.9576
rgnd_t6_p_n19 gnd__t6_p_n19 0 33.9576
rgnd_t7_p_n19 gnd__t7_p_n19 0 38.2988
rgnd_t8_p_n19 gnd__t8_p_n19 0 28.0185
rgnd_t9_p_n19 gnd__t9_p_n19 0 21.7106
rgnd_t10_p_n19 gnd__t10_p_n19 0 21.7106
rgnd_t11_p_n19 gnd__t11_p_n19 0 28.0185
rgnd_t12_p_n19 gnd__t12_p_n19 0 18.9833
rgnd_t13_p_n19 gnd__t13_p_n19 0 6.8325
rgnd_t14_p_n19 gnd__t14_p_n19 0 6.8325
rgnd_t15_p_n19 gnd__t15_p_n19 0 18.9833
rgnd_t16_p_n19 gnd__t16_p_n19 0 24.2409
rgnd_t17_p_n19 gnd__t17_p_n19 0 16.5511
rgnd_t18_p_n19 gnd__t18_p_n19 0 16.5511
rgnd_t19_p_n19 gnd__t19_p_n19 0 24.2409
rgnd_t20_p_n19 gnd__t20_p_n19 0 24.2409
rgnd_t21_p_n19 gnd__t21_p_n19 0 16.5511
rgnd_t22_p_n19 gnd__t22_p_n19 0 16.5511
rgnd_t23_p_n19 gnd__t23_p_n19 0 24.2409
rgnd_t24_p_n19 gnd__t24_p_n19 0 18.9833
rgnd_t25_p_n19 gnd__t25_p_n19 0 6.8325
rgnd_t26_p_n19 gnd__t26_p_n19 0 6.8325
rgnd_t27_p_n19 gnd__t27_p_n19 0 18.9833
rgnd_t28_p_n19 gnd__t28_p_n19 0 28.0185
rgnd_t29_p_n19 gnd__t29_p_n19 0 21.7106
rgnd_t30_p_n19 gnd__t30_p_n19 0 21.7106
rgnd_t31_p_n19 gnd__t31_p_n19 0 28.0185
rbl_0_t0_p_n19 bl_0__t0_p_n19 bl_0_p_n19 14.8304
rbl_0_t1_p_n19 bl_0__t1_p_n19 bl_0_p_n19 10.9301
rbl_0_t2_p_n19 bl_0__t2_p_n19 bl_0_p_n19 14.8304
rbl_0_t3_p_n19 bl_0__t3_p_n19 bl_0_p_n19 10.9301
rbl_1_t0_p_n19 bl_1__t0_p_n19 bl_1_p_n19 10.9301
rbl_1_t1_p_n19 bl_1__t1_p_n19 bl_1_p_n19 14.8304
rbl_1_t2_p_n19 bl_1__t2_p_n19 bl_1_p_n19 14.8304
rbl_1_t3_p_n19 bl_1__t3_p_n19 bl_1_p_n19 10.9301
rbl_2_t0_p_n19 bl_2__t0_p_n19 bl_2_p_n19 10.9301
rbl_2_t1_p_n19 bl_2__t1_p_n19 bl_2_p_n19 14.8304
rbl_2_t2_p_n19 bl_2__t2_p_n19 bl_2_p_n19 14.8304
rbl_2_t3_p_n19 bl_2__t3_p_n19 bl_2_p_n19 10.9301
rbl_3_t0_p_n19 bl_3__t0_p_n19 bl_3_p_n19 14.8304
rbl_3_t1_p_n19 bl_3__t1_p_n19 bl_3_p_n19 10.9301
rbl_3_t2_p_n19 bl_3__t2_p_n19 bl_3_p_n19 14.8304
rbl_3_t3_p_n19 bl_3__t3_p_n19 bl_3_p_n19 10.9301
rrbl_0_t0_p_n19 rbl_0__t0_p_n19 rbl_0_p_n19 36.5601
rrbl_0_t1_p_n19 rbl_0__t1_p_n19 rbl_0_p_n19 36.5601
rrbl_0_t2_p_n19 rbl_0__t2_p_n19 rbl_0_p_n19 2.99444
rrbl_0_t3_p_n19 rbl_0__t3_p_n19 rbl_0_p_n19 2.99444
rrbl_1_t0_p_n19 rbl_1__t0_p_n19 rbl_1_p_n19 36.5601
rrbl_1_t1_p_n19 rbl_1__t1_p_n19 rbl_1_p_n19 36.5601
rrbl_1_t2_p_n19 rbl_1__t2_p_n19 rbl_1_p_n19 2.99444
rrbl_1_t3_p_n19 rbl_1__t3_p_n19 rbl_1_p_n19 2.99444
rrbl_2_t0_p_n19 rbl_2__t0_p_n19 rbl_2_p_n19 36.5601
rrbl_2_t1_p_n19 rbl_2__t1_p_n19 rbl_2_p_n19 36.5601
rrbl_2_t2_p_n19 rbl_2__t2_p_n19 rbl_2_p_n19 2.99444
rrbl_2_t3_p_n19 rbl_2__t3_p_n19 rbl_2_p_n19 2.99444
rrbl_3_t0_p_n19 rbl_3__t0_p_n19 rbl_3_p_n19 36.5601
rrbl_3_t1_p_n19 rbl_3__t1_p_n19 rbl_3_p_n19 36.5601
rrbl_3_t2_p_n19 rbl_3__t2_p_n19 rbl_3_p_n19 2.99444
rrbl_3_t3_p_n19 rbl_3__t3_p_n19 rbl_3_p_n19 2.99444
rrwl_0_t0_p_n19 rwl_0__t0_p_n19 rwl_0_p_n19 38.2618
rrwl_0_t1_p_n19 rwl_0__t1_p_n19 rwl_0_p_n19 12.7539
rrwl_0_t2_p_n19 rwl_0__t2_p_n19 rwl_0_p_n19 38.2618
rrwl_0_t3_p_n19 rwl_0__t3_p_n19 rwl_0_p_n19 12.7539
rrwl_1_t0_p_n19 rwl_1__t0_p_n19 rwl_1_p_n19 38.2618
rrwl_1_t1_p_n19 rwl_1__t1_p_n19 rwl_1_p_n19 12.7539
rrwl_1_t2_p_n19 rwl_1__t2_p_n19 rwl_1_p_n19 12.7539
rrwl_1_t3_p_n19 rwl_1__t3_p_n19 rwl_1_p_n19 38.2618
rrwl_2_t0_p_n19 rwl_2__t0_p_n19 rwl_2_p_n19 12.7539
rrwl_2_t1_p_n19 rwl_2__t1_p_n19 rwl_2_p_n19 12.7539
rrwl_2_t2_p_n19 rwl_2__t2_p_n19 rwl_2_p_n19 38.2618
rrwl_2_t3_p_n19 rwl_2__t3_p_n19 rwl_2_p_n19 38.2618
rrwl_3_t0_p_n19 rwl_3__t0_p_n19 rwl_3_p_n19 38.2618
rrwl_3_t1_p_n19 rwl_3__t1_p_n19 rwl_3_p_n19 12.7539
rrwl_3_t2_p_n19 rwl_3__t2_p_n19 rwl_3_p_n19 12.7539
rrwl_3_t3_p_n19 rwl_3__t3_p_n19 rwl_3_p_n19 38.2618
rwl_0_t0_p_n19 wl_0__t0_p_n19 wl_0_p_n19 245.959
rwl_0_t1_p_n19 wl_0__t1_p_n19 wl_0_p_n19 245.959
rwl_0_t2_p_n19 wl_0__t2_p_n19 wl_0_p_n19 81.9864
rwl_0_t3_p_n19 wl_0__t3_p_n19 wl_0_p_n19 81.9864
rwl_1_t0_p_n19 wl_1__t0_p_n19 wl_1_p_n19 245.959
rwl_1_t1_p_n19 wl_1__t1_p_n19 wl_1_p_n19 81.9864
rwl_1_t2_p_n19 wl_1__t2_p_n19 wl_1_p_n19 81.9864
rwl_1_t3_p_n19 wl_1__t3_p_n19 wl_1_p_n19 245.959
rwl_2_t0_p_n19 wl_2__t0_p_n19 wl_2_p_n19 245.959
rwl_2_t1_p_n19 wl_2__t1_p_n19 wl_2_p_n19 81.9864
rwl_2_t2_p_n19 wl_2__t2_p_n19 wl_2_p_n19 81.9864
rwl_2_t3_p_n19 wl_2__t3_p_n19 wl_2_p_n19 245.959
rwl_3_t0_p_n19 wl_3__t0_p_n19 wl_3_p_n19 245.959
rwl_3_t1_p_n19 wl_3__t1_p_n19 wl_3_p_n19 81.9864
rwl_3_t2_p_n19 wl_3__t2_p_n19 wl_3_p_n19 81.9864
rwl_3_t3_p_n19 wl_3__t3_p_n19 wl_3_p_n19 245.959
c_10_p_n19 n10_p_n19 0 2.91622e-16
c_17_p_n19 n17_p_n19 0 2.91528e-16
c_18_p_n19 n18_p_n19 0 2.91528e-16
c_19_p_n19 n19_p_n19 0 1.1371e-16
c_20_p_n19 n20_p_n19 0 2.91622e-16
c_22_p_n19 n22_p_n19 0 2.91528e-16
c_23_p_n19 n23_p_n19 0 2.91528e-16
c_24_p_n19 n24_p_n19 0 2.91528e-16
c_25_p_n19 n25_p_n19 0 2.91622e-16
c_29_p_n19 n29_p_n19 0 2.91528e-16
c_30_p_n19 n30_p_n19 0 2.91528e-16
c_31_p_n19 n31_p_n19 0 2.91528e-16
c_32_p_n19 n32_p_n19 0 2.91622e-16
c_7_p_n19 n7_p_n19 0 2.91528e-16
c_8_p_n19 n8_p_n19 0 2.91528e-16
c_9_p_n19 n9_p_n19 0 2.91528e-16
cgnd_p_n19 0 0 2.48166e-15
cbl_0_p_n19 bl_0_p_n19 0 4.52661e-16
cbl_1_p_n19 bl_1_p_n19 0 4.52661e-16
cbl_2_p_n19 bl_2_p_n19 0 4.52661e-16
cbl_3_p_n19 bl_3_p_n19 0 4.52661e-16
crbl_0_p_n19 rbl_0_p_n19 0 9.14472e-16
crbl_1_p_n19 rbl_1_p_n19 0 9.14472e-16
crbl_2_p_n19 rbl_2_p_n19 0 9.14472e-16
crbl_3_p_n19 rbl_3_p_n19 0 9.17566e-16
crwl_0_p_n19 rwl_0_p_n19 0 5.19495e-16
crwl_1_p_n19 rwl_1_p_n19 0 5.11719e-16
crwl_2_p_n19 rwl_2_p_n19 0 5.11719e-16
crwl_3_p_n19 rwl_3_p_n19 0 5.19495e-16
cwl_0_p_n19 wl_0_p_n19 0 3.30388e-16
cwl_1_p_n19 wl_1_p_n19 0 3.30388e-16
cwl_2_p_n19 wl_2_p_n19 0 3.30388e-16
cwl_3_p_n19 wl_3_p_n19 0 3.30388e-16
ccc__10__9_p_n19 n10_p_n19 n9_p_n19 1.02e-17
ccc__10_bl_3_p_n19 n10_p_n19 bl_3_p_n19 1.3999e-17
ccc__10_rwl_0_p_n19 n10_p_n19 rwl_0_p_n19 4.335e-18
ccc__17__18_p_n19 n17_p_n19 n18_p_n19 1.02e-17
ccc__17_bl_0_p_n19 n17_p_n19 bl_0_p_n19 8.415e-18
ccc__17_rwl_1_p_n19 n17_p_n19 rwl_1_p_n19 1.3194e-17
ccc__18__19_p_n19 n18_p_n19 n19_p_n19 1.02e-17
ccc__18_bl_1_p_n19 n18_p_n19 bl_1_p_n19 8.415e-18
ccc__18_rwl_1_p_n19 n18_p_n19 rwl_1_p_n19 1.3194e-17
ccc__19__20_p_n19 n19_p_n19 n20_p_n19 1.02e-17
ccc__19_bl_2_p_n19 n19_p_n19 bl_2_p_n19 8.415e-18
ccc__19_rwl_1_p_n19 n19_p_n19 rwl_1_p_n19 1.3194e-17
ccc__20_bl_3_p_n19 n20_p_n19 bl_3_p_n19 8.415e-18
ccc__20_rwl_1_p_n19 n20_p_n19 rwl_1_p_n19 6.655e-18
ccc__22__23_p_n19 n22_p_n19 n23_p_n19 1.02e-17
ccc__22_bl_0_p_n19 n22_p_n19 bl_0_p_n19 8.415e-18
ccc__22_rwl_2_p_n19 n22_p_n19 rwl_2_p_n19 1.3194e-17
ccc__23__24_p_n19 n23_p_n19 n24_p_n19 1.02e-17
ccc__23_bl_1_p_n19 n23_p_n19 bl_1_p_n19 8.415e-18
ccc__23_rwl_2_p_n19 n23_p_n19 rwl_2_p_n19 1.3194e-17
ccc__24__25_p_n19 n24_p_n19 n25_p_n19 1.02e-17
ccc__24_bl_2_p_n19 n24_p_n19 bl_2_p_n19 8.415e-18
ccc__24_rwl_2_p_n19 n24_p_n19 rwl_2_p_n19 1.3194e-17
ccc__25_bl_3_p_n19 n25_p_n19 bl_3_p_n19 8.415e-18
ccc__25_rwl_2_p_n19 n25_p_n19 rwl_2_p_n19 6.655e-18
ccc__29__30_p_n19 n29_p_n19 n30_p_n19 1.02e-17
ccc__29_bl_0_p_n19 n29_p_n19 bl_0_p_n19 8.415e-18
ccc__29_rwl_3_p_n19 n29_p_n19 rwl_3_p_n19 1.3194e-17
ccc__30__31_p_n19 n30_p_n19 n31_p_n19 1.02e-17
ccc__30_bl_1_p_n19 n30_p_n19 bl_1_p_n19 8.415e-18
ccc__30_rwl_3_p_n19 n30_p_n19 rwl_3_p_n19 1.3194e-17
ccc__31__32_p_n19 n31_p_n19 n32_p_n19 1.02e-17
ccc__31_bl_2_p_n19 n31_p_n19 bl_2_p_n19 8.415e-18
ccc__31_rwl_3_p_n19 n31_p_n19 rwl_3_p_n19 1.3194e-17
ccc__32_bl_3_p_n19 n32_p_n19 bl_3_p_n19 8.415e-18
ccc__32_rwl_3_p_n19 n32_p_n19 rwl_3_p_n19 6.655e-18
ccc__7__8_p_n19 n7_p_n19 n8_p_n19 1.02e-17
ccc__7_bl_0_p_n19 n7_p_n19 bl_0_p_n19 1.3999e-17
ccc__7_rwl_0_p_n19 n7_p_n19 rwl_0_p_n19 8.961e-18
ccc__8__9_p_n19 n8_p_n19 n9_p_n19 1.02e-17
ccc__8_bl_1_p_n19 n8_p_n19 bl_1_p_n19 1.3999e-17
ccc__8_rwl_0_p_n19 n8_p_n19 rwl_0_p_n19 8.961e-18
ccc__9_bl_2_p_n19 n9_p_n19 bl_2_p_n19 1.3999e-17
ccc__9_rwl_0_p_n19 n9_p_n19 rwl_0_p_n19 8.961e-18
ccc_bl_0_rbl_0_p_n19 bl_0_p_n19 rbl_0_p_n19 1.88693e-16
ccc_bl_0_rwl_1_p_n19 bl_0_p_n19 rwl_1_p_n19 1.0093e-17
ccc_bl_0_rwl_2_p_n19 bl_0_p_n19 rwl_2_p_n19 1.0093e-17
ccc_bl_1_rbl_0_p_n19 bl_1_p_n19 rbl_0_p_n19 1.633e-16
ccc_bl_1_rbl_1_p_n19 bl_1_p_n19 rbl_1_p_n19 1.88693e-16
ccc_bl_1_rwl_1_p_n19 bl_1_p_n19 rwl_1_p_n19 1.0093e-17
ccc_bl_1_rwl_2_p_n19 bl_1_p_n19 rwl_2_p_n19 1.0093e-17
ccc_bl_2_rbl_1_p_n19 bl_2_p_n19 rbl_1_p_n19 1.633e-16
ccc_bl_2_rbl_2_p_n19 bl_2_p_n19 rbl_2_p_n19 1.88693e-16
ccc_bl_2_rwl_1_p_n19 bl_2_p_n19 rwl_1_p_n19 1.0093e-17
ccc_bl_2_rwl_2_p_n19 bl_2_p_n19 rwl_2_p_n19 1.0093e-17
ccc_bl_3_rbl_2_p_n19 bl_3_p_n19 rbl_2_p_n19 1.633e-16
ccc_bl_3_rbl_3_p_n19 bl_3_p_n19 rbl_3_p_n19 1.88693e-16
ccc_bl_3_rwl_1_p_n19 bl_3_p_n19 rwl_1_p_n19 1.0093e-17
ccc_bl_3_rwl_2_p_n19 bl_3_p_n19 rwl_2_p_n19 1.0093e-17
ccc_rbl_0_rbl_1_p_n19 rbl_0_p_n19 rbl_1_p_n19 3.432e-17
ccc_rbl_0_rwl_0_p_n19 rbl_0_p_n19 rwl_0_p_n19 4.9752e-17
ccc_rbl_0_rwl_1_p_n19 rbl_0_p_n19 rwl_1_p_n19 4.9752e-17
ccc_rbl_0_rwl_2_p_n19 rbl_0_p_n19 rwl_2_p_n19 4.9752e-17
ccc_rbl_0_rwl_3_p_n19 rbl_0_p_n19 rwl_3_p_n19 4.9752e-17
ccc_rbl_1_rbl_2_p_n19 rbl_1_p_n19 rbl_2_p_n19 3.432e-17
ccc_rbl_1_rwl_0_p_n19 rbl_1_p_n19 rwl_0_p_n19 4.9752e-17
ccc_rbl_1_rwl_1_p_n19 rbl_1_p_n19 rwl_1_p_n19 4.9752e-17
ccc_rbl_1_rwl_2_p_n19 rbl_1_p_n19 rwl_2_p_n19 4.9752e-17
ccc_rbl_1_rwl_3_p_n19 rbl_1_p_n19 rwl_3_p_n19 4.9752e-17
ccc_rbl_2_rbl_3_p_n19 rbl_2_p_n19 rbl_3_p_n19 3.432e-17
ccc_rbl_2_rwl_0_p_n19 rbl_2_p_n19 rwl_0_p_n19 4.9752e-17
ccc_rbl_2_rwl_1_p_n19 rbl_2_p_n19 rwl_1_p_n19 4.9752e-17
ccc_rbl_2_rwl_2_p_n19 rbl_2_p_n19 rwl_2_p_n19 4.9752e-17
ccc_rbl_2_rwl_3_p_n19 rbl_2_p_n19 rwl_3_p_n19 4.9752e-17
ccc_rbl_3_rwl_0_p_n19 rbl_3_p_n19 rwl_0_p_n19 3.3407e-17
ccc_rbl_3_rwl_1_p_n19 rbl_3_p_n19 rwl_1_p_n19 3.3407e-17
ccc_rbl_3_rwl_2_p_n19 rbl_3_p_n19 rwl_2_p_n19 3.3407e-17
ccc_rbl_3_rwl_3_p_n19 rbl_3_p_n19 rwl_3_p_n19 3.3407e-17
vdw_p_n19_0 wl_0_p_n19 0 dc 0
vdr_p_n19_0 rwl_0_p_n19 vdd dc 0
vdw_p_n19_1 wl_1_p_n19 0 dc 0
vdr_p_n19_1 rwl_1_p_n19 vdd dc 0
vdw_p_n19_2 wl_2_p_n19 0 dc 0
vdr_p_n19_2 rwl_2_p_n19 vdd dc 0
vdw_p_n19_3 wl_3_p_n19 0 dc 0
vdr_p_n19_3 rwl_3_p_n19 vdd dc 0
vdb_p_n19_0 bl_0_p_n19 0 dc 0
vdp_p_n19_0 rbl_0_p_n19 vrbl dc 0
vdb_p_n19_1 bl_1_p_n19 0 dc 0
vdp_p_n19_1 rbl_1_p_n19 vrbl dc 0
vdb_p_n19_2 bl_2_p_n19 0 dc 0
vdp_p_n19_2 rbl_2_p_n19 vrbl dc 0
vdb_p_n19_3 bl_3_p_n19 0 dc 0
vdp_p_n19_3 rbl_3_p_n19 vrbl dc 0
vdn_p_n19_n7 n7_p_n19 0 dc 1
vdn_p_n19_n8 n8_p_n19 0 dc 1
vdn_p_n19_n9 n9_p_n19 0 dc 1
vdn_p_n19_n10 n10_p_n19 0 dc 1
vdn_p_n19_n17 n17_p_n19 0 dc 1
vdn_p_n19_n18 n18_p_n19 0 dc 1
vdn_p_n19_n20 n20_p_n19 0 dc 1
vdn_p_n19_n22 n22_p_n19 0 dc 1
vdn_p_n19_n23 n23_p_n19 0 dc 1
vdn_p_n19_n24 n24_p_n19 0 dc 1
vdn_p_n19_n25 n25_p_n19 0 dc 1
vdn_p_n19_n29 n29_p_n19 0 dc 1
vdn_p_n19_n30 n30_p_n19 0 dc 1
vdn_p_n19_n31 n31_p_n19 0 dc 1
vdn_p_n19_n32 n32_p_n19 0 dc 1
bdr_p_n19 n19_p_n19 0 i=5e-08*min(1,max(0,(time-1e-09)/0.2n))*0.5*(1+tanh((v(n19_p_n19)-0.05)/0.01))

* ---- instance p_n20: variant p, probed storage node \$20 ----
xm1_p_n20 rwl_0__t2_p_n20 n7__t0_p_n20 rbl_0__t0_p_n20 gnd__t0_p_n20 sky130_fd_pr__nfet_01v8 L=0.15 W=0.42 nf=1 ad=0.1197 as=0.1197 pd=1.41 ps=1.41 mult=1 m=1
xm2_p_n20 rwl_0__t3_p_n20 n8__t1_p_n20 rbl_1__t1_p_n20 gnd__t1_p_n20 sky130_fd_pr__nfet_01v8 L=0.15 W=0.42 nf=1 ad=0.1197 as=0.1197 pd=1.41 ps=1.41 mult=1 m=1
xm3_p_n20 rwl_0__t1_p_n20 n9__t1_p_n20 rbl_2__t1_p_n20 gnd__t2_p_n20 sky130_fd_pr__nfet_01v8 L=0.15 W=0.42 nf=1 ad=0.1197 as=0.1197 pd=1.41 ps=1.41 mult=1 m=1
xm4_p_n20 rwl_0__t0_p_n20 n10__t1_p_n20 rbl_3__t1_p_n20 gnd__t3_p_n20 sky130_fd_pr__nfet_01v8 L=0.15 W=0.42 nf=1 ad=0.1197 as=0.1197 pd=1.41 ps=1.41 mult=1 m=1
xm5_p_n20 bl_0__t0_p_n20 wl_0__t0_p_n20 n7__t1_p_n20 gnd__t8_p_n20 sky130_fd_pr__nfet_01v8 L=0.15 W=0.42 nf=1 ad=0.0588 as=0.1197 pd=0.7 ps=1.41 mult=1 m=1
xm6_p_n20 n17__t0_p_n20 wl_1__t0_p_n20 bl_0__t1_p_n20 gnd__t20_p_n20 sky130_fd_pr__nfet_01v8 L=0.15 W=0.42 nf=1 ad=0.1197 as=0.0588 pd=1.41 ps=0.7 mult=1 m=1
xm7_p_n20 bl_1__t2_p_n20 wl_0__t3_p_n20 n8__t0_p_n20 gnd__t9_p_n20 sky130_fd_pr__nfet_01v8 L=0.15 W=0.42 nf=1 ad=0.0588 as=0.1197 pd=0.7 ps=1.41 mult=1 m=1
xm8_p_n20 n18__t0_p_n20 wl_1__t1_p_n20 bl_1__t0_p_n20 gnd__t21_p_n20 sky130_fd_pr__nfet_01v8 L=0.15 W=0.42 nf=1 ad=0.1197 as=0.0588 pd=1.41 ps=0.7 mult=1 m=1
xm9_p_n20 bl_2__t2_p_n20 wl_0__t2_p_n20 n9__t0_p_n20 gnd__t10_p_n20 sky130_fd_pr__nfet_01v8 L=0.15 W=0.42 nf=1 ad=0.0588 as=0.1197 pd=0.7 ps=1.41 mult=1 m=1
xm10_p_n20 n19__t0_p_n20 wl_1__t2_p_n20 bl_2__t0_p_n20 gnd__t22_p_n20 sky130_fd_pr__nfet_01v8 L=0.15 W=0.42 nf=1 ad=0.1197 as=0.0588 pd=1.41 ps=0.7 mult=1 m=1
xm11_p_n20 bl_3__t2_p_n20 wl_0__t1_p_n20 n10__t0_p_n20 gnd__t11_p_n20 sky130_fd_pr__nfet_01v8 L=0.15 W=0.42 nf=1 ad=0.0588 as=0.1197 pd=0.7 ps=1.41 mult=1 m=1
xm12_p_n20 n20__t0_p_n20 wl_1__t3_p_n20 bl_3__t1_p_n20 gnd__t23_p_n20 sky130_fd_pr__nfet_01v8 L=0.15 W=0.42 nf=1 ad=0.1197 as=0.0588 pd=1.41 ps=0.7 mult=1 m=1
xm13_p_n20 rbl_0__t3_p_n20 n17__t1_p_n20 rwl_1__t0_p_n20 gnd__t12_p_n20 sky130_fd_pr__nfet_01v8 L=0.15 W=0.42 nf=1 ad=0.0588 as=0.1197 pd=0.7 ps=1.41 mult=1 m=1
xm14_p_n20 rwl_2__t3_p_n20 n22__t0_p_n20 rbl_0__t2_p_n20 gnd__t24_p_n20 sky130_fd_pr__nfet_01v8 L=0.15 W=0.42 nf=1 ad=0.1197 as=0.0588 pd=1.41 ps=0.7 mult=1 m=1
xm15_p_n20 rbl_1__t3_p_n20 n18__t1_p_n20 rwl_1__t1_p_n20 gnd__t13_p_n20 sky130_fd_pr__nfet_01v8 L=0.15 W=0.42 nf=1 ad=0.0588 as=0.1197 pd=0.7 ps=1.41 mult=1 m=1
xm16_p_n20 rwl_2__t0_p_n20 n23__t0_p_n20 rbl_1__t2_p_n20 gnd__t25_p_n20 sky130_fd_pr__nfet_01v8 L=0.15 W=0.42 nf=1 ad=0.1197 as=0.0588 pd=1.41 ps=0.7 mult=1 m=1
xm17_p_n20 rbl_2__t3_p_n20 n19__t1_p_n20 rwl_1__t2_p_n20 gnd__t14_p_n20 sky130_fd_pr__nfet_01v8 L=0.15 W=0.42 nf=1 ad=0.0588 as=0.1197 pd=0.7 ps=1.41 mult=1 m=1
xm18_p_n20 rwl_2__t1_p_n20 n24__t0_p_n20 rbl_2__t2_p_n20 gnd__t26_p_n20 sky130_fd_pr__nfet_01v8 L=0.15 W=0.42 nf=1 ad=0.1197 as=0.0588 pd=1.41 ps=0.7 mult=1 m=1
xm19_p_n20 rbl_3__t3_p_n20 n20__t1_p_n20 rwl_1__t3_p_n20 gnd__t15_p_n20 sky130_fd_pr__nfet_01v8 L=0.15 W=0.42 nf=1 ad=0.0588 as=0.1197 pd=0.7 ps=1.41 mult=1 m=1
xm20_p_n20 rwl_2__t2_p_n20 n25__t0_p_n20 rbl_3__t2_p_n20 gnd__t27_p_n20 sky130_fd_pr__nfet_01v8 L=0.15 W=0.42 nf=1 ad=0.1197 as=0.0588 pd=1.41 ps=0.7 mult=1 m=1
xm21_p_n20 bl_0__t3_p_n20 wl_2__t0_p_n20 n22__t1_p_n20 gnd__t16_p_n20 sky130_fd_pr__nfet_01v8 L=0.15 W=0.42 nf=1 ad=0.0588 as=0.1197 pd=0.7 ps=1.41 mult=1 m=1
xm22_p_n20 n29__t0_p_n20 wl_3__t3_p_n20 bl_0__t2_p_n20 gnd__t28_p_n20 sky130_fd_pr__nfet_01v8 L=0.15 W=0.42 nf=1 ad=0.1197 as=0.0588 pd=1.41 ps=0.7 mult=1 m=1
xm23_p_n20 bl_1__t3_p_n20 wl_2__t1_p_n20 n23__t1_p_n20 gnd__t17_p_n20 sky130_fd_pr__nfet_01v8 L=0.15 W=0.42 nf=1 ad=0.0588 as=0.1197 pd=0.7 ps=1.41 mult=1 m=1
xm24_p_n20 n30__t0_p_n20 wl_3__t2_p_n20 bl_1__t1_p_n20 gnd__t29_p_n20 sky130_fd_pr__nfet_01v8 L=0.15 W=0.42 nf=1 ad=0.1197 as=0.0588 pd=1.41 ps=0.7 mult=1 m=1
xm25_p_n20 bl_2__t3_p_n20 wl_2__t2_p_n20 n24__t1_p_n20 gnd__t18_p_n20 sky130_fd_pr__nfet_01v8 L=0.15 W=0.42 nf=1 ad=0.0588 as=0.1197 pd=0.7 ps=1.41 mult=1 m=1
xm26_p_n20 n31__t0_p_n20 wl_3__t1_p_n20 bl_2__t1_p_n20 gnd__t30_p_n20 sky130_fd_pr__nfet_01v8 L=0.15 W=0.42 nf=1 ad=0.1197 as=0.0588 pd=1.41 ps=0.7 mult=1 m=1
xm27_p_n20 bl_3__t3_p_n20 wl_2__t3_p_n20 n25__t1_p_n20 gnd__t19_p_n20 sky130_fd_pr__nfet_01v8 L=0.15 W=0.42 nf=1 ad=0.0588 as=0.1197 pd=0.7 ps=1.41 mult=1 m=1
xm28_p_n20 n32__t0_p_n20 wl_3__t0_p_n20 bl_3__t0_p_n20 gnd__t31_p_n20 sky130_fd_pr__nfet_01v8 L=0.15 W=0.42 nf=1 ad=0.1197 as=0.0588 pd=1.41 ps=0.7 mult=1 m=1
xm29_p_n20 rbl_0__t1_p_n20 n29__t1_p_n20 rwl_3__t0_p_n20 gnd__t4_p_n20 sky130_fd_pr__nfet_01v8 L=0.15 W=0.42 nf=1 ad=0.1197 as=0.1197 pd=1.41 ps=1.41 mult=1 m=1
xm30_p_n20 rbl_1__t0_p_n20 n30__t1_p_n20 rwl_3__t1_p_n20 gnd__t5_p_n20 sky130_fd_pr__nfet_01v8 L=0.15 W=0.42 nf=1 ad=0.1197 as=0.1197 pd=1.41 ps=1.41 mult=1 m=1
xm31_p_n20 rbl_2__t0_p_n20 n31__t1_p_n20 rwl_3__t2_p_n20 gnd__t6_p_n20 sky130_fd_pr__nfet_01v8 L=0.15 W=0.42 nf=1 ad=0.1197 as=0.1197 pd=1.41 ps=1.41 mult=1 m=1
xm32_p_n20 rbl_3__t0_p_n20 n32__t1_p_n20 rwl_3__t3_p_n20 gnd__t7_p_n20 sky130_fd_pr__nfet_01v8 L=0.15 W=0.42 nf=1 ad=0.1197 as=0.1197 pd=1.41 ps=1.41 mult=1 m=1
r_10_t0_p_n20 n10__t0_p_n20 n10_p_n20 183.071
r_10_t1_p_n20 n10__t1_p_n20 n10_p_n20 183.071
r_17_t0_p_n20 n17__t0_p_n20 n17_p_n20 183.071
r_17_t1_p_n20 n17__t1_p_n20 n17_p_n20 183.071
r_18_t0_p_n20 n18__t0_p_n20 n18_p_n20 183.071
r_18_t1_p_n20 n18__t1_p_n20 n18_p_n20 183.071
r_19_t0_p_n20 n19__t0_p_n20 n19_p_n20 183.071
r_19_t1_p_n20 n19__t1_p_n20 n19_p_n20 183.071
r_20_t0_p_n20 n20__t0_p_n20 n20_p_n20 183.071
r_20_t1_p_n20 n20__t1_p_n20 n20_p_n20 183.071
r_22_t0_p_n20 n22__t0_p_n20 n22_p_n20 183.071
r_22_t1_p_n20 n22__t1_p_n20 n22_p_n20 183.071
r_23_t0_p_n20 n23__t0_p_n20 n23_p_n20 183.071
r_23_t1_p_n20 n23__t1_p_n20 n23_p_n20 183.071
r_24_t0_p_n20 n24__t0_p_n20 n24_p_n20 183.071
r_24_t1_p_n20 n24__t1_p_n20 n24_p_n20 183.071
r_25_t0_p_n20 n25__t0_p_n20 n25_p_n20 183.071
r_25_t1_p_n20 n25__t1_p_n20 n25_p_n20 183.071
r_29_t0_p_n20 n29__t0_p_n20 n29_p_n20 183.071
r_29_t1_p_n20 n29__t1_p_n20 n29_p_n20 183.071
r_30_t0_p_n20 n30__t0_p_n20 n30_p_n20 183.071
r_30_t1_p_n20 n30__t1_p_n20 n30_p_n20 183.071
r_31_t0_p_n20 n31__t0_p_n20 n31_p_n20 183.071
r_31_t1_p_n20 n31__t1_p_n20 n31_p_n20 183.071
r_32_t0_p_n20 n32__t0_p_n20 n32_p_n20 183.071
r_32_t1_p_n20 n32__t1_p_n20 n32_p_n20 183.071
r_7_t0_p_n20 n7__t0_p_n20 n7_p_n20 183.071
r_7_t1_p_n20 n7__t1_p_n20 n7_p_n20 183.071
r_8_t0_p_n20 n8__t0_p_n20 n8_p_n20 183.071
r_8_t1_p_n20 n8__t1_p_n20 n8_p_n20 183.071
r_9_t0_p_n20 n9__t0_p_n20 n9_p_n20 183.071
r_9_t1_p_n20 n9__t1_p_n20 n9_p_n20 183.071
rgnd_t0_p_n20 gnd__t0_p_n20 0 38.2988
rgnd_t1_p_n20 gnd__t1_p_n20 0 33.9576
rgnd_t2_p_n20 gnd__t2_p_n20 0 33.9576
rgnd_t3_p_n20 gnd__t3_p_n20 0 38.2988
rgnd_t4_p_n20 gnd__t4_p_n20 0 38.2988
rgnd_t5_p_n20 gnd__t5_p_n20 0 33.9576
rgnd_t6_p_n20 gnd__t6_p_n20 0 33.9576
rgnd_t7_p_n20 gnd__t7_p_n20 0 38.2988
rgnd_t8_p_n20 gnd__t8_p_n20 0 28.0185
rgnd_t9_p_n20 gnd__t9_p_n20 0 21.7106
rgnd_t10_p_n20 gnd__t10_p_n20 0 21.7106
rgnd_t11_p_n20 gnd__t11_p_n20 0 28.0185
rgnd_t12_p_n20 gnd__t12_p_n20 0 18.9833
rgnd_t13_p_n20 gnd__t13_p_n20 0 6.8325
rgnd_t14_p_n20 gnd__t14_p_n20 0 6.8325
rgnd_t15_p_n20 gnd__t15_p_n20 0 18.9833
rgnd_t16_p_n20 gnd__t16_p_n20 0 24.2409
rgnd_t17_p_n20 gnd__t17_p_n20 0 16.5511
rgnd_t18_p_n20 gnd__t18_p_n20 0 16.5511
rgnd_t19_p_n20 gnd__t19_p_n20 0 24.2409
rgnd_t20_p_n20 gnd__t20_p_n20 0 24.2409
rgnd_t21_p_n20 gnd__t21_p_n20 0 16.5511
rgnd_t22_p_n20 gnd__t22_p_n20 0 16.5511
rgnd_t23_p_n20 gnd__t23_p_n20 0 24.2409
rgnd_t24_p_n20 gnd__t24_p_n20 0 18.9833
rgnd_t25_p_n20 gnd__t25_p_n20 0 6.8325
rgnd_t26_p_n20 gnd__t26_p_n20 0 6.8325
rgnd_t27_p_n20 gnd__t27_p_n20 0 18.9833
rgnd_t28_p_n20 gnd__t28_p_n20 0 28.0185
rgnd_t29_p_n20 gnd__t29_p_n20 0 21.7106
rgnd_t30_p_n20 gnd__t30_p_n20 0 21.7106
rgnd_t31_p_n20 gnd__t31_p_n20 0 28.0185
rbl_0_t0_p_n20 bl_0__t0_p_n20 bl_0_p_n20 14.8304
rbl_0_t1_p_n20 bl_0__t1_p_n20 bl_0_p_n20 10.9301
rbl_0_t2_p_n20 bl_0__t2_p_n20 bl_0_p_n20 14.8304
rbl_0_t3_p_n20 bl_0__t3_p_n20 bl_0_p_n20 10.9301
rbl_1_t0_p_n20 bl_1__t0_p_n20 bl_1_p_n20 10.9301
rbl_1_t1_p_n20 bl_1__t1_p_n20 bl_1_p_n20 14.8304
rbl_1_t2_p_n20 bl_1__t2_p_n20 bl_1_p_n20 14.8304
rbl_1_t3_p_n20 bl_1__t3_p_n20 bl_1_p_n20 10.9301
rbl_2_t0_p_n20 bl_2__t0_p_n20 bl_2_p_n20 10.9301
rbl_2_t1_p_n20 bl_2__t1_p_n20 bl_2_p_n20 14.8304
rbl_2_t2_p_n20 bl_2__t2_p_n20 bl_2_p_n20 14.8304
rbl_2_t3_p_n20 bl_2__t3_p_n20 bl_2_p_n20 10.9301
rbl_3_t0_p_n20 bl_3__t0_p_n20 bl_3_p_n20 14.8304
rbl_3_t1_p_n20 bl_3__t1_p_n20 bl_3_p_n20 10.9301
rbl_3_t2_p_n20 bl_3__t2_p_n20 bl_3_p_n20 14.8304
rbl_3_t3_p_n20 bl_3__t3_p_n20 bl_3_p_n20 10.9301
rrbl_0_t0_p_n20 rbl_0__t0_p_n20 rbl_0_p_n20 36.5601
rrbl_0_t1_p_n20 rbl_0__t1_p_n20 rbl_0_p_n20 36.5601
rrbl_0_t2_p_n20 rbl_0__t2_p_n20 rbl_0_p_n20 2.99444
rrbl_0_t3_p_n20 rbl_0__t3_p_n20 rbl_0_p_n20 2.99444
rrbl_1_t0_p_n20 rbl_1__t0_p_n20 rbl_1_p_n20 36.5601
rrbl_1_t1_p_n20 rbl_1__t1_p_n20 rbl_1_p_n20 36.5601
rrbl_1_t2_p_n20 rbl_1__t2_p_n20 rbl_1_p_n20 2.99444
rrbl_1_t3_p_n20 rbl_1__t3_p_n20 rbl_1_p_n20 2.99444
rrbl_2_t0_p_n20 rbl_2__t0_p_n20 rbl_2_p_n20 36.5601
rrbl_2_t1_p_n20 rbl_2__t1_p_n20 rbl_2_p_n20 36.5601
rrbl_2_t2_p_n20 rbl_2__t2_p_n20 rbl_2_p_n20 2.99444
rrbl_2_t3_p_n20 rbl_2__t3_p_n20 rbl_2_p_n20 2.99444
rrbl_3_t0_p_n20 rbl_3__t0_p_n20 rbl_3_p_n20 36.5601
rrbl_3_t1_p_n20 rbl_3__t1_p_n20 rbl_3_p_n20 36.5601
rrbl_3_t2_p_n20 rbl_3__t2_p_n20 rbl_3_p_n20 2.99444
rrbl_3_t3_p_n20 rbl_3__t3_p_n20 rbl_3_p_n20 2.99444
rrwl_0_t0_p_n20 rwl_0__t0_p_n20 rwl_0_p_n20 38.2618
rrwl_0_t1_p_n20 rwl_0__t1_p_n20 rwl_0_p_n20 12.7539
rrwl_0_t2_p_n20 rwl_0__t2_p_n20 rwl_0_p_n20 38.2618
rrwl_0_t3_p_n20 rwl_0__t3_p_n20 rwl_0_p_n20 12.7539
rrwl_1_t0_p_n20 rwl_1__t0_p_n20 rwl_1_p_n20 38.2618
rrwl_1_t1_p_n20 rwl_1__t1_p_n20 rwl_1_p_n20 12.7539
rrwl_1_t2_p_n20 rwl_1__t2_p_n20 rwl_1_p_n20 12.7539
rrwl_1_t3_p_n20 rwl_1__t3_p_n20 rwl_1_p_n20 38.2618
rrwl_2_t0_p_n20 rwl_2__t0_p_n20 rwl_2_p_n20 12.7539
rrwl_2_t1_p_n20 rwl_2__t1_p_n20 rwl_2_p_n20 12.7539
rrwl_2_t2_p_n20 rwl_2__t2_p_n20 rwl_2_p_n20 38.2618
rrwl_2_t3_p_n20 rwl_2__t3_p_n20 rwl_2_p_n20 38.2618
rrwl_3_t0_p_n20 rwl_3__t0_p_n20 rwl_3_p_n20 38.2618
rrwl_3_t1_p_n20 rwl_3__t1_p_n20 rwl_3_p_n20 12.7539
rrwl_3_t2_p_n20 rwl_3__t2_p_n20 rwl_3_p_n20 12.7539
rrwl_3_t3_p_n20 rwl_3__t3_p_n20 rwl_3_p_n20 38.2618
rwl_0_t0_p_n20 wl_0__t0_p_n20 wl_0_p_n20 245.959
rwl_0_t1_p_n20 wl_0__t1_p_n20 wl_0_p_n20 245.959
rwl_0_t2_p_n20 wl_0__t2_p_n20 wl_0_p_n20 81.9864
rwl_0_t3_p_n20 wl_0__t3_p_n20 wl_0_p_n20 81.9864
rwl_1_t0_p_n20 wl_1__t0_p_n20 wl_1_p_n20 245.959
rwl_1_t1_p_n20 wl_1__t1_p_n20 wl_1_p_n20 81.9864
rwl_1_t2_p_n20 wl_1__t2_p_n20 wl_1_p_n20 81.9864
rwl_1_t3_p_n20 wl_1__t3_p_n20 wl_1_p_n20 245.959
rwl_2_t0_p_n20 wl_2__t0_p_n20 wl_2_p_n20 245.959
rwl_2_t1_p_n20 wl_2__t1_p_n20 wl_2_p_n20 81.9864
rwl_2_t2_p_n20 wl_2__t2_p_n20 wl_2_p_n20 81.9864
rwl_2_t3_p_n20 wl_2__t3_p_n20 wl_2_p_n20 245.959
rwl_3_t0_p_n20 wl_3__t0_p_n20 wl_3_p_n20 245.959
rwl_3_t1_p_n20 wl_3__t1_p_n20 wl_3_p_n20 81.9864
rwl_3_t2_p_n20 wl_3__t2_p_n20 wl_3_p_n20 81.9864
rwl_3_t3_p_n20 wl_3__t3_p_n20 wl_3_p_n20 245.959
c_10_p_n20 n10_p_n20 0 2.91622e-16
c_17_p_n20 n17_p_n20 0 2.91528e-16
c_18_p_n20 n18_p_n20 0 2.91528e-16
c_19_p_n20 n19_p_n20 0 2.91528e-16
c_20_p_n20 n20_p_n20 0 1.13804e-16
c_22_p_n20 n22_p_n20 0 2.91528e-16
c_23_p_n20 n23_p_n20 0 2.91528e-16
c_24_p_n20 n24_p_n20 0 2.91528e-16
c_25_p_n20 n25_p_n20 0 2.91622e-16
c_29_p_n20 n29_p_n20 0 2.91528e-16
c_30_p_n20 n30_p_n20 0 2.91528e-16
c_31_p_n20 n31_p_n20 0 2.91528e-16
c_32_p_n20 n32_p_n20 0 2.91622e-16
c_7_p_n20 n7_p_n20 0 2.91528e-16
c_8_p_n20 n8_p_n20 0 2.91528e-16
c_9_p_n20 n9_p_n20 0 2.91528e-16
cgnd_p_n20 0 0 2.48166e-15
cbl_0_p_n20 bl_0_p_n20 0 4.52661e-16
cbl_1_p_n20 bl_1_p_n20 0 4.52661e-16
cbl_2_p_n20 bl_2_p_n20 0 4.52661e-16
cbl_3_p_n20 bl_3_p_n20 0 4.52661e-16
crbl_0_p_n20 rbl_0_p_n20 0 9.14472e-16
crbl_1_p_n20 rbl_1_p_n20 0 9.14472e-16
crbl_2_p_n20 rbl_2_p_n20 0 9.14472e-16
crbl_3_p_n20 rbl_3_p_n20 0 9.17566e-16
crwl_0_p_n20 rwl_0_p_n20 0 5.19495e-16
crwl_1_p_n20 rwl_1_p_n20 0 5.11719e-16
crwl_2_p_n20 rwl_2_p_n20 0 5.11719e-16
crwl_3_p_n20 rwl_3_p_n20 0 5.19495e-16
cwl_0_p_n20 wl_0_p_n20 0 3.30388e-16
cwl_1_p_n20 wl_1_p_n20 0 3.30388e-16
cwl_2_p_n20 wl_2_p_n20 0 3.30388e-16
cwl_3_p_n20 wl_3_p_n20 0 3.30388e-16
ccc__10__9_p_n20 n10_p_n20 n9_p_n20 1.02e-17
ccc__10_bl_3_p_n20 n10_p_n20 bl_3_p_n20 1.3999e-17
ccc__10_rwl_0_p_n20 n10_p_n20 rwl_0_p_n20 4.335e-18
ccc__17__18_p_n20 n17_p_n20 n18_p_n20 1.02e-17
ccc__17_bl_0_p_n20 n17_p_n20 bl_0_p_n20 8.415e-18
ccc__17_rwl_1_p_n20 n17_p_n20 rwl_1_p_n20 1.3194e-17
ccc__18__19_p_n20 n18_p_n20 n19_p_n20 1.02e-17
ccc__18_bl_1_p_n20 n18_p_n20 bl_1_p_n20 8.415e-18
ccc__18_rwl_1_p_n20 n18_p_n20 rwl_1_p_n20 1.3194e-17
ccc__19__20_p_n20 n19_p_n20 n20_p_n20 1.02e-17
ccc__19_bl_2_p_n20 n19_p_n20 bl_2_p_n20 8.415e-18
ccc__19_rwl_1_p_n20 n19_p_n20 rwl_1_p_n20 1.3194e-17
ccc__20_bl_3_p_n20 n20_p_n20 bl_3_p_n20 8.415e-18
ccc__20_rwl_1_p_n20 n20_p_n20 rwl_1_p_n20 6.655e-18
ccc__22__23_p_n20 n22_p_n20 n23_p_n20 1.02e-17
ccc__22_bl_0_p_n20 n22_p_n20 bl_0_p_n20 8.415e-18
ccc__22_rwl_2_p_n20 n22_p_n20 rwl_2_p_n20 1.3194e-17
ccc__23__24_p_n20 n23_p_n20 n24_p_n20 1.02e-17
ccc__23_bl_1_p_n20 n23_p_n20 bl_1_p_n20 8.415e-18
ccc__23_rwl_2_p_n20 n23_p_n20 rwl_2_p_n20 1.3194e-17
ccc__24__25_p_n20 n24_p_n20 n25_p_n20 1.02e-17
ccc__24_bl_2_p_n20 n24_p_n20 bl_2_p_n20 8.415e-18
ccc__24_rwl_2_p_n20 n24_p_n20 rwl_2_p_n20 1.3194e-17
ccc__25_bl_3_p_n20 n25_p_n20 bl_3_p_n20 8.415e-18
ccc__25_rwl_2_p_n20 n25_p_n20 rwl_2_p_n20 6.655e-18
ccc__29__30_p_n20 n29_p_n20 n30_p_n20 1.02e-17
ccc__29_bl_0_p_n20 n29_p_n20 bl_0_p_n20 8.415e-18
ccc__29_rwl_3_p_n20 n29_p_n20 rwl_3_p_n20 1.3194e-17
ccc__30__31_p_n20 n30_p_n20 n31_p_n20 1.02e-17
ccc__30_bl_1_p_n20 n30_p_n20 bl_1_p_n20 8.415e-18
ccc__30_rwl_3_p_n20 n30_p_n20 rwl_3_p_n20 1.3194e-17
ccc__31__32_p_n20 n31_p_n20 n32_p_n20 1.02e-17
ccc__31_bl_2_p_n20 n31_p_n20 bl_2_p_n20 8.415e-18
ccc__31_rwl_3_p_n20 n31_p_n20 rwl_3_p_n20 1.3194e-17
ccc__32_bl_3_p_n20 n32_p_n20 bl_3_p_n20 8.415e-18
ccc__32_rwl_3_p_n20 n32_p_n20 rwl_3_p_n20 6.655e-18
ccc__7__8_p_n20 n7_p_n20 n8_p_n20 1.02e-17
ccc__7_bl_0_p_n20 n7_p_n20 bl_0_p_n20 1.3999e-17
ccc__7_rwl_0_p_n20 n7_p_n20 rwl_0_p_n20 8.961e-18
ccc__8__9_p_n20 n8_p_n20 n9_p_n20 1.02e-17
ccc__8_bl_1_p_n20 n8_p_n20 bl_1_p_n20 1.3999e-17
ccc__8_rwl_0_p_n20 n8_p_n20 rwl_0_p_n20 8.961e-18
ccc__9_bl_2_p_n20 n9_p_n20 bl_2_p_n20 1.3999e-17
ccc__9_rwl_0_p_n20 n9_p_n20 rwl_0_p_n20 8.961e-18
ccc_bl_0_rbl_0_p_n20 bl_0_p_n20 rbl_0_p_n20 1.88693e-16
ccc_bl_0_rwl_1_p_n20 bl_0_p_n20 rwl_1_p_n20 1.0093e-17
ccc_bl_0_rwl_2_p_n20 bl_0_p_n20 rwl_2_p_n20 1.0093e-17
ccc_bl_1_rbl_0_p_n20 bl_1_p_n20 rbl_0_p_n20 1.633e-16
ccc_bl_1_rbl_1_p_n20 bl_1_p_n20 rbl_1_p_n20 1.88693e-16
ccc_bl_1_rwl_1_p_n20 bl_1_p_n20 rwl_1_p_n20 1.0093e-17
ccc_bl_1_rwl_2_p_n20 bl_1_p_n20 rwl_2_p_n20 1.0093e-17
ccc_bl_2_rbl_1_p_n20 bl_2_p_n20 rbl_1_p_n20 1.633e-16
ccc_bl_2_rbl_2_p_n20 bl_2_p_n20 rbl_2_p_n20 1.88693e-16
ccc_bl_2_rwl_1_p_n20 bl_2_p_n20 rwl_1_p_n20 1.0093e-17
ccc_bl_2_rwl_2_p_n20 bl_2_p_n20 rwl_2_p_n20 1.0093e-17
ccc_bl_3_rbl_2_p_n20 bl_3_p_n20 rbl_2_p_n20 1.633e-16
ccc_bl_3_rbl_3_p_n20 bl_3_p_n20 rbl_3_p_n20 1.88693e-16
ccc_bl_3_rwl_1_p_n20 bl_3_p_n20 rwl_1_p_n20 1.0093e-17
ccc_bl_3_rwl_2_p_n20 bl_3_p_n20 rwl_2_p_n20 1.0093e-17
ccc_rbl_0_rbl_1_p_n20 rbl_0_p_n20 rbl_1_p_n20 3.432e-17
ccc_rbl_0_rwl_0_p_n20 rbl_0_p_n20 rwl_0_p_n20 4.9752e-17
ccc_rbl_0_rwl_1_p_n20 rbl_0_p_n20 rwl_1_p_n20 4.9752e-17
ccc_rbl_0_rwl_2_p_n20 rbl_0_p_n20 rwl_2_p_n20 4.9752e-17
ccc_rbl_0_rwl_3_p_n20 rbl_0_p_n20 rwl_3_p_n20 4.9752e-17
ccc_rbl_1_rbl_2_p_n20 rbl_1_p_n20 rbl_2_p_n20 3.432e-17
ccc_rbl_1_rwl_0_p_n20 rbl_1_p_n20 rwl_0_p_n20 4.9752e-17
ccc_rbl_1_rwl_1_p_n20 rbl_1_p_n20 rwl_1_p_n20 4.9752e-17
ccc_rbl_1_rwl_2_p_n20 rbl_1_p_n20 rwl_2_p_n20 4.9752e-17
ccc_rbl_1_rwl_3_p_n20 rbl_1_p_n20 rwl_3_p_n20 4.9752e-17
ccc_rbl_2_rbl_3_p_n20 rbl_2_p_n20 rbl_3_p_n20 3.432e-17
ccc_rbl_2_rwl_0_p_n20 rbl_2_p_n20 rwl_0_p_n20 4.9752e-17
ccc_rbl_2_rwl_1_p_n20 rbl_2_p_n20 rwl_1_p_n20 4.9752e-17
ccc_rbl_2_rwl_2_p_n20 rbl_2_p_n20 rwl_2_p_n20 4.9752e-17
ccc_rbl_2_rwl_3_p_n20 rbl_2_p_n20 rwl_3_p_n20 4.9752e-17
ccc_rbl_3_rwl_0_p_n20 rbl_3_p_n20 rwl_0_p_n20 3.3407e-17
ccc_rbl_3_rwl_1_p_n20 rbl_3_p_n20 rwl_1_p_n20 3.3407e-17
ccc_rbl_3_rwl_2_p_n20 rbl_3_p_n20 rwl_2_p_n20 3.3407e-17
ccc_rbl_3_rwl_3_p_n20 rbl_3_p_n20 rwl_3_p_n20 3.3407e-17
vdw_p_n20_0 wl_0_p_n20 0 dc 0
vdr_p_n20_0 rwl_0_p_n20 vdd dc 0
vdw_p_n20_1 wl_1_p_n20 0 dc 0
vdr_p_n20_1 rwl_1_p_n20 vdd dc 0
vdw_p_n20_2 wl_2_p_n20 0 dc 0
vdr_p_n20_2 rwl_2_p_n20 vdd dc 0
vdw_p_n20_3 wl_3_p_n20 0 dc 0
vdr_p_n20_3 rwl_3_p_n20 vdd dc 0
vdb_p_n20_0 bl_0_p_n20 0 dc 0
vdp_p_n20_0 rbl_0_p_n20 vrbl dc 0
vdb_p_n20_1 bl_1_p_n20 0 dc 0
vdp_p_n20_1 rbl_1_p_n20 vrbl dc 0
vdb_p_n20_2 bl_2_p_n20 0 dc 0
vdp_p_n20_2 rbl_2_p_n20 vrbl dc 0
vdb_p_n20_3 bl_3_p_n20 0 dc 0
vdp_p_n20_3 rbl_3_p_n20 vrbl dc 0
vdn_p_n20_n7 n7_p_n20 0 dc 1
vdn_p_n20_n8 n8_p_n20 0 dc 1
vdn_p_n20_n9 n9_p_n20 0 dc 1
vdn_p_n20_n10 n10_p_n20 0 dc 1
vdn_p_n20_n17 n17_p_n20 0 dc 1
vdn_p_n20_n18 n18_p_n20 0 dc 1
vdn_p_n20_n19 n19_p_n20 0 dc 1
vdn_p_n20_n22 n22_p_n20 0 dc 1
vdn_p_n20_n23 n23_p_n20 0 dc 1
vdn_p_n20_n24 n24_p_n20 0 dc 1
vdn_p_n20_n25 n25_p_n20 0 dc 1
vdn_p_n20_n29 n29_p_n20 0 dc 1
vdn_p_n20_n30 n30_p_n20 0 dc 1
vdn_p_n20_n31 n31_p_n20 0 dc 1
vdn_p_n20_n32 n32_p_n20 0 dc 1
bdr_p_n20 n20_p_n20 0 i=5e-08*min(1,max(0,(time-1e-09)/0.2n))*0.5*(1+tanh((v(n20_p_n20)-0.05)/0.01))

* ---- instance p_n22: variant p, probed storage node \$22 ----
xm1_p_n22 rwl_0__t2_p_n22 n7__t0_p_n22 rbl_0__t0_p_n22 gnd__t0_p_n22 sky130_fd_pr__nfet_01v8 L=0.15 W=0.42 nf=1 ad=0.1197 as=0.1197 pd=1.41 ps=1.41 mult=1 m=1
xm2_p_n22 rwl_0__t3_p_n22 n8__t1_p_n22 rbl_1__t1_p_n22 gnd__t1_p_n22 sky130_fd_pr__nfet_01v8 L=0.15 W=0.42 nf=1 ad=0.1197 as=0.1197 pd=1.41 ps=1.41 mult=1 m=1
xm3_p_n22 rwl_0__t1_p_n22 n9__t1_p_n22 rbl_2__t1_p_n22 gnd__t2_p_n22 sky130_fd_pr__nfet_01v8 L=0.15 W=0.42 nf=1 ad=0.1197 as=0.1197 pd=1.41 ps=1.41 mult=1 m=1
xm4_p_n22 rwl_0__t0_p_n22 n10__t1_p_n22 rbl_3__t1_p_n22 gnd__t3_p_n22 sky130_fd_pr__nfet_01v8 L=0.15 W=0.42 nf=1 ad=0.1197 as=0.1197 pd=1.41 ps=1.41 mult=1 m=1
xm5_p_n22 bl_0__t0_p_n22 wl_0__t0_p_n22 n7__t1_p_n22 gnd__t8_p_n22 sky130_fd_pr__nfet_01v8 L=0.15 W=0.42 nf=1 ad=0.0588 as=0.1197 pd=0.7 ps=1.41 mult=1 m=1
xm6_p_n22 n17__t0_p_n22 wl_1__t0_p_n22 bl_0__t1_p_n22 gnd__t20_p_n22 sky130_fd_pr__nfet_01v8 L=0.15 W=0.42 nf=1 ad=0.1197 as=0.0588 pd=1.41 ps=0.7 mult=1 m=1
xm7_p_n22 bl_1__t2_p_n22 wl_0__t3_p_n22 n8__t0_p_n22 gnd__t9_p_n22 sky130_fd_pr__nfet_01v8 L=0.15 W=0.42 nf=1 ad=0.0588 as=0.1197 pd=0.7 ps=1.41 mult=1 m=1
xm8_p_n22 n18__t0_p_n22 wl_1__t1_p_n22 bl_1__t0_p_n22 gnd__t21_p_n22 sky130_fd_pr__nfet_01v8 L=0.15 W=0.42 nf=1 ad=0.1197 as=0.0588 pd=1.41 ps=0.7 mult=1 m=1
xm9_p_n22 bl_2__t2_p_n22 wl_0__t2_p_n22 n9__t0_p_n22 gnd__t10_p_n22 sky130_fd_pr__nfet_01v8 L=0.15 W=0.42 nf=1 ad=0.0588 as=0.1197 pd=0.7 ps=1.41 mult=1 m=1
xm10_p_n22 n19__t0_p_n22 wl_1__t2_p_n22 bl_2__t0_p_n22 gnd__t22_p_n22 sky130_fd_pr__nfet_01v8 L=0.15 W=0.42 nf=1 ad=0.1197 as=0.0588 pd=1.41 ps=0.7 mult=1 m=1
xm11_p_n22 bl_3__t2_p_n22 wl_0__t1_p_n22 n10__t0_p_n22 gnd__t11_p_n22 sky130_fd_pr__nfet_01v8 L=0.15 W=0.42 nf=1 ad=0.0588 as=0.1197 pd=0.7 ps=1.41 mult=1 m=1
xm12_p_n22 n20__t0_p_n22 wl_1__t3_p_n22 bl_3__t1_p_n22 gnd__t23_p_n22 sky130_fd_pr__nfet_01v8 L=0.15 W=0.42 nf=1 ad=0.1197 as=0.0588 pd=1.41 ps=0.7 mult=1 m=1
xm13_p_n22 rbl_0__t3_p_n22 n17__t1_p_n22 rwl_1__t0_p_n22 gnd__t12_p_n22 sky130_fd_pr__nfet_01v8 L=0.15 W=0.42 nf=1 ad=0.0588 as=0.1197 pd=0.7 ps=1.41 mult=1 m=1
xm14_p_n22 rwl_2__t3_p_n22 n22__t0_p_n22 rbl_0__t2_p_n22 gnd__t24_p_n22 sky130_fd_pr__nfet_01v8 L=0.15 W=0.42 nf=1 ad=0.1197 as=0.0588 pd=1.41 ps=0.7 mult=1 m=1
xm15_p_n22 rbl_1__t3_p_n22 n18__t1_p_n22 rwl_1__t1_p_n22 gnd__t13_p_n22 sky130_fd_pr__nfet_01v8 L=0.15 W=0.42 nf=1 ad=0.0588 as=0.1197 pd=0.7 ps=1.41 mult=1 m=1
xm16_p_n22 rwl_2__t0_p_n22 n23__t0_p_n22 rbl_1__t2_p_n22 gnd__t25_p_n22 sky130_fd_pr__nfet_01v8 L=0.15 W=0.42 nf=1 ad=0.1197 as=0.0588 pd=1.41 ps=0.7 mult=1 m=1
xm17_p_n22 rbl_2__t3_p_n22 n19__t1_p_n22 rwl_1__t2_p_n22 gnd__t14_p_n22 sky130_fd_pr__nfet_01v8 L=0.15 W=0.42 nf=1 ad=0.0588 as=0.1197 pd=0.7 ps=1.41 mult=1 m=1
xm18_p_n22 rwl_2__t1_p_n22 n24__t0_p_n22 rbl_2__t2_p_n22 gnd__t26_p_n22 sky130_fd_pr__nfet_01v8 L=0.15 W=0.42 nf=1 ad=0.1197 as=0.0588 pd=1.41 ps=0.7 mult=1 m=1
xm19_p_n22 rbl_3__t3_p_n22 n20__t1_p_n22 rwl_1__t3_p_n22 gnd__t15_p_n22 sky130_fd_pr__nfet_01v8 L=0.15 W=0.42 nf=1 ad=0.0588 as=0.1197 pd=0.7 ps=1.41 mult=1 m=1
xm20_p_n22 rwl_2__t2_p_n22 n25__t0_p_n22 rbl_3__t2_p_n22 gnd__t27_p_n22 sky130_fd_pr__nfet_01v8 L=0.15 W=0.42 nf=1 ad=0.1197 as=0.0588 pd=1.41 ps=0.7 mult=1 m=1
xm21_p_n22 bl_0__t3_p_n22 wl_2__t0_p_n22 n22__t1_p_n22 gnd__t16_p_n22 sky130_fd_pr__nfet_01v8 L=0.15 W=0.42 nf=1 ad=0.0588 as=0.1197 pd=0.7 ps=1.41 mult=1 m=1
xm22_p_n22 n29__t0_p_n22 wl_3__t3_p_n22 bl_0__t2_p_n22 gnd__t28_p_n22 sky130_fd_pr__nfet_01v8 L=0.15 W=0.42 nf=1 ad=0.1197 as=0.0588 pd=1.41 ps=0.7 mult=1 m=1
xm23_p_n22 bl_1__t3_p_n22 wl_2__t1_p_n22 n23__t1_p_n22 gnd__t17_p_n22 sky130_fd_pr__nfet_01v8 L=0.15 W=0.42 nf=1 ad=0.0588 as=0.1197 pd=0.7 ps=1.41 mult=1 m=1
xm24_p_n22 n30__t0_p_n22 wl_3__t2_p_n22 bl_1__t1_p_n22 gnd__t29_p_n22 sky130_fd_pr__nfet_01v8 L=0.15 W=0.42 nf=1 ad=0.1197 as=0.0588 pd=1.41 ps=0.7 mult=1 m=1
xm25_p_n22 bl_2__t3_p_n22 wl_2__t2_p_n22 n24__t1_p_n22 gnd__t18_p_n22 sky130_fd_pr__nfet_01v8 L=0.15 W=0.42 nf=1 ad=0.0588 as=0.1197 pd=0.7 ps=1.41 mult=1 m=1
xm26_p_n22 n31__t0_p_n22 wl_3__t1_p_n22 bl_2__t1_p_n22 gnd__t30_p_n22 sky130_fd_pr__nfet_01v8 L=0.15 W=0.42 nf=1 ad=0.1197 as=0.0588 pd=1.41 ps=0.7 mult=1 m=1
xm27_p_n22 bl_3__t3_p_n22 wl_2__t3_p_n22 n25__t1_p_n22 gnd__t19_p_n22 sky130_fd_pr__nfet_01v8 L=0.15 W=0.42 nf=1 ad=0.0588 as=0.1197 pd=0.7 ps=1.41 mult=1 m=1
xm28_p_n22 n32__t0_p_n22 wl_3__t0_p_n22 bl_3__t0_p_n22 gnd__t31_p_n22 sky130_fd_pr__nfet_01v8 L=0.15 W=0.42 nf=1 ad=0.1197 as=0.0588 pd=1.41 ps=0.7 mult=1 m=1
xm29_p_n22 rbl_0__t1_p_n22 n29__t1_p_n22 rwl_3__t0_p_n22 gnd__t4_p_n22 sky130_fd_pr__nfet_01v8 L=0.15 W=0.42 nf=1 ad=0.1197 as=0.1197 pd=1.41 ps=1.41 mult=1 m=1
xm30_p_n22 rbl_1__t0_p_n22 n30__t1_p_n22 rwl_3__t1_p_n22 gnd__t5_p_n22 sky130_fd_pr__nfet_01v8 L=0.15 W=0.42 nf=1 ad=0.1197 as=0.1197 pd=1.41 ps=1.41 mult=1 m=1
xm31_p_n22 rbl_2__t0_p_n22 n31__t1_p_n22 rwl_3__t2_p_n22 gnd__t6_p_n22 sky130_fd_pr__nfet_01v8 L=0.15 W=0.42 nf=1 ad=0.1197 as=0.1197 pd=1.41 ps=1.41 mult=1 m=1
xm32_p_n22 rbl_3__t0_p_n22 n32__t1_p_n22 rwl_3__t3_p_n22 gnd__t7_p_n22 sky130_fd_pr__nfet_01v8 L=0.15 W=0.42 nf=1 ad=0.1197 as=0.1197 pd=1.41 ps=1.41 mult=1 m=1
r_10_t0_p_n22 n10__t0_p_n22 n10_p_n22 183.071
r_10_t1_p_n22 n10__t1_p_n22 n10_p_n22 183.071
r_17_t0_p_n22 n17__t0_p_n22 n17_p_n22 183.071
r_17_t1_p_n22 n17__t1_p_n22 n17_p_n22 183.071
r_18_t0_p_n22 n18__t0_p_n22 n18_p_n22 183.071
r_18_t1_p_n22 n18__t1_p_n22 n18_p_n22 183.071
r_19_t0_p_n22 n19__t0_p_n22 n19_p_n22 183.071
r_19_t1_p_n22 n19__t1_p_n22 n19_p_n22 183.071
r_20_t0_p_n22 n20__t0_p_n22 n20_p_n22 183.071
r_20_t1_p_n22 n20__t1_p_n22 n20_p_n22 183.071
r_22_t0_p_n22 n22__t0_p_n22 n22_p_n22 183.071
r_22_t1_p_n22 n22__t1_p_n22 n22_p_n22 183.071
r_23_t0_p_n22 n23__t0_p_n22 n23_p_n22 183.071
r_23_t1_p_n22 n23__t1_p_n22 n23_p_n22 183.071
r_24_t0_p_n22 n24__t0_p_n22 n24_p_n22 183.071
r_24_t1_p_n22 n24__t1_p_n22 n24_p_n22 183.071
r_25_t0_p_n22 n25__t0_p_n22 n25_p_n22 183.071
r_25_t1_p_n22 n25__t1_p_n22 n25_p_n22 183.071
r_29_t0_p_n22 n29__t0_p_n22 n29_p_n22 183.071
r_29_t1_p_n22 n29__t1_p_n22 n29_p_n22 183.071
r_30_t0_p_n22 n30__t0_p_n22 n30_p_n22 183.071
r_30_t1_p_n22 n30__t1_p_n22 n30_p_n22 183.071
r_31_t0_p_n22 n31__t0_p_n22 n31_p_n22 183.071
r_31_t1_p_n22 n31__t1_p_n22 n31_p_n22 183.071
r_32_t0_p_n22 n32__t0_p_n22 n32_p_n22 183.071
r_32_t1_p_n22 n32__t1_p_n22 n32_p_n22 183.071
r_7_t0_p_n22 n7__t0_p_n22 n7_p_n22 183.071
r_7_t1_p_n22 n7__t1_p_n22 n7_p_n22 183.071
r_8_t0_p_n22 n8__t0_p_n22 n8_p_n22 183.071
r_8_t1_p_n22 n8__t1_p_n22 n8_p_n22 183.071
r_9_t0_p_n22 n9__t0_p_n22 n9_p_n22 183.071
r_9_t1_p_n22 n9__t1_p_n22 n9_p_n22 183.071
rgnd_t0_p_n22 gnd__t0_p_n22 0 38.2988
rgnd_t1_p_n22 gnd__t1_p_n22 0 33.9576
rgnd_t2_p_n22 gnd__t2_p_n22 0 33.9576
rgnd_t3_p_n22 gnd__t3_p_n22 0 38.2988
rgnd_t4_p_n22 gnd__t4_p_n22 0 38.2988
rgnd_t5_p_n22 gnd__t5_p_n22 0 33.9576
rgnd_t6_p_n22 gnd__t6_p_n22 0 33.9576
rgnd_t7_p_n22 gnd__t7_p_n22 0 38.2988
rgnd_t8_p_n22 gnd__t8_p_n22 0 28.0185
rgnd_t9_p_n22 gnd__t9_p_n22 0 21.7106
rgnd_t10_p_n22 gnd__t10_p_n22 0 21.7106
rgnd_t11_p_n22 gnd__t11_p_n22 0 28.0185
rgnd_t12_p_n22 gnd__t12_p_n22 0 18.9833
rgnd_t13_p_n22 gnd__t13_p_n22 0 6.8325
rgnd_t14_p_n22 gnd__t14_p_n22 0 6.8325
rgnd_t15_p_n22 gnd__t15_p_n22 0 18.9833
rgnd_t16_p_n22 gnd__t16_p_n22 0 24.2409
rgnd_t17_p_n22 gnd__t17_p_n22 0 16.5511
rgnd_t18_p_n22 gnd__t18_p_n22 0 16.5511
rgnd_t19_p_n22 gnd__t19_p_n22 0 24.2409
rgnd_t20_p_n22 gnd__t20_p_n22 0 24.2409
rgnd_t21_p_n22 gnd__t21_p_n22 0 16.5511
rgnd_t22_p_n22 gnd__t22_p_n22 0 16.5511
rgnd_t23_p_n22 gnd__t23_p_n22 0 24.2409
rgnd_t24_p_n22 gnd__t24_p_n22 0 18.9833
rgnd_t25_p_n22 gnd__t25_p_n22 0 6.8325
rgnd_t26_p_n22 gnd__t26_p_n22 0 6.8325
rgnd_t27_p_n22 gnd__t27_p_n22 0 18.9833
rgnd_t28_p_n22 gnd__t28_p_n22 0 28.0185
rgnd_t29_p_n22 gnd__t29_p_n22 0 21.7106
rgnd_t30_p_n22 gnd__t30_p_n22 0 21.7106
rgnd_t31_p_n22 gnd__t31_p_n22 0 28.0185
rbl_0_t0_p_n22 bl_0__t0_p_n22 bl_0_p_n22 14.8304
rbl_0_t1_p_n22 bl_0__t1_p_n22 bl_0_p_n22 10.9301
rbl_0_t2_p_n22 bl_0__t2_p_n22 bl_0_p_n22 14.8304
rbl_0_t3_p_n22 bl_0__t3_p_n22 bl_0_p_n22 10.9301
rbl_1_t0_p_n22 bl_1__t0_p_n22 bl_1_p_n22 10.9301
rbl_1_t1_p_n22 bl_1__t1_p_n22 bl_1_p_n22 14.8304
rbl_1_t2_p_n22 bl_1__t2_p_n22 bl_1_p_n22 14.8304
rbl_1_t3_p_n22 bl_1__t3_p_n22 bl_1_p_n22 10.9301
rbl_2_t0_p_n22 bl_2__t0_p_n22 bl_2_p_n22 10.9301
rbl_2_t1_p_n22 bl_2__t1_p_n22 bl_2_p_n22 14.8304
rbl_2_t2_p_n22 bl_2__t2_p_n22 bl_2_p_n22 14.8304
rbl_2_t3_p_n22 bl_2__t3_p_n22 bl_2_p_n22 10.9301
rbl_3_t0_p_n22 bl_3__t0_p_n22 bl_3_p_n22 14.8304
rbl_3_t1_p_n22 bl_3__t1_p_n22 bl_3_p_n22 10.9301
rbl_3_t2_p_n22 bl_3__t2_p_n22 bl_3_p_n22 14.8304
rbl_3_t3_p_n22 bl_3__t3_p_n22 bl_3_p_n22 10.9301
rrbl_0_t0_p_n22 rbl_0__t0_p_n22 rbl_0_p_n22 36.5601
rrbl_0_t1_p_n22 rbl_0__t1_p_n22 rbl_0_p_n22 36.5601
rrbl_0_t2_p_n22 rbl_0__t2_p_n22 rbl_0_p_n22 2.99444
rrbl_0_t3_p_n22 rbl_0__t3_p_n22 rbl_0_p_n22 2.99444
rrbl_1_t0_p_n22 rbl_1__t0_p_n22 rbl_1_p_n22 36.5601
rrbl_1_t1_p_n22 rbl_1__t1_p_n22 rbl_1_p_n22 36.5601
rrbl_1_t2_p_n22 rbl_1__t2_p_n22 rbl_1_p_n22 2.99444
rrbl_1_t3_p_n22 rbl_1__t3_p_n22 rbl_1_p_n22 2.99444
rrbl_2_t0_p_n22 rbl_2__t0_p_n22 rbl_2_p_n22 36.5601
rrbl_2_t1_p_n22 rbl_2__t1_p_n22 rbl_2_p_n22 36.5601
rrbl_2_t2_p_n22 rbl_2__t2_p_n22 rbl_2_p_n22 2.99444
rrbl_2_t3_p_n22 rbl_2__t3_p_n22 rbl_2_p_n22 2.99444
rrbl_3_t0_p_n22 rbl_3__t0_p_n22 rbl_3_p_n22 36.5601
rrbl_3_t1_p_n22 rbl_3__t1_p_n22 rbl_3_p_n22 36.5601
rrbl_3_t2_p_n22 rbl_3__t2_p_n22 rbl_3_p_n22 2.99444
rrbl_3_t3_p_n22 rbl_3__t3_p_n22 rbl_3_p_n22 2.99444
rrwl_0_t0_p_n22 rwl_0__t0_p_n22 rwl_0_p_n22 38.2618
rrwl_0_t1_p_n22 rwl_0__t1_p_n22 rwl_0_p_n22 12.7539
rrwl_0_t2_p_n22 rwl_0__t2_p_n22 rwl_0_p_n22 38.2618
rrwl_0_t3_p_n22 rwl_0__t3_p_n22 rwl_0_p_n22 12.7539
rrwl_1_t0_p_n22 rwl_1__t0_p_n22 rwl_1_p_n22 38.2618
rrwl_1_t1_p_n22 rwl_1__t1_p_n22 rwl_1_p_n22 12.7539
rrwl_1_t2_p_n22 rwl_1__t2_p_n22 rwl_1_p_n22 12.7539
rrwl_1_t3_p_n22 rwl_1__t3_p_n22 rwl_1_p_n22 38.2618
rrwl_2_t0_p_n22 rwl_2__t0_p_n22 rwl_2_p_n22 12.7539
rrwl_2_t1_p_n22 rwl_2__t1_p_n22 rwl_2_p_n22 12.7539
rrwl_2_t2_p_n22 rwl_2__t2_p_n22 rwl_2_p_n22 38.2618
rrwl_2_t3_p_n22 rwl_2__t3_p_n22 rwl_2_p_n22 38.2618
rrwl_3_t0_p_n22 rwl_3__t0_p_n22 rwl_3_p_n22 38.2618
rrwl_3_t1_p_n22 rwl_3__t1_p_n22 rwl_3_p_n22 12.7539
rrwl_3_t2_p_n22 rwl_3__t2_p_n22 rwl_3_p_n22 12.7539
rrwl_3_t3_p_n22 rwl_3__t3_p_n22 rwl_3_p_n22 38.2618
rwl_0_t0_p_n22 wl_0__t0_p_n22 wl_0_p_n22 245.959
rwl_0_t1_p_n22 wl_0__t1_p_n22 wl_0_p_n22 245.959
rwl_0_t2_p_n22 wl_0__t2_p_n22 wl_0_p_n22 81.9864
rwl_0_t3_p_n22 wl_0__t3_p_n22 wl_0_p_n22 81.9864
rwl_1_t0_p_n22 wl_1__t0_p_n22 wl_1_p_n22 245.959
rwl_1_t1_p_n22 wl_1__t1_p_n22 wl_1_p_n22 81.9864
rwl_1_t2_p_n22 wl_1__t2_p_n22 wl_1_p_n22 81.9864
rwl_1_t3_p_n22 wl_1__t3_p_n22 wl_1_p_n22 245.959
rwl_2_t0_p_n22 wl_2__t0_p_n22 wl_2_p_n22 245.959
rwl_2_t1_p_n22 wl_2__t1_p_n22 wl_2_p_n22 81.9864
rwl_2_t2_p_n22 wl_2__t2_p_n22 wl_2_p_n22 81.9864
rwl_2_t3_p_n22 wl_2__t3_p_n22 wl_2_p_n22 245.959
rwl_3_t0_p_n22 wl_3__t0_p_n22 wl_3_p_n22 245.959
rwl_3_t1_p_n22 wl_3__t1_p_n22 wl_3_p_n22 81.9864
rwl_3_t2_p_n22 wl_3__t2_p_n22 wl_3_p_n22 81.9864
rwl_3_t3_p_n22 wl_3__t3_p_n22 wl_3_p_n22 245.959
c_10_p_n22 n10_p_n22 0 2.91622e-16
c_17_p_n22 n17_p_n22 0 2.91528e-16
c_18_p_n22 n18_p_n22 0 2.91528e-16
c_19_p_n22 n19_p_n22 0 2.91528e-16
c_20_p_n22 n20_p_n22 0 2.91622e-16
c_22_p_n22 n22_p_n22 0 1.1371e-16
c_23_p_n22 n23_p_n22 0 2.91528e-16
c_24_p_n22 n24_p_n22 0 2.91528e-16
c_25_p_n22 n25_p_n22 0 2.91622e-16
c_29_p_n22 n29_p_n22 0 2.91528e-16
c_30_p_n22 n30_p_n22 0 2.91528e-16
c_31_p_n22 n31_p_n22 0 2.91528e-16
c_32_p_n22 n32_p_n22 0 2.91622e-16
c_7_p_n22 n7_p_n22 0 2.91528e-16
c_8_p_n22 n8_p_n22 0 2.91528e-16
c_9_p_n22 n9_p_n22 0 2.91528e-16
cgnd_p_n22 0 0 2.48166e-15
cbl_0_p_n22 bl_0_p_n22 0 4.52661e-16
cbl_1_p_n22 bl_1_p_n22 0 4.52661e-16
cbl_2_p_n22 bl_2_p_n22 0 4.52661e-16
cbl_3_p_n22 bl_3_p_n22 0 4.52661e-16
crbl_0_p_n22 rbl_0_p_n22 0 9.14472e-16
crbl_1_p_n22 rbl_1_p_n22 0 9.14472e-16
crbl_2_p_n22 rbl_2_p_n22 0 9.14472e-16
crbl_3_p_n22 rbl_3_p_n22 0 9.17566e-16
crwl_0_p_n22 rwl_0_p_n22 0 5.19495e-16
crwl_1_p_n22 rwl_1_p_n22 0 5.11719e-16
crwl_2_p_n22 rwl_2_p_n22 0 5.11719e-16
crwl_3_p_n22 rwl_3_p_n22 0 5.19495e-16
cwl_0_p_n22 wl_0_p_n22 0 3.30388e-16
cwl_1_p_n22 wl_1_p_n22 0 3.30388e-16
cwl_2_p_n22 wl_2_p_n22 0 3.30388e-16
cwl_3_p_n22 wl_3_p_n22 0 3.30388e-16
ccc__10__9_p_n22 n10_p_n22 n9_p_n22 1.02e-17
ccc__10_bl_3_p_n22 n10_p_n22 bl_3_p_n22 1.3999e-17
ccc__10_rwl_0_p_n22 n10_p_n22 rwl_0_p_n22 4.335e-18
ccc__17__18_p_n22 n17_p_n22 n18_p_n22 1.02e-17
ccc__17_bl_0_p_n22 n17_p_n22 bl_0_p_n22 8.415e-18
ccc__17_rwl_1_p_n22 n17_p_n22 rwl_1_p_n22 1.3194e-17
ccc__18__19_p_n22 n18_p_n22 n19_p_n22 1.02e-17
ccc__18_bl_1_p_n22 n18_p_n22 bl_1_p_n22 8.415e-18
ccc__18_rwl_1_p_n22 n18_p_n22 rwl_1_p_n22 1.3194e-17
ccc__19__20_p_n22 n19_p_n22 n20_p_n22 1.02e-17
ccc__19_bl_2_p_n22 n19_p_n22 bl_2_p_n22 8.415e-18
ccc__19_rwl_1_p_n22 n19_p_n22 rwl_1_p_n22 1.3194e-17
ccc__20_bl_3_p_n22 n20_p_n22 bl_3_p_n22 8.415e-18
ccc__20_rwl_1_p_n22 n20_p_n22 rwl_1_p_n22 6.655e-18
ccc__22__23_p_n22 n22_p_n22 n23_p_n22 1.02e-17
ccc__22_bl_0_p_n22 n22_p_n22 bl_0_p_n22 8.415e-18
ccc__22_rwl_2_p_n22 n22_p_n22 rwl_2_p_n22 1.3194e-17
ccc__23__24_p_n22 n23_p_n22 n24_p_n22 1.02e-17
ccc__23_bl_1_p_n22 n23_p_n22 bl_1_p_n22 8.415e-18
ccc__23_rwl_2_p_n22 n23_p_n22 rwl_2_p_n22 1.3194e-17
ccc__24__25_p_n22 n24_p_n22 n25_p_n22 1.02e-17
ccc__24_bl_2_p_n22 n24_p_n22 bl_2_p_n22 8.415e-18
ccc__24_rwl_2_p_n22 n24_p_n22 rwl_2_p_n22 1.3194e-17
ccc__25_bl_3_p_n22 n25_p_n22 bl_3_p_n22 8.415e-18
ccc__25_rwl_2_p_n22 n25_p_n22 rwl_2_p_n22 6.655e-18
ccc__29__30_p_n22 n29_p_n22 n30_p_n22 1.02e-17
ccc__29_bl_0_p_n22 n29_p_n22 bl_0_p_n22 8.415e-18
ccc__29_rwl_3_p_n22 n29_p_n22 rwl_3_p_n22 1.3194e-17
ccc__30__31_p_n22 n30_p_n22 n31_p_n22 1.02e-17
ccc__30_bl_1_p_n22 n30_p_n22 bl_1_p_n22 8.415e-18
ccc__30_rwl_3_p_n22 n30_p_n22 rwl_3_p_n22 1.3194e-17
ccc__31__32_p_n22 n31_p_n22 n32_p_n22 1.02e-17
ccc__31_bl_2_p_n22 n31_p_n22 bl_2_p_n22 8.415e-18
ccc__31_rwl_3_p_n22 n31_p_n22 rwl_3_p_n22 1.3194e-17
ccc__32_bl_3_p_n22 n32_p_n22 bl_3_p_n22 8.415e-18
ccc__32_rwl_3_p_n22 n32_p_n22 rwl_3_p_n22 6.655e-18
ccc__7__8_p_n22 n7_p_n22 n8_p_n22 1.02e-17
ccc__7_bl_0_p_n22 n7_p_n22 bl_0_p_n22 1.3999e-17
ccc__7_rwl_0_p_n22 n7_p_n22 rwl_0_p_n22 8.961e-18
ccc__8__9_p_n22 n8_p_n22 n9_p_n22 1.02e-17
ccc__8_bl_1_p_n22 n8_p_n22 bl_1_p_n22 1.3999e-17
ccc__8_rwl_0_p_n22 n8_p_n22 rwl_0_p_n22 8.961e-18
ccc__9_bl_2_p_n22 n9_p_n22 bl_2_p_n22 1.3999e-17
ccc__9_rwl_0_p_n22 n9_p_n22 rwl_0_p_n22 8.961e-18
ccc_bl_0_rbl_0_p_n22 bl_0_p_n22 rbl_0_p_n22 1.88693e-16
ccc_bl_0_rwl_1_p_n22 bl_0_p_n22 rwl_1_p_n22 1.0093e-17
ccc_bl_0_rwl_2_p_n22 bl_0_p_n22 rwl_2_p_n22 1.0093e-17
ccc_bl_1_rbl_0_p_n22 bl_1_p_n22 rbl_0_p_n22 1.633e-16
ccc_bl_1_rbl_1_p_n22 bl_1_p_n22 rbl_1_p_n22 1.88693e-16
ccc_bl_1_rwl_1_p_n22 bl_1_p_n22 rwl_1_p_n22 1.0093e-17
ccc_bl_1_rwl_2_p_n22 bl_1_p_n22 rwl_2_p_n22 1.0093e-17
ccc_bl_2_rbl_1_p_n22 bl_2_p_n22 rbl_1_p_n22 1.633e-16
ccc_bl_2_rbl_2_p_n22 bl_2_p_n22 rbl_2_p_n22 1.88693e-16
ccc_bl_2_rwl_1_p_n22 bl_2_p_n22 rwl_1_p_n22 1.0093e-17
ccc_bl_2_rwl_2_p_n22 bl_2_p_n22 rwl_2_p_n22 1.0093e-17
ccc_bl_3_rbl_2_p_n22 bl_3_p_n22 rbl_2_p_n22 1.633e-16
ccc_bl_3_rbl_3_p_n22 bl_3_p_n22 rbl_3_p_n22 1.88693e-16
ccc_bl_3_rwl_1_p_n22 bl_3_p_n22 rwl_1_p_n22 1.0093e-17
ccc_bl_3_rwl_2_p_n22 bl_3_p_n22 rwl_2_p_n22 1.0093e-17
ccc_rbl_0_rbl_1_p_n22 rbl_0_p_n22 rbl_1_p_n22 3.432e-17
ccc_rbl_0_rwl_0_p_n22 rbl_0_p_n22 rwl_0_p_n22 4.9752e-17
ccc_rbl_0_rwl_1_p_n22 rbl_0_p_n22 rwl_1_p_n22 4.9752e-17
ccc_rbl_0_rwl_2_p_n22 rbl_0_p_n22 rwl_2_p_n22 4.9752e-17
ccc_rbl_0_rwl_3_p_n22 rbl_0_p_n22 rwl_3_p_n22 4.9752e-17
ccc_rbl_1_rbl_2_p_n22 rbl_1_p_n22 rbl_2_p_n22 3.432e-17
ccc_rbl_1_rwl_0_p_n22 rbl_1_p_n22 rwl_0_p_n22 4.9752e-17
ccc_rbl_1_rwl_1_p_n22 rbl_1_p_n22 rwl_1_p_n22 4.9752e-17
ccc_rbl_1_rwl_2_p_n22 rbl_1_p_n22 rwl_2_p_n22 4.9752e-17
ccc_rbl_1_rwl_3_p_n22 rbl_1_p_n22 rwl_3_p_n22 4.9752e-17
ccc_rbl_2_rbl_3_p_n22 rbl_2_p_n22 rbl_3_p_n22 3.432e-17
ccc_rbl_2_rwl_0_p_n22 rbl_2_p_n22 rwl_0_p_n22 4.9752e-17
ccc_rbl_2_rwl_1_p_n22 rbl_2_p_n22 rwl_1_p_n22 4.9752e-17
ccc_rbl_2_rwl_2_p_n22 rbl_2_p_n22 rwl_2_p_n22 4.9752e-17
ccc_rbl_2_rwl_3_p_n22 rbl_2_p_n22 rwl_3_p_n22 4.9752e-17
ccc_rbl_3_rwl_0_p_n22 rbl_3_p_n22 rwl_0_p_n22 3.3407e-17
ccc_rbl_3_rwl_1_p_n22 rbl_3_p_n22 rwl_1_p_n22 3.3407e-17
ccc_rbl_3_rwl_2_p_n22 rbl_3_p_n22 rwl_2_p_n22 3.3407e-17
ccc_rbl_3_rwl_3_p_n22 rbl_3_p_n22 rwl_3_p_n22 3.3407e-17
vdw_p_n22_0 wl_0_p_n22 0 dc 0
vdr_p_n22_0 rwl_0_p_n22 vdd dc 0
vdw_p_n22_1 wl_1_p_n22 0 dc 0
vdr_p_n22_1 rwl_1_p_n22 vdd dc 0
vdw_p_n22_2 wl_2_p_n22 0 dc 0
vdr_p_n22_2 rwl_2_p_n22 vdd dc 0
vdw_p_n22_3 wl_3_p_n22 0 dc 0
vdr_p_n22_3 rwl_3_p_n22 vdd dc 0
vdb_p_n22_0 bl_0_p_n22 0 dc 0
vdp_p_n22_0 rbl_0_p_n22 vrbl dc 0
vdb_p_n22_1 bl_1_p_n22 0 dc 0
vdp_p_n22_1 rbl_1_p_n22 vrbl dc 0
vdb_p_n22_2 bl_2_p_n22 0 dc 0
vdp_p_n22_2 rbl_2_p_n22 vrbl dc 0
vdb_p_n22_3 bl_3_p_n22 0 dc 0
vdp_p_n22_3 rbl_3_p_n22 vrbl dc 0
vdn_p_n22_n7 n7_p_n22 0 dc 1
vdn_p_n22_n8 n8_p_n22 0 dc 1
vdn_p_n22_n9 n9_p_n22 0 dc 1
vdn_p_n22_n10 n10_p_n22 0 dc 1
vdn_p_n22_n17 n17_p_n22 0 dc 1
vdn_p_n22_n18 n18_p_n22 0 dc 1
vdn_p_n22_n19 n19_p_n22 0 dc 1
vdn_p_n22_n20 n20_p_n22 0 dc 1
vdn_p_n22_n23 n23_p_n22 0 dc 1
vdn_p_n22_n24 n24_p_n22 0 dc 1
vdn_p_n22_n25 n25_p_n22 0 dc 1
vdn_p_n22_n29 n29_p_n22 0 dc 1
vdn_p_n22_n30 n30_p_n22 0 dc 1
vdn_p_n22_n31 n31_p_n22 0 dc 1
vdn_p_n22_n32 n32_p_n22 0 dc 1
bdr_p_n22 n22_p_n22 0 i=5e-08*min(1,max(0,(time-1e-09)/0.2n))*0.5*(1+tanh((v(n22_p_n22)-0.05)/0.01))

* ---- instance p_n23: variant p, probed storage node \$23 ----
xm1_p_n23 rwl_0__t2_p_n23 n7__t0_p_n23 rbl_0__t0_p_n23 gnd__t0_p_n23 sky130_fd_pr__nfet_01v8 L=0.15 W=0.42 nf=1 ad=0.1197 as=0.1197 pd=1.41 ps=1.41 mult=1 m=1
xm2_p_n23 rwl_0__t3_p_n23 n8__t1_p_n23 rbl_1__t1_p_n23 gnd__t1_p_n23 sky130_fd_pr__nfet_01v8 L=0.15 W=0.42 nf=1 ad=0.1197 as=0.1197 pd=1.41 ps=1.41 mult=1 m=1
xm3_p_n23 rwl_0__t1_p_n23 n9__t1_p_n23 rbl_2__t1_p_n23 gnd__t2_p_n23 sky130_fd_pr__nfet_01v8 L=0.15 W=0.42 nf=1 ad=0.1197 as=0.1197 pd=1.41 ps=1.41 mult=1 m=1
xm4_p_n23 rwl_0__t0_p_n23 n10__t1_p_n23 rbl_3__t1_p_n23 gnd__t3_p_n23 sky130_fd_pr__nfet_01v8 L=0.15 W=0.42 nf=1 ad=0.1197 as=0.1197 pd=1.41 ps=1.41 mult=1 m=1
xm5_p_n23 bl_0__t0_p_n23 wl_0__t0_p_n23 n7__t1_p_n23 gnd__t8_p_n23 sky130_fd_pr__nfet_01v8 L=0.15 W=0.42 nf=1 ad=0.0588 as=0.1197 pd=0.7 ps=1.41 mult=1 m=1
xm6_p_n23 n17__t0_p_n23 wl_1__t0_p_n23 bl_0__t1_p_n23 gnd__t20_p_n23 sky130_fd_pr__nfet_01v8 L=0.15 W=0.42 nf=1 ad=0.1197 as=0.0588 pd=1.41 ps=0.7 mult=1 m=1
xm7_p_n23 bl_1__t2_p_n23 wl_0__t3_p_n23 n8__t0_p_n23 gnd__t9_p_n23 sky130_fd_pr__nfet_01v8 L=0.15 W=0.42 nf=1 ad=0.0588 as=0.1197 pd=0.7 ps=1.41 mult=1 m=1
xm8_p_n23 n18__t0_p_n23 wl_1__t1_p_n23 bl_1__t0_p_n23 gnd__t21_p_n23 sky130_fd_pr__nfet_01v8 L=0.15 W=0.42 nf=1 ad=0.1197 as=0.0588 pd=1.41 ps=0.7 mult=1 m=1
xm9_p_n23 bl_2__t2_p_n23 wl_0__t2_p_n23 n9__t0_p_n23 gnd__t10_p_n23 sky130_fd_pr__nfet_01v8 L=0.15 W=0.42 nf=1 ad=0.0588 as=0.1197 pd=0.7 ps=1.41 mult=1 m=1
xm10_p_n23 n19__t0_p_n23 wl_1__t2_p_n23 bl_2__t0_p_n23 gnd__t22_p_n23 sky130_fd_pr__nfet_01v8 L=0.15 W=0.42 nf=1 ad=0.1197 as=0.0588 pd=1.41 ps=0.7 mult=1 m=1
xm11_p_n23 bl_3__t2_p_n23 wl_0__t1_p_n23 n10__t0_p_n23 gnd__t11_p_n23 sky130_fd_pr__nfet_01v8 L=0.15 W=0.42 nf=1 ad=0.0588 as=0.1197 pd=0.7 ps=1.41 mult=1 m=1
xm12_p_n23 n20__t0_p_n23 wl_1__t3_p_n23 bl_3__t1_p_n23 gnd__t23_p_n23 sky130_fd_pr__nfet_01v8 L=0.15 W=0.42 nf=1 ad=0.1197 as=0.0588 pd=1.41 ps=0.7 mult=1 m=1
xm13_p_n23 rbl_0__t3_p_n23 n17__t1_p_n23 rwl_1__t0_p_n23 gnd__t12_p_n23 sky130_fd_pr__nfet_01v8 L=0.15 W=0.42 nf=1 ad=0.0588 as=0.1197 pd=0.7 ps=1.41 mult=1 m=1
xm14_p_n23 rwl_2__t3_p_n23 n22__t0_p_n23 rbl_0__t2_p_n23 gnd__t24_p_n23 sky130_fd_pr__nfet_01v8 L=0.15 W=0.42 nf=1 ad=0.1197 as=0.0588 pd=1.41 ps=0.7 mult=1 m=1
xm15_p_n23 rbl_1__t3_p_n23 n18__t1_p_n23 rwl_1__t1_p_n23 gnd__t13_p_n23 sky130_fd_pr__nfet_01v8 L=0.15 W=0.42 nf=1 ad=0.0588 as=0.1197 pd=0.7 ps=1.41 mult=1 m=1
xm16_p_n23 rwl_2__t0_p_n23 n23__t0_p_n23 rbl_1__t2_p_n23 gnd__t25_p_n23 sky130_fd_pr__nfet_01v8 L=0.15 W=0.42 nf=1 ad=0.1197 as=0.0588 pd=1.41 ps=0.7 mult=1 m=1
xm17_p_n23 rbl_2__t3_p_n23 n19__t1_p_n23 rwl_1__t2_p_n23 gnd__t14_p_n23 sky130_fd_pr__nfet_01v8 L=0.15 W=0.42 nf=1 ad=0.0588 as=0.1197 pd=0.7 ps=1.41 mult=1 m=1
xm18_p_n23 rwl_2__t1_p_n23 n24__t0_p_n23 rbl_2__t2_p_n23 gnd__t26_p_n23 sky130_fd_pr__nfet_01v8 L=0.15 W=0.42 nf=1 ad=0.1197 as=0.0588 pd=1.41 ps=0.7 mult=1 m=1
xm19_p_n23 rbl_3__t3_p_n23 n20__t1_p_n23 rwl_1__t3_p_n23 gnd__t15_p_n23 sky130_fd_pr__nfet_01v8 L=0.15 W=0.42 nf=1 ad=0.0588 as=0.1197 pd=0.7 ps=1.41 mult=1 m=1
xm20_p_n23 rwl_2__t2_p_n23 n25__t0_p_n23 rbl_3__t2_p_n23 gnd__t27_p_n23 sky130_fd_pr__nfet_01v8 L=0.15 W=0.42 nf=1 ad=0.1197 as=0.0588 pd=1.41 ps=0.7 mult=1 m=1
xm21_p_n23 bl_0__t3_p_n23 wl_2__t0_p_n23 n22__t1_p_n23 gnd__t16_p_n23 sky130_fd_pr__nfet_01v8 L=0.15 W=0.42 nf=1 ad=0.0588 as=0.1197 pd=0.7 ps=1.41 mult=1 m=1
xm22_p_n23 n29__t0_p_n23 wl_3__t3_p_n23 bl_0__t2_p_n23 gnd__t28_p_n23 sky130_fd_pr__nfet_01v8 L=0.15 W=0.42 nf=1 ad=0.1197 as=0.0588 pd=1.41 ps=0.7 mult=1 m=1
xm23_p_n23 bl_1__t3_p_n23 wl_2__t1_p_n23 n23__t1_p_n23 gnd__t17_p_n23 sky130_fd_pr__nfet_01v8 L=0.15 W=0.42 nf=1 ad=0.0588 as=0.1197 pd=0.7 ps=1.41 mult=1 m=1
xm24_p_n23 n30__t0_p_n23 wl_3__t2_p_n23 bl_1__t1_p_n23 gnd__t29_p_n23 sky130_fd_pr__nfet_01v8 L=0.15 W=0.42 nf=1 ad=0.1197 as=0.0588 pd=1.41 ps=0.7 mult=1 m=1
xm25_p_n23 bl_2__t3_p_n23 wl_2__t2_p_n23 n24__t1_p_n23 gnd__t18_p_n23 sky130_fd_pr__nfet_01v8 L=0.15 W=0.42 nf=1 ad=0.0588 as=0.1197 pd=0.7 ps=1.41 mult=1 m=1
xm26_p_n23 n31__t0_p_n23 wl_3__t1_p_n23 bl_2__t1_p_n23 gnd__t30_p_n23 sky130_fd_pr__nfet_01v8 L=0.15 W=0.42 nf=1 ad=0.1197 as=0.0588 pd=1.41 ps=0.7 mult=1 m=1
xm27_p_n23 bl_3__t3_p_n23 wl_2__t3_p_n23 n25__t1_p_n23 gnd__t19_p_n23 sky130_fd_pr__nfet_01v8 L=0.15 W=0.42 nf=1 ad=0.0588 as=0.1197 pd=0.7 ps=1.41 mult=1 m=1
xm28_p_n23 n32__t0_p_n23 wl_3__t0_p_n23 bl_3__t0_p_n23 gnd__t31_p_n23 sky130_fd_pr__nfet_01v8 L=0.15 W=0.42 nf=1 ad=0.1197 as=0.0588 pd=1.41 ps=0.7 mult=1 m=1
xm29_p_n23 rbl_0__t1_p_n23 n29__t1_p_n23 rwl_3__t0_p_n23 gnd__t4_p_n23 sky130_fd_pr__nfet_01v8 L=0.15 W=0.42 nf=1 ad=0.1197 as=0.1197 pd=1.41 ps=1.41 mult=1 m=1
xm30_p_n23 rbl_1__t0_p_n23 n30__t1_p_n23 rwl_3__t1_p_n23 gnd__t5_p_n23 sky130_fd_pr__nfet_01v8 L=0.15 W=0.42 nf=1 ad=0.1197 as=0.1197 pd=1.41 ps=1.41 mult=1 m=1
xm31_p_n23 rbl_2__t0_p_n23 n31__t1_p_n23 rwl_3__t2_p_n23 gnd__t6_p_n23 sky130_fd_pr__nfet_01v8 L=0.15 W=0.42 nf=1 ad=0.1197 as=0.1197 pd=1.41 ps=1.41 mult=1 m=1
xm32_p_n23 rbl_3__t0_p_n23 n32__t1_p_n23 rwl_3__t3_p_n23 gnd__t7_p_n23 sky130_fd_pr__nfet_01v8 L=0.15 W=0.42 nf=1 ad=0.1197 as=0.1197 pd=1.41 ps=1.41 mult=1 m=1
r_10_t0_p_n23 n10__t0_p_n23 n10_p_n23 183.071
r_10_t1_p_n23 n10__t1_p_n23 n10_p_n23 183.071
r_17_t0_p_n23 n17__t0_p_n23 n17_p_n23 183.071
r_17_t1_p_n23 n17__t1_p_n23 n17_p_n23 183.071
r_18_t0_p_n23 n18__t0_p_n23 n18_p_n23 183.071
r_18_t1_p_n23 n18__t1_p_n23 n18_p_n23 183.071
r_19_t0_p_n23 n19__t0_p_n23 n19_p_n23 183.071
r_19_t1_p_n23 n19__t1_p_n23 n19_p_n23 183.071
r_20_t0_p_n23 n20__t0_p_n23 n20_p_n23 183.071
r_20_t1_p_n23 n20__t1_p_n23 n20_p_n23 183.071
r_22_t0_p_n23 n22__t0_p_n23 n22_p_n23 183.071
r_22_t1_p_n23 n22__t1_p_n23 n22_p_n23 183.071
r_23_t0_p_n23 n23__t0_p_n23 n23_p_n23 183.071
r_23_t1_p_n23 n23__t1_p_n23 n23_p_n23 183.071
r_24_t0_p_n23 n24__t0_p_n23 n24_p_n23 183.071
r_24_t1_p_n23 n24__t1_p_n23 n24_p_n23 183.071
r_25_t0_p_n23 n25__t0_p_n23 n25_p_n23 183.071
r_25_t1_p_n23 n25__t1_p_n23 n25_p_n23 183.071
r_29_t0_p_n23 n29__t0_p_n23 n29_p_n23 183.071
r_29_t1_p_n23 n29__t1_p_n23 n29_p_n23 183.071
r_30_t0_p_n23 n30__t0_p_n23 n30_p_n23 183.071
r_30_t1_p_n23 n30__t1_p_n23 n30_p_n23 183.071
r_31_t0_p_n23 n31__t0_p_n23 n31_p_n23 183.071
r_31_t1_p_n23 n31__t1_p_n23 n31_p_n23 183.071
r_32_t0_p_n23 n32__t0_p_n23 n32_p_n23 183.071
r_32_t1_p_n23 n32__t1_p_n23 n32_p_n23 183.071
r_7_t0_p_n23 n7__t0_p_n23 n7_p_n23 183.071
r_7_t1_p_n23 n7__t1_p_n23 n7_p_n23 183.071
r_8_t0_p_n23 n8__t0_p_n23 n8_p_n23 183.071
r_8_t1_p_n23 n8__t1_p_n23 n8_p_n23 183.071
r_9_t0_p_n23 n9__t0_p_n23 n9_p_n23 183.071
r_9_t1_p_n23 n9__t1_p_n23 n9_p_n23 183.071
rgnd_t0_p_n23 gnd__t0_p_n23 0 38.2988
rgnd_t1_p_n23 gnd__t1_p_n23 0 33.9576
rgnd_t2_p_n23 gnd__t2_p_n23 0 33.9576
rgnd_t3_p_n23 gnd__t3_p_n23 0 38.2988
rgnd_t4_p_n23 gnd__t4_p_n23 0 38.2988
rgnd_t5_p_n23 gnd__t5_p_n23 0 33.9576
rgnd_t6_p_n23 gnd__t6_p_n23 0 33.9576
rgnd_t7_p_n23 gnd__t7_p_n23 0 38.2988
rgnd_t8_p_n23 gnd__t8_p_n23 0 28.0185
rgnd_t9_p_n23 gnd__t9_p_n23 0 21.7106
rgnd_t10_p_n23 gnd__t10_p_n23 0 21.7106
rgnd_t11_p_n23 gnd__t11_p_n23 0 28.0185
rgnd_t12_p_n23 gnd__t12_p_n23 0 18.9833
rgnd_t13_p_n23 gnd__t13_p_n23 0 6.8325
rgnd_t14_p_n23 gnd__t14_p_n23 0 6.8325
rgnd_t15_p_n23 gnd__t15_p_n23 0 18.9833
rgnd_t16_p_n23 gnd__t16_p_n23 0 24.2409
rgnd_t17_p_n23 gnd__t17_p_n23 0 16.5511
rgnd_t18_p_n23 gnd__t18_p_n23 0 16.5511
rgnd_t19_p_n23 gnd__t19_p_n23 0 24.2409
rgnd_t20_p_n23 gnd__t20_p_n23 0 24.2409
rgnd_t21_p_n23 gnd__t21_p_n23 0 16.5511
rgnd_t22_p_n23 gnd__t22_p_n23 0 16.5511
rgnd_t23_p_n23 gnd__t23_p_n23 0 24.2409
rgnd_t24_p_n23 gnd__t24_p_n23 0 18.9833
rgnd_t25_p_n23 gnd__t25_p_n23 0 6.8325
rgnd_t26_p_n23 gnd__t26_p_n23 0 6.8325
rgnd_t27_p_n23 gnd__t27_p_n23 0 18.9833
rgnd_t28_p_n23 gnd__t28_p_n23 0 28.0185
rgnd_t29_p_n23 gnd__t29_p_n23 0 21.7106
rgnd_t30_p_n23 gnd__t30_p_n23 0 21.7106
rgnd_t31_p_n23 gnd__t31_p_n23 0 28.0185
rbl_0_t0_p_n23 bl_0__t0_p_n23 bl_0_p_n23 14.8304
rbl_0_t1_p_n23 bl_0__t1_p_n23 bl_0_p_n23 10.9301
rbl_0_t2_p_n23 bl_0__t2_p_n23 bl_0_p_n23 14.8304
rbl_0_t3_p_n23 bl_0__t3_p_n23 bl_0_p_n23 10.9301
rbl_1_t0_p_n23 bl_1__t0_p_n23 bl_1_p_n23 10.9301
rbl_1_t1_p_n23 bl_1__t1_p_n23 bl_1_p_n23 14.8304
rbl_1_t2_p_n23 bl_1__t2_p_n23 bl_1_p_n23 14.8304
rbl_1_t3_p_n23 bl_1__t3_p_n23 bl_1_p_n23 10.9301
rbl_2_t0_p_n23 bl_2__t0_p_n23 bl_2_p_n23 10.9301
rbl_2_t1_p_n23 bl_2__t1_p_n23 bl_2_p_n23 14.8304
rbl_2_t2_p_n23 bl_2__t2_p_n23 bl_2_p_n23 14.8304
rbl_2_t3_p_n23 bl_2__t3_p_n23 bl_2_p_n23 10.9301
rbl_3_t0_p_n23 bl_3__t0_p_n23 bl_3_p_n23 14.8304
rbl_3_t1_p_n23 bl_3__t1_p_n23 bl_3_p_n23 10.9301
rbl_3_t2_p_n23 bl_3__t2_p_n23 bl_3_p_n23 14.8304
rbl_3_t3_p_n23 bl_3__t3_p_n23 bl_3_p_n23 10.9301
rrbl_0_t0_p_n23 rbl_0__t0_p_n23 rbl_0_p_n23 36.5601
rrbl_0_t1_p_n23 rbl_0__t1_p_n23 rbl_0_p_n23 36.5601
rrbl_0_t2_p_n23 rbl_0__t2_p_n23 rbl_0_p_n23 2.99444
rrbl_0_t3_p_n23 rbl_0__t3_p_n23 rbl_0_p_n23 2.99444
rrbl_1_t0_p_n23 rbl_1__t0_p_n23 rbl_1_p_n23 36.5601
rrbl_1_t1_p_n23 rbl_1__t1_p_n23 rbl_1_p_n23 36.5601
rrbl_1_t2_p_n23 rbl_1__t2_p_n23 rbl_1_p_n23 2.99444
rrbl_1_t3_p_n23 rbl_1__t3_p_n23 rbl_1_p_n23 2.99444
rrbl_2_t0_p_n23 rbl_2__t0_p_n23 rbl_2_p_n23 36.5601
rrbl_2_t1_p_n23 rbl_2__t1_p_n23 rbl_2_p_n23 36.5601
rrbl_2_t2_p_n23 rbl_2__t2_p_n23 rbl_2_p_n23 2.99444
rrbl_2_t3_p_n23 rbl_2__t3_p_n23 rbl_2_p_n23 2.99444
rrbl_3_t0_p_n23 rbl_3__t0_p_n23 rbl_3_p_n23 36.5601
rrbl_3_t1_p_n23 rbl_3__t1_p_n23 rbl_3_p_n23 36.5601
rrbl_3_t2_p_n23 rbl_3__t2_p_n23 rbl_3_p_n23 2.99444
rrbl_3_t3_p_n23 rbl_3__t3_p_n23 rbl_3_p_n23 2.99444
rrwl_0_t0_p_n23 rwl_0__t0_p_n23 rwl_0_p_n23 38.2618
rrwl_0_t1_p_n23 rwl_0__t1_p_n23 rwl_0_p_n23 12.7539
rrwl_0_t2_p_n23 rwl_0__t2_p_n23 rwl_0_p_n23 38.2618
rrwl_0_t3_p_n23 rwl_0__t3_p_n23 rwl_0_p_n23 12.7539
rrwl_1_t0_p_n23 rwl_1__t0_p_n23 rwl_1_p_n23 38.2618
rrwl_1_t1_p_n23 rwl_1__t1_p_n23 rwl_1_p_n23 12.7539
rrwl_1_t2_p_n23 rwl_1__t2_p_n23 rwl_1_p_n23 12.7539
rrwl_1_t3_p_n23 rwl_1__t3_p_n23 rwl_1_p_n23 38.2618
rrwl_2_t0_p_n23 rwl_2__t0_p_n23 rwl_2_p_n23 12.7539
rrwl_2_t1_p_n23 rwl_2__t1_p_n23 rwl_2_p_n23 12.7539
rrwl_2_t2_p_n23 rwl_2__t2_p_n23 rwl_2_p_n23 38.2618
rrwl_2_t3_p_n23 rwl_2__t3_p_n23 rwl_2_p_n23 38.2618
rrwl_3_t0_p_n23 rwl_3__t0_p_n23 rwl_3_p_n23 38.2618
rrwl_3_t1_p_n23 rwl_3__t1_p_n23 rwl_3_p_n23 12.7539
rrwl_3_t2_p_n23 rwl_3__t2_p_n23 rwl_3_p_n23 12.7539
rrwl_3_t3_p_n23 rwl_3__t3_p_n23 rwl_3_p_n23 38.2618
rwl_0_t0_p_n23 wl_0__t0_p_n23 wl_0_p_n23 245.959
rwl_0_t1_p_n23 wl_0__t1_p_n23 wl_0_p_n23 245.959
rwl_0_t2_p_n23 wl_0__t2_p_n23 wl_0_p_n23 81.9864
rwl_0_t3_p_n23 wl_0__t3_p_n23 wl_0_p_n23 81.9864
rwl_1_t0_p_n23 wl_1__t0_p_n23 wl_1_p_n23 245.959
rwl_1_t1_p_n23 wl_1__t1_p_n23 wl_1_p_n23 81.9864
rwl_1_t2_p_n23 wl_1__t2_p_n23 wl_1_p_n23 81.9864
rwl_1_t3_p_n23 wl_1__t3_p_n23 wl_1_p_n23 245.959
rwl_2_t0_p_n23 wl_2__t0_p_n23 wl_2_p_n23 245.959
rwl_2_t1_p_n23 wl_2__t1_p_n23 wl_2_p_n23 81.9864
rwl_2_t2_p_n23 wl_2__t2_p_n23 wl_2_p_n23 81.9864
rwl_2_t3_p_n23 wl_2__t3_p_n23 wl_2_p_n23 245.959
rwl_3_t0_p_n23 wl_3__t0_p_n23 wl_3_p_n23 245.959
rwl_3_t1_p_n23 wl_3__t1_p_n23 wl_3_p_n23 81.9864
rwl_3_t2_p_n23 wl_3__t2_p_n23 wl_3_p_n23 81.9864
rwl_3_t3_p_n23 wl_3__t3_p_n23 wl_3_p_n23 245.959
c_10_p_n23 n10_p_n23 0 2.91622e-16
c_17_p_n23 n17_p_n23 0 2.91528e-16
c_18_p_n23 n18_p_n23 0 2.91528e-16
c_19_p_n23 n19_p_n23 0 2.91528e-16
c_20_p_n23 n20_p_n23 0 2.91622e-16
c_22_p_n23 n22_p_n23 0 2.91528e-16
c_23_p_n23 n23_p_n23 0 1.1371e-16
c_24_p_n23 n24_p_n23 0 2.91528e-16
c_25_p_n23 n25_p_n23 0 2.91622e-16
c_29_p_n23 n29_p_n23 0 2.91528e-16
c_30_p_n23 n30_p_n23 0 2.91528e-16
c_31_p_n23 n31_p_n23 0 2.91528e-16
c_32_p_n23 n32_p_n23 0 2.91622e-16
c_7_p_n23 n7_p_n23 0 2.91528e-16
c_8_p_n23 n8_p_n23 0 2.91528e-16
c_9_p_n23 n9_p_n23 0 2.91528e-16
cgnd_p_n23 0 0 2.48166e-15
cbl_0_p_n23 bl_0_p_n23 0 4.52661e-16
cbl_1_p_n23 bl_1_p_n23 0 4.52661e-16
cbl_2_p_n23 bl_2_p_n23 0 4.52661e-16
cbl_3_p_n23 bl_3_p_n23 0 4.52661e-16
crbl_0_p_n23 rbl_0_p_n23 0 9.14472e-16
crbl_1_p_n23 rbl_1_p_n23 0 9.14472e-16
crbl_2_p_n23 rbl_2_p_n23 0 9.14472e-16
crbl_3_p_n23 rbl_3_p_n23 0 9.17566e-16
crwl_0_p_n23 rwl_0_p_n23 0 5.19495e-16
crwl_1_p_n23 rwl_1_p_n23 0 5.11719e-16
crwl_2_p_n23 rwl_2_p_n23 0 5.11719e-16
crwl_3_p_n23 rwl_3_p_n23 0 5.19495e-16
cwl_0_p_n23 wl_0_p_n23 0 3.30388e-16
cwl_1_p_n23 wl_1_p_n23 0 3.30388e-16
cwl_2_p_n23 wl_2_p_n23 0 3.30388e-16
cwl_3_p_n23 wl_3_p_n23 0 3.30388e-16
ccc__10__9_p_n23 n10_p_n23 n9_p_n23 1.02e-17
ccc__10_bl_3_p_n23 n10_p_n23 bl_3_p_n23 1.3999e-17
ccc__10_rwl_0_p_n23 n10_p_n23 rwl_0_p_n23 4.335e-18
ccc__17__18_p_n23 n17_p_n23 n18_p_n23 1.02e-17
ccc__17_bl_0_p_n23 n17_p_n23 bl_0_p_n23 8.415e-18
ccc__17_rwl_1_p_n23 n17_p_n23 rwl_1_p_n23 1.3194e-17
ccc__18__19_p_n23 n18_p_n23 n19_p_n23 1.02e-17
ccc__18_bl_1_p_n23 n18_p_n23 bl_1_p_n23 8.415e-18
ccc__18_rwl_1_p_n23 n18_p_n23 rwl_1_p_n23 1.3194e-17
ccc__19__20_p_n23 n19_p_n23 n20_p_n23 1.02e-17
ccc__19_bl_2_p_n23 n19_p_n23 bl_2_p_n23 8.415e-18
ccc__19_rwl_1_p_n23 n19_p_n23 rwl_1_p_n23 1.3194e-17
ccc__20_bl_3_p_n23 n20_p_n23 bl_3_p_n23 8.415e-18
ccc__20_rwl_1_p_n23 n20_p_n23 rwl_1_p_n23 6.655e-18
ccc__22__23_p_n23 n22_p_n23 n23_p_n23 1.02e-17
ccc__22_bl_0_p_n23 n22_p_n23 bl_0_p_n23 8.415e-18
ccc__22_rwl_2_p_n23 n22_p_n23 rwl_2_p_n23 1.3194e-17
ccc__23__24_p_n23 n23_p_n23 n24_p_n23 1.02e-17
ccc__23_bl_1_p_n23 n23_p_n23 bl_1_p_n23 8.415e-18
ccc__23_rwl_2_p_n23 n23_p_n23 rwl_2_p_n23 1.3194e-17
ccc__24__25_p_n23 n24_p_n23 n25_p_n23 1.02e-17
ccc__24_bl_2_p_n23 n24_p_n23 bl_2_p_n23 8.415e-18
ccc__24_rwl_2_p_n23 n24_p_n23 rwl_2_p_n23 1.3194e-17
ccc__25_bl_3_p_n23 n25_p_n23 bl_3_p_n23 8.415e-18
ccc__25_rwl_2_p_n23 n25_p_n23 rwl_2_p_n23 6.655e-18
ccc__29__30_p_n23 n29_p_n23 n30_p_n23 1.02e-17
ccc__29_bl_0_p_n23 n29_p_n23 bl_0_p_n23 8.415e-18
ccc__29_rwl_3_p_n23 n29_p_n23 rwl_3_p_n23 1.3194e-17
ccc__30__31_p_n23 n30_p_n23 n31_p_n23 1.02e-17
ccc__30_bl_1_p_n23 n30_p_n23 bl_1_p_n23 8.415e-18
ccc__30_rwl_3_p_n23 n30_p_n23 rwl_3_p_n23 1.3194e-17
ccc__31__32_p_n23 n31_p_n23 n32_p_n23 1.02e-17
ccc__31_bl_2_p_n23 n31_p_n23 bl_2_p_n23 8.415e-18
ccc__31_rwl_3_p_n23 n31_p_n23 rwl_3_p_n23 1.3194e-17
ccc__32_bl_3_p_n23 n32_p_n23 bl_3_p_n23 8.415e-18
ccc__32_rwl_3_p_n23 n32_p_n23 rwl_3_p_n23 6.655e-18
ccc__7__8_p_n23 n7_p_n23 n8_p_n23 1.02e-17
ccc__7_bl_0_p_n23 n7_p_n23 bl_0_p_n23 1.3999e-17
ccc__7_rwl_0_p_n23 n7_p_n23 rwl_0_p_n23 8.961e-18
ccc__8__9_p_n23 n8_p_n23 n9_p_n23 1.02e-17
ccc__8_bl_1_p_n23 n8_p_n23 bl_1_p_n23 1.3999e-17
ccc__8_rwl_0_p_n23 n8_p_n23 rwl_0_p_n23 8.961e-18
ccc__9_bl_2_p_n23 n9_p_n23 bl_2_p_n23 1.3999e-17
ccc__9_rwl_0_p_n23 n9_p_n23 rwl_0_p_n23 8.961e-18
ccc_bl_0_rbl_0_p_n23 bl_0_p_n23 rbl_0_p_n23 1.88693e-16
ccc_bl_0_rwl_1_p_n23 bl_0_p_n23 rwl_1_p_n23 1.0093e-17
ccc_bl_0_rwl_2_p_n23 bl_0_p_n23 rwl_2_p_n23 1.0093e-17
ccc_bl_1_rbl_0_p_n23 bl_1_p_n23 rbl_0_p_n23 1.633e-16
ccc_bl_1_rbl_1_p_n23 bl_1_p_n23 rbl_1_p_n23 1.88693e-16
ccc_bl_1_rwl_1_p_n23 bl_1_p_n23 rwl_1_p_n23 1.0093e-17
ccc_bl_1_rwl_2_p_n23 bl_1_p_n23 rwl_2_p_n23 1.0093e-17
ccc_bl_2_rbl_1_p_n23 bl_2_p_n23 rbl_1_p_n23 1.633e-16
ccc_bl_2_rbl_2_p_n23 bl_2_p_n23 rbl_2_p_n23 1.88693e-16
ccc_bl_2_rwl_1_p_n23 bl_2_p_n23 rwl_1_p_n23 1.0093e-17
ccc_bl_2_rwl_2_p_n23 bl_2_p_n23 rwl_2_p_n23 1.0093e-17
ccc_bl_3_rbl_2_p_n23 bl_3_p_n23 rbl_2_p_n23 1.633e-16
ccc_bl_3_rbl_3_p_n23 bl_3_p_n23 rbl_3_p_n23 1.88693e-16
ccc_bl_3_rwl_1_p_n23 bl_3_p_n23 rwl_1_p_n23 1.0093e-17
ccc_bl_3_rwl_2_p_n23 bl_3_p_n23 rwl_2_p_n23 1.0093e-17
ccc_rbl_0_rbl_1_p_n23 rbl_0_p_n23 rbl_1_p_n23 3.432e-17
ccc_rbl_0_rwl_0_p_n23 rbl_0_p_n23 rwl_0_p_n23 4.9752e-17
ccc_rbl_0_rwl_1_p_n23 rbl_0_p_n23 rwl_1_p_n23 4.9752e-17
ccc_rbl_0_rwl_2_p_n23 rbl_0_p_n23 rwl_2_p_n23 4.9752e-17
ccc_rbl_0_rwl_3_p_n23 rbl_0_p_n23 rwl_3_p_n23 4.9752e-17
ccc_rbl_1_rbl_2_p_n23 rbl_1_p_n23 rbl_2_p_n23 3.432e-17
ccc_rbl_1_rwl_0_p_n23 rbl_1_p_n23 rwl_0_p_n23 4.9752e-17
ccc_rbl_1_rwl_1_p_n23 rbl_1_p_n23 rwl_1_p_n23 4.9752e-17
ccc_rbl_1_rwl_2_p_n23 rbl_1_p_n23 rwl_2_p_n23 4.9752e-17
ccc_rbl_1_rwl_3_p_n23 rbl_1_p_n23 rwl_3_p_n23 4.9752e-17
ccc_rbl_2_rbl_3_p_n23 rbl_2_p_n23 rbl_3_p_n23 3.432e-17
ccc_rbl_2_rwl_0_p_n23 rbl_2_p_n23 rwl_0_p_n23 4.9752e-17
ccc_rbl_2_rwl_1_p_n23 rbl_2_p_n23 rwl_1_p_n23 4.9752e-17
ccc_rbl_2_rwl_2_p_n23 rbl_2_p_n23 rwl_2_p_n23 4.9752e-17
ccc_rbl_2_rwl_3_p_n23 rbl_2_p_n23 rwl_3_p_n23 4.9752e-17
ccc_rbl_3_rwl_0_p_n23 rbl_3_p_n23 rwl_0_p_n23 3.3407e-17
ccc_rbl_3_rwl_1_p_n23 rbl_3_p_n23 rwl_1_p_n23 3.3407e-17
ccc_rbl_3_rwl_2_p_n23 rbl_3_p_n23 rwl_2_p_n23 3.3407e-17
ccc_rbl_3_rwl_3_p_n23 rbl_3_p_n23 rwl_3_p_n23 3.3407e-17
vdw_p_n23_0 wl_0_p_n23 0 dc 0
vdr_p_n23_0 rwl_0_p_n23 vdd dc 0
vdw_p_n23_1 wl_1_p_n23 0 dc 0
vdr_p_n23_1 rwl_1_p_n23 vdd dc 0
vdw_p_n23_2 wl_2_p_n23 0 dc 0
vdr_p_n23_2 rwl_2_p_n23 vdd dc 0
vdw_p_n23_3 wl_3_p_n23 0 dc 0
vdr_p_n23_3 rwl_3_p_n23 vdd dc 0
vdb_p_n23_0 bl_0_p_n23 0 dc 0
vdp_p_n23_0 rbl_0_p_n23 vrbl dc 0
vdb_p_n23_1 bl_1_p_n23 0 dc 0
vdp_p_n23_1 rbl_1_p_n23 vrbl dc 0
vdb_p_n23_2 bl_2_p_n23 0 dc 0
vdp_p_n23_2 rbl_2_p_n23 vrbl dc 0
vdb_p_n23_3 bl_3_p_n23 0 dc 0
vdp_p_n23_3 rbl_3_p_n23 vrbl dc 0
vdn_p_n23_n7 n7_p_n23 0 dc 1
vdn_p_n23_n8 n8_p_n23 0 dc 1
vdn_p_n23_n9 n9_p_n23 0 dc 1
vdn_p_n23_n10 n10_p_n23 0 dc 1
vdn_p_n23_n17 n17_p_n23 0 dc 1
vdn_p_n23_n18 n18_p_n23 0 dc 1
vdn_p_n23_n19 n19_p_n23 0 dc 1
vdn_p_n23_n20 n20_p_n23 0 dc 1
vdn_p_n23_n22 n22_p_n23 0 dc 1
vdn_p_n23_n24 n24_p_n23 0 dc 1
vdn_p_n23_n25 n25_p_n23 0 dc 1
vdn_p_n23_n29 n29_p_n23 0 dc 1
vdn_p_n23_n30 n30_p_n23 0 dc 1
vdn_p_n23_n31 n31_p_n23 0 dc 1
vdn_p_n23_n32 n32_p_n23 0 dc 1
bdr_p_n23 n23_p_n23 0 i=5e-08*min(1,max(0,(time-1e-09)/0.2n))*0.5*(1+tanh((v(n23_p_n23)-0.05)/0.01))

* ---- instance p_n24: variant p, probed storage node \$24 ----
xm1_p_n24 rwl_0__t2_p_n24 n7__t0_p_n24 rbl_0__t0_p_n24 gnd__t0_p_n24 sky130_fd_pr__nfet_01v8 L=0.15 W=0.42 nf=1 ad=0.1197 as=0.1197 pd=1.41 ps=1.41 mult=1 m=1
xm2_p_n24 rwl_0__t3_p_n24 n8__t1_p_n24 rbl_1__t1_p_n24 gnd__t1_p_n24 sky130_fd_pr__nfet_01v8 L=0.15 W=0.42 nf=1 ad=0.1197 as=0.1197 pd=1.41 ps=1.41 mult=1 m=1
xm3_p_n24 rwl_0__t1_p_n24 n9__t1_p_n24 rbl_2__t1_p_n24 gnd__t2_p_n24 sky130_fd_pr__nfet_01v8 L=0.15 W=0.42 nf=1 ad=0.1197 as=0.1197 pd=1.41 ps=1.41 mult=1 m=1
xm4_p_n24 rwl_0__t0_p_n24 n10__t1_p_n24 rbl_3__t1_p_n24 gnd__t3_p_n24 sky130_fd_pr__nfet_01v8 L=0.15 W=0.42 nf=1 ad=0.1197 as=0.1197 pd=1.41 ps=1.41 mult=1 m=1
xm5_p_n24 bl_0__t0_p_n24 wl_0__t0_p_n24 n7__t1_p_n24 gnd__t8_p_n24 sky130_fd_pr__nfet_01v8 L=0.15 W=0.42 nf=1 ad=0.0588 as=0.1197 pd=0.7 ps=1.41 mult=1 m=1
xm6_p_n24 n17__t0_p_n24 wl_1__t0_p_n24 bl_0__t1_p_n24 gnd__t20_p_n24 sky130_fd_pr__nfet_01v8 L=0.15 W=0.42 nf=1 ad=0.1197 as=0.0588 pd=1.41 ps=0.7 mult=1 m=1
xm7_p_n24 bl_1__t2_p_n24 wl_0__t3_p_n24 n8__t0_p_n24 gnd__t9_p_n24 sky130_fd_pr__nfet_01v8 L=0.15 W=0.42 nf=1 ad=0.0588 as=0.1197 pd=0.7 ps=1.41 mult=1 m=1
xm8_p_n24 n18__t0_p_n24 wl_1__t1_p_n24 bl_1__t0_p_n24 gnd__t21_p_n24 sky130_fd_pr__nfet_01v8 L=0.15 W=0.42 nf=1 ad=0.1197 as=0.0588 pd=1.41 ps=0.7 mult=1 m=1
xm9_p_n24 bl_2__t2_p_n24 wl_0__t2_p_n24 n9__t0_p_n24 gnd__t10_p_n24 sky130_fd_pr__nfet_01v8 L=0.15 W=0.42 nf=1 ad=0.0588 as=0.1197 pd=0.7 ps=1.41 mult=1 m=1
xm10_p_n24 n19__t0_p_n24 wl_1__t2_p_n24 bl_2__t0_p_n24 gnd__t22_p_n24 sky130_fd_pr__nfet_01v8 L=0.15 W=0.42 nf=1 ad=0.1197 as=0.0588 pd=1.41 ps=0.7 mult=1 m=1
xm11_p_n24 bl_3__t2_p_n24 wl_0__t1_p_n24 n10__t0_p_n24 gnd__t11_p_n24 sky130_fd_pr__nfet_01v8 L=0.15 W=0.42 nf=1 ad=0.0588 as=0.1197 pd=0.7 ps=1.41 mult=1 m=1
xm12_p_n24 n20__t0_p_n24 wl_1__t3_p_n24 bl_3__t1_p_n24 gnd__t23_p_n24 sky130_fd_pr__nfet_01v8 L=0.15 W=0.42 nf=1 ad=0.1197 as=0.0588 pd=1.41 ps=0.7 mult=1 m=1
xm13_p_n24 rbl_0__t3_p_n24 n17__t1_p_n24 rwl_1__t0_p_n24 gnd__t12_p_n24 sky130_fd_pr__nfet_01v8 L=0.15 W=0.42 nf=1 ad=0.0588 as=0.1197 pd=0.7 ps=1.41 mult=1 m=1
xm14_p_n24 rwl_2__t3_p_n24 n22__t0_p_n24 rbl_0__t2_p_n24 gnd__t24_p_n24 sky130_fd_pr__nfet_01v8 L=0.15 W=0.42 nf=1 ad=0.1197 as=0.0588 pd=1.41 ps=0.7 mult=1 m=1
xm15_p_n24 rbl_1__t3_p_n24 n18__t1_p_n24 rwl_1__t1_p_n24 gnd__t13_p_n24 sky130_fd_pr__nfet_01v8 L=0.15 W=0.42 nf=1 ad=0.0588 as=0.1197 pd=0.7 ps=1.41 mult=1 m=1
xm16_p_n24 rwl_2__t0_p_n24 n23__t0_p_n24 rbl_1__t2_p_n24 gnd__t25_p_n24 sky130_fd_pr__nfet_01v8 L=0.15 W=0.42 nf=1 ad=0.1197 as=0.0588 pd=1.41 ps=0.7 mult=1 m=1
xm17_p_n24 rbl_2__t3_p_n24 n19__t1_p_n24 rwl_1__t2_p_n24 gnd__t14_p_n24 sky130_fd_pr__nfet_01v8 L=0.15 W=0.42 nf=1 ad=0.0588 as=0.1197 pd=0.7 ps=1.41 mult=1 m=1
xm18_p_n24 rwl_2__t1_p_n24 n24__t0_p_n24 rbl_2__t2_p_n24 gnd__t26_p_n24 sky130_fd_pr__nfet_01v8 L=0.15 W=0.42 nf=1 ad=0.1197 as=0.0588 pd=1.41 ps=0.7 mult=1 m=1
xm19_p_n24 rbl_3__t3_p_n24 n20__t1_p_n24 rwl_1__t3_p_n24 gnd__t15_p_n24 sky130_fd_pr__nfet_01v8 L=0.15 W=0.42 nf=1 ad=0.0588 as=0.1197 pd=0.7 ps=1.41 mult=1 m=1
xm20_p_n24 rwl_2__t2_p_n24 n25__t0_p_n24 rbl_3__t2_p_n24 gnd__t27_p_n24 sky130_fd_pr__nfet_01v8 L=0.15 W=0.42 nf=1 ad=0.1197 as=0.0588 pd=1.41 ps=0.7 mult=1 m=1
xm21_p_n24 bl_0__t3_p_n24 wl_2__t0_p_n24 n22__t1_p_n24 gnd__t16_p_n24 sky130_fd_pr__nfet_01v8 L=0.15 W=0.42 nf=1 ad=0.0588 as=0.1197 pd=0.7 ps=1.41 mult=1 m=1
xm22_p_n24 n29__t0_p_n24 wl_3__t3_p_n24 bl_0__t2_p_n24 gnd__t28_p_n24 sky130_fd_pr__nfet_01v8 L=0.15 W=0.42 nf=1 ad=0.1197 as=0.0588 pd=1.41 ps=0.7 mult=1 m=1
xm23_p_n24 bl_1__t3_p_n24 wl_2__t1_p_n24 n23__t1_p_n24 gnd__t17_p_n24 sky130_fd_pr__nfet_01v8 L=0.15 W=0.42 nf=1 ad=0.0588 as=0.1197 pd=0.7 ps=1.41 mult=1 m=1
xm24_p_n24 n30__t0_p_n24 wl_3__t2_p_n24 bl_1__t1_p_n24 gnd__t29_p_n24 sky130_fd_pr__nfet_01v8 L=0.15 W=0.42 nf=1 ad=0.1197 as=0.0588 pd=1.41 ps=0.7 mult=1 m=1
xm25_p_n24 bl_2__t3_p_n24 wl_2__t2_p_n24 n24__t1_p_n24 gnd__t18_p_n24 sky130_fd_pr__nfet_01v8 L=0.15 W=0.42 nf=1 ad=0.0588 as=0.1197 pd=0.7 ps=1.41 mult=1 m=1
xm26_p_n24 n31__t0_p_n24 wl_3__t1_p_n24 bl_2__t1_p_n24 gnd__t30_p_n24 sky130_fd_pr__nfet_01v8 L=0.15 W=0.42 nf=1 ad=0.1197 as=0.0588 pd=1.41 ps=0.7 mult=1 m=1
xm27_p_n24 bl_3__t3_p_n24 wl_2__t3_p_n24 n25__t1_p_n24 gnd__t19_p_n24 sky130_fd_pr__nfet_01v8 L=0.15 W=0.42 nf=1 ad=0.0588 as=0.1197 pd=0.7 ps=1.41 mult=1 m=1
xm28_p_n24 n32__t0_p_n24 wl_3__t0_p_n24 bl_3__t0_p_n24 gnd__t31_p_n24 sky130_fd_pr__nfet_01v8 L=0.15 W=0.42 nf=1 ad=0.1197 as=0.0588 pd=1.41 ps=0.7 mult=1 m=1
xm29_p_n24 rbl_0__t1_p_n24 n29__t1_p_n24 rwl_3__t0_p_n24 gnd__t4_p_n24 sky130_fd_pr__nfet_01v8 L=0.15 W=0.42 nf=1 ad=0.1197 as=0.1197 pd=1.41 ps=1.41 mult=1 m=1
xm30_p_n24 rbl_1__t0_p_n24 n30__t1_p_n24 rwl_3__t1_p_n24 gnd__t5_p_n24 sky130_fd_pr__nfet_01v8 L=0.15 W=0.42 nf=1 ad=0.1197 as=0.1197 pd=1.41 ps=1.41 mult=1 m=1
xm31_p_n24 rbl_2__t0_p_n24 n31__t1_p_n24 rwl_3__t2_p_n24 gnd__t6_p_n24 sky130_fd_pr__nfet_01v8 L=0.15 W=0.42 nf=1 ad=0.1197 as=0.1197 pd=1.41 ps=1.41 mult=1 m=1
xm32_p_n24 rbl_3__t0_p_n24 n32__t1_p_n24 rwl_3__t3_p_n24 gnd__t7_p_n24 sky130_fd_pr__nfet_01v8 L=0.15 W=0.42 nf=1 ad=0.1197 as=0.1197 pd=1.41 ps=1.41 mult=1 m=1
r_10_t0_p_n24 n10__t0_p_n24 n10_p_n24 183.071
r_10_t1_p_n24 n10__t1_p_n24 n10_p_n24 183.071
r_17_t0_p_n24 n17__t0_p_n24 n17_p_n24 183.071
r_17_t1_p_n24 n17__t1_p_n24 n17_p_n24 183.071
r_18_t0_p_n24 n18__t0_p_n24 n18_p_n24 183.071
r_18_t1_p_n24 n18__t1_p_n24 n18_p_n24 183.071
r_19_t0_p_n24 n19__t0_p_n24 n19_p_n24 183.071
r_19_t1_p_n24 n19__t1_p_n24 n19_p_n24 183.071
r_20_t0_p_n24 n20__t0_p_n24 n20_p_n24 183.071
r_20_t1_p_n24 n20__t1_p_n24 n20_p_n24 183.071
r_22_t0_p_n24 n22__t0_p_n24 n22_p_n24 183.071
r_22_t1_p_n24 n22__t1_p_n24 n22_p_n24 183.071
r_23_t0_p_n24 n23__t0_p_n24 n23_p_n24 183.071
r_23_t1_p_n24 n23__t1_p_n24 n23_p_n24 183.071
r_24_t0_p_n24 n24__t0_p_n24 n24_p_n24 183.071
r_24_t1_p_n24 n24__t1_p_n24 n24_p_n24 183.071
r_25_t0_p_n24 n25__t0_p_n24 n25_p_n24 183.071
r_25_t1_p_n24 n25__t1_p_n24 n25_p_n24 183.071
r_29_t0_p_n24 n29__t0_p_n24 n29_p_n24 183.071
r_29_t1_p_n24 n29__t1_p_n24 n29_p_n24 183.071
r_30_t0_p_n24 n30__t0_p_n24 n30_p_n24 183.071
r_30_t1_p_n24 n30__t1_p_n24 n30_p_n24 183.071
r_31_t0_p_n24 n31__t0_p_n24 n31_p_n24 183.071
r_31_t1_p_n24 n31__t1_p_n24 n31_p_n24 183.071
r_32_t0_p_n24 n32__t0_p_n24 n32_p_n24 183.071
r_32_t1_p_n24 n32__t1_p_n24 n32_p_n24 183.071
r_7_t0_p_n24 n7__t0_p_n24 n7_p_n24 183.071
r_7_t1_p_n24 n7__t1_p_n24 n7_p_n24 183.071
r_8_t0_p_n24 n8__t0_p_n24 n8_p_n24 183.071
r_8_t1_p_n24 n8__t1_p_n24 n8_p_n24 183.071
r_9_t0_p_n24 n9__t0_p_n24 n9_p_n24 183.071
r_9_t1_p_n24 n9__t1_p_n24 n9_p_n24 183.071
rgnd_t0_p_n24 gnd__t0_p_n24 0 38.2988
rgnd_t1_p_n24 gnd__t1_p_n24 0 33.9576
rgnd_t2_p_n24 gnd__t2_p_n24 0 33.9576
rgnd_t3_p_n24 gnd__t3_p_n24 0 38.2988
rgnd_t4_p_n24 gnd__t4_p_n24 0 38.2988
rgnd_t5_p_n24 gnd__t5_p_n24 0 33.9576
rgnd_t6_p_n24 gnd__t6_p_n24 0 33.9576
rgnd_t7_p_n24 gnd__t7_p_n24 0 38.2988
rgnd_t8_p_n24 gnd__t8_p_n24 0 28.0185
rgnd_t9_p_n24 gnd__t9_p_n24 0 21.7106
rgnd_t10_p_n24 gnd__t10_p_n24 0 21.7106
rgnd_t11_p_n24 gnd__t11_p_n24 0 28.0185
rgnd_t12_p_n24 gnd__t12_p_n24 0 18.9833
rgnd_t13_p_n24 gnd__t13_p_n24 0 6.8325
rgnd_t14_p_n24 gnd__t14_p_n24 0 6.8325
rgnd_t15_p_n24 gnd__t15_p_n24 0 18.9833
rgnd_t16_p_n24 gnd__t16_p_n24 0 24.2409
rgnd_t17_p_n24 gnd__t17_p_n24 0 16.5511
rgnd_t18_p_n24 gnd__t18_p_n24 0 16.5511
rgnd_t19_p_n24 gnd__t19_p_n24 0 24.2409
rgnd_t20_p_n24 gnd__t20_p_n24 0 24.2409
rgnd_t21_p_n24 gnd__t21_p_n24 0 16.5511
rgnd_t22_p_n24 gnd__t22_p_n24 0 16.5511
rgnd_t23_p_n24 gnd__t23_p_n24 0 24.2409
rgnd_t24_p_n24 gnd__t24_p_n24 0 18.9833
rgnd_t25_p_n24 gnd__t25_p_n24 0 6.8325
rgnd_t26_p_n24 gnd__t26_p_n24 0 6.8325
rgnd_t27_p_n24 gnd__t27_p_n24 0 18.9833
rgnd_t28_p_n24 gnd__t28_p_n24 0 28.0185
rgnd_t29_p_n24 gnd__t29_p_n24 0 21.7106
rgnd_t30_p_n24 gnd__t30_p_n24 0 21.7106
rgnd_t31_p_n24 gnd__t31_p_n24 0 28.0185
rbl_0_t0_p_n24 bl_0__t0_p_n24 bl_0_p_n24 14.8304
rbl_0_t1_p_n24 bl_0__t1_p_n24 bl_0_p_n24 10.9301
rbl_0_t2_p_n24 bl_0__t2_p_n24 bl_0_p_n24 14.8304
rbl_0_t3_p_n24 bl_0__t3_p_n24 bl_0_p_n24 10.9301
rbl_1_t0_p_n24 bl_1__t0_p_n24 bl_1_p_n24 10.9301
rbl_1_t1_p_n24 bl_1__t1_p_n24 bl_1_p_n24 14.8304
rbl_1_t2_p_n24 bl_1__t2_p_n24 bl_1_p_n24 14.8304
rbl_1_t3_p_n24 bl_1__t3_p_n24 bl_1_p_n24 10.9301
rbl_2_t0_p_n24 bl_2__t0_p_n24 bl_2_p_n24 10.9301
rbl_2_t1_p_n24 bl_2__t1_p_n24 bl_2_p_n24 14.8304
rbl_2_t2_p_n24 bl_2__t2_p_n24 bl_2_p_n24 14.8304
rbl_2_t3_p_n24 bl_2__t3_p_n24 bl_2_p_n24 10.9301
rbl_3_t0_p_n24 bl_3__t0_p_n24 bl_3_p_n24 14.8304
rbl_3_t1_p_n24 bl_3__t1_p_n24 bl_3_p_n24 10.9301
rbl_3_t2_p_n24 bl_3__t2_p_n24 bl_3_p_n24 14.8304
rbl_3_t3_p_n24 bl_3__t3_p_n24 bl_3_p_n24 10.9301
rrbl_0_t0_p_n24 rbl_0__t0_p_n24 rbl_0_p_n24 36.5601
rrbl_0_t1_p_n24 rbl_0__t1_p_n24 rbl_0_p_n24 36.5601
rrbl_0_t2_p_n24 rbl_0__t2_p_n24 rbl_0_p_n24 2.99444
rrbl_0_t3_p_n24 rbl_0__t3_p_n24 rbl_0_p_n24 2.99444
rrbl_1_t0_p_n24 rbl_1__t0_p_n24 rbl_1_p_n24 36.5601
rrbl_1_t1_p_n24 rbl_1__t1_p_n24 rbl_1_p_n24 36.5601
rrbl_1_t2_p_n24 rbl_1__t2_p_n24 rbl_1_p_n24 2.99444
rrbl_1_t3_p_n24 rbl_1__t3_p_n24 rbl_1_p_n24 2.99444
rrbl_2_t0_p_n24 rbl_2__t0_p_n24 rbl_2_p_n24 36.5601
rrbl_2_t1_p_n24 rbl_2__t1_p_n24 rbl_2_p_n24 36.5601
rrbl_2_t2_p_n24 rbl_2__t2_p_n24 rbl_2_p_n24 2.99444
rrbl_2_t3_p_n24 rbl_2__t3_p_n24 rbl_2_p_n24 2.99444
rrbl_3_t0_p_n24 rbl_3__t0_p_n24 rbl_3_p_n24 36.5601
rrbl_3_t1_p_n24 rbl_3__t1_p_n24 rbl_3_p_n24 36.5601
rrbl_3_t2_p_n24 rbl_3__t2_p_n24 rbl_3_p_n24 2.99444
rrbl_3_t3_p_n24 rbl_3__t3_p_n24 rbl_3_p_n24 2.99444
rrwl_0_t0_p_n24 rwl_0__t0_p_n24 rwl_0_p_n24 38.2618
rrwl_0_t1_p_n24 rwl_0__t1_p_n24 rwl_0_p_n24 12.7539
rrwl_0_t2_p_n24 rwl_0__t2_p_n24 rwl_0_p_n24 38.2618
rrwl_0_t3_p_n24 rwl_0__t3_p_n24 rwl_0_p_n24 12.7539
rrwl_1_t0_p_n24 rwl_1__t0_p_n24 rwl_1_p_n24 38.2618
rrwl_1_t1_p_n24 rwl_1__t1_p_n24 rwl_1_p_n24 12.7539
rrwl_1_t2_p_n24 rwl_1__t2_p_n24 rwl_1_p_n24 12.7539
rrwl_1_t3_p_n24 rwl_1__t3_p_n24 rwl_1_p_n24 38.2618
rrwl_2_t0_p_n24 rwl_2__t0_p_n24 rwl_2_p_n24 12.7539
rrwl_2_t1_p_n24 rwl_2__t1_p_n24 rwl_2_p_n24 12.7539
rrwl_2_t2_p_n24 rwl_2__t2_p_n24 rwl_2_p_n24 38.2618
rrwl_2_t3_p_n24 rwl_2__t3_p_n24 rwl_2_p_n24 38.2618
rrwl_3_t0_p_n24 rwl_3__t0_p_n24 rwl_3_p_n24 38.2618
rrwl_3_t1_p_n24 rwl_3__t1_p_n24 rwl_3_p_n24 12.7539
rrwl_3_t2_p_n24 rwl_3__t2_p_n24 rwl_3_p_n24 12.7539
rrwl_3_t3_p_n24 rwl_3__t3_p_n24 rwl_3_p_n24 38.2618
rwl_0_t0_p_n24 wl_0__t0_p_n24 wl_0_p_n24 245.959
rwl_0_t1_p_n24 wl_0__t1_p_n24 wl_0_p_n24 245.959
rwl_0_t2_p_n24 wl_0__t2_p_n24 wl_0_p_n24 81.9864
rwl_0_t3_p_n24 wl_0__t3_p_n24 wl_0_p_n24 81.9864
rwl_1_t0_p_n24 wl_1__t0_p_n24 wl_1_p_n24 245.959
rwl_1_t1_p_n24 wl_1__t1_p_n24 wl_1_p_n24 81.9864
rwl_1_t2_p_n24 wl_1__t2_p_n24 wl_1_p_n24 81.9864
rwl_1_t3_p_n24 wl_1__t3_p_n24 wl_1_p_n24 245.959
rwl_2_t0_p_n24 wl_2__t0_p_n24 wl_2_p_n24 245.959
rwl_2_t1_p_n24 wl_2__t1_p_n24 wl_2_p_n24 81.9864
rwl_2_t2_p_n24 wl_2__t2_p_n24 wl_2_p_n24 81.9864
rwl_2_t3_p_n24 wl_2__t3_p_n24 wl_2_p_n24 245.959
rwl_3_t0_p_n24 wl_3__t0_p_n24 wl_3_p_n24 245.959
rwl_3_t1_p_n24 wl_3__t1_p_n24 wl_3_p_n24 81.9864
rwl_3_t2_p_n24 wl_3__t2_p_n24 wl_3_p_n24 81.9864
rwl_3_t3_p_n24 wl_3__t3_p_n24 wl_3_p_n24 245.959
c_10_p_n24 n10_p_n24 0 2.91622e-16
c_17_p_n24 n17_p_n24 0 2.91528e-16
c_18_p_n24 n18_p_n24 0 2.91528e-16
c_19_p_n24 n19_p_n24 0 2.91528e-16
c_20_p_n24 n20_p_n24 0 2.91622e-16
c_22_p_n24 n22_p_n24 0 2.91528e-16
c_23_p_n24 n23_p_n24 0 2.91528e-16
c_24_p_n24 n24_p_n24 0 1.1371e-16
c_25_p_n24 n25_p_n24 0 2.91622e-16
c_29_p_n24 n29_p_n24 0 2.91528e-16
c_30_p_n24 n30_p_n24 0 2.91528e-16
c_31_p_n24 n31_p_n24 0 2.91528e-16
c_32_p_n24 n32_p_n24 0 2.91622e-16
c_7_p_n24 n7_p_n24 0 2.91528e-16
c_8_p_n24 n8_p_n24 0 2.91528e-16
c_9_p_n24 n9_p_n24 0 2.91528e-16
cgnd_p_n24 0 0 2.48166e-15
cbl_0_p_n24 bl_0_p_n24 0 4.52661e-16
cbl_1_p_n24 bl_1_p_n24 0 4.52661e-16
cbl_2_p_n24 bl_2_p_n24 0 4.52661e-16
cbl_3_p_n24 bl_3_p_n24 0 4.52661e-16
crbl_0_p_n24 rbl_0_p_n24 0 9.14472e-16
crbl_1_p_n24 rbl_1_p_n24 0 9.14472e-16
crbl_2_p_n24 rbl_2_p_n24 0 9.14472e-16
crbl_3_p_n24 rbl_3_p_n24 0 9.17566e-16
crwl_0_p_n24 rwl_0_p_n24 0 5.19495e-16
crwl_1_p_n24 rwl_1_p_n24 0 5.11719e-16
crwl_2_p_n24 rwl_2_p_n24 0 5.11719e-16
crwl_3_p_n24 rwl_3_p_n24 0 5.19495e-16
cwl_0_p_n24 wl_0_p_n24 0 3.30388e-16
cwl_1_p_n24 wl_1_p_n24 0 3.30388e-16
cwl_2_p_n24 wl_2_p_n24 0 3.30388e-16
cwl_3_p_n24 wl_3_p_n24 0 3.30388e-16
ccc__10__9_p_n24 n10_p_n24 n9_p_n24 1.02e-17
ccc__10_bl_3_p_n24 n10_p_n24 bl_3_p_n24 1.3999e-17
ccc__10_rwl_0_p_n24 n10_p_n24 rwl_0_p_n24 4.335e-18
ccc__17__18_p_n24 n17_p_n24 n18_p_n24 1.02e-17
ccc__17_bl_0_p_n24 n17_p_n24 bl_0_p_n24 8.415e-18
ccc__17_rwl_1_p_n24 n17_p_n24 rwl_1_p_n24 1.3194e-17
ccc__18__19_p_n24 n18_p_n24 n19_p_n24 1.02e-17
ccc__18_bl_1_p_n24 n18_p_n24 bl_1_p_n24 8.415e-18
ccc__18_rwl_1_p_n24 n18_p_n24 rwl_1_p_n24 1.3194e-17
ccc__19__20_p_n24 n19_p_n24 n20_p_n24 1.02e-17
ccc__19_bl_2_p_n24 n19_p_n24 bl_2_p_n24 8.415e-18
ccc__19_rwl_1_p_n24 n19_p_n24 rwl_1_p_n24 1.3194e-17
ccc__20_bl_3_p_n24 n20_p_n24 bl_3_p_n24 8.415e-18
ccc__20_rwl_1_p_n24 n20_p_n24 rwl_1_p_n24 6.655e-18
ccc__22__23_p_n24 n22_p_n24 n23_p_n24 1.02e-17
ccc__22_bl_0_p_n24 n22_p_n24 bl_0_p_n24 8.415e-18
ccc__22_rwl_2_p_n24 n22_p_n24 rwl_2_p_n24 1.3194e-17
ccc__23__24_p_n24 n23_p_n24 n24_p_n24 1.02e-17
ccc__23_bl_1_p_n24 n23_p_n24 bl_1_p_n24 8.415e-18
ccc__23_rwl_2_p_n24 n23_p_n24 rwl_2_p_n24 1.3194e-17
ccc__24__25_p_n24 n24_p_n24 n25_p_n24 1.02e-17
ccc__24_bl_2_p_n24 n24_p_n24 bl_2_p_n24 8.415e-18
ccc__24_rwl_2_p_n24 n24_p_n24 rwl_2_p_n24 1.3194e-17
ccc__25_bl_3_p_n24 n25_p_n24 bl_3_p_n24 8.415e-18
ccc__25_rwl_2_p_n24 n25_p_n24 rwl_2_p_n24 6.655e-18
ccc__29__30_p_n24 n29_p_n24 n30_p_n24 1.02e-17
ccc__29_bl_0_p_n24 n29_p_n24 bl_0_p_n24 8.415e-18
ccc__29_rwl_3_p_n24 n29_p_n24 rwl_3_p_n24 1.3194e-17
ccc__30__31_p_n24 n30_p_n24 n31_p_n24 1.02e-17
ccc__30_bl_1_p_n24 n30_p_n24 bl_1_p_n24 8.415e-18
ccc__30_rwl_3_p_n24 n30_p_n24 rwl_3_p_n24 1.3194e-17
ccc__31__32_p_n24 n31_p_n24 n32_p_n24 1.02e-17
ccc__31_bl_2_p_n24 n31_p_n24 bl_2_p_n24 8.415e-18
ccc__31_rwl_3_p_n24 n31_p_n24 rwl_3_p_n24 1.3194e-17
ccc__32_bl_3_p_n24 n32_p_n24 bl_3_p_n24 8.415e-18
ccc__32_rwl_3_p_n24 n32_p_n24 rwl_3_p_n24 6.655e-18
ccc__7__8_p_n24 n7_p_n24 n8_p_n24 1.02e-17
ccc__7_bl_0_p_n24 n7_p_n24 bl_0_p_n24 1.3999e-17
ccc__7_rwl_0_p_n24 n7_p_n24 rwl_0_p_n24 8.961e-18
ccc__8__9_p_n24 n8_p_n24 n9_p_n24 1.02e-17
ccc__8_bl_1_p_n24 n8_p_n24 bl_1_p_n24 1.3999e-17
ccc__8_rwl_0_p_n24 n8_p_n24 rwl_0_p_n24 8.961e-18
ccc__9_bl_2_p_n24 n9_p_n24 bl_2_p_n24 1.3999e-17
ccc__9_rwl_0_p_n24 n9_p_n24 rwl_0_p_n24 8.961e-18
ccc_bl_0_rbl_0_p_n24 bl_0_p_n24 rbl_0_p_n24 1.88693e-16
ccc_bl_0_rwl_1_p_n24 bl_0_p_n24 rwl_1_p_n24 1.0093e-17
ccc_bl_0_rwl_2_p_n24 bl_0_p_n24 rwl_2_p_n24 1.0093e-17
ccc_bl_1_rbl_0_p_n24 bl_1_p_n24 rbl_0_p_n24 1.633e-16
ccc_bl_1_rbl_1_p_n24 bl_1_p_n24 rbl_1_p_n24 1.88693e-16
ccc_bl_1_rwl_1_p_n24 bl_1_p_n24 rwl_1_p_n24 1.0093e-17
ccc_bl_1_rwl_2_p_n24 bl_1_p_n24 rwl_2_p_n24 1.0093e-17
ccc_bl_2_rbl_1_p_n24 bl_2_p_n24 rbl_1_p_n24 1.633e-16
ccc_bl_2_rbl_2_p_n24 bl_2_p_n24 rbl_2_p_n24 1.88693e-16
ccc_bl_2_rwl_1_p_n24 bl_2_p_n24 rwl_1_p_n24 1.0093e-17
ccc_bl_2_rwl_2_p_n24 bl_2_p_n24 rwl_2_p_n24 1.0093e-17
ccc_bl_3_rbl_2_p_n24 bl_3_p_n24 rbl_2_p_n24 1.633e-16
ccc_bl_3_rbl_3_p_n24 bl_3_p_n24 rbl_3_p_n24 1.88693e-16
ccc_bl_3_rwl_1_p_n24 bl_3_p_n24 rwl_1_p_n24 1.0093e-17
ccc_bl_3_rwl_2_p_n24 bl_3_p_n24 rwl_2_p_n24 1.0093e-17
ccc_rbl_0_rbl_1_p_n24 rbl_0_p_n24 rbl_1_p_n24 3.432e-17
ccc_rbl_0_rwl_0_p_n24 rbl_0_p_n24 rwl_0_p_n24 4.9752e-17
ccc_rbl_0_rwl_1_p_n24 rbl_0_p_n24 rwl_1_p_n24 4.9752e-17
ccc_rbl_0_rwl_2_p_n24 rbl_0_p_n24 rwl_2_p_n24 4.9752e-17
ccc_rbl_0_rwl_3_p_n24 rbl_0_p_n24 rwl_3_p_n24 4.9752e-17
ccc_rbl_1_rbl_2_p_n24 rbl_1_p_n24 rbl_2_p_n24 3.432e-17
ccc_rbl_1_rwl_0_p_n24 rbl_1_p_n24 rwl_0_p_n24 4.9752e-17
ccc_rbl_1_rwl_1_p_n24 rbl_1_p_n24 rwl_1_p_n24 4.9752e-17
ccc_rbl_1_rwl_2_p_n24 rbl_1_p_n24 rwl_2_p_n24 4.9752e-17
ccc_rbl_1_rwl_3_p_n24 rbl_1_p_n24 rwl_3_p_n24 4.9752e-17
ccc_rbl_2_rbl_3_p_n24 rbl_2_p_n24 rbl_3_p_n24 3.432e-17
ccc_rbl_2_rwl_0_p_n24 rbl_2_p_n24 rwl_0_p_n24 4.9752e-17
ccc_rbl_2_rwl_1_p_n24 rbl_2_p_n24 rwl_1_p_n24 4.9752e-17
ccc_rbl_2_rwl_2_p_n24 rbl_2_p_n24 rwl_2_p_n24 4.9752e-17
ccc_rbl_2_rwl_3_p_n24 rbl_2_p_n24 rwl_3_p_n24 4.9752e-17
ccc_rbl_3_rwl_0_p_n24 rbl_3_p_n24 rwl_0_p_n24 3.3407e-17
ccc_rbl_3_rwl_1_p_n24 rbl_3_p_n24 rwl_1_p_n24 3.3407e-17
ccc_rbl_3_rwl_2_p_n24 rbl_3_p_n24 rwl_2_p_n24 3.3407e-17
ccc_rbl_3_rwl_3_p_n24 rbl_3_p_n24 rwl_3_p_n24 3.3407e-17
vdw_p_n24_0 wl_0_p_n24 0 dc 0
vdr_p_n24_0 rwl_0_p_n24 vdd dc 0
vdw_p_n24_1 wl_1_p_n24 0 dc 0
vdr_p_n24_1 rwl_1_p_n24 vdd dc 0
vdw_p_n24_2 wl_2_p_n24 0 dc 0
vdr_p_n24_2 rwl_2_p_n24 vdd dc 0
vdw_p_n24_3 wl_3_p_n24 0 dc 0
vdr_p_n24_3 rwl_3_p_n24 vdd dc 0
vdb_p_n24_0 bl_0_p_n24 0 dc 0
vdp_p_n24_0 rbl_0_p_n24 vrbl dc 0
vdb_p_n24_1 bl_1_p_n24 0 dc 0
vdp_p_n24_1 rbl_1_p_n24 vrbl dc 0
vdb_p_n24_2 bl_2_p_n24 0 dc 0
vdp_p_n24_2 rbl_2_p_n24 vrbl dc 0
vdb_p_n24_3 bl_3_p_n24 0 dc 0
vdp_p_n24_3 rbl_3_p_n24 vrbl dc 0
vdn_p_n24_n7 n7_p_n24 0 dc 1
vdn_p_n24_n8 n8_p_n24 0 dc 1
vdn_p_n24_n9 n9_p_n24 0 dc 1
vdn_p_n24_n10 n10_p_n24 0 dc 1
vdn_p_n24_n17 n17_p_n24 0 dc 1
vdn_p_n24_n18 n18_p_n24 0 dc 1
vdn_p_n24_n19 n19_p_n24 0 dc 1
vdn_p_n24_n20 n20_p_n24 0 dc 1
vdn_p_n24_n22 n22_p_n24 0 dc 1
vdn_p_n24_n23 n23_p_n24 0 dc 1
vdn_p_n24_n25 n25_p_n24 0 dc 1
vdn_p_n24_n29 n29_p_n24 0 dc 1
vdn_p_n24_n30 n30_p_n24 0 dc 1
vdn_p_n24_n31 n31_p_n24 0 dc 1
vdn_p_n24_n32 n32_p_n24 0 dc 1
bdr_p_n24 n24_p_n24 0 i=5e-08*min(1,max(0,(time-1e-09)/0.2n))*0.5*(1+tanh((v(n24_p_n24)-0.05)/0.01))

* ---- instance p_n25: variant p, probed storage node \$25 ----
xm1_p_n25 rwl_0__t2_p_n25 n7__t0_p_n25 rbl_0__t0_p_n25 gnd__t0_p_n25 sky130_fd_pr__nfet_01v8 L=0.15 W=0.42 nf=1 ad=0.1197 as=0.1197 pd=1.41 ps=1.41 mult=1 m=1
xm2_p_n25 rwl_0__t3_p_n25 n8__t1_p_n25 rbl_1__t1_p_n25 gnd__t1_p_n25 sky130_fd_pr__nfet_01v8 L=0.15 W=0.42 nf=1 ad=0.1197 as=0.1197 pd=1.41 ps=1.41 mult=1 m=1
xm3_p_n25 rwl_0__t1_p_n25 n9__t1_p_n25 rbl_2__t1_p_n25 gnd__t2_p_n25 sky130_fd_pr__nfet_01v8 L=0.15 W=0.42 nf=1 ad=0.1197 as=0.1197 pd=1.41 ps=1.41 mult=1 m=1
xm4_p_n25 rwl_0__t0_p_n25 n10__t1_p_n25 rbl_3__t1_p_n25 gnd__t3_p_n25 sky130_fd_pr__nfet_01v8 L=0.15 W=0.42 nf=1 ad=0.1197 as=0.1197 pd=1.41 ps=1.41 mult=1 m=1
xm5_p_n25 bl_0__t0_p_n25 wl_0__t0_p_n25 n7__t1_p_n25 gnd__t8_p_n25 sky130_fd_pr__nfet_01v8 L=0.15 W=0.42 nf=1 ad=0.0588 as=0.1197 pd=0.7 ps=1.41 mult=1 m=1
xm6_p_n25 n17__t0_p_n25 wl_1__t0_p_n25 bl_0__t1_p_n25 gnd__t20_p_n25 sky130_fd_pr__nfet_01v8 L=0.15 W=0.42 nf=1 ad=0.1197 as=0.0588 pd=1.41 ps=0.7 mult=1 m=1
xm7_p_n25 bl_1__t2_p_n25 wl_0__t3_p_n25 n8__t0_p_n25 gnd__t9_p_n25 sky130_fd_pr__nfet_01v8 L=0.15 W=0.42 nf=1 ad=0.0588 as=0.1197 pd=0.7 ps=1.41 mult=1 m=1
xm8_p_n25 n18__t0_p_n25 wl_1__t1_p_n25 bl_1__t0_p_n25 gnd__t21_p_n25 sky130_fd_pr__nfet_01v8 L=0.15 W=0.42 nf=1 ad=0.1197 as=0.0588 pd=1.41 ps=0.7 mult=1 m=1
xm9_p_n25 bl_2__t2_p_n25 wl_0__t2_p_n25 n9__t0_p_n25 gnd__t10_p_n25 sky130_fd_pr__nfet_01v8 L=0.15 W=0.42 nf=1 ad=0.0588 as=0.1197 pd=0.7 ps=1.41 mult=1 m=1
xm10_p_n25 n19__t0_p_n25 wl_1__t2_p_n25 bl_2__t0_p_n25 gnd__t22_p_n25 sky130_fd_pr__nfet_01v8 L=0.15 W=0.42 nf=1 ad=0.1197 as=0.0588 pd=1.41 ps=0.7 mult=1 m=1
xm11_p_n25 bl_3__t2_p_n25 wl_0__t1_p_n25 n10__t0_p_n25 gnd__t11_p_n25 sky130_fd_pr__nfet_01v8 L=0.15 W=0.42 nf=1 ad=0.0588 as=0.1197 pd=0.7 ps=1.41 mult=1 m=1
xm12_p_n25 n20__t0_p_n25 wl_1__t3_p_n25 bl_3__t1_p_n25 gnd__t23_p_n25 sky130_fd_pr__nfet_01v8 L=0.15 W=0.42 nf=1 ad=0.1197 as=0.0588 pd=1.41 ps=0.7 mult=1 m=1
xm13_p_n25 rbl_0__t3_p_n25 n17__t1_p_n25 rwl_1__t0_p_n25 gnd__t12_p_n25 sky130_fd_pr__nfet_01v8 L=0.15 W=0.42 nf=1 ad=0.0588 as=0.1197 pd=0.7 ps=1.41 mult=1 m=1
xm14_p_n25 rwl_2__t3_p_n25 n22__t0_p_n25 rbl_0__t2_p_n25 gnd__t24_p_n25 sky130_fd_pr__nfet_01v8 L=0.15 W=0.42 nf=1 ad=0.1197 as=0.0588 pd=1.41 ps=0.7 mult=1 m=1
xm15_p_n25 rbl_1__t3_p_n25 n18__t1_p_n25 rwl_1__t1_p_n25 gnd__t13_p_n25 sky130_fd_pr__nfet_01v8 L=0.15 W=0.42 nf=1 ad=0.0588 as=0.1197 pd=0.7 ps=1.41 mult=1 m=1
xm16_p_n25 rwl_2__t0_p_n25 n23__t0_p_n25 rbl_1__t2_p_n25 gnd__t25_p_n25 sky130_fd_pr__nfet_01v8 L=0.15 W=0.42 nf=1 ad=0.1197 as=0.0588 pd=1.41 ps=0.7 mult=1 m=1
xm17_p_n25 rbl_2__t3_p_n25 n19__t1_p_n25 rwl_1__t2_p_n25 gnd__t14_p_n25 sky130_fd_pr__nfet_01v8 L=0.15 W=0.42 nf=1 ad=0.0588 as=0.1197 pd=0.7 ps=1.41 mult=1 m=1
xm18_p_n25 rwl_2__t1_p_n25 n24__t0_p_n25 rbl_2__t2_p_n25 gnd__t26_p_n25 sky130_fd_pr__nfet_01v8 L=0.15 W=0.42 nf=1 ad=0.1197 as=0.0588 pd=1.41 ps=0.7 mult=1 m=1
xm19_p_n25 rbl_3__t3_p_n25 n20__t1_p_n25 rwl_1__t3_p_n25 gnd__t15_p_n25 sky130_fd_pr__nfet_01v8 L=0.15 W=0.42 nf=1 ad=0.0588 as=0.1197 pd=0.7 ps=1.41 mult=1 m=1
xm20_p_n25 rwl_2__t2_p_n25 n25__t0_p_n25 rbl_3__t2_p_n25 gnd__t27_p_n25 sky130_fd_pr__nfet_01v8 L=0.15 W=0.42 nf=1 ad=0.1197 as=0.0588 pd=1.41 ps=0.7 mult=1 m=1
xm21_p_n25 bl_0__t3_p_n25 wl_2__t0_p_n25 n22__t1_p_n25 gnd__t16_p_n25 sky130_fd_pr__nfet_01v8 L=0.15 W=0.42 nf=1 ad=0.0588 as=0.1197 pd=0.7 ps=1.41 mult=1 m=1
xm22_p_n25 n29__t0_p_n25 wl_3__t3_p_n25 bl_0__t2_p_n25 gnd__t28_p_n25 sky130_fd_pr__nfet_01v8 L=0.15 W=0.42 nf=1 ad=0.1197 as=0.0588 pd=1.41 ps=0.7 mult=1 m=1
xm23_p_n25 bl_1__t3_p_n25 wl_2__t1_p_n25 n23__t1_p_n25 gnd__t17_p_n25 sky130_fd_pr__nfet_01v8 L=0.15 W=0.42 nf=1 ad=0.0588 as=0.1197 pd=0.7 ps=1.41 mult=1 m=1
xm24_p_n25 n30__t0_p_n25 wl_3__t2_p_n25 bl_1__t1_p_n25 gnd__t29_p_n25 sky130_fd_pr__nfet_01v8 L=0.15 W=0.42 nf=1 ad=0.1197 as=0.0588 pd=1.41 ps=0.7 mult=1 m=1
xm25_p_n25 bl_2__t3_p_n25 wl_2__t2_p_n25 n24__t1_p_n25 gnd__t18_p_n25 sky130_fd_pr__nfet_01v8 L=0.15 W=0.42 nf=1 ad=0.0588 as=0.1197 pd=0.7 ps=1.41 mult=1 m=1
xm26_p_n25 n31__t0_p_n25 wl_3__t1_p_n25 bl_2__t1_p_n25 gnd__t30_p_n25 sky130_fd_pr__nfet_01v8 L=0.15 W=0.42 nf=1 ad=0.1197 as=0.0588 pd=1.41 ps=0.7 mult=1 m=1
xm27_p_n25 bl_3__t3_p_n25 wl_2__t3_p_n25 n25__t1_p_n25 gnd__t19_p_n25 sky130_fd_pr__nfet_01v8 L=0.15 W=0.42 nf=1 ad=0.0588 as=0.1197 pd=0.7 ps=1.41 mult=1 m=1
xm28_p_n25 n32__t0_p_n25 wl_3__t0_p_n25 bl_3__t0_p_n25 gnd__t31_p_n25 sky130_fd_pr__nfet_01v8 L=0.15 W=0.42 nf=1 ad=0.1197 as=0.0588 pd=1.41 ps=0.7 mult=1 m=1
xm29_p_n25 rbl_0__t1_p_n25 n29__t1_p_n25 rwl_3__t0_p_n25 gnd__t4_p_n25 sky130_fd_pr__nfet_01v8 L=0.15 W=0.42 nf=1 ad=0.1197 as=0.1197 pd=1.41 ps=1.41 mult=1 m=1
xm30_p_n25 rbl_1__t0_p_n25 n30__t1_p_n25 rwl_3__t1_p_n25 gnd__t5_p_n25 sky130_fd_pr__nfet_01v8 L=0.15 W=0.42 nf=1 ad=0.1197 as=0.1197 pd=1.41 ps=1.41 mult=1 m=1
xm31_p_n25 rbl_2__t0_p_n25 n31__t1_p_n25 rwl_3__t2_p_n25 gnd__t6_p_n25 sky130_fd_pr__nfet_01v8 L=0.15 W=0.42 nf=1 ad=0.1197 as=0.1197 pd=1.41 ps=1.41 mult=1 m=1
xm32_p_n25 rbl_3__t0_p_n25 n32__t1_p_n25 rwl_3__t3_p_n25 gnd__t7_p_n25 sky130_fd_pr__nfet_01v8 L=0.15 W=0.42 nf=1 ad=0.1197 as=0.1197 pd=1.41 ps=1.41 mult=1 m=1
r_10_t0_p_n25 n10__t0_p_n25 n10_p_n25 183.071
r_10_t1_p_n25 n10__t1_p_n25 n10_p_n25 183.071
r_17_t0_p_n25 n17__t0_p_n25 n17_p_n25 183.071
r_17_t1_p_n25 n17__t1_p_n25 n17_p_n25 183.071
r_18_t0_p_n25 n18__t0_p_n25 n18_p_n25 183.071
r_18_t1_p_n25 n18__t1_p_n25 n18_p_n25 183.071
r_19_t0_p_n25 n19__t0_p_n25 n19_p_n25 183.071
r_19_t1_p_n25 n19__t1_p_n25 n19_p_n25 183.071
r_20_t0_p_n25 n20__t0_p_n25 n20_p_n25 183.071
r_20_t1_p_n25 n20__t1_p_n25 n20_p_n25 183.071
r_22_t0_p_n25 n22__t0_p_n25 n22_p_n25 183.071
r_22_t1_p_n25 n22__t1_p_n25 n22_p_n25 183.071
r_23_t0_p_n25 n23__t0_p_n25 n23_p_n25 183.071
r_23_t1_p_n25 n23__t1_p_n25 n23_p_n25 183.071
r_24_t0_p_n25 n24__t0_p_n25 n24_p_n25 183.071
r_24_t1_p_n25 n24__t1_p_n25 n24_p_n25 183.071
r_25_t0_p_n25 n25__t0_p_n25 n25_p_n25 183.071
r_25_t1_p_n25 n25__t1_p_n25 n25_p_n25 183.071
r_29_t0_p_n25 n29__t0_p_n25 n29_p_n25 183.071
r_29_t1_p_n25 n29__t1_p_n25 n29_p_n25 183.071
r_30_t0_p_n25 n30__t0_p_n25 n30_p_n25 183.071
r_30_t1_p_n25 n30__t1_p_n25 n30_p_n25 183.071
r_31_t0_p_n25 n31__t0_p_n25 n31_p_n25 183.071
r_31_t1_p_n25 n31__t1_p_n25 n31_p_n25 183.071
r_32_t0_p_n25 n32__t0_p_n25 n32_p_n25 183.071
r_32_t1_p_n25 n32__t1_p_n25 n32_p_n25 183.071
r_7_t0_p_n25 n7__t0_p_n25 n7_p_n25 183.071
r_7_t1_p_n25 n7__t1_p_n25 n7_p_n25 183.071
r_8_t0_p_n25 n8__t0_p_n25 n8_p_n25 183.071
r_8_t1_p_n25 n8__t1_p_n25 n8_p_n25 183.071
r_9_t0_p_n25 n9__t0_p_n25 n9_p_n25 183.071
r_9_t1_p_n25 n9__t1_p_n25 n9_p_n25 183.071
rgnd_t0_p_n25 gnd__t0_p_n25 0 38.2988
rgnd_t1_p_n25 gnd__t1_p_n25 0 33.9576
rgnd_t2_p_n25 gnd__t2_p_n25 0 33.9576
rgnd_t3_p_n25 gnd__t3_p_n25 0 38.2988
rgnd_t4_p_n25 gnd__t4_p_n25 0 38.2988
rgnd_t5_p_n25 gnd__t5_p_n25 0 33.9576
rgnd_t6_p_n25 gnd__t6_p_n25 0 33.9576
rgnd_t7_p_n25 gnd__t7_p_n25 0 38.2988
rgnd_t8_p_n25 gnd__t8_p_n25 0 28.0185
rgnd_t9_p_n25 gnd__t9_p_n25 0 21.7106
rgnd_t10_p_n25 gnd__t10_p_n25 0 21.7106
rgnd_t11_p_n25 gnd__t11_p_n25 0 28.0185
rgnd_t12_p_n25 gnd__t12_p_n25 0 18.9833
rgnd_t13_p_n25 gnd__t13_p_n25 0 6.8325
rgnd_t14_p_n25 gnd__t14_p_n25 0 6.8325
rgnd_t15_p_n25 gnd__t15_p_n25 0 18.9833
rgnd_t16_p_n25 gnd__t16_p_n25 0 24.2409
rgnd_t17_p_n25 gnd__t17_p_n25 0 16.5511
rgnd_t18_p_n25 gnd__t18_p_n25 0 16.5511
rgnd_t19_p_n25 gnd__t19_p_n25 0 24.2409
rgnd_t20_p_n25 gnd__t20_p_n25 0 24.2409
rgnd_t21_p_n25 gnd__t21_p_n25 0 16.5511
rgnd_t22_p_n25 gnd__t22_p_n25 0 16.5511
rgnd_t23_p_n25 gnd__t23_p_n25 0 24.2409
rgnd_t24_p_n25 gnd__t24_p_n25 0 18.9833
rgnd_t25_p_n25 gnd__t25_p_n25 0 6.8325
rgnd_t26_p_n25 gnd__t26_p_n25 0 6.8325
rgnd_t27_p_n25 gnd__t27_p_n25 0 18.9833
rgnd_t28_p_n25 gnd__t28_p_n25 0 28.0185
rgnd_t29_p_n25 gnd__t29_p_n25 0 21.7106
rgnd_t30_p_n25 gnd__t30_p_n25 0 21.7106
rgnd_t31_p_n25 gnd__t31_p_n25 0 28.0185
rbl_0_t0_p_n25 bl_0__t0_p_n25 bl_0_p_n25 14.8304
rbl_0_t1_p_n25 bl_0__t1_p_n25 bl_0_p_n25 10.9301
rbl_0_t2_p_n25 bl_0__t2_p_n25 bl_0_p_n25 14.8304
rbl_0_t3_p_n25 bl_0__t3_p_n25 bl_0_p_n25 10.9301
rbl_1_t0_p_n25 bl_1__t0_p_n25 bl_1_p_n25 10.9301
rbl_1_t1_p_n25 bl_1__t1_p_n25 bl_1_p_n25 14.8304
rbl_1_t2_p_n25 bl_1__t2_p_n25 bl_1_p_n25 14.8304
rbl_1_t3_p_n25 bl_1__t3_p_n25 bl_1_p_n25 10.9301
rbl_2_t0_p_n25 bl_2__t0_p_n25 bl_2_p_n25 10.9301
rbl_2_t1_p_n25 bl_2__t1_p_n25 bl_2_p_n25 14.8304
rbl_2_t2_p_n25 bl_2__t2_p_n25 bl_2_p_n25 14.8304
rbl_2_t3_p_n25 bl_2__t3_p_n25 bl_2_p_n25 10.9301
rbl_3_t0_p_n25 bl_3__t0_p_n25 bl_3_p_n25 14.8304
rbl_3_t1_p_n25 bl_3__t1_p_n25 bl_3_p_n25 10.9301
rbl_3_t2_p_n25 bl_3__t2_p_n25 bl_3_p_n25 14.8304
rbl_3_t3_p_n25 bl_3__t3_p_n25 bl_3_p_n25 10.9301
rrbl_0_t0_p_n25 rbl_0__t0_p_n25 rbl_0_p_n25 36.5601
rrbl_0_t1_p_n25 rbl_0__t1_p_n25 rbl_0_p_n25 36.5601
rrbl_0_t2_p_n25 rbl_0__t2_p_n25 rbl_0_p_n25 2.99444
rrbl_0_t3_p_n25 rbl_0__t3_p_n25 rbl_0_p_n25 2.99444
rrbl_1_t0_p_n25 rbl_1__t0_p_n25 rbl_1_p_n25 36.5601
rrbl_1_t1_p_n25 rbl_1__t1_p_n25 rbl_1_p_n25 36.5601
rrbl_1_t2_p_n25 rbl_1__t2_p_n25 rbl_1_p_n25 2.99444
rrbl_1_t3_p_n25 rbl_1__t3_p_n25 rbl_1_p_n25 2.99444
rrbl_2_t0_p_n25 rbl_2__t0_p_n25 rbl_2_p_n25 36.5601
rrbl_2_t1_p_n25 rbl_2__t1_p_n25 rbl_2_p_n25 36.5601
rrbl_2_t2_p_n25 rbl_2__t2_p_n25 rbl_2_p_n25 2.99444
rrbl_2_t3_p_n25 rbl_2__t3_p_n25 rbl_2_p_n25 2.99444
rrbl_3_t0_p_n25 rbl_3__t0_p_n25 rbl_3_p_n25 36.5601
rrbl_3_t1_p_n25 rbl_3__t1_p_n25 rbl_3_p_n25 36.5601
rrbl_3_t2_p_n25 rbl_3__t2_p_n25 rbl_3_p_n25 2.99444
rrbl_3_t3_p_n25 rbl_3__t3_p_n25 rbl_3_p_n25 2.99444
rrwl_0_t0_p_n25 rwl_0__t0_p_n25 rwl_0_p_n25 38.2618
rrwl_0_t1_p_n25 rwl_0__t1_p_n25 rwl_0_p_n25 12.7539
rrwl_0_t2_p_n25 rwl_0__t2_p_n25 rwl_0_p_n25 38.2618
rrwl_0_t3_p_n25 rwl_0__t3_p_n25 rwl_0_p_n25 12.7539
rrwl_1_t0_p_n25 rwl_1__t0_p_n25 rwl_1_p_n25 38.2618
rrwl_1_t1_p_n25 rwl_1__t1_p_n25 rwl_1_p_n25 12.7539
rrwl_1_t2_p_n25 rwl_1__t2_p_n25 rwl_1_p_n25 12.7539
rrwl_1_t3_p_n25 rwl_1__t3_p_n25 rwl_1_p_n25 38.2618
rrwl_2_t0_p_n25 rwl_2__t0_p_n25 rwl_2_p_n25 12.7539
rrwl_2_t1_p_n25 rwl_2__t1_p_n25 rwl_2_p_n25 12.7539
rrwl_2_t2_p_n25 rwl_2__t2_p_n25 rwl_2_p_n25 38.2618
rrwl_2_t3_p_n25 rwl_2__t3_p_n25 rwl_2_p_n25 38.2618
rrwl_3_t0_p_n25 rwl_3__t0_p_n25 rwl_3_p_n25 38.2618
rrwl_3_t1_p_n25 rwl_3__t1_p_n25 rwl_3_p_n25 12.7539
rrwl_3_t2_p_n25 rwl_3__t2_p_n25 rwl_3_p_n25 12.7539
rrwl_3_t3_p_n25 rwl_3__t3_p_n25 rwl_3_p_n25 38.2618
rwl_0_t0_p_n25 wl_0__t0_p_n25 wl_0_p_n25 245.959
rwl_0_t1_p_n25 wl_0__t1_p_n25 wl_0_p_n25 245.959
rwl_0_t2_p_n25 wl_0__t2_p_n25 wl_0_p_n25 81.9864
rwl_0_t3_p_n25 wl_0__t3_p_n25 wl_0_p_n25 81.9864
rwl_1_t0_p_n25 wl_1__t0_p_n25 wl_1_p_n25 245.959
rwl_1_t1_p_n25 wl_1__t1_p_n25 wl_1_p_n25 81.9864
rwl_1_t2_p_n25 wl_1__t2_p_n25 wl_1_p_n25 81.9864
rwl_1_t3_p_n25 wl_1__t3_p_n25 wl_1_p_n25 245.959
rwl_2_t0_p_n25 wl_2__t0_p_n25 wl_2_p_n25 245.959
rwl_2_t1_p_n25 wl_2__t1_p_n25 wl_2_p_n25 81.9864
rwl_2_t2_p_n25 wl_2__t2_p_n25 wl_2_p_n25 81.9864
rwl_2_t3_p_n25 wl_2__t3_p_n25 wl_2_p_n25 245.959
rwl_3_t0_p_n25 wl_3__t0_p_n25 wl_3_p_n25 245.959
rwl_3_t1_p_n25 wl_3__t1_p_n25 wl_3_p_n25 81.9864
rwl_3_t2_p_n25 wl_3__t2_p_n25 wl_3_p_n25 81.9864
rwl_3_t3_p_n25 wl_3__t3_p_n25 wl_3_p_n25 245.959
c_10_p_n25 n10_p_n25 0 2.91622e-16
c_17_p_n25 n17_p_n25 0 2.91528e-16
c_18_p_n25 n18_p_n25 0 2.91528e-16
c_19_p_n25 n19_p_n25 0 2.91528e-16
c_20_p_n25 n20_p_n25 0 2.91622e-16
c_22_p_n25 n22_p_n25 0 2.91528e-16
c_23_p_n25 n23_p_n25 0 2.91528e-16
c_24_p_n25 n24_p_n25 0 2.91528e-16
c_25_p_n25 n25_p_n25 0 1.13804e-16
c_29_p_n25 n29_p_n25 0 2.91528e-16
c_30_p_n25 n30_p_n25 0 2.91528e-16
c_31_p_n25 n31_p_n25 0 2.91528e-16
c_32_p_n25 n32_p_n25 0 2.91622e-16
c_7_p_n25 n7_p_n25 0 2.91528e-16
c_8_p_n25 n8_p_n25 0 2.91528e-16
c_9_p_n25 n9_p_n25 0 2.91528e-16
cgnd_p_n25 0 0 2.48166e-15
cbl_0_p_n25 bl_0_p_n25 0 4.52661e-16
cbl_1_p_n25 bl_1_p_n25 0 4.52661e-16
cbl_2_p_n25 bl_2_p_n25 0 4.52661e-16
cbl_3_p_n25 bl_3_p_n25 0 4.52661e-16
crbl_0_p_n25 rbl_0_p_n25 0 9.14472e-16
crbl_1_p_n25 rbl_1_p_n25 0 9.14472e-16
crbl_2_p_n25 rbl_2_p_n25 0 9.14472e-16
crbl_3_p_n25 rbl_3_p_n25 0 9.17566e-16
crwl_0_p_n25 rwl_0_p_n25 0 5.19495e-16
crwl_1_p_n25 rwl_1_p_n25 0 5.11719e-16
crwl_2_p_n25 rwl_2_p_n25 0 5.11719e-16
crwl_3_p_n25 rwl_3_p_n25 0 5.19495e-16
cwl_0_p_n25 wl_0_p_n25 0 3.30388e-16
cwl_1_p_n25 wl_1_p_n25 0 3.30388e-16
cwl_2_p_n25 wl_2_p_n25 0 3.30388e-16
cwl_3_p_n25 wl_3_p_n25 0 3.30388e-16
ccc__10__9_p_n25 n10_p_n25 n9_p_n25 1.02e-17
ccc__10_bl_3_p_n25 n10_p_n25 bl_3_p_n25 1.3999e-17
ccc__10_rwl_0_p_n25 n10_p_n25 rwl_0_p_n25 4.335e-18
ccc__17__18_p_n25 n17_p_n25 n18_p_n25 1.02e-17
ccc__17_bl_0_p_n25 n17_p_n25 bl_0_p_n25 8.415e-18
ccc__17_rwl_1_p_n25 n17_p_n25 rwl_1_p_n25 1.3194e-17
ccc__18__19_p_n25 n18_p_n25 n19_p_n25 1.02e-17
ccc__18_bl_1_p_n25 n18_p_n25 bl_1_p_n25 8.415e-18
ccc__18_rwl_1_p_n25 n18_p_n25 rwl_1_p_n25 1.3194e-17
ccc__19__20_p_n25 n19_p_n25 n20_p_n25 1.02e-17
ccc__19_bl_2_p_n25 n19_p_n25 bl_2_p_n25 8.415e-18
ccc__19_rwl_1_p_n25 n19_p_n25 rwl_1_p_n25 1.3194e-17
ccc__20_bl_3_p_n25 n20_p_n25 bl_3_p_n25 8.415e-18
ccc__20_rwl_1_p_n25 n20_p_n25 rwl_1_p_n25 6.655e-18
ccc__22__23_p_n25 n22_p_n25 n23_p_n25 1.02e-17
ccc__22_bl_0_p_n25 n22_p_n25 bl_0_p_n25 8.415e-18
ccc__22_rwl_2_p_n25 n22_p_n25 rwl_2_p_n25 1.3194e-17
ccc__23__24_p_n25 n23_p_n25 n24_p_n25 1.02e-17
ccc__23_bl_1_p_n25 n23_p_n25 bl_1_p_n25 8.415e-18
ccc__23_rwl_2_p_n25 n23_p_n25 rwl_2_p_n25 1.3194e-17
ccc__24__25_p_n25 n24_p_n25 n25_p_n25 1.02e-17
ccc__24_bl_2_p_n25 n24_p_n25 bl_2_p_n25 8.415e-18
ccc__24_rwl_2_p_n25 n24_p_n25 rwl_2_p_n25 1.3194e-17
ccc__25_bl_3_p_n25 n25_p_n25 bl_3_p_n25 8.415e-18
ccc__25_rwl_2_p_n25 n25_p_n25 rwl_2_p_n25 6.655e-18
ccc__29__30_p_n25 n29_p_n25 n30_p_n25 1.02e-17
ccc__29_bl_0_p_n25 n29_p_n25 bl_0_p_n25 8.415e-18
ccc__29_rwl_3_p_n25 n29_p_n25 rwl_3_p_n25 1.3194e-17
ccc__30__31_p_n25 n30_p_n25 n31_p_n25 1.02e-17
ccc__30_bl_1_p_n25 n30_p_n25 bl_1_p_n25 8.415e-18
ccc__30_rwl_3_p_n25 n30_p_n25 rwl_3_p_n25 1.3194e-17
ccc__31__32_p_n25 n31_p_n25 n32_p_n25 1.02e-17
ccc__31_bl_2_p_n25 n31_p_n25 bl_2_p_n25 8.415e-18
ccc__31_rwl_3_p_n25 n31_p_n25 rwl_3_p_n25 1.3194e-17
ccc__32_bl_3_p_n25 n32_p_n25 bl_3_p_n25 8.415e-18
ccc__32_rwl_3_p_n25 n32_p_n25 rwl_3_p_n25 6.655e-18
ccc__7__8_p_n25 n7_p_n25 n8_p_n25 1.02e-17
ccc__7_bl_0_p_n25 n7_p_n25 bl_0_p_n25 1.3999e-17
ccc__7_rwl_0_p_n25 n7_p_n25 rwl_0_p_n25 8.961e-18
ccc__8__9_p_n25 n8_p_n25 n9_p_n25 1.02e-17
ccc__8_bl_1_p_n25 n8_p_n25 bl_1_p_n25 1.3999e-17
ccc__8_rwl_0_p_n25 n8_p_n25 rwl_0_p_n25 8.961e-18
ccc__9_bl_2_p_n25 n9_p_n25 bl_2_p_n25 1.3999e-17
ccc__9_rwl_0_p_n25 n9_p_n25 rwl_0_p_n25 8.961e-18
ccc_bl_0_rbl_0_p_n25 bl_0_p_n25 rbl_0_p_n25 1.88693e-16
ccc_bl_0_rwl_1_p_n25 bl_0_p_n25 rwl_1_p_n25 1.0093e-17
ccc_bl_0_rwl_2_p_n25 bl_0_p_n25 rwl_2_p_n25 1.0093e-17
ccc_bl_1_rbl_0_p_n25 bl_1_p_n25 rbl_0_p_n25 1.633e-16
ccc_bl_1_rbl_1_p_n25 bl_1_p_n25 rbl_1_p_n25 1.88693e-16
ccc_bl_1_rwl_1_p_n25 bl_1_p_n25 rwl_1_p_n25 1.0093e-17
ccc_bl_1_rwl_2_p_n25 bl_1_p_n25 rwl_2_p_n25 1.0093e-17
ccc_bl_2_rbl_1_p_n25 bl_2_p_n25 rbl_1_p_n25 1.633e-16
ccc_bl_2_rbl_2_p_n25 bl_2_p_n25 rbl_2_p_n25 1.88693e-16
ccc_bl_2_rwl_1_p_n25 bl_2_p_n25 rwl_1_p_n25 1.0093e-17
ccc_bl_2_rwl_2_p_n25 bl_2_p_n25 rwl_2_p_n25 1.0093e-17
ccc_bl_3_rbl_2_p_n25 bl_3_p_n25 rbl_2_p_n25 1.633e-16
ccc_bl_3_rbl_3_p_n25 bl_3_p_n25 rbl_3_p_n25 1.88693e-16
ccc_bl_3_rwl_1_p_n25 bl_3_p_n25 rwl_1_p_n25 1.0093e-17
ccc_bl_3_rwl_2_p_n25 bl_3_p_n25 rwl_2_p_n25 1.0093e-17
ccc_rbl_0_rbl_1_p_n25 rbl_0_p_n25 rbl_1_p_n25 3.432e-17
ccc_rbl_0_rwl_0_p_n25 rbl_0_p_n25 rwl_0_p_n25 4.9752e-17
ccc_rbl_0_rwl_1_p_n25 rbl_0_p_n25 rwl_1_p_n25 4.9752e-17
ccc_rbl_0_rwl_2_p_n25 rbl_0_p_n25 rwl_2_p_n25 4.9752e-17
ccc_rbl_0_rwl_3_p_n25 rbl_0_p_n25 rwl_3_p_n25 4.9752e-17
ccc_rbl_1_rbl_2_p_n25 rbl_1_p_n25 rbl_2_p_n25 3.432e-17
ccc_rbl_1_rwl_0_p_n25 rbl_1_p_n25 rwl_0_p_n25 4.9752e-17
ccc_rbl_1_rwl_1_p_n25 rbl_1_p_n25 rwl_1_p_n25 4.9752e-17
ccc_rbl_1_rwl_2_p_n25 rbl_1_p_n25 rwl_2_p_n25 4.9752e-17
ccc_rbl_1_rwl_3_p_n25 rbl_1_p_n25 rwl_3_p_n25 4.9752e-17
ccc_rbl_2_rbl_3_p_n25 rbl_2_p_n25 rbl_3_p_n25 3.432e-17
ccc_rbl_2_rwl_0_p_n25 rbl_2_p_n25 rwl_0_p_n25 4.9752e-17
ccc_rbl_2_rwl_1_p_n25 rbl_2_p_n25 rwl_1_p_n25 4.9752e-17
ccc_rbl_2_rwl_2_p_n25 rbl_2_p_n25 rwl_2_p_n25 4.9752e-17
ccc_rbl_2_rwl_3_p_n25 rbl_2_p_n25 rwl_3_p_n25 4.9752e-17
ccc_rbl_3_rwl_0_p_n25 rbl_3_p_n25 rwl_0_p_n25 3.3407e-17
ccc_rbl_3_rwl_1_p_n25 rbl_3_p_n25 rwl_1_p_n25 3.3407e-17
ccc_rbl_3_rwl_2_p_n25 rbl_3_p_n25 rwl_2_p_n25 3.3407e-17
ccc_rbl_3_rwl_3_p_n25 rbl_3_p_n25 rwl_3_p_n25 3.3407e-17
vdw_p_n25_0 wl_0_p_n25 0 dc 0
vdr_p_n25_0 rwl_0_p_n25 vdd dc 0
vdw_p_n25_1 wl_1_p_n25 0 dc 0
vdr_p_n25_1 rwl_1_p_n25 vdd dc 0
vdw_p_n25_2 wl_2_p_n25 0 dc 0
vdr_p_n25_2 rwl_2_p_n25 vdd dc 0
vdw_p_n25_3 wl_3_p_n25 0 dc 0
vdr_p_n25_3 rwl_3_p_n25 vdd dc 0
vdb_p_n25_0 bl_0_p_n25 0 dc 0
vdp_p_n25_0 rbl_0_p_n25 vrbl dc 0
vdb_p_n25_1 bl_1_p_n25 0 dc 0
vdp_p_n25_1 rbl_1_p_n25 vrbl dc 0
vdb_p_n25_2 bl_2_p_n25 0 dc 0
vdp_p_n25_2 rbl_2_p_n25 vrbl dc 0
vdb_p_n25_3 bl_3_p_n25 0 dc 0
vdp_p_n25_3 rbl_3_p_n25 vrbl dc 0
vdn_p_n25_n7 n7_p_n25 0 dc 1
vdn_p_n25_n8 n8_p_n25 0 dc 1
vdn_p_n25_n9 n9_p_n25 0 dc 1
vdn_p_n25_n10 n10_p_n25 0 dc 1
vdn_p_n25_n17 n17_p_n25 0 dc 1
vdn_p_n25_n18 n18_p_n25 0 dc 1
vdn_p_n25_n19 n19_p_n25 0 dc 1
vdn_p_n25_n20 n20_p_n25 0 dc 1
vdn_p_n25_n22 n22_p_n25 0 dc 1
vdn_p_n25_n23 n23_p_n25 0 dc 1
vdn_p_n25_n24 n24_p_n25 0 dc 1
vdn_p_n25_n29 n29_p_n25 0 dc 1
vdn_p_n25_n30 n30_p_n25 0 dc 1
vdn_p_n25_n31 n31_p_n25 0 dc 1
vdn_p_n25_n32 n32_p_n25 0 dc 1
bdr_p_n25 n25_p_n25 0 i=5e-08*min(1,max(0,(time-1e-09)/0.2n))*0.5*(1+tanh((v(n25_p_n25)-0.05)/0.01))

* ---- instance p_n29: variant p, probed storage node \$29 ----
xm1_p_n29 rwl_0__t2_p_n29 n7__t0_p_n29 rbl_0__t0_p_n29 gnd__t0_p_n29 sky130_fd_pr__nfet_01v8 L=0.15 W=0.42 nf=1 ad=0.1197 as=0.1197 pd=1.41 ps=1.41 mult=1 m=1
xm2_p_n29 rwl_0__t3_p_n29 n8__t1_p_n29 rbl_1__t1_p_n29 gnd__t1_p_n29 sky130_fd_pr__nfet_01v8 L=0.15 W=0.42 nf=1 ad=0.1197 as=0.1197 pd=1.41 ps=1.41 mult=1 m=1
xm3_p_n29 rwl_0__t1_p_n29 n9__t1_p_n29 rbl_2__t1_p_n29 gnd__t2_p_n29 sky130_fd_pr__nfet_01v8 L=0.15 W=0.42 nf=1 ad=0.1197 as=0.1197 pd=1.41 ps=1.41 mult=1 m=1
xm4_p_n29 rwl_0__t0_p_n29 n10__t1_p_n29 rbl_3__t1_p_n29 gnd__t3_p_n29 sky130_fd_pr__nfet_01v8 L=0.15 W=0.42 nf=1 ad=0.1197 as=0.1197 pd=1.41 ps=1.41 mult=1 m=1
xm5_p_n29 bl_0__t0_p_n29 wl_0__t0_p_n29 n7__t1_p_n29 gnd__t8_p_n29 sky130_fd_pr__nfet_01v8 L=0.15 W=0.42 nf=1 ad=0.0588 as=0.1197 pd=0.7 ps=1.41 mult=1 m=1
xm6_p_n29 n17__t0_p_n29 wl_1__t0_p_n29 bl_0__t1_p_n29 gnd__t20_p_n29 sky130_fd_pr__nfet_01v8 L=0.15 W=0.42 nf=1 ad=0.1197 as=0.0588 pd=1.41 ps=0.7 mult=1 m=1
xm7_p_n29 bl_1__t2_p_n29 wl_0__t3_p_n29 n8__t0_p_n29 gnd__t9_p_n29 sky130_fd_pr__nfet_01v8 L=0.15 W=0.42 nf=1 ad=0.0588 as=0.1197 pd=0.7 ps=1.41 mult=1 m=1
xm8_p_n29 n18__t0_p_n29 wl_1__t1_p_n29 bl_1__t0_p_n29 gnd__t21_p_n29 sky130_fd_pr__nfet_01v8 L=0.15 W=0.42 nf=1 ad=0.1197 as=0.0588 pd=1.41 ps=0.7 mult=1 m=1
xm9_p_n29 bl_2__t2_p_n29 wl_0__t2_p_n29 n9__t0_p_n29 gnd__t10_p_n29 sky130_fd_pr__nfet_01v8 L=0.15 W=0.42 nf=1 ad=0.0588 as=0.1197 pd=0.7 ps=1.41 mult=1 m=1
xm10_p_n29 n19__t0_p_n29 wl_1__t2_p_n29 bl_2__t0_p_n29 gnd__t22_p_n29 sky130_fd_pr__nfet_01v8 L=0.15 W=0.42 nf=1 ad=0.1197 as=0.0588 pd=1.41 ps=0.7 mult=1 m=1
xm11_p_n29 bl_3__t2_p_n29 wl_0__t1_p_n29 n10__t0_p_n29 gnd__t11_p_n29 sky130_fd_pr__nfet_01v8 L=0.15 W=0.42 nf=1 ad=0.0588 as=0.1197 pd=0.7 ps=1.41 mult=1 m=1
xm12_p_n29 n20__t0_p_n29 wl_1__t3_p_n29 bl_3__t1_p_n29 gnd__t23_p_n29 sky130_fd_pr__nfet_01v8 L=0.15 W=0.42 nf=1 ad=0.1197 as=0.0588 pd=1.41 ps=0.7 mult=1 m=1
xm13_p_n29 rbl_0__t3_p_n29 n17__t1_p_n29 rwl_1__t0_p_n29 gnd__t12_p_n29 sky130_fd_pr__nfet_01v8 L=0.15 W=0.42 nf=1 ad=0.0588 as=0.1197 pd=0.7 ps=1.41 mult=1 m=1
xm14_p_n29 rwl_2__t3_p_n29 n22__t0_p_n29 rbl_0__t2_p_n29 gnd__t24_p_n29 sky130_fd_pr__nfet_01v8 L=0.15 W=0.42 nf=1 ad=0.1197 as=0.0588 pd=1.41 ps=0.7 mult=1 m=1
xm15_p_n29 rbl_1__t3_p_n29 n18__t1_p_n29 rwl_1__t1_p_n29 gnd__t13_p_n29 sky130_fd_pr__nfet_01v8 L=0.15 W=0.42 nf=1 ad=0.0588 as=0.1197 pd=0.7 ps=1.41 mult=1 m=1
xm16_p_n29 rwl_2__t0_p_n29 n23__t0_p_n29 rbl_1__t2_p_n29 gnd__t25_p_n29 sky130_fd_pr__nfet_01v8 L=0.15 W=0.42 nf=1 ad=0.1197 as=0.0588 pd=1.41 ps=0.7 mult=1 m=1
xm17_p_n29 rbl_2__t3_p_n29 n19__t1_p_n29 rwl_1__t2_p_n29 gnd__t14_p_n29 sky130_fd_pr__nfet_01v8 L=0.15 W=0.42 nf=1 ad=0.0588 as=0.1197 pd=0.7 ps=1.41 mult=1 m=1
xm18_p_n29 rwl_2__t1_p_n29 n24__t0_p_n29 rbl_2__t2_p_n29 gnd__t26_p_n29 sky130_fd_pr__nfet_01v8 L=0.15 W=0.42 nf=1 ad=0.1197 as=0.0588 pd=1.41 ps=0.7 mult=1 m=1
xm19_p_n29 rbl_3__t3_p_n29 n20__t1_p_n29 rwl_1__t3_p_n29 gnd__t15_p_n29 sky130_fd_pr__nfet_01v8 L=0.15 W=0.42 nf=1 ad=0.0588 as=0.1197 pd=0.7 ps=1.41 mult=1 m=1
xm20_p_n29 rwl_2__t2_p_n29 n25__t0_p_n29 rbl_3__t2_p_n29 gnd__t27_p_n29 sky130_fd_pr__nfet_01v8 L=0.15 W=0.42 nf=1 ad=0.1197 as=0.0588 pd=1.41 ps=0.7 mult=1 m=1
xm21_p_n29 bl_0__t3_p_n29 wl_2__t0_p_n29 n22__t1_p_n29 gnd__t16_p_n29 sky130_fd_pr__nfet_01v8 L=0.15 W=0.42 nf=1 ad=0.0588 as=0.1197 pd=0.7 ps=1.41 mult=1 m=1
xm22_p_n29 n29__t0_p_n29 wl_3__t3_p_n29 bl_0__t2_p_n29 gnd__t28_p_n29 sky130_fd_pr__nfet_01v8 L=0.15 W=0.42 nf=1 ad=0.1197 as=0.0588 pd=1.41 ps=0.7 mult=1 m=1
xm23_p_n29 bl_1__t3_p_n29 wl_2__t1_p_n29 n23__t1_p_n29 gnd__t17_p_n29 sky130_fd_pr__nfet_01v8 L=0.15 W=0.42 nf=1 ad=0.0588 as=0.1197 pd=0.7 ps=1.41 mult=1 m=1
xm24_p_n29 n30__t0_p_n29 wl_3__t2_p_n29 bl_1__t1_p_n29 gnd__t29_p_n29 sky130_fd_pr__nfet_01v8 L=0.15 W=0.42 nf=1 ad=0.1197 as=0.0588 pd=1.41 ps=0.7 mult=1 m=1
xm25_p_n29 bl_2__t3_p_n29 wl_2__t2_p_n29 n24__t1_p_n29 gnd__t18_p_n29 sky130_fd_pr__nfet_01v8 L=0.15 W=0.42 nf=1 ad=0.0588 as=0.1197 pd=0.7 ps=1.41 mult=1 m=1
xm26_p_n29 n31__t0_p_n29 wl_3__t1_p_n29 bl_2__t1_p_n29 gnd__t30_p_n29 sky130_fd_pr__nfet_01v8 L=0.15 W=0.42 nf=1 ad=0.1197 as=0.0588 pd=1.41 ps=0.7 mult=1 m=1
xm27_p_n29 bl_3__t3_p_n29 wl_2__t3_p_n29 n25__t1_p_n29 gnd__t19_p_n29 sky130_fd_pr__nfet_01v8 L=0.15 W=0.42 nf=1 ad=0.0588 as=0.1197 pd=0.7 ps=1.41 mult=1 m=1
xm28_p_n29 n32__t0_p_n29 wl_3__t0_p_n29 bl_3__t0_p_n29 gnd__t31_p_n29 sky130_fd_pr__nfet_01v8 L=0.15 W=0.42 nf=1 ad=0.1197 as=0.0588 pd=1.41 ps=0.7 mult=1 m=1
xm29_p_n29 rbl_0__t1_p_n29 n29__t1_p_n29 rwl_3__t0_p_n29 gnd__t4_p_n29 sky130_fd_pr__nfet_01v8 L=0.15 W=0.42 nf=1 ad=0.1197 as=0.1197 pd=1.41 ps=1.41 mult=1 m=1
xm30_p_n29 rbl_1__t0_p_n29 n30__t1_p_n29 rwl_3__t1_p_n29 gnd__t5_p_n29 sky130_fd_pr__nfet_01v8 L=0.15 W=0.42 nf=1 ad=0.1197 as=0.1197 pd=1.41 ps=1.41 mult=1 m=1
xm31_p_n29 rbl_2__t0_p_n29 n31__t1_p_n29 rwl_3__t2_p_n29 gnd__t6_p_n29 sky130_fd_pr__nfet_01v8 L=0.15 W=0.42 nf=1 ad=0.1197 as=0.1197 pd=1.41 ps=1.41 mult=1 m=1
xm32_p_n29 rbl_3__t0_p_n29 n32__t1_p_n29 rwl_3__t3_p_n29 gnd__t7_p_n29 sky130_fd_pr__nfet_01v8 L=0.15 W=0.42 nf=1 ad=0.1197 as=0.1197 pd=1.41 ps=1.41 mult=1 m=1
r_10_t0_p_n29 n10__t0_p_n29 n10_p_n29 183.071
r_10_t1_p_n29 n10__t1_p_n29 n10_p_n29 183.071
r_17_t0_p_n29 n17__t0_p_n29 n17_p_n29 183.071
r_17_t1_p_n29 n17__t1_p_n29 n17_p_n29 183.071
r_18_t0_p_n29 n18__t0_p_n29 n18_p_n29 183.071
r_18_t1_p_n29 n18__t1_p_n29 n18_p_n29 183.071
r_19_t0_p_n29 n19__t0_p_n29 n19_p_n29 183.071
r_19_t1_p_n29 n19__t1_p_n29 n19_p_n29 183.071
r_20_t0_p_n29 n20__t0_p_n29 n20_p_n29 183.071
r_20_t1_p_n29 n20__t1_p_n29 n20_p_n29 183.071
r_22_t0_p_n29 n22__t0_p_n29 n22_p_n29 183.071
r_22_t1_p_n29 n22__t1_p_n29 n22_p_n29 183.071
r_23_t0_p_n29 n23__t0_p_n29 n23_p_n29 183.071
r_23_t1_p_n29 n23__t1_p_n29 n23_p_n29 183.071
r_24_t0_p_n29 n24__t0_p_n29 n24_p_n29 183.071
r_24_t1_p_n29 n24__t1_p_n29 n24_p_n29 183.071
r_25_t0_p_n29 n25__t0_p_n29 n25_p_n29 183.071
r_25_t1_p_n29 n25__t1_p_n29 n25_p_n29 183.071
r_29_t0_p_n29 n29__t0_p_n29 n29_p_n29 183.071
r_29_t1_p_n29 n29__t1_p_n29 n29_p_n29 183.071
r_30_t0_p_n29 n30__t0_p_n29 n30_p_n29 183.071
r_30_t1_p_n29 n30__t1_p_n29 n30_p_n29 183.071
r_31_t0_p_n29 n31__t0_p_n29 n31_p_n29 183.071
r_31_t1_p_n29 n31__t1_p_n29 n31_p_n29 183.071
r_32_t0_p_n29 n32__t0_p_n29 n32_p_n29 183.071
r_32_t1_p_n29 n32__t1_p_n29 n32_p_n29 183.071
r_7_t0_p_n29 n7__t0_p_n29 n7_p_n29 183.071
r_7_t1_p_n29 n7__t1_p_n29 n7_p_n29 183.071
r_8_t0_p_n29 n8__t0_p_n29 n8_p_n29 183.071
r_8_t1_p_n29 n8__t1_p_n29 n8_p_n29 183.071
r_9_t0_p_n29 n9__t0_p_n29 n9_p_n29 183.071
r_9_t1_p_n29 n9__t1_p_n29 n9_p_n29 183.071
rgnd_t0_p_n29 gnd__t0_p_n29 0 38.2988
rgnd_t1_p_n29 gnd__t1_p_n29 0 33.9576
rgnd_t2_p_n29 gnd__t2_p_n29 0 33.9576
rgnd_t3_p_n29 gnd__t3_p_n29 0 38.2988
rgnd_t4_p_n29 gnd__t4_p_n29 0 38.2988
rgnd_t5_p_n29 gnd__t5_p_n29 0 33.9576
rgnd_t6_p_n29 gnd__t6_p_n29 0 33.9576
rgnd_t7_p_n29 gnd__t7_p_n29 0 38.2988
rgnd_t8_p_n29 gnd__t8_p_n29 0 28.0185
rgnd_t9_p_n29 gnd__t9_p_n29 0 21.7106
rgnd_t10_p_n29 gnd__t10_p_n29 0 21.7106
rgnd_t11_p_n29 gnd__t11_p_n29 0 28.0185
rgnd_t12_p_n29 gnd__t12_p_n29 0 18.9833
rgnd_t13_p_n29 gnd__t13_p_n29 0 6.8325
rgnd_t14_p_n29 gnd__t14_p_n29 0 6.8325
rgnd_t15_p_n29 gnd__t15_p_n29 0 18.9833
rgnd_t16_p_n29 gnd__t16_p_n29 0 24.2409
rgnd_t17_p_n29 gnd__t17_p_n29 0 16.5511
rgnd_t18_p_n29 gnd__t18_p_n29 0 16.5511
rgnd_t19_p_n29 gnd__t19_p_n29 0 24.2409
rgnd_t20_p_n29 gnd__t20_p_n29 0 24.2409
rgnd_t21_p_n29 gnd__t21_p_n29 0 16.5511
rgnd_t22_p_n29 gnd__t22_p_n29 0 16.5511
rgnd_t23_p_n29 gnd__t23_p_n29 0 24.2409
rgnd_t24_p_n29 gnd__t24_p_n29 0 18.9833
rgnd_t25_p_n29 gnd__t25_p_n29 0 6.8325
rgnd_t26_p_n29 gnd__t26_p_n29 0 6.8325
rgnd_t27_p_n29 gnd__t27_p_n29 0 18.9833
rgnd_t28_p_n29 gnd__t28_p_n29 0 28.0185
rgnd_t29_p_n29 gnd__t29_p_n29 0 21.7106
rgnd_t30_p_n29 gnd__t30_p_n29 0 21.7106
rgnd_t31_p_n29 gnd__t31_p_n29 0 28.0185
rbl_0_t0_p_n29 bl_0__t0_p_n29 bl_0_p_n29 14.8304
rbl_0_t1_p_n29 bl_0__t1_p_n29 bl_0_p_n29 10.9301
rbl_0_t2_p_n29 bl_0__t2_p_n29 bl_0_p_n29 14.8304
rbl_0_t3_p_n29 bl_0__t3_p_n29 bl_0_p_n29 10.9301
rbl_1_t0_p_n29 bl_1__t0_p_n29 bl_1_p_n29 10.9301
rbl_1_t1_p_n29 bl_1__t1_p_n29 bl_1_p_n29 14.8304
rbl_1_t2_p_n29 bl_1__t2_p_n29 bl_1_p_n29 14.8304
rbl_1_t3_p_n29 bl_1__t3_p_n29 bl_1_p_n29 10.9301
rbl_2_t0_p_n29 bl_2__t0_p_n29 bl_2_p_n29 10.9301
rbl_2_t1_p_n29 bl_2__t1_p_n29 bl_2_p_n29 14.8304
rbl_2_t2_p_n29 bl_2__t2_p_n29 bl_2_p_n29 14.8304
rbl_2_t3_p_n29 bl_2__t3_p_n29 bl_2_p_n29 10.9301
rbl_3_t0_p_n29 bl_3__t0_p_n29 bl_3_p_n29 14.8304
rbl_3_t1_p_n29 bl_3__t1_p_n29 bl_3_p_n29 10.9301
rbl_3_t2_p_n29 bl_3__t2_p_n29 bl_3_p_n29 14.8304
rbl_3_t3_p_n29 bl_3__t3_p_n29 bl_3_p_n29 10.9301
rrbl_0_t0_p_n29 rbl_0__t0_p_n29 rbl_0_p_n29 36.5601
rrbl_0_t1_p_n29 rbl_0__t1_p_n29 rbl_0_p_n29 36.5601
rrbl_0_t2_p_n29 rbl_0__t2_p_n29 rbl_0_p_n29 2.99444
rrbl_0_t3_p_n29 rbl_0__t3_p_n29 rbl_0_p_n29 2.99444
rrbl_1_t0_p_n29 rbl_1__t0_p_n29 rbl_1_p_n29 36.5601
rrbl_1_t1_p_n29 rbl_1__t1_p_n29 rbl_1_p_n29 36.5601
rrbl_1_t2_p_n29 rbl_1__t2_p_n29 rbl_1_p_n29 2.99444
rrbl_1_t3_p_n29 rbl_1__t3_p_n29 rbl_1_p_n29 2.99444
rrbl_2_t0_p_n29 rbl_2__t0_p_n29 rbl_2_p_n29 36.5601
rrbl_2_t1_p_n29 rbl_2__t1_p_n29 rbl_2_p_n29 36.5601
rrbl_2_t2_p_n29 rbl_2__t2_p_n29 rbl_2_p_n29 2.99444
rrbl_2_t3_p_n29 rbl_2__t3_p_n29 rbl_2_p_n29 2.99444
rrbl_3_t0_p_n29 rbl_3__t0_p_n29 rbl_3_p_n29 36.5601
rrbl_3_t1_p_n29 rbl_3__t1_p_n29 rbl_3_p_n29 36.5601
rrbl_3_t2_p_n29 rbl_3__t2_p_n29 rbl_3_p_n29 2.99444
rrbl_3_t3_p_n29 rbl_3__t3_p_n29 rbl_3_p_n29 2.99444
rrwl_0_t0_p_n29 rwl_0__t0_p_n29 rwl_0_p_n29 38.2618
rrwl_0_t1_p_n29 rwl_0__t1_p_n29 rwl_0_p_n29 12.7539
rrwl_0_t2_p_n29 rwl_0__t2_p_n29 rwl_0_p_n29 38.2618
rrwl_0_t3_p_n29 rwl_0__t3_p_n29 rwl_0_p_n29 12.7539
rrwl_1_t0_p_n29 rwl_1__t0_p_n29 rwl_1_p_n29 38.2618
rrwl_1_t1_p_n29 rwl_1__t1_p_n29 rwl_1_p_n29 12.7539
rrwl_1_t2_p_n29 rwl_1__t2_p_n29 rwl_1_p_n29 12.7539
rrwl_1_t3_p_n29 rwl_1__t3_p_n29 rwl_1_p_n29 38.2618
rrwl_2_t0_p_n29 rwl_2__t0_p_n29 rwl_2_p_n29 12.7539
rrwl_2_t1_p_n29 rwl_2__t1_p_n29 rwl_2_p_n29 12.7539
rrwl_2_t2_p_n29 rwl_2__t2_p_n29 rwl_2_p_n29 38.2618
rrwl_2_t3_p_n29 rwl_2__t3_p_n29 rwl_2_p_n29 38.2618
rrwl_3_t0_p_n29 rwl_3__t0_p_n29 rwl_3_p_n29 38.2618
rrwl_3_t1_p_n29 rwl_3__t1_p_n29 rwl_3_p_n29 12.7539
rrwl_3_t2_p_n29 rwl_3__t2_p_n29 rwl_3_p_n29 12.7539
rrwl_3_t3_p_n29 rwl_3__t3_p_n29 rwl_3_p_n29 38.2618
rwl_0_t0_p_n29 wl_0__t0_p_n29 wl_0_p_n29 245.959
rwl_0_t1_p_n29 wl_0__t1_p_n29 wl_0_p_n29 245.959
rwl_0_t2_p_n29 wl_0__t2_p_n29 wl_0_p_n29 81.9864
rwl_0_t3_p_n29 wl_0__t3_p_n29 wl_0_p_n29 81.9864
rwl_1_t0_p_n29 wl_1__t0_p_n29 wl_1_p_n29 245.959
rwl_1_t1_p_n29 wl_1__t1_p_n29 wl_1_p_n29 81.9864
rwl_1_t2_p_n29 wl_1__t2_p_n29 wl_1_p_n29 81.9864
rwl_1_t3_p_n29 wl_1__t3_p_n29 wl_1_p_n29 245.959
rwl_2_t0_p_n29 wl_2__t0_p_n29 wl_2_p_n29 245.959
rwl_2_t1_p_n29 wl_2__t1_p_n29 wl_2_p_n29 81.9864
rwl_2_t2_p_n29 wl_2__t2_p_n29 wl_2_p_n29 81.9864
rwl_2_t3_p_n29 wl_2__t3_p_n29 wl_2_p_n29 245.959
rwl_3_t0_p_n29 wl_3__t0_p_n29 wl_3_p_n29 245.959
rwl_3_t1_p_n29 wl_3__t1_p_n29 wl_3_p_n29 81.9864
rwl_3_t2_p_n29 wl_3__t2_p_n29 wl_3_p_n29 81.9864
rwl_3_t3_p_n29 wl_3__t3_p_n29 wl_3_p_n29 245.959
c_10_p_n29 n10_p_n29 0 2.91622e-16
c_17_p_n29 n17_p_n29 0 2.91528e-16
c_18_p_n29 n18_p_n29 0 2.91528e-16
c_19_p_n29 n19_p_n29 0 2.91528e-16
c_20_p_n29 n20_p_n29 0 2.91622e-16
c_22_p_n29 n22_p_n29 0 2.91528e-16
c_23_p_n29 n23_p_n29 0 2.91528e-16
c_24_p_n29 n24_p_n29 0 2.91528e-16
c_25_p_n29 n25_p_n29 0 2.91622e-16
c_29_p_n29 n29_p_n29 0 1.1371e-16
c_30_p_n29 n30_p_n29 0 2.91528e-16
c_31_p_n29 n31_p_n29 0 2.91528e-16
c_32_p_n29 n32_p_n29 0 2.91622e-16
c_7_p_n29 n7_p_n29 0 2.91528e-16
c_8_p_n29 n8_p_n29 0 2.91528e-16
c_9_p_n29 n9_p_n29 0 2.91528e-16
cgnd_p_n29 0 0 2.48166e-15
cbl_0_p_n29 bl_0_p_n29 0 4.52661e-16
cbl_1_p_n29 bl_1_p_n29 0 4.52661e-16
cbl_2_p_n29 bl_2_p_n29 0 4.52661e-16
cbl_3_p_n29 bl_3_p_n29 0 4.52661e-16
crbl_0_p_n29 rbl_0_p_n29 0 9.14472e-16
crbl_1_p_n29 rbl_1_p_n29 0 9.14472e-16
crbl_2_p_n29 rbl_2_p_n29 0 9.14472e-16
crbl_3_p_n29 rbl_3_p_n29 0 9.17566e-16
crwl_0_p_n29 rwl_0_p_n29 0 5.19495e-16
crwl_1_p_n29 rwl_1_p_n29 0 5.11719e-16
crwl_2_p_n29 rwl_2_p_n29 0 5.11719e-16
crwl_3_p_n29 rwl_3_p_n29 0 5.19495e-16
cwl_0_p_n29 wl_0_p_n29 0 3.30388e-16
cwl_1_p_n29 wl_1_p_n29 0 3.30388e-16
cwl_2_p_n29 wl_2_p_n29 0 3.30388e-16
cwl_3_p_n29 wl_3_p_n29 0 3.30388e-16
ccc__10__9_p_n29 n10_p_n29 n9_p_n29 1.02e-17
ccc__10_bl_3_p_n29 n10_p_n29 bl_3_p_n29 1.3999e-17
ccc__10_rwl_0_p_n29 n10_p_n29 rwl_0_p_n29 4.335e-18
ccc__17__18_p_n29 n17_p_n29 n18_p_n29 1.02e-17
ccc__17_bl_0_p_n29 n17_p_n29 bl_0_p_n29 8.415e-18
ccc__17_rwl_1_p_n29 n17_p_n29 rwl_1_p_n29 1.3194e-17
ccc__18__19_p_n29 n18_p_n29 n19_p_n29 1.02e-17
ccc__18_bl_1_p_n29 n18_p_n29 bl_1_p_n29 8.415e-18
ccc__18_rwl_1_p_n29 n18_p_n29 rwl_1_p_n29 1.3194e-17
ccc__19__20_p_n29 n19_p_n29 n20_p_n29 1.02e-17
ccc__19_bl_2_p_n29 n19_p_n29 bl_2_p_n29 8.415e-18
ccc__19_rwl_1_p_n29 n19_p_n29 rwl_1_p_n29 1.3194e-17
ccc__20_bl_3_p_n29 n20_p_n29 bl_3_p_n29 8.415e-18
ccc__20_rwl_1_p_n29 n20_p_n29 rwl_1_p_n29 6.655e-18
ccc__22__23_p_n29 n22_p_n29 n23_p_n29 1.02e-17
ccc__22_bl_0_p_n29 n22_p_n29 bl_0_p_n29 8.415e-18
ccc__22_rwl_2_p_n29 n22_p_n29 rwl_2_p_n29 1.3194e-17
ccc__23__24_p_n29 n23_p_n29 n24_p_n29 1.02e-17
ccc__23_bl_1_p_n29 n23_p_n29 bl_1_p_n29 8.415e-18
ccc__23_rwl_2_p_n29 n23_p_n29 rwl_2_p_n29 1.3194e-17
ccc__24__25_p_n29 n24_p_n29 n25_p_n29 1.02e-17
ccc__24_bl_2_p_n29 n24_p_n29 bl_2_p_n29 8.415e-18
ccc__24_rwl_2_p_n29 n24_p_n29 rwl_2_p_n29 1.3194e-17
ccc__25_bl_3_p_n29 n25_p_n29 bl_3_p_n29 8.415e-18
ccc__25_rwl_2_p_n29 n25_p_n29 rwl_2_p_n29 6.655e-18
ccc__29__30_p_n29 n29_p_n29 n30_p_n29 1.02e-17
ccc__29_bl_0_p_n29 n29_p_n29 bl_0_p_n29 8.415e-18
ccc__29_rwl_3_p_n29 n29_p_n29 rwl_3_p_n29 1.3194e-17
ccc__30__31_p_n29 n30_p_n29 n31_p_n29 1.02e-17
ccc__30_bl_1_p_n29 n30_p_n29 bl_1_p_n29 8.415e-18
ccc__30_rwl_3_p_n29 n30_p_n29 rwl_3_p_n29 1.3194e-17
ccc__31__32_p_n29 n31_p_n29 n32_p_n29 1.02e-17
ccc__31_bl_2_p_n29 n31_p_n29 bl_2_p_n29 8.415e-18
ccc__31_rwl_3_p_n29 n31_p_n29 rwl_3_p_n29 1.3194e-17
ccc__32_bl_3_p_n29 n32_p_n29 bl_3_p_n29 8.415e-18
ccc__32_rwl_3_p_n29 n32_p_n29 rwl_3_p_n29 6.655e-18
ccc__7__8_p_n29 n7_p_n29 n8_p_n29 1.02e-17
ccc__7_bl_0_p_n29 n7_p_n29 bl_0_p_n29 1.3999e-17
ccc__7_rwl_0_p_n29 n7_p_n29 rwl_0_p_n29 8.961e-18
ccc__8__9_p_n29 n8_p_n29 n9_p_n29 1.02e-17
ccc__8_bl_1_p_n29 n8_p_n29 bl_1_p_n29 1.3999e-17
ccc__8_rwl_0_p_n29 n8_p_n29 rwl_0_p_n29 8.961e-18
ccc__9_bl_2_p_n29 n9_p_n29 bl_2_p_n29 1.3999e-17
ccc__9_rwl_0_p_n29 n9_p_n29 rwl_0_p_n29 8.961e-18
ccc_bl_0_rbl_0_p_n29 bl_0_p_n29 rbl_0_p_n29 1.88693e-16
ccc_bl_0_rwl_1_p_n29 bl_0_p_n29 rwl_1_p_n29 1.0093e-17
ccc_bl_0_rwl_2_p_n29 bl_0_p_n29 rwl_2_p_n29 1.0093e-17
ccc_bl_1_rbl_0_p_n29 bl_1_p_n29 rbl_0_p_n29 1.633e-16
ccc_bl_1_rbl_1_p_n29 bl_1_p_n29 rbl_1_p_n29 1.88693e-16
ccc_bl_1_rwl_1_p_n29 bl_1_p_n29 rwl_1_p_n29 1.0093e-17
ccc_bl_1_rwl_2_p_n29 bl_1_p_n29 rwl_2_p_n29 1.0093e-17
ccc_bl_2_rbl_1_p_n29 bl_2_p_n29 rbl_1_p_n29 1.633e-16
ccc_bl_2_rbl_2_p_n29 bl_2_p_n29 rbl_2_p_n29 1.88693e-16
ccc_bl_2_rwl_1_p_n29 bl_2_p_n29 rwl_1_p_n29 1.0093e-17
ccc_bl_2_rwl_2_p_n29 bl_2_p_n29 rwl_2_p_n29 1.0093e-17
ccc_bl_3_rbl_2_p_n29 bl_3_p_n29 rbl_2_p_n29 1.633e-16
ccc_bl_3_rbl_3_p_n29 bl_3_p_n29 rbl_3_p_n29 1.88693e-16
ccc_bl_3_rwl_1_p_n29 bl_3_p_n29 rwl_1_p_n29 1.0093e-17
ccc_bl_3_rwl_2_p_n29 bl_3_p_n29 rwl_2_p_n29 1.0093e-17
ccc_rbl_0_rbl_1_p_n29 rbl_0_p_n29 rbl_1_p_n29 3.432e-17
ccc_rbl_0_rwl_0_p_n29 rbl_0_p_n29 rwl_0_p_n29 4.9752e-17
ccc_rbl_0_rwl_1_p_n29 rbl_0_p_n29 rwl_1_p_n29 4.9752e-17
ccc_rbl_0_rwl_2_p_n29 rbl_0_p_n29 rwl_2_p_n29 4.9752e-17
ccc_rbl_0_rwl_3_p_n29 rbl_0_p_n29 rwl_3_p_n29 4.9752e-17
ccc_rbl_1_rbl_2_p_n29 rbl_1_p_n29 rbl_2_p_n29 3.432e-17
ccc_rbl_1_rwl_0_p_n29 rbl_1_p_n29 rwl_0_p_n29 4.9752e-17
ccc_rbl_1_rwl_1_p_n29 rbl_1_p_n29 rwl_1_p_n29 4.9752e-17
ccc_rbl_1_rwl_2_p_n29 rbl_1_p_n29 rwl_2_p_n29 4.9752e-17
ccc_rbl_1_rwl_3_p_n29 rbl_1_p_n29 rwl_3_p_n29 4.9752e-17
ccc_rbl_2_rbl_3_p_n29 rbl_2_p_n29 rbl_3_p_n29 3.432e-17
ccc_rbl_2_rwl_0_p_n29 rbl_2_p_n29 rwl_0_p_n29 4.9752e-17
ccc_rbl_2_rwl_1_p_n29 rbl_2_p_n29 rwl_1_p_n29 4.9752e-17
ccc_rbl_2_rwl_2_p_n29 rbl_2_p_n29 rwl_2_p_n29 4.9752e-17
ccc_rbl_2_rwl_3_p_n29 rbl_2_p_n29 rwl_3_p_n29 4.9752e-17
ccc_rbl_3_rwl_0_p_n29 rbl_3_p_n29 rwl_0_p_n29 3.3407e-17
ccc_rbl_3_rwl_1_p_n29 rbl_3_p_n29 rwl_1_p_n29 3.3407e-17
ccc_rbl_3_rwl_2_p_n29 rbl_3_p_n29 rwl_2_p_n29 3.3407e-17
ccc_rbl_3_rwl_3_p_n29 rbl_3_p_n29 rwl_3_p_n29 3.3407e-17
vdw_p_n29_0 wl_0_p_n29 0 dc 0
vdr_p_n29_0 rwl_0_p_n29 vdd dc 0
vdw_p_n29_1 wl_1_p_n29 0 dc 0
vdr_p_n29_1 rwl_1_p_n29 vdd dc 0
vdw_p_n29_2 wl_2_p_n29 0 dc 0
vdr_p_n29_2 rwl_2_p_n29 vdd dc 0
vdw_p_n29_3 wl_3_p_n29 0 dc 0
vdr_p_n29_3 rwl_3_p_n29 vdd dc 0
vdb_p_n29_0 bl_0_p_n29 0 dc 0
vdp_p_n29_0 rbl_0_p_n29 vrbl dc 0
vdb_p_n29_1 bl_1_p_n29 0 dc 0
vdp_p_n29_1 rbl_1_p_n29 vrbl dc 0
vdb_p_n29_2 bl_2_p_n29 0 dc 0
vdp_p_n29_2 rbl_2_p_n29 vrbl dc 0
vdb_p_n29_3 bl_3_p_n29 0 dc 0
vdp_p_n29_3 rbl_3_p_n29 vrbl dc 0
vdn_p_n29_n7 n7_p_n29 0 dc 1
vdn_p_n29_n8 n8_p_n29 0 dc 1
vdn_p_n29_n9 n9_p_n29 0 dc 1
vdn_p_n29_n10 n10_p_n29 0 dc 1
vdn_p_n29_n17 n17_p_n29 0 dc 1
vdn_p_n29_n18 n18_p_n29 0 dc 1
vdn_p_n29_n19 n19_p_n29 0 dc 1
vdn_p_n29_n20 n20_p_n29 0 dc 1
vdn_p_n29_n22 n22_p_n29 0 dc 1
vdn_p_n29_n23 n23_p_n29 0 dc 1
vdn_p_n29_n24 n24_p_n29 0 dc 1
vdn_p_n29_n25 n25_p_n29 0 dc 1
vdn_p_n29_n30 n30_p_n29 0 dc 1
vdn_p_n29_n31 n31_p_n29 0 dc 1
vdn_p_n29_n32 n32_p_n29 0 dc 1
bdr_p_n29 n29_p_n29 0 i=5e-08*min(1,max(0,(time-1e-09)/0.2n))*0.5*(1+tanh((v(n29_p_n29)-0.05)/0.01))

* ---- instance p_n30: variant p, probed storage node \$30 ----
xm1_p_n30 rwl_0__t2_p_n30 n7__t0_p_n30 rbl_0__t0_p_n30 gnd__t0_p_n30 sky130_fd_pr__nfet_01v8 L=0.15 W=0.42 nf=1 ad=0.1197 as=0.1197 pd=1.41 ps=1.41 mult=1 m=1
xm2_p_n30 rwl_0__t3_p_n30 n8__t1_p_n30 rbl_1__t1_p_n30 gnd__t1_p_n30 sky130_fd_pr__nfet_01v8 L=0.15 W=0.42 nf=1 ad=0.1197 as=0.1197 pd=1.41 ps=1.41 mult=1 m=1
xm3_p_n30 rwl_0__t1_p_n30 n9__t1_p_n30 rbl_2__t1_p_n30 gnd__t2_p_n30 sky130_fd_pr__nfet_01v8 L=0.15 W=0.42 nf=1 ad=0.1197 as=0.1197 pd=1.41 ps=1.41 mult=1 m=1
xm4_p_n30 rwl_0__t0_p_n30 n10__t1_p_n30 rbl_3__t1_p_n30 gnd__t3_p_n30 sky130_fd_pr__nfet_01v8 L=0.15 W=0.42 nf=1 ad=0.1197 as=0.1197 pd=1.41 ps=1.41 mult=1 m=1
xm5_p_n30 bl_0__t0_p_n30 wl_0__t0_p_n30 n7__t1_p_n30 gnd__t8_p_n30 sky130_fd_pr__nfet_01v8 L=0.15 W=0.42 nf=1 ad=0.0588 as=0.1197 pd=0.7 ps=1.41 mult=1 m=1
xm6_p_n30 n17__t0_p_n30 wl_1__t0_p_n30 bl_0__t1_p_n30 gnd__t20_p_n30 sky130_fd_pr__nfet_01v8 L=0.15 W=0.42 nf=1 ad=0.1197 as=0.0588 pd=1.41 ps=0.7 mult=1 m=1
xm7_p_n30 bl_1__t2_p_n30 wl_0__t3_p_n30 n8__t0_p_n30 gnd__t9_p_n30 sky130_fd_pr__nfet_01v8 L=0.15 W=0.42 nf=1 ad=0.0588 as=0.1197 pd=0.7 ps=1.41 mult=1 m=1
xm8_p_n30 n18__t0_p_n30 wl_1__t1_p_n30 bl_1__t0_p_n30 gnd__t21_p_n30 sky130_fd_pr__nfet_01v8 L=0.15 W=0.42 nf=1 ad=0.1197 as=0.0588 pd=1.41 ps=0.7 mult=1 m=1
xm9_p_n30 bl_2__t2_p_n30 wl_0__t2_p_n30 n9__t0_p_n30 gnd__t10_p_n30 sky130_fd_pr__nfet_01v8 L=0.15 W=0.42 nf=1 ad=0.0588 as=0.1197 pd=0.7 ps=1.41 mult=1 m=1
xm10_p_n30 n19__t0_p_n30 wl_1__t2_p_n30 bl_2__t0_p_n30 gnd__t22_p_n30 sky130_fd_pr__nfet_01v8 L=0.15 W=0.42 nf=1 ad=0.1197 as=0.0588 pd=1.41 ps=0.7 mult=1 m=1
xm11_p_n30 bl_3__t2_p_n30 wl_0__t1_p_n30 n10__t0_p_n30 gnd__t11_p_n30 sky130_fd_pr__nfet_01v8 L=0.15 W=0.42 nf=1 ad=0.0588 as=0.1197 pd=0.7 ps=1.41 mult=1 m=1
xm12_p_n30 n20__t0_p_n30 wl_1__t3_p_n30 bl_3__t1_p_n30 gnd__t23_p_n30 sky130_fd_pr__nfet_01v8 L=0.15 W=0.42 nf=1 ad=0.1197 as=0.0588 pd=1.41 ps=0.7 mult=1 m=1
xm13_p_n30 rbl_0__t3_p_n30 n17__t1_p_n30 rwl_1__t0_p_n30 gnd__t12_p_n30 sky130_fd_pr__nfet_01v8 L=0.15 W=0.42 nf=1 ad=0.0588 as=0.1197 pd=0.7 ps=1.41 mult=1 m=1
xm14_p_n30 rwl_2__t3_p_n30 n22__t0_p_n30 rbl_0__t2_p_n30 gnd__t24_p_n30 sky130_fd_pr__nfet_01v8 L=0.15 W=0.42 nf=1 ad=0.1197 as=0.0588 pd=1.41 ps=0.7 mult=1 m=1
xm15_p_n30 rbl_1__t3_p_n30 n18__t1_p_n30 rwl_1__t1_p_n30 gnd__t13_p_n30 sky130_fd_pr__nfet_01v8 L=0.15 W=0.42 nf=1 ad=0.0588 as=0.1197 pd=0.7 ps=1.41 mult=1 m=1
xm16_p_n30 rwl_2__t0_p_n30 n23__t0_p_n30 rbl_1__t2_p_n30 gnd__t25_p_n30 sky130_fd_pr__nfet_01v8 L=0.15 W=0.42 nf=1 ad=0.1197 as=0.0588 pd=1.41 ps=0.7 mult=1 m=1
xm17_p_n30 rbl_2__t3_p_n30 n19__t1_p_n30 rwl_1__t2_p_n30 gnd__t14_p_n30 sky130_fd_pr__nfet_01v8 L=0.15 W=0.42 nf=1 ad=0.0588 as=0.1197 pd=0.7 ps=1.41 mult=1 m=1
xm18_p_n30 rwl_2__t1_p_n30 n24__t0_p_n30 rbl_2__t2_p_n30 gnd__t26_p_n30 sky130_fd_pr__nfet_01v8 L=0.15 W=0.42 nf=1 ad=0.1197 as=0.0588 pd=1.41 ps=0.7 mult=1 m=1
xm19_p_n30 rbl_3__t3_p_n30 n20__t1_p_n30 rwl_1__t3_p_n30 gnd__t15_p_n30 sky130_fd_pr__nfet_01v8 L=0.15 W=0.42 nf=1 ad=0.0588 as=0.1197 pd=0.7 ps=1.41 mult=1 m=1
xm20_p_n30 rwl_2__t2_p_n30 n25__t0_p_n30 rbl_3__t2_p_n30 gnd__t27_p_n30 sky130_fd_pr__nfet_01v8 L=0.15 W=0.42 nf=1 ad=0.1197 as=0.0588 pd=1.41 ps=0.7 mult=1 m=1
xm21_p_n30 bl_0__t3_p_n30 wl_2__t0_p_n30 n22__t1_p_n30 gnd__t16_p_n30 sky130_fd_pr__nfet_01v8 L=0.15 W=0.42 nf=1 ad=0.0588 as=0.1197 pd=0.7 ps=1.41 mult=1 m=1
xm22_p_n30 n29__t0_p_n30 wl_3__t3_p_n30 bl_0__t2_p_n30 gnd__t28_p_n30 sky130_fd_pr__nfet_01v8 L=0.15 W=0.42 nf=1 ad=0.1197 as=0.0588 pd=1.41 ps=0.7 mult=1 m=1
xm23_p_n30 bl_1__t3_p_n30 wl_2__t1_p_n30 n23__t1_p_n30 gnd__t17_p_n30 sky130_fd_pr__nfet_01v8 L=0.15 W=0.42 nf=1 ad=0.0588 as=0.1197 pd=0.7 ps=1.41 mult=1 m=1
xm24_p_n30 n30__t0_p_n30 wl_3__t2_p_n30 bl_1__t1_p_n30 gnd__t29_p_n30 sky130_fd_pr__nfet_01v8 L=0.15 W=0.42 nf=1 ad=0.1197 as=0.0588 pd=1.41 ps=0.7 mult=1 m=1
xm25_p_n30 bl_2__t3_p_n30 wl_2__t2_p_n30 n24__t1_p_n30 gnd__t18_p_n30 sky130_fd_pr__nfet_01v8 L=0.15 W=0.42 nf=1 ad=0.0588 as=0.1197 pd=0.7 ps=1.41 mult=1 m=1
xm26_p_n30 n31__t0_p_n30 wl_3__t1_p_n30 bl_2__t1_p_n30 gnd__t30_p_n30 sky130_fd_pr__nfet_01v8 L=0.15 W=0.42 nf=1 ad=0.1197 as=0.0588 pd=1.41 ps=0.7 mult=1 m=1
xm27_p_n30 bl_3__t3_p_n30 wl_2__t3_p_n30 n25__t1_p_n30 gnd__t19_p_n30 sky130_fd_pr__nfet_01v8 L=0.15 W=0.42 nf=1 ad=0.0588 as=0.1197 pd=0.7 ps=1.41 mult=1 m=1
xm28_p_n30 n32__t0_p_n30 wl_3__t0_p_n30 bl_3__t0_p_n30 gnd__t31_p_n30 sky130_fd_pr__nfet_01v8 L=0.15 W=0.42 nf=1 ad=0.1197 as=0.0588 pd=1.41 ps=0.7 mult=1 m=1
xm29_p_n30 rbl_0__t1_p_n30 n29__t1_p_n30 rwl_3__t0_p_n30 gnd__t4_p_n30 sky130_fd_pr__nfet_01v8 L=0.15 W=0.42 nf=1 ad=0.1197 as=0.1197 pd=1.41 ps=1.41 mult=1 m=1
xm30_p_n30 rbl_1__t0_p_n30 n30__t1_p_n30 rwl_3__t1_p_n30 gnd__t5_p_n30 sky130_fd_pr__nfet_01v8 L=0.15 W=0.42 nf=1 ad=0.1197 as=0.1197 pd=1.41 ps=1.41 mult=1 m=1
xm31_p_n30 rbl_2__t0_p_n30 n31__t1_p_n30 rwl_3__t2_p_n30 gnd__t6_p_n30 sky130_fd_pr__nfet_01v8 L=0.15 W=0.42 nf=1 ad=0.1197 as=0.1197 pd=1.41 ps=1.41 mult=1 m=1
xm32_p_n30 rbl_3__t0_p_n30 n32__t1_p_n30 rwl_3__t3_p_n30 gnd__t7_p_n30 sky130_fd_pr__nfet_01v8 L=0.15 W=0.42 nf=1 ad=0.1197 as=0.1197 pd=1.41 ps=1.41 mult=1 m=1
r_10_t0_p_n30 n10__t0_p_n30 n10_p_n30 183.071
r_10_t1_p_n30 n10__t1_p_n30 n10_p_n30 183.071
r_17_t0_p_n30 n17__t0_p_n30 n17_p_n30 183.071
r_17_t1_p_n30 n17__t1_p_n30 n17_p_n30 183.071
r_18_t0_p_n30 n18__t0_p_n30 n18_p_n30 183.071
r_18_t1_p_n30 n18__t1_p_n30 n18_p_n30 183.071
r_19_t0_p_n30 n19__t0_p_n30 n19_p_n30 183.071
r_19_t1_p_n30 n19__t1_p_n30 n19_p_n30 183.071
r_20_t0_p_n30 n20__t0_p_n30 n20_p_n30 183.071
r_20_t1_p_n30 n20__t1_p_n30 n20_p_n30 183.071
r_22_t0_p_n30 n22__t0_p_n30 n22_p_n30 183.071
r_22_t1_p_n30 n22__t1_p_n30 n22_p_n30 183.071
r_23_t0_p_n30 n23__t0_p_n30 n23_p_n30 183.071
r_23_t1_p_n30 n23__t1_p_n30 n23_p_n30 183.071
r_24_t0_p_n30 n24__t0_p_n30 n24_p_n30 183.071
r_24_t1_p_n30 n24__t1_p_n30 n24_p_n30 183.071
r_25_t0_p_n30 n25__t0_p_n30 n25_p_n30 183.071
r_25_t1_p_n30 n25__t1_p_n30 n25_p_n30 183.071
r_29_t0_p_n30 n29__t0_p_n30 n29_p_n30 183.071
r_29_t1_p_n30 n29__t1_p_n30 n29_p_n30 183.071
r_30_t0_p_n30 n30__t0_p_n30 n30_p_n30 183.071
r_30_t1_p_n30 n30__t1_p_n30 n30_p_n30 183.071
r_31_t0_p_n30 n31__t0_p_n30 n31_p_n30 183.071
r_31_t1_p_n30 n31__t1_p_n30 n31_p_n30 183.071
r_32_t0_p_n30 n32__t0_p_n30 n32_p_n30 183.071
r_32_t1_p_n30 n32__t1_p_n30 n32_p_n30 183.071
r_7_t0_p_n30 n7__t0_p_n30 n7_p_n30 183.071
r_7_t1_p_n30 n7__t1_p_n30 n7_p_n30 183.071
r_8_t0_p_n30 n8__t0_p_n30 n8_p_n30 183.071
r_8_t1_p_n30 n8__t1_p_n30 n8_p_n30 183.071
r_9_t0_p_n30 n9__t0_p_n30 n9_p_n30 183.071
r_9_t1_p_n30 n9__t1_p_n30 n9_p_n30 183.071
rgnd_t0_p_n30 gnd__t0_p_n30 0 38.2988
rgnd_t1_p_n30 gnd__t1_p_n30 0 33.9576
rgnd_t2_p_n30 gnd__t2_p_n30 0 33.9576
rgnd_t3_p_n30 gnd__t3_p_n30 0 38.2988
rgnd_t4_p_n30 gnd__t4_p_n30 0 38.2988
rgnd_t5_p_n30 gnd__t5_p_n30 0 33.9576
rgnd_t6_p_n30 gnd__t6_p_n30 0 33.9576
rgnd_t7_p_n30 gnd__t7_p_n30 0 38.2988
rgnd_t8_p_n30 gnd__t8_p_n30 0 28.0185
rgnd_t9_p_n30 gnd__t9_p_n30 0 21.7106
rgnd_t10_p_n30 gnd__t10_p_n30 0 21.7106
rgnd_t11_p_n30 gnd__t11_p_n30 0 28.0185
rgnd_t12_p_n30 gnd__t12_p_n30 0 18.9833
rgnd_t13_p_n30 gnd__t13_p_n30 0 6.8325
rgnd_t14_p_n30 gnd__t14_p_n30 0 6.8325
rgnd_t15_p_n30 gnd__t15_p_n30 0 18.9833
rgnd_t16_p_n30 gnd__t16_p_n30 0 24.2409
rgnd_t17_p_n30 gnd__t17_p_n30 0 16.5511
rgnd_t18_p_n30 gnd__t18_p_n30 0 16.5511
rgnd_t19_p_n30 gnd__t19_p_n30 0 24.2409
rgnd_t20_p_n30 gnd__t20_p_n30 0 24.2409
rgnd_t21_p_n30 gnd__t21_p_n30 0 16.5511
rgnd_t22_p_n30 gnd__t22_p_n30 0 16.5511
rgnd_t23_p_n30 gnd__t23_p_n30 0 24.2409
rgnd_t24_p_n30 gnd__t24_p_n30 0 18.9833
rgnd_t25_p_n30 gnd__t25_p_n30 0 6.8325
rgnd_t26_p_n30 gnd__t26_p_n30 0 6.8325
rgnd_t27_p_n30 gnd__t27_p_n30 0 18.9833
rgnd_t28_p_n30 gnd__t28_p_n30 0 28.0185
rgnd_t29_p_n30 gnd__t29_p_n30 0 21.7106
rgnd_t30_p_n30 gnd__t30_p_n30 0 21.7106
rgnd_t31_p_n30 gnd__t31_p_n30 0 28.0185
rbl_0_t0_p_n30 bl_0__t0_p_n30 bl_0_p_n30 14.8304
rbl_0_t1_p_n30 bl_0__t1_p_n30 bl_0_p_n30 10.9301
rbl_0_t2_p_n30 bl_0__t2_p_n30 bl_0_p_n30 14.8304
rbl_0_t3_p_n30 bl_0__t3_p_n30 bl_0_p_n30 10.9301
rbl_1_t0_p_n30 bl_1__t0_p_n30 bl_1_p_n30 10.9301
rbl_1_t1_p_n30 bl_1__t1_p_n30 bl_1_p_n30 14.8304
rbl_1_t2_p_n30 bl_1__t2_p_n30 bl_1_p_n30 14.8304
rbl_1_t3_p_n30 bl_1__t3_p_n30 bl_1_p_n30 10.9301
rbl_2_t0_p_n30 bl_2__t0_p_n30 bl_2_p_n30 10.9301
rbl_2_t1_p_n30 bl_2__t1_p_n30 bl_2_p_n30 14.8304
rbl_2_t2_p_n30 bl_2__t2_p_n30 bl_2_p_n30 14.8304
rbl_2_t3_p_n30 bl_2__t3_p_n30 bl_2_p_n30 10.9301
rbl_3_t0_p_n30 bl_3__t0_p_n30 bl_3_p_n30 14.8304
rbl_3_t1_p_n30 bl_3__t1_p_n30 bl_3_p_n30 10.9301
rbl_3_t2_p_n30 bl_3__t2_p_n30 bl_3_p_n30 14.8304
rbl_3_t3_p_n30 bl_3__t3_p_n30 bl_3_p_n30 10.9301
rrbl_0_t0_p_n30 rbl_0__t0_p_n30 rbl_0_p_n30 36.5601
rrbl_0_t1_p_n30 rbl_0__t1_p_n30 rbl_0_p_n30 36.5601
rrbl_0_t2_p_n30 rbl_0__t2_p_n30 rbl_0_p_n30 2.99444
rrbl_0_t3_p_n30 rbl_0__t3_p_n30 rbl_0_p_n30 2.99444
rrbl_1_t0_p_n30 rbl_1__t0_p_n30 rbl_1_p_n30 36.5601
rrbl_1_t1_p_n30 rbl_1__t1_p_n30 rbl_1_p_n30 36.5601
rrbl_1_t2_p_n30 rbl_1__t2_p_n30 rbl_1_p_n30 2.99444
rrbl_1_t3_p_n30 rbl_1__t3_p_n30 rbl_1_p_n30 2.99444
rrbl_2_t0_p_n30 rbl_2__t0_p_n30 rbl_2_p_n30 36.5601
rrbl_2_t1_p_n30 rbl_2__t1_p_n30 rbl_2_p_n30 36.5601
rrbl_2_t2_p_n30 rbl_2__t2_p_n30 rbl_2_p_n30 2.99444
rrbl_2_t3_p_n30 rbl_2__t3_p_n30 rbl_2_p_n30 2.99444
rrbl_3_t0_p_n30 rbl_3__t0_p_n30 rbl_3_p_n30 36.5601
rrbl_3_t1_p_n30 rbl_3__t1_p_n30 rbl_3_p_n30 36.5601
rrbl_3_t2_p_n30 rbl_3__t2_p_n30 rbl_3_p_n30 2.99444
rrbl_3_t3_p_n30 rbl_3__t3_p_n30 rbl_3_p_n30 2.99444
rrwl_0_t0_p_n30 rwl_0__t0_p_n30 rwl_0_p_n30 38.2618
rrwl_0_t1_p_n30 rwl_0__t1_p_n30 rwl_0_p_n30 12.7539
rrwl_0_t2_p_n30 rwl_0__t2_p_n30 rwl_0_p_n30 38.2618
rrwl_0_t3_p_n30 rwl_0__t3_p_n30 rwl_0_p_n30 12.7539
rrwl_1_t0_p_n30 rwl_1__t0_p_n30 rwl_1_p_n30 38.2618
rrwl_1_t1_p_n30 rwl_1__t1_p_n30 rwl_1_p_n30 12.7539
rrwl_1_t2_p_n30 rwl_1__t2_p_n30 rwl_1_p_n30 12.7539
rrwl_1_t3_p_n30 rwl_1__t3_p_n30 rwl_1_p_n30 38.2618
rrwl_2_t0_p_n30 rwl_2__t0_p_n30 rwl_2_p_n30 12.7539
rrwl_2_t1_p_n30 rwl_2__t1_p_n30 rwl_2_p_n30 12.7539
rrwl_2_t2_p_n30 rwl_2__t2_p_n30 rwl_2_p_n30 38.2618
rrwl_2_t3_p_n30 rwl_2__t3_p_n30 rwl_2_p_n30 38.2618
rrwl_3_t0_p_n30 rwl_3__t0_p_n30 rwl_3_p_n30 38.2618
rrwl_3_t1_p_n30 rwl_3__t1_p_n30 rwl_3_p_n30 12.7539
rrwl_3_t2_p_n30 rwl_3__t2_p_n30 rwl_3_p_n30 12.7539
rrwl_3_t3_p_n30 rwl_3__t3_p_n30 rwl_3_p_n30 38.2618
rwl_0_t0_p_n30 wl_0__t0_p_n30 wl_0_p_n30 245.959
rwl_0_t1_p_n30 wl_0__t1_p_n30 wl_0_p_n30 245.959
rwl_0_t2_p_n30 wl_0__t2_p_n30 wl_0_p_n30 81.9864
rwl_0_t3_p_n30 wl_0__t3_p_n30 wl_0_p_n30 81.9864
rwl_1_t0_p_n30 wl_1__t0_p_n30 wl_1_p_n30 245.959
rwl_1_t1_p_n30 wl_1__t1_p_n30 wl_1_p_n30 81.9864
rwl_1_t2_p_n30 wl_1__t2_p_n30 wl_1_p_n30 81.9864
rwl_1_t3_p_n30 wl_1__t3_p_n30 wl_1_p_n30 245.959
rwl_2_t0_p_n30 wl_2__t0_p_n30 wl_2_p_n30 245.959
rwl_2_t1_p_n30 wl_2__t1_p_n30 wl_2_p_n30 81.9864
rwl_2_t2_p_n30 wl_2__t2_p_n30 wl_2_p_n30 81.9864
rwl_2_t3_p_n30 wl_2__t3_p_n30 wl_2_p_n30 245.959
rwl_3_t0_p_n30 wl_3__t0_p_n30 wl_3_p_n30 245.959
rwl_3_t1_p_n30 wl_3__t1_p_n30 wl_3_p_n30 81.9864
rwl_3_t2_p_n30 wl_3__t2_p_n30 wl_3_p_n30 81.9864
rwl_3_t3_p_n30 wl_3__t3_p_n30 wl_3_p_n30 245.959
c_10_p_n30 n10_p_n30 0 2.91622e-16
c_17_p_n30 n17_p_n30 0 2.91528e-16
c_18_p_n30 n18_p_n30 0 2.91528e-16
c_19_p_n30 n19_p_n30 0 2.91528e-16
c_20_p_n30 n20_p_n30 0 2.91622e-16
c_22_p_n30 n22_p_n30 0 2.91528e-16
c_23_p_n30 n23_p_n30 0 2.91528e-16
c_24_p_n30 n24_p_n30 0 2.91528e-16
c_25_p_n30 n25_p_n30 0 2.91622e-16
c_29_p_n30 n29_p_n30 0 2.91528e-16
c_30_p_n30 n30_p_n30 0 1.1371e-16
c_31_p_n30 n31_p_n30 0 2.91528e-16
c_32_p_n30 n32_p_n30 0 2.91622e-16
c_7_p_n30 n7_p_n30 0 2.91528e-16
c_8_p_n30 n8_p_n30 0 2.91528e-16
c_9_p_n30 n9_p_n30 0 2.91528e-16
cgnd_p_n30 0 0 2.48166e-15
cbl_0_p_n30 bl_0_p_n30 0 4.52661e-16
cbl_1_p_n30 bl_1_p_n30 0 4.52661e-16
cbl_2_p_n30 bl_2_p_n30 0 4.52661e-16
cbl_3_p_n30 bl_3_p_n30 0 4.52661e-16
crbl_0_p_n30 rbl_0_p_n30 0 9.14472e-16
crbl_1_p_n30 rbl_1_p_n30 0 9.14472e-16
crbl_2_p_n30 rbl_2_p_n30 0 9.14472e-16
crbl_3_p_n30 rbl_3_p_n30 0 9.17566e-16
crwl_0_p_n30 rwl_0_p_n30 0 5.19495e-16
crwl_1_p_n30 rwl_1_p_n30 0 5.11719e-16
crwl_2_p_n30 rwl_2_p_n30 0 5.11719e-16
crwl_3_p_n30 rwl_3_p_n30 0 5.19495e-16
cwl_0_p_n30 wl_0_p_n30 0 3.30388e-16
cwl_1_p_n30 wl_1_p_n30 0 3.30388e-16
cwl_2_p_n30 wl_2_p_n30 0 3.30388e-16
cwl_3_p_n30 wl_3_p_n30 0 3.30388e-16
ccc__10__9_p_n30 n10_p_n30 n9_p_n30 1.02e-17
ccc__10_bl_3_p_n30 n10_p_n30 bl_3_p_n30 1.3999e-17
ccc__10_rwl_0_p_n30 n10_p_n30 rwl_0_p_n30 4.335e-18
ccc__17__18_p_n30 n17_p_n30 n18_p_n30 1.02e-17
ccc__17_bl_0_p_n30 n17_p_n30 bl_0_p_n30 8.415e-18
ccc__17_rwl_1_p_n30 n17_p_n30 rwl_1_p_n30 1.3194e-17
ccc__18__19_p_n30 n18_p_n30 n19_p_n30 1.02e-17
ccc__18_bl_1_p_n30 n18_p_n30 bl_1_p_n30 8.415e-18
ccc__18_rwl_1_p_n30 n18_p_n30 rwl_1_p_n30 1.3194e-17
ccc__19__20_p_n30 n19_p_n30 n20_p_n30 1.02e-17
ccc__19_bl_2_p_n30 n19_p_n30 bl_2_p_n30 8.415e-18
ccc__19_rwl_1_p_n30 n19_p_n30 rwl_1_p_n30 1.3194e-17
ccc__20_bl_3_p_n30 n20_p_n30 bl_3_p_n30 8.415e-18
ccc__20_rwl_1_p_n30 n20_p_n30 rwl_1_p_n30 6.655e-18
ccc__22__23_p_n30 n22_p_n30 n23_p_n30 1.02e-17
ccc__22_bl_0_p_n30 n22_p_n30 bl_0_p_n30 8.415e-18
ccc__22_rwl_2_p_n30 n22_p_n30 rwl_2_p_n30 1.3194e-17
ccc__23__24_p_n30 n23_p_n30 n24_p_n30 1.02e-17
ccc__23_bl_1_p_n30 n23_p_n30 bl_1_p_n30 8.415e-18
ccc__23_rwl_2_p_n30 n23_p_n30 rwl_2_p_n30 1.3194e-17
ccc__24__25_p_n30 n24_p_n30 n25_p_n30 1.02e-17
ccc__24_bl_2_p_n30 n24_p_n30 bl_2_p_n30 8.415e-18
ccc__24_rwl_2_p_n30 n24_p_n30 rwl_2_p_n30 1.3194e-17
ccc__25_bl_3_p_n30 n25_p_n30 bl_3_p_n30 8.415e-18
ccc__25_rwl_2_p_n30 n25_p_n30 rwl_2_p_n30 6.655e-18
ccc__29__30_p_n30 n29_p_n30 n30_p_n30 1.02e-17
ccc__29_bl_0_p_n30 n29_p_n30 bl_0_p_n30 8.415e-18
ccc__29_rwl_3_p_n30 n29_p_n30 rwl_3_p_n30 1.3194e-17
ccc__30__31_p_n30 n30_p_n30 n31_p_n30 1.02e-17
ccc__30_bl_1_p_n30 n30_p_n30 bl_1_p_n30 8.415e-18
ccc__30_rwl_3_p_n30 n30_p_n30 rwl_3_p_n30 1.3194e-17
ccc__31__32_p_n30 n31_p_n30 n32_p_n30 1.02e-17
ccc__31_bl_2_p_n30 n31_p_n30 bl_2_p_n30 8.415e-18
ccc__31_rwl_3_p_n30 n31_p_n30 rwl_3_p_n30 1.3194e-17
ccc__32_bl_3_p_n30 n32_p_n30 bl_3_p_n30 8.415e-18
ccc__32_rwl_3_p_n30 n32_p_n30 rwl_3_p_n30 6.655e-18
ccc__7__8_p_n30 n7_p_n30 n8_p_n30 1.02e-17
ccc__7_bl_0_p_n30 n7_p_n30 bl_0_p_n30 1.3999e-17
ccc__7_rwl_0_p_n30 n7_p_n30 rwl_0_p_n30 8.961e-18
ccc__8__9_p_n30 n8_p_n30 n9_p_n30 1.02e-17
ccc__8_bl_1_p_n30 n8_p_n30 bl_1_p_n30 1.3999e-17
ccc__8_rwl_0_p_n30 n8_p_n30 rwl_0_p_n30 8.961e-18
ccc__9_bl_2_p_n30 n9_p_n30 bl_2_p_n30 1.3999e-17
ccc__9_rwl_0_p_n30 n9_p_n30 rwl_0_p_n30 8.961e-18
ccc_bl_0_rbl_0_p_n30 bl_0_p_n30 rbl_0_p_n30 1.88693e-16
ccc_bl_0_rwl_1_p_n30 bl_0_p_n30 rwl_1_p_n30 1.0093e-17
ccc_bl_0_rwl_2_p_n30 bl_0_p_n30 rwl_2_p_n30 1.0093e-17
ccc_bl_1_rbl_0_p_n30 bl_1_p_n30 rbl_0_p_n30 1.633e-16
ccc_bl_1_rbl_1_p_n30 bl_1_p_n30 rbl_1_p_n30 1.88693e-16
ccc_bl_1_rwl_1_p_n30 bl_1_p_n30 rwl_1_p_n30 1.0093e-17
ccc_bl_1_rwl_2_p_n30 bl_1_p_n30 rwl_2_p_n30 1.0093e-17
ccc_bl_2_rbl_1_p_n30 bl_2_p_n30 rbl_1_p_n30 1.633e-16
ccc_bl_2_rbl_2_p_n30 bl_2_p_n30 rbl_2_p_n30 1.88693e-16
ccc_bl_2_rwl_1_p_n30 bl_2_p_n30 rwl_1_p_n30 1.0093e-17
ccc_bl_2_rwl_2_p_n30 bl_2_p_n30 rwl_2_p_n30 1.0093e-17
ccc_bl_3_rbl_2_p_n30 bl_3_p_n30 rbl_2_p_n30 1.633e-16
ccc_bl_3_rbl_3_p_n30 bl_3_p_n30 rbl_3_p_n30 1.88693e-16
ccc_bl_3_rwl_1_p_n30 bl_3_p_n30 rwl_1_p_n30 1.0093e-17
ccc_bl_3_rwl_2_p_n30 bl_3_p_n30 rwl_2_p_n30 1.0093e-17
ccc_rbl_0_rbl_1_p_n30 rbl_0_p_n30 rbl_1_p_n30 3.432e-17
ccc_rbl_0_rwl_0_p_n30 rbl_0_p_n30 rwl_0_p_n30 4.9752e-17
ccc_rbl_0_rwl_1_p_n30 rbl_0_p_n30 rwl_1_p_n30 4.9752e-17
ccc_rbl_0_rwl_2_p_n30 rbl_0_p_n30 rwl_2_p_n30 4.9752e-17
ccc_rbl_0_rwl_3_p_n30 rbl_0_p_n30 rwl_3_p_n30 4.9752e-17
ccc_rbl_1_rbl_2_p_n30 rbl_1_p_n30 rbl_2_p_n30 3.432e-17
ccc_rbl_1_rwl_0_p_n30 rbl_1_p_n30 rwl_0_p_n30 4.9752e-17
ccc_rbl_1_rwl_1_p_n30 rbl_1_p_n30 rwl_1_p_n30 4.9752e-17
ccc_rbl_1_rwl_2_p_n30 rbl_1_p_n30 rwl_2_p_n30 4.9752e-17
ccc_rbl_1_rwl_3_p_n30 rbl_1_p_n30 rwl_3_p_n30 4.9752e-17
ccc_rbl_2_rbl_3_p_n30 rbl_2_p_n30 rbl_3_p_n30 3.432e-17
ccc_rbl_2_rwl_0_p_n30 rbl_2_p_n30 rwl_0_p_n30 4.9752e-17
ccc_rbl_2_rwl_1_p_n30 rbl_2_p_n30 rwl_1_p_n30 4.9752e-17
ccc_rbl_2_rwl_2_p_n30 rbl_2_p_n30 rwl_2_p_n30 4.9752e-17
ccc_rbl_2_rwl_3_p_n30 rbl_2_p_n30 rwl_3_p_n30 4.9752e-17
ccc_rbl_3_rwl_0_p_n30 rbl_3_p_n30 rwl_0_p_n30 3.3407e-17
ccc_rbl_3_rwl_1_p_n30 rbl_3_p_n30 rwl_1_p_n30 3.3407e-17
ccc_rbl_3_rwl_2_p_n30 rbl_3_p_n30 rwl_2_p_n30 3.3407e-17
ccc_rbl_3_rwl_3_p_n30 rbl_3_p_n30 rwl_3_p_n30 3.3407e-17
vdw_p_n30_0 wl_0_p_n30 0 dc 0
vdr_p_n30_0 rwl_0_p_n30 vdd dc 0
vdw_p_n30_1 wl_1_p_n30 0 dc 0
vdr_p_n30_1 rwl_1_p_n30 vdd dc 0
vdw_p_n30_2 wl_2_p_n30 0 dc 0
vdr_p_n30_2 rwl_2_p_n30 vdd dc 0
vdw_p_n30_3 wl_3_p_n30 0 dc 0
vdr_p_n30_3 rwl_3_p_n30 vdd dc 0
vdb_p_n30_0 bl_0_p_n30 0 dc 0
vdp_p_n30_0 rbl_0_p_n30 vrbl dc 0
vdb_p_n30_1 bl_1_p_n30 0 dc 0
vdp_p_n30_1 rbl_1_p_n30 vrbl dc 0
vdb_p_n30_2 bl_2_p_n30 0 dc 0
vdp_p_n30_2 rbl_2_p_n30 vrbl dc 0
vdb_p_n30_3 bl_3_p_n30 0 dc 0
vdp_p_n30_3 rbl_3_p_n30 vrbl dc 0
vdn_p_n30_n7 n7_p_n30 0 dc 1
vdn_p_n30_n8 n8_p_n30 0 dc 1
vdn_p_n30_n9 n9_p_n30 0 dc 1
vdn_p_n30_n10 n10_p_n30 0 dc 1
vdn_p_n30_n17 n17_p_n30 0 dc 1
vdn_p_n30_n18 n18_p_n30 0 dc 1
vdn_p_n30_n19 n19_p_n30 0 dc 1
vdn_p_n30_n20 n20_p_n30 0 dc 1
vdn_p_n30_n22 n22_p_n30 0 dc 1
vdn_p_n30_n23 n23_p_n30 0 dc 1
vdn_p_n30_n24 n24_p_n30 0 dc 1
vdn_p_n30_n25 n25_p_n30 0 dc 1
vdn_p_n30_n29 n29_p_n30 0 dc 1
vdn_p_n30_n31 n31_p_n30 0 dc 1
vdn_p_n30_n32 n32_p_n30 0 dc 1
bdr_p_n30 n30_p_n30 0 i=5e-08*min(1,max(0,(time-1e-09)/0.2n))*0.5*(1+tanh((v(n30_p_n30)-0.05)/0.01))

* ---- instance p_n31: variant p, probed storage node \$31 ----
xm1_p_n31 rwl_0__t2_p_n31 n7__t0_p_n31 rbl_0__t0_p_n31 gnd__t0_p_n31 sky130_fd_pr__nfet_01v8 L=0.15 W=0.42 nf=1 ad=0.1197 as=0.1197 pd=1.41 ps=1.41 mult=1 m=1
xm2_p_n31 rwl_0__t3_p_n31 n8__t1_p_n31 rbl_1__t1_p_n31 gnd__t1_p_n31 sky130_fd_pr__nfet_01v8 L=0.15 W=0.42 nf=1 ad=0.1197 as=0.1197 pd=1.41 ps=1.41 mult=1 m=1
xm3_p_n31 rwl_0__t1_p_n31 n9__t1_p_n31 rbl_2__t1_p_n31 gnd__t2_p_n31 sky130_fd_pr__nfet_01v8 L=0.15 W=0.42 nf=1 ad=0.1197 as=0.1197 pd=1.41 ps=1.41 mult=1 m=1
xm4_p_n31 rwl_0__t0_p_n31 n10__t1_p_n31 rbl_3__t1_p_n31 gnd__t3_p_n31 sky130_fd_pr__nfet_01v8 L=0.15 W=0.42 nf=1 ad=0.1197 as=0.1197 pd=1.41 ps=1.41 mult=1 m=1
xm5_p_n31 bl_0__t0_p_n31 wl_0__t0_p_n31 n7__t1_p_n31 gnd__t8_p_n31 sky130_fd_pr__nfet_01v8 L=0.15 W=0.42 nf=1 ad=0.0588 as=0.1197 pd=0.7 ps=1.41 mult=1 m=1
xm6_p_n31 n17__t0_p_n31 wl_1__t0_p_n31 bl_0__t1_p_n31 gnd__t20_p_n31 sky130_fd_pr__nfet_01v8 L=0.15 W=0.42 nf=1 ad=0.1197 as=0.0588 pd=1.41 ps=0.7 mult=1 m=1
xm7_p_n31 bl_1__t2_p_n31 wl_0__t3_p_n31 n8__t0_p_n31 gnd__t9_p_n31 sky130_fd_pr__nfet_01v8 L=0.15 W=0.42 nf=1 ad=0.0588 as=0.1197 pd=0.7 ps=1.41 mult=1 m=1
xm8_p_n31 n18__t0_p_n31 wl_1__t1_p_n31 bl_1__t0_p_n31 gnd__t21_p_n31 sky130_fd_pr__nfet_01v8 L=0.15 W=0.42 nf=1 ad=0.1197 as=0.0588 pd=1.41 ps=0.7 mult=1 m=1
xm9_p_n31 bl_2__t2_p_n31 wl_0__t2_p_n31 n9__t0_p_n31 gnd__t10_p_n31 sky130_fd_pr__nfet_01v8 L=0.15 W=0.42 nf=1 ad=0.0588 as=0.1197 pd=0.7 ps=1.41 mult=1 m=1
xm10_p_n31 n19__t0_p_n31 wl_1__t2_p_n31 bl_2__t0_p_n31 gnd__t22_p_n31 sky130_fd_pr__nfet_01v8 L=0.15 W=0.42 nf=1 ad=0.1197 as=0.0588 pd=1.41 ps=0.7 mult=1 m=1
xm11_p_n31 bl_3__t2_p_n31 wl_0__t1_p_n31 n10__t0_p_n31 gnd__t11_p_n31 sky130_fd_pr__nfet_01v8 L=0.15 W=0.42 nf=1 ad=0.0588 as=0.1197 pd=0.7 ps=1.41 mult=1 m=1
xm12_p_n31 n20__t0_p_n31 wl_1__t3_p_n31 bl_3__t1_p_n31 gnd__t23_p_n31 sky130_fd_pr__nfet_01v8 L=0.15 W=0.42 nf=1 ad=0.1197 as=0.0588 pd=1.41 ps=0.7 mult=1 m=1
xm13_p_n31 rbl_0__t3_p_n31 n17__t1_p_n31 rwl_1__t0_p_n31 gnd__t12_p_n31 sky130_fd_pr__nfet_01v8 L=0.15 W=0.42 nf=1 ad=0.0588 as=0.1197 pd=0.7 ps=1.41 mult=1 m=1
xm14_p_n31 rwl_2__t3_p_n31 n22__t0_p_n31 rbl_0__t2_p_n31 gnd__t24_p_n31 sky130_fd_pr__nfet_01v8 L=0.15 W=0.42 nf=1 ad=0.1197 as=0.0588 pd=1.41 ps=0.7 mult=1 m=1
xm15_p_n31 rbl_1__t3_p_n31 n18__t1_p_n31 rwl_1__t1_p_n31 gnd__t13_p_n31 sky130_fd_pr__nfet_01v8 L=0.15 W=0.42 nf=1 ad=0.0588 as=0.1197 pd=0.7 ps=1.41 mult=1 m=1
xm16_p_n31 rwl_2__t0_p_n31 n23__t0_p_n31 rbl_1__t2_p_n31 gnd__t25_p_n31 sky130_fd_pr__nfet_01v8 L=0.15 W=0.42 nf=1 ad=0.1197 as=0.0588 pd=1.41 ps=0.7 mult=1 m=1
xm17_p_n31 rbl_2__t3_p_n31 n19__t1_p_n31 rwl_1__t2_p_n31 gnd__t14_p_n31 sky130_fd_pr__nfet_01v8 L=0.15 W=0.42 nf=1 ad=0.0588 as=0.1197 pd=0.7 ps=1.41 mult=1 m=1
xm18_p_n31 rwl_2__t1_p_n31 n24__t0_p_n31 rbl_2__t2_p_n31 gnd__t26_p_n31 sky130_fd_pr__nfet_01v8 L=0.15 W=0.42 nf=1 ad=0.1197 as=0.0588 pd=1.41 ps=0.7 mult=1 m=1
xm19_p_n31 rbl_3__t3_p_n31 n20__t1_p_n31 rwl_1__t3_p_n31 gnd__t15_p_n31 sky130_fd_pr__nfet_01v8 L=0.15 W=0.42 nf=1 ad=0.0588 as=0.1197 pd=0.7 ps=1.41 mult=1 m=1
xm20_p_n31 rwl_2__t2_p_n31 n25__t0_p_n31 rbl_3__t2_p_n31 gnd__t27_p_n31 sky130_fd_pr__nfet_01v8 L=0.15 W=0.42 nf=1 ad=0.1197 as=0.0588 pd=1.41 ps=0.7 mult=1 m=1
xm21_p_n31 bl_0__t3_p_n31 wl_2__t0_p_n31 n22__t1_p_n31 gnd__t16_p_n31 sky130_fd_pr__nfet_01v8 L=0.15 W=0.42 nf=1 ad=0.0588 as=0.1197 pd=0.7 ps=1.41 mult=1 m=1
xm22_p_n31 n29__t0_p_n31 wl_3__t3_p_n31 bl_0__t2_p_n31 gnd__t28_p_n31 sky130_fd_pr__nfet_01v8 L=0.15 W=0.42 nf=1 ad=0.1197 as=0.0588 pd=1.41 ps=0.7 mult=1 m=1
xm23_p_n31 bl_1__t3_p_n31 wl_2__t1_p_n31 n23__t1_p_n31 gnd__t17_p_n31 sky130_fd_pr__nfet_01v8 L=0.15 W=0.42 nf=1 ad=0.0588 as=0.1197 pd=0.7 ps=1.41 mult=1 m=1
xm24_p_n31 n30__t0_p_n31 wl_3__t2_p_n31 bl_1__t1_p_n31 gnd__t29_p_n31 sky130_fd_pr__nfet_01v8 L=0.15 W=0.42 nf=1 ad=0.1197 as=0.0588 pd=1.41 ps=0.7 mult=1 m=1
xm25_p_n31 bl_2__t3_p_n31 wl_2__t2_p_n31 n24__t1_p_n31 gnd__t18_p_n31 sky130_fd_pr__nfet_01v8 L=0.15 W=0.42 nf=1 ad=0.0588 as=0.1197 pd=0.7 ps=1.41 mult=1 m=1
xm26_p_n31 n31__t0_p_n31 wl_3__t1_p_n31 bl_2__t1_p_n31 gnd__t30_p_n31 sky130_fd_pr__nfet_01v8 L=0.15 W=0.42 nf=1 ad=0.1197 as=0.0588 pd=1.41 ps=0.7 mult=1 m=1
xm27_p_n31 bl_3__t3_p_n31 wl_2__t3_p_n31 n25__t1_p_n31 gnd__t19_p_n31 sky130_fd_pr__nfet_01v8 L=0.15 W=0.42 nf=1 ad=0.0588 as=0.1197 pd=0.7 ps=1.41 mult=1 m=1
xm28_p_n31 n32__t0_p_n31 wl_3__t0_p_n31 bl_3__t0_p_n31 gnd__t31_p_n31 sky130_fd_pr__nfet_01v8 L=0.15 W=0.42 nf=1 ad=0.1197 as=0.0588 pd=1.41 ps=0.7 mult=1 m=1
xm29_p_n31 rbl_0__t1_p_n31 n29__t1_p_n31 rwl_3__t0_p_n31 gnd__t4_p_n31 sky130_fd_pr__nfet_01v8 L=0.15 W=0.42 nf=1 ad=0.1197 as=0.1197 pd=1.41 ps=1.41 mult=1 m=1
xm30_p_n31 rbl_1__t0_p_n31 n30__t1_p_n31 rwl_3__t1_p_n31 gnd__t5_p_n31 sky130_fd_pr__nfet_01v8 L=0.15 W=0.42 nf=1 ad=0.1197 as=0.1197 pd=1.41 ps=1.41 mult=1 m=1
xm31_p_n31 rbl_2__t0_p_n31 n31__t1_p_n31 rwl_3__t2_p_n31 gnd__t6_p_n31 sky130_fd_pr__nfet_01v8 L=0.15 W=0.42 nf=1 ad=0.1197 as=0.1197 pd=1.41 ps=1.41 mult=1 m=1
xm32_p_n31 rbl_3__t0_p_n31 n32__t1_p_n31 rwl_3__t3_p_n31 gnd__t7_p_n31 sky130_fd_pr__nfet_01v8 L=0.15 W=0.42 nf=1 ad=0.1197 as=0.1197 pd=1.41 ps=1.41 mult=1 m=1
r_10_t0_p_n31 n10__t0_p_n31 n10_p_n31 183.071
r_10_t1_p_n31 n10__t1_p_n31 n10_p_n31 183.071
r_17_t0_p_n31 n17__t0_p_n31 n17_p_n31 183.071
r_17_t1_p_n31 n17__t1_p_n31 n17_p_n31 183.071
r_18_t0_p_n31 n18__t0_p_n31 n18_p_n31 183.071
r_18_t1_p_n31 n18__t1_p_n31 n18_p_n31 183.071
r_19_t0_p_n31 n19__t0_p_n31 n19_p_n31 183.071
r_19_t1_p_n31 n19__t1_p_n31 n19_p_n31 183.071
r_20_t0_p_n31 n20__t0_p_n31 n20_p_n31 183.071
r_20_t1_p_n31 n20__t1_p_n31 n20_p_n31 183.071
r_22_t0_p_n31 n22__t0_p_n31 n22_p_n31 183.071
r_22_t1_p_n31 n22__t1_p_n31 n22_p_n31 183.071
r_23_t0_p_n31 n23__t0_p_n31 n23_p_n31 183.071
r_23_t1_p_n31 n23__t1_p_n31 n23_p_n31 183.071
r_24_t0_p_n31 n24__t0_p_n31 n24_p_n31 183.071
r_24_t1_p_n31 n24__t1_p_n31 n24_p_n31 183.071
r_25_t0_p_n31 n25__t0_p_n31 n25_p_n31 183.071
r_25_t1_p_n31 n25__t1_p_n31 n25_p_n31 183.071
r_29_t0_p_n31 n29__t0_p_n31 n29_p_n31 183.071
r_29_t1_p_n31 n29__t1_p_n31 n29_p_n31 183.071
r_30_t0_p_n31 n30__t0_p_n31 n30_p_n31 183.071
r_30_t1_p_n31 n30__t1_p_n31 n30_p_n31 183.071
r_31_t0_p_n31 n31__t0_p_n31 n31_p_n31 183.071
r_31_t1_p_n31 n31__t1_p_n31 n31_p_n31 183.071
r_32_t0_p_n31 n32__t0_p_n31 n32_p_n31 183.071
r_32_t1_p_n31 n32__t1_p_n31 n32_p_n31 183.071
r_7_t0_p_n31 n7__t0_p_n31 n7_p_n31 183.071
r_7_t1_p_n31 n7__t1_p_n31 n7_p_n31 183.071
r_8_t0_p_n31 n8__t0_p_n31 n8_p_n31 183.071
r_8_t1_p_n31 n8__t1_p_n31 n8_p_n31 183.071
r_9_t0_p_n31 n9__t0_p_n31 n9_p_n31 183.071
r_9_t1_p_n31 n9__t1_p_n31 n9_p_n31 183.071
rgnd_t0_p_n31 gnd__t0_p_n31 0 38.2988
rgnd_t1_p_n31 gnd__t1_p_n31 0 33.9576
rgnd_t2_p_n31 gnd__t2_p_n31 0 33.9576
rgnd_t3_p_n31 gnd__t3_p_n31 0 38.2988
rgnd_t4_p_n31 gnd__t4_p_n31 0 38.2988
rgnd_t5_p_n31 gnd__t5_p_n31 0 33.9576
rgnd_t6_p_n31 gnd__t6_p_n31 0 33.9576
rgnd_t7_p_n31 gnd__t7_p_n31 0 38.2988
rgnd_t8_p_n31 gnd__t8_p_n31 0 28.0185
rgnd_t9_p_n31 gnd__t9_p_n31 0 21.7106
rgnd_t10_p_n31 gnd__t10_p_n31 0 21.7106
rgnd_t11_p_n31 gnd__t11_p_n31 0 28.0185
rgnd_t12_p_n31 gnd__t12_p_n31 0 18.9833
rgnd_t13_p_n31 gnd__t13_p_n31 0 6.8325
rgnd_t14_p_n31 gnd__t14_p_n31 0 6.8325
rgnd_t15_p_n31 gnd__t15_p_n31 0 18.9833
rgnd_t16_p_n31 gnd__t16_p_n31 0 24.2409
rgnd_t17_p_n31 gnd__t17_p_n31 0 16.5511
rgnd_t18_p_n31 gnd__t18_p_n31 0 16.5511
rgnd_t19_p_n31 gnd__t19_p_n31 0 24.2409
rgnd_t20_p_n31 gnd__t20_p_n31 0 24.2409
rgnd_t21_p_n31 gnd__t21_p_n31 0 16.5511
rgnd_t22_p_n31 gnd__t22_p_n31 0 16.5511
rgnd_t23_p_n31 gnd__t23_p_n31 0 24.2409
rgnd_t24_p_n31 gnd__t24_p_n31 0 18.9833
rgnd_t25_p_n31 gnd__t25_p_n31 0 6.8325
rgnd_t26_p_n31 gnd__t26_p_n31 0 6.8325
rgnd_t27_p_n31 gnd__t27_p_n31 0 18.9833
rgnd_t28_p_n31 gnd__t28_p_n31 0 28.0185
rgnd_t29_p_n31 gnd__t29_p_n31 0 21.7106
rgnd_t30_p_n31 gnd__t30_p_n31 0 21.7106
rgnd_t31_p_n31 gnd__t31_p_n31 0 28.0185
rbl_0_t0_p_n31 bl_0__t0_p_n31 bl_0_p_n31 14.8304
rbl_0_t1_p_n31 bl_0__t1_p_n31 bl_0_p_n31 10.9301
rbl_0_t2_p_n31 bl_0__t2_p_n31 bl_0_p_n31 14.8304
rbl_0_t3_p_n31 bl_0__t3_p_n31 bl_0_p_n31 10.9301
rbl_1_t0_p_n31 bl_1__t0_p_n31 bl_1_p_n31 10.9301
rbl_1_t1_p_n31 bl_1__t1_p_n31 bl_1_p_n31 14.8304
rbl_1_t2_p_n31 bl_1__t2_p_n31 bl_1_p_n31 14.8304
rbl_1_t3_p_n31 bl_1__t3_p_n31 bl_1_p_n31 10.9301
rbl_2_t0_p_n31 bl_2__t0_p_n31 bl_2_p_n31 10.9301
rbl_2_t1_p_n31 bl_2__t1_p_n31 bl_2_p_n31 14.8304
rbl_2_t2_p_n31 bl_2__t2_p_n31 bl_2_p_n31 14.8304
rbl_2_t3_p_n31 bl_2__t3_p_n31 bl_2_p_n31 10.9301
rbl_3_t0_p_n31 bl_3__t0_p_n31 bl_3_p_n31 14.8304
rbl_3_t1_p_n31 bl_3__t1_p_n31 bl_3_p_n31 10.9301
rbl_3_t2_p_n31 bl_3__t2_p_n31 bl_3_p_n31 14.8304
rbl_3_t3_p_n31 bl_3__t3_p_n31 bl_3_p_n31 10.9301
rrbl_0_t0_p_n31 rbl_0__t0_p_n31 rbl_0_p_n31 36.5601
rrbl_0_t1_p_n31 rbl_0__t1_p_n31 rbl_0_p_n31 36.5601
rrbl_0_t2_p_n31 rbl_0__t2_p_n31 rbl_0_p_n31 2.99444
rrbl_0_t3_p_n31 rbl_0__t3_p_n31 rbl_0_p_n31 2.99444
rrbl_1_t0_p_n31 rbl_1__t0_p_n31 rbl_1_p_n31 36.5601
rrbl_1_t1_p_n31 rbl_1__t1_p_n31 rbl_1_p_n31 36.5601
rrbl_1_t2_p_n31 rbl_1__t2_p_n31 rbl_1_p_n31 2.99444
rrbl_1_t3_p_n31 rbl_1__t3_p_n31 rbl_1_p_n31 2.99444
rrbl_2_t0_p_n31 rbl_2__t0_p_n31 rbl_2_p_n31 36.5601
rrbl_2_t1_p_n31 rbl_2__t1_p_n31 rbl_2_p_n31 36.5601
rrbl_2_t2_p_n31 rbl_2__t2_p_n31 rbl_2_p_n31 2.99444
rrbl_2_t3_p_n31 rbl_2__t3_p_n31 rbl_2_p_n31 2.99444
rrbl_3_t0_p_n31 rbl_3__t0_p_n31 rbl_3_p_n31 36.5601
rrbl_3_t1_p_n31 rbl_3__t1_p_n31 rbl_3_p_n31 36.5601
rrbl_3_t2_p_n31 rbl_3__t2_p_n31 rbl_3_p_n31 2.99444
rrbl_3_t3_p_n31 rbl_3__t3_p_n31 rbl_3_p_n31 2.99444
rrwl_0_t0_p_n31 rwl_0__t0_p_n31 rwl_0_p_n31 38.2618
rrwl_0_t1_p_n31 rwl_0__t1_p_n31 rwl_0_p_n31 12.7539
rrwl_0_t2_p_n31 rwl_0__t2_p_n31 rwl_0_p_n31 38.2618
rrwl_0_t3_p_n31 rwl_0__t3_p_n31 rwl_0_p_n31 12.7539
rrwl_1_t0_p_n31 rwl_1__t0_p_n31 rwl_1_p_n31 38.2618
rrwl_1_t1_p_n31 rwl_1__t1_p_n31 rwl_1_p_n31 12.7539
rrwl_1_t2_p_n31 rwl_1__t2_p_n31 rwl_1_p_n31 12.7539
rrwl_1_t3_p_n31 rwl_1__t3_p_n31 rwl_1_p_n31 38.2618
rrwl_2_t0_p_n31 rwl_2__t0_p_n31 rwl_2_p_n31 12.7539
rrwl_2_t1_p_n31 rwl_2__t1_p_n31 rwl_2_p_n31 12.7539
rrwl_2_t2_p_n31 rwl_2__t2_p_n31 rwl_2_p_n31 38.2618
rrwl_2_t3_p_n31 rwl_2__t3_p_n31 rwl_2_p_n31 38.2618
rrwl_3_t0_p_n31 rwl_3__t0_p_n31 rwl_3_p_n31 38.2618
rrwl_3_t1_p_n31 rwl_3__t1_p_n31 rwl_3_p_n31 12.7539
rrwl_3_t2_p_n31 rwl_3__t2_p_n31 rwl_3_p_n31 12.7539
rrwl_3_t3_p_n31 rwl_3__t3_p_n31 rwl_3_p_n31 38.2618
rwl_0_t0_p_n31 wl_0__t0_p_n31 wl_0_p_n31 245.959
rwl_0_t1_p_n31 wl_0__t1_p_n31 wl_0_p_n31 245.959
rwl_0_t2_p_n31 wl_0__t2_p_n31 wl_0_p_n31 81.9864
rwl_0_t3_p_n31 wl_0__t3_p_n31 wl_0_p_n31 81.9864
rwl_1_t0_p_n31 wl_1__t0_p_n31 wl_1_p_n31 245.959
rwl_1_t1_p_n31 wl_1__t1_p_n31 wl_1_p_n31 81.9864
rwl_1_t2_p_n31 wl_1__t2_p_n31 wl_1_p_n31 81.9864
rwl_1_t3_p_n31 wl_1__t3_p_n31 wl_1_p_n31 245.959
rwl_2_t0_p_n31 wl_2__t0_p_n31 wl_2_p_n31 245.959
rwl_2_t1_p_n31 wl_2__t1_p_n31 wl_2_p_n31 81.9864
rwl_2_t2_p_n31 wl_2__t2_p_n31 wl_2_p_n31 81.9864
rwl_2_t3_p_n31 wl_2__t3_p_n31 wl_2_p_n31 245.959
rwl_3_t0_p_n31 wl_3__t0_p_n31 wl_3_p_n31 245.959
rwl_3_t1_p_n31 wl_3__t1_p_n31 wl_3_p_n31 81.9864
rwl_3_t2_p_n31 wl_3__t2_p_n31 wl_3_p_n31 81.9864
rwl_3_t3_p_n31 wl_3__t3_p_n31 wl_3_p_n31 245.959
c_10_p_n31 n10_p_n31 0 2.91622e-16
c_17_p_n31 n17_p_n31 0 2.91528e-16
c_18_p_n31 n18_p_n31 0 2.91528e-16
c_19_p_n31 n19_p_n31 0 2.91528e-16
c_20_p_n31 n20_p_n31 0 2.91622e-16
c_22_p_n31 n22_p_n31 0 2.91528e-16
c_23_p_n31 n23_p_n31 0 2.91528e-16
c_24_p_n31 n24_p_n31 0 2.91528e-16
c_25_p_n31 n25_p_n31 0 2.91622e-16
c_29_p_n31 n29_p_n31 0 2.91528e-16
c_30_p_n31 n30_p_n31 0 2.91528e-16
c_31_p_n31 n31_p_n31 0 1.1371e-16
c_32_p_n31 n32_p_n31 0 2.91622e-16
c_7_p_n31 n7_p_n31 0 2.91528e-16
c_8_p_n31 n8_p_n31 0 2.91528e-16
c_9_p_n31 n9_p_n31 0 2.91528e-16
cgnd_p_n31 0 0 2.48166e-15
cbl_0_p_n31 bl_0_p_n31 0 4.52661e-16
cbl_1_p_n31 bl_1_p_n31 0 4.52661e-16
cbl_2_p_n31 bl_2_p_n31 0 4.52661e-16
cbl_3_p_n31 bl_3_p_n31 0 4.52661e-16
crbl_0_p_n31 rbl_0_p_n31 0 9.14472e-16
crbl_1_p_n31 rbl_1_p_n31 0 9.14472e-16
crbl_2_p_n31 rbl_2_p_n31 0 9.14472e-16
crbl_3_p_n31 rbl_3_p_n31 0 9.17566e-16
crwl_0_p_n31 rwl_0_p_n31 0 5.19495e-16
crwl_1_p_n31 rwl_1_p_n31 0 5.11719e-16
crwl_2_p_n31 rwl_2_p_n31 0 5.11719e-16
crwl_3_p_n31 rwl_3_p_n31 0 5.19495e-16
cwl_0_p_n31 wl_0_p_n31 0 3.30388e-16
cwl_1_p_n31 wl_1_p_n31 0 3.30388e-16
cwl_2_p_n31 wl_2_p_n31 0 3.30388e-16
cwl_3_p_n31 wl_3_p_n31 0 3.30388e-16
ccc__10__9_p_n31 n10_p_n31 n9_p_n31 1.02e-17
ccc__10_bl_3_p_n31 n10_p_n31 bl_3_p_n31 1.3999e-17
ccc__10_rwl_0_p_n31 n10_p_n31 rwl_0_p_n31 4.335e-18
ccc__17__18_p_n31 n17_p_n31 n18_p_n31 1.02e-17
ccc__17_bl_0_p_n31 n17_p_n31 bl_0_p_n31 8.415e-18
ccc__17_rwl_1_p_n31 n17_p_n31 rwl_1_p_n31 1.3194e-17
ccc__18__19_p_n31 n18_p_n31 n19_p_n31 1.02e-17
ccc__18_bl_1_p_n31 n18_p_n31 bl_1_p_n31 8.415e-18
ccc__18_rwl_1_p_n31 n18_p_n31 rwl_1_p_n31 1.3194e-17
ccc__19__20_p_n31 n19_p_n31 n20_p_n31 1.02e-17
ccc__19_bl_2_p_n31 n19_p_n31 bl_2_p_n31 8.415e-18
ccc__19_rwl_1_p_n31 n19_p_n31 rwl_1_p_n31 1.3194e-17
ccc__20_bl_3_p_n31 n20_p_n31 bl_3_p_n31 8.415e-18
ccc__20_rwl_1_p_n31 n20_p_n31 rwl_1_p_n31 6.655e-18
ccc__22__23_p_n31 n22_p_n31 n23_p_n31 1.02e-17
ccc__22_bl_0_p_n31 n22_p_n31 bl_0_p_n31 8.415e-18
ccc__22_rwl_2_p_n31 n22_p_n31 rwl_2_p_n31 1.3194e-17
ccc__23__24_p_n31 n23_p_n31 n24_p_n31 1.02e-17
ccc__23_bl_1_p_n31 n23_p_n31 bl_1_p_n31 8.415e-18
ccc__23_rwl_2_p_n31 n23_p_n31 rwl_2_p_n31 1.3194e-17
ccc__24__25_p_n31 n24_p_n31 n25_p_n31 1.02e-17
ccc__24_bl_2_p_n31 n24_p_n31 bl_2_p_n31 8.415e-18
ccc__24_rwl_2_p_n31 n24_p_n31 rwl_2_p_n31 1.3194e-17
ccc__25_bl_3_p_n31 n25_p_n31 bl_3_p_n31 8.415e-18
ccc__25_rwl_2_p_n31 n25_p_n31 rwl_2_p_n31 6.655e-18
ccc__29__30_p_n31 n29_p_n31 n30_p_n31 1.02e-17
ccc__29_bl_0_p_n31 n29_p_n31 bl_0_p_n31 8.415e-18
ccc__29_rwl_3_p_n31 n29_p_n31 rwl_3_p_n31 1.3194e-17
ccc__30__31_p_n31 n30_p_n31 n31_p_n31 1.02e-17
ccc__30_bl_1_p_n31 n30_p_n31 bl_1_p_n31 8.415e-18
ccc__30_rwl_3_p_n31 n30_p_n31 rwl_3_p_n31 1.3194e-17
ccc__31__32_p_n31 n31_p_n31 n32_p_n31 1.02e-17
ccc__31_bl_2_p_n31 n31_p_n31 bl_2_p_n31 8.415e-18
ccc__31_rwl_3_p_n31 n31_p_n31 rwl_3_p_n31 1.3194e-17
ccc__32_bl_3_p_n31 n32_p_n31 bl_3_p_n31 8.415e-18
ccc__32_rwl_3_p_n31 n32_p_n31 rwl_3_p_n31 6.655e-18
ccc__7__8_p_n31 n7_p_n31 n8_p_n31 1.02e-17
ccc__7_bl_0_p_n31 n7_p_n31 bl_0_p_n31 1.3999e-17
ccc__7_rwl_0_p_n31 n7_p_n31 rwl_0_p_n31 8.961e-18
ccc__8__9_p_n31 n8_p_n31 n9_p_n31 1.02e-17
ccc__8_bl_1_p_n31 n8_p_n31 bl_1_p_n31 1.3999e-17
ccc__8_rwl_0_p_n31 n8_p_n31 rwl_0_p_n31 8.961e-18
ccc__9_bl_2_p_n31 n9_p_n31 bl_2_p_n31 1.3999e-17
ccc__9_rwl_0_p_n31 n9_p_n31 rwl_0_p_n31 8.961e-18
ccc_bl_0_rbl_0_p_n31 bl_0_p_n31 rbl_0_p_n31 1.88693e-16
ccc_bl_0_rwl_1_p_n31 bl_0_p_n31 rwl_1_p_n31 1.0093e-17
ccc_bl_0_rwl_2_p_n31 bl_0_p_n31 rwl_2_p_n31 1.0093e-17
ccc_bl_1_rbl_0_p_n31 bl_1_p_n31 rbl_0_p_n31 1.633e-16
ccc_bl_1_rbl_1_p_n31 bl_1_p_n31 rbl_1_p_n31 1.88693e-16
ccc_bl_1_rwl_1_p_n31 bl_1_p_n31 rwl_1_p_n31 1.0093e-17
ccc_bl_1_rwl_2_p_n31 bl_1_p_n31 rwl_2_p_n31 1.0093e-17
ccc_bl_2_rbl_1_p_n31 bl_2_p_n31 rbl_1_p_n31 1.633e-16
ccc_bl_2_rbl_2_p_n31 bl_2_p_n31 rbl_2_p_n31 1.88693e-16
ccc_bl_2_rwl_1_p_n31 bl_2_p_n31 rwl_1_p_n31 1.0093e-17
ccc_bl_2_rwl_2_p_n31 bl_2_p_n31 rwl_2_p_n31 1.0093e-17
ccc_bl_3_rbl_2_p_n31 bl_3_p_n31 rbl_2_p_n31 1.633e-16
ccc_bl_3_rbl_3_p_n31 bl_3_p_n31 rbl_3_p_n31 1.88693e-16
ccc_bl_3_rwl_1_p_n31 bl_3_p_n31 rwl_1_p_n31 1.0093e-17
ccc_bl_3_rwl_2_p_n31 bl_3_p_n31 rwl_2_p_n31 1.0093e-17
ccc_rbl_0_rbl_1_p_n31 rbl_0_p_n31 rbl_1_p_n31 3.432e-17
ccc_rbl_0_rwl_0_p_n31 rbl_0_p_n31 rwl_0_p_n31 4.9752e-17
ccc_rbl_0_rwl_1_p_n31 rbl_0_p_n31 rwl_1_p_n31 4.9752e-17
ccc_rbl_0_rwl_2_p_n31 rbl_0_p_n31 rwl_2_p_n31 4.9752e-17
ccc_rbl_0_rwl_3_p_n31 rbl_0_p_n31 rwl_3_p_n31 4.9752e-17
ccc_rbl_1_rbl_2_p_n31 rbl_1_p_n31 rbl_2_p_n31 3.432e-17
ccc_rbl_1_rwl_0_p_n31 rbl_1_p_n31 rwl_0_p_n31 4.9752e-17
ccc_rbl_1_rwl_1_p_n31 rbl_1_p_n31 rwl_1_p_n31 4.9752e-17
ccc_rbl_1_rwl_2_p_n31 rbl_1_p_n31 rwl_2_p_n31 4.9752e-17
ccc_rbl_1_rwl_3_p_n31 rbl_1_p_n31 rwl_3_p_n31 4.9752e-17
ccc_rbl_2_rbl_3_p_n31 rbl_2_p_n31 rbl_3_p_n31 3.432e-17
ccc_rbl_2_rwl_0_p_n31 rbl_2_p_n31 rwl_0_p_n31 4.9752e-17
ccc_rbl_2_rwl_1_p_n31 rbl_2_p_n31 rwl_1_p_n31 4.9752e-17
ccc_rbl_2_rwl_2_p_n31 rbl_2_p_n31 rwl_2_p_n31 4.9752e-17
ccc_rbl_2_rwl_3_p_n31 rbl_2_p_n31 rwl_3_p_n31 4.9752e-17
ccc_rbl_3_rwl_0_p_n31 rbl_3_p_n31 rwl_0_p_n31 3.3407e-17
ccc_rbl_3_rwl_1_p_n31 rbl_3_p_n31 rwl_1_p_n31 3.3407e-17
ccc_rbl_3_rwl_2_p_n31 rbl_3_p_n31 rwl_2_p_n31 3.3407e-17
ccc_rbl_3_rwl_3_p_n31 rbl_3_p_n31 rwl_3_p_n31 3.3407e-17
vdw_p_n31_0 wl_0_p_n31 0 dc 0
vdr_p_n31_0 rwl_0_p_n31 vdd dc 0
vdw_p_n31_1 wl_1_p_n31 0 dc 0
vdr_p_n31_1 rwl_1_p_n31 vdd dc 0
vdw_p_n31_2 wl_2_p_n31 0 dc 0
vdr_p_n31_2 rwl_2_p_n31 vdd dc 0
vdw_p_n31_3 wl_3_p_n31 0 dc 0
vdr_p_n31_3 rwl_3_p_n31 vdd dc 0
vdb_p_n31_0 bl_0_p_n31 0 dc 0
vdp_p_n31_0 rbl_0_p_n31 vrbl dc 0
vdb_p_n31_1 bl_1_p_n31 0 dc 0
vdp_p_n31_1 rbl_1_p_n31 vrbl dc 0
vdb_p_n31_2 bl_2_p_n31 0 dc 0
vdp_p_n31_2 rbl_2_p_n31 vrbl dc 0
vdb_p_n31_3 bl_3_p_n31 0 dc 0
vdp_p_n31_3 rbl_3_p_n31 vrbl dc 0
vdn_p_n31_n7 n7_p_n31 0 dc 1
vdn_p_n31_n8 n8_p_n31 0 dc 1
vdn_p_n31_n9 n9_p_n31 0 dc 1
vdn_p_n31_n10 n10_p_n31 0 dc 1
vdn_p_n31_n17 n17_p_n31 0 dc 1
vdn_p_n31_n18 n18_p_n31 0 dc 1
vdn_p_n31_n19 n19_p_n31 0 dc 1
vdn_p_n31_n20 n20_p_n31 0 dc 1
vdn_p_n31_n22 n22_p_n31 0 dc 1
vdn_p_n31_n23 n23_p_n31 0 dc 1
vdn_p_n31_n24 n24_p_n31 0 dc 1
vdn_p_n31_n25 n25_p_n31 0 dc 1
vdn_p_n31_n29 n29_p_n31 0 dc 1
vdn_p_n31_n30 n30_p_n31 0 dc 1
vdn_p_n31_n32 n32_p_n31 0 dc 1
bdr_p_n31 n31_p_n31 0 i=5e-08*min(1,max(0,(time-1e-09)/0.2n))*0.5*(1+tanh((v(n31_p_n31)-0.05)/0.01))

* ---- instance p_n32: variant p, probed storage node \$32 ----
xm1_p_n32 rwl_0__t2_p_n32 n7__t0_p_n32 rbl_0__t0_p_n32 gnd__t0_p_n32 sky130_fd_pr__nfet_01v8 L=0.15 W=0.42 nf=1 ad=0.1197 as=0.1197 pd=1.41 ps=1.41 mult=1 m=1
xm2_p_n32 rwl_0__t3_p_n32 n8__t1_p_n32 rbl_1__t1_p_n32 gnd__t1_p_n32 sky130_fd_pr__nfet_01v8 L=0.15 W=0.42 nf=1 ad=0.1197 as=0.1197 pd=1.41 ps=1.41 mult=1 m=1
xm3_p_n32 rwl_0__t1_p_n32 n9__t1_p_n32 rbl_2__t1_p_n32 gnd__t2_p_n32 sky130_fd_pr__nfet_01v8 L=0.15 W=0.42 nf=1 ad=0.1197 as=0.1197 pd=1.41 ps=1.41 mult=1 m=1
xm4_p_n32 rwl_0__t0_p_n32 n10__t1_p_n32 rbl_3__t1_p_n32 gnd__t3_p_n32 sky130_fd_pr__nfet_01v8 L=0.15 W=0.42 nf=1 ad=0.1197 as=0.1197 pd=1.41 ps=1.41 mult=1 m=1
xm5_p_n32 bl_0__t0_p_n32 wl_0__t0_p_n32 n7__t1_p_n32 gnd__t8_p_n32 sky130_fd_pr__nfet_01v8 L=0.15 W=0.42 nf=1 ad=0.0588 as=0.1197 pd=0.7 ps=1.41 mult=1 m=1
xm6_p_n32 n17__t0_p_n32 wl_1__t0_p_n32 bl_0__t1_p_n32 gnd__t20_p_n32 sky130_fd_pr__nfet_01v8 L=0.15 W=0.42 nf=1 ad=0.1197 as=0.0588 pd=1.41 ps=0.7 mult=1 m=1
xm7_p_n32 bl_1__t2_p_n32 wl_0__t3_p_n32 n8__t0_p_n32 gnd__t9_p_n32 sky130_fd_pr__nfet_01v8 L=0.15 W=0.42 nf=1 ad=0.0588 as=0.1197 pd=0.7 ps=1.41 mult=1 m=1
xm8_p_n32 n18__t0_p_n32 wl_1__t1_p_n32 bl_1__t0_p_n32 gnd__t21_p_n32 sky130_fd_pr__nfet_01v8 L=0.15 W=0.42 nf=1 ad=0.1197 as=0.0588 pd=1.41 ps=0.7 mult=1 m=1
xm9_p_n32 bl_2__t2_p_n32 wl_0__t2_p_n32 n9__t0_p_n32 gnd__t10_p_n32 sky130_fd_pr__nfet_01v8 L=0.15 W=0.42 nf=1 ad=0.0588 as=0.1197 pd=0.7 ps=1.41 mult=1 m=1
xm10_p_n32 n19__t0_p_n32 wl_1__t2_p_n32 bl_2__t0_p_n32 gnd__t22_p_n32 sky130_fd_pr__nfet_01v8 L=0.15 W=0.42 nf=1 ad=0.1197 as=0.0588 pd=1.41 ps=0.7 mult=1 m=1
xm11_p_n32 bl_3__t2_p_n32 wl_0__t1_p_n32 n10__t0_p_n32 gnd__t11_p_n32 sky130_fd_pr__nfet_01v8 L=0.15 W=0.42 nf=1 ad=0.0588 as=0.1197 pd=0.7 ps=1.41 mult=1 m=1
xm12_p_n32 n20__t0_p_n32 wl_1__t3_p_n32 bl_3__t1_p_n32 gnd__t23_p_n32 sky130_fd_pr__nfet_01v8 L=0.15 W=0.42 nf=1 ad=0.1197 as=0.0588 pd=1.41 ps=0.7 mult=1 m=1
xm13_p_n32 rbl_0__t3_p_n32 n17__t1_p_n32 rwl_1__t0_p_n32 gnd__t12_p_n32 sky130_fd_pr__nfet_01v8 L=0.15 W=0.42 nf=1 ad=0.0588 as=0.1197 pd=0.7 ps=1.41 mult=1 m=1
xm14_p_n32 rwl_2__t3_p_n32 n22__t0_p_n32 rbl_0__t2_p_n32 gnd__t24_p_n32 sky130_fd_pr__nfet_01v8 L=0.15 W=0.42 nf=1 ad=0.1197 as=0.0588 pd=1.41 ps=0.7 mult=1 m=1
xm15_p_n32 rbl_1__t3_p_n32 n18__t1_p_n32 rwl_1__t1_p_n32 gnd__t13_p_n32 sky130_fd_pr__nfet_01v8 L=0.15 W=0.42 nf=1 ad=0.0588 as=0.1197 pd=0.7 ps=1.41 mult=1 m=1
xm16_p_n32 rwl_2__t0_p_n32 n23__t0_p_n32 rbl_1__t2_p_n32 gnd__t25_p_n32 sky130_fd_pr__nfet_01v8 L=0.15 W=0.42 nf=1 ad=0.1197 as=0.0588 pd=1.41 ps=0.7 mult=1 m=1
xm17_p_n32 rbl_2__t3_p_n32 n19__t1_p_n32 rwl_1__t2_p_n32 gnd__t14_p_n32 sky130_fd_pr__nfet_01v8 L=0.15 W=0.42 nf=1 ad=0.0588 as=0.1197 pd=0.7 ps=1.41 mult=1 m=1
xm18_p_n32 rwl_2__t1_p_n32 n24__t0_p_n32 rbl_2__t2_p_n32 gnd__t26_p_n32 sky130_fd_pr__nfet_01v8 L=0.15 W=0.42 nf=1 ad=0.1197 as=0.0588 pd=1.41 ps=0.7 mult=1 m=1
xm19_p_n32 rbl_3__t3_p_n32 n20__t1_p_n32 rwl_1__t3_p_n32 gnd__t15_p_n32 sky130_fd_pr__nfet_01v8 L=0.15 W=0.42 nf=1 ad=0.0588 as=0.1197 pd=0.7 ps=1.41 mult=1 m=1
xm20_p_n32 rwl_2__t2_p_n32 n25__t0_p_n32 rbl_3__t2_p_n32 gnd__t27_p_n32 sky130_fd_pr__nfet_01v8 L=0.15 W=0.42 nf=1 ad=0.1197 as=0.0588 pd=1.41 ps=0.7 mult=1 m=1
xm21_p_n32 bl_0__t3_p_n32 wl_2__t0_p_n32 n22__t1_p_n32 gnd__t16_p_n32 sky130_fd_pr__nfet_01v8 L=0.15 W=0.42 nf=1 ad=0.0588 as=0.1197 pd=0.7 ps=1.41 mult=1 m=1
xm22_p_n32 n29__t0_p_n32 wl_3__t3_p_n32 bl_0__t2_p_n32 gnd__t28_p_n32 sky130_fd_pr__nfet_01v8 L=0.15 W=0.42 nf=1 ad=0.1197 as=0.0588 pd=1.41 ps=0.7 mult=1 m=1
xm23_p_n32 bl_1__t3_p_n32 wl_2__t1_p_n32 n23__t1_p_n32 gnd__t17_p_n32 sky130_fd_pr__nfet_01v8 L=0.15 W=0.42 nf=1 ad=0.0588 as=0.1197 pd=0.7 ps=1.41 mult=1 m=1
xm24_p_n32 n30__t0_p_n32 wl_3__t2_p_n32 bl_1__t1_p_n32 gnd__t29_p_n32 sky130_fd_pr__nfet_01v8 L=0.15 W=0.42 nf=1 ad=0.1197 as=0.0588 pd=1.41 ps=0.7 mult=1 m=1
xm25_p_n32 bl_2__t3_p_n32 wl_2__t2_p_n32 n24__t1_p_n32 gnd__t18_p_n32 sky130_fd_pr__nfet_01v8 L=0.15 W=0.42 nf=1 ad=0.0588 as=0.1197 pd=0.7 ps=1.41 mult=1 m=1
xm26_p_n32 n31__t0_p_n32 wl_3__t1_p_n32 bl_2__t1_p_n32 gnd__t30_p_n32 sky130_fd_pr__nfet_01v8 L=0.15 W=0.42 nf=1 ad=0.1197 as=0.0588 pd=1.41 ps=0.7 mult=1 m=1
xm27_p_n32 bl_3__t3_p_n32 wl_2__t3_p_n32 n25__t1_p_n32 gnd__t19_p_n32 sky130_fd_pr__nfet_01v8 L=0.15 W=0.42 nf=1 ad=0.0588 as=0.1197 pd=0.7 ps=1.41 mult=1 m=1
xm28_p_n32 n32__t0_p_n32 wl_3__t0_p_n32 bl_3__t0_p_n32 gnd__t31_p_n32 sky130_fd_pr__nfet_01v8 L=0.15 W=0.42 nf=1 ad=0.1197 as=0.0588 pd=1.41 ps=0.7 mult=1 m=1
xm29_p_n32 rbl_0__t1_p_n32 n29__t1_p_n32 rwl_3__t0_p_n32 gnd__t4_p_n32 sky130_fd_pr__nfet_01v8 L=0.15 W=0.42 nf=1 ad=0.1197 as=0.1197 pd=1.41 ps=1.41 mult=1 m=1
xm30_p_n32 rbl_1__t0_p_n32 n30__t1_p_n32 rwl_3__t1_p_n32 gnd__t5_p_n32 sky130_fd_pr__nfet_01v8 L=0.15 W=0.42 nf=1 ad=0.1197 as=0.1197 pd=1.41 ps=1.41 mult=1 m=1
xm31_p_n32 rbl_2__t0_p_n32 n31__t1_p_n32 rwl_3__t2_p_n32 gnd__t6_p_n32 sky130_fd_pr__nfet_01v8 L=0.15 W=0.42 nf=1 ad=0.1197 as=0.1197 pd=1.41 ps=1.41 mult=1 m=1
xm32_p_n32 rbl_3__t0_p_n32 n32__t1_p_n32 rwl_3__t3_p_n32 gnd__t7_p_n32 sky130_fd_pr__nfet_01v8 L=0.15 W=0.42 nf=1 ad=0.1197 as=0.1197 pd=1.41 ps=1.41 mult=1 m=1
r_10_t0_p_n32 n10__t0_p_n32 n10_p_n32 183.071
r_10_t1_p_n32 n10__t1_p_n32 n10_p_n32 183.071
r_17_t0_p_n32 n17__t0_p_n32 n17_p_n32 183.071
r_17_t1_p_n32 n17__t1_p_n32 n17_p_n32 183.071
r_18_t0_p_n32 n18__t0_p_n32 n18_p_n32 183.071
r_18_t1_p_n32 n18__t1_p_n32 n18_p_n32 183.071
r_19_t0_p_n32 n19__t0_p_n32 n19_p_n32 183.071
r_19_t1_p_n32 n19__t1_p_n32 n19_p_n32 183.071
r_20_t0_p_n32 n20__t0_p_n32 n20_p_n32 183.071
r_20_t1_p_n32 n20__t1_p_n32 n20_p_n32 183.071
r_22_t0_p_n32 n22__t0_p_n32 n22_p_n32 183.071
r_22_t1_p_n32 n22__t1_p_n32 n22_p_n32 183.071
r_23_t0_p_n32 n23__t0_p_n32 n23_p_n32 183.071
r_23_t1_p_n32 n23__t1_p_n32 n23_p_n32 183.071
r_24_t0_p_n32 n24__t0_p_n32 n24_p_n32 183.071
r_24_t1_p_n32 n24__t1_p_n32 n24_p_n32 183.071
r_25_t0_p_n32 n25__t0_p_n32 n25_p_n32 183.071
r_25_t1_p_n32 n25__t1_p_n32 n25_p_n32 183.071
r_29_t0_p_n32 n29__t0_p_n32 n29_p_n32 183.071
r_29_t1_p_n32 n29__t1_p_n32 n29_p_n32 183.071
r_30_t0_p_n32 n30__t0_p_n32 n30_p_n32 183.071
r_30_t1_p_n32 n30__t1_p_n32 n30_p_n32 183.071
r_31_t0_p_n32 n31__t0_p_n32 n31_p_n32 183.071
r_31_t1_p_n32 n31__t1_p_n32 n31_p_n32 183.071
r_32_t0_p_n32 n32__t0_p_n32 n32_p_n32 183.071
r_32_t1_p_n32 n32__t1_p_n32 n32_p_n32 183.071
r_7_t0_p_n32 n7__t0_p_n32 n7_p_n32 183.071
r_7_t1_p_n32 n7__t1_p_n32 n7_p_n32 183.071
r_8_t0_p_n32 n8__t0_p_n32 n8_p_n32 183.071
r_8_t1_p_n32 n8__t1_p_n32 n8_p_n32 183.071
r_9_t0_p_n32 n9__t0_p_n32 n9_p_n32 183.071
r_9_t1_p_n32 n9__t1_p_n32 n9_p_n32 183.071
rgnd_t0_p_n32 gnd__t0_p_n32 0 38.2988
rgnd_t1_p_n32 gnd__t1_p_n32 0 33.9576
rgnd_t2_p_n32 gnd__t2_p_n32 0 33.9576
rgnd_t3_p_n32 gnd__t3_p_n32 0 38.2988
rgnd_t4_p_n32 gnd__t4_p_n32 0 38.2988
rgnd_t5_p_n32 gnd__t5_p_n32 0 33.9576
rgnd_t6_p_n32 gnd__t6_p_n32 0 33.9576
rgnd_t7_p_n32 gnd__t7_p_n32 0 38.2988
rgnd_t8_p_n32 gnd__t8_p_n32 0 28.0185
rgnd_t9_p_n32 gnd__t9_p_n32 0 21.7106
rgnd_t10_p_n32 gnd__t10_p_n32 0 21.7106
rgnd_t11_p_n32 gnd__t11_p_n32 0 28.0185
rgnd_t12_p_n32 gnd__t12_p_n32 0 18.9833
rgnd_t13_p_n32 gnd__t13_p_n32 0 6.8325
rgnd_t14_p_n32 gnd__t14_p_n32 0 6.8325
rgnd_t15_p_n32 gnd__t15_p_n32 0 18.9833
rgnd_t16_p_n32 gnd__t16_p_n32 0 24.2409
rgnd_t17_p_n32 gnd__t17_p_n32 0 16.5511
rgnd_t18_p_n32 gnd__t18_p_n32 0 16.5511
rgnd_t19_p_n32 gnd__t19_p_n32 0 24.2409
rgnd_t20_p_n32 gnd__t20_p_n32 0 24.2409
rgnd_t21_p_n32 gnd__t21_p_n32 0 16.5511
rgnd_t22_p_n32 gnd__t22_p_n32 0 16.5511
rgnd_t23_p_n32 gnd__t23_p_n32 0 24.2409
rgnd_t24_p_n32 gnd__t24_p_n32 0 18.9833
rgnd_t25_p_n32 gnd__t25_p_n32 0 6.8325
rgnd_t26_p_n32 gnd__t26_p_n32 0 6.8325
rgnd_t27_p_n32 gnd__t27_p_n32 0 18.9833
rgnd_t28_p_n32 gnd__t28_p_n32 0 28.0185
rgnd_t29_p_n32 gnd__t29_p_n32 0 21.7106
rgnd_t30_p_n32 gnd__t30_p_n32 0 21.7106
rgnd_t31_p_n32 gnd__t31_p_n32 0 28.0185
rbl_0_t0_p_n32 bl_0__t0_p_n32 bl_0_p_n32 14.8304
rbl_0_t1_p_n32 bl_0__t1_p_n32 bl_0_p_n32 10.9301
rbl_0_t2_p_n32 bl_0__t2_p_n32 bl_0_p_n32 14.8304
rbl_0_t3_p_n32 bl_0__t3_p_n32 bl_0_p_n32 10.9301
rbl_1_t0_p_n32 bl_1__t0_p_n32 bl_1_p_n32 10.9301
rbl_1_t1_p_n32 bl_1__t1_p_n32 bl_1_p_n32 14.8304
rbl_1_t2_p_n32 bl_1__t2_p_n32 bl_1_p_n32 14.8304
rbl_1_t3_p_n32 bl_1__t3_p_n32 bl_1_p_n32 10.9301
rbl_2_t0_p_n32 bl_2__t0_p_n32 bl_2_p_n32 10.9301
rbl_2_t1_p_n32 bl_2__t1_p_n32 bl_2_p_n32 14.8304
rbl_2_t2_p_n32 bl_2__t2_p_n32 bl_2_p_n32 14.8304
rbl_2_t3_p_n32 bl_2__t3_p_n32 bl_2_p_n32 10.9301
rbl_3_t0_p_n32 bl_3__t0_p_n32 bl_3_p_n32 14.8304
rbl_3_t1_p_n32 bl_3__t1_p_n32 bl_3_p_n32 10.9301
rbl_3_t2_p_n32 bl_3__t2_p_n32 bl_3_p_n32 14.8304
rbl_3_t3_p_n32 bl_3__t3_p_n32 bl_3_p_n32 10.9301
rrbl_0_t0_p_n32 rbl_0__t0_p_n32 rbl_0_p_n32 36.5601
rrbl_0_t1_p_n32 rbl_0__t1_p_n32 rbl_0_p_n32 36.5601
rrbl_0_t2_p_n32 rbl_0__t2_p_n32 rbl_0_p_n32 2.99444
rrbl_0_t3_p_n32 rbl_0__t3_p_n32 rbl_0_p_n32 2.99444
rrbl_1_t0_p_n32 rbl_1__t0_p_n32 rbl_1_p_n32 36.5601
rrbl_1_t1_p_n32 rbl_1__t1_p_n32 rbl_1_p_n32 36.5601
rrbl_1_t2_p_n32 rbl_1__t2_p_n32 rbl_1_p_n32 2.99444
rrbl_1_t3_p_n32 rbl_1__t3_p_n32 rbl_1_p_n32 2.99444
rrbl_2_t0_p_n32 rbl_2__t0_p_n32 rbl_2_p_n32 36.5601
rrbl_2_t1_p_n32 rbl_2__t1_p_n32 rbl_2_p_n32 36.5601
rrbl_2_t2_p_n32 rbl_2__t2_p_n32 rbl_2_p_n32 2.99444
rrbl_2_t3_p_n32 rbl_2__t3_p_n32 rbl_2_p_n32 2.99444
rrbl_3_t0_p_n32 rbl_3__t0_p_n32 rbl_3_p_n32 36.5601
rrbl_3_t1_p_n32 rbl_3__t1_p_n32 rbl_3_p_n32 36.5601
rrbl_3_t2_p_n32 rbl_3__t2_p_n32 rbl_3_p_n32 2.99444
rrbl_3_t3_p_n32 rbl_3__t3_p_n32 rbl_3_p_n32 2.99444
rrwl_0_t0_p_n32 rwl_0__t0_p_n32 rwl_0_p_n32 38.2618
rrwl_0_t1_p_n32 rwl_0__t1_p_n32 rwl_0_p_n32 12.7539
rrwl_0_t2_p_n32 rwl_0__t2_p_n32 rwl_0_p_n32 38.2618
rrwl_0_t3_p_n32 rwl_0__t3_p_n32 rwl_0_p_n32 12.7539
rrwl_1_t0_p_n32 rwl_1__t0_p_n32 rwl_1_p_n32 38.2618
rrwl_1_t1_p_n32 rwl_1__t1_p_n32 rwl_1_p_n32 12.7539
rrwl_1_t2_p_n32 rwl_1__t2_p_n32 rwl_1_p_n32 12.7539
rrwl_1_t3_p_n32 rwl_1__t3_p_n32 rwl_1_p_n32 38.2618
rrwl_2_t0_p_n32 rwl_2__t0_p_n32 rwl_2_p_n32 12.7539
rrwl_2_t1_p_n32 rwl_2__t1_p_n32 rwl_2_p_n32 12.7539
rrwl_2_t2_p_n32 rwl_2__t2_p_n32 rwl_2_p_n32 38.2618
rrwl_2_t3_p_n32 rwl_2__t3_p_n32 rwl_2_p_n32 38.2618
rrwl_3_t0_p_n32 rwl_3__t0_p_n32 rwl_3_p_n32 38.2618
rrwl_3_t1_p_n32 rwl_3__t1_p_n32 rwl_3_p_n32 12.7539
rrwl_3_t2_p_n32 rwl_3__t2_p_n32 rwl_3_p_n32 12.7539
rrwl_3_t3_p_n32 rwl_3__t3_p_n32 rwl_3_p_n32 38.2618
rwl_0_t0_p_n32 wl_0__t0_p_n32 wl_0_p_n32 245.959
rwl_0_t1_p_n32 wl_0__t1_p_n32 wl_0_p_n32 245.959
rwl_0_t2_p_n32 wl_0__t2_p_n32 wl_0_p_n32 81.9864
rwl_0_t3_p_n32 wl_0__t3_p_n32 wl_0_p_n32 81.9864
rwl_1_t0_p_n32 wl_1__t0_p_n32 wl_1_p_n32 245.959
rwl_1_t1_p_n32 wl_1__t1_p_n32 wl_1_p_n32 81.9864
rwl_1_t2_p_n32 wl_1__t2_p_n32 wl_1_p_n32 81.9864
rwl_1_t3_p_n32 wl_1__t3_p_n32 wl_1_p_n32 245.959
rwl_2_t0_p_n32 wl_2__t0_p_n32 wl_2_p_n32 245.959
rwl_2_t1_p_n32 wl_2__t1_p_n32 wl_2_p_n32 81.9864
rwl_2_t2_p_n32 wl_2__t2_p_n32 wl_2_p_n32 81.9864
rwl_2_t3_p_n32 wl_2__t3_p_n32 wl_2_p_n32 245.959
rwl_3_t0_p_n32 wl_3__t0_p_n32 wl_3_p_n32 245.959
rwl_3_t1_p_n32 wl_3__t1_p_n32 wl_3_p_n32 81.9864
rwl_3_t2_p_n32 wl_3__t2_p_n32 wl_3_p_n32 81.9864
rwl_3_t3_p_n32 wl_3__t3_p_n32 wl_3_p_n32 245.959
c_10_p_n32 n10_p_n32 0 2.91622e-16
c_17_p_n32 n17_p_n32 0 2.91528e-16
c_18_p_n32 n18_p_n32 0 2.91528e-16
c_19_p_n32 n19_p_n32 0 2.91528e-16
c_20_p_n32 n20_p_n32 0 2.91622e-16
c_22_p_n32 n22_p_n32 0 2.91528e-16
c_23_p_n32 n23_p_n32 0 2.91528e-16
c_24_p_n32 n24_p_n32 0 2.91528e-16
c_25_p_n32 n25_p_n32 0 2.91622e-16
c_29_p_n32 n29_p_n32 0 2.91528e-16
c_30_p_n32 n30_p_n32 0 2.91528e-16
c_31_p_n32 n31_p_n32 0 2.91528e-16
c_32_p_n32 n32_p_n32 0 1.13804e-16
c_7_p_n32 n7_p_n32 0 2.91528e-16
c_8_p_n32 n8_p_n32 0 2.91528e-16
c_9_p_n32 n9_p_n32 0 2.91528e-16
cgnd_p_n32 0 0 2.48166e-15
cbl_0_p_n32 bl_0_p_n32 0 4.52661e-16
cbl_1_p_n32 bl_1_p_n32 0 4.52661e-16
cbl_2_p_n32 bl_2_p_n32 0 4.52661e-16
cbl_3_p_n32 bl_3_p_n32 0 4.52661e-16
crbl_0_p_n32 rbl_0_p_n32 0 9.14472e-16
crbl_1_p_n32 rbl_1_p_n32 0 9.14472e-16
crbl_2_p_n32 rbl_2_p_n32 0 9.14472e-16
crbl_3_p_n32 rbl_3_p_n32 0 9.17566e-16
crwl_0_p_n32 rwl_0_p_n32 0 5.19495e-16
crwl_1_p_n32 rwl_1_p_n32 0 5.11719e-16
crwl_2_p_n32 rwl_2_p_n32 0 5.11719e-16
crwl_3_p_n32 rwl_3_p_n32 0 5.19495e-16
cwl_0_p_n32 wl_0_p_n32 0 3.30388e-16
cwl_1_p_n32 wl_1_p_n32 0 3.30388e-16
cwl_2_p_n32 wl_2_p_n32 0 3.30388e-16
cwl_3_p_n32 wl_3_p_n32 0 3.30388e-16
ccc__10__9_p_n32 n10_p_n32 n9_p_n32 1.02e-17
ccc__10_bl_3_p_n32 n10_p_n32 bl_3_p_n32 1.3999e-17
ccc__10_rwl_0_p_n32 n10_p_n32 rwl_0_p_n32 4.335e-18
ccc__17__18_p_n32 n17_p_n32 n18_p_n32 1.02e-17
ccc__17_bl_0_p_n32 n17_p_n32 bl_0_p_n32 8.415e-18
ccc__17_rwl_1_p_n32 n17_p_n32 rwl_1_p_n32 1.3194e-17
ccc__18__19_p_n32 n18_p_n32 n19_p_n32 1.02e-17
ccc__18_bl_1_p_n32 n18_p_n32 bl_1_p_n32 8.415e-18
ccc__18_rwl_1_p_n32 n18_p_n32 rwl_1_p_n32 1.3194e-17
ccc__19__20_p_n32 n19_p_n32 n20_p_n32 1.02e-17
ccc__19_bl_2_p_n32 n19_p_n32 bl_2_p_n32 8.415e-18
ccc__19_rwl_1_p_n32 n19_p_n32 rwl_1_p_n32 1.3194e-17
ccc__20_bl_3_p_n32 n20_p_n32 bl_3_p_n32 8.415e-18
ccc__20_rwl_1_p_n32 n20_p_n32 rwl_1_p_n32 6.655e-18
ccc__22__23_p_n32 n22_p_n32 n23_p_n32 1.02e-17
ccc__22_bl_0_p_n32 n22_p_n32 bl_0_p_n32 8.415e-18
ccc__22_rwl_2_p_n32 n22_p_n32 rwl_2_p_n32 1.3194e-17
ccc__23__24_p_n32 n23_p_n32 n24_p_n32 1.02e-17
ccc__23_bl_1_p_n32 n23_p_n32 bl_1_p_n32 8.415e-18
ccc__23_rwl_2_p_n32 n23_p_n32 rwl_2_p_n32 1.3194e-17
ccc__24__25_p_n32 n24_p_n32 n25_p_n32 1.02e-17
ccc__24_bl_2_p_n32 n24_p_n32 bl_2_p_n32 8.415e-18
ccc__24_rwl_2_p_n32 n24_p_n32 rwl_2_p_n32 1.3194e-17
ccc__25_bl_3_p_n32 n25_p_n32 bl_3_p_n32 8.415e-18
ccc__25_rwl_2_p_n32 n25_p_n32 rwl_2_p_n32 6.655e-18
ccc__29__30_p_n32 n29_p_n32 n30_p_n32 1.02e-17
ccc__29_bl_0_p_n32 n29_p_n32 bl_0_p_n32 8.415e-18
ccc__29_rwl_3_p_n32 n29_p_n32 rwl_3_p_n32 1.3194e-17
ccc__30__31_p_n32 n30_p_n32 n31_p_n32 1.02e-17
ccc__30_bl_1_p_n32 n30_p_n32 bl_1_p_n32 8.415e-18
ccc__30_rwl_3_p_n32 n30_p_n32 rwl_3_p_n32 1.3194e-17
ccc__31__32_p_n32 n31_p_n32 n32_p_n32 1.02e-17
ccc__31_bl_2_p_n32 n31_p_n32 bl_2_p_n32 8.415e-18
ccc__31_rwl_3_p_n32 n31_p_n32 rwl_3_p_n32 1.3194e-17
ccc__32_bl_3_p_n32 n32_p_n32 bl_3_p_n32 8.415e-18
ccc__32_rwl_3_p_n32 n32_p_n32 rwl_3_p_n32 6.655e-18
ccc__7__8_p_n32 n7_p_n32 n8_p_n32 1.02e-17
ccc__7_bl_0_p_n32 n7_p_n32 bl_0_p_n32 1.3999e-17
ccc__7_rwl_0_p_n32 n7_p_n32 rwl_0_p_n32 8.961e-18
ccc__8__9_p_n32 n8_p_n32 n9_p_n32 1.02e-17
ccc__8_bl_1_p_n32 n8_p_n32 bl_1_p_n32 1.3999e-17
ccc__8_rwl_0_p_n32 n8_p_n32 rwl_0_p_n32 8.961e-18
ccc__9_bl_2_p_n32 n9_p_n32 bl_2_p_n32 1.3999e-17
ccc__9_rwl_0_p_n32 n9_p_n32 rwl_0_p_n32 8.961e-18
ccc_bl_0_rbl_0_p_n32 bl_0_p_n32 rbl_0_p_n32 1.88693e-16
ccc_bl_0_rwl_1_p_n32 bl_0_p_n32 rwl_1_p_n32 1.0093e-17
ccc_bl_0_rwl_2_p_n32 bl_0_p_n32 rwl_2_p_n32 1.0093e-17
ccc_bl_1_rbl_0_p_n32 bl_1_p_n32 rbl_0_p_n32 1.633e-16
ccc_bl_1_rbl_1_p_n32 bl_1_p_n32 rbl_1_p_n32 1.88693e-16
ccc_bl_1_rwl_1_p_n32 bl_1_p_n32 rwl_1_p_n32 1.0093e-17
ccc_bl_1_rwl_2_p_n32 bl_1_p_n32 rwl_2_p_n32 1.0093e-17
ccc_bl_2_rbl_1_p_n32 bl_2_p_n32 rbl_1_p_n32 1.633e-16
ccc_bl_2_rbl_2_p_n32 bl_2_p_n32 rbl_2_p_n32 1.88693e-16
ccc_bl_2_rwl_1_p_n32 bl_2_p_n32 rwl_1_p_n32 1.0093e-17
ccc_bl_2_rwl_2_p_n32 bl_2_p_n32 rwl_2_p_n32 1.0093e-17
ccc_bl_3_rbl_2_p_n32 bl_3_p_n32 rbl_2_p_n32 1.633e-16
ccc_bl_3_rbl_3_p_n32 bl_3_p_n32 rbl_3_p_n32 1.88693e-16
ccc_bl_3_rwl_1_p_n32 bl_3_p_n32 rwl_1_p_n32 1.0093e-17
ccc_bl_3_rwl_2_p_n32 bl_3_p_n32 rwl_2_p_n32 1.0093e-17
ccc_rbl_0_rbl_1_p_n32 rbl_0_p_n32 rbl_1_p_n32 3.432e-17
ccc_rbl_0_rwl_0_p_n32 rbl_0_p_n32 rwl_0_p_n32 4.9752e-17
ccc_rbl_0_rwl_1_p_n32 rbl_0_p_n32 rwl_1_p_n32 4.9752e-17
ccc_rbl_0_rwl_2_p_n32 rbl_0_p_n32 rwl_2_p_n32 4.9752e-17
ccc_rbl_0_rwl_3_p_n32 rbl_0_p_n32 rwl_3_p_n32 4.9752e-17
ccc_rbl_1_rbl_2_p_n32 rbl_1_p_n32 rbl_2_p_n32 3.432e-17
ccc_rbl_1_rwl_0_p_n32 rbl_1_p_n32 rwl_0_p_n32 4.9752e-17
ccc_rbl_1_rwl_1_p_n32 rbl_1_p_n32 rwl_1_p_n32 4.9752e-17
ccc_rbl_1_rwl_2_p_n32 rbl_1_p_n32 rwl_2_p_n32 4.9752e-17
ccc_rbl_1_rwl_3_p_n32 rbl_1_p_n32 rwl_3_p_n32 4.9752e-17
ccc_rbl_2_rbl_3_p_n32 rbl_2_p_n32 rbl_3_p_n32 3.432e-17
ccc_rbl_2_rwl_0_p_n32 rbl_2_p_n32 rwl_0_p_n32 4.9752e-17
ccc_rbl_2_rwl_1_p_n32 rbl_2_p_n32 rwl_1_p_n32 4.9752e-17
ccc_rbl_2_rwl_2_p_n32 rbl_2_p_n32 rwl_2_p_n32 4.9752e-17
ccc_rbl_2_rwl_3_p_n32 rbl_2_p_n32 rwl_3_p_n32 4.9752e-17
ccc_rbl_3_rwl_0_p_n32 rbl_3_p_n32 rwl_0_p_n32 3.3407e-17
ccc_rbl_3_rwl_1_p_n32 rbl_3_p_n32 rwl_1_p_n32 3.3407e-17
ccc_rbl_3_rwl_2_p_n32 rbl_3_p_n32 rwl_2_p_n32 3.3407e-17
ccc_rbl_3_rwl_3_p_n32 rbl_3_p_n32 rwl_3_p_n32 3.3407e-17
vdw_p_n32_0 wl_0_p_n32 0 dc 0
vdr_p_n32_0 rwl_0_p_n32 vdd dc 0
vdw_p_n32_1 wl_1_p_n32 0 dc 0
vdr_p_n32_1 rwl_1_p_n32 vdd dc 0
vdw_p_n32_2 wl_2_p_n32 0 dc 0
vdr_p_n32_2 rwl_2_p_n32 vdd dc 0
vdw_p_n32_3 wl_3_p_n32 0 dc 0
vdr_p_n32_3 rwl_3_p_n32 vdd dc 0
vdb_p_n32_0 bl_0_p_n32 0 dc 0
vdp_p_n32_0 rbl_0_p_n32 vrbl dc 0
vdb_p_n32_1 bl_1_p_n32 0 dc 0
vdp_p_n32_1 rbl_1_p_n32 vrbl dc 0
vdb_p_n32_2 bl_2_p_n32 0 dc 0
vdp_p_n32_2 rbl_2_p_n32 vrbl dc 0
vdb_p_n32_3 bl_3_p_n32 0 dc 0
vdp_p_n32_3 rbl_3_p_n32 vrbl dc 0
vdn_p_n32_n7 n7_p_n32 0 dc 1
vdn_p_n32_n8 n8_p_n32 0 dc 1
vdn_p_n32_n9 n9_p_n32 0 dc 1
vdn_p_n32_n10 n10_p_n32 0 dc 1
vdn_p_n32_n17 n17_p_n32 0 dc 1
vdn_p_n32_n18 n18_p_n32 0 dc 1
vdn_p_n32_n19 n19_p_n32 0 dc 1
vdn_p_n32_n20 n20_p_n32 0 dc 1
vdn_p_n32_n22 n22_p_n32 0 dc 1
vdn_p_n32_n23 n23_p_n32 0 dc 1
vdn_p_n32_n24 n24_p_n32 0 dc 1
vdn_p_n32_n25 n25_p_n32 0 dc 1
vdn_p_n32_n29 n29_p_n32 0 dc 1
vdn_p_n32_n30 n30_p_n32 0 dc 1
vdn_p_n32_n31 n31_p_n32 0 dc 1
bdr_p_n32 n32_p_n32 0 i=5e-08*min(1,max(0,(time-1e-09)/0.2n))*0.5*(1+tanh((v(n32_p_n32)-0.05)/0.01))

* ---- instance b_n7: variant b, probed storage node \$7 ----
xm1_b_n7 rwl_0__t2_b_n7 n7__t0_b_n7 rbl_0__t0_b_n7 gnd__t0_b_n7 sky130_fd_pr__nfet_01v8 L=0.15 W=0.42 nf=1 ad=0.1197 as=0.1197 pd=1.41 ps=1.41 mult=1 m=1
xm2_b_n7 rwl_0__t3_b_n7 n8__t1_b_n7 rbl_1__t1_b_n7 gnd__t1_b_n7 sky130_fd_pr__nfet_01v8 L=0.15 W=0.42 nf=1 ad=0.1197 as=0.1197 pd=1.41 ps=1.41 mult=1 m=1
xm3_b_n7 rwl_0__t1_b_n7 n9__t1_b_n7 rbl_2__t1_b_n7 gnd__t2_b_n7 sky130_fd_pr__nfet_01v8 L=0.15 W=0.42 nf=1 ad=0.1197 as=0.1197 pd=1.41 ps=1.41 mult=1 m=1
xm4_b_n7 rwl_0__t0_b_n7 n10__t1_b_n7 rbl_3__t1_b_n7 gnd__t3_b_n7 sky130_fd_pr__nfet_01v8 L=0.15 W=0.42 nf=1 ad=0.1197 as=0.1197 pd=1.41 ps=1.41 mult=1 m=1
xm5_b_n7 bl_0__t0_b_n7 wl_0__t0_b_n7 n7__t1_b_n7 gnd__t8_b_n7 sky130_fd_pr__nfet_01v8 L=0.15 W=0.42 nf=1 ad=0.0588 as=0.1197 pd=0.7 ps=1.41 mult=1 m=1
xm6_b_n7 n17__t0_b_n7 wl_1__t0_b_n7 bl_0__t1_b_n7 gnd__t20_b_n7 sky130_fd_pr__nfet_01v8 L=0.15 W=0.42 nf=1 ad=0.1197 as=0.0588 pd=1.41 ps=0.7 mult=1 m=1
xm7_b_n7 bl_1__t2_b_n7 wl_0__t3_b_n7 n8__t0_b_n7 gnd__t9_b_n7 sky130_fd_pr__nfet_01v8 L=0.15 W=0.42 nf=1 ad=0.0588 as=0.1197 pd=0.7 ps=1.41 mult=1 m=1
xm8_b_n7 n18__t0_b_n7 wl_1__t1_b_n7 bl_1__t0_b_n7 gnd__t21_b_n7 sky130_fd_pr__nfet_01v8 L=0.15 W=0.42 nf=1 ad=0.1197 as=0.0588 pd=1.41 ps=0.7 mult=1 m=1
xm9_b_n7 bl_2__t2_b_n7 wl_0__t2_b_n7 n9__t0_b_n7 gnd__t10_b_n7 sky130_fd_pr__nfet_01v8 L=0.15 W=0.42 nf=1 ad=0.0588 as=0.1197 pd=0.7 ps=1.41 mult=1 m=1
xm10_b_n7 n19__t0_b_n7 wl_1__t2_b_n7 bl_2__t0_b_n7 gnd__t22_b_n7 sky130_fd_pr__nfet_01v8 L=0.15 W=0.42 nf=1 ad=0.1197 as=0.0588 pd=1.41 ps=0.7 mult=1 m=1
xm11_b_n7 bl_3__t2_b_n7 wl_0__t1_b_n7 n10__t0_b_n7 gnd__t11_b_n7 sky130_fd_pr__nfet_01v8 L=0.15 W=0.42 nf=1 ad=0.0588 as=0.1197 pd=0.7 ps=1.41 mult=1 m=1
xm12_b_n7 n20__t0_b_n7 wl_1__t3_b_n7 bl_3__t1_b_n7 gnd__t23_b_n7 sky130_fd_pr__nfet_01v8 L=0.15 W=0.42 nf=1 ad=0.1197 as=0.0588 pd=1.41 ps=0.7 mult=1 m=1
xm13_b_n7 rbl_0__t3_b_n7 n17__t1_b_n7 rwl_1__t0_b_n7 gnd__t12_b_n7 sky130_fd_pr__nfet_01v8 L=0.15 W=0.42 nf=1 ad=0.0588 as=0.1197 pd=0.7 ps=1.41 mult=1 m=1
xm14_b_n7 rwl_2__t3_b_n7 n22__t0_b_n7 rbl_0__t2_b_n7 gnd__t24_b_n7 sky130_fd_pr__nfet_01v8 L=0.15 W=0.42 nf=1 ad=0.1197 as=0.0588 pd=1.41 ps=0.7 mult=1 m=1
xm15_b_n7 rbl_1__t3_b_n7 n18__t1_b_n7 rwl_1__t1_b_n7 gnd__t13_b_n7 sky130_fd_pr__nfet_01v8 L=0.15 W=0.42 nf=1 ad=0.0588 as=0.1197 pd=0.7 ps=1.41 mult=1 m=1
xm16_b_n7 rwl_2__t0_b_n7 n23__t0_b_n7 rbl_1__t2_b_n7 gnd__t25_b_n7 sky130_fd_pr__nfet_01v8 L=0.15 W=0.42 nf=1 ad=0.1197 as=0.0588 pd=1.41 ps=0.7 mult=1 m=1
xm17_b_n7 rbl_2__t3_b_n7 n19__t1_b_n7 rwl_1__t2_b_n7 gnd__t14_b_n7 sky130_fd_pr__nfet_01v8 L=0.15 W=0.42 nf=1 ad=0.0588 as=0.1197 pd=0.7 ps=1.41 mult=1 m=1
xm18_b_n7 rwl_2__t1_b_n7 n24__t0_b_n7 rbl_2__t2_b_n7 gnd__t26_b_n7 sky130_fd_pr__nfet_01v8 L=0.15 W=0.42 nf=1 ad=0.1197 as=0.0588 pd=1.41 ps=0.7 mult=1 m=1
xm19_b_n7 rbl_3__t3_b_n7 n20__t1_b_n7 rwl_1__t3_b_n7 gnd__t15_b_n7 sky130_fd_pr__nfet_01v8 L=0.15 W=0.42 nf=1 ad=0.0588 as=0.1197 pd=0.7 ps=1.41 mult=1 m=1
xm20_b_n7 rwl_2__t2_b_n7 n25__t0_b_n7 rbl_3__t2_b_n7 gnd__t27_b_n7 sky130_fd_pr__nfet_01v8 L=0.15 W=0.42 nf=1 ad=0.1197 as=0.0588 pd=1.41 ps=0.7 mult=1 m=1
xm21_b_n7 bl_0__t3_b_n7 wl_2__t0_b_n7 n22__t1_b_n7 gnd__t16_b_n7 sky130_fd_pr__nfet_01v8 L=0.15 W=0.42 nf=1 ad=0.0588 as=0.1197 pd=0.7 ps=1.41 mult=1 m=1
xm22_b_n7 n29__t0_b_n7 wl_3__t3_b_n7 bl_0__t2_b_n7 gnd__t28_b_n7 sky130_fd_pr__nfet_01v8 L=0.15 W=0.42 nf=1 ad=0.1197 as=0.0588 pd=1.41 ps=0.7 mult=1 m=1
xm23_b_n7 bl_1__t3_b_n7 wl_2__t1_b_n7 n23__t1_b_n7 gnd__t17_b_n7 sky130_fd_pr__nfet_01v8 L=0.15 W=0.42 nf=1 ad=0.0588 as=0.1197 pd=0.7 ps=1.41 mult=1 m=1
xm24_b_n7 n30__t0_b_n7 wl_3__t2_b_n7 bl_1__t1_b_n7 gnd__t29_b_n7 sky130_fd_pr__nfet_01v8 L=0.15 W=0.42 nf=1 ad=0.1197 as=0.0588 pd=1.41 ps=0.7 mult=1 m=1
xm25_b_n7 bl_2__t3_b_n7 wl_2__t2_b_n7 n24__t1_b_n7 gnd__t18_b_n7 sky130_fd_pr__nfet_01v8 L=0.15 W=0.42 nf=1 ad=0.0588 as=0.1197 pd=0.7 ps=1.41 mult=1 m=1
xm26_b_n7 n31__t0_b_n7 wl_3__t1_b_n7 bl_2__t1_b_n7 gnd__t30_b_n7 sky130_fd_pr__nfet_01v8 L=0.15 W=0.42 nf=1 ad=0.1197 as=0.0588 pd=1.41 ps=0.7 mult=1 m=1
xm27_b_n7 bl_3__t3_b_n7 wl_2__t3_b_n7 n25__t1_b_n7 gnd__t19_b_n7 sky130_fd_pr__nfet_01v8 L=0.15 W=0.42 nf=1 ad=0.0588 as=0.1197 pd=0.7 ps=1.41 mult=1 m=1
xm28_b_n7 n32__t0_b_n7 wl_3__t0_b_n7 bl_3__t0_b_n7 gnd__t31_b_n7 sky130_fd_pr__nfet_01v8 L=0.15 W=0.42 nf=1 ad=0.1197 as=0.0588 pd=1.41 ps=0.7 mult=1 m=1
xm29_b_n7 rbl_0__t1_b_n7 n29__t1_b_n7 rwl_3__t0_b_n7 gnd__t4_b_n7 sky130_fd_pr__nfet_01v8 L=0.15 W=0.42 nf=1 ad=0.1197 as=0.1197 pd=1.41 ps=1.41 mult=1 m=1
xm30_b_n7 rbl_1__t0_b_n7 n30__t1_b_n7 rwl_3__t1_b_n7 gnd__t5_b_n7 sky130_fd_pr__nfet_01v8 L=0.15 W=0.42 nf=1 ad=0.1197 as=0.1197 pd=1.41 ps=1.41 mult=1 m=1
xm31_b_n7 rbl_2__t0_b_n7 n31__t1_b_n7 rwl_3__t2_b_n7 gnd__t6_b_n7 sky130_fd_pr__nfet_01v8 L=0.15 W=0.42 nf=1 ad=0.1197 as=0.1197 pd=1.41 ps=1.41 mult=1 m=1
xm32_b_n7 rbl_3__t0_b_n7 n32__t1_b_n7 rwl_3__t3_b_n7 gnd__t7_b_n7 sky130_fd_pr__nfet_01v8 L=0.15 W=0.42 nf=1 ad=0.1197 as=0.1197 pd=1.41 ps=1.41 mult=1 m=1
r_10_t0_b_n7 n10__t0_b_n7 n10_b_n7 183.071
r_10_t1_b_n7 n10__t1_b_n7 n10_b_n7 183.071
r_17_t0_b_n7 n17__t0_b_n7 n17_b_n7 183.071
r_17_t1_b_n7 n17__t1_b_n7 n17_b_n7 183.071
r_18_t0_b_n7 n18__t0_b_n7 n18_b_n7 183.071
r_18_t1_b_n7 n18__t1_b_n7 n18_b_n7 183.071
r_19_t0_b_n7 n19__t0_b_n7 n19_b_n7 183.071
r_19_t1_b_n7 n19__t1_b_n7 n19_b_n7 183.071
r_20_t0_b_n7 n20__t0_b_n7 n20_b_n7 183.071
r_20_t1_b_n7 n20__t1_b_n7 n20_b_n7 183.071
r_22_t0_b_n7 n22__t0_b_n7 n22_b_n7 183.071
r_22_t1_b_n7 n22__t1_b_n7 n22_b_n7 183.071
r_23_t0_b_n7 n23__t0_b_n7 n23_b_n7 183.071
r_23_t1_b_n7 n23__t1_b_n7 n23_b_n7 183.071
r_24_t0_b_n7 n24__t0_b_n7 n24_b_n7 183.071
r_24_t1_b_n7 n24__t1_b_n7 n24_b_n7 183.071
r_25_t0_b_n7 n25__t0_b_n7 n25_b_n7 183.071
r_25_t1_b_n7 n25__t1_b_n7 n25_b_n7 183.071
r_29_t0_b_n7 n29__t0_b_n7 n29_b_n7 183.071
r_29_t1_b_n7 n29__t1_b_n7 n29_b_n7 183.071
r_30_t0_b_n7 n30__t0_b_n7 n30_b_n7 183.071
r_30_t1_b_n7 n30__t1_b_n7 n30_b_n7 183.071
r_31_t0_b_n7 n31__t0_b_n7 n31_b_n7 183.071
r_31_t1_b_n7 n31__t1_b_n7 n31_b_n7 183.071
r_32_t0_b_n7 n32__t0_b_n7 n32_b_n7 183.071
r_32_t1_b_n7 n32__t1_b_n7 n32_b_n7 183.071
r_7_t0_b_n7 n7__t0_b_n7 n7_b_n7 183.071
r_7_t1_b_n7 n7__t1_b_n7 n7_b_n7 183.071
r_8_t0_b_n7 n8__t0_b_n7 n8_b_n7 183.071
r_8_t1_b_n7 n8__t1_b_n7 n8_b_n7 183.071
r_9_t0_b_n7 n9__t0_b_n7 n9_b_n7 183.071
r_9_t1_b_n7 n9__t1_b_n7 n9_b_n7 183.071
rgnd_t0_b_n7 gnd__t0_b_n7 0 38.2988
rgnd_t1_b_n7 gnd__t1_b_n7 0 33.9576
rgnd_t2_b_n7 gnd__t2_b_n7 0 33.9576
rgnd_t3_b_n7 gnd__t3_b_n7 0 38.2988
rgnd_t4_b_n7 gnd__t4_b_n7 0 38.2988
rgnd_t5_b_n7 gnd__t5_b_n7 0 33.9576
rgnd_t6_b_n7 gnd__t6_b_n7 0 33.9576
rgnd_t7_b_n7 gnd__t7_b_n7 0 38.2988
rgnd_t8_b_n7 gnd__t8_b_n7 0 28.0185
rgnd_t9_b_n7 gnd__t9_b_n7 0 21.7106
rgnd_t10_b_n7 gnd__t10_b_n7 0 21.7106
rgnd_t11_b_n7 gnd__t11_b_n7 0 28.0185
rgnd_t12_b_n7 gnd__t12_b_n7 0 18.9833
rgnd_t13_b_n7 gnd__t13_b_n7 0 6.8325
rgnd_t14_b_n7 gnd__t14_b_n7 0 6.8325
rgnd_t15_b_n7 gnd__t15_b_n7 0 18.9833
rgnd_t16_b_n7 gnd__t16_b_n7 0 24.2409
rgnd_t17_b_n7 gnd__t17_b_n7 0 16.5511
rgnd_t18_b_n7 gnd__t18_b_n7 0 16.5511
rgnd_t19_b_n7 gnd__t19_b_n7 0 24.2409
rgnd_t20_b_n7 gnd__t20_b_n7 0 24.2409
rgnd_t21_b_n7 gnd__t21_b_n7 0 16.5511
rgnd_t22_b_n7 gnd__t22_b_n7 0 16.5511
rgnd_t23_b_n7 gnd__t23_b_n7 0 24.2409
rgnd_t24_b_n7 gnd__t24_b_n7 0 18.9833
rgnd_t25_b_n7 gnd__t25_b_n7 0 6.8325
rgnd_t26_b_n7 gnd__t26_b_n7 0 6.8325
rgnd_t27_b_n7 gnd__t27_b_n7 0 18.9833
rgnd_t28_b_n7 gnd__t28_b_n7 0 28.0185
rgnd_t29_b_n7 gnd__t29_b_n7 0 21.7106
rgnd_t30_b_n7 gnd__t30_b_n7 0 21.7106
rgnd_t31_b_n7 gnd__t31_b_n7 0 28.0185
rbl_0_t0_b_n7 bl_0__t0_b_n7 bl_0_b_n7 14.8304
rbl_0_t1_b_n7 bl_0__t1_b_n7 bl_0_b_n7 10.9301
rbl_0_t2_b_n7 bl_0__t2_b_n7 bl_0_b_n7 14.8304
rbl_0_t3_b_n7 bl_0__t3_b_n7 bl_0_b_n7 10.9301
rbl_1_t0_b_n7 bl_1__t0_b_n7 bl_1_b_n7 10.9301
rbl_1_t1_b_n7 bl_1__t1_b_n7 bl_1_b_n7 14.8304
rbl_1_t2_b_n7 bl_1__t2_b_n7 bl_1_b_n7 14.8304
rbl_1_t3_b_n7 bl_1__t3_b_n7 bl_1_b_n7 10.9301
rbl_2_t0_b_n7 bl_2__t0_b_n7 bl_2_b_n7 10.9301
rbl_2_t1_b_n7 bl_2__t1_b_n7 bl_2_b_n7 14.8304
rbl_2_t2_b_n7 bl_2__t2_b_n7 bl_2_b_n7 14.8304
rbl_2_t3_b_n7 bl_2__t3_b_n7 bl_2_b_n7 10.9301
rbl_3_t0_b_n7 bl_3__t0_b_n7 bl_3_b_n7 14.8304
rbl_3_t1_b_n7 bl_3__t1_b_n7 bl_3_b_n7 10.9301
rbl_3_t2_b_n7 bl_3__t2_b_n7 bl_3_b_n7 14.8304
rbl_3_t3_b_n7 bl_3__t3_b_n7 bl_3_b_n7 10.9301
rrbl_0_t0_b_n7 rbl_0__t0_b_n7 rbl_0_b_n7 36.5601
rrbl_0_t1_b_n7 rbl_0__t1_b_n7 rbl_0_b_n7 36.5601
rrbl_0_t2_b_n7 rbl_0__t2_b_n7 rbl_0_b_n7 2.99444
rrbl_0_t3_b_n7 rbl_0__t3_b_n7 rbl_0_b_n7 2.99444
rrbl_1_t0_b_n7 rbl_1__t0_b_n7 rbl_1_b_n7 36.5601
rrbl_1_t1_b_n7 rbl_1__t1_b_n7 rbl_1_b_n7 36.5601
rrbl_1_t2_b_n7 rbl_1__t2_b_n7 rbl_1_b_n7 2.99444
rrbl_1_t3_b_n7 rbl_1__t3_b_n7 rbl_1_b_n7 2.99444
rrbl_2_t0_b_n7 rbl_2__t0_b_n7 rbl_2_b_n7 36.5601
rrbl_2_t1_b_n7 rbl_2__t1_b_n7 rbl_2_b_n7 36.5601
rrbl_2_t2_b_n7 rbl_2__t2_b_n7 rbl_2_b_n7 2.99444
rrbl_2_t3_b_n7 rbl_2__t3_b_n7 rbl_2_b_n7 2.99444
rrbl_3_t0_b_n7 rbl_3__t0_b_n7 rbl_3_b_n7 36.5601
rrbl_3_t1_b_n7 rbl_3__t1_b_n7 rbl_3_b_n7 36.5601
rrbl_3_t2_b_n7 rbl_3__t2_b_n7 rbl_3_b_n7 2.99444
rrbl_3_t3_b_n7 rbl_3__t3_b_n7 rbl_3_b_n7 2.99444
rrwl_0_t0_b_n7 rwl_0__t0_b_n7 rwl_0_b_n7 38.2618
rrwl_0_t1_b_n7 rwl_0__t1_b_n7 rwl_0_b_n7 12.7539
rrwl_0_t2_b_n7 rwl_0__t2_b_n7 rwl_0_b_n7 38.2618
rrwl_0_t3_b_n7 rwl_0__t3_b_n7 rwl_0_b_n7 12.7539
rrwl_1_t0_b_n7 rwl_1__t0_b_n7 rwl_1_b_n7 38.2618
rrwl_1_t1_b_n7 rwl_1__t1_b_n7 rwl_1_b_n7 12.7539
rrwl_1_t2_b_n7 rwl_1__t2_b_n7 rwl_1_b_n7 12.7539
rrwl_1_t3_b_n7 rwl_1__t3_b_n7 rwl_1_b_n7 38.2618
rrwl_2_t0_b_n7 rwl_2__t0_b_n7 rwl_2_b_n7 12.7539
rrwl_2_t1_b_n7 rwl_2__t1_b_n7 rwl_2_b_n7 12.7539
rrwl_2_t2_b_n7 rwl_2__t2_b_n7 rwl_2_b_n7 38.2618
rrwl_2_t3_b_n7 rwl_2__t3_b_n7 rwl_2_b_n7 38.2618
rrwl_3_t0_b_n7 rwl_3__t0_b_n7 rwl_3_b_n7 38.2618
rrwl_3_t1_b_n7 rwl_3__t1_b_n7 rwl_3_b_n7 12.7539
rrwl_3_t2_b_n7 rwl_3__t2_b_n7 rwl_3_b_n7 12.7539
rrwl_3_t3_b_n7 rwl_3__t3_b_n7 rwl_3_b_n7 38.2618
rwl_0_t0_b_n7 wl_0__t0_b_n7 wl_0_b_n7 245.959
rwl_0_t1_b_n7 wl_0__t1_b_n7 wl_0_b_n7 245.959
rwl_0_t2_b_n7 wl_0__t2_b_n7 wl_0_b_n7 81.9864
rwl_0_t3_b_n7 wl_0__t3_b_n7 wl_0_b_n7 81.9864
rwl_1_t0_b_n7 wl_1__t0_b_n7 wl_1_b_n7 245.959
rwl_1_t1_b_n7 wl_1__t1_b_n7 wl_1_b_n7 81.9864
rwl_1_t2_b_n7 wl_1__t2_b_n7 wl_1_b_n7 81.9864
rwl_1_t3_b_n7 wl_1__t3_b_n7 wl_1_b_n7 245.959
rwl_2_t0_b_n7 wl_2__t0_b_n7 wl_2_b_n7 245.959
rwl_2_t1_b_n7 wl_2__t1_b_n7 wl_2_b_n7 81.9864
rwl_2_t2_b_n7 wl_2__t2_b_n7 wl_2_b_n7 81.9864
rwl_2_t3_b_n7 wl_2__t3_b_n7 wl_2_b_n7 245.959
rwl_3_t0_b_n7 wl_3__t0_b_n7 wl_3_b_n7 245.959
rwl_3_t1_b_n7 wl_3__t1_b_n7 wl_3_b_n7 81.9864
rwl_3_t2_b_n7 wl_3__t2_b_n7 wl_3_b_n7 81.9864
rwl_3_t3_b_n7 wl_3__t3_b_n7 wl_3_b_n7 245.959
c_10_b_n7 n10_b_n7 0 2.91622e-16
c_17_b_n7 n17_b_n7 0 2.91528e-16
c_18_b_n7 n18_b_n7 0 2.91528e-16
c_19_b_n7 n19_b_n7 0 2.91528e-16
c_20_b_n7 n20_b_n7 0 2.91622e-16
c_22_b_n7 n22_b_n7 0 2.91528e-16
c_23_b_n7 n23_b_n7 0 2.91528e-16
c_24_b_n7 n24_b_n7 0 2.91528e-16
c_25_b_n7 n25_b_n7 0 2.91622e-16
c_29_b_n7 n29_b_n7 0 2.91528e-16
c_30_b_n7 n30_b_n7 0 2.91528e-16
c_31_b_n7 n31_b_n7 0 2.91528e-16
c_32_b_n7 n32_b_n7 0 2.91622e-16
c_7_b_n7 n7_b_n7 0 2.91528e-16
c_8_b_n7 n8_b_n7 0 2.91528e-16
c_9_b_n7 n9_b_n7 0 2.91528e-16
cgnd_b_n7 0 0 2.48166e-15
cbl_0_b_n7 bl_0_b_n7 0 4.52661e-16
cbl_1_b_n7 bl_1_b_n7 0 4.52661e-16
cbl_2_b_n7 bl_2_b_n7 0 4.52661e-16
cbl_3_b_n7 bl_3_b_n7 0 4.52661e-16
crbl_0_b_n7 rbl_0_b_n7 0 9.14472e-16
crbl_1_b_n7 rbl_1_b_n7 0 9.14472e-16
crbl_2_b_n7 rbl_2_b_n7 0 9.14472e-16
crbl_3_b_n7 rbl_3_b_n7 0 9.17566e-16
crwl_0_b_n7 rwl_0_b_n7 0 5.19495e-16
crwl_1_b_n7 rwl_1_b_n7 0 5.11719e-16
crwl_2_b_n7 rwl_2_b_n7 0 5.11719e-16
crwl_3_b_n7 rwl_3_b_n7 0 5.19495e-16
cwl_0_b_n7 wl_0_b_n7 0 3.30388e-16
cwl_1_b_n7 wl_1_b_n7 0 3.30388e-16
cwl_2_b_n7 wl_2_b_n7 0 3.30388e-16
cwl_3_b_n7 wl_3_b_n7 0 3.30388e-16
ccc__10__9_b_n7 n10_b_n7 n9_b_n7 1.02e-17
ccc__10_bl_3_b_n7 n10_b_n7 bl_3_b_n7 1.3999e-17
ccc__10_rwl_0_b_n7 n10_b_n7 rwl_0_b_n7 4.335e-18
ccc__17__18_b_n7 n17_b_n7 n18_b_n7 1.02e-17
ccc__17_bl_0_b_n7 n17_b_n7 bl_0_b_n7 8.415e-18
ccc__17_rwl_1_b_n7 n17_b_n7 rwl_1_b_n7 1.3194e-17
ccc__18__19_b_n7 n18_b_n7 n19_b_n7 1.02e-17
ccc__18_bl_1_b_n7 n18_b_n7 bl_1_b_n7 8.415e-18
ccc__18_rwl_1_b_n7 n18_b_n7 rwl_1_b_n7 1.3194e-17
ccc__19__20_b_n7 n19_b_n7 n20_b_n7 1.02e-17
ccc__19_bl_2_b_n7 n19_b_n7 bl_2_b_n7 8.415e-18
ccc__19_rwl_1_b_n7 n19_b_n7 rwl_1_b_n7 1.3194e-17
ccc__20_bl_3_b_n7 n20_b_n7 bl_3_b_n7 8.415e-18
ccc__20_rwl_1_b_n7 n20_b_n7 rwl_1_b_n7 6.655e-18
ccc__22__23_b_n7 n22_b_n7 n23_b_n7 1.02e-17
ccc__22_bl_0_b_n7 n22_b_n7 bl_0_b_n7 8.415e-18
ccc__22_rwl_2_b_n7 n22_b_n7 rwl_2_b_n7 1.3194e-17
ccc__23__24_b_n7 n23_b_n7 n24_b_n7 1.02e-17
ccc__23_bl_1_b_n7 n23_b_n7 bl_1_b_n7 8.415e-18
ccc__23_rwl_2_b_n7 n23_b_n7 rwl_2_b_n7 1.3194e-17
ccc__24__25_b_n7 n24_b_n7 n25_b_n7 1.02e-17
ccc__24_bl_2_b_n7 n24_b_n7 bl_2_b_n7 8.415e-18
ccc__24_rwl_2_b_n7 n24_b_n7 rwl_2_b_n7 1.3194e-17
ccc__25_bl_3_b_n7 n25_b_n7 bl_3_b_n7 8.415e-18
ccc__25_rwl_2_b_n7 n25_b_n7 rwl_2_b_n7 6.655e-18
ccc__29__30_b_n7 n29_b_n7 n30_b_n7 1.02e-17
ccc__29_bl_0_b_n7 n29_b_n7 bl_0_b_n7 8.415e-18
ccc__29_rwl_3_b_n7 n29_b_n7 rwl_3_b_n7 1.3194e-17
ccc__30__31_b_n7 n30_b_n7 n31_b_n7 1.02e-17
ccc__30_bl_1_b_n7 n30_b_n7 bl_1_b_n7 8.415e-18
ccc__30_rwl_3_b_n7 n30_b_n7 rwl_3_b_n7 1.3194e-17
ccc__31__32_b_n7 n31_b_n7 n32_b_n7 1.02e-17
ccc__31_bl_2_b_n7 n31_b_n7 bl_2_b_n7 8.415e-18
ccc__31_rwl_3_b_n7 n31_b_n7 rwl_3_b_n7 1.3194e-17
ccc__32_bl_3_b_n7 n32_b_n7 bl_3_b_n7 8.415e-18
ccc__32_rwl_3_b_n7 n32_b_n7 rwl_3_b_n7 6.655e-18
ccc__7__8_b_n7 n7_b_n7 n8_b_n7 1.02e-17
ccc__7_bl_0_b_n7 n7_b_n7 bl_0_b_n7 1.3999e-17
ccc__7_rwl_0_b_n7 n7_b_n7 rwl_0_b_n7 8.961e-18
ccc__8__9_b_n7 n8_b_n7 n9_b_n7 1.02e-17
ccc__8_bl_1_b_n7 n8_b_n7 bl_1_b_n7 1.3999e-17
ccc__8_rwl_0_b_n7 n8_b_n7 rwl_0_b_n7 8.961e-18
ccc__9_bl_2_b_n7 n9_b_n7 bl_2_b_n7 1.3999e-17
ccc__9_rwl_0_b_n7 n9_b_n7 rwl_0_b_n7 8.961e-18
ccc_bl_0_rbl_0_b_n7 bl_0_b_n7 rbl_0_b_n7 1.88693e-16
ccc_bl_0_rwl_1_b_n7 bl_0_b_n7 rwl_1_b_n7 1.0093e-17
ccc_bl_0_rwl_2_b_n7 bl_0_b_n7 rwl_2_b_n7 1.0093e-17
ccc_bl_1_rbl_0_b_n7 bl_1_b_n7 rbl_0_b_n7 1.633e-16
ccc_bl_1_rbl_1_b_n7 bl_1_b_n7 rbl_1_b_n7 1.88693e-16
ccc_bl_1_rwl_1_b_n7 bl_1_b_n7 rwl_1_b_n7 1.0093e-17
ccc_bl_1_rwl_2_b_n7 bl_1_b_n7 rwl_2_b_n7 1.0093e-17
ccc_bl_2_rbl_1_b_n7 bl_2_b_n7 rbl_1_b_n7 1.633e-16
ccc_bl_2_rbl_2_b_n7 bl_2_b_n7 rbl_2_b_n7 1.88693e-16
ccc_bl_2_rwl_1_b_n7 bl_2_b_n7 rwl_1_b_n7 1.0093e-17
ccc_bl_2_rwl_2_b_n7 bl_2_b_n7 rwl_2_b_n7 1.0093e-17
ccc_bl_3_rbl_2_b_n7 bl_3_b_n7 rbl_2_b_n7 1.633e-16
ccc_bl_3_rbl_3_b_n7 bl_3_b_n7 rbl_3_b_n7 1.88693e-16
ccc_bl_3_rwl_1_b_n7 bl_3_b_n7 rwl_1_b_n7 1.0093e-17
ccc_bl_3_rwl_2_b_n7 bl_3_b_n7 rwl_2_b_n7 1.0093e-17
ccc_rbl_0_rbl_1_b_n7 rbl_0_b_n7 rbl_1_b_n7 3.432e-17
ccc_rbl_0_rwl_0_b_n7 rbl_0_b_n7 rwl_0_b_n7 4.9752e-17
ccc_rbl_0_rwl_1_b_n7 rbl_0_b_n7 rwl_1_b_n7 4.9752e-17
ccc_rbl_0_rwl_2_b_n7 rbl_0_b_n7 rwl_2_b_n7 4.9752e-17
ccc_rbl_0_rwl_3_b_n7 rbl_0_b_n7 rwl_3_b_n7 4.9752e-17
ccc_rbl_1_rbl_2_b_n7 rbl_1_b_n7 rbl_2_b_n7 3.432e-17
ccc_rbl_1_rwl_0_b_n7 rbl_1_b_n7 rwl_0_b_n7 4.9752e-17
ccc_rbl_1_rwl_1_b_n7 rbl_1_b_n7 rwl_1_b_n7 4.9752e-17
ccc_rbl_1_rwl_2_b_n7 rbl_1_b_n7 rwl_2_b_n7 4.9752e-17
ccc_rbl_1_rwl_3_b_n7 rbl_1_b_n7 rwl_3_b_n7 4.9752e-17
ccc_rbl_2_rbl_3_b_n7 rbl_2_b_n7 rbl_3_b_n7 3.432e-17
ccc_rbl_2_rwl_0_b_n7 rbl_2_b_n7 rwl_0_b_n7 4.9752e-17
ccc_rbl_2_rwl_1_b_n7 rbl_2_b_n7 rwl_1_b_n7 4.9752e-17
ccc_rbl_2_rwl_2_b_n7 rbl_2_b_n7 rwl_2_b_n7 4.9752e-17
ccc_rbl_2_rwl_3_b_n7 rbl_2_b_n7 rwl_3_b_n7 4.9752e-17
ccc_rbl_3_rwl_0_b_n7 rbl_3_b_n7 rwl_0_b_n7 3.3407e-17
ccc_rbl_3_rwl_1_b_n7 rbl_3_b_n7 rwl_1_b_n7 3.3407e-17
ccc_rbl_3_rwl_2_b_n7 rbl_3_b_n7 rwl_2_b_n7 3.3407e-17
ccc_rbl_3_rwl_3_b_n7 rbl_3_b_n7 rwl_3_b_n7 3.3407e-17
vdw_b_n7_0 wl_0_b_n7 0 dc 0
vdr_b_n7_0 rwl_0_b_n7 0 dc 0
vdw_b_n7_1 wl_1_b_n7 0 dc 0
vdr_b_n7_1 rwl_1_b_n7 0 dc 0
vdw_b_n7_2 wl_2_b_n7 0 dc 0
vdr_b_n7_2 rwl_2_b_n7 0 dc 0
vdw_b_n7_3 wl_3_b_n7 0 dc 0
vdr_b_n7_3 rwl_3_b_n7 0 dc 0
vdb_b_n7_0 bl_0_b_n7 0 dc 0
vdp_b_n7_0 rbl_0_b_n7 0 dc 0
vdb_b_n7_1 bl_1_b_n7 0 dc 0
vdp_b_n7_1 rbl_1_b_n7 0 dc 0
vdb_b_n7_2 bl_2_b_n7 0 dc 0
vdp_b_n7_2 rbl_2_b_n7 0 dc 0
vdb_b_n7_3 bl_3_b_n7 0 dc 0
vdp_b_n7_3 rbl_3_b_n7 0 dc 0
vdn_b_n7_n8 n8_b_n7 0 dc 1
vdn_b_n7_n9 n9_b_n7 0 dc 1
vdn_b_n7_n10 n10_b_n7 0 dc 1
vdn_b_n7_n17 n17_b_n7 0 dc 1
vdn_b_n7_n18 n18_b_n7 0 dc 1
vdn_b_n7_n19 n19_b_n7 0 dc 1
vdn_b_n7_n20 n20_b_n7 0 dc 1
vdn_b_n7_n22 n22_b_n7 0 dc 1
vdn_b_n7_n23 n23_b_n7 0 dc 1
vdn_b_n7_n24 n24_b_n7 0 dc 1
vdn_b_n7_n25 n25_b_n7 0 dc 1
vdn_b_n7_n29 n29_b_n7 0 dc 1
vdn_b_n7_n30 n30_b_n7 0 dc 1
vdn_b_n7_n31 n31_b_n7 0 dc 1
vdn_b_n7_n32 n32_b_n7 0 dc 1
bdr_b_n7 n7_b_n7 0 i=5e-08*min(1,max(0,(time-1e-09)/0.2n))*0.5*(1+tanh((v(n7_b_n7)-0.05)/0.01))

* ---- instance b_n8: variant b, probed storage node \$8 ----
xm1_b_n8 rwl_0__t2_b_n8 n7__t0_b_n8 rbl_0__t0_b_n8 gnd__t0_b_n8 sky130_fd_pr__nfet_01v8 L=0.15 W=0.42 nf=1 ad=0.1197 as=0.1197 pd=1.41 ps=1.41 mult=1 m=1
xm2_b_n8 rwl_0__t3_b_n8 n8__t1_b_n8 rbl_1__t1_b_n8 gnd__t1_b_n8 sky130_fd_pr__nfet_01v8 L=0.15 W=0.42 nf=1 ad=0.1197 as=0.1197 pd=1.41 ps=1.41 mult=1 m=1
xm3_b_n8 rwl_0__t1_b_n8 n9__t1_b_n8 rbl_2__t1_b_n8 gnd__t2_b_n8 sky130_fd_pr__nfet_01v8 L=0.15 W=0.42 nf=1 ad=0.1197 as=0.1197 pd=1.41 ps=1.41 mult=1 m=1
xm4_b_n8 rwl_0__t0_b_n8 n10__t1_b_n8 rbl_3__t1_b_n8 gnd__t3_b_n8 sky130_fd_pr__nfet_01v8 L=0.15 W=0.42 nf=1 ad=0.1197 as=0.1197 pd=1.41 ps=1.41 mult=1 m=1
xm5_b_n8 bl_0__t0_b_n8 wl_0__t0_b_n8 n7__t1_b_n8 gnd__t8_b_n8 sky130_fd_pr__nfet_01v8 L=0.15 W=0.42 nf=1 ad=0.0588 as=0.1197 pd=0.7 ps=1.41 mult=1 m=1
xm6_b_n8 n17__t0_b_n8 wl_1__t0_b_n8 bl_0__t1_b_n8 gnd__t20_b_n8 sky130_fd_pr__nfet_01v8 L=0.15 W=0.42 nf=1 ad=0.1197 as=0.0588 pd=1.41 ps=0.7 mult=1 m=1
xm7_b_n8 bl_1__t2_b_n8 wl_0__t3_b_n8 n8__t0_b_n8 gnd__t9_b_n8 sky130_fd_pr__nfet_01v8 L=0.15 W=0.42 nf=1 ad=0.0588 as=0.1197 pd=0.7 ps=1.41 mult=1 m=1
xm8_b_n8 n18__t0_b_n8 wl_1__t1_b_n8 bl_1__t0_b_n8 gnd__t21_b_n8 sky130_fd_pr__nfet_01v8 L=0.15 W=0.42 nf=1 ad=0.1197 as=0.0588 pd=1.41 ps=0.7 mult=1 m=1
xm9_b_n8 bl_2__t2_b_n8 wl_0__t2_b_n8 n9__t0_b_n8 gnd__t10_b_n8 sky130_fd_pr__nfet_01v8 L=0.15 W=0.42 nf=1 ad=0.0588 as=0.1197 pd=0.7 ps=1.41 mult=1 m=1
xm10_b_n8 n19__t0_b_n8 wl_1__t2_b_n8 bl_2__t0_b_n8 gnd__t22_b_n8 sky130_fd_pr__nfet_01v8 L=0.15 W=0.42 nf=1 ad=0.1197 as=0.0588 pd=1.41 ps=0.7 mult=1 m=1
xm11_b_n8 bl_3__t2_b_n8 wl_0__t1_b_n8 n10__t0_b_n8 gnd__t11_b_n8 sky130_fd_pr__nfet_01v8 L=0.15 W=0.42 nf=1 ad=0.0588 as=0.1197 pd=0.7 ps=1.41 mult=1 m=1
xm12_b_n8 n20__t0_b_n8 wl_1__t3_b_n8 bl_3__t1_b_n8 gnd__t23_b_n8 sky130_fd_pr__nfet_01v8 L=0.15 W=0.42 nf=1 ad=0.1197 as=0.0588 pd=1.41 ps=0.7 mult=1 m=1
xm13_b_n8 rbl_0__t3_b_n8 n17__t1_b_n8 rwl_1__t0_b_n8 gnd__t12_b_n8 sky130_fd_pr__nfet_01v8 L=0.15 W=0.42 nf=1 ad=0.0588 as=0.1197 pd=0.7 ps=1.41 mult=1 m=1
xm14_b_n8 rwl_2__t3_b_n8 n22__t0_b_n8 rbl_0__t2_b_n8 gnd__t24_b_n8 sky130_fd_pr__nfet_01v8 L=0.15 W=0.42 nf=1 ad=0.1197 as=0.0588 pd=1.41 ps=0.7 mult=1 m=1
xm15_b_n8 rbl_1__t3_b_n8 n18__t1_b_n8 rwl_1__t1_b_n8 gnd__t13_b_n8 sky130_fd_pr__nfet_01v8 L=0.15 W=0.42 nf=1 ad=0.0588 as=0.1197 pd=0.7 ps=1.41 mult=1 m=1
xm16_b_n8 rwl_2__t0_b_n8 n23__t0_b_n8 rbl_1__t2_b_n8 gnd__t25_b_n8 sky130_fd_pr__nfet_01v8 L=0.15 W=0.42 nf=1 ad=0.1197 as=0.0588 pd=1.41 ps=0.7 mult=1 m=1
xm17_b_n8 rbl_2__t3_b_n8 n19__t1_b_n8 rwl_1__t2_b_n8 gnd__t14_b_n8 sky130_fd_pr__nfet_01v8 L=0.15 W=0.42 nf=1 ad=0.0588 as=0.1197 pd=0.7 ps=1.41 mult=1 m=1
xm18_b_n8 rwl_2__t1_b_n8 n24__t0_b_n8 rbl_2__t2_b_n8 gnd__t26_b_n8 sky130_fd_pr__nfet_01v8 L=0.15 W=0.42 nf=1 ad=0.1197 as=0.0588 pd=1.41 ps=0.7 mult=1 m=1
xm19_b_n8 rbl_3__t3_b_n8 n20__t1_b_n8 rwl_1__t3_b_n8 gnd__t15_b_n8 sky130_fd_pr__nfet_01v8 L=0.15 W=0.42 nf=1 ad=0.0588 as=0.1197 pd=0.7 ps=1.41 mult=1 m=1
xm20_b_n8 rwl_2__t2_b_n8 n25__t0_b_n8 rbl_3__t2_b_n8 gnd__t27_b_n8 sky130_fd_pr__nfet_01v8 L=0.15 W=0.42 nf=1 ad=0.1197 as=0.0588 pd=1.41 ps=0.7 mult=1 m=1
xm21_b_n8 bl_0__t3_b_n8 wl_2__t0_b_n8 n22__t1_b_n8 gnd__t16_b_n8 sky130_fd_pr__nfet_01v8 L=0.15 W=0.42 nf=1 ad=0.0588 as=0.1197 pd=0.7 ps=1.41 mult=1 m=1
xm22_b_n8 n29__t0_b_n8 wl_3__t3_b_n8 bl_0__t2_b_n8 gnd__t28_b_n8 sky130_fd_pr__nfet_01v8 L=0.15 W=0.42 nf=1 ad=0.1197 as=0.0588 pd=1.41 ps=0.7 mult=1 m=1
xm23_b_n8 bl_1__t3_b_n8 wl_2__t1_b_n8 n23__t1_b_n8 gnd__t17_b_n8 sky130_fd_pr__nfet_01v8 L=0.15 W=0.42 nf=1 ad=0.0588 as=0.1197 pd=0.7 ps=1.41 mult=1 m=1
xm24_b_n8 n30__t0_b_n8 wl_3__t2_b_n8 bl_1__t1_b_n8 gnd__t29_b_n8 sky130_fd_pr__nfet_01v8 L=0.15 W=0.42 nf=1 ad=0.1197 as=0.0588 pd=1.41 ps=0.7 mult=1 m=1
xm25_b_n8 bl_2__t3_b_n8 wl_2__t2_b_n8 n24__t1_b_n8 gnd__t18_b_n8 sky130_fd_pr__nfet_01v8 L=0.15 W=0.42 nf=1 ad=0.0588 as=0.1197 pd=0.7 ps=1.41 mult=1 m=1
xm26_b_n8 n31__t0_b_n8 wl_3__t1_b_n8 bl_2__t1_b_n8 gnd__t30_b_n8 sky130_fd_pr__nfet_01v8 L=0.15 W=0.42 nf=1 ad=0.1197 as=0.0588 pd=1.41 ps=0.7 mult=1 m=1
xm27_b_n8 bl_3__t3_b_n8 wl_2__t3_b_n8 n25__t1_b_n8 gnd__t19_b_n8 sky130_fd_pr__nfet_01v8 L=0.15 W=0.42 nf=1 ad=0.0588 as=0.1197 pd=0.7 ps=1.41 mult=1 m=1
xm28_b_n8 n32__t0_b_n8 wl_3__t0_b_n8 bl_3__t0_b_n8 gnd__t31_b_n8 sky130_fd_pr__nfet_01v8 L=0.15 W=0.42 nf=1 ad=0.1197 as=0.0588 pd=1.41 ps=0.7 mult=1 m=1
xm29_b_n8 rbl_0__t1_b_n8 n29__t1_b_n8 rwl_3__t0_b_n8 gnd__t4_b_n8 sky130_fd_pr__nfet_01v8 L=0.15 W=0.42 nf=1 ad=0.1197 as=0.1197 pd=1.41 ps=1.41 mult=1 m=1
xm30_b_n8 rbl_1__t0_b_n8 n30__t1_b_n8 rwl_3__t1_b_n8 gnd__t5_b_n8 sky130_fd_pr__nfet_01v8 L=0.15 W=0.42 nf=1 ad=0.1197 as=0.1197 pd=1.41 ps=1.41 mult=1 m=1
xm31_b_n8 rbl_2__t0_b_n8 n31__t1_b_n8 rwl_3__t2_b_n8 gnd__t6_b_n8 sky130_fd_pr__nfet_01v8 L=0.15 W=0.42 nf=1 ad=0.1197 as=0.1197 pd=1.41 ps=1.41 mult=1 m=1
xm32_b_n8 rbl_3__t0_b_n8 n32__t1_b_n8 rwl_3__t3_b_n8 gnd__t7_b_n8 sky130_fd_pr__nfet_01v8 L=0.15 W=0.42 nf=1 ad=0.1197 as=0.1197 pd=1.41 ps=1.41 mult=1 m=1
r_10_t0_b_n8 n10__t0_b_n8 n10_b_n8 183.071
r_10_t1_b_n8 n10__t1_b_n8 n10_b_n8 183.071
r_17_t0_b_n8 n17__t0_b_n8 n17_b_n8 183.071
r_17_t1_b_n8 n17__t1_b_n8 n17_b_n8 183.071
r_18_t0_b_n8 n18__t0_b_n8 n18_b_n8 183.071
r_18_t1_b_n8 n18__t1_b_n8 n18_b_n8 183.071
r_19_t0_b_n8 n19__t0_b_n8 n19_b_n8 183.071
r_19_t1_b_n8 n19__t1_b_n8 n19_b_n8 183.071
r_20_t0_b_n8 n20__t0_b_n8 n20_b_n8 183.071
r_20_t1_b_n8 n20__t1_b_n8 n20_b_n8 183.071
r_22_t0_b_n8 n22__t0_b_n8 n22_b_n8 183.071
r_22_t1_b_n8 n22__t1_b_n8 n22_b_n8 183.071
r_23_t0_b_n8 n23__t0_b_n8 n23_b_n8 183.071
r_23_t1_b_n8 n23__t1_b_n8 n23_b_n8 183.071
r_24_t0_b_n8 n24__t0_b_n8 n24_b_n8 183.071
r_24_t1_b_n8 n24__t1_b_n8 n24_b_n8 183.071
r_25_t0_b_n8 n25__t0_b_n8 n25_b_n8 183.071
r_25_t1_b_n8 n25__t1_b_n8 n25_b_n8 183.071
r_29_t0_b_n8 n29__t0_b_n8 n29_b_n8 183.071
r_29_t1_b_n8 n29__t1_b_n8 n29_b_n8 183.071
r_30_t0_b_n8 n30__t0_b_n8 n30_b_n8 183.071
r_30_t1_b_n8 n30__t1_b_n8 n30_b_n8 183.071
r_31_t0_b_n8 n31__t0_b_n8 n31_b_n8 183.071
r_31_t1_b_n8 n31__t1_b_n8 n31_b_n8 183.071
r_32_t0_b_n8 n32__t0_b_n8 n32_b_n8 183.071
r_32_t1_b_n8 n32__t1_b_n8 n32_b_n8 183.071
r_7_t0_b_n8 n7__t0_b_n8 n7_b_n8 183.071
r_7_t1_b_n8 n7__t1_b_n8 n7_b_n8 183.071
r_8_t0_b_n8 n8__t0_b_n8 n8_b_n8 183.071
r_8_t1_b_n8 n8__t1_b_n8 n8_b_n8 183.071
r_9_t0_b_n8 n9__t0_b_n8 n9_b_n8 183.071
r_9_t1_b_n8 n9__t1_b_n8 n9_b_n8 183.071
rgnd_t0_b_n8 gnd__t0_b_n8 0 38.2988
rgnd_t1_b_n8 gnd__t1_b_n8 0 33.9576
rgnd_t2_b_n8 gnd__t2_b_n8 0 33.9576
rgnd_t3_b_n8 gnd__t3_b_n8 0 38.2988
rgnd_t4_b_n8 gnd__t4_b_n8 0 38.2988
rgnd_t5_b_n8 gnd__t5_b_n8 0 33.9576
rgnd_t6_b_n8 gnd__t6_b_n8 0 33.9576
rgnd_t7_b_n8 gnd__t7_b_n8 0 38.2988
rgnd_t8_b_n8 gnd__t8_b_n8 0 28.0185
rgnd_t9_b_n8 gnd__t9_b_n8 0 21.7106
rgnd_t10_b_n8 gnd__t10_b_n8 0 21.7106
rgnd_t11_b_n8 gnd__t11_b_n8 0 28.0185
rgnd_t12_b_n8 gnd__t12_b_n8 0 18.9833
rgnd_t13_b_n8 gnd__t13_b_n8 0 6.8325
rgnd_t14_b_n8 gnd__t14_b_n8 0 6.8325
rgnd_t15_b_n8 gnd__t15_b_n8 0 18.9833
rgnd_t16_b_n8 gnd__t16_b_n8 0 24.2409
rgnd_t17_b_n8 gnd__t17_b_n8 0 16.5511
rgnd_t18_b_n8 gnd__t18_b_n8 0 16.5511
rgnd_t19_b_n8 gnd__t19_b_n8 0 24.2409
rgnd_t20_b_n8 gnd__t20_b_n8 0 24.2409
rgnd_t21_b_n8 gnd__t21_b_n8 0 16.5511
rgnd_t22_b_n8 gnd__t22_b_n8 0 16.5511
rgnd_t23_b_n8 gnd__t23_b_n8 0 24.2409
rgnd_t24_b_n8 gnd__t24_b_n8 0 18.9833
rgnd_t25_b_n8 gnd__t25_b_n8 0 6.8325
rgnd_t26_b_n8 gnd__t26_b_n8 0 6.8325
rgnd_t27_b_n8 gnd__t27_b_n8 0 18.9833
rgnd_t28_b_n8 gnd__t28_b_n8 0 28.0185
rgnd_t29_b_n8 gnd__t29_b_n8 0 21.7106
rgnd_t30_b_n8 gnd__t30_b_n8 0 21.7106
rgnd_t31_b_n8 gnd__t31_b_n8 0 28.0185
rbl_0_t0_b_n8 bl_0__t0_b_n8 bl_0_b_n8 14.8304
rbl_0_t1_b_n8 bl_0__t1_b_n8 bl_0_b_n8 10.9301
rbl_0_t2_b_n8 bl_0__t2_b_n8 bl_0_b_n8 14.8304
rbl_0_t3_b_n8 bl_0__t3_b_n8 bl_0_b_n8 10.9301
rbl_1_t0_b_n8 bl_1__t0_b_n8 bl_1_b_n8 10.9301
rbl_1_t1_b_n8 bl_1__t1_b_n8 bl_1_b_n8 14.8304
rbl_1_t2_b_n8 bl_1__t2_b_n8 bl_1_b_n8 14.8304
rbl_1_t3_b_n8 bl_1__t3_b_n8 bl_1_b_n8 10.9301
rbl_2_t0_b_n8 bl_2__t0_b_n8 bl_2_b_n8 10.9301
rbl_2_t1_b_n8 bl_2__t1_b_n8 bl_2_b_n8 14.8304
rbl_2_t2_b_n8 bl_2__t2_b_n8 bl_2_b_n8 14.8304
rbl_2_t3_b_n8 bl_2__t3_b_n8 bl_2_b_n8 10.9301
rbl_3_t0_b_n8 bl_3__t0_b_n8 bl_3_b_n8 14.8304
rbl_3_t1_b_n8 bl_3__t1_b_n8 bl_3_b_n8 10.9301
rbl_3_t2_b_n8 bl_3__t2_b_n8 bl_3_b_n8 14.8304
rbl_3_t3_b_n8 bl_3__t3_b_n8 bl_3_b_n8 10.9301
rrbl_0_t0_b_n8 rbl_0__t0_b_n8 rbl_0_b_n8 36.5601
rrbl_0_t1_b_n8 rbl_0__t1_b_n8 rbl_0_b_n8 36.5601
rrbl_0_t2_b_n8 rbl_0__t2_b_n8 rbl_0_b_n8 2.99444
rrbl_0_t3_b_n8 rbl_0__t3_b_n8 rbl_0_b_n8 2.99444
rrbl_1_t0_b_n8 rbl_1__t0_b_n8 rbl_1_b_n8 36.5601
rrbl_1_t1_b_n8 rbl_1__t1_b_n8 rbl_1_b_n8 36.5601
rrbl_1_t2_b_n8 rbl_1__t2_b_n8 rbl_1_b_n8 2.99444
rrbl_1_t3_b_n8 rbl_1__t3_b_n8 rbl_1_b_n8 2.99444
rrbl_2_t0_b_n8 rbl_2__t0_b_n8 rbl_2_b_n8 36.5601
rrbl_2_t1_b_n8 rbl_2__t1_b_n8 rbl_2_b_n8 36.5601
rrbl_2_t2_b_n8 rbl_2__t2_b_n8 rbl_2_b_n8 2.99444
rrbl_2_t3_b_n8 rbl_2__t3_b_n8 rbl_2_b_n8 2.99444
rrbl_3_t0_b_n8 rbl_3__t0_b_n8 rbl_3_b_n8 36.5601
rrbl_3_t1_b_n8 rbl_3__t1_b_n8 rbl_3_b_n8 36.5601
rrbl_3_t2_b_n8 rbl_3__t2_b_n8 rbl_3_b_n8 2.99444
rrbl_3_t3_b_n8 rbl_3__t3_b_n8 rbl_3_b_n8 2.99444
rrwl_0_t0_b_n8 rwl_0__t0_b_n8 rwl_0_b_n8 38.2618
rrwl_0_t1_b_n8 rwl_0__t1_b_n8 rwl_0_b_n8 12.7539
rrwl_0_t2_b_n8 rwl_0__t2_b_n8 rwl_0_b_n8 38.2618
rrwl_0_t3_b_n8 rwl_0__t3_b_n8 rwl_0_b_n8 12.7539
rrwl_1_t0_b_n8 rwl_1__t0_b_n8 rwl_1_b_n8 38.2618
rrwl_1_t1_b_n8 rwl_1__t1_b_n8 rwl_1_b_n8 12.7539
rrwl_1_t2_b_n8 rwl_1__t2_b_n8 rwl_1_b_n8 12.7539
rrwl_1_t3_b_n8 rwl_1__t3_b_n8 rwl_1_b_n8 38.2618
rrwl_2_t0_b_n8 rwl_2__t0_b_n8 rwl_2_b_n8 12.7539
rrwl_2_t1_b_n8 rwl_2__t1_b_n8 rwl_2_b_n8 12.7539
rrwl_2_t2_b_n8 rwl_2__t2_b_n8 rwl_2_b_n8 38.2618
rrwl_2_t3_b_n8 rwl_2__t3_b_n8 rwl_2_b_n8 38.2618
rrwl_3_t0_b_n8 rwl_3__t0_b_n8 rwl_3_b_n8 38.2618
rrwl_3_t1_b_n8 rwl_3__t1_b_n8 rwl_3_b_n8 12.7539
rrwl_3_t2_b_n8 rwl_3__t2_b_n8 rwl_3_b_n8 12.7539
rrwl_3_t3_b_n8 rwl_3__t3_b_n8 rwl_3_b_n8 38.2618
rwl_0_t0_b_n8 wl_0__t0_b_n8 wl_0_b_n8 245.959
rwl_0_t1_b_n8 wl_0__t1_b_n8 wl_0_b_n8 245.959
rwl_0_t2_b_n8 wl_0__t2_b_n8 wl_0_b_n8 81.9864
rwl_0_t3_b_n8 wl_0__t3_b_n8 wl_0_b_n8 81.9864
rwl_1_t0_b_n8 wl_1__t0_b_n8 wl_1_b_n8 245.959
rwl_1_t1_b_n8 wl_1__t1_b_n8 wl_1_b_n8 81.9864
rwl_1_t2_b_n8 wl_1__t2_b_n8 wl_1_b_n8 81.9864
rwl_1_t3_b_n8 wl_1__t3_b_n8 wl_1_b_n8 245.959
rwl_2_t0_b_n8 wl_2__t0_b_n8 wl_2_b_n8 245.959
rwl_2_t1_b_n8 wl_2__t1_b_n8 wl_2_b_n8 81.9864
rwl_2_t2_b_n8 wl_2__t2_b_n8 wl_2_b_n8 81.9864
rwl_2_t3_b_n8 wl_2__t3_b_n8 wl_2_b_n8 245.959
rwl_3_t0_b_n8 wl_3__t0_b_n8 wl_3_b_n8 245.959
rwl_3_t1_b_n8 wl_3__t1_b_n8 wl_3_b_n8 81.9864
rwl_3_t2_b_n8 wl_3__t2_b_n8 wl_3_b_n8 81.9864
rwl_3_t3_b_n8 wl_3__t3_b_n8 wl_3_b_n8 245.959
c_10_b_n8 n10_b_n8 0 2.91622e-16
c_17_b_n8 n17_b_n8 0 2.91528e-16
c_18_b_n8 n18_b_n8 0 2.91528e-16
c_19_b_n8 n19_b_n8 0 2.91528e-16
c_20_b_n8 n20_b_n8 0 2.91622e-16
c_22_b_n8 n22_b_n8 0 2.91528e-16
c_23_b_n8 n23_b_n8 0 2.91528e-16
c_24_b_n8 n24_b_n8 0 2.91528e-16
c_25_b_n8 n25_b_n8 0 2.91622e-16
c_29_b_n8 n29_b_n8 0 2.91528e-16
c_30_b_n8 n30_b_n8 0 2.91528e-16
c_31_b_n8 n31_b_n8 0 2.91528e-16
c_32_b_n8 n32_b_n8 0 2.91622e-16
c_7_b_n8 n7_b_n8 0 2.91528e-16
c_8_b_n8 n8_b_n8 0 2.91528e-16
c_9_b_n8 n9_b_n8 0 2.91528e-16
cgnd_b_n8 0 0 2.48166e-15
cbl_0_b_n8 bl_0_b_n8 0 4.52661e-16
cbl_1_b_n8 bl_1_b_n8 0 4.52661e-16
cbl_2_b_n8 bl_2_b_n8 0 4.52661e-16
cbl_3_b_n8 bl_3_b_n8 0 4.52661e-16
crbl_0_b_n8 rbl_0_b_n8 0 9.14472e-16
crbl_1_b_n8 rbl_1_b_n8 0 9.14472e-16
crbl_2_b_n8 rbl_2_b_n8 0 9.14472e-16
crbl_3_b_n8 rbl_3_b_n8 0 9.17566e-16
crwl_0_b_n8 rwl_0_b_n8 0 5.19495e-16
crwl_1_b_n8 rwl_1_b_n8 0 5.11719e-16
crwl_2_b_n8 rwl_2_b_n8 0 5.11719e-16
crwl_3_b_n8 rwl_3_b_n8 0 5.19495e-16
cwl_0_b_n8 wl_0_b_n8 0 3.30388e-16
cwl_1_b_n8 wl_1_b_n8 0 3.30388e-16
cwl_2_b_n8 wl_2_b_n8 0 3.30388e-16
cwl_3_b_n8 wl_3_b_n8 0 3.30388e-16
ccc__10__9_b_n8 n10_b_n8 n9_b_n8 1.02e-17
ccc__10_bl_3_b_n8 n10_b_n8 bl_3_b_n8 1.3999e-17
ccc__10_rwl_0_b_n8 n10_b_n8 rwl_0_b_n8 4.335e-18
ccc__17__18_b_n8 n17_b_n8 n18_b_n8 1.02e-17
ccc__17_bl_0_b_n8 n17_b_n8 bl_0_b_n8 8.415e-18
ccc__17_rwl_1_b_n8 n17_b_n8 rwl_1_b_n8 1.3194e-17
ccc__18__19_b_n8 n18_b_n8 n19_b_n8 1.02e-17
ccc__18_bl_1_b_n8 n18_b_n8 bl_1_b_n8 8.415e-18
ccc__18_rwl_1_b_n8 n18_b_n8 rwl_1_b_n8 1.3194e-17
ccc__19__20_b_n8 n19_b_n8 n20_b_n8 1.02e-17
ccc__19_bl_2_b_n8 n19_b_n8 bl_2_b_n8 8.415e-18
ccc__19_rwl_1_b_n8 n19_b_n8 rwl_1_b_n8 1.3194e-17
ccc__20_bl_3_b_n8 n20_b_n8 bl_3_b_n8 8.415e-18
ccc__20_rwl_1_b_n8 n20_b_n8 rwl_1_b_n8 6.655e-18
ccc__22__23_b_n8 n22_b_n8 n23_b_n8 1.02e-17
ccc__22_bl_0_b_n8 n22_b_n8 bl_0_b_n8 8.415e-18
ccc__22_rwl_2_b_n8 n22_b_n8 rwl_2_b_n8 1.3194e-17
ccc__23__24_b_n8 n23_b_n8 n24_b_n8 1.02e-17
ccc__23_bl_1_b_n8 n23_b_n8 bl_1_b_n8 8.415e-18
ccc__23_rwl_2_b_n8 n23_b_n8 rwl_2_b_n8 1.3194e-17
ccc__24__25_b_n8 n24_b_n8 n25_b_n8 1.02e-17
ccc__24_bl_2_b_n8 n24_b_n8 bl_2_b_n8 8.415e-18
ccc__24_rwl_2_b_n8 n24_b_n8 rwl_2_b_n8 1.3194e-17
ccc__25_bl_3_b_n8 n25_b_n8 bl_3_b_n8 8.415e-18
ccc__25_rwl_2_b_n8 n25_b_n8 rwl_2_b_n8 6.655e-18
ccc__29__30_b_n8 n29_b_n8 n30_b_n8 1.02e-17
ccc__29_bl_0_b_n8 n29_b_n8 bl_0_b_n8 8.415e-18
ccc__29_rwl_3_b_n8 n29_b_n8 rwl_3_b_n8 1.3194e-17
ccc__30__31_b_n8 n30_b_n8 n31_b_n8 1.02e-17
ccc__30_bl_1_b_n8 n30_b_n8 bl_1_b_n8 8.415e-18
ccc__30_rwl_3_b_n8 n30_b_n8 rwl_3_b_n8 1.3194e-17
ccc__31__32_b_n8 n31_b_n8 n32_b_n8 1.02e-17
ccc__31_bl_2_b_n8 n31_b_n8 bl_2_b_n8 8.415e-18
ccc__31_rwl_3_b_n8 n31_b_n8 rwl_3_b_n8 1.3194e-17
ccc__32_bl_3_b_n8 n32_b_n8 bl_3_b_n8 8.415e-18
ccc__32_rwl_3_b_n8 n32_b_n8 rwl_3_b_n8 6.655e-18
ccc__7__8_b_n8 n7_b_n8 n8_b_n8 1.02e-17
ccc__7_bl_0_b_n8 n7_b_n8 bl_0_b_n8 1.3999e-17
ccc__7_rwl_0_b_n8 n7_b_n8 rwl_0_b_n8 8.961e-18
ccc__8__9_b_n8 n8_b_n8 n9_b_n8 1.02e-17
ccc__8_bl_1_b_n8 n8_b_n8 bl_1_b_n8 1.3999e-17
ccc__8_rwl_0_b_n8 n8_b_n8 rwl_0_b_n8 8.961e-18
ccc__9_bl_2_b_n8 n9_b_n8 bl_2_b_n8 1.3999e-17
ccc__9_rwl_0_b_n8 n9_b_n8 rwl_0_b_n8 8.961e-18
ccc_bl_0_rbl_0_b_n8 bl_0_b_n8 rbl_0_b_n8 1.88693e-16
ccc_bl_0_rwl_1_b_n8 bl_0_b_n8 rwl_1_b_n8 1.0093e-17
ccc_bl_0_rwl_2_b_n8 bl_0_b_n8 rwl_2_b_n8 1.0093e-17
ccc_bl_1_rbl_0_b_n8 bl_1_b_n8 rbl_0_b_n8 1.633e-16
ccc_bl_1_rbl_1_b_n8 bl_1_b_n8 rbl_1_b_n8 1.88693e-16
ccc_bl_1_rwl_1_b_n8 bl_1_b_n8 rwl_1_b_n8 1.0093e-17
ccc_bl_1_rwl_2_b_n8 bl_1_b_n8 rwl_2_b_n8 1.0093e-17
ccc_bl_2_rbl_1_b_n8 bl_2_b_n8 rbl_1_b_n8 1.633e-16
ccc_bl_2_rbl_2_b_n8 bl_2_b_n8 rbl_2_b_n8 1.88693e-16
ccc_bl_2_rwl_1_b_n8 bl_2_b_n8 rwl_1_b_n8 1.0093e-17
ccc_bl_2_rwl_2_b_n8 bl_2_b_n8 rwl_2_b_n8 1.0093e-17
ccc_bl_3_rbl_2_b_n8 bl_3_b_n8 rbl_2_b_n8 1.633e-16
ccc_bl_3_rbl_3_b_n8 bl_3_b_n8 rbl_3_b_n8 1.88693e-16
ccc_bl_3_rwl_1_b_n8 bl_3_b_n8 rwl_1_b_n8 1.0093e-17
ccc_bl_3_rwl_2_b_n8 bl_3_b_n8 rwl_2_b_n8 1.0093e-17
ccc_rbl_0_rbl_1_b_n8 rbl_0_b_n8 rbl_1_b_n8 3.432e-17
ccc_rbl_0_rwl_0_b_n8 rbl_0_b_n8 rwl_0_b_n8 4.9752e-17
ccc_rbl_0_rwl_1_b_n8 rbl_0_b_n8 rwl_1_b_n8 4.9752e-17
ccc_rbl_0_rwl_2_b_n8 rbl_0_b_n8 rwl_2_b_n8 4.9752e-17
ccc_rbl_0_rwl_3_b_n8 rbl_0_b_n8 rwl_3_b_n8 4.9752e-17
ccc_rbl_1_rbl_2_b_n8 rbl_1_b_n8 rbl_2_b_n8 3.432e-17
ccc_rbl_1_rwl_0_b_n8 rbl_1_b_n8 rwl_0_b_n8 4.9752e-17
ccc_rbl_1_rwl_1_b_n8 rbl_1_b_n8 rwl_1_b_n8 4.9752e-17
ccc_rbl_1_rwl_2_b_n8 rbl_1_b_n8 rwl_2_b_n8 4.9752e-17
ccc_rbl_1_rwl_3_b_n8 rbl_1_b_n8 rwl_3_b_n8 4.9752e-17
ccc_rbl_2_rbl_3_b_n8 rbl_2_b_n8 rbl_3_b_n8 3.432e-17
ccc_rbl_2_rwl_0_b_n8 rbl_2_b_n8 rwl_0_b_n8 4.9752e-17
ccc_rbl_2_rwl_1_b_n8 rbl_2_b_n8 rwl_1_b_n8 4.9752e-17
ccc_rbl_2_rwl_2_b_n8 rbl_2_b_n8 rwl_2_b_n8 4.9752e-17
ccc_rbl_2_rwl_3_b_n8 rbl_2_b_n8 rwl_3_b_n8 4.9752e-17
ccc_rbl_3_rwl_0_b_n8 rbl_3_b_n8 rwl_0_b_n8 3.3407e-17
ccc_rbl_3_rwl_1_b_n8 rbl_3_b_n8 rwl_1_b_n8 3.3407e-17
ccc_rbl_3_rwl_2_b_n8 rbl_3_b_n8 rwl_2_b_n8 3.3407e-17
ccc_rbl_3_rwl_3_b_n8 rbl_3_b_n8 rwl_3_b_n8 3.3407e-17
vdw_b_n8_0 wl_0_b_n8 0 dc 0
vdr_b_n8_0 rwl_0_b_n8 0 dc 0
vdw_b_n8_1 wl_1_b_n8 0 dc 0
vdr_b_n8_1 rwl_1_b_n8 0 dc 0
vdw_b_n8_2 wl_2_b_n8 0 dc 0
vdr_b_n8_2 rwl_2_b_n8 0 dc 0
vdw_b_n8_3 wl_3_b_n8 0 dc 0
vdr_b_n8_3 rwl_3_b_n8 0 dc 0
vdb_b_n8_0 bl_0_b_n8 0 dc 0
vdp_b_n8_0 rbl_0_b_n8 0 dc 0
vdb_b_n8_1 bl_1_b_n8 0 dc 0
vdp_b_n8_1 rbl_1_b_n8 0 dc 0
vdb_b_n8_2 bl_2_b_n8 0 dc 0
vdp_b_n8_2 rbl_2_b_n8 0 dc 0
vdb_b_n8_3 bl_3_b_n8 0 dc 0
vdp_b_n8_3 rbl_3_b_n8 0 dc 0
vdn_b_n8_n7 n7_b_n8 0 dc 1
vdn_b_n8_n9 n9_b_n8 0 dc 1
vdn_b_n8_n10 n10_b_n8 0 dc 1
vdn_b_n8_n17 n17_b_n8 0 dc 1
vdn_b_n8_n18 n18_b_n8 0 dc 1
vdn_b_n8_n19 n19_b_n8 0 dc 1
vdn_b_n8_n20 n20_b_n8 0 dc 1
vdn_b_n8_n22 n22_b_n8 0 dc 1
vdn_b_n8_n23 n23_b_n8 0 dc 1
vdn_b_n8_n24 n24_b_n8 0 dc 1
vdn_b_n8_n25 n25_b_n8 0 dc 1
vdn_b_n8_n29 n29_b_n8 0 dc 1
vdn_b_n8_n30 n30_b_n8 0 dc 1
vdn_b_n8_n31 n31_b_n8 0 dc 1
vdn_b_n8_n32 n32_b_n8 0 dc 1
bdr_b_n8 n8_b_n8 0 i=5e-08*min(1,max(0,(time-1e-09)/0.2n))*0.5*(1+tanh((v(n8_b_n8)-0.05)/0.01))

* ---- instance b_n9: variant b, probed storage node \$9 ----
xm1_b_n9 rwl_0__t2_b_n9 n7__t0_b_n9 rbl_0__t0_b_n9 gnd__t0_b_n9 sky130_fd_pr__nfet_01v8 L=0.15 W=0.42 nf=1 ad=0.1197 as=0.1197 pd=1.41 ps=1.41 mult=1 m=1
xm2_b_n9 rwl_0__t3_b_n9 n8__t1_b_n9 rbl_1__t1_b_n9 gnd__t1_b_n9 sky130_fd_pr__nfet_01v8 L=0.15 W=0.42 nf=1 ad=0.1197 as=0.1197 pd=1.41 ps=1.41 mult=1 m=1
xm3_b_n9 rwl_0__t1_b_n9 n9__t1_b_n9 rbl_2__t1_b_n9 gnd__t2_b_n9 sky130_fd_pr__nfet_01v8 L=0.15 W=0.42 nf=1 ad=0.1197 as=0.1197 pd=1.41 ps=1.41 mult=1 m=1
xm4_b_n9 rwl_0__t0_b_n9 n10__t1_b_n9 rbl_3__t1_b_n9 gnd__t3_b_n9 sky130_fd_pr__nfet_01v8 L=0.15 W=0.42 nf=1 ad=0.1197 as=0.1197 pd=1.41 ps=1.41 mult=1 m=1
xm5_b_n9 bl_0__t0_b_n9 wl_0__t0_b_n9 n7__t1_b_n9 gnd__t8_b_n9 sky130_fd_pr__nfet_01v8 L=0.15 W=0.42 nf=1 ad=0.0588 as=0.1197 pd=0.7 ps=1.41 mult=1 m=1
xm6_b_n9 n17__t0_b_n9 wl_1__t0_b_n9 bl_0__t1_b_n9 gnd__t20_b_n9 sky130_fd_pr__nfet_01v8 L=0.15 W=0.42 nf=1 ad=0.1197 as=0.0588 pd=1.41 ps=0.7 mult=1 m=1
xm7_b_n9 bl_1__t2_b_n9 wl_0__t3_b_n9 n8__t0_b_n9 gnd__t9_b_n9 sky130_fd_pr__nfet_01v8 L=0.15 W=0.42 nf=1 ad=0.0588 as=0.1197 pd=0.7 ps=1.41 mult=1 m=1
xm8_b_n9 n18__t0_b_n9 wl_1__t1_b_n9 bl_1__t0_b_n9 gnd__t21_b_n9 sky130_fd_pr__nfet_01v8 L=0.15 W=0.42 nf=1 ad=0.1197 as=0.0588 pd=1.41 ps=0.7 mult=1 m=1
xm9_b_n9 bl_2__t2_b_n9 wl_0__t2_b_n9 n9__t0_b_n9 gnd__t10_b_n9 sky130_fd_pr__nfet_01v8 L=0.15 W=0.42 nf=1 ad=0.0588 as=0.1197 pd=0.7 ps=1.41 mult=1 m=1
xm10_b_n9 n19__t0_b_n9 wl_1__t2_b_n9 bl_2__t0_b_n9 gnd__t22_b_n9 sky130_fd_pr__nfet_01v8 L=0.15 W=0.42 nf=1 ad=0.1197 as=0.0588 pd=1.41 ps=0.7 mult=1 m=1
xm11_b_n9 bl_3__t2_b_n9 wl_0__t1_b_n9 n10__t0_b_n9 gnd__t11_b_n9 sky130_fd_pr__nfet_01v8 L=0.15 W=0.42 nf=1 ad=0.0588 as=0.1197 pd=0.7 ps=1.41 mult=1 m=1
xm12_b_n9 n20__t0_b_n9 wl_1__t3_b_n9 bl_3__t1_b_n9 gnd__t23_b_n9 sky130_fd_pr__nfet_01v8 L=0.15 W=0.42 nf=1 ad=0.1197 as=0.0588 pd=1.41 ps=0.7 mult=1 m=1
xm13_b_n9 rbl_0__t3_b_n9 n17__t1_b_n9 rwl_1__t0_b_n9 gnd__t12_b_n9 sky130_fd_pr__nfet_01v8 L=0.15 W=0.42 nf=1 ad=0.0588 as=0.1197 pd=0.7 ps=1.41 mult=1 m=1
xm14_b_n9 rwl_2__t3_b_n9 n22__t0_b_n9 rbl_0__t2_b_n9 gnd__t24_b_n9 sky130_fd_pr__nfet_01v8 L=0.15 W=0.42 nf=1 ad=0.1197 as=0.0588 pd=1.41 ps=0.7 mult=1 m=1
xm15_b_n9 rbl_1__t3_b_n9 n18__t1_b_n9 rwl_1__t1_b_n9 gnd__t13_b_n9 sky130_fd_pr__nfet_01v8 L=0.15 W=0.42 nf=1 ad=0.0588 as=0.1197 pd=0.7 ps=1.41 mult=1 m=1
xm16_b_n9 rwl_2__t0_b_n9 n23__t0_b_n9 rbl_1__t2_b_n9 gnd__t25_b_n9 sky130_fd_pr__nfet_01v8 L=0.15 W=0.42 nf=1 ad=0.1197 as=0.0588 pd=1.41 ps=0.7 mult=1 m=1
xm17_b_n9 rbl_2__t3_b_n9 n19__t1_b_n9 rwl_1__t2_b_n9 gnd__t14_b_n9 sky130_fd_pr__nfet_01v8 L=0.15 W=0.42 nf=1 ad=0.0588 as=0.1197 pd=0.7 ps=1.41 mult=1 m=1
xm18_b_n9 rwl_2__t1_b_n9 n24__t0_b_n9 rbl_2__t2_b_n9 gnd__t26_b_n9 sky130_fd_pr__nfet_01v8 L=0.15 W=0.42 nf=1 ad=0.1197 as=0.0588 pd=1.41 ps=0.7 mult=1 m=1
xm19_b_n9 rbl_3__t3_b_n9 n20__t1_b_n9 rwl_1__t3_b_n9 gnd__t15_b_n9 sky130_fd_pr__nfet_01v8 L=0.15 W=0.42 nf=1 ad=0.0588 as=0.1197 pd=0.7 ps=1.41 mult=1 m=1
xm20_b_n9 rwl_2__t2_b_n9 n25__t0_b_n9 rbl_3__t2_b_n9 gnd__t27_b_n9 sky130_fd_pr__nfet_01v8 L=0.15 W=0.42 nf=1 ad=0.1197 as=0.0588 pd=1.41 ps=0.7 mult=1 m=1
xm21_b_n9 bl_0__t3_b_n9 wl_2__t0_b_n9 n22__t1_b_n9 gnd__t16_b_n9 sky130_fd_pr__nfet_01v8 L=0.15 W=0.42 nf=1 ad=0.0588 as=0.1197 pd=0.7 ps=1.41 mult=1 m=1
xm22_b_n9 n29__t0_b_n9 wl_3__t3_b_n9 bl_0__t2_b_n9 gnd__t28_b_n9 sky130_fd_pr__nfet_01v8 L=0.15 W=0.42 nf=1 ad=0.1197 as=0.0588 pd=1.41 ps=0.7 mult=1 m=1
xm23_b_n9 bl_1__t3_b_n9 wl_2__t1_b_n9 n23__t1_b_n9 gnd__t17_b_n9 sky130_fd_pr__nfet_01v8 L=0.15 W=0.42 nf=1 ad=0.0588 as=0.1197 pd=0.7 ps=1.41 mult=1 m=1
xm24_b_n9 n30__t0_b_n9 wl_3__t2_b_n9 bl_1__t1_b_n9 gnd__t29_b_n9 sky130_fd_pr__nfet_01v8 L=0.15 W=0.42 nf=1 ad=0.1197 as=0.0588 pd=1.41 ps=0.7 mult=1 m=1
xm25_b_n9 bl_2__t3_b_n9 wl_2__t2_b_n9 n24__t1_b_n9 gnd__t18_b_n9 sky130_fd_pr__nfet_01v8 L=0.15 W=0.42 nf=1 ad=0.0588 as=0.1197 pd=0.7 ps=1.41 mult=1 m=1
xm26_b_n9 n31__t0_b_n9 wl_3__t1_b_n9 bl_2__t1_b_n9 gnd__t30_b_n9 sky130_fd_pr__nfet_01v8 L=0.15 W=0.42 nf=1 ad=0.1197 as=0.0588 pd=1.41 ps=0.7 mult=1 m=1
xm27_b_n9 bl_3__t3_b_n9 wl_2__t3_b_n9 n25__t1_b_n9 gnd__t19_b_n9 sky130_fd_pr__nfet_01v8 L=0.15 W=0.42 nf=1 ad=0.0588 as=0.1197 pd=0.7 ps=1.41 mult=1 m=1
xm28_b_n9 n32__t0_b_n9 wl_3__t0_b_n9 bl_3__t0_b_n9 gnd__t31_b_n9 sky130_fd_pr__nfet_01v8 L=0.15 W=0.42 nf=1 ad=0.1197 as=0.0588 pd=1.41 ps=0.7 mult=1 m=1
xm29_b_n9 rbl_0__t1_b_n9 n29__t1_b_n9 rwl_3__t0_b_n9 gnd__t4_b_n9 sky130_fd_pr__nfet_01v8 L=0.15 W=0.42 nf=1 ad=0.1197 as=0.1197 pd=1.41 ps=1.41 mult=1 m=1
xm30_b_n9 rbl_1__t0_b_n9 n30__t1_b_n9 rwl_3__t1_b_n9 gnd__t5_b_n9 sky130_fd_pr__nfet_01v8 L=0.15 W=0.42 nf=1 ad=0.1197 as=0.1197 pd=1.41 ps=1.41 mult=1 m=1
xm31_b_n9 rbl_2__t0_b_n9 n31__t1_b_n9 rwl_3__t2_b_n9 gnd__t6_b_n9 sky130_fd_pr__nfet_01v8 L=0.15 W=0.42 nf=1 ad=0.1197 as=0.1197 pd=1.41 ps=1.41 mult=1 m=1
xm32_b_n9 rbl_3__t0_b_n9 n32__t1_b_n9 rwl_3__t3_b_n9 gnd__t7_b_n9 sky130_fd_pr__nfet_01v8 L=0.15 W=0.42 nf=1 ad=0.1197 as=0.1197 pd=1.41 ps=1.41 mult=1 m=1
r_10_t0_b_n9 n10__t0_b_n9 n10_b_n9 183.071
r_10_t1_b_n9 n10__t1_b_n9 n10_b_n9 183.071
r_17_t0_b_n9 n17__t0_b_n9 n17_b_n9 183.071
r_17_t1_b_n9 n17__t1_b_n9 n17_b_n9 183.071
r_18_t0_b_n9 n18__t0_b_n9 n18_b_n9 183.071
r_18_t1_b_n9 n18__t1_b_n9 n18_b_n9 183.071
r_19_t0_b_n9 n19__t0_b_n9 n19_b_n9 183.071
r_19_t1_b_n9 n19__t1_b_n9 n19_b_n9 183.071
r_20_t0_b_n9 n20__t0_b_n9 n20_b_n9 183.071
r_20_t1_b_n9 n20__t1_b_n9 n20_b_n9 183.071
r_22_t0_b_n9 n22__t0_b_n9 n22_b_n9 183.071
r_22_t1_b_n9 n22__t1_b_n9 n22_b_n9 183.071
r_23_t0_b_n9 n23__t0_b_n9 n23_b_n9 183.071
r_23_t1_b_n9 n23__t1_b_n9 n23_b_n9 183.071
r_24_t0_b_n9 n24__t0_b_n9 n24_b_n9 183.071
r_24_t1_b_n9 n24__t1_b_n9 n24_b_n9 183.071
r_25_t0_b_n9 n25__t0_b_n9 n25_b_n9 183.071
r_25_t1_b_n9 n25__t1_b_n9 n25_b_n9 183.071
r_29_t0_b_n9 n29__t0_b_n9 n29_b_n9 183.071
r_29_t1_b_n9 n29__t1_b_n9 n29_b_n9 183.071
r_30_t0_b_n9 n30__t0_b_n9 n30_b_n9 183.071
r_30_t1_b_n9 n30__t1_b_n9 n30_b_n9 183.071
r_31_t0_b_n9 n31__t0_b_n9 n31_b_n9 183.071
r_31_t1_b_n9 n31__t1_b_n9 n31_b_n9 183.071
r_32_t0_b_n9 n32__t0_b_n9 n32_b_n9 183.071
r_32_t1_b_n9 n32__t1_b_n9 n32_b_n9 183.071
r_7_t0_b_n9 n7__t0_b_n9 n7_b_n9 183.071
r_7_t1_b_n9 n7__t1_b_n9 n7_b_n9 183.071
r_8_t0_b_n9 n8__t0_b_n9 n8_b_n9 183.071
r_8_t1_b_n9 n8__t1_b_n9 n8_b_n9 183.071
r_9_t0_b_n9 n9__t0_b_n9 n9_b_n9 183.071
r_9_t1_b_n9 n9__t1_b_n9 n9_b_n9 183.071
rgnd_t0_b_n9 gnd__t0_b_n9 0 38.2988
rgnd_t1_b_n9 gnd__t1_b_n9 0 33.9576
rgnd_t2_b_n9 gnd__t2_b_n9 0 33.9576
rgnd_t3_b_n9 gnd__t3_b_n9 0 38.2988
rgnd_t4_b_n9 gnd__t4_b_n9 0 38.2988
rgnd_t5_b_n9 gnd__t5_b_n9 0 33.9576
rgnd_t6_b_n9 gnd__t6_b_n9 0 33.9576
rgnd_t7_b_n9 gnd__t7_b_n9 0 38.2988
rgnd_t8_b_n9 gnd__t8_b_n9 0 28.0185
rgnd_t9_b_n9 gnd__t9_b_n9 0 21.7106
rgnd_t10_b_n9 gnd__t10_b_n9 0 21.7106
rgnd_t11_b_n9 gnd__t11_b_n9 0 28.0185
rgnd_t12_b_n9 gnd__t12_b_n9 0 18.9833
rgnd_t13_b_n9 gnd__t13_b_n9 0 6.8325
rgnd_t14_b_n9 gnd__t14_b_n9 0 6.8325
rgnd_t15_b_n9 gnd__t15_b_n9 0 18.9833
rgnd_t16_b_n9 gnd__t16_b_n9 0 24.2409
rgnd_t17_b_n9 gnd__t17_b_n9 0 16.5511
rgnd_t18_b_n9 gnd__t18_b_n9 0 16.5511
rgnd_t19_b_n9 gnd__t19_b_n9 0 24.2409
rgnd_t20_b_n9 gnd__t20_b_n9 0 24.2409
rgnd_t21_b_n9 gnd__t21_b_n9 0 16.5511
rgnd_t22_b_n9 gnd__t22_b_n9 0 16.5511
rgnd_t23_b_n9 gnd__t23_b_n9 0 24.2409
rgnd_t24_b_n9 gnd__t24_b_n9 0 18.9833
rgnd_t25_b_n9 gnd__t25_b_n9 0 6.8325
rgnd_t26_b_n9 gnd__t26_b_n9 0 6.8325
rgnd_t27_b_n9 gnd__t27_b_n9 0 18.9833
rgnd_t28_b_n9 gnd__t28_b_n9 0 28.0185
rgnd_t29_b_n9 gnd__t29_b_n9 0 21.7106
rgnd_t30_b_n9 gnd__t30_b_n9 0 21.7106
rgnd_t31_b_n9 gnd__t31_b_n9 0 28.0185
rbl_0_t0_b_n9 bl_0__t0_b_n9 bl_0_b_n9 14.8304
rbl_0_t1_b_n9 bl_0__t1_b_n9 bl_0_b_n9 10.9301
rbl_0_t2_b_n9 bl_0__t2_b_n9 bl_0_b_n9 14.8304
rbl_0_t3_b_n9 bl_0__t3_b_n9 bl_0_b_n9 10.9301
rbl_1_t0_b_n9 bl_1__t0_b_n9 bl_1_b_n9 10.9301
rbl_1_t1_b_n9 bl_1__t1_b_n9 bl_1_b_n9 14.8304
rbl_1_t2_b_n9 bl_1__t2_b_n9 bl_1_b_n9 14.8304
rbl_1_t3_b_n9 bl_1__t3_b_n9 bl_1_b_n9 10.9301
rbl_2_t0_b_n9 bl_2__t0_b_n9 bl_2_b_n9 10.9301
rbl_2_t1_b_n9 bl_2__t1_b_n9 bl_2_b_n9 14.8304
rbl_2_t2_b_n9 bl_2__t2_b_n9 bl_2_b_n9 14.8304
rbl_2_t3_b_n9 bl_2__t3_b_n9 bl_2_b_n9 10.9301
rbl_3_t0_b_n9 bl_3__t0_b_n9 bl_3_b_n9 14.8304
rbl_3_t1_b_n9 bl_3__t1_b_n9 bl_3_b_n9 10.9301
rbl_3_t2_b_n9 bl_3__t2_b_n9 bl_3_b_n9 14.8304
rbl_3_t3_b_n9 bl_3__t3_b_n9 bl_3_b_n9 10.9301
rrbl_0_t0_b_n9 rbl_0__t0_b_n9 rbl_0_b_n9 36.5601
rrbl_0_t1_b_n9 rbl_0__t1_b_n9 rbl_0_b_n9 36.5601
rrbl_0_t2_b_n9 rbl_0__t2_b_n9 rbl_0_b_n9 2.99444
rrbl_0_t3_b_n9 rbl_0__t3_b_n9 rbl_0_b_n9 2.99444
rrbl_1_t0_b_n9 rbl_1__t0_b_n9 rbl_1_b_n9 36.5601
rrbl_1_t1_b_n9 rbl_1__t1_b_n9 rbl_1_b_n9 36.5601
rrbl_1_t2_b_n9 rbl_1__t2_b_n9 rbl_1_b_n9 2.99444
rrbl_1_t3_b_n9 rbl_1__t3_b_n9 rbl_1_b_n9 2.99444
rrbl_2_t0_b_n9 rbl_2__t0_b_n9 rbl_2_b_n9 36.5601
rrbl_2_t1_b_n9 rbl_2__t1_b_n9 rbl_2_b_n9 36.5601
rrbl_2_t2_b_n9 rbl_2__t2_b_n9 rbl_2_b_n9 2.99444
rrbl_2_t3_b_n9 rbl_2__t3_b_n9 rbl_2_b_n9 2.99444
rrbl_3_t0_b_n9 rbl_3__t0_b_n9 rbl_3_b_n9 36.5601
rrbl_3_t1_b_n9 rbl_3__t1_b_n9 rbl_3_b_n9 36.5601
rrbl_3_t2_b_n9 rbl_3__t2_b_n9 rbl_3_b_n9 2.99444
rrbl_3_t3_b_n9 rbl_3__t3_b_n9 rbl_3_b_n9 2.99444
rrwl_0_t0_b_n9 rwl_0__t0_b_n9 rwl_0_b_n9 38.2618
rrwl_0_t1_b_n9 rwl_0__t1_b_n9 rwl_0_b_n9 12.7539
rrwl_0_t2_b_n9 rwl_0__t2_b_n9 rwl_0_b_n9 38.2618
rrwl_0_t3_b_n9 rwl_0__t3_b_n9 rwl_0_b_n9 12.7539
rrwl_1_t0_b_n9 rwl_1__t0_b_n9 rwl_1_b_n9 38.2618
rrwl_1_t1_b_n9 rwl_1__t1_b_n9 rwl_1_b_n9 12.7539
rrwl_1_t2_b_n9 rwl_1__t2_b_n9 rwl_1_b_n9 12.7539
rrwl_1_t3_b_n9 rwl_1__t3_b_n9 rwl_1_b_n9 38.2618
rrwl_2_t0_b_n9 rwl_2__t0_b_n9 rwl_2_b_n9 12.7539
rrwl_2_t1_b_n9 rwl_2__t1_b_n9 rwl_2_b_n9 12.7539
rrwl_2_t2_b_n9 rwl_2__t2_b_n9 rwl_2_b_n9 38.2618
rrwl_2_t3_b_n9 rwl_2__t3_b_n9 rwl_2_b_n9 38.2618
rrwl_3_t0_b_n9 rwl_3__t0_b_n9 rwl_3_b_n9 38.2618
rrwl_3_t1_b_n9 rwl_3__t1_b_n9 rwl_3_b_n9 12.7539
rrwl_3_t2_b_n9 rwl_3__t2_b_n9 rwl_3_b_n9 12.7539
rrwl_3_t3_b_n9 rwl_3__t3_b_n9 rwl_3_b_n9 38.2618
rwl_0_t0_b_n9 wl_0__t0_b_n9 wl_0_b_n9 245.959
rwl_0_t1_b_n9 wl_0__t1_b_n9 wl_0_b_n9 245.959
rwl_0_t2_b_n9 wl_0__t2_b_n9 wl_0_b_n9 81.9864
rwl_0_t3_b_n9 wl_0__t3_b_n9 wl_0_b_n9 81.9864
rwl_1_t0_b_n9 wl_1__t0_b_n9 wl_1_b_n9 245.959
rwl_1_t1_b_n9 wl_1__t1_b_n9 wl_1_b_n9 81.9864
rwl_1_t2_b_n9 wl_1__t2_b_n9 wl_1_b_n9 81.9864
rwl_1_t3_b_n9 wl_1__t3_b_n9 wl_1_b_n9 245.959
rwl_2_t0_b_n9 wl_2__t0_b_n9 wl_2_b_n9 245.959
rwl_2_t1_b_n9 wl_2__t1_b_n9 wl_2_b_n9 81.9864
rwl_2_t2_b_n9 wl_2__t2_b_n9 wl_2_b_n9 81.9864
rwl_2_t3_b_n9 wl_2__t3_b_n9 wl_2_b_n9 245.959
rwl_3_t0_b_n9 wl_3__t0_b_n9 wl_3_b_n9 245.959
rwl_3_t1_b_n9 wl_3__t1_b_n9 wl_3_b_n9 81.9864
rwl_3_t2_b_n9 wl_3__t2_b_n9 wl_3_b_n9 81.9864
rwl_3_t3_b_n9 wl_3__t3_b_n9 wl_3_b_n9 245.959
c_10_b_n9 n10_b_n9 0 2.91622e-16
c_17_b_n9 n17_b_n9 0 2.91528e-16
c_18_b_n9 n18_b_n9 0 2.91528e-16
c_19_b_n9 n19_b_n9 0 2.91528e-16
c_20_b_n9 n20_b_n9 0 2.91622e-16
c_22_b_n9 n22_b_n9 0 2.91528e-16
c_23_b_n9 n23_b_n9 0 2.91528e-16
c_24_b_n9 n24_b_n9 0 2.91528e-16
c_25_b_n9 n25_b_n9 0 2.91622e-16
c_29_b_n9 n29_b_n9 0 2.91528e-16
c_30_b_n9 n30_b_n9 0 2.91528e-16
c_31_b_n9 n31_b_n9 0 2.91528e-16
c_32_b_n9 n32_b_n9 0 2.91622e-16
c_7_b_n9 n7_b_n9 0 2.91528e-16
c_8_b_n9 n8_b_n9 0 2.91528e-16
c_9_b_n9 n9_b_n9 0 2.91528e-16
cgnd_b_n9 0 0 2.48166e-15
cbl_0_b_n9 bl_0_b_n9 0 4.52661e-16
cbl_1_b_n9 bl_1_b_n9 0 4.52661e-16
cbl_2_b_n9 bl_2_b_n9 0 4.52661e-16
cbl_3_b_n9 bl_3_b_n9 0 4.52661e-16
crbl_0_b_n9 rbl_0_b_n9 0 9.14472e-16
crbl_1_b_n9 rbl_1_b_n9 0 9.14472e-16
crbl_2_b_n9 rbl_2_b_n9 0 9.14472e-16
crbl_3_b_n9 rbl_3_b_n9 0 9.17566e-16
crwl_0_b_n9 rwl_0_b_n9 0 5.19495e-16
crwl_1_b_n9 rwl_1_b_n9 0 5.11719e-16
crwl_2_b_n9 rwl_2_b_n9 0 5.11719e-16
crwl_3_b_n9 rwl_3_b_n9 0 5.19495e-16
cwl_0_b_n9 wl_0_b_n9 0 3.30388e-16
cwl_1_b_n9 wl_1_b_n9 0 3.30388e-16
cwl_2_b_n9 wl_2_b_n9 0 3.30388e-16
cwl_3_b_n9 wl_3_b_n9 0 3.30388e-16
ccc__10__9_b_n9 n10_b_n9 n9_b_n9 1.02e-17
ccc__10_bl_3_b_n9 n10_b_n9 bl_3_b_n9 1.3999e-17
ccc__10_rwl_0_b_n9 n10_b_n9 rwl_0_b_n9 4.335e-18
ccc__17__18_b_n9 n17_b_n9 n18_b_n9 1.02e-17
ccc__17_bl_0_b_n9 n17_b_n9 bl_0_b_n9 8.415e-18
ccc__17_rwl_1_b_n9 n17_b_n9 rwl_1_b_n9 1.3194e-17
ccc__18__19_b_n9 n18_b_n9 n19_b_n9 1.02e-17
ccc__18_bl_1_b_n9 n18_b_n9 bl_1_b_n9 8.415e-18
ccc__18_rwl_1_b_n9 n18_b_n9 rwl_1_b_n9 1.3194e-17
ccc__19__20_b_n9 n19_b_n9 n20_b_n9 1.02e-17
ccc__19_bl_2_b_n9 n19_b_n9 bl_2_b_n9 8.415e-18
ccc__19_rwl_1_b_n9 n19_b_n9 rwl_1_b_n9 1.3194e-17
ccc__20_bl_3_b_n9 n20_b_n9 bl_3_b_n9 8.415e-18
ccc__20_rwl_1_b_n9 n20_b_n9 rwl_1_b_n9 6.655e-18
ccc__22__23_b_n9 n22_b_n9 n23_b_n9 1.02e-17
ccc__22_bl_0_b_n9 n22_b_n9 bl_0_b_n9 8.415e-18
ccc__22_rwl_2_b_n9 n22_b_n9 rwl_2_b_n9 1.3194e-17
ccc__23__24_b_n9 n23_b_n9 n24_b_n9 1.02e-17
ccc__23_bl_1_b_n9 n23_b_n9 bl_1_b_n9 8.415e-18
ccc__23_rwl_2_b_n9 n23_b_n9 rwl_2_b_n9 1.3194e-17
ccc__24__25_b_n9 n24_b_n9 n25_b_n9 1.02e-17
ccc__24_bl_2_b_n9 n24_b_n9 bl_2_b_n9 8.415e-18
ccc__24_rwl_2_b_n9 n24_b_n9 rwl_2_b_n9 1.3194e-17
ccc__25_bl_3_b_n9 n25_b_n9 bl_3_b_n9 8.415e-18
ccc__25_rwl_2_b_n9 n25_b_n9 rwl_2_b_n9 6.655e-18
ccc__29__30_b_n9 n29_b_n9 n30_b_n9 1.02e-17
ccc__29_bl_0_b_n9 n29_b_n9 bl_0_b_n9 8.415e-18
ccc__29_rwl_3_b_n9 n29_b_n9 rwl_3_b_n9 1.3194e-17
ccc__30__31_b_n9 n30_b_n9 n31_b_n9 1.02e-17
ccc__30_bl_1_b_n9 n30_b_n9 bl_1_b_n9 8.415e-18
ccc__30_rwl_3_b_n9 n30_b_n9 rwl_3_b_n9 1.3194e-17
ccc__31__32_b_n9 n31_b_n9 n32_b_n9 1.02e-17
ccc__31_bl_2_b_n9 n31_b_n9 bl_2_b_n9 8.415e-18
ccc__31_rwl_3_b_n9 n31_b_n9 rwl_3_b_n9 1.3194e-17
ccc__32_bl_3_b_n9 n32_b_n9 bl_3_b_n9 8.415e-18
ccc__32_rwl_3_b_n9 n32_b_n9 rwl_3_b_n9 6.655e-18
ccc__7__8_b_n9 n7_b_n9 n8_b_n9 1.02e-17
ccc__7_bl_0_b_n9 n7_b_n9 bl_0_b_n9 1.3999e-17
ccc__7_rwl_0_b_n9 n7_b_n9 rwl_0_b_n9 8.961e-18
ccc__8__9_b_n9 n8_b_n9 n9_b_n9 1.02e-17
ccc__8_bl_1_b_n9 n8_b_n9 bl_1_b_n9 1.3999e-17
ccc__8_rwl_0_b_n9 n8_b_n9 rwl_0_b_n9 8.961e-18
ccc__9_bl_2_b_n9 n9_b_n9 bl_2_b_n9 1.3999e-17
ccc__9_rwl_0_b_n9 n9_b_n9 rwl_0_b_n9 8.961e-18
ccc_bl_0_rbl_0_b_n9 bl_0_b_n9 rbl_0_b_n9 1.88693e-16
ccc_bl_0_rwl_1_b_n9 bl_0_b_n9 rwl_1_b_n9 1.0093e-17
ccc_bl_0_rwl_2_b_n9 bl_0_b_n9 rwl_2_b_n9 1.0093e-17
ccc_bl_1_rbl_0_b_n9 bl_1_b_n9 rbl_0_b_n9 1.633e-16
ccc_bl_1_rbl_1_b_n9 bl_1_b_n9 rbl_1_b_n9 1.88693e-16
ccc_bl_1_rwl_1_b_n9 bl_1_b_n9 rwl_1_b_n9 1.0093e-17
ccc_bl_1_rwl_2_b_n9 bl_1_b_n9 rwl_2_b_n9 1.0093e-17
ccc_bl_2_rbl_1_b_n9 bl_2_b_n9 rbl_1_b_n9 1.633e-16
ccc_bl_2_rbl_2_b_n9 bl_2_b_n9 rbl_2_b_n9 1.88693e-16
ccc_bl_2_rwl_1_b_n9 bl_2_b_n9 rwl_1_b_n9 1.0093e-17
ccc_bl_2_rwl_2_b_n9 bl_2_b_n9 rwl_2_b_n9 1.0093e-17
ccc_bl_3_rbl_2_b_n9 bl_3_b_n9 rbl_2_b_n9 1.633e-16
ccc_bl_3_rbl_3_b_n9 bl_3_b_n9 rbl_3_b_n9 1.88693e-16
ccc_bl_3_rwl_1_b_n9 bl_3_b_n9 rwl_1_b_n9 1.0093e-17
ccc_bl_3_rwl_2_b_n9 bl_3_b_n9 rwl_2_b_n9 1.0093e-17
ccc_rbl_0_rbl_1_b_n9 rbl_0_b_n9 rbl_1_b_n9 3.432e-17
ccc_rbl_0_rwl_0_b_n9 rbl_0_b_n9 rwl_0_b_n9 4.9752e-17
ccc_rbl_0_rwl_1_b_n9 rbl_0_b_n9 rwl_1_b_n9 4.9752e-17
ccc_rbl_0_rwl_2_b_n9 rbl_0_b_n9 rwl_2_b_n9 4.9752e-17
ccc_rbl_0_rwl_3_b_n9 rbl_0_b_n9 rwl_3_b_n9 4.9752e-17
ccc_rbl_1_rbl_2_b_n9 rbl_1_b_n9 rbl_2_b_n9 3.432e-17
ccc_rbl_1_rwl_0_b_n9 rbl_1_b_n9 rwl_0_b_n9 4.9752e-17
ccc_rbl_1_rwl_1_b_n9 rbl_1_b_n9 rwl_1_b_n9 4.9752e-17
ccc_rbl_1_rwl_2_b_n9 rbl_1_b_n9 rwl_2_b_n9 4.9752e-17
ccc_rbl_1_rwl_3_b_n9 rbl_1_b_n9 rwl_3_b_n9 4.9752e-17
ccc_rbl_2_rbl_3_b_n9 rbl_2_b_n9 rbl_3_b_n9 3.432e-17
ccc_rbl_2_rwl_0_b_n9 rbl_2_b_n9 rwl_0_b_n9 4.9752e-17
ccc_rbl_2_rwl_1_b_n9 rbl_2_b_n9 rwl_1_b_n9 4.9752e-17
ccc_rbl_2_rwl_2_b_n9 rbl_2_b_n9 rwl_2_b_n9 4.9752e-17
ccc_rbl_2_rwl_3_b_n9 rbl_2_b_n9 rwl_3_b_n9 4.9752e-17
ccc_rbl_3_rwl_0_b_n9 rbl_3_b_n9 rwl_0_b_n9 3.3407e-17
ccc_rbl_3_rwl_1_b_n9 rbl_3_b_n9 rwl_1_b_n9 3.3407e-17
ccc_rbl_3_rwl_2_b_n9 rbl_3_b_n9 rwl_2_b_n9 3.3407e-17
ccc_rbl_3_rwl_3_b_n9 rbl_3_b_n9 rwl_3_b_n9 3.3407e-17
vdw_b_n9_0 wl_0_b_n9 0 dc 0
vdr_b_n9_0 rwl_0_b_n9 0 dc 0
vdw_b_n9_1 wl_1_b_n9 0 dc 0
vdr_b_n9_1 rwl_1_b_n9 0 dc 0
vdw_b_n9_2 wl_2_b_n9 0 dc 0
vdr_b_n9_2 rwl_2_b_n9 0 dc 0
vdw_b_n9_3 wl_3_b_n9 0 dc 0
vdr_b_n9_3 rwl_3_b_n9 0 dc 0
vdb_b_n9_0 bl_0_b_n9 0 dc 0
vdp_b_n9_0 rbl_0_b_n9 0 dc 0
vdb_b_n9_1 bl_1_b_n9 0 dc 0
vdp_b_n9_1 rbl_1_b_n9 0 dc 0
vdb_b_n9_2 bl_2_b_n9 0 dc 0
vdp_b_n9_2 rbl_2_b_n9 0 dc 0
vdb_b_n9_3 bl_3_b_n9 0 dc 0
vdp_b_n9_3 rbl_3_b_n9 0 dc 0
vdn_b_n9_n7 n7_b_n9 0 dc 1
vdn_b_n9_n8 n8_b_n9 0 dc 1
vdn_b_n9_n10 n10_b_n9 0 dc 1
vdn_b_n9_n17 n17_b_n9 0 dc 1
vdn_b_n9_n18 n18_b_n9 0 dc 1
vdn_b_n9_n19 n19_b_n9 0 dc 1
vdn_b_n9_n20 n20_b_n9 0 dc 1
vdn_b_n9_n22 n22_b_n9 0 dc 1
vdn_b_n9_n23 n23_b_n9 0 dc 1
vdn_b_n9_n24 n24_b_n9 0 dc 1
vdn_b_n9_n25 n25_b_n9 0 dc 1
vdn_b_n9_n29 n29_b_n9 0 dc 1
vdn_b_n9_n30 n30_b_n9 0 dc 1
vdn_b_n9_n31 n31_b_n9 0 dc 1
vdn_b_n9_n32 n32_b_n9 0 dc 1
bdr_b_n9 n9_b_n9 0 i=5e-08*min(1,max(0,(time-1e-09)/0.2n))*0.5*(1+tanh((v(n9_b_n9)-0.05)/0.01))

* ---- instance b_n10: variant b, probed storage node \$10 ----
xm1_b_n10 rwl_0__t2_b_n10 n7__t0_b_n10 rbl_0__t0_b_n10 gnd__t0_b_n10 sky130_fd_pr__nfet_01v8 L=0.15 W=0.42 nf=1 ad=0.1197 as=0.1197 pd=1.41 ps=1.41 mult=1 m=1
xm2_b_n10 rwl_0__t3_b_n10 n8__t1_b_n10 rbl_1__t1_b_n10 gnd__t1_b_n10 sky130_fd_pr__nfet_01v8 L=0.15 W=0.42 nf=1 ad=0.1197 as=0.1197 pd=1.41 ps=1.41 mult=1 m=1
xm3_b_n10 rwl_0__t1_b_n10 n9__t1_b_n10 rbl_2__t1_b_n10 gnd__t2_b_n10 sky130_fd_pr__nfet_01v8 L=0.15 W=0.42 nf=1 ad=0.1197 as=0.1197 pd=1.41 ps=1.41 mult=1 m=1
xm4_b_n10 rwl_0__t0_b_n10 n10__t1_b_n10 rbl_3__t1_b_n10 gnd__t3_b_n10 sky130_fd_pr__nfet_01v8 L=0.15 W=0.42 nf=1 ad=0.1197 as=0.1197 pd=1.41 ps=1.41 mult=1 m=1
xm5_b_n10 bl_0__t0_b_n10 wl_0__t0_b_n10 n7__t1_b_n10 gnd__t8_b_n10 sky130_fd_pr__nfet_01v8 L=0.15 W=0.42 nf=1 ad=0.0588 as=0.1197 pd=0.7 ps=1.41 mult=1 m=1
xm6_b_n10 n17__t0_b_n10 wl_1__t0_b_n10 bl_0__t1_b_n10 gnd__t20_b_n10 sky130_fd_pr__nfet_01v8 L=0.15 W=0.42 nf=1 ad=0.1197 as=0.0588 pd=1.41 ps=0.7 mult=1 m=1
xm7_b_n10 bl_1__t2_b_n10 wl_0__t3_b_n10 n8__t0_b_n10 gnd__t9_b_n10 sky130_fd_pr__nfet_01v8 L=0.15 W=0.42 nf=1 ad=0.0588 as=0.1197 pd=0.7 ps=1.41 mult=1 m=1
xm8_b_n10 n18__t0_b_n10 wl_1__t1_b_n10 bl_1__t0_b_n10 gnd__t21_b_n10 sky130_fd_pr__nfet_01v8 L=0.15 W=0.42 nf=1 ad=0.1197 as=0.0588 pd=1.41 ps=0.7 mult=1 m=1
xm9_b_n10 bl_2__t2_b_n10 wl_0__t2_b_n10 n9__t0_b_n10 gnd__t10_b_n10 sky130_fd_pr__nfet_01v8 L=0.15 W=0.42 nf=1 ad=0.0588 as=0.1197 pd=0.7 ps=1.41 mult=1 m=1
xm10_b_n10 n19__t0_b_n10 wl_1__t2_b_n10 bl_2__t0_b_n10 gnd__t22_b_n10 sky130_fd_pr__nfet_01v8 L=0.15 W=0.42 nf=1 ad=0.1197 as=0.0588 pd=1.41 ps=0.7 mult=1 m=1
xm11_b_n10 bl_3__t2_b_n10 wl_0__t1_b_n10 n10__t0_b_n10 gnd__t11_b_n10 sky130_fd_pr__nfet_01v8 L=0.15 W=0.42 nf=1 ad=0.0588 as=0.1197 pd=0.7 ps=1.41 mult=1 m=1
xm12_b_n10 n20__t0_b_n10 wl_1__t3_b_n10 bl_3__t1_b_n10 gnd__t23_b_n10 sky130_fd_pr__nfet_01v8 L=0.15 W=0.42 nf=1 ad=0.1197 as=0.0588 pd=1.41 ps=0.7 mult=1 m=1
xm13_b_n10 rbl_0__t3_b_n10 n17__t1_b_n10 rwl_1__t0_b_n10 gnd__t12_b_n10 sky130_fd_pr__nfet_01v8 L=0.15 W=0.42 nf=1 ad=0.0588 as=0.1197 pd=0.7 ps=1.41 mult=1 m=1
xm14_b_n10 rwl_2__t3_b_n10 n22__t0_b_n10 rbl_0__t2_b_n10 gnd__t24_b_n10 sky130_fd_pr__nfet_01v8 L=0.15 W=0.42 nf=1 ad=0.1197 as=0.0588 pd=1.41 ps=0.7 mult=1 m=1
xm15_b_n10 rbl_1__t3_b_n10 n18__t1_b_n10 rwl_1__t1_b_n10 gnd__t13_b_n10 sky130_fd_pr__nfet_01v8 L=0.15 W=0.42 nf=1 ad=0.0588 as=0.1197 pd=0.7 ps=1.41 mult=1 m=1
xm16_b_n10 rwl_2__t0_b_n10 n23__t0_b_n10 rbl_1__t2_b_n10 gnd__t25_b_n10 sky130_fd_pr__nfet_01v8 L=0.15 W=0.42 nf=1 ad=0.1197 as=0.0588 pd=1.41 ps=0.7 mult=1 m=1
xm17_b_n10 rbl_2__t3_b_n10 n19__t1_b_n10 rwl_1__t2_b_n10 gnd__t14_b_n10 sky130_fd_pr__nfet_01v8 L=0.15 W=0.42 nf=1 ad=0.0588 as=0.1197 pd=0.7 ps=1.41 mult=1 m=1
xm18_b_n10 rwl_2__t1_b_n10 n24__t0_b_n10 rbl_2__t2_b_n10 gnd__t26_b_n10 sky130_fd_pr__nfet_01v8 L=0.15 W=0.42 nf=1 ad=0.1197 as=0.0588 pd=1.41 ps=0.7 mult=1 m=1
xm19_b_n10 rbl_3__t3_b_n10 n20__t1_b_n10 rwl_1__t3_b_n10 gnd__t15_b_n10 sky130_fd_pr__nfet_01v8 L=0.15 W=0.42 nf=1 ad=0.0588 as=0.1197 pd=0.7 ps=1.41 mult=1 m=1
xm20_b_n10 rwl_2__t2_b_n10 n25__t0_b_n10 rbl_3__t2_b_n10 gnd__t27_b_n10 sky130_fd_pr__nfet_01v8 L=0.15 W=0.42 nf=1 ad=0.1197 as=0.0588 pd=1.41 ps=0.7 mult=1 m=1
xm21_b_n10 bl_0__t3_b_n10 wl_2__t0_b_n10 n22__t1_b_n10 gnd__t16_b_n10 sky130_fd_pr__nfet_01v8 L=0.15 W=0.42 nf=1 ad=0.0588 as=0.1197 pd=0.7 ps=1.41 mult=1 m=1
xm22_b_n10 n29__t0_b_n10 wl_3__t3_b_n10 bl_0__t2_b_n10 gnd__t28_b_n10 sky130_fd_pr__nfet_01v8 L=0.15 W=0.42 nf=1 ad=0.1197 as=0.0588 pd=1.41 ps=0.7 mult=1 m=1
xm23_b_n10 bl_1__t3_b_n10 wl_2__t1_b_n10 n23__t1_b_n10 gnd__t17_b_n10 sky130_fd_pr__nfet_01v8 L=0.15 W=0.42 nf=1 ad=0.0588 as=0.1197 pd=0.7 ps=1.41 mult=1 m=1
xm24_b_n10 n30__t0_b_n10 wl_3__t2_b_n10 bl_1__t1_b_n10 gnd__t29_b_n10 sky130_fd_pr__nfet_01v8 L=0.15 W=0.42 nf=1 ad=0.1197 as=0.0588 pd=1.41 ps=0.7 mult=1 m=1
xm25_b_n10 bl_2__t3_b_n10 wl_2__t2_b_n10 n24__t1_b_n10 gnd__t18_b_n10 sky130_fd_pr__nfet_01v8 L=0.15 W=0.42 nf=1 ad=0.0588 as=0.1197 pd=0.7 ps=1.41 mult=1 m=1
xm26_b_n10 n31__t0_b_n10 wl_3__t1_b_n10 bl_2__t1_b_n10 gnd__t30_b_n10 sky130_fd_pr__nfet_01v8 L=0.15 W=0.42 nf=1 ad=0.1197 as=0.0588 pd=1.41 ps=0.7 mult=1 m=1
xm27_b_n10 bl_3__t3_b_n10 wl_2__t3_b_n10 n25__t1_b_n10 gnd__t19_b_n10 sky130_fd_pr__nfet_01v8 L=0.15 W=0.42 nf=1 ad=0.0588 as=0.1197 pd=0.7 ps=1.41 mult=1 m=1
xm28_b_n10 n32__t0_b_n10 wl_3__t0_b_n10 bl_3__t0_b_n10 gnd__t31_b_n10 sky130_fd_pr__nfet_01v8 L=0.15 W=0.42 nf=1 ad=0.1197 as=0.0588 pd=1.41 ps=0.7 mult=1 m=1
xm29_b_n10 rbl_0__t1_b_n10 n29__t1_b_n10 rwl_3__t0_b_n10 gnd__t4_b_n10 sky130_fd_pr__nfet_01v8 L=0.15 W=0.42 nf=1 ad=0.1197 as=0.1197 pd=1.41 ps=1.41 mult=1 m=1
xm30_b_n10 rbl_1__t0_b_n10 n30__t1_b_n10 rwl_3__t1_b_n10 gnd__t5_b_n10 sky130_fd_pr__nfet_01v8 L=0.15 W=0.42 nf=1 ad=0.1197 as=0.1197 pd=1.41 ps=1.41 mult=1 m=1
xm31_b_n10 rbl_2__t0_b_n10 n31__t1_b_n10 rwl_3__t2_b_n10 gnd__t6_b_n10 sky130_fd_pr__nfet_01v8 L=0.15 W=0.42 nf=1 ad=0.1197 as=0.1197 pd=1.41 ps=1.41 mult=1 m=1
xm32_b_n10 rbl_3__t0_b_n10 n32__t1_b_n10 rwl_3__t3_b_n10 gnd__t7_b_n10 sky130_fd_pr__nfet_01v8 L=0.15 W=0.42 nf=1 ad=0.1197 as=0.1197 pd=1.41 ps=1.41 mult=1 m=1
r_10_t0_b_n10 n10__t0_b_n10 n10_b_n10 183.071
r_10_t1_b_n10 n10__t1_b_n10 n10_b_n10 183.071
r_17_t0_b_n10 n17__t0_b_n10 n17_b_n10 183.071
r_17_t1_b_n10 n17__t1_b_n10 n17_b_n10 183.071
r_18_t0_b_n10 n18__t0_b_n10 n18_b_n10 183.071
r_18_t1_b_n10 n18__t1_b_n10 n18_b_n10 183.071
r_19_t0_b_n10 n19__t0_b_n10 n19_b_n10 183.071
r_19_t1_b_n10 n19__t1_b_n10 n19_b_n10 183.071
r_20_t0_b_n10 n20__t0_b_n10 n20_b_n10 183.071
r_20_t1_b_n10 n20__t1_b_n10 n20_b_n10 183.071
r_22_t0_b_n10 n22__t0_b_n10 n22_b_n10 183.071
r_22_t1_b_n10 n22__t1_b_n10 n22_b_n10 183.071
r_23_t0_b_n10 n23__t0_b_n10 n23_b_n10 183.071
r_23_t1_b_n10 n23__t1_b_n10 n23_b_n10 183.071
r_24_t0_b_n10 n24__t0_b_n10 n24_b_n10 183.071
r_24_t1_b_n10 n24__t1_b_n10 n24_b_n10 183.071
r_25_t0_b_n10 n25__t0_b_n10 n25_b_n10 183.071
r_25_t1_b_n10 n25__t1_b_n10 n25_b_n10 183.071
r_29_t0_b_n10 n29__t0_b_n10 n29_b_n10 183.071
r_29_t1_b_n10 n29__t1_b_n10 n29_b_n10 183.071
r_30_t0_b_n10 n30__t0_b_n10 n30_b_n10 183.071
r_30_t1_b_n10 n30__t1_b_n10 n30_b_n10 183.071
r_31_t0_b_n10 n31__t0_b_n10 n31_b_n10 183.071
r_31_t1_b_n10 n31__t1_b_n10 n31_b_n10 183.071
r_32_t0_b_n10 n32__t0_b_n10 n32_b_n10 183.071
r_32_t1_b_n10 n32__t1_b_n10 n32_b_n10 183.071
r_7_t0_b_n10 n7__t0_b_n10 n7_b_n10 183.071
r_7_t1_b_n10 n7__t1_b_n10 n7_b_n10 183.071
r_8_t0_b_n10 n8__t0_b_n10 n8_b_n10 183.071
r_8_t1_b_n10 n8__t1_b_n10 n8_b_n10 183.071
r_9_t0_b_n10 n9__t0_b_n10 n9_b_n10 183.071
r_9_t1_b_n10 n9__t1_b_n10 n9_b_n10 183.071
rgnd_t0_b_n10 gnd__t0_b_n10 0 38.2988
rgnd_t1_b_n10 gnd__t1_b_n10 0 33.9576
rgnd_t2_b_n10 gnd__t2_b_n10 0 33.9576
rgnd_t3_b_n10 gnd__t3_b_n10 0 38.2988
rgnd_t4_b_n10 gnd__t4_b_n10 0 38.2988
rgnd_t5_b_n10 gnd__t5_b_n10 0 33.9576
rgnd_t6_b_n10 gnd__t6_b_n10 0 33.9576
rgnd_t7_b_n10 gnd__t7_b_n10 0 38.2988
rgnd_t8_b_n10 gnd__t8_b_n10 0 28.0185
rgnd_t9_b_n10 gnd__t9_b_n10 0 21.7106
rgnd_t10_b_n10 gnd__t10_b_n10 0 21.7106
rgnd_t11_b_n10 gnd__t11_b_n10 0 28.0185
rgnd_t12_b_n10 gnd__t12_b_n10 0 18.9833
rgnd_t13_b_n10 gnd__t13_b_n10 0 6.8325
rgnd_t14_b_n10 gnd__t14_b_n10 0 6.8325
rgnd_t15_b_n10 gnd__t15_b_n10 0 18.9833
rgnd_t16_b_n10 gnd__t16_b_n10 0 24.2409
rgnd_t17_b_n10 gnd__t17_b_n10 0 16.5511
rgnd_t18_b_n10 gnd__t18_b_n10 0 16.5511
rgnd_t19_b_n10 gnd__t19_b_n10 0 24.2409
rgnd_t20_b_n10 gnd__t20_b_n10 0 24.2409
rgnd_t21_b_n10 gnd__t21_b_n10 0 16.5511
rgnd_t22_b_n10 gnd__t22_b_n10 0 16.5511
rgnd_t23_b_n10 gnd__t23_b_n10 0 24.2409
rgnd_t24_b_n10 gnd__t24_b_n10 0 18.9833
rgnd_t25_b_n10 gnd__t25_b_n10 0 6.8325
rgnd_t26_b_n10 gnd__t26_b_n10 0 6.8325
rgnd_t27_b_n10 gnd__t27_b_n10 0 18.9833
rgnd_t28_b_n10 gnd__t28_b_n10 0 28.0185
rgnd_t29_b_n10 gnd__t29_b_n10 0 21.7106
rgnd_t30_b_n10 gnd__t30_b_n10 0 21.7106
rgnd_t31_b_n10 gnd__t31_b_n10 0 28.0185
rbl_0_t0_b_n10 bl_0__t0_b_n10 bl_0_b_n10 14.8304
rbl_0_t1_b_n10 bl_0__t1_b_n10 bl_0_b_n10 10.9301
rbl_0_t2_b_n10 bl_0__t2_b_n10 bl_0_b_n10 14.8304
rbl_0_t3_b_n10 bl_0__t3_b_n10 bl_0_b_n10 10.9301
rbl_1_t0_b_n10 bl_1__t0_b_n10 bl_1_b_n10 10.9301
rbl_1_t1_b_n10 bl_1__t1_b_n10 bl_1_b_n10 14.8304
rbl_1_t2_b_n10 bl_1__t2_b_n10 bl_1_b_n10 14.8304
rbl_1_t3_b_n10 bl_1__t3_b_n10 bl_1_b_n10 10.9301
rbl_2_t0_b_n10 bl_2__t0_b_n10 bl_2_b_n10 10.9301
rbl_2_t1_b_n10 bl_2__t1_b_n10 bl_2_b_n10 14.8304
rbl_2_t2_b_n10 bl_2__t2_b_n10 bl_2_b_n10 14.8304
rbl_2_t3_b_n10 bl_2__t3_b_n10 bl_2_b_n10 10.9301
rbl_3_t0_b_n10 bl_3__t0_b_n10 bl_3_b_n10 14.8304
rbl_3_t1_b_n10 bl_3__t1_b_n10 bl_3_b_n10 10.9301
rbl_3_t2_b_n10 bl_3__t2_b_n10 bl_3_b_n10 14.8304
rbl_3_t3_b_n10 bl_3__t3_b_n10 bl_3_b_n10 10.9301
rrbl_0_t0_b_n10 rbl_0__t0_b_n10 rbl_0_b_n10 36.5601
rrbl_0_t1_b_n10 rbl_0__t1_b_n10 rbl_0_b_n10 36.5601
rrbl_0_t2_b_n10 rbl_0__t2_b_n10 rbl_0_b_n10 2.99444
rrbl_0_t3_b_n10 rbl_0__t3_b_n10 rbl_0_b_n10 2.99444
rrbl_1_t0_b_n10 rbl_1__t0_b_n10 rbl_1_b_n10 36.5601
rrbl_1_t1_b_n10 rbl_1__t1_b_n10 rbl_1_b_n10 36.5601
rrbl_1_t2_b_n10 rbl_1__t2_b_n10 rbl_1_b_n10 2.99444
rrbl_1_t3_b_n10 rbl_1__t3_b_n10 rbl_1_b_n10 2.99444
rrbl_2_t0_b_n10 rbl_2__t0_b_n10 rbl_2_b_n10 36.5601
rrbl_2_t1_b_n10 rbl_2__t1_b_n10 rbl_2_b_n10 36.5601
rrbl_2_t2_b_n10 rbl_2__t2_b_n10 rbl_2_b_n10 2.99444
rrbl_2_t3_b_n10 rbl_2__t3_b_n10 rbl_2_b_n10 2.99444
rrbl_3_t0_b_n10 rbl_3__t0_b_n10 rbl_3_b_n10 36.5601
rrbl_3_t1_b_n10 rbl_3__t1_b_n10 rbl_3_b_n10 36.5601
rrbl_3_t2_b_n10 rbl_3__t2_b_n10 rbl_3_b_n10 2.99444
rrbl_3_t3_b_n10 rbl_3__t3_b_n10 rbl_3_b_n10 2.99444
rrwl_0_t0_b_n10 rwl_0__t0_b_n10 rwl_0_b_n10 38.2618
rrwl_0_t1_b_n10 rwl_0__t1_b_n10 rwl_0_b_n10 12.7539
rrwl_0_t2_b_n10 rwl_0__t2_b_n10 rwl_0_b_n10 38.2618
rrwl_0_t3_b_n10 rwl_0__t3_b_n10 rwl_0_b_n10 12.7539
rrwl_1_t0_b_n10 rwl_1__t0_b_n10 rwl_1_b_n10 38.2618
rrwl_1_t1_b_n10 rwl_1__t1_b_n10 rwl_1_b_n10 12.7539
rrwl_1_t2_b_n10 rwl_1__t2_b_n10 rwl_1_b_n10 12.7539
rrwl_1_t3_b_n10 rwl_1__t3_b_n10 rwl_1_b_n10 38.2618
rrwl_2_t0_b_n10 rwl_2__t0_b_n10 rwl_2_b_n10 12.7539
rrwl_2_t1_b_n10 rwl_2__t1_b_n10 rwl_2_b_n10 12.7539
rrwl_2_t2_b_n10 rwl_2__t2_b_n10 rwl_2_b_n10 38.2618
rrwl_2_t3_b_n10 rwl_2__t3_b_n10 rwl_2_b_n10 38.2618
rrwl_3_t0_b_n10 rwl_3__t0_b_n10 rwl_3_b_n10 38.2618
rrwl_3_t1_b_n10 rwl_3__t1_b_n10 rwl_3_b_n10 12.7539
rrwl_3_t2_b_n10 rwl_3__t2_b_n10 rwl_3_b_n10 12.7539
rrwl_3_t3_b_n10 rwl_3__t3_b_n10 rwl_3_b_n10 38.2618
rwl_0_t0_b_n10 wl_0__t0_b_n10 wl_0_b_n10 245.959
rwl_0_t1_b_n10 wl_0__t1_b_n10 wl_0_b_n10 245.959
rwl_0_t2_b_n10 wl_0__t2_b_n10 wl_0_b_n10 81.9864
rwl_0_t3_b_n10 wl_0__t3_b_n10 wl_0_b_n10 81.9864
rwl_1_t0_b_n10 wl_1__t0_b_n10 wl_1_b_n10 245.959
rwl_1_t1_b_n10 wl_1__t1_b_n10 wl_1_b_n10 81.9864
rwl_1_t2_b_n10 wl_1__t2_b_n10 wl_1_b_n10 81.9864
rwl_1_t3_b_n10 wl_1__t3_b_n10 wl_1_b_n10 245.959
rwl_2_t0_b_n10 wl_2__t0_b_n10 wl_2_b_n10 245.959
rwl_2_t1_b_n10 wl_2__t1_b_n10 wl_2_b_n10 81.9864
rwl_2_t2_b_n10 wl_2__t2_b_n10 wl_2_b_n10 81.9864
rwl_2_t3_b_n10 wl_2__t3_b_n10 wl_2_b_n10 245.959
rwl_3_t0_b_n10 wl_3__t0_b_n10 wl_3_b_n10 245.959
rwl_3_t1_b_n10 wl_3__t1_b_n10 wl_3_b_n10 81.9864
rwl_3_t2_b_n10 wl_3__t2_b_n10 wl_3_b_n10 81.9864
rwl_3_t3_b_n10 wl_3__t3_b_n10 wl_3_b_n10 245.959
c_10_b_n10 n10_b_n10 0 2.91622e-16
c_17_b_n10 n17_b_n10 0 2.91528e-16
c_18_b_n10 n18_b_n10 0 2.91528e-16
c_19_b_n10 n19_b_n10 0 2.91528e-16
c_20_b_n10 n20_b_n10 0 2.91622e-16
c_22_b_n10 n22_b_n10 0 2.91528e-16
c_23_b_n10 n23_b_n10 0 2.91528e-16
c_24_b_n10 n24_b_n10 0 2.91528e-16
c_25_b_n10 n25_b_n10 0 2.91622e-16
c_29_b_n10 n29_b_n10 0 2.91528e-16
c_30_b_n10 n30_b_n10 0 2.91528e-16
c_31_b_n10 n31_b_n10 0 2.91528e-16
c_32_b_n10 n32_b_n10 0 2.91622e-16
c_7_b_n10 n7_b_n10 0 2.91528e-16
c_8_b_n10 n8_b_n10 0 2.91528e-16
c_9_b_n10 n9_b_n10 0 2.91528e-16
cgnd_b_n10 0 0 2.48166e-15
cbl_0_b_n10 bl_0_b_n10 0 4.52661e-16
cbl_1_b_n10 bl_1_b_n10 0 4.52661e-16
cbl_2_b_n10 bl_2_b_n10 0 4.52661e-16
cbl_3_b_n10 bl_3_b_n10 0 4.52661e-16
crbl_0_b_n10 rbl_0_b_n10 0 9.14472e-16
crbl_1_b_n10 rbl_1_b_n10 0 9.14472e-16
crbl_2_b_n10 rbl_2_b_n10 0 9.14472e-16
crbl_3_b_n10 rbl_3_b_n10 0 9.17566e-16
crwl_0_b_n10 rwl_0_b_n10 0 5.19495e-16
crwl_1_b_n10 rwl_1_b_n10 0 5.11719e-16
crwl_2_b_n10 rwl_2_b_n10 0 5.11719e-16
crwl_3_b_n10 rwl_3_b_n10 0 5.19495e-16
cwl_0_b_n10 wl_0_b_n10 0 3.30388e-16
cwl_1_b_n10 wl_1_b_n10 0 3.30388e-16
cwl_2_b_n10 wl_2_b_n10 0 3.30388e-16
cwl_3_b_n10 wl_3_b_n10 0 3.30388e-16
ccc__10__9_b_n10 n10_b_n10 n9_b_n10 1.02e-17
ccc__10_bl_3_b_n10 n10_b_n10 bl_3_b_n10 1.3999e-17
ccc__10_rwl_0_b_n10 n10_b_n10 rwl_0_b_n10 4.335e-18
ccc__17__18_b_n10 n17_b_n10 n18_b_n10 1.02e-17
ccc__17_bl_0_b_n10 n17_b_n10 bl_0_b_n10 8.415e-18
ccc__17_rwl_1_b_n10 n17_b_n10 rwl_1_b_n10 1.3194e-17
ccc__18__19_b_n10 n18_b_n10 n19_b_n10 1.02e-17
ccc__18_bl_1_b_n10 n18_b_n10 bl_1_b_n10 8.415e-18
ccc__18_rwl_1_b_n10 n18_b_n10 rwl_1_b_n10 1.3194e-17
ccc__19__20_b_n10 n19_b_n10 n20_b_n10 1.02e-17
ccc__19_bl_2_b_n10 n19_b_n10 bl_2_b_n10 8.415e-18
ccc__19_rwl_1_b_n10 n19_b_n10 rwl_1_b_n10 1.3194e-17
ccc__20_bl_3_b_n10 n20_b_n10 bl_3_b_n10 8.415e-18
ccc__20_rwl_1_b_n10 n20_b_n10 rwl_1_b_n10 6.655e-18
ccc__22__23_b_n10 n22_b_n10 n23_b_n10 1.02e-17
ccc__22_bl_0_b_n10 n22_b_n10 bl_0_b_n10 8.415e-18
ccc__22_rwl_2_b_n10 n22_b_n10 rwl_2_b_n10 1.3194e-17
ccc__23__24_b_n10 n23_b_n10 n24_b_n10 1.02e-17
ccc__23_bl_1_b_n10 n23_b_n10 bl_1_b_n10 8.415e-18
ccc__23_rwl_2_b_n10 n23_b_n10 rwl_2_b_n10 1.3194e-17
ccc__24__25_b_n10 n24_b_n10 n25_b_n10 1.02e-17
ccc__24_bl_2_b_n10 n24_b_n10 bl_2_b_n10 8.415e-18
ccc__24_rwl_2_b_n10 n24_b_n10 rwl_2_b_n10 1.3194e-17
ccc__25_bl_3_b_n10 n25_b_n10 bl_3_b_n10 8.415e-18
ccc__25_rwl_2_b_n10 n25_b_n10 rwl_2_b_n10 6.655e-18
ccc__29__30_b_n10 n29_b_n10 n30_b_n10 1.02e-17
ccc__29_bl_0_b_n10 n29_b_n10 bl_0_b_n10 8.415e-18
ccc__29_rwl_3_b_n10 n29_b_n10 rwl_3_b_n10 1.3194e-17
ccc__30__31_b_n10 n30_b_n10 n31_b_n10 1.02e-17
ccc__30_bl_1_b_n10 n30_b_n10 bl_1_b_n10 8.415e-18
ccc__30_rwl_3_b_n10 n30_b_n10 rwl_3_b_n10 1.3194e-17
ccc__31__32_b_n10 n31_b_n10 n32_b_n10 1.02e-17
ccc__31_bl_2_b_n10 n31_b_n10 bl_2_b_n10 8.415e-18
ccc__31_rwl_3_b_n10 n31_b_n10 rwl_3_b_n10 1.3194e-17
ccc__32_bl_3_b_n10 n32_b_n10 bl_3_b_n10 8.415e-18
ccc__32_rwl_3_b_n10 n32_b_n10 rwl_3_b_n10 6.655e-18
ccc__7__8_b_n10 n7_b_n10 n8_b_n10 1.02e-17
ccc__7_bl_0_b_n10 n7_b_n10 bl_0_b_n10 1.3999e-17
ccc__7_rwl_0_b_n10 n7_b_n10 rwl_0_b_n10 8.961e-18
ccc__8__9_b_n10 n8_b_n10 n9_b_n10 1.02e-17
ccc__8_bl_1_b_n10 n8_b_n10 bl_1_b_n10 1.3999e-17
ccc__8_rwl_0_b_n10 n8_b_n10 rwl_0_b_n10 8.961e-18
ccc__9_bl_2_b_n10 n9_b_n10 bl_2_b_n10 1.3999e-17
ccc__9_rwl_0_b_n10 n9_b_n10 rwl_0_b_n10 8.961e-18
ccc_bl_0_rbl_0_b_n10 bl_0_b_n10 rbl_0_b_n10 1.88693e-16
ccc_bl_0_rwl_1_b_n10 bl_0_b_n10 rwl_1_b_n10 1.0093e-17
ccc_bl_0_rwl_2_b_n10 bl_0_b_n10 rwl_2_b_n10 1.0093e-17
ccc_bl_1_rbl_0_b_n10 bl_1_b_n10 rbl_0_b_n10 1.633e-16
ccc_bl_1_rbl_1_b_n10 bl_1_b_n10 rbl_1_b_n10 1.88693e-16
ccc_bl_1_rwl_1_b_n10 bl_1_b_n10 rwl_1_b_n10 1.0093e-17
ccc_bl_1_rwl_2_b_n10 bl_1_b_n10 rwl_2_b_n10 1.0093e-17
ccc_bl_2_rbl_1_b_n10 bl_2_b_n10 rbl_1_b_n10 1.633e-16
ccc_bl_2_rbl_2_b_n10 bl_2_b_n10 rbl_2_b_n10 1.88693e-16
ccc_bl_2_rwl_1_b_n10 bl_2_b_n10 rwl_1_b_n10 1.0093e-17
ccc_bl_2_rwl_2_b_n10 bl_2_b_n10 rwl_2_b_n10 1.0093e-17
ccc_bl_3_rbl_2_b_n10 bl_3_b_n10 rbl_2_b_n10 1.633e-16
ccc_bl_3_rbl_3_b_n10 bl_3_b_n10 rbl_3_b_n10 1.88693e-16
ccc_bl_3_rwl_1_b_n10 bl_3_b_n10 rwl_1_b_n10 1.0093e-17
ccc_bl_3_rwl_2_b_n10 bl_3_b_n10 rwl_2_b_n10 1.0093e-17
ccc_rbl_0_rbl_1_b_n10 rbl_0_b_n10 rbl_1_b_n10 3.432e-17
ccc_rbl_0_rwl_0_b_n10 rbl_0_b_n10 rwl_0_b_n10 4.9752e-17
ccc_rbl_0_rwl_1_b_n10 rbl_0_b_n10 rwl_1_b_n10 4.9752e-17
ccc_rbl_0_rwl_2_b_n10 rbl_0_b_n10 rwl_2_b_n10 4.9752e-17
ccc_rbl_0_rwl_3_b_n10 rbl_0_b_n10 rwl_3_b_n10 4.9752e-17
ccc_rbl_1_rbl_2_b_n10 rbl_1_b_n10 rbl_2_b_n10 3.432e-17
ccc_rbl_1_rwl_0_b_n10 rbl_1_b_n10 rwl_0_b_n10 4.9752e-17
ccc_rbl_1_rwl_1_b_n10 rbl_1_b_n10 rwl_1_b_n10 4.9752e-17
ccc_rbl_1_rwl_2_b_n10 rbl_1_b_n10 rwl_2_b_n10 4.9752e-17
ccc_rbl_1_rwl_3_b_n10 rbl_1_b_n10 rwl_3_b_n10 4.9752e-17
ccc_rbl_2_rbl_3_b_n10 rbl_2_b_n10 rbl_3_b_n10 3.432e-17
ccc_rbl_2_rwl_0_b_n10 rbl_2_b_n10 rwl_0_b_n10 4.9752e-17
ccc_rbl_2_rwl_1_b_n10 rbl_2_b_n10 rwl_1_b_n10 4.9752e-17
ccc_rbl_2_rwl_2_b_n10 rbl_2_b_n10 rwl_2_b_n10 4.9752e-17
ccc_rbl_2_rwl_3_b_n10 rbl_2_b_n10 rwl_3_b_n10 4.9752e-17
ccc_rbl_3_rwl_0_b_n10 rbl_3_b_n10 rwl_0_b_n10 3.3407e-17
ccc_rbl_3_rwl_1_b_n10 rbl_3_b_n10 rwl_1_b_n10 3.3407e-17
ccc_rbl_3_rwl_2_b_n10 rbl_3_b_n10 rwl_2_b_n10 3.3407e-17
ccc_rbl_3_rwl_3_b_n10 rbl_3_b_n10 rwl_3_b_n10 3.3407e-17
vdw_b_n10_0 wl_0_b_n10 0 dc 0
vdr_b_n10_0 rwl_0_b_n10 0 dc 0
vdw_b_n10_1 wl_1_b_n10 0 dc 0
vdr_b_n10_1 rwl_1_b_n10 0 dc 0
vdw_b_n10_2 wl_2_b_n10 0 dc 0
vdr_b_n10_2 rwl_2_b_n10 0 dc 0
vdw_b_n10_3 wl_3_b_n10 0 dc 0
vdr_b_n10_3 rwl_3_b_n10 0 dc 0
vdb_b_n10_0 bl_0_b_n10 0 dc 0
vdp_b_n10_0 rbl_0_b_n10 0 dc 0
vdb_b_n10_1 bl_1_b_n10 0 dc 0
vdp_b_n10_1 rbl_1_b_n10 0 dc 0
vdb_b_n10_2 bl_2_b_n10 0 dc 0
vdp_b_n10_2 rbl_2_b_n10 0 dc 0
vdb_b_n10_3 bl_3_b_n10 0 dc 0
vdp_b_n10_3 rbl_3_b_n10 0 dc 0
vdn_b_n10_n7 n7_b_n10 0 dc 1
vdn_b_n10_n8 n8_b_n10 0 dc 1
vdn_b_n10_n9 n9_b_n10 0 dc 1
vdn_b_n10_n17 n17_b_n10 0 dc 1
vdn_b_n10_n18 n18_b_n10 0 dc 1
vdn_b_n10_n19 n19_b_n10 0 dc 1
vdn_b_n10_n20 n20_b_n10 0 dc 1
vdn_b_n10_n22 n22_b_n10 0 dc 1
vdn_b_n10_n23 n23_b_n10 0 dc 1
vdn_b_n10_n24 n24_b_n10 0 dc 1
vdn_b_n10_n25 n25_b_n10 0 dc 1
vdn_b_n10_n29 n29_b_n10 0 dc 1
vdn_b_n10_n30 n30_b_n10 0 dc 1
vdn_b_n10_n31 n31_b_n10 0 dc 1
vdn_b_n10_n32 n32_b_n10 0 dc 1
bdr_b_n10 n10_b_n10 0 i=5e-08*min(1,max(0,(time-1e-09)/0.2n))*0.5*(1+tanh((v(n10_b_n10)-0.05)/0.01))

* ---- instance b_n17: variant b, probed storage node \$17 ----
xm1_b_n17 rwl_0__t2_b_n17 n7__t0_b_n17 rbl_0__t0_b_n17 gnd__t0_b_n17 sky130_fd_pr__nfet_01v8 L=0.15 W=0.42 nf=1 ad=0.1197 as=0.1197 pd=1.41 ps=1.41 mult=1 m=1
xm2_b_n17 rwl_0__t3_b_n17 n8__t1_b_n17 rbl_1__t1_b_n17 gnd__t1_b_n17 sky130_fd_pr__nfet_01v8 L=0.15 W=0.42 nf=1 ad=0.1197 as=0.1197 pd=1.41 ps=1.41 mult=1 m=1
xm3_b_n17 rwl_0__t1_b_n17 n9__t1_b_n17 rbl_2__t1_b_n17 gnd__t2_b_n17 sky130_fd_pr__nfet_01v8 L=0.15 W=0.42 nf=1 ad=0.1197 as=0.1197 pd=1.41 ps=1.41 mult=1 m=1
xm4_b_n17 rwl_0__t0_b_n17 n10__t1_b_n17 rbl_3__t1_b_n17 gnd__t3_b_n17 sky130_fd_pr__nfet_01v8 L=0.15 W=0.42 nf=1 ad=0.1197 as=0.1197 pd=1.41 ps=1.41 mult=1 m=1
xm5_b_n17 bl_0__t0_b_n17 wl_0__t0_b_n17 n7__t1_b_n17 gnd__t8_b_n17 sky130_fd_pr__nfet_01v8 L=0.15 W=0.42 nf=1 ad=0.0588 as=0.1197 pd=0.7 ps=1.41 mult=1 m=1
xm6_b_n17 n17__t0_b_n17 wl_1__t0_b_n17 bl_0__t1_b_n17 gnd__t20_b_n17 sky130_fd_pr__nfet_01v8 L=0.15 W=0.42 nf=1 ad=0.1197 as=0.0588 pd=1.41 ps=0.7 mult=1 m=1
xm7_b_n17 bl_1__t2_b_n17 wl_0__t3_b_n17 n8__t0_b_n17 gnd__t9_b_n17 sky130_fd_pr__nfet_01v8 L=0.15 W=0.42 nf=1 ad=0.0588 as=0.1197 pd=0.7 ps=1.41 mult=1 m=1
xm8_b_n17 n18__t0_b_n17 wl_1__t1_b_n17 bl_1__t0_b_n17 gnd__t21_b_n17 sky130_fd_pr__nfet_01v8 L=0.15 W=0.42 nf=1 ad=0.1197 as=0.0588 pd=1.41 ps=0.7 mult=1 m=1
xm9_b_n17 bl_2__t2_b_n17 wl_0__t2_b_n17 n9__t0_b_n17 gnd__t10_b_n17 sky130_fd_pr__nfet_01v8 L=0.15 W=0.42 nf=1 ad=0.0588 as=0.1197 pd=0.7 ps=1.41 mult=1 m=1
xm10_b_n17 n19__t0_b_n17 wl_1__t2_b_n17 bl_2__t0_b_n17 gnd__t22_b_n17 sky130_fd_pr__nfet_01v8 L=0.15 W=0.42 nf=1 ad=0.1197 as=0.0588 pd=1.41 ps=0.7 mult=1 m=1
xm11_b_n17 bl_3__t2_b_n17 wl_0__t1_b_n17 n10__t0_b_n17 gnd__t11_b_n17 sky130_fd_pr__nfet_01v8 L=0.15 W=0.42 nf=1 ad=0.0588 as=0.1197 pd=0.7 ps=1.41 mult=1 m=1
xm12_b_n17 n20__t0_b_n17 wl_1__t3_b_n17 bl_3__t1_b_n17 gnd__t23_b_n17 sky130_fd_pr__nfet_01v8 L=0.15 W=0.42 nf=1 ad=0.1197 as=0.0588 pd=1.41 ps=0.7 mult=1 m=1
xm13_b_n17 rbl_0__t3_b_n17 n17__t1_b_n17 rwl_1__t0_b_n17 gnd__t12_b_n17 sky130_fd_pr__nfet_01v8 L=0.15 W=0.42 nf=1 ad=0.0588 as=0.1197 pd=0.7 ps=1.41 mult=1 m=1
xm14_b_n17 rwl_2__t3_b_n17 n22__t0_b_n17 rbl_0__t2_b_n17 gnd__t24_b_n17 sky130_fd_pr__nfet_01v8 L=0.15 W=0.42 nf=1 ad=0.1197 as=0.0588 pd=1.41 ps=0.7 mult=1 m=1
xm15_b_n17 rbl_1__t3_b_n17 n18__t1_b_n17 rwl_1__t1_b_n17 gnd__t13_b_n17 sky130_fd_pr__nfet_01v8 L=0.15 W=0.42 nf=1 ad=0.0588 as=0.1197 pd=0.7 ps=1.41 mult=1 m=1
xm16_b_n17 rwl_2__t0_b_n17 n23__t0_b_n17 rbl_1__t2_b_n17 gnd__t25_b_n17 sky130_fd_pr__nfet_01v8 L=0.15 W=0.42 nf=1 ad=0.1197 as=0.0588 pd=1.41 ps=0.7 mult=1 m=1
xm17_b_n17 rbl_2__t3_b_n17 n19__t1_b_n17 rwl_1__t2_b_n17 gnd__t14_b_n17 sky130_fd_pr__nfet_01v8 L=0.15 W=0.42 nf=1 ad=0.0588 as=0.1197 pd=0.7 ps=1.41 mult=1 m=1
xm18_b_n17 rwl_2__t1_b_n17 n24__t0_b_n17 rbl_2__t2_b_n17 gnd__t26_b_n17 sky130_fd_pr__nfet_01v8 L=0.15 W=0.42 nf=1 ad=0.1197 as=0.0588 pd=1.41 ps=0.7 mult=1 m=1
xm19_b_n17 rbl_3__t3_b_n17 n20__t1_b_n17 rwl_1__t3_b_n17 gnd__t15_b_n17 sky130_fd_pr__nfet_01v8 L=0.15 W=0.42 nf=1 ad=0.0588 as=0.1197 pd=0.7 ps=1.41 mult=1 m=1
xm20_b_n17 rwl_2__t2_b_n17 n25__t0_b_n17 rbl_3__t2_b_n17 gnd__t27_b_n17 sky130_fd_pr__nfet_01v8 L=0.15 W=0.42 nf=1 ad=0.1197 as=0.0588 pd=1.41 ps=0.7 mult=1 m=1
xm21_b_n17 bl_0__t3_b_n17 wl_2__t0_b_n17 n22__t1_b_n17 gnd__t16_b_n17 sky130_fd_pr__nfet_01v8 L=0.15 W=0.42 nf=1 ad=0.0588 as=0.1197 pd=0.7 ps=1.41 mult=1 m=1
xm22_b_n17 n29__t0_b_n17 wl_3__t3_b_n17 bl_0__t2_b_n17 gnd__t28_b_n17 sky130_fd_pr__nfet_01v8 L=0.15 W=0.42 nf=1 ad=0.1197 as=0.0588 pd=1.41 ps=0.7 mult=1 m=1
xm23_b_n17 bl_1__t3_b_n17 wl_2__t1_b_n17 n23__t1_b_n17 gnd__t17_b_n17 sky130_fd_pr__nfet_01v8 L=0.15 W=0.42 nf=1 ad=0.0588 as=0.1197 pd=0.7 ps=1.41 mult=1 m=1
xm24_b_n17 n30__t0_b_n17 wl_3__t2_b_n17 bl_1__t1_b_n17 gnd__t29_b_n17 sky130_fd_pr__nfet_01v8 L=0.15 W=0.42 nf=1 ad=0.1197 as=0.0588 pd=1.41 ps=0.7 mult=1 m=1
xm25_b_n17 bl_2__t3_b_n17 wl_2__t2_b_n17 n24__t1_b_n17 gnd__t18_b_n17 sky130_fd_pr__nfet_01v8 L=0.15 W=0.42 nf=1 ad=0.0588 as=0.1197 pd=0.7 ps=1.41 mult=1 m=1
xm26_b_n17 n31__t0_b_n17 wl_3__t1_b_n17 bl_2__t1_b_n17 gnd__t30_b_n17 sky130_fd_pr__nfet_01v8 L=0.15 W=0.42 nf=1 ad=0.1197 as=0.0588 pd=1.41 ps=0.7 mult=1 m=1
xm27_b_n17 bl_3__t3_b_n17 wl_2__t3_b_n17 n25__t1_b_n17 gnd__t19_b_n17 sky130_fd_pr__nfet_01v8 L=0.15 W=0.42 nf=1 ad=0.0588 as=0.1197 pd=0.7 ps=1.41 mult=1 m=1
xm28_b_n17 n32__t0_b_n17 wl_3__t0_b_n17 bl_3__t0_b_n17 gnd__t31_b_n17 sky130_fd_pr__nfet_01v8 L=0.15 W=0.42 nf=1 ad=0.1197 as=0.0588 pd=1.41 ps=0.7 mult=1 m=1
xm29_b_n17 rbl_0__t1_b_n17 n29__t1_b_n17 rwl_3__t0_b_n17 gnd__t4_b_n17 sky130_fd_pr__nfet_01v8 L=0.15 W=0.42 nf=1 ad=0.1197 as=0.1197 pd=1.41 ps=1.41 mult=1 m=1
xm30_b_n17 rbl_1__t0_b_n17 n30__t1_b_n17 rwl_3__t1_b_n17 gnd__t5_b_n17 sky130_fd_pr__nfet_01v8 L=0.15 W=0.42 nf=1 ad=0.1197 as=0.1197 pd=1.41 ps=1.41 mult=1 m=1
xm31_b_n17 rbl_2__t0_b_n17 n31__t1_b_n17 rwl_3__t2_b_n17 gnd__t6_b_n17 sky130_fd_pr__nfet_01v8 L=0.15 W=0.42 nf=1 ad=0.1197 as=0.1197 pd=1.41 ps=1.41 mult=1 m=1
xm32_b_n17 rbl_3__t0_b_n17 n32__t1_b_n17 rwl_3__t3_b_n17 gnd__t7_b_n17 sky130_fd_pr__nfet_01v8 L=0.15 W=0.42 nf=1 ad=0.1197 as=0.1197 pd=1.41 ps=1.41 mult=1 m=1
r_10_t0_b_n17 n10__t0_b_n17 n10_b_n17 183.071
r_10_t1_b_n17 n10__t1_b_n17 n10_b_n17 183.071
r_17_t0_b_n17 n17__t0_b_n17 n17_b_n17 183.071
r_17_t1_b_n17 n17__t1_b_n17 n17_b_n17 183.071
r_18_t0_b_n17 n18__t0_b_n17 n18_b_n17 183.071
r_18_t1_b_n17 n18__t1_b_n17 n18_b_n17 183.071
r_19_t0_b_n17 n19__t0_b_n17 n19_b_n17 183.071
r_19_t1_b_n17 n19__t1_b_n17 n19_b_n17 183.071
r_20_t0_b_n17 n20__t0_b_n17 n20_b_n17 183.071
r_20_t1_b_n17 n20__t1_b_n17 n20_b_n17 183.071
r_22_t0_b_n17 n22__t0_b_n17 n22_b_n17 183.071
r_22_t1_b_n17 n22__t1_b_n17 n22_b_n17 183.071
r_23_t0_b_n17 n23__t0_b_n17 n23_b_n17 183.071
r_23_t1_b_n17 n23__t1_b_n17 n23_b_n17 183.071
r_24_t0_b_n17 n24__t0_b_n17 n24_b_n17 183.071
r_24_t1_b_n17 n24__t1_b_n17 n24_b_n17 183.071
r_25_t0_b_n17 n25__t0_b_n17 n25_b_n17 183.071
r_25_t1_b_n17 n25__t1_b_n17 n25_b_n17 183.071
r_29_t0_b_n17 n29__t0_b_n17 n29_b_n17 183.071
r_29_t1_b_n17 n29__t1_b_n17 n29_b_n17 183.071
r_30_t0_b_n17 n30__t0_b_n17 n30_b_n17 183.071
r_30_t1_b_n17 n30__t1_b_n17 n30_b_n17 183.071
r_31_t0_b_n17 n31__t0_b_n17 n31_b_n17 183.071
r_31_t1_b_n17 n31__t1_b_n17 n31_b_n17 183.071
r_32_t0_b_n17 n32__t0_b_n17 n32_b_n17 183.071
r_32_t1_b_n17 n32__t1_b_n17 n32_b_n17 183.071
r_7_t0_b_n17 n7__t0_b_n17 n7_b_n17 183.071
r_7_t1_b_n17 n7__t1_b_n17 n7_b_n17 183.071
r_8_t0_b_n17 n8__t0_b_n17 n8_b_n17 183.071
r_8_t1_b_n17 n8__t1_b_n17 n8_b_n17 183.071
r_9_t0_b_n17 n9__t0_b_n17 n9_b_n17 183.071
r_9_t1_b_n17 n9__t1_b_n17 n9_b_n17 183.071
rgnd_t0_b_n17 gnd__t0_b_n17 0 38.2988
rgnd_t1_b_n17 gnd__t1_b_n17 0 33.9576
rgnd_t2_b_n17 gnd__t2_b_n17 0 33.9576
rgnd_t3_b_n17 gnd__t3_b_n17 0 38.2988
rgnd_t4_b_n17 gnd__t4_b_n17 0 38.2988
rgnd_t5_b_n17 gnd__t5_b_n17 0 33.9576
rgnd_t6_b_n17 gnd__t6_b_n17 0 33.9576
rgnd_t7_b_n17 gnd__t7_b_n17 0 38.2988
rgnd_t8_b_n17 gnd__t8_b_n17 0 28.0185
rgnd_t9_b_n17 gnd__t9_b_n17 0 21.7106
rgnd_t10_b_n17 gnd__t10_b_n17 0 21.7106
rgnd_t11_b_n17 gnd__t11_b_n17 0 28.0185
rgnd_t12_b_n17 gnd__t12_b_n17 0 18.9833
rgnd_t13_b_n17 gnd__t13_b_n17 0 6.8325
rgnd_t14_b_n17 gnd__t14_b_n17 0 6.8325
rgnd_t15_b_n17 gnd__t15_b_n17 0 18.9833
rgnd_t16_b_n17 gnd__t16_b_n17 0 24.2409
rgnd_t17_b_n17 gnd__t17_b_n17 0 16.5511
rgnd_t18_b_n17 gnd__t18_b_n17 0 16.5511
rgnd_t19_b_n17 gnd__t19_b_n17 0 24.2409
rgnd_t20_b_n17 gnd__t20_b_n17 0 24.2409
rgnd_t21_b_n17 gnd__t21_b_n17 0 16.5511
rgnd_t22_b_n17 gnd__t22_b_n17 0 16.5511
rgnd_t23_b_n17 gnd__t23_b_n17 0 24.2409
rgnd_t24_b_n17 gnd__t24_b_n17 0 18.9833
rgnd_t25_b_n17 gnd__t25_b_n17 0 6.8325
rgnd_t26_b_n17 gnd__t26_b_n17 0 6.8325
rgnd_t27_b_n17 gnd__t27_b_n17 0 18.9833
rgnd_t28_b_n17 gnd__t28_b_n17 0 28.0185
rgnd_t29_b_n17 gnd__t29_b_n17 0 21.7106
rgnd_t30_b_n17 gnd__t30_b_n17 0 21.7106
rgnd_t31_b_n17 gnd__t31_b_n17 0 28.0185
rbl_0_t0_b_n17 bl_0__t0_b_n17 bl_0_b_n17 14.8304
rbl_0_t1_b_n17 bl_0__t1_b_n17 bl_0_b_n17 10.9301
rbl_0_t2_b_n17 bl_0__t2_b_n17 bl_0_b_n17 14.8304
rbl_0_t3_b_n17 bl_0__t3_b_n17 bl_0_b_n17 10.9301
rbl_1_t0_b_n17 bl_1__t0_b_n17 bl_1_b_n17 10.9301
rbl_1_t1_b_n17 bl_1__t1_b_n17 bl_1_b_n17 14.8304
rbl_1_t2_b_n17 bl_1__t2_b_n17 bl_1_b_n17 14.8304
rbl_1_t3_b_n17 bl_1__t3_b_n17 bl_1_b_n17 10.9301
rbl_2_t0_b_n17 bl_2__t0_b_n17 bl_2_b_n17 10.9301
rbl_2_t1_b_n17 bl_2__t1_b_n17 bl_2_b_n17 14.8304
rbl_2_t2_b_n17 bl_2__t2_b_n17 bl_2_b_n17 14.8304
rbl_2_t3_b_n17 bl_2__t3_b_n17 bl_2_b_n17 10.9301
rbl_3_t0_b_n17 bl_3__t0_b_n17 bl_3_b_n17 14.8304
rbl_3_t1_b_n17 bl_3__t1_b_n17 bl_3_b_n17 10.9301
rbl_3_t2_b_n17 bl_3__t2_b_n17 bl_3_b_n17 14.8304
rbl_3_t3_b_n17 bl_3__t3_b_n17 bl_3_b_n17 10.9301
rrbl_0_t0_b_n17 rbl_0__t0_b_n17 rbl_0_b_n17 36.5601
rrbl_0_t1_b_n17 rbl_0__t1_b_n17 rbl_0_b_n17 36.5601
rrbl_0_t2_b_n17 rbl_0__t2_b_n17 rbl_0_b_n17 2.99444
rrbl_0_t3_b_n17 rbl_0__t3_b_n17 rbl_0_b_n17 2.99444
rrbl_1_t0_b_n17 rbl_1__t0_b_n17 rbl_1_b_n17 36.5601
rrbl_1_t1_b_n17 rbl_1__t1_b_n17 rbl_1_b_n17 36.5601
rrbl_1_t2_b_n17 rbl_1__t2_b_n17 rbl_1_b_n17 2.99444
rrbl_1_t3_b_n17 rbl_1__t3_b_n17 rbl_1_b_n17 2.99444
rrbl_2_t0_b_n17 rbl_2__t0_b_n17 rbl_2_b_n17 36.5601
rrbl_2_t1_b_n17 rbl_2__t1_b_n17 rbl_2_b_n17 36.5601
rrbl_2_t2_b_n17 rbl_2__t2_b_n17 rbl_2_b_n17 2.99444
rrbl_2_t3_b_n17 rbl_2__t3_b_n17 rbl_2_b_n17 2.99444
rrbl_3_t0_b_n17 rbl_3__t0_b_n17 rbl_3_b_n17 36.5601
rrbl_3_t1_b_n17 rbl_3__t1_b_n17 rbl_3_b_n17 36.5601
rrbl_3_t2_b_n17 rbl_3__t2_b_n17 rbl_3_b_n17 2.99444
rrbl_3_t3_b_n17 rbl_3__t3_b_n17 rbl_3_b_n17 2.99444
rrwl_0_t0_b_n17 rwl_0__t0_b_n17 rwl_0_b_n17 38.2618
rrwl_0_t1_b_n17 rwl_0__t1_b_n17 rwl_0_b_n17 12.7539
rrwl_0_t2_b_n17 rwl_0__t2_b_n17 rwl_0_b_n17 38.2618
rrwl_0_t3_b_n17 rwl_0__t3_b_n17 rwl_0_b_n17 12.7539
rrwl_1_t0_b_n17 rwl_1__t0_b_n17 rwl_1_b_n17 38.2618
rrwl_1_t1_b_n17 rwl_1__t1_b_n17 rwl_1_b_n17 12.7539
rrwl_1_t2_b_n17 rwl_1__t2_b_n17 rwl_1_b_n17 12.7539
rrwl_1_t3_b_n17 rwl_1__t3_b_n17 rwl_1_b_n17 38.2618
rrwl_2_t0_b_n17 rwl_2__t0_b_n17 rwl_2_b_n17 12.7539
rrwl_2_t1_b_n17 rwl_2__t1_b_n17 rwl_2_b_n17 12.7539
rrwl_2_t2_b_n17 rwl_2__t2_b_n17 rwl_2_b_n17 38.2618
rrwl_2_t3_b_n17 rwl_2__t3_b_n17 rwl_2_b_n17 38.2618
rrwl_3_t0_b_n17 rwl_3__t0_b_n17 rwl_3_b_n17 38.2618
rrwl_3_t1_b_n17 rwl_3__t1_b_n17 rwl_3_b_n17 12.7539
rrwl_3_t2_b_n17 rwl_3__t2_b_n17 rwl_3_b_n17 12.7539
rrwl_3_t3_b_n17 rwl_3__t3_b_n17 rwl_3_b_n17 38.2618
rwl_0_t0_b_n17 wl_0__t0_b_n17 wl_0_b_n17 245.959
rwl_0_t1_b_n17 wl_0__t1_b_n17 wl_0_b_n17 245.959
rwl_0_t2_b_n17 wl_0__t2_b_n17 wl_0_b_n17 81.9864
rwl_0_t3_b_n17 wl_0__t3_b_n17 wl_0_b_n17 81.9864
rwl_1_t0_b_n17 wl_1__t0_b_n17 wl_1_b_n17 245.959
rwl_1_t1_b_n17 wl_1__t1_b_n17 wl_1_b_n17 81.9864
rwl_1_t2_b_n17 wl_1__t2_b_n17 wl_1_b_n17 81.9864
rwl_1_t3_b_n17 wl_1__t3_b_n17 wl_1_b_n17 245.959
rwl_2_t0_b_n17 wl_2__t0_b_n17 wl_2_b_n17 245.959
rwl_2_t1_b_n17 wl_2__t1_b_n17 wl_2_b_n17 81.9864
rwl_2_t2_b_n17 wl_2__t2_b_n17 wl_2_b_n17 81.9864
rwl_2_t3_b_n17 wl_2__t3_b_n17 wl_2_b_n17 245.959
rwl_3_t0_b_n17 wl_3__t0_b_n17 wl_3_b_n17 245.959
rwl_3_t1_b_n17 wl_3__t1_b_n17 wl_3_b_n17 81.9864
rwl_3_t2_b_n17 wl_3__t2_b_n17 wl_3_b_n17 81.9864
rwl_3_t3_b_n17 wl_3__t3_b_n17 wl_3_b_n17 245.959
c_10_b_n17 n10_b_n17 0 2.91622e-16
c_17_b_n17 n17_b_n17 0 2.91528e-16
c_18_b_n17 n18_b_n17 0 2.91528e-16
c_19_b_n17 n19_b_n17 0 2.91528e-16
c_20_b_n17 n20_b_n17 0 2.91622e-16
c_22_b_n17 n22_b_n17 0 2.91528e-16
c_23_b_n17 n23_b_n17 0 2.91528e-16
c_24_b_n17 n24_b_n17 0 2.91528e-16
c_25_b_n17 n25_b_n17 0 2.91622e-16
c_29_b_n17 n29_b_n17 0 2.91528e-16
c_30_b_n17 n30_b_n17 0 2.91528e-16
c_31_b_n17 n31_b_n17 0 2.91528e-16
c_32_b_n17 n32_b_n17 0 2.91622e-16
c_7_b_n17 n7_b_n17 0 2.91528e-16
c_8_b_n17 n8_b_n17 0 2.91528e-16
c_9_b_n17 n9_b_n17 0 2.91528e-16
cgnd_b_n17 0 0 2.48166e-15
cbl_0_b_n17 bl_0_b_n17 0 4.52661e-16
cbl_1_b_n17 bl_1_b_n17 0 4.52661e-16
cbl_2_b_n17 bl_2_b_n17 0 4.52661e-16
cbl_3_b_n17 bl_3_b_n17 0 4.52661e-16
crbl_0_b_n17 rbl_0_b_n17 0 9.14472e-16
crbl_1_b_n17 rbl_1_b_n17 0 9.14472e-16
crbl_2_b_n17 rbl_2_b_n17 0 9.14472e-16
crbl_3_b_n17 rbl_3_b_n17 0 9.17566e-16
crwl_0_b_n17 rwl_0_b_n17 0 5.19495e-16
crwl_1_b_n17 rwl_1_b_n17 0 5.11719e-16
crwl_2_b_n17 rwl_2_b_n17 0 5.11719e-16
crwl_3_b_n17 rwl_3_b_n17 0 5.19495e-16
cwl_0_b_n17 wl_0_b_n17 0 3.30388e-16
cwl_1_b_n17 wl_1_b_n17 0 3.30388e-16
cwl_2_b_n17 wl_2_b_n17 0 3.30388e-16
cwl_3_b_n17 wl_3_b_n17 0 3.30388e-16
ccc__10__9_b_n17 n10_b_n17 n9_b_n17 1.02e-17
ccc__10_bl_3_b_n17 n10_b_n17 bl_3_b_n17 1.3999e-17
ccc__10_rwl_0_b_n17 n10_b_n17 rwl_0_b_n17 4.335e-18
ccc__17__18_b_n17 n17_b_n17 n18_b_n17 1.02e-17
ccc__17_bl_0_b_n17 n17_b_n17 bl_0_b_n17 8.415e-18
ccc__17_rwl_1_b_n17 n17_b_n17 rwl_1_b_n17 1.3194e-17
ccc__18__19_b_n17 n18_b_n17 n19_b_n17 1.02e-17
ccc__18_bl_1_b_n17 n18_b_n17 bl_1_b_n17 8.415e-18
ccc__18_rwl_1_b_n17 n18_b_n17 rwl_1_b_n17 1.3194e-17
ccc__19__20_b_n17 n19_b_n17 n20_b_n17 1.02e-17
ccc__19_bl_2_b_n17 n19_b_n17 bl_2_b_n17 8.415e-18
ccc__19_rwl_1_b_n17 n19_b_n17 rwl_1_b_n17 1.3194e-17
ccc__20_bl_3_b_n17 n20_b_n17 bl_3_b_n17 8.415e-18
ccc__20_rwl_1_b_n17 n20_b_n17 rwl_1_b_n17 6.655e-18
ccc__22__23_b_n17 n22_b_n17 n23_b_n17 1.02e-17
ccc__22_bl_0_b_n17 n22_b_n17 bl_0_b_n17 8.415e-18
ccc__22_rwl_2_b_n17 n22_b_n17 rwl_2_b_n17 1.3194e-17
ccc__23__24_b_n17 n23_b_n17 n24_b_n17 1.02e-17
ccc__23_bl_1_b_n17 n23_b_n17 bl_1_b_n17 8.415e-18
ccc__23_rwl_2_b_n17 n23_b_n17 rwl_2_b_n17 1.3194e-17
ccc__24__25_b_n17 n24_b_n17 n25_b_n17 1.02e-17
ccc__24_bl_2_b_n17 n24_b_n17 bl_2_b_n17 8.415e-18
ccc__24_rwl_2_b_n17 n24_b_n17 rwl_2_b_n17 1.3194e-17
ccc__25_bl_3_b_n17 n25_b_n17 bl_3_b_n17 8.415e-18
ccc__25_rwl_2_b_n17 n25_b_n17 rwl_2_b_n17 6.655e-18
ccc__29__30_b_n17 n29_b_n17 n30_b_n17 1.02e-17
ccc__29_bl_0_b_n17 n29_b_n17 bl_0_b_n17 8.415e-18
ccc__29_rwl_3_b_n17 n29_b_n17 rwl_3_b_n17 1.3194e-17
ccc__30__31_b_n17 n30_b_n17 n31_b_n17 1.02e-17
ccc__30_bl_1_b_n17 n30_b_n17 bl_1_b_n17 8.415e-18
ccc__30_rwl_3_b_n17 n30_b_n17 rwl_3_b_n17 1.3194e-17
ccc__31__32_b_n17 n31_b_n17 n32_b_n17 1.02e-17
ccc__31_bl_2_b_n17 n31_b_n17 bl_2_b_n17 8.415e-18
ccc__31_rwl_3_b_n17 n31_b_n17 rwl_3_b_n17 1.3194e-17
ccc__32_bl_3_b_n17 n32_b_n17 bl_3_b_n17 8.415e-18
ccc__32_rwl_3_b_n17 n32_b_n17 rwl_3_b_n17 6.655e-18
ccc__7__8_b_n17 n7_b_n17 n8_b_n17 1.02e-17
ccc__7_bl_0_b_n17 n7_b_n17 bl_0_b_n17 1.3999e-17
ccc__7_rwl_0_b_n17 n7_b_n17 rwl_0_b_n17 8.961e-18
ccc__8__9_b_n17 n8_b_n17 n9_b_n17 1.02e-17
ccc__8_bl_1_b_n17 n8_b_n17 bl_1_b_n17 1.3999e-17
ccc__8_rwl_0_b_n17 n8_b_n17 rwl_0_b_n17 8.961e-18
ccc__9_bl_2_b_n17 n9_b_n17 bl_2_b_n17 1.3999e-17
ccc__9_rwl_0_b_n17 n9_b_n17 rwl_0_b_n17 8.961e-18
ccc_bl_0_rbl_0_b_n17 bl_0_b_n17 rbl_0_b_n17 1.88693e-16
ccc_bl_0_rwl_1_b_n17 bl_0_b_n17 rwl_1_b_n17 1.0093e-17
ccc_bl_0_rwl_2_b_n17 bl_0_b_n17 rwl_2_b_n17 1.0093e-17
ccc_bl_1_rbl_0_b_n17 bl_1_b_n17 rbl_0_b_n17 1.633e-16
ccc_bl_1_rbl_1_b_n17 bl_1_b_n17 rbl_1_b_n17 1.88693e-16
ccc_bl_1_rwl_1_b_n17 bl_1_b_n17 rwl_1_b_n17 1.0093e-17
ccc_bl_1_rwl_2_b_n17 bl_1_b_n17 rwl_2_b_n17 1.0093e-17
ccc_bl_2_rbl_1_b_n17 bl_2_b_n17 rbl_1_b_n17 1.633e-16
ccc_bl_2_rbl_2_b_n17 bl_2_b_n17 rbl_2_b_n17 1.88693e-16
ccc_bl_2_rwl_1_b_n17 bl_2_b_n17 rwl_1_b_n17 1.0093e-17
ccc_bl_2_rwl_2_b_n17 bl_2_b_n17 rwl_2_b_n17 1.0093e-17
ccc_bl_3_rbl_2_b_n17 bl_3_b_n17 rbl_2_b_n17 1.633e-16
ccc_bl_3_rbl_3_b_n17 bl_3_b_n17 rbl_3_b_n17 1.88693e-16
ccc_bl_3_rwl_1_b_n17 bl_3_b_n17 rwl_1_b_n17 1.0093e-17
ccc_bl_3_rwl_2_b_n17 bl_3_b_n17 rwl_2_b_n17 1.0093e-17
ccc_rbl_0_rbl_1_b_n17 rbl_0_b_n17 rbl_1_b_n17 3.432e-17
ccc_rbl_0_rwl_0_b_n17 rbl_0_b_n17 rwl_0_b_n17 4.9752e-17
ccc_rbl_0_rwl_1_b_n17 rbl_0_b_n17 rwl_1_b_n17 4.9752e-17
ccc_rbl_0_rwl_2_b_n17 rbl_0_b_n17 rwl_2_b_n17 4.9752e-17
ccc_rbl_0_rwl_3_b_n17 rbl_0_b_n17 rwl_3_b_n17 4.9752e-17
ccc_rbl_1_rbl_2_b_n17 rbl_1_b_n17 rbl_2_b_n17 3.432e-17
ccc_rbl_1_rwl_0_b_n17 rbl_1_b_n17 rwl_0_b_n17 4.9752e-17
ccc_rbl_1_rwl_1_b_n17 rbl_1_b_n17 rwl_1_b_n17 4.9752e-17
ccc_rbl_1_rwl_2_b_n17 rbl_1_b_n17 rwl_2_b_n17 4.9752e-17
ccc_rbl_1_rwl_3_b_n17 rbl_1_b_n17 rwl_3_b_n17 4.9752e-17
ccc_rbl_2_rbl_3_b_n17 rbl_2_b_n17 rbl_3_b_n17 3.432e-17
ccc_rbl_2_rwl_0_b_n17 rbl_2_b_n17 rwl_0_b_n17 4.9752e-17
ccc_rbl_2_rwl_1_b_n17 rbl_2_b_n17 rwl_1_b_n17 4.9752e-17
ccc_rbl_2_rwl_2_b_n17 rbl_2_b_n17 rwl_2_b_n17 4.9752e-17
ccc_rbl_2_rwl_3_b_n17 rbl_2_b_n17 rwl_3_b_n17 4.9752e-17
ccc_rbl_3_rwl_0_b_n17 rbl_3_b_n17 rwl_0_b_n17 3.3407e-17
ccc_rbl_3_rwl_1_b_n17 rbl_3_b_n17 rwl_1_b_n17 3.3407e-17
ccc_rbl_3_rwl_2_b_n17 rbl_3_b_n17 rwl_2_b_n17 3.3407e-17
ccc_rbl_3_rwl_3_b_n17 rbl_3_b_n17 rwl_3_b_n17 3.3407e-17
vdw_b_n17_0 wl_0_b_n17 0 dc 0
vdr_b_n17_0 rwl_0_b_n17 0 dc 0
vdw_b_n17_1 wl_1_b_n17 0 dc 0
vdr_b_n17_1 rwl_1_b_n17 0 dc 0
vdw_b_n17_2 wl_2_b_n17 0 dc 0
vdr_b_n17_2 rwl_2_b_n17 0 dc 0
vdw_b_n17_3 wl_3_b_n17 0 dc 0
vdr_b_n17_3 rwl_3_b_n17 0 dc 0
vdb_b_n17_0 bl_0_b_n17 0 dc 0
vdp_b_n17_0 rbl_0_b_n17 0 dc 0
vdb_b_n17_1 bl_1_b_n17 0 dc 0
vdp_b_n17_1 rbl_1_b_n17 0 dc 0
vdb_b_n17_2 bl_2_b_n17 0 dc 0
vdp_b_n17_2 rbl_2_b_n17 0 dc 0
vdb_b_n17_3 bl_3_b_n17 0 dc 0
vdp_b_n17_3 rbl_3_b_n17 0 dc 0
vdn_b_n17_n7 n7_b_n17 0 dc 1
vdn_b_n17_n8 n8_b_n17 0 dc 1
vdn_b_n17_n9 n9_b_n17 0 dc 1
vdn_b_n17_n10 n10_b_n17 0 dc 1
vdn_b_n17_n18 n18_b_n17 0 dc 1
vdn_b_n17_n19 n19_b_n17 0 dc 1
vdn_b_n17_n20 n20_b_n17 0 dc 1
vdn_b_n17_n22 n22_b_n17 0 dc 1
vdn_b_n17_n23 n23_b_n17 0 dc 1
vdn_b_n17_n24 n24_b_n17 0 dc 1
vdn_b_n17_n25 n25_b_n17 0 dc 1
vdn_b_n17_n29 n29_b_n17 0 dc 1
vdn_b_n17_n30 n30_b_n17 0 dc 1
vdn_b_n17_n31 n31_b_n17 0 dc 1
vdn_b_n17_n32 n32_b_n17 0 dc 1
bdr_b_n17 n17_b_n17 0 i=5e-08*min(1,max(0,(time-1e-09)/0.2n))*0.5*(1+tanh((v(n17_b_n17)-0.05)/0.01))

* ---- instance b_n18: variant b, probed storage node \$18 ----
xm1_b_n18 rwl_0__t2_b_n18 n7__t0_b_n18 rbl_0__t0_b_n18 gnd__t0_b_n18 sky130_fd_pr__nfet_01v8 L=0.15 W=0.42 nf=1 ad=0.1197 as=0.1197 pd=1.41 ps=1.41 mult=1 m=1
xm2_b_n18 rwl_0__t3_b_n18 n8__t1_b_n18 rbl_1__t1_b_n18 gnd__t1_b_n18 sky130_fd_pr__nfet_01v8 L=0.15 W=0.42 nf=1 ad=0.1197 as=0.1197 pd=1.41 ps=1.41 mult=1 m=1
xm3_b_n18 rwl_0__t1_b_n18 n9__t1_b_n18 rbl_2__t1_b_n18 gnd__t2_b_n18 sky130_fd_pr__nfet_01v8 L=0.15 W=0.42 nf=1 ad=0.1197 as=0.1197 pd=1.41 ps=1.41 mult=1 m=1
xm4_b_n18 rwl_0__t0_b_n18 n10__t1_b_n18 rbl_3__t1_b_n18 gnd__t3_b_n18 sky130_fd_pr__nfet_01v8 L=0.15 W=0.42 nf=1 ad=0.1197 as=0.1197 pd=1.41 ps=1.41 mult=1 m=1
xm5_b_n18 bl_0__t0_b_n18 wl_0__t0_b_n18 n7__t1_b_n18 gnd__t8_b_n18 sky130_fd_pr__nfet_01v8 L=0.15 W=0.42 nf=1 ad=0.0588 as=0.1197 pd=0.7 ps=1.41 mult=1 m=1
xm6_b_n18 n17__t0_b_n18 wl_1__t0_b_n18 bl_0__t1_b_n18 gnd__t20_b_n18 sky130_fd_pr__nfet_01v8 L=0.15 W=0.42 nf=1 ad=0.1197 as=0.0588 pd=1.41 ps=0.7 mult=1 m=1
xm7_b_n18 bl_1__t2_b_n18 wl_0__t3_b_n18 n8__t0_b_n18 gnd__t9_b_n18 sky130_fd_pr__nfet_01v8 L=0.15 W=0.42 nf=1 ad=0.0588 as=0.1197 pd=0.7 ps=1.41 mult=1 m=1
xm8_b_n18 n18__t0_b_n18 wl_1__t1_b_n18 bl_1__t0_b_n18 gnd__t21_b_n18 sky130_fd_pr__nfet_01v8 L=0.15 W=0.42 nf=1 ad=0.1197 as=0.0588 pd=1.41 ps=0.7 mult=1 m=1
xm9_b_n18 bl_2__t2_b_n18 wl_0__t2_b_n18 n9__t0_b_n18 gnd__t10_b_n18 sky130_fd_pr__nfet_01v8 L=0.15 W=0.42 nf=1 ad=0.0588 as=0.1197 pd=0.7 ps=1.41 mult=1 m=1
xm10_b_n18 n19__t0_b_n18 wl_1__t2_b_n18 bl_2__t0_b_n18 gnd__t22_b_n18 sky130_fd_pr__nfet_01v8 L=0.15 W=0.42 nf=1 ad=0.1197 as=0.0588 pd=1.41 ps=0.7 mult=1 m=1
xm11_b_n18 bl_3__t2_b_n18 wl_0__t1_b_n18 n10__t0_b_n18 gnd__t11_b_n18 sky130_fd_pr__nfet_01v8 L=0.15 W=0.42 nf=1 ad=0.0588 as=0.1197 pd=0.7 ps=1.41 mult=1 m=1
xm12_b_n18 n20__t0_b_n18 wl_1__t3_b_n18 bl_3__t1_b_n18 gnd__t23_b_n18 sky130_fd_pr__nfet_01v8 L=0.15 W=0.42 nf=1 ad=0.1197 as=0.0588 pd=1.41 ps=0.7 mult=1 m=1
xm13_b_n18 rbl_0__t3_b_n18 n17__t1_b_n18 rwl_1__t0_b_n18 gnd__t12_b_n18 sky130_fd_pr__nfet_01v8 L=0.15 W=0.42 nf=1 ad=0.0588 as=0.1197 pd=0.7 ps=1.41 mult=1 m=1
xm14_b_n18 rwl_2__t3_b_n18 n22__t0_b_n18 rbl_0__t2_b_n18 gnd__t24_b_n18 sky130_fd_pr__nfet_01v8 L=0.15 W=0.42 nf=1 ad=0.1197 as=0.0588 pd=1.41 ps=0.7 mult=1 m=1
xm15_b_n18 rbl_1__t3_b_n18 n18__t1_b_n18 rwl_1__t1_b_n18 gnd__t13_b_n18 sky130_fd_pr__nfet_01v8 L=0.15 W=0.42 nf=1 ad=0.0588 as=0.1197 pd=0.7 ps=1.41 mult=1 m=1
xm16_b_n18 rwl_2__t0_b_n18 n23__t0_b_n18 rbl_1__t2_b_n18 gnd__t25_b_n18 sky130_fd_pr__nfet_01v8 L=0.15 W=0.42 nf=1 ad=0.1197 as=0.0588 pd=1.41 ps=0.7 mult=1 m=1
xm17_b_n18 rbl_2__t3_b_n18 n19__t1_b_n18 rwl_1__t2_b_n18 gnd__t14_b_n18 sky130_fd_pr__nfet_01v8 L=0.15 W=0.42 nf=1 ad=0.0588 as=0.1197 pd=0.7 ps=1.41 mult=1 m=1
xm18_b_n18 rwl_2__t1_b_n18 n24__t0_b_n18 rbl_2__t2_b_n18 gnd__t26_b_n18 sky130_fd_pr__nfet_01v8 L=0.15 W=0.42 nf=1 ad=0.1197 as=0.0588 pd=1.41 ps=0.7 mult=1 m=1
xm19_b_n18 rbl_3__t3_b_n18 n20__t1_b_n18 rwl_1__t3_b_n18 gnd__t15_b_n18 sky130_fd_pr__nfet_01v8 L=0.15 W=0.42 nf=1 ad=0.0588 as=0.1197 pd=0.7 ps=1.41 mult=1 m=1
xm20_b_n18 rwl_2__t2_b_n18 n25__t0_b_n18 rbl_3__t2_b_n18 gnd__t27_b_n18 sky130_fd_pr__nfet_01v8 L=0.15 W=0.42 nf=1 ad=0.1197 as=0.0588 pd=1.41 ps=0.7 mult=1 m=1
xm21_b_n18 bl_0__t3_b_n18 wl_2__t0_b_n18 n22__t1_b_n18 gnd__t16_b_n18 sky130_fd_pr__nfet_01v8 L=0.15 W=0.42 nf=1 ad=0.0588 as=0.1197 pd=0.7 ps=1.41 mult=1 m=1
xm22_b_n18 n29__t0_b_n18 wl_3__t3_b_n18 bl_0__t2_b_n18 gnd__t28_b_n18 sky130_fd_pr__nfet_01v8 L=0.15 W=0.42 nf=1 ad=0.1197 as=0.0588 pd=1.41 ps=0.7 mult=1 m=1
xm23_b_n18 bl_1__t3_b_n18 wl_2__t1_b_n18 n23__t1_b_n18 gnd__t17_b_n18 sky130_fd_pr__nfet_01v8 L=0.15 W=0.42 nf=1 ad=0.0588 as=0.1197 pd=0.7 ps=1.41 mult=1 m=1
xm24_b_n18 n30__t0_b_n18 wl_3__t2_b_n18 bl_1__t1_b_n18 gnd__t29_b_n18 sky130_fd_pr__nfet_01v8 L=0.15 W=0.42 nf=1 ad=0.1197 as=0.0588 pd=1.41 ps=0.7 mult=1 m=1
xm25_b_n18 bl_2__t3_b_n18 wl_2__t2_b_n18 n24__t1_b_n18 gnd__t18_b_n18 sky130_fd_pr__nfet_01v8 L=0.15 W=0.42 nf=1 ad=0.0588 as=0.1197 pd=0.7 ps=1.41 mult=1 m=1
xm26_b_n18 n31__t0_b_n18 wl_3__t1_b_n18 bl_2__t1_b_n18 gnd__t30_b_n18 sky130_fd_pr__nfet_01v8 L=0.15 W=0.42 nf=1 ad=0.1197 as=0.0588 pd=1.41 ps=0.7 mult=1 m=1
xm27_b_n18 bl_3__t3_b_n18 wl_2__t3_b_n18 n25__t1_b_n18 gnd__t19_b_n18 sky130_fd_pr__nfet_01v8 L=0.15 W=0.42 nf=1 ad=0.0588 as=0.1197 pd=0.7 ps=1.41 mult=1 m=1
xm28_b_n18 n32__t0_b_n18 wl_3__t0_b_n18 bl_3__t0_b_n18 gnd__t31_b_n18 sky130_fd_pr__nfet_01v8 L=0.15 W=0.42 nf=1 ad=0.1197 as=0.0588 pd=1.41 ps=0.7 mult=1 m=1
xm29_b_n18 rbl_0__t1_b_n18 n29__t1_b_n18 rwl_3__t0_b_n18 gnd__t4_b_n18 sky130_fd_pr__nfet_01v8 L=0.15 W=0.42 nf=1 ad=0.1197 as=0.1197 pd=1.41 ps=1.41 mult=1 m=1
xm30_b_n18 rbl_1__t0_b_n18 n30__t1_b_n18 rwl_3__t1_b_n18 gnd__t5_b_n18 sky130_fd_pr__nfet_01v8 L=0.15 W=0.42 nf=1 ad=0.1197 as=0.1197 pd=1.41 ps=1.41 mult=1 m=1
xm31_b_n18 rbl_2__t0_b_n18 n31__t1_b_n18 rwl_3__t2_b_n18 gnd__t6_b_n18 sky130_fd_pr__nfet_01v8 L=0.15 W=0.42 nf=1 ad=0.1197 as=0.1197 pd=1.41 ps=1.41 mult=1 m=1
xm32_b_n18 rbl_3__t0_b_n18 n32__t1_b_n18 rwl_3__t3_b_n18 gnd__t7_b_n18 sky130_fd_pr__nfet_01v8 L=0.15 W=0.42 nf=1 ad=0.1197 as=0.1197 pd=1.41 ps=1.41 mult=1 m=1
r_10_t0_b_n18 n10__t0_b_n18 n10_b_n18 183.071
r_10_t1_b_n18 n10__t1_b_n18 n10_b_n18 183.071
r_17_t0_b_n18 n17__t0_b_n18 n17_b_n18 183.071
r_17_t1_b_n18 n17__t1_b_n18 n17_b_n18 183.071
r_18_t0_b_n18 n18__t0_b_n18 n18_b_n18 183.071
r_18_t1_b_n18 n18__t1_b_n18 n18_b_n18 183.071
r_19_t0_b_n18 n19__t0_b_n18 n19_b_n18 183.071
r_19_t1_b_n18 n19__t1_b_n18 n19_b_n18 183.071
r_20_t0_b_n18 n20__t0_b_n18 n20_b_n18 183.071
r_20_t1_b_n18 n20__t1_b_n18 n20_b_n18 183.071
r_22_t0_b_n18 n22__t0_b_n18 n22_b_n18 183.071
r_22_t1_b_n18 n22__t1_b_n18 n22_b_n18 183.071
r_23_t0_b_n18 n23__t0_b_n18 n23_b_n18 183.071
r_23_t1_b_n18 n23__t1_b_n18 n23_b_n18 183.071
r_24_t0_b_n18 n24__t0_b_n18 n24_b_n18 183.071
r_24_t1_b_n18 n24__t1_b_n18 n24_b_n18 183.071
r_25_t0_b_n18 n25__t0_b_n18 n25_b_n18 183.071
r_25_t1_b_n18 n25__t1_b_n18 n25_b_n18 183.071
r_29_t0_b_n18 n29__t0_b_n18 n29_b_n18 183.071
r_29_t1_b_n18 n29__t1_b_n18 n29_b_n18 183.071
r_30_t0_b_n18 n30__t0_b_n18 n30_b_n18 183.071
r_30_t1_b_n18 n30__t1_b_n18 n30_b_n18 183.071
r_31_t0_b_n18 n31__t0_b_n18 n31_b_n18 183.071
r_31_t1_b_n18 n31__t1_b_n18 n31_b_n18 183.071
r_32_t0_b_n18 n32__t0_b_n18 n32_b_n18 183.071
r_32_t1_b_n18 n32__t1_b_n18 n32_b_n18 183.071
r_7_t0_b_n18 n7__t0_b_n18 n7_b_n18 183.071
r_7_t1_b_n18 n7__t1_b_n18 n7_b_n18 183.071
r_8_t0_b_n18 n8__t0_b_n18 n8_b_n18 183.071
r_8_t1_b_n18 n8__t1_b_n18 n8_b_n18 183.071
r_9_t0_b_n18 n9__t0_b_n18 n9_b_n18 183.071
r_9_t1_b_n18 n9__t1_b_n18 n9_b_n18 183.071
rgnd_t0_b_n18 gnd__t0_b_n18 0 38.2988
rgnd_t1_b_n18 gnd__t1_b_n18 0 33.9576
rgnd_t2_b_n18 gnd__t2_b_n18 0 33.9576
rgnd_t3_b_n18 gnd__t3_b_n18 0 38.2988
rgnd_t4_b_n18 gnd__t4_b_n18 0 38.2988
rgnd_t5_b_n18 gnd__t5_b_n18 0 33.9576
rgnd_t6_b_n18 gnd__t6_b_n18 0 33.9576
rgnd_t7_b_n18 gnd__t7_b_n18 0 38.2988
rgnd_t8_b_n18 gnd__t8_b_n18 0 28.0185
rgnd_t9_b_n18 gnd__t9_b_n18 0 21.7106
rgnd_t10_b_n18 gnd__t10_b_n18 0 21.7106
rgnd_t11_b_n18 gnd__t11_b_n18 0 28.0185
rgnd_t12_b_n18 gnd__t12_b_n18 0 18.9833
rgnd_t13_b_n18 gnd__t13_b_n18 0 6.8325
rgnd_t14_b_n18 gnd__t14_b_n18 0 6.8325
rgnd_t15_b_n18 gnd__t15_b_n18 0 18.9833
rgnd_t16_b_n18 gnd__t16_b_n18 0 24.2409
rgnd_t17_b_n18 gnd__t17_b_n18 0 16.5511
rgnd_t18_b_n18 gnd__t18_b_n18 0 16.5511
rgnd_t19_b_n18 gnd__t19_b_n18 0 24.2409
rgnd_t20_b_n18 gnd__t20_b_n18 0 24.2409
rgnd_t21_b_n18 gnd__t21_b_n18 0 16.5511
rgnd_t22_b_n18 gnd__t22_b_n18 0 16.5511
rgnd_t23_b_n18 gnd__t23_b_n18 0 24.2409
rgnd_t24_b_n18 gnd__t24_b_n18 0 18.9833
rgnd_t25_b_n18 gnd__t25_b_n18 0 6.8325
rgnd_t26_b_n18 gnd__t26_b_n18 0 6.8325
rgnd_t27_b_n18 gnd__t27_b_n18 0 18.9833
rgnd_t28_b_n18 gnd__t28_b_n18 0 28.0185
rgnd_t29_b_n18 gnd__t29_b_n18 0 21.7106
rgnd_t30_b_n18 gnd__t30_b_n18 0 21.7106
rgnd_t31_b_n18 gnd__t31_b_n18 0 28.0185
rbl_0_t0_b_n18 bl_0__t0_b_n18 bl_0_b_n18 14.8304
rbl_0_t1_b_n18 bl_0__t1_b_n18 bl_0_b_n18 10.9301
rbl_0_t2_b_n18 bl_0__t2_b_n18 bl_0_b_n18 14.8304
rbl_0_t3_b_n18 bl_0__t3_b_n18 bl_0_b_n18 10.9301
rbl_1_t0_b_n18 bl_1__t0_b_n18 bl_1_b_n18 10.9301
rbl_1_t1_b_n18 bl_1__t1_b_n18 bl_1_b_n18 14.8304
rbl_1_t2_b_n18 bl_1__t2_b_n18 bl_1_b_n18 14.8304
rbl_1_t3_b_n18 bl_1__t3_b_n18 bl_1_b_n18 10.9301
rbl_2_t0_b_n18 bl_2__t0_b_n18 bl_2_b_n18 10.9301
rbl_2_t1_b_n18 bl_2__t1_b_n18 bl_2_b_n18 14.8304
rbl_2_t2_b_n18 bl_2__t2_b_n18 bl_2_b_n18 14.8304
rbl_2_t3_b_n18 bl_2__t3_b_n18 bl_2_b_n18 10.9301
rbl_3_t0_b_n18 bl_3__t0_b_n18 bl_3_b_n18 14.8304
rbl_3_t1_b_n18 bl_3__t1_b_n18 bl_3_b_n18 10.9301
rbl_3_t2_b_n18 bl_3__t2_b_n18 bl_3_b_n18 14.8304
rbl_3_t3_b_n18 bl_3__t3_b_n18 bl_3_b_n18 10.9301
rrbl_0_t0_b_n18 rbl_0__t0_b_n18 rbl_0_b_n18 36.5601
rrbl_0_t1_b_n18 rbl_0__t1_b_n18 rbl_0_b_n18 36.5601
rrbl_0_t2_b_n18 rbl_0__t2_b_n18 rbl_0_b_n18 2.99444
rrbl_0_t3_b_n18 rbl_0__t3_b_n18 rbl_0_b_n18 2.99444
rrbl_1_t0_b_n18 rbl_1__t0_b_n18 rbl_1_b_n18 36.5601
rrbl_1_t1_b_n18 rbl_1__t1_b_n18 rbl_1_b_n18 36.5601
rrbl_1_t2_b_n18 rbl_1__t2_b_n18 rbl_1_b_n18 2.99444
rrbl_1_t3_b_n18 rbl_1__t3_b_n18 rbl_1_b_n18 2.99444
rrbl_2_t0_b_n18 rbl_2__t0_b_n18 rbl_2_b_n18 36.5601
rrbl_2_t1_b_n18 rbl_2__t1_b_n18 rbl_2_b_n18 36.5601
rrbl_2_t2_b_n18 rbl_2__t2_b_n18 rbl_2_b_n18 2.99444
rrbl_2_t3_b_n18 rbl_2__t3_b_n18 rbl_2_b_n18 2.99444
rrbl_3_t0_b_n18 rbl_3__t0_b_n18 rbl_3_b_n18 36.5601
rrbl_3_t1_b_n18 rbl_3__t1_b_n18 rbl_3_b_n18 36.5601
rrbl_3_t2_b_n18 rbl_3__t2_b_n18 rbl_3_b_n18 2.99444
rrbl_3_t3_b_n18 rbl_3__t3_b_n18 rbl_3_b_n18 2.99444
rrwl_0_t0_b_n18 rwl_0__t0_b_n18 rwl_0_b_n18 38.2618
rrwl_0_t1_b_n18 rwl_0__t1_b_n18 rwl_0_b_n18 12.7539
rrwl_0_t2_b_n18 rwl_0__t2_b_n18 rwl_0_b_n18 38.2618
rrwl_0_t3_b_n18 rwl_0__t3_b_n18 rwl_0_b_n18 12.7539
rrwl_1_t0_b_n18 rwl_1__t0_b_n18 rwl_1_b_n18 38.2618
rrwl_1_t1_b_n18 rwl_1__t1_b_n18 rwl_1_b_n18 12.7539
rrwl_1_t2_b_n18 rwl_1__t2_b_n18 rwl_1_b_n18 12.7539
rrwl_1_t3_b_n18 rwl_1__t3_b_n18 rwl_1_b_n18 38.2618
rrwl_2_t0_b_n18 rwl_2__t0_b_n18 rwl_2_b_n18 12.7539
rrwl_2_t1_b_n18 rwl_2__t1_b_n18 rwl_2_b_n18 12.7539
rrwl_2_t2_b_n18 rwl_2__t2_b_n18 rwl_2_b_n18 38.2618
rrwl_2_t3_b_n18 rwl_2__t3_b_n18 rwl_2_b_n18 38.2618
rrwl_3_t0_b_n18 rwl_3__t0_b_n18 rwl_3_b_n18 38.2618
rrwl_3_t1_b_n18 rwl_3__t1_b_n18 rwl_3_b_n18 12.7539
rrwl_3_t2_b_n18 rwl_3__t2_b_n18 rwl_3_b_n18 12.7539
rrwl_3_t3_b_n18 rwl_3__t3_b_n18 rwl_3_b_n18 38.2618
rwl_0_t0_b_n18 wl_0__t0_b_n18 wl_0_b_n18 245.959
rwl_0_t1_b_n18 wl_0__t1_b_n18 wl_0_b_n18 245.959
rwl_0_t2_b_n18 wl_0__t2_b_n18 wl_0_b_n18 81.9864
rwl_0_t3_b_n18 wl_0__t3_b_n18 wl_0_b_n18 81.9864
rwl_1_t0_b_n18 wl_1__t0_b_n18 wl_1_b_n18 245.959
rwl_1_t1_b_n18 wl_1__t1_b_n18 wl_1_b_n18 81.9864
rwl_1_t2_b_n18 wl_1__t2_b_n18 wl_1_b_n18 81.9864
rwl_1_t3_b_n18 wl_1__t3_b_n18 wl_1_b_n18 245.959
rwl_2_t0_b_n18 wl_2__t0_b_n18 wl_2_b_n18 245.959
rwl_2_t1_b_n18 wl_2__t1_b_n18 wl_2_b_n18 81.9864
rwl_2_t2_b_n18 wl_2__t2_b_n18 wl_2_b_n18 81.9864
rwl_2_t3_b_n18 wl_2__t3_b_n18 wl_2_b_n18 245.959
rwl_3_t0_b_n18 wl_3__t0_b_n18 wl_3_b_n18 245.959
rwl_3_t1_b_n18 wl_3__t1_b_n18 wl_3_b_n18 81.9864
rwl_3_t2_b_n18 wl_3__t2_b_n18 wl_3_b_n18 81.9864
rwl_3_t3_b_n18 wl_3__t3_b_n18 wl_3_b_n18 245.959
c_10_b_n18 n10_b_n18 0 2.91622e-16
c_17_b_n18 n17_b_n18 0 2.91528e-16
c_18_b_n18 n18_b_n18 0 2.91528e-16
c_19_b_n18 n19_b_n18 0 2.91528e-16
c_20_b_n18 n20_b_n18 0 2.91622e-16
c_22_b_n18 n22_b_n18 0 2.91528e-16
c_23_b_n18 n23_b_n18 0 2.91528e-16
c_24_b_n18 n24_b_n18 0 2.91528e-16
c_25_b_n18 n25_b_n18 0 2.91622e-16
c_29_b_n18 n29_b_n18 0 2.91528e-16
c_30_b_n18 n30_b_n18 0 2.91528e-16
c_31_b_n18 n31_b_n18 0 2.91528e-16
c_32_b_n18 n32_b_n18 0 2.91622e-16
c_7_b_n18 n7_b_n18 0 2.91528e-16
c_8_b_n18 n8_b_n18 0 2.91528e-16
c_9_b_n18 n9_b_n18 0 2.91528e-16
cgnd_b_n18 0 0 2.48166e-15
cbl_0_b_n18 bl_0_b_n18 0 4.52661e-16
cbl_1_b_n18 bl_1_b_n18 0 4.52661e-16
cbl_2_b_n18 bl_2_b_n18 0 4.52661e-16
cbl_3_b_n18 bl_3_b_n18 0 4.52661e-16
crbl_0_b_n18 rbl_0_b_n18 0 9.14472e-16
crbl_1_b_n18 rbl_1_b_n18 0 9.14472e-16
crbl_2_b_n18 rbl_2_b_n18 0 9.14472e-16
crbl_3_b_n18 rbl_3_b_n18 0 9.17566e-16
crwl_0_b_n18 rwl_0_b_n18 0 5.19495e-16
crwl_1_b_n18 rwl_1_b_n18 0 5.11719e-16
crwl_2_b_n18 rwl_2_b_n18 0 5.11719e-16
crwl_3_b_n18 rwl_3_b_n18 0 5.19495e-16
cwl_0_b_n18 wl_0_b_n18 0 3.30388e-16
cwl_1_b_n18 wl_1_b_n18 0 3.30388e-16
cwl_2_b_n18 wl_2_b_n18 0 3.30388e-16
cwl_3_b_n18 wl_3_b_n18 0 3.30388e-16
ccc__10__9_b_n18 n10_b_n18 n9_b_n18 1.02e-17
ccc__10_bl_3_b_n18 n10_b_n18 bl_3_b_n18 1.3999e-17
ccc__10_rwl_0_b_n18 n10_b_n18 rwl_0_b_n18 4.335e-18
ccc__17__18_b_n18 n17_b_n18 n18_b_n18 1.02e-17
ccc__17_bl_0_b_n18 n17_b_n18 bl_0_b_n18 8.415e-18
ccc__17_rwl_1_b_n18 n17_b_n18 rwl_1_b_n18 1.3194e-17
ccc__18__19_b_n18 n18_b_n18 n19_b_n18 1.02e-17
ccc__18_bl_1_b_n18 n18_b_n18 bl_1_b_n18 8.415e-18
ccc__18_rwl_1_b_n18 n18_b_n18 rwl_1_b_n18 1.3194e-17
ccc__19__20_b_n18 n19_b_n18 n20_b_n18 1.02e-17
ccc__19_bl_2_b_n18 n19_b_n18 bl_2_b_n18 8.415e-18
ccc__19_rwl_1_b_n18 n19_b_n18 rwl_1_b_n18 1.3194e-17
ccc__20_bl_3_b_n18 n20_b_n18 bl_3_b_n18 8.415e-18
ccc__20_rwl_1_b_n18 n20_b_n18 rwl_1_b_n18 6.655e-18
ccc__22__23_b_n18 n22_b_n18 n23_b_n18 1.02e-17
ccc__22_bl_0_b_n18 n22_b_n18 bl_0_b_n18 8.415e-18
ccc__22_rwl_2_b_n18 n22_b_n18 rwl_2_b_n18 1.3194e-17
ccc__23__24_b_n18 n23_b_n18 n24_b_n18 1.02e-17
ccc__23_bl_1_b_n18 n23_b_n18 bl_1_b_n18 8.415e-18
ccc__23_rwl_2_b_n18 n23_b_n18 rwl_2_b_n18 1.3194e-17
ccc__24__25_b_n18 n24_b_n18 n25_b_n18 1.02e-17
ccc__24_bl_2_b_n18 n24_b_n18 bl_2_b_n18 8.415e-18
ccc__24_rwl_2_b_n18 n24_b_n18 rwl_2_b_n18 1.3194e-17
ccc__25_bl_3_b_n18 n25_b_n18 bl_3_b_n18 8.415e-18
ccc__25_rwl_2_b_n18 n25_b_n18 rwl_2_b_n18 6.655e-18
ccc__29__30_b_n18 n29_b_n18 n30_b_n18 1.02e-17
ccc__29_bl_0_b_n18 n29_b_n18 bl_0_b_n18 8.415e-18
ccc__29_rwl_3_b_n18 n29_b_n18 rwl_3_b_n18 1.3194e-17
ccc__30__31_b_n18 n30_b_n18 n31_b_n18 1.02e-17
ccc__30_bl_1_b_n18 n30_b_n18 bl_1_b_n18 8.415e-18
ccc__30_rwl_3_b_n18 n30_b_n18 rwl_3_b_n18 1.3194e-17
ccc__31__32_b_n18 n31_b_n18 n32_b_n18 1.02e-17
ccc__31_bl_2_b_n18 n31_b_n18 bl_2_b_n18 8.415e-18
ccc__31_rwl_3_b_n18 n31_b_n18 rwl_3_b_n18 1.3194e-17
ccc__32_bl_3_b_n18 n32_b_n18 bl_3_b_n18 8.415e-18
ccc__32_rwl_3_b_n18 n32_b_n18 rwl_3_b_n18 6.655e-18
ccc__7__8_b_n18 n7_b_n18 n8_b_n18 1.02e-17
ccc__7_bl_0_b_n18 n7_b_n18 bl_0_b_n18 1.3999e-17
ccc__7_rwl_0_b_n18 n7_b_n18 rwl_0_b_n18 8.961e-18
ccc__8__9_b_n18 n8_b_n18 n9_b_n18 1.02e-17
ccc__8_bl_1_b_n18 n8_b_n18 bl_1_b_n18 1.3999e-17
ccc__8_rwl_0_b_n18 n8_b_n18 rwl_0_b_n18 8.961e-18
ccc__9_bl_2_b_n18 n9_b_n18 bl_2_b_n18 1.3999e-17
ccc__9_rwl_0_b_n18 n9_b_n18 rwl_0_b_n18 8.961e-18
ccc_bl_0_rbl_0_b_n18 bl_0_b_n18 rbl_0_b_n18 1.88693e-16
ccc_bl_0_rwl_1_b_n18 bl_0_b_n18 rwl_1_b_n18 1.0093e-17
ccc_bl_0_rwl_2_b_n18 bl_0_b_n18 rwl_2_b_n18 1.0093e-17
ccc_bl_1_rbl_0_b_n18 bl_1_b_n18 rbl_0_b_n18 1.633e-16
ccc_bl_1_rbl_1_b_n18 bl_1_b_n18 rbl_1_b_n18 1.88693e-16
ccc_bl_1_rwl_1_b_n18 bl_1_b_n18 rwl_1_b_n18 1.0093e-17
ccc_bl_1_rwl_2_b_n18 bl_1_b_n18 rwl_2_b_n18 1.0093e-17
ccc_bl_2_rbl_1_b_n18 bl_2_b_n18 rbl_1_b_n18 1.633e-16
ccc_bl_2_rbl_2_b_n18 bl_2_b_n18 rbl_2_b_n18 1.88693e-16
ccc_bl_2_rwl_1_b_n18 bl_2_b_n18 rwl_1_b_n18 1.0093e-17
ccc_bl_2_rwl_2_b_n18 bl_2_b_n18 rwl_2_b_n18 1.0093e-17
ccc_bl_3_rbl_2_b_n18 bl_3_b_n18 rbl_2_b_n18 1.633e-16
ccc_bl_3_rbl_3_b_n18 bl_3_b_n18 rbl_3_b_n18 1.88693e-16
ccc_bl_3_rwl_1_b_n18 bl_3_b_n18 rwl_1_b_n18 1.0093e-17
ccc_bl_3_rwl_2_b_n18 bl_3_b_n18 rwl_2_b_n18 1.0093e-17
ccc_rbl_0_rbl_1_b_n18 rbl_0_b_n18 rbl_1_b_n18 3.432e-17
ccc_rbl_0_rwl_0_b_n18 rbl_0_b_n18 rwl_0_b_n18 4.9752e-17
ccc_rbl_0_rwl_1_b_n18 rbl_0_b_n18 rwl_1_b_n18 4.9752e-17
ccc_rbl_0_rwl_2_b_n18 rbl_0_b_n18 rwl_2_b_n18 4.9752e-17
ccc_rbl_0_rwl_3_b_n18 rbl_0_b_n18 rwl_3_b_n18 4.9752e-17
ccc_rbl_1_rbl_2_b_n18 rbl_1_b_n18 rbl_2_b_n18 3.432e-17
ccc_rbl_1_rwl_0_b_n18 rbl_1_b_n18 rwl_0_b_n18 4.9752e-17
ccc_rbl_1_rwl_1_b_n18 rbl_1_b_n18 rwl_1_b_n18 4.9752e-17
ccc_rbl_1_rwl_2_b_n18 rbl_1_b_n18 rwl_2_b_n18 4.9752e-17
ccc_rbl_1_rwl_3_b_n18 rbl_1_b_n18 rwl_3_b_n18 4.9752e-17
ccc_rbl_2_rbl_3_b_n18 rbl_2_b_n18 rbl_3_b_n18 3.432e-17
ccc_rbl_2_rwl_0_b_n18 rbl_2_b_n18 rwl_0_b_n18 4.9752e-17
ccc_rbl_2_rwl_1_b_n18 rbl_2_b_n18 rwl_1_b_n18 4.9752e-17
ccc_rbl_2_rwl_2_b_n18 rbl_2_b_n18 rwl_2_b_n18 4.9752e-17
ccc_rbl_2_rwl_3_b_n18 rbl_2_b_n18 rwl_3_b_n18 4.9752e-17
ccc_rbl_3_rwl_0_b_n18 rbl_3_b_n18 rwl_0_b_n18 3.3407e-17
ccc_rbl_3_rwl_1_b_n18 rbl_3_b_n18 rwl_1_b_n18 3.3407e-17
ccc_rbl_3_rwl_2_b_n18 rbl_3_b_n18 rwl_2_b_n18 3.3407e-17
ccc_rbl_3_rwl_3_b_n18 rbl_3_b_n18 rwl_3_b_n18 3.3407e-17
vdw_b_n18_0 wl_0_b_n18 0 dc 0
vdr_b_n18_0 rwl_0_b_n18 0 dc 0
vdw_b_n18_1 wl_1_b_n18 0 dc 0
vdr_b_n18_1 rwl_1_b_n18 0 dc 0
vdw_b_n18_2 wl_2_b_n18 0 dc 0
vdr_b_n18_2 rwl_2_b_n18 0 dc 0
vdw_b_n18_3 wl_3_b_n18 0 dc 0
vdr_b_n18_3 rwl_3_b_n18 0 dc 0
vdb_b_n18_0 bl_0_b_n18 0 dc 0
vdp_b_n18_0 rbl_0_b_n18 0 dc 0
vdb_b_n18_1 bl_1_b_n18 0 dc 0
vdp_b_n18_1 rbl_1_b_n18 0 dc 0
vdb_b_n18_2 bl_2_b_n18 0 dc 0
vdp_b_n18_2 rbl_2_b_n18 0 dc 0
vdb_b_n18_3 bl_3_b_n18 0 dc 0
vdp_b_n18_3 rbl_3_b_n18 0 dc 0
vdn_b_n18_n7 n7_b_n18 0 dc 1
vdn_b_n18_n8 n8_b_n18 0 dc 1
vdn_b_n18_n9 n9_b_n18 0 dc 1
vdn_b_n18_n10 n10_b_n18 0 dc 1
vdn_b_n18_n17 n17_b_n18 0 dc 1
vdn_b_n18_n19 n19_b_n18 0 dc 1
vdn_b_n18_n20 n20_b_n18 0 dc 1
vdn_b_n18_n22 n22_b_n18 0 dc 1
vdn_b_n18_n23 n23_b_n18 0 dc 1
vdn_b_n18_n24 n24_b_n18 0 dc 1
vdn_b_n18_n25 n25_b_n18 0 dc 1
vdn_b_n18_n29 n29_b_n18 0 dc 1
vdn_b_n18_n30 n30_b_n18 0 dc 1
vdn_b_n18_n31 n31_b_n18 0 dc 1
vdn_b_n18_n32 n32_b_n18 0 dc 1
bdr_b_n18 n18_b_n18 0 i=5e-08*min(1,max(0,(time-1e-09)/0.2n))*0.5*(1+tanh((v(n18_b_n18)-0.05)/0.01))

* ---- instance b_n19: variant b, probed storage node \$19 ----
xm1_b_n19 rwl_0__t2_b_n19 n7__t0_b_n19 rbl_0__t0_b_n19 gnd__t0_b_n19 sky130_fd_pr__nfet_01v8 L=0.15 W=0.42 nf=1 ad=0.1197 as=0.1197 pd=1.41 ps=1.41 mult=1 m=1
xm2_b_n19 rwl_0__t3_b_n19 n8__t1_b_n19 rbl_1__t1_b_n19 gnd__t1_b_n19 sky130_fd_pr__nfet_01v8 L=0.15 W=0.42 nf=1 ad=0.1197 as=0.1197 pd=1.41 ps=1.41 mult=1 m=1
xm3_b_n19 rwl_0__t1_b_n19 n9__t1_b_n19 rbl_2__t1_b_n19 gnd__t2_b_n19 sky130_fd_pr__nfet_01v8 L=0.15 W=0.42 nf=1 ad=0.1197 as=0.1197 pd=1.41 ps=1.41 mult=1 m=1
xm4_b_n19 rwl_0__t0_b_n19 n10__t1_b_n19 rbl_3__t1_b_n19 gnd__t3_b_n19 sky130_fd_pr__nfet_01v8 L=0.15 W=0.42 nf=1 ad=0.1197 as=0.1197 pd=1.41 ps=1.41 mult=1 m=1
xm5_b_n19 bl_0__t0_b_n19 wl_0__t0_b_n19 n7__t1_b_n19 gnd__t8_b_n19 sky130_fd_pr__nfet_01v8 L=0.15 W=0.42 nf=1 ad=0.0588 as=0.1197 pd=0.7 ps=1.41 mult=1 m=1
xm6_b_n19 n17__t0_b_n19 wl_1__t0_b_n19 bl_0__t1_b_n19 gnd__t20_b_n19 sky130_fd_pr__nfet_01v8 L=0.15 W=0.42 nf=1 ad=0.1197 as=0.0588 pd=1.41 ps=0.7 mult=1 m=1
xm7_b_n19 bl_1__t2_b_n19 wl_0__t3_b_n19 n8__t0_b_n19 gnd__t9_b_n19 sky130_fd_pr__nfet_01v8 L=0.15 W=0.42 nf=1 ad=0.0588 as=0.1197 pd=0.7 ps=1.41 mult=1 m=1
xm8_b_n19 n18__t0_b_n19 wl_1__t1_b_n19 bl_1__t0_b_n19 gnd__t21_b_n19 sky130_fd_pr__nfet_01v8 L=0.15 W=0.42 nf=1 ad=0.1197 as=0.0588 pd=1.41 ps=0.7 mult=1 m=1
xm9_b_n19 bl_2__t2_b_n19 wl_0__t2_b_n19 n9__t0_b_n19 gnd__t10_b_n19 sky130_fd_pr__nfet_01v8 L=0.15 W=0.42 nf=1 ad=0.0588 as=0.1197 pd=0.7 ps=1.41 mult=1 m=1
xm10_b_n19 n19__t0_b_n19 wl_1__t2_b_n19 bl_2__t0_b_n19 gnd__t22_b_n19 sky130_fd_pr__nfet_01v8 L=0.15 W=0.42 nf=1 ad=0.1197 as=0.0588 pd=1.41 ps=0.7 mult=1 m=1
xm11_b_n19 bl_3__t2_b_n19 wl_0__t1_b_n19 n10__t0_b_n19 gnd__t11_b_n19 sky130_fd_pr__nfet_01v8 L=0.15 W=0.42 nf=1 ad=0.0588 as=0.1197 pd=0.7 ps=1.41 mult=1 m=1
xm12_b_n19 n20__t0_b_n19 wl_1__t3_b_n19 bl_3__t1_b_n19 gnd__t23_b_n19 sky130_fd_pr__nfet_01v8 L=0.15 W=0.42 nf=1 ad=0.1197 as=0.0588 pd=1.41 ps=0.7 mult=1 m=1
xm13_b_n19 rbl_0__t3_b_n19 n17__t1_b_n19 rwl_1__t0_b_n19 gnd__t12_b_n19 sky130_fd_pr__nfet_01v8 L=0.15 W=0.42 nf=1 ad=0.0588 as=0.1197 pd=0.7 ps=1.41 mult=1 m=1
xm14_b_n19 rwl_2__t3_b_n19 n22__t0_b_n19 rbl_0__t2_b_n19 gnd__t24_b_n19 sky130_fd_pr__nfet_01v8 L=0.15 W=0.42 nf=1 ad=0.1197 as=0.0588 pd=1.41 ps=0.7 mult=1 m=1
xm15_b_n19 rbl_1__t3_b_n19 n18__t1_b_n19 rwl_1__t1_b_n19 gnd__t13_b_n19 sky130_fd_pr__nfet_01v8 L=0.15 W=0.42 nf=1 ad=0.0588 as=0.1197 pd=0.7 ps=1.41 mult=1 m=1
xm16_b_n19 rwl_2__t0_b_n19 n23__t0_b_n19 rbl_1__t2_b_n19 gnd__t25_b_n19 sky130_fd_pr__nfet_01v8 L=0.15 W=0.42 nf=1 ad=0.1197 as=0.0588 pd=1.41 ps=0.7 mult=1 m=1
xm17_b_n19 rbl_2__t3_b_n19 n19__t1_b_n19 rwl_1__t2_b_n19 gnd__t14_b_n19 sky130_fd_pr__nfet_01v8 L=0.15 W=0.42 nf=1 ad=0.0588 as=0.1197 pd=0.7 ps=1.41 mult=1 m=1
xm18_b_n19 rwl_2__t1_b_n19 n24__t0_b_n19 rbl_2__t2_b_n19 gnd__t26_b_n19 sky130_fd_pr__nfet_01v8 L=0.15 W=0.42 nf=1 ad=0.1197 as=0.0588 pd=1.41 ps=0.7 mult=1 m=1
xm19_b_n19 rbl_3__t3_b_n19 n20__t1_b_n19 rwl_1__t3_b_n19 gnd__t15_b_n19 sky130_fd_pr__nfet_01v8 L=0.15 W=0.42 nf=1 ad=0.0588 as=0.1197 pd=0.7 ps=1.41 mult=1 m=1
xm20_b_n19 rwl_2__t2_b_n19 n25__t0_b_n19 rbl_3__t2_b_n19 gnd__t27_b_n19 sky130_fd_pr__nfet_01v8 L=0.15 W=0.42 nf=1 ad=0.1197 as=0.0588 pd=1.41 ps=0.7 mult=1 m=1
xm21_b_n19 bl_0__t3_b_n19 wl_2__t0_b_n19 n22__t1_b_n19 gnd__t16_b_n19 sky130_fd_pr__nfet_01v8 L=0.15 W=0.42 nf=1 ad=0.0588 as=0.1197 pd=0.7 ps=1.41 mult=1 m=1
xm22_b_n19 n29__t0_b_n19 wl_3__t3_b_n19 bl_0__t2_b_n19 gnd__t28_b_n19 sky130_fd_pr__nfet_01v8 L=0.15 W=0.42 nf=1 ad=0.1197 as=0.0588 pd=1.41 ps=0.7 mult=1 m=1
xm23_b_n19 bl_1__t3_b_n19 wl_2__t1_b_n19 n23__t1_b_n19 gnd__t17_b_n19 sky130_fd_pr__nfet_01v8 L=0.15 W=0.42 nf=1 ad=0.0588 as=0.1197 pd=0.7 ps=1.41 mult=1 m=1
xm24_b_n19 n30__t0_b_n19 wl_3__t2_b_n19 bl_1__t1_b_n19 gnd__t29_b_n19 sky130_fd_pr__nfet_01v8 L=0.15 W=0.42 nf=1 ad=0.1197 as=0.0588 pd=1.41 ps=0.7 mult=1 m=1
xm25_b_n19 bl_2__t3_b_n19 wl_2__t2_b_n19 n24__t1_b_n19 gnd__t18_b_n19 sky130_fd_pr__nfet_01v8 L=0.15 W=0.42 nf=1 ad=0.0588 as=0.1197 pd=0.7 ps=1.41 mult=1 m=1
xm26_b_n19 n31__t0_b_n19 wl_3__t1_b_n19 bl_2__t1_b_n19 gnd__t30_b_n19 sky130_fd_pr__nfet_01v8 L=0.15 W=0.42 nf=1 ad=0.1197 as=0.0588 pd=1.41 ps=0.7 mult=1 m=1
xm27_b_n19 bl_3__t3_b_n19 wl_2__t3_b_n19 n25__t1_b_n19 gnd__t19_b_n19 sky130_fd_pr__nfet_01v8 L=0.15 W=0.42 nf=1 ad=0.0588 as=0.1197 pd=0.7 ps=1.41 mult=1 m=1
xm28_b_n19 n32__t0_b_n19 wl_3__t0_b_n19 bl_3__t0_b_n19 gnd__t31_b_n19 sky130_fd_pr__nfet_01v8 L=0.15 W=0.42 nf=1 ad=0.1197 as=0.0588 pd=1.41 ps=0.7 mult=1 m=1
xm29_b_n19 rbl_0__t1_b_n19 n29__t1_b_n19 rwl_3__t0_b_n19 gnd__t4_b_n19 sky130_fd_pr__nfet_01v8 L=0.15 W=0.42 nf=1 ad=0.1197 as=0.1197 pd=1.41 ps=1.41 mult=1 m=1
xm30_b_n19 rbl_1__t0_b_n19 n30__t1_b_n19 rwl_3__t1_b_n19 gnd__t5_b_n19 sky130_fd_pr__nfet_01v8 L=0.15 W=0.42 nf=1 ad=0.1197 as=0.1197 pd=1.41 ps=1.41 mult=1 m=1
xm31_b_n19 rbl_2__t0_b_n19 n31__t1_b_n19 rwl_3__t2_b_n19 gnd__t6_b_n19 sky130_fd_pr__nfet_01v8 L=0.15 W=0.42 nf=1 ad=0.1197 as=0.1197 pd=1.41 ps=1.41 mult=1 m=1
xm32_b_n19 rbl_3__t0_b_n19 n32__t1_b_n19 rwl_3__t3_b_n19 gnd__t7_b_n19 sky130_fd_pr__nfet_01v8 L=0.15 W=0.42 nf=1 ad=0.1197 as=0.1197 pd=1.41 ps=1.41 mult=1 m=1
r_10_t0_b_n19 n10__t0_b_n19 n10_b_n19 183.071
r_10_t1_b_n19 n10__t1_b_n19 n10_b_n19 183.071
r_17_t0_b_n19 n17__t0_b_n19 n17_b_n19 183.071
r_17_t1_b_n19 n17__t1_b_n19 n17_b_n19 183.071
r_18_t0_b_n19 n18__t0_b_n19 n18_b_n19 183.071
r_18_t1_b_n19 n18__t1_b_n19 n18_b_n19 183.071
r_19_t0_b_n19 n19__t0_b_n19 n19_b_n19 183.071
r_19_t1_b_n19 n19__t1_b_n19 n19_b_n19 183.071
r_20_t0_b_n19 n20__t0_b_n19 n20_b_n19 183.071
r_20_t1_b_n19 n20__t1_b_n19 n20_b_n19 183.071
r_22_t0_b_n19 n22__t0_b_n19 n22_b_n19 183.071
r_22_t1_b_n19 n22__t1_b_n19 n22_b_n19 183.071
r_23_t0_b_n19 n23__t0_b_n19 n23_b_n19 183.071
r_23_t1_b_n19 n23__t1_b_n19 n23_b_n19 183.071
r_24_t0_b_n19 n24__t0_b_n19 n24_b_n19 183.071
r_24_t1_b_n19 n24__t1_b_n19 n24_b_n19 183.071
r_25_t0_b_n19 n25__t0_b_n19 n25_b_n19 183.071
r_25_t1_b_n19 n25__t1_b_n19 n25_b_n19 183.071
r_29_t0_b_n19 n29__t0_b_n19 n29_b_n19 183.071
r_29_t1_b_n19 n29__t1_b_n19 n29_b_n19 183.071
r_30_t0_b_n19 n30__t0_b_n19 n30_b_n19 183.071
r_30_t1_b_n19 n30__t1_b_n19 n30_b_n19 183.071
r_31_t0_b_n19 n31__t0_b_n19 n31_b_n19 183.071
r_31_t1_b_n19 n31__t1_b_n19 n31_b_n19 183.071
r_32_t0_b_n19 n32__t0_b_n19 n32_b_n19 183.071
r_32_t1_b_n19 n32__t1_b_n19 n32_b_n19 183.071
r_7_t0_b_n19 n7__t0_b_n19 n7_b_n19 183.071
r_7_t1_b_n19 n7__t1_b_n19 n7_b_n19 183.071
r_8_t0_b_n19 n8__t0_b_n19 n8_b_n19 183.071
r_8_t1_b_n19 n8__t1_b_n19 n8_b_n19 183.071
r_9_t0_b_n19 n9__t0_b_n19 n9_b_n19 183.071
r_9_t1_b_n19 n9__t1_b_n19 n9_b_n19 183.071
rgnd_t0_b_n19 gnd__t0_b_n19 0 38.2988
rgnd_t1_b_n19 gnd__t1_b_n19 0 33.9576
rgnd_t2_b_n19 gnd__t2_b_n19 0 33.9576
rgnd_t3_b_n19 gnd__t3_b_n19 0 38.2988
rgnd_t4_b_n19 gnd__t4_b_n19 0 38.2988
rgnd_t5_b_n19 gnd__t5_b_n19 0 33.9576
rgnd_t6_b_n19 gnd__t6_b_n19 0 33.9576
rgnd_t7_b_n19 gnd__t7_b_n19 0 38.2988
rgnd_t8_b_n19 gnd__t8_b_n19 0 28.0185
rgnd_t9_b_n19 gnd__t9_b_n19 0 21.7106
rgnd_t10_b_n19 gnd__t10_b_n19 0 21.7106
rgnd_t11_b_n19 gnd__t11_b_n19 0 28.0185
rgnd_t12_b_n19 gnd__t12_b_n19 0 18.9833
rgnd_t13_b_n19 gnd__t13_b_n19 0 6.8325
rgnd_t14_b_n19 gnd__t14_b_n19 0 6.8325
rgnd_t15_b_n19 gnd__t15_b_n19 0 18.9833
rgnd_t16_b_n19 gnd__t16_b_n19 0 24.2409
rgnd_t17_b_n19 gnd__t17_b_n19 0 16.5511
rgnd_t18_b_n19 gnd__t18_b_n19 0 16.5511
rgnd_t19_b_n19 gnd__t19_b_n19 0 24.2409
rgnd_t20_b_n19 gnd__t20_b_n19 0 24.2409
rgnd_t21_b_n19 gnd__t21_b_n19 0 16.5511
rgnd_t22_b_n19 gnd__t22_b_n19 0 16.5511
rgnd_t23_b_n19 gnd__t23_b_n19 0 24.2409
rgnd_t24_b_n19 gnd__t24_b_n19 0 18.9833
rgnd_t25_b_n19 gnd__t25_b_n19 0 6.8325
rgnd_t26_b_n19 gnd__t26_b_n19 0 6.8325
rgnd_t27_b_n19 gnd__t27_b_n19 0 18.9833
rgnd_t28_b_n19 gnd__t28_b_n19 0 28.0185
rgnd_t29_b_n19 gnd__t29_b_n19 0 21.7106
rgnd_t30_b_n19 gnd__t30_b_n19 0 21.7106
rgnd_t31_b_n19 gnd__t31_b_n19 0 28.0185
rbl_0_t0_b_n19 bl_0__t0_b_n19 bl_0_b_n19 14.8304
rbl_0_t1_b_n19 bl_0__t1_b_n19 bl_0_b_n19 10.9301
rbl_0_t2_b_n19 bl_0__t2_b_n19 bl_0_b_n19 14.8304
rbl_0_t3_b_n19 bl_0__t3_b_n19 bl_0_b_n19 10.9301
rbl_1_t0_b_n19 bl_1__t0_b_n19 bl_1_b_n19 10.9301
rbl_1_t1_b_n19 bl_1__t1_b_n19 bl_1_b_n19 14.8304
rbl_1_t2_b_n19 bl_1__t2_b_n19 bl_1_b_n19 14.8304
rbl_1_t3_b_n19 bl_1__t3_b_n19 bl_1_b_n19 10.9301
rbl_2_t0_b_n19 bl_2__t0_b_n19 bl_2_b_n19 10.9301
rbl_2_t1_b_n19 bl_2__t1_b_n19 bl_2_b_n19 14.8304
rbl_2_t2_b_n19 bl_2__t2_b_n19 bl_2_b_n19 14.8304
rbl_2_t3_b_n19 bl_2__t3_b_n19 bl_2_b_n19 10.9301
rbl_3_t0_b_n19 bl_3__t0_b_n19 bl_3_b_n19 14.8304
rbl_3_t1_b_n19 bl_3__t1_b_n19 bl_3_b_n19 10.9301
rbl_3_t2_b_n19 bl_3__t2_b_n19 bl_3_b_n19 14.8304
rbl_3_t3_b_n19 bl_3__t3_b_n19 bl_3_b_n19 10.9301
rrbl_0_t0_b_n19 rbl_0__t0_b_n19 rbl_0_b_n19 36.5601
rrbl_0_t1_b_n19 rbl_0__t1_b_n19 rbl_0_b_n19 36.5601
rrbl_0_t2_b_n19 rbl_0__t2_b_n19 rbl_0_b_n19 2.99444
rrbl_0_t3_b_n19 rbl_0__t3_b_n19 rbl_0_b_n19 2.99444
rrbl_1_t0_b_n19 rbl_1__t0_b_n19 rbl_1_b_n19 36.5601
rrbl_1_t1_b_n19 rbl_1__t1_b_n19 rbl_1_b_n19 36.5601
rrbl_1_t2_b_n19 rbl_1__t2_b_n19 rbl_1_b_n19 2.99444
rrbl_1_t3_b_n19 rbl_1__t3_b_n19 rbl_1_b_n19 2.99444
rrbl_2_t0_b_n19 rbl_2__t0_b_n19 rbl_2_b_n19 36.5601
rrbl_2_t1_b_n19 rbl_2__t1_b_n19 rbl_2_b_n19 36.5601
rrbl_2_t2_b_n19 rbl_2__t2_b_n19 rbl_2_b_n19 2.99444
rrbl_2_t3_b_n19 rbl_2__t3_b_n19 rbl_2_b_n19 2.99444
rrbl_3_t0_b_n19 rbl_3__t0_b_n19 rbl_3_b_n19 36.5601
rrbl_3_t1_b_n19 rbl_3__t1_b_n19 rbl_3_b_n19 36.5601
rrbl_3_t2_b_n19 rbl_3__t2_b_n19 rbl_3_b_n19 2.99444
rrbl_3_t3_b_n19 rbl_3__t3_b_n19 rbl_3_b_n19 2.99444
rrwl_0_t0_b_n19 rwl_0__t0_b_n19 rwl_0_b_n19 38.2618
rrwl_0_t1_b_n19 rwl_0__t1_b_n19 rwl_0_b_n19 12.7539
rrwl_0_t2_b_n19 rwl_0__t2_b_n19 rwl_0_b_n19 38.2618
rrwl_0_t3_b_n19 rwl_0__t3_b_n19 rwl_0_b_n19 12.7539
rrwl_1_t0_b_n19 rwl_1__t0_b_n19 rwl_1_b_n19 38.2618
rrwl_1_t1_b_n19 rwl_1__t1_b_n19 rwl_1_b_n19 12.7539
rrwl_1_t2_b_n19 rwl_1__t2_b_n19 rwl_1_b_n19 12.7539
rrwl_1_t3_b_n19 rwl_1__t3_b_n19 rwl_1_b_n19 38.2618
rrwl_2_t0_b_n19 rwl_2__t0_b_n19 rwl_2_b_n19 12.7539
rrwl_2_t1_b_n19 rwl_2__t1_b_n19 rwl_2_b_n19 12.7539
rrwl_2_t2_b_n19 rwl_2__t2_b_n19 rwl_2_b_n19 38.2618
rrwl_2_t3_b_n19 rwl_2__t3_b_n19 rwl_2_b_n19 38.2618
rrwl_3_t0_b_n19 rwl_3__t0_b_n19 rwl_3_b_n19 38.2618
rrwl_3_t1_b_n19 rwl_3__t1_b_n19 rwl_3_b_n19 12.7539
rrwl_3_t2_b_n19 rwl_3__t2_b_n19 rwl_3_b_n19 12.7539
rrwl_3_t3_b_n19 rwl_3__t3_b_n19 rwl_3_b_n19 38.2618
rwl_0_t0_b_n19 wl_0__t0_b_n19 wl_0_b_n19 245.959
rwl_0_t1_b_n19 wl_0__t1_b_n19 wl_0_b_n19 245.959
rwl_0_t2_b_n19 wl_0__t2_b_n19 wl_0_b_n19 81.9864
rwl_0_t3_b_n19 wl_0__t3_b_n19 wl_0_b_n19 81.9864
rwl_1_t0_b_n19 wl_1__t0_b_n19 wl_1_b_n19 245.959
rwl_1_t1_b_n19 wl_1__t1_b_n19 wl_1_b_n19 81.9864
rwl_1_t2_b_n19 wl_1__t2_b_n19 wl_1_b_n19 81.9864
rwl_1_t3_b_n19 wl_1__t3_b_n19 wl_1_b_n19 245.959
rwl_2_t0_b_n19 wl_2__t0_b_n19 wl_2_b_n19 245.959
rwl_2_t1_b_n19 wl_2__t1_b_n19 wl_2_b_n19 81.9864
rwl_2_t2_b_n19 wl_2__t2_b_n19 wl_2_b_n19 81.9864
rwl_2_t3_b_n19 wl_2__t3_b_n19 wl_2_b_n19 245.959
rwl_3_t0_b_n19 wl_3__t0_b_n19 wl_3_b_n19 245.959
rwl_3_t1_b_n19 wl_3__t1_b_n19 wl_3_b_n19 81.9864
rwl_3_t2_b_n19 wl_3__t2_b_n19 wl_3_b_n19 81.9864
rwl_3_t3_b_n19 wl_3__t3_b_n19 wl_3_b_n19 245.959
c_10_b_n19 n10_b_n19 0 2.91622e-16
c_17_b_n19 n17_b_n19 0 2.91528e-16
c_18_b_n19 n18_b_n19 0 2.91528e-16
c_19_b_n19 n19_b_n19 0 2.91528e-16
c_20_b_n19 n20_b_n19 0 2.91622e-16
c_22_b_n19 n22_b_n19 0 2.91528e-16
c_23_b_n19 n23_b_n19 0 2.91528e-16
c_24_b_n19 n24_b_n19 0 2.91528e-16
c_25_b_n19 n25_b_n19 0 2.91622e-16
c_29_b_n19 n29_b_n19 0 2.91528e-16
c_30_b_n19 n30_b_n19 0 2.91528e-16
c_31_b_n19 n31_b_n19 0 2.91528e-16
c_32_b_n19 n32_b_n19 0 2.91622e-16
c_7_b_n19 n7_b_n19 0 2.91528e-16
c_8_b_n19 n8_b_n19 0 2.91528e-16
c_9_b_n19 n9_b_n19 0 2.91528e-16
cgnd_b_n19 0 0 2.48166e-15
cbl_0_b_n19 bl_0_b_n19 0 4.52661e-16
cbl_1_b_n19 bl_1_b_n19 0 4.52661e-16
cbl_2_b_n19 bl_2_b_n19 0 4.52661e-16
cbl_3_b_n19 bl_3_b_n19 0 4.52661e-16
crbl_0_b_n19 rbl_0_b_n19 0 9.14472e-16
crbl_1_b_n19 rbl_1_b_n19 0 9.14472e-16
crbl_2_b_n19 rbl_2_b_n19 0 9.14472e-16
crbl_3_b_n19 rbl_3_b_n19 0 9.17566e-16
crwl_0_b_n19 rwl_0_b_n19 0 5.19495e-16
crwl_1_b_n19 rwl_1_b_n19 0 5.11719e-16
crwl_2_b_n19 rwl_2_b_n19 0 5.11719e-16
crwl_3_b_n19 rwl_3_b_n19 0 5.19495e-16
cwl_0_b_n19 wl_0_b_n19 0 3.30388e-16
cwl_1_b_n19 wl_1_b_n19 0 3.30388e-16
cwl_2_b_n19 wl_2_b_n19 0 3.30388e-16
cwl_3_b_n19 wl_3_b_n19 0 3.30388e-16
ccc__10__9_b_n19 n10_b_n19 n9_b_n19 1.02e-17
ccc__10_bl_3_b_n19 n10_b_n19 bl_3_b_n19 1.3999e-17
ccc__10_rwl_0_b_n19 n10_b_n19 rwl_0_b_n19 4.335e-18
ccc__17__18_b_n19 n17_b_n19 n18_b_n19 1.02e-17
ccc__17_bl_0_b_n19 n17_b_n19 bl_0_b_n19 8.415e-18
ccc__17_rwl_1_b_n19 n17_b_n19 rwl_1_b_n19 1.3194e-17
ccc__18__19_b_n19 n18_b_n19 n19_b_n19 1.02e-17
ccc__18_bl_1_b_n19 n18_b_n19 bl_1_b_n19 8.415e-18
ccc__18_rwl_1_b_n19 n18_b_n19 rwl_1_b_n19 1.3194e-17
ccc__19__20_b_n19 n19_b_n19 n20_b_n19 1.02e-17
ccc__19_bl_2_b_n19 n19_b_n19 bl_2_b_n19 8.415e-18
ccc__19_rwl_1_b_n19 n19_b_n19 rwl_1_b_n19 1.3194e-17
ccc__20_bl_3_b_n19 n20_b_n19 bl_3_b_n19 8.415e-18
ccc__20_rwl_1_b_n19 n20_b_n19 rwl_1_b_n19 6.655e-18
ccc__22__23_b_n19 n22_b_n19 n23_b_n19 1.02e-17
ccc__22_bl_0_b_n19 n22_b_n19 bl_0_b_n19 8.415e-18
ccc__22_rwl_2_b_n19 n22_b_n19 rwl_2_b_n19 1.3194e-17
ccc__23__24_b_n19 n23_b_n19 n24_b_n19 1.02e-17
ccc__23_bl_1_b_n19 n23_b_n19 bl_1_b_n19 8.415e-18
ccc__23_rwl_2_b_n19 n23_b_n19 rwl_2_b_n19 1.3194e-17
ccc__24__25_b_n19 n24_b_n19 n25_b_n19 1.02e-17
ccc__24_bl_2_b_n19 n24_b_n19 bl_2_b_n19 8.415e-18
ccc__24_rwl_2_b_n19 n24_b_n19 rwl_2_b_n19 1.3194e-17
ccc__25_bl_3_b_n19 n25_b_n19 bl_3_b_n19 8.415e-18
ccc__25_rwl_2_b_n19 n25_b_n19 rwl_2_b_n19 6.655e-18
ccc__29__30_b_n19 n29_b_n19 n30_b_n19 1.02e-17
ccc__29_bl_0_b_n19 n29_b_n19 bl_0_b_n19 8.415e-18
ccc__29_rwl_3_b_n19 n29_b_n19 rwl_3_b_n19 1.3194e-17
ccc__30__31_b_n19 n30_b_n19 n31_b_n19 1.02e-17
ccc__30_bl_1_b_n19 n30_b_n19 bl_1_b_n19 8.415e-18
ccc__30_rwl_3_b_n19 n30_b_n19 rwl_3_b_n19 1.3194e-17
ccc__31__32_b_n19 n31_b_n19 n32_b_n19 1.02e-17
ccc__31_bl_2_b_n19 n31_b_n19 bl_2_b_n19 8.415e-18
ccc__31_rwl_3_b_n19 n31_b_n19 rwl_3_b_n19 1.3194e-17
ccc__32_bl_3_b_n19 n32_b_n19 bl_3_b_n19 8.415e-18
ccc__32_rwl_3_b_n19 n32_b_n19 rwl_3_b_n19 6.655e-18
ccc__7__8_b_n19 n7_b_n19 n8_b_n19 1.02e-17
ccc__7_bl_0_b_n19 n7_b_n19 bl_0_b_n19 1.3999e-17
ccc__7_rwl_0_b_n19 n7_b_n19 rwl_0_b_n19 8.961e-18
ccc__8__9_b_n19 n8_b_n19 n9_b_n19 1.02e-17
ccc__8_bl_1_b_n19 n8_b_n19 bl_1_b_n19 1.3999e-17
ccc__8_rwl_0_b_n19 n8_b_n19 rwl_0_b_n19 8.961e-18
ccc__9_bl_2_b_n19 n9_b_n19 bl_2_b_n19 1.3999e-17
ccc__9_rwl_0_b_n19 n9_b_n19 rwl_0_b_n19 8.961e-18
ccc_bl_0_rbl_0_b_n19 bl_0_b_n19 rbl_0_b_n19 1.88693e-16
ccc_bl_0_rwl_1_b_n19 bl_0_b_n19 rwl_1_b_n19 1.0093e-17
ccc_bl_0_rwl_2_b_n19 bl_0_b_n19 rwl_2_b_n19 1.0093e-17
ccc_bl_1_rbl_0_b_n19 bl_1_b_n19 rbl_0_b_n19 1.633e-16
ccc_bl_1_rbl_1_b_n19 bl_1_b_n19 rbl_1_b_n19 1.88693e-16
ccc_bl_1_rwl_1_b_n19 bl_1_b_n19 rwl_1_b_n19 1.0093e-17
ccc_bl_1_rwl_2_b_n19 bl_1_b_n19 rwl_2_b_n19 1.0093e-17
ccc_bl_2_rbl_1_b_n19 bl_2_b_n19 rbl_1_b_n19 1.633e-16
ccc_bl_2_rbl_2_b_n19 bl_2_b_n19 rbl_2_b_n19 1.88693e-16
ccc_bl_2_rwl_1_b_n19 bl_2_b_n19 rwl_1_b_n19 1.0093e-17
ccc_bl_2_rwl_2_b_n19 bl_2_b_n19 rwl_2_b_n19 1.0093e-17
ccc_bl_3_rbl_2_b_n19 bl_3_b_n19 rbl_2_b_n19 1.633e-16
ccc_bl_3_rbl_3_b_n19 bl_3_b_n19 rbl_3_b_n19 1.88693e-16
ccc_bl_3_rwl_1_b_n19 bl_3_b_n19 rwl_1_b_n19 1.0093e-17
ccc_bl_3_rwl_2_b_n19 bl_3_b_n19 rwl_2_b_n19 1.0093e-17
ccc_rbl_0_rbl_1_b_n19 rbl_0_b_n19 rbl_1_b_n19 3.432e-17
ccc_rbl_0_rwl_0_b_n19 rbl_0_b_n19 rwl_0_b_n19 4.9752e-17
ccc_rbl_0_rwl_1_b_n19 rbl_0_b_n19 rwl_1_b_n19 4.9752e-17
ccc_rbl_0_rwl_2_b_n19 rbl_0_b_n19 rwl_2_b_n19 4.9752e-17
ccc_rbl_0_rwl_3_b_n19 rbl_0_b_n19 rwl_3_b_n19 4.9752e-17
ccc_rbl_1_rbl_2_b_n19 rbl_1_b_n19 rbl_2_b_n19 3.432e-17
ccc_rbl_1_rwl_0_b_n19 rbl_1_b_n19 rwl_0_b_n19 4.9752e-17
ccc_rbl_1_rwl_1_b_n19 rbl_1_b_n19 rwl_1_b_n19 4.9752e-17
ccc_rbl_1_rwl_2_b_n19 rbl_1_b_n19 rwl_2_b_n19 4.9752e-17
ccc_rbl_1_rwl_3_b_n19 rbl_1_b_n19 rwl_3_b_n19 4.9752e-17
ccc_rbl_2_rbl_3_b_n19 rbl_2_b_n19 rbl_3_b_n19 3.432e-17
ccc_rbl_2_rwl_0_b_n19 rbl_2_b_n19 rwl_0_b_n19 4.9752e-17
ccc_rbl_2_rwl_1_b_n19 rbl_2_b_n19 rwl_1_b_n19 4.9752e-17
ccc_rbl_2_rwl_2_b_n19 rbl_2_b_n19 rwl_2_b_n19 4.9752e-17
ccc_rbl_2_rwl_3_b_n19 rbl_2_b_n19 rwl_3_b_n19 4.9752e-17
ccc_rbl_3_rwl_0_b_n19 rbl_3_b_n19 rwl_0_b_n19 3.3407e-17
ccc_rbl_3_rwl_1_b_n19 rbl_3_b_n19 rwl_1_b_n19 3.3407e-17
ccc_rbl_3_rwl_2_b_n19 rbl_3_b_n19 rwl_2_b_n19 3.3407e-17
ccc_rbl_3_rwl_3_b_n19 rbl_3_b_n19 rwl_3_b_n19 3.3407e-17
vdw_b_n19_0 wl_0_b_n19 0 dc 0
vdr_b_n19_0 rwl_0_b_n19 0 dc 0
vdw_b_n19_1 wl_1_b_n19 0 dc 0
vdr_b_n19_1 rwl_1_b_n19 0 dc 0
vdw_b_n19_2 wl_2_b_n19 0 dc 0
vdr_b_n19_2 rwl_2_b_n19 0 dc 0
vdw_b_n19_3 wl_3_b_n19 0 dc 0
vdr_b_n19_3 rwl_3_b_n19 0 dc 0
vdb_b_n19_0 bl_0_b_n19 0 dc 0
vdp_b_n19_0 rbl_0_b_n19 0 dc 0
vdb_b_n19_1 bl_1_b_n19 0 dc 0
vdp_b_n19_1 rbl_1_b_n19 0 dc 0
vdb_b_n19_2 bl_2_b_n19 0 dc 0
vdp_b_n19_2 rbl_2_b_n19 0 dc 0
vdb_b_n19_3 bl_3_b_n19 0 dc 0
vdp_b_n19_3 rbl_3_b_n19 0 dc 0
vdn_b_n19_n7 n7_b_n19 0 dc 1
vdn_b_n19_n8 n8_b_n19 0 dc 1
vdn_b_n19_n9 n9_b_n19 0 dc 1
vdn_b_n19_n10 n10_b_n19 0 dc 1
vdn_b_n19_n17 n17_b_n19 0 dc 1
vdn_b_n19_n18 n18_b_n19 0 dc 1
vdn_b_n19_n20 n20_b_n19 0 dc 1
vdn_b_n19_n22 n22_b_n19 0 dc 1
vdn_b_n19_n23 n23_b_n19 0 dc 1
vdn_b_n19_n24 n24_b_n19 0 dc 1
vdn_b_n19_n25 n25_b_n19 0 dc 1
vdn_b_n19_n29 n29_b_n19 0 dc 1
vdn_b_n19_n30 n30_b_n19 0 dc 1
vdn_b_n19_n31 n31_b_n19 0 dc 1
vdn_b_n19_n32 n32_b_n19 0 dc 1
bdr_b_n19 n19_b_n19 0 i=5e-08*min(1,max(0,(time-1e-09)/0.2n))*0.5*(1+tanh((v(n19_b_n19)-0.05)/0.01))

* ---- instance b_n20: variant b, probed storage node \$20 ----
xm1_b_n20 rwl_0__t2_b_n20 n7__t0_b_n20 rbl_0__t0_b_n20 gnd__t0_b_n20 sky130_fd_pr__nfet_01v8 L=0.15 W=0.42 nf=1 ad=0.1197 as=0.1197 pd=1.41 ps=1.41 mult=1 m=1
xm2_b_n20 rwl_0__t3_b_n20 n8__t1_b_n20 rbl_1__t1_b_n20 gnd__t1_b_n20 sky130_fd_pr__nfet_01v8 L=0.15 W=0.42 nf=1 ad=0.1197 as=0.1197 pd=1.41 ps=1.41 mult=1 m=1
xm3_b_n20 rwl_0__t1_b_n20 n9__t1_b_n20 rbl_2__t1_b_n20 gnd__t2_b_n20 sky130_fd_pr__nfet_01v8 L=0.15 W=0.42 nf=1 ad=0.1197 as=0.1197 pd=1.41 ps=1.41 mult=1 m=1
xm4_b_n20 rwl_0__t0_b_n20 n10__t1_b_n20 rbl_3__t1_b_n20 gnd__t3_b_n20 sky130_fd_pr__nfet_01v8 L=0.15 W=0.42 nf=1 ad=0.1197 as=0.1197 pd=1.41 ps=1.41 mult=1 m=1
xm5_b_n20 bl_0__t0_b_n20 wl_0__t0_b_n20 n7__t1_b_n20 gnd__t8_b_n20 sky130_fd_pr__nfet_01v8 L=0.15 W=0.42 nf=1 ad=0.0588 as=0.1197 pd=0.7 ps=1.41 mult=1 m=1
xm6_b_n20 n17__t0_b_n20 wl_1__t0_b_n20 bl_0__t1_b_n20 gnd__t20_b_n20 sky130_fd_pr__nfet_01v8 L=0.15 W=0.42 nf=1 ad=0.1197 as=0.0588 pd=1.41 ps=0.7 mult=1 m=1
xm7_b_n20 bl_1__t2_b_n20 wl_0__t3_b_n20 n8__t0_b_n20 gnd__t9_b_n20 sky130_fd_pr__nfet_01v8 L=0.15 W=0.42 nf=1 ad=0.0588 as=0.1197 pd=0.7 ps=1.41 mult=1 m=1
xm8_b_n20 n18__t0_b_n20 wl_1__t1_b_n20 bl_1__t0_b_n20 gnd__t21_b_n20 sky130_fd_pr__nfet_01v8 L=0.15 W=0.42 nf=1 ad=0.1197 as=0.0588 pd=1.41 ps=0.7 mult=1 m=1
xm9_b_n20 bl_2__t2_b_n20 wl_0__t2_b_n20 n9__t0_b_n20 gnd__t10_b_n20 sky130_fd_pr__nfet_01v8 L=0.15 W=0.42 nf=1 ad=0.0588 as=0.1197 pd=0.7 ps=1.41 mult=1 m=1
xm10_b_n20 n19__t0_b_n20 wl_1__t2_b_n20 bl_2__t0_b_n20 gnd__t22_b_n20 sky130_fd_pr__nfet_01v8 L=0.15 W=0.42 nf=1 ad=0.1197 as=0.0588 pd=1.41 ps=0.7 mult=1 m=1
xm11_b_n20 bl_3__t2_b_n20 wl_0__t1_b_n20 n10__t0_b_n20 gnd__t11_b_n20 sky130_fd_pr__nfet_01v8 L=0.15 W=0.42 nf=1 ad=0.0588 as=0.1197 pd=0.7 ps=1.41 mult=1 m=1
xm12_b_n20 n20__t0_b_n20 wl_1__t3_b_n20 bl_3__t1_b_n20 gnd__t23_b_n20 sky130_fd_pr__nfet_01v8 L=0.15 W=0.42 nf=1 ad=0.1197 as=0.0588 pd=1.41 ps=0.7 mult=1 m=1
xm13_b_n20 rbl_0__t3_b_n20 n17__t1_b_n20 rwl_1__t0_b_n20 gnd__t12_b_n20 sky130_fd_pr__nfet_01v8 L=0.15 W=0.42 nf=1 ad=0.0588 as=0.1197 pd=0.7 ps=1.41 mult=1 m=1
xm14_b_n20 rwl_2__t3_b_n20 n22__t0_b_n20 rbl_0__t2_b_n20 gnd__t24_b_n20 sky130_fd_pr__nfet_01v8 L=0.15 W=0.42 nf=1 ad=0.1197 as=0.0588 pd=1.41 ps=0.7 mult=1 m=1
xm15_b_n20 rbl_1__t3_b_n20 n18__t1_b_n20 rwl_1__t1_b_n20 gnd__t13_b_n20 sky130_fd_pr__nfet_01v8 L=0.15 W=0.42 nf=1 ad=0.0588 as=0.1197 pd=0.7 ps=1.41 mult=1 m=1
xm16_b_n20 rwl_2__t0_b_n20 n23__t0_b_n20 rbl_1__t2_b_n20 gnd__t25_b_n20 sky130_fd_pr__nfet_01v8 L=0.15 W=0.42 nf=1 ad=0.1197 as=0.0588 pd=1.41 ps=0.7 mult=1 m=1
xm17_b_n20 rbl_2__t3_b_n20 n19__t1_b_n20 rwl_1__t2_b_n20 gnd__t14_b_n20 sky130_fd_pr__nfet_01v8 L=0.15 W=0.42 nf=1 ad=0.0588 as=0.1197 pd=0.7 ps=1.41 mult=1 m=1
xm18_b_n20 rwl_2__t1_b_n20 n24__t0_b_n20 rbl_2__t2_b_n20 gnd__t26_b_n20 sky130_fd_pr__nfet_01v8 L=0.15 W=0.42 nf=1 ad=0.1197 as=0.0588 pd=1.41 ps=0.7 mult=1 m=1
xm19_b_n20 rbl_3__t3_b_n20 n20__t1_b_n20 rwl_1__t3_b_n20 gnd__t15_b_n20 sky130_fd_pr__nfet_01v8 L=0.15 W=0.42 nf=1 ad=0.0588 as=0.1197 pd=0.7 ps=1.41 mult=1 m=1
xm20_b_n20 rwl_2__t2_b_n20 n25__t0_b_n20 rbl_3__t2_b_n20 gnd__t27_b_n20 sky130_fd_pr__nfet_01v8 L=0.15 W=0.42 nf=1 ad=0.1197 as=0.0588 pd=1.41 ps=0.7 mult=1 m=1
xm21_b_n20 bl_0__t3_b_n20 wl_2__t0_b_n20 n22__t1_b_n20 gnd__t16_b_n20 sky130_fd_pr__nfet_01v8 L=0.15 W=0.42 nf=1 ad=0.0588 as=0.1197 pd=0.7 ps=1.41 mult=1 m=1
xm22_b_n20 n29__t0_b_n20 wl_3__t3_b_n20 bl_0__t2_b_n20 gnd__t28_b_n20 sky130_fd_pr__nfet_01v8 L=0.15 W=0.42 nf=1 ad=0.1197 as=0.0588 pd=1.41 ps=0.7 mult=1 m=1
xm23_b_n20 bl_1__t3_b_n20 wl_2__t1_b_n20 n23__t1_b_n20 gnd__t17_b_n20 sky130_fd_pr__nfet_01v8 L=0.15 W=0.42 nf=1 ad=0.0588 as=0.1197 pd=0.7 ps=1.41 mult=1 m=1
xm24_b_n20 n30__t0_b_n20 wl_3__t2_b_n20 bl_1__t1_b_n20 gnd__t29_b_n20 sky130_fd_pr__nfet_01v8 L=0.15 W=0.42 nf=1 ad=0.1197 as=0.0588 pd=1.41 ps=0.7 mult=1 m=1
xm25_b_n20 bl_2__t3_b_n20 wl_2__t2_b_n20 n24__t1_b_n20 gnd__t18_b_n20 sky130_fd_pr__nfet_01v8 L=0.15 W=0.42 nf=1 ad=0.0588 as=0.1197 pd=0.7 ps=1.41 mult=1 m=1
xm26_b_n20 n31__t0_b_n20 wl_3__t1_b_n20 bl_2__t1_b_n20 gnd__t30_b_n20 sky130_fd_pr__nfet_01v8 L=0.15 W=0.42 nf=1 ad=0.1197 as=0.0588 pd=1.41 ps=0.7 mult=1 m=1
xm27_b_n20 bl_3__t3_b_n20 wl_2__t3_b_n20 n25__t1_b_n20 gnd__t19_b_n20 sky130_fd_pr__nfet_01v8 L=0.15 W=0.42 nf=1 ad=0.0588 as=0.1197 pd=0.7 ps=1.41 mult=1 m=1
xm28_b_n20 n32__t0_b_n20 wl_3__t0_b_n20 bl_3__t0_b_n20 gnd__t31_b_n20 sky130_fd_pr__nfet_01v8 L=0.15 W=0.42 nf=1 ad=0.1197 as=0.0588 pd=1.41 ps=0.7 mult=1 m=1
xm29_b_n20 rbl_0__t1_b_n20 n29__t1_b_n20 rwl_3__t0_b_n20 gnd__t4_b_n20 sky130_fd_pr__nfet_01v8 L=0.15 W=0.42 nf=1 ad=0.1197 as=0.1197 pd=1.41 ps=1.41 mult=1 m=1
xm30_b_n20 rbl_1__t0_b_n20 n30__t1_b_n20 rwl_3__t1_b_n20 gnd__t5_b_n20 sky130_fd_pr__nfet_01v8 L=0.15 W=0.42 nf=1 ad=0.1197 as=0.1197 pd=1.41 ps=1.41 mult=1 m=1
xm31_b_n20 rbl_2__t0_b_n20 n31__t1_b_n20 rwl_3__t2_b_n20 gnd__t6_b_n20 sky130_fd_pr__nfet_01v8 L=0.15 W=0.42 nf=1 ad=0.1197 as=0.1197 pd=1.41 ps=1.41 mult=1 m=1
xm32_b_n20 rbl_3__t0_b_n20 n32__t1_b_n20 rwl_3__t3_b_n20 gnd__t7_b_n20 sky130_fd_pr__nfet_01v8 L=0.15 W=0.42 nf=1 ad=0.1197 as=0.1197 pd=1.41 ps=1.41 mult=1 m=1
r_10_t0_b_n20 n10__t0_b_n20 n10_b_n20 183.071
r_10_t1_b_n20 n10__t1_b_n20 n10_b_n20 183.071
r_17_t0_b_n20 n17__t0_b_n20 n17_b_n20 183.071
r_17_t1_b_n20 n17__t1_b_n20 n17_b_n20 183.071
r_18_t0_b_n20 n18__t0_b_n20 n18_b_n20 183.071
r_18_t1_b_n20 n18__t1_b_n20 n18_b_n20 183.071
r_19_t0_b_n20 n19__t0_b_n20 n19_b_n20 183.071
r_19_t1_b_n20 n19__t1_b_n20 n19_b_n20 183.071
r_20_t0_b_n20 n20__t0_b_n20 n20_b_n20 183.071
r_20_t1_b_n20 n20__t1_b_n20 n20_b_n20 183.071
r_22_t0_b_n20 n22__t0_b_n20 n22_b_n20 183.071
r_22_t1_b_n20 n22__t1_b_n20 n22_b_n20 183.071
r_23_t0_b_n20 n23__t0_b_n20 n23_b_n20 183.071
r_23_t1_b_n20 n23__t1_b_n20 n23_b_n20 183.071
r_24_t0_b_n20 n24__t0_b_n20 n24_b_n20 183.071
r_24_t1_b_n20 n24__t1_b_n20 n24_b_n20 183.071
r_25_t0_b_n20 n25__t0_b_n20 n25_b_n20 183.071
r_25_t1_b_n20 n25__t1_b_n20 n25_b_n20 183.071
r_29_t0_b_n20 n29__t0_b_n20 n29_b_n20 183.071
r_29_t1_b_n20 n29__t1_b_n20 n29_b_n20 183.071
r_30_t0_b_n20 n30__t0_b_n20 n30_b_n20 183.071
r_30_t1_b_n20 n30__t1_b_n20 n30_b_n20 183.071
r_31_t0_b_n20 n31__t0_b_n20 n31_b_n20 183.071
r_31_t1_b_n20 n31__t1_b_n20 n31_b_n20 183.071
r_32_t0_b_n20 n32__t0_b_n20 n32_b_n20 183.071
r_32_t1_b_n20 n32__t1_b_n20 n32_b_n20 183.071
r_7_t0_b_n20 n7__t0_b_n20 n7_b_n20 183.071
r_7_t1_b_n20 n7__t1_b_n20 n7_b_n20 183.071
r_8_t0_b_n20 n8__t0_b_n20 n8_b_n20 183.071
r_8_t1_b_n20 n8__t1_b_n20 n8_b_n20 183.071
r_9_t0_b_n20 n9__t0_b_n20 n9_b_n20 183.071
r_9_t1_b_n20 n9__t1_b_n20 n9_b_n20 183.071
rgnd_t0_b_n20 gnd__t0_b_n20 0 38.2988
rgnd_t1_b_n20 gnd__t1_b_n20 0 33.9576
rgnd_t2_b_n20 gnd__t2_b_n20 0 33.9576
rgnd_t3_b_n20 gnd__t3_b_n20 0 38.2988
rgnd_t4_b_n20 gnd__t4_b_n20 0 38.2988
rgnd_t5_b_n20 gnd__t5_b_n20 0 33.9576
rgnd_t6_b_n20 gnd__t6_b_n20 0 33.9576
rgnd_t7_b_n20 gnd__t7_b_n20 0 38.2988
rgnd_t8_b_n20 gnd__t8_b_n20 0 28.0185
rgnd_t9_b_n20 gnd__t9_b_n20 0 21.7106
rgnd_t10_b_n20 gnd__t10_b_n20 0 21.7106
rgnd_t11_b_n20 gnd__t11_b_n20 0 28.0185
rgnd_t12_b_n20 gnd__t12_b_n20 0 18.9833
rgnd_t13_b_n20 gnd__t13_b_n20 0 6.8325
rgnd_t14_b_n20 gnd__t14_b_n20 0 6.8325
rgnd_t15_b_n20 gnd__t15_b_n20 0 18.9833
rgnd_t16_b_n20 gnd__t16_b_n20 0 24.2409
rgnd_t17_b_n20 gnd__t17_b_n20 0 16.5511
rgnd_t18_b_n20 gnd__t18_b_n20 0 16.5511
rgnd_t19_b_n20 gnd__t19_b_n20 0 24.2409
rgnd_t20_b_n20 gnd__t20_b_n20 0 24.2409
rgnd_t21_b_n20 gnd__t21_b_n20 0 16.5511
rgnd_t22_b_n20 gnd__t22_b_n20 0 16.5511
rgnd_t23_b_n20 gnd__t23_b_n20 0 24.2409
rgnd_t24_b_n20 gnd__t24_b_n20 0 18.9833
rgnd_t25_b_n20 gnd__t25_b_n20 0 6.8325
rgnd_t26_b_n20 gnd__t26_b_n20 0 6.8325
rgnd_t27_b_n20 gnd__t27_b_n20 0 18.9833
rgnd_t28_b_n20 gnd__t28_b_n20 0 28.0185
rgnd_t29_b_n20 gnd__t29_b_n20 0 21.7106
rgnd_t30_b_n20 gnd__t30_b_n20 0 21.7106
rgnd_t31_b_n20 gnd__t31_b_n20 0 28.0185
rbl_0_t0_b_n20 bl_0__t0_b_n20 bl_0_b_n20 14.8304
rbl_0_t1_b_n20 bl_0__t1_b_n20 bl_0_b_n20 10.9301
rbl_0_t2_b_n20 bl_0__t2_b_n20 bl_0_b_n20 14.8304
rbl_0_t3_b_n20 bl_0__t3_b_n20 bl_0_b_n20 10.9301
rbl_1_t0_b_n20 bl_1__t0_b_n20 bl_1_b_n20 10.9301
rbl_1_t1_b_n20 bl_1__t1_b_n20 bl_1_b_n20 14.8304
rbl_1_t2_b_n20 bl_1__t2_b_n20 bl_1_b_n20 14.8304
rbl_1_t3_b_n20 bl_1__t3_b_n20 bl_1_b_n20 10.9301
rbl_2_t0_b_n20 bl_2__t0_b_n20 bl_2_b_n20 10.9301
rbl_2_t1_b_n20 bl_2__t1_b_n20 bl_2_b_n20 14.8304
rbl_2_t2_b_n20 bl_2__t2_b_n20 bl_2_b_n20 14.8304
rbl_2_t3_b_n20 bl_2__t3_b_n20 bl_2_b_n20 10.9301
rbl_3_t0_b_n20 bl_3__t0_b_n20 bl_3_b_n20 14.8304
rbl_3_t1_b_n20 bl_3__t1_b_n20 bl_3_b_n20 10.9301
rbl_3_t2_b_n20 bl_3__t2_b_n20 bl_3_b_n20 14.8304
rbl_3_t3_b_n20 bl_3__t3_b_n20 bl_3_b_n20 10.9301
rrbl_0_t0_b_n20 rbl_0__t0_b_n20 rbl_0_b_n20 36.5601
rrbl_0_t1_b_n20 rbl_0__t1_b_n20 rbl_0_b_n20 36.5601
rrbl_0_t2_b_n20 rbl_0__t2_b_n20 rbl_0_b_n20 2.99444
rrbl_0_t3_b_n20 rbl_0__t3_b_n20 rbl_0_b_n20 2.99444
rrbl_1_t0_b_n20 rbl_1__t0_b_n20 rbl_1_b_n20 36.5601
rrbl_1_t1_b_n20 rbl_1__t1_b_n20 rbl_1_b_n20 36.5601
rrbl_1_t2_b_n20 rbl_1__t2_b_n20 rbl_1_b_n20 2.99444
rrbl_1_t3_b_n20 rbl_1__t3_b_n20 rbl_1_b_n20 2.99444
rrbl_2_t0_b_n20 rbl_2__t0_b_n20 rbl_2_b_n20 36.5601
rrbl_2_t1_b_n20 rbl_2__t1_b_n20 rbl_2_b_n20 36.5601
rrbl_2_t2_b_n20 rbl_2__t2_b_n20 rbl_2_b_n20 2.99444
rrbl_2_t3_b_n20 rbl_2__t3_b_n20 rbl_2_b_n20 2.99444
rrbl_3_t0_b_n20 rbl_3__t0_b_n20 rbl_3_b_n20 36.5601
rrbl_3_t1_b_n20 rbl_3__t1_b_n20 rbl_3_b_n20 36.5601
rrbl_3_t2_b_n20 rbl_3__t2_b_n20 rbl_3_b_n20 2.99444
rrbl_3_t3_b_n20 rbl_3__t3_b_n20 rbl_3_b_n20 2.99444
rrwl_0_t0_b_n20 rwl_0__t0_b_n20 rwl_0_b_n20 38.2618
rrwl_0_t1_b_n20 rwl_0__t1_b_n20 rwl_0_b_n20 12.7539
rrwl_0_t2_b_n20 rwl_0__t2_b_n20 rwl_0_b_n20 38.2618
rrwl_0_t3_b_n20 rwl_0__t3_b_n20 rwl_0_b_n20 12.7539
rrwl_1_t0_b_n20 rwl_1__t0_b_n20 rwl_1_b_n20 38.2618
rrwl_1_t1_b_n20 rwl_1__t1_b_n20 rwl_1_b_n20 12.7539
rrwl_1_t2_b_n20 rwl_1__t2_b_n20 rwl_1_b_n20 12.7539
rrwl_1_t3_b_n20 rwl_1__t3_b_n20 rwl_1_b_n20 38.2618
rrwl_2_t0_b_n20 rwl_2__t0_b_n20 rwl_2_b_n20 12.7539
rrwl_2_t1_b_n20 rwl_2__t1_b_n20 rwl_2_b_n20 12.7539
rrwl_2_t2_b_n20 rwl_2__t2_b_n20 rwl_2_b_n20 38.2618
rrwl_2_t3_b_n20 rwl_2__t3_b_n20 rwl_2_b_n20 38.2618
rrwl_3_t0_b_n20 rwl_3__t0_b_n20 rwl_3_b_n20 38.2618
rrwl_3_t1_b_n20 rwl_3__t1_b_n20 rwl_3_b_n20 12.7539
rrwl_3_t2_b_n20 rwl_3__t2_b_n20 rwl_3_b_n20 12.7539
rrwl_3_t3_b_n20 rwl_3__t3_b_n20 rwl_3_b_n20 38.2618
rwl_0_t0_b_n20 wl_0__t0_b_n20 wl_0_b_n20 245.959
rwl_0_t1_b_n20 wl_0__t1_b_n20 wl_0_b_n20 245.959
rwl_0_t2_b_n20 wl_0__t2_b_n20 wl_0_b_n20 81.9864
rwl_0_t3_b_n20 wl_0__t3_b_n20 wl_0_b_n20 81.9864
rwl_1_t0_b_n20 wl_1__t0_b_n20 wl_1_b_n20 245.959
rwl_1_t1_b_n20 wl_1__t1_b_n20 wl_1_b_n20 81.9864
rwl_1_t2_b_n20 wl_1__t2_b_n20 wl_1_b_n20 81.9864
rwl_1_t3_b_n20 wl_1__t3_b_n20 wl_1_b_n20 245.959
rwl_2_t0_b_n20 wl_2__t0_b_n20 wl_2_b_n20 245.959
rwl_2_t1_b_n20 wl_2__t1_b_n20 wl_2_b_n20 81.9864
rwl_2_t2_b_n20 wl_2__t2_b_n20 wl_2_b_n20 81.9864
rwl_2_t3_b_n20 wl_2__t3_b_n20 wl_2_b_n20 245.959
rwl_3_t0_b_n20 wl_3__t0_b_n20 wl_3_b_n20 245.959
rwl_3_t1_b_n20 wl_3__t1_b_n20 wl_3_b_n20 81.9864
rwl_3_t2_b_n20 wl_3__t2_b_n20 wl_3_b_n20 81.9864
rwl_3_t3_b_n20 wl_3__t3_b_n20 wl_3_b_n20 245.959
c_10_b_n20 n10_b_n20 0 2.91622e-16
c_17_b_n20 n17_b_n20 0 2.91528e-16
c_18_b_n20 n18_b_n20 0 2.91528e-16
c_19_b_n20 n19_b_n20 0 2.91528e-16
c_20_b_n20 n20_b_n20 0 2.91622e-16
c_22_b_n20 n22_b_n20 0 2.91528e-16
c_23_b_n20 n23_b_n20 0 2.91528e-16
c_24_b_n20 n24_b_n20 0 2.91528e-16
c_25_b_n20 n25_b_n20 0 2.91622e-16
c_29_b_n20 n29_b_n20 0 2.91528e-16
c_30_b_n20 n30_b_n20 0 2.91528e-16
c_31_b_n20 n31_b_n20 0 2.91528e-16
c_32_b_n20 n32_b_n20 0 2.91622e-16
c_7_b_n20 n7_b_n20 0 2.91528e-16
c_8_b_n20 n8_b_n20 0 2.91528e-16
c_9_b_n20 n9_b_n20 0 2.91528e-16
cgnd_b_n20 0 0 2.48166e-15
cbl_0_b_n20 bl_0_b_n20 0 4.52661e-16
cbl_1_b_n20 bl_1_b_n20 0 4.52661e-16
cbl_2_b_n20 bl_2_b_n20 0 4.52661e-16
cbl_3_b_n20 bl_3_b_n20 0 4.52661e-16
crbl_0_b_n20 rbl_0_b_n20 0 9.14472e-16
crbl_1_b_n20 rbl_1_b_n20 0 9.14472e-16
crbl_2_b_n20 rbl_2_b_n20 0 9.14472e-16
crbl_3_b_n20 rbl_3_b_n20 0 9.17566e-16
crwl_0_b_n20 rwl_0_b_n20 0 5.19495e-16
crwl_1_b_n20 rwl_1_b_n20 0 5.11719e-16
crwl_2_b_n20 rwl_2_b_n20 0 5.11719e-16
crwl_3_b_n20 rwl_3_b_n20 0 5.19495e-16
cwl_0_b_n20 wl_0_b_n20 0 3.30388e-16
cwl_1_b_n20 wl_1_b_n20 0 3.30388e-16
cwl_2_b_n20 wl_2_b_n20 0 3.30388e-16
cwl_3_b_n20 wl_3_b_n20 0 3.30388e-16
ccc__10__9_b_n20 n10_b_n20 n9_b_n20 1.02e-17
ccc__10_bl_3_b_n20 n10_b_n20 bl_3_b_n20 1.3999e-17
ccc__10_rwl_0_b_n20 n10_b_n20 rwl_0_b_n20 4.335e-18
ccc__17__18_b_n20 n17_b_n20 n18_b_n20 1.02e-17
ccc__17_bl_0_b_n20 n17_b_n20 bl_0_b_n20 8.415e-18
ccc__17_rwl_1_b_n20 n17_b_n20 rwl_1_b_n20 1.3194e-17
ccc__18__19_b_n20 n18_b_n20 n19_b_n20 1.02e-17
ccc__18_bl_1_b_n20 n18_b_n20 bl_1_b_n20 8.415e-18
ccc__18_rwl_1_b_n20 n18_b_n20 rwl_1_b_n20 1.3194e-17
ccc__19__20_b_n20 n19_b_n20 n20_b_n20 1.02e-17
ccc__19_bl_2_b_n20 n19_b_n20 bl_2_b_n20 8.415e-18
ccc__19_rwl_1_b_n20 n19_b_n20 rwl_1_b_n20 1.3194e-17
ccc__20_bl_3_b_n20 n20_b_n20 bl_3_b_n20 8.415e-18
ccc__20_rwl_1_b_n20 n20_b_n20 rwl_1_b_n20 6.655e-18
ccc__22__23_b_n20 n22_b_n20 n23_b_n20 1.02e-17
ccc__22_bl_0_b_n20 n22_b_n20 bl_0_b_n20 8.415e-18
ccc__22_rwl_2_b_n20 n22_b_n20 rwl_2_b_n20 1.3194e-17
ccc__23__24_b_n20 n23_b_n20 n24_b_n20 1.02e-17
ccc__23_bl_1_b_n20 n23_b_n20 bl_1_b_n20 8.415e-18
ccc__23_rwl_2_b_n20 n23_b_n20 rwl_2_b_n20 1.3194e-17
ccc__24__25_b_n20 n24_b_n20 n25_b_n20 1.02e-17
ccc__24_bl_2_b_n20 n24_b_n20 bl_2_b_n20 8.415e-18
ccc__24_rwl_2_b_n20 n24_b_n20 rwl_2_b_n20 1.3194e-17
ccc__25_bl_3_b_n20 n25_b_n20 bl_3_b_n20 8.415e-18
ccc__25_rwl_2_b_n20 n25_b_n20 rwl_2_b_n20 6.655e-18
ccc__29__30_b_n20 n29_b_n20 n30_b_n20 1.02e-17
ccc__29_bl_0_b_n20 n29_b_n20 bl_0_b_n20 8.415e-18
ccc__29_rwl_3_b_n20 n29_b_n20 rwl_3_b_n20 1.3194e-17
ccc__30__31_b_n20 n30_b_n20 n31_b_n20 1.02e-17
ccc__30_bl_1_b_n20 n30_b_n20 bl_1_b_n20 8.415e-18
ccc__30_rwl_3_b_n20 n30_b_n20 rwl_3_b_n20 1.3194e-17
ccc__31__32_b_n20 n31_b_n20 n32_b_n20 1.02e-17
ccc__31_bl_2_b_n20 n31_b_n20 bl_2_b_n20 8.415e-18
ccc__31_rwl_3_b_n20 n31_b_n20 rwl_3_b_n20 1.3194e-17
ccc__32_bl_3_b_n20 n32_b_n20 bl_3_b_n20 8.415e-18
ccc__32_rwl_3_b_n20 n32_b_n20 rwl_3_b_n20 6.655e-18
ccc__7__8_b_n20 n7_b_n20 n8_b_n20 1.02e-17
ccc__7_bl_0_b_n20 n7_b_n20 bl_0_b_n20 1.3999e-17
ccc__7_rwl_0_b_n20 n7_b_n20 rwl_0_b_n20 8.961e-18
ccc__8__9_b_n20 n8_b_n20 n9_b_n20 1.02e-17
ccc__8_bl_1_b_n20 n8_b_n20 bl_1_b_n20 1.3999e-17
ccc__8_rwl_0_b_n20 n8_b_n20 rwl_0_b_n20 8.961e-18
ccc__9_bl_2_b_n20 n9_b_n20 bl_2_b_n20 1.3999e-17
ccc__9_rwl_0_b_n20 n9_b_n20 rwl_0_b_n20 8.961e-18
ccc_bl_0_rbl_0_b_n20 bl_0_b_n20 rbl_0_b_n20 1.88693e-16
ccc_bl_0_rwl_1_b_n20 bl_0_b_n20 rwl_1_b_n20 1.0093e-17
ccc_bl_0_rwl_2_b_n20 bl_0_b_n20 rwl_2_b_n20 1.0093e-17
ccc_bl_1_rbl_0_b_n20 bl_1_b_n20 rbl_0_b_n20 1.633e-16
ccc_bl_1_rbl_1_b_n20 bl_1_b_n20 rbl_1_b_n20 1.88693e-16
ccc_bl_1_rwl_1_b_n20 bl_1_b_n20 rwl_1_b_n20 1.0093e-17
ccc_bl_1_rwl_2_b_n20 bl_1_b_n20 rwl_2_b_n20 1.0093e-17
ccc_bl_2_rbl_1_b_n20 bl_2_b_n20 rbl_1_b_n20 1.633e-16
ccc_bl_2_rbl_2_b_n20 bl_2_b_n20 rbl_2_b_n20 1.88693e-16
ccc_bl_2_rwl_1_b_n20 bl_2_b_n20 rwl_1_b_n20 1.0093e-17
ccc_bl_2_rwl_2_b_n20 bl_2_b_n20 rwl_2_b_n20 1.0093e-17
ccc_bl_3_rbl_2_b_n20 bl_3_b_n20 rbl_2_b_n20 1.633e-16
ccc_bl_3_rbl_3_b_n20 bl_3_b_n20 rbl_3_b_n20 1.88693e-16
ccc_bl_3_rwl_1_b_n20 bl_3_b_n20 rwl_1_b_n20 1.0093e-17
ccc_bl_3_rwl_2_b_n20 bl_3_b_n20 rwl_2_b_n20 1.0093e-17
ccc_rbl_0_rbl_1_b_n20 rbl_0_b_n20 rbl_1_b_n20 3.432e-17
ccc_rbl_0_rwl_0_b_n20 rbl_0_b_n20 rwl_0_b_n20 4.9752e-17
ccc_rbl_0_rwl_1_b_n20 rbl_0_b_n20 rwl_1_b_n20 4.9752e-17
ccc_rbl_0_rwl_2_b_n20 rbl_0_b_n20 rwl_2_b_n20 4.9752e-17
ccc_rbl_0_rwl_3_b_n20 rbl_0_b_n20 rwl_3_b_n20 4.9752e-17
ccc_rbl_1_rbl_2_b_n20 rbl_1_b_n20 rbl_2_b_n20 3.432e-17
ccc_rbl_1_rwl_0_b_n20 rbl_1_b_n20 rwl_0_b_n20 4.9752e-17
ccc_rbl_1_rwl_1_b_n20 rbl_1_b_n20 rwl_1_b_n20 4.9752e-17
ccc_rbl_1_rwl_2_b_n20 rbl_1_b_n20 rwl_2_b_n20 4.9752e-17
ccc_rbl_1_rwl_3_b_n20 rbl_1_b_n20 rwl_3_b_n20 4.9752e-17
ccc_rbl_2_rbl_3_b_n20 rbl_2_b_n20 rbl_3_b_n20 3.432e-17
ccc_rbl_2_rwl_0_b_n20 rbl_2_b_n20 rwl_0_b_n20 4.9752e-17
ccc_rbl_2_rwl_1_b_n20 rbl_2_b_n20 rwl_1_b_n20 4.9752e-17
ccc_rbl_2_rwl_2_b_n20 rbl_2_b_n20 rwl_2_b_n20 4.9752e-17
ccc_rbl_2_rwl_3_b_n20 rbl_2_b_n20 rwl_3_b_n20 4.9752e-17
ccc_rbl_3_rwl_0_b_n20 rbl_3_b_n20 rwl_0_b_n20 3.3407e-17
ccc_rbl_3_rwl_1_b_n20 rbl_3_b_n20 rwl_1_b_n20 3.3407e-17
ccc_rbl_3_rwl_2_b_n20 rbl_3_b_n20 rwl_2_b_n20 3.3407e-17
ccc_rbl_3_rwl_3_b_n20 rbl_3_b_n20 rwl_3_b_n20 3.3407e-17
vdw_b_n20_0 wl_0_b_n20 0 dc 0
vdr_b_n20_0 rwl_0_b_n20 0 dc 0
vdw_b_n20_1 wl_1_b_n20 0 dc 0
vdr_b_n20_1 rwl_1_b_n20 0 dc 0
vdw_b_n20_2 wl_2_b_n20 0 dc 0
vdr_b_n20_2 rwl_2_b_n20 0 dc 0
vdw_b_n20_3 wl_3_b_n20 0 dc 0
vdr_b_n20_3 rwl_3_b_n20 0 dc 0
vdb_b_n20_0 bl_0_b_n20 0 dc 0
vdp_b_n20_0 rbl_0_b_n20 0 dc 0
vdb_b_n20_1 bl_1_b_n20 0 dc 0
vdp_b_n20_1 rbl_1_b_n20 0 dc 0
vdb_b_n20_2 bl_2_b_n20 0 dc 0
vdp_b_n20_2 rbl_2_b_n20 0 dc 0
vdb_b_n20_3 bl_3_b_n20 0 dc 0
vdp_b_n20_3 rbl_3_b_n20 0 dc 0
vdn_b_n20_n7 n7_b_n20 0 dc 1
vdn_b_n20_n8 n8_b_n20 0 dc 1
vdn_b_n20_n9 n9_b_n20 0 dc 1
vdn_b_n20_n10 n10_b_n20 0 dc 1
vdn_b_n20_n17 n17_b_n20 0 dc 1
vdn_b_n20_n18 n18_b_n20 0 dc 1
vdn_b_n20_n19 n19_b_n20 0 dc 1
vdn_b_n20_n22 n22_b_n20 0 dc 1
vdn_b_n20_n23 n23_b_n20 0 dc 1
vdn_b_n20_n24 n24_b_n20 0 dc 1
vdn_b_n20_n25 n25_b_n20 0 dc 1
vdn_b_n20_n29 n29_b_n20 0 dc 1
vdn_b_n20_n30 n30_b_n20 0 dc 1
vdn_b_n20_n31 n31_b_n20 0 dc 1
vdn_b_n20_n32 n32_b_n20 0 dc 1
bdr_b_n20 n20_b_n20 0 i=5e-08*min(1,max(0,(time-1e-09)/0.2n))*0.5*(1+tanh((v(n20_b_n20)-0.05)/0.01))

* ---- instance b_n22: variant b, probed storage node \$22 ----
xm1_b_n22 rwl_0__t2_b_n22 n7__t0_b_n22 rbl_0__t0_b_n22 gnd__t0_b_n22 sky130_fd_pr__nfet_01v8 L=0.15 W=0.42 nf=1 ad=0.1197 as=0.1197 pd=1.41 ps=1.41 mult=1 m=1
xm2_b_n22 rwl_0__t3_b_n22 n8__t1_b_n22 rbl_1__t1_b_n22 gnd__t1_b_n22 sky130_fd_pr__nfet_01v8 L=0.15 W=0.42 nf=1 ad=0.1197 as=0.1197 pd=1.41 ps=1.41 mult=1 m=1
xm3_b_n22 rwl_0__t1_b_n22 n9__t1_b_n22 rbl_2__t1_b_n22 gnd__t2_b_n22 sky130_fd_pr__nfet_01v8 L=0.15 W=0.42 nf=1 ad=0.1197 as=0.1197 pd=1.41 ps=1.41 mult=1 m=1
xm4_b_n22 rwl_0__t0_b_n22 n10__t1_b_n22 rbl_3__t1_b_n22 gnd__t3_b_n22 sky130_fd_pr__nfet_01v8 L=0.15 W=0.42 nf=1 ad=0.1197 as=0.1197 pd=1.41 ps=1.41 mult=1 m=1
xm5_b_n22 bl_0__t0_b_n22 wl_0__t0_b_n22 n7__t1_b_n22 gnd__t8_b_n22 sky130_fd_pr__nfet_01v8 L=0.15 W=0.42 nf=1 ad=0.0588 as=0.1197 pd=0.7 ps=1.41 mult=1 m=1
xm6_b_n22 n17__t0_b_n22 wl_1__t0_b_n22 bl_0__t1_b_n22 gnd__t20_b_n22 sky130_fd_pr__nfet_01v8 L=0.15 W=0.42 nf=1 ad=0.1197 as=0.0588 pd=1.41 ps=0.7 mult=1 m=1
xm7_b_n22 bl_1__t2_b_n22 wl_0__t3_b_n22 n8__t0_b_n22 gnd__t9_b_n22 sky130_fd_pr__nfet_01v8 L=0.15 W=0.42 nf=1 ad=0.0588 as=0.1197 pd=0.7 ps=1.41 mult=1 m=1
xm8_b_n22 n18__t0_b_n22 wl_1__t1_b_n22 bl_1__t0_b_n22 gnd__t21_b_n22 sky130_fd_pr__nfet_01v8 L=0.15 W=0.42 nf=1 ad=0.1197 as=0.0588 pd=1.41 ps=0.7 mult=1 m=1
xm9_b_n22 bl_2__t2_b_n22 wl_0__t2_b_n22 n9__t0_b_n22 gnd__t10_b_n22 sky130_fd_pr__nfet_01v8 L=0.15 W=0.42 nf=1 ad=0.0588 as=0.1197 pd=0.7 ps=1.41 mult=1 m=1
xm10_b_n22 n19__t0_b_n22 wl_1__t2_b_n22 bl_2__t0_b_n22 gnd__t22_b_n22 sky130_fd_pr__nfet_01v8 L=0.15 W=0.42 nf=1 ad=0.1197 as=0.0588 pd=1.41 ps=0.7 mult=1 m=1
xm11_b_n22 bl_3__t2_b_n22 wl_0__t1_b_n22 n10__t0_b_n22 gnd__t11_b_n22 sky130_fd_pr__nfet_01v8 L=0.15 W=0.42 nf=1 ad=0.0588 as=0.1197 pd=0.7 ps=1.41 mult=1 m=1
xm12_b_n22 n20__t0_b_n22 wl_1__t3_b_n22 bl_3__t1_b_n22 gnd__t23_b_n22 sky130_fd_pr__nfet_01v8 L=0.15 W=0.42 nf=1 ad=0.1197 as=0.0588 pd=1.41 ps=0.7 mult=1 m=1
xm13_b_n22 rbl_0__t3_b_n22 n17__t1_b_n22 rwl_1__t0_b_n22 gnd__t12_b_n22 sky130_fd_pr__nfet_01v8 L=0.15 W=0.42 nf=1 ad=0.0588 as=0.1197 pd=0.7 ps=1.41 mult=1 m=1
xm14_b_n22 rwl_2__t3_b_n22 n22__t0_b_n22 rbl_0__t2_b_n22 gnd__t24_b_n22 sky130_fd_pr__nfet_01v8 L=0.15 W=0.42 nf=1 ad=0.1197 as=0.0588 pd=1.41 ps=0.7 mult=1 m=1
xm15_b_n22 rbl_1__t3_b_n22 n18__t1_b_n22 rwl_1__t1_b_n22 gnd__t13_b_n22 sky130_fd_pr__nfet_01v8 L=0.15 W=0.42 nf=1 ad=0.0588 as=0.1197 pd=0.7 ps=1.41 mult=1 m=1
xm16_b_n22 rwl_2__t0_b_n22 n23__t0_b_n22 rbl_1__t2_b_n22 gnd__t25_b_n22 sky130_fd_pr__nfet_01v8 L=0.15 W=0.42 nf=1 ad=0.1197 as=0.0588 pd=1.41 ps=0.7 mult=1 m=1
xm17_b_n22 rbl_2__t3_b_n22 n19__t1_b_n22 rwl_1__t2_b_n22 gnd__t14_b_n22 sky130_fd_pr__nfet_01v8 L=0.15 W=0.42 nf=1 ad=0.0588 as=0.1197 pd=0.7 ps=1.41 mult=1 m=1
xm18_b_n22 rwl_2__t1_b_n22 n24__t0_b_n22 rbl_2__t2_b_n22 gnd__t26_b_n22 sky130_fd_pr__nfet_01v8 L=0.15 W=0.42 nf=1 ad=0.1197 as=0.0588 pd=1.41 ps=0.7 mult=1 m=1
xm19_b_n22 rbl_3__t3_b_n22 n20__t1_b_n22 rwl_1__t3_b_n22 gnd__t15_b_n22 sky130_fd_pr__nfet_01v8 L=0.15 W=0.42 nf=1 ad=0.0588 as=0.1197 pd=0.7 ps=1.41 mult=1 m=1
xm20_b_n22 rwl_2__t2_b_n22 n25__t0_b_n22 rbl_3__t2_b_n22 gnd__t27_b_n22 sky130_fd_pr__nfet_01v8 L=0.15 W=0.42 nf=1 ad=0.1197 as=0.0588 pd=1.41 ps=0.7 mult=1 m=1
xm21_b_n22 bl_0__t3_b_n22 wl_2__t0_b_n22 n22__t1_b_n22 gnd__t16_b_n22 sky130_fd_pr__nfet_01v8 L=0.15 W=0.42 nf=1 ad=0.0588 as=0.1197 pd=0.7 ps=1.41 mult=1 m=1
xm22_b_n22 n29__t0_b_n22 wl_3__t3_b_n22 bl_0__t2_b_n22 gnd__t28_b_n22 sky130_fd_pr__nfet_01v8 L=0.15 W=0.42 nf=1 ad=0.1197 as=0.0588 pd=1.41 ps=0.7 mult=1 m=1
xm23_b_n22 bl_1__t3_b_n22 wl_2__t1_b_n22 n23__t1_b_n22 gnd__t17_b_n22 sky130_fd_pr__nfet_01v8 L=0.15 W=0.42 nf=1 ad=0.0588 as=0.1197 pd=0.7 ps=1.41 mult=1 m=1
xm24_b_n22 n30__t0_b_n22 wl_3__t2_b_n22 bl_1__t1_b_n22 gnd__t29_b_n22 sky130_fd_pr__nfet_01v8 L=0.15 W=0.42 nf=1 ad=0.1197 as=0.0588 pd=1.41 ps=0.7 mult=1 m=1
xm25_b_n22 bl_2__t3_b_n22 wl_2__t2_b_n22 n24__t1_b_n22 gnd__t18_b_n22 sky130_fd_pr__nfet_01v8 L=0.15 W=0.42 nf=1 ad=0.0588 as=0.1197 pd=0.7 ps=1.41 mult=1 m=1
xm26_b_n22 n31__t0_b_n22 wl_3__t1_b_n22 bl_2__t1_b_n22 gnd__t30_b_n22 sky130_fd_pr__nfet_01v8 L=0.15 W=0.42 nf=1 ad=0.1197 as=0.0588 pd=1.41 ps=0.7 mult=1 m=1
xm27_b_n22 bl_3__t3_b_n22 wl_2__t3_b_n22 n25__t1_b_n22 gnd__t19_b_n22 sky130_fd_pr__nfet_01v8 L=0.15 W=0.42 nf=1 ad=0.0588 as=0.1197 pd=0.7 ps=1.41 mult=1 m=1
xm28_b_n22 n32__t0_b_n22 wl_3__t0_b_n22 bl_3__t0_b_n22 gnd__t31_b_n22 sky130_fd_pr__nfet_01v8 L=0.15 W=0.42 nf=1 ad=0.1197 as=0.0588 pd=1.41 ps=0.7 mult=1 m=1
xm29_b_n22 rbl_0__t1_b_n22 n29__t1_b_n22 rwl_3__t0_b_n22 gnd__t4_b_n22 sky130_fd_pr__nfet_01v8 L=0.15 W=0.42 nf=1 ad=0.1197 as=0.1197 pd=1.41 ps=1.41 mult=1 m=1
xm30_b_n22 rbl_1__t0_b_n22 n30__t1_b_n22 rwl_3__t1_b_n22 gnd__t5_b_n22 sky130_fd_pr__nfet_01v8 L=0.15 W=0.42 nf=1 ad=0.1197 as=0.1197 pd=1.41 ps=1.41 mult=1 m=1
xm31_b_n22 rbl_2__t0_b_n22 n31__t1_b_n22 rwl_3__t2_b_n22 gnd__t6_b_n22 sky130_fd_pr__nfet_01v8 L=0.15 W=0.42 nf=1 ad=0.1197 as=0.1197 pd=1.41 ps=1.41 mult=1 m=1
xm32_b_n22 rbl_3__t0_b_n22 n32__t1_b_n22 rwl_3__t3_b_n22 gnd__t7_b_n22 sky130_fd_pr__nfet_01v8 L=0.15 W=0.42 nf=1 ad=0.1197 as=0.1197 pd=1.41 ps=1.41 mult=1 m=1
r_10_t0_b_n22 n10__t0_b_n22 n10_b_n22 183.071
r_10_t1_b_n22 n10__t1_b_n22 n10_b_n22 183.071
r_17_t0_b_n22 n17__t0_b_n22 n17_b_n22 183.071
r_17_t1_b_n22 n17__t1_b_n22 n17_b_n22 183.071
r_18_t0_b_n22 n18__t0_b_n22 n18_b_n22 183.071
r_18_t1_b_n22 n18__t1_b_n22 n18_b_n22 183.071
r_19_t0_b_n22 n19__t0_b_n22 n19_b_n22 183.071
r_19_t1_b_n22 n19__t1_b_n22 n19_b_n22 183.071
r_20_t0_b_n22 n20__t0_b_n22 n20_b_n22 183.071
r_20_t1_b_n22 n20__t1_b_n22 n20_b_n22 183.071
r_22_t0_b_n22 n22__t0_b_n22 n22_b_n22 183.071
r_22_t1_b_n22 n22__t1_b_n22 n22_b_n22 183.071
r_23_t0_b_n22 n23__t0_b_n22 n23_b_n22 183.071
r_23_t1_b_n22 n23__t1_b_n22 n23_b_n22 183.071
r_24_t0_b_n22 n24__t0_b_n22 n24_b_n22 183.071
r_24_t1_b_n22 n24__t1_b_n22 n24_b_n22 183.071
r_25_t0_b_n22 n25__t0_b_n22 n25_b_n22 183.071
r_25_t1_b_n22 n25__t1_b_n22 n25_b_n22 183.071
r_29_t0_b_n22 n29__t0_b_n22 n29_b_n22 183.071
r_29_t1_b_n22 n29__t1_b_n22 n29_b_n22 183.071
r_30_t0_b_n22 n30__t0_b_n22 n30_b_n22 183.071
r_30_t1_b_n22 n30__t1_b_n22 n30_b_n22 183.071
r_31_t0_b_n22 n31__t0_b_n22 n31_b_n22 183.071
r_31_t1_b_n22 n31__t1_b_n22 n31_b_n22 183.071
r_32_t0_b_n22 n32__t0_b_n22 n32_b_n22 183.071
r_32_t1_b_n22 n32__t1_b_n22 n32_b_n22 183.071
r_7_t0_b_n22 n7__t0_b_n22 n7_b_n22 183.071
r_7_t1_b_n22 n7__t1_b_n22 n7_b_n22 183.071
r_8_t0_b_n22 n8__t0_b_n22 n8_b_n22 183.071
r_8_t1_b_n22 n8__t1_b_n22 n8_b_n22 183.071
r_9_t0_b_n22 n9__t0_b_n22 n9_b_n22 183.071
r_9_t1_b_n22 n9__t1_b_n22 n9_b_n22 183.071
rgnd_t0_b_n22 gnd__t0_b_n22 0 38.2988
rgnd_t1_b_n22 gnd__t1_b_n22 0 33.9576
rgnd_t2_b_n22 gnd__t2_b_n22 0 33.9576
rgnd_t3_b_n22 gnd__t3_b_n22 0 38.2988
rgnd_t4_b_n22 gnd__t4_b_n22 0 38.2988
rgnd_t5_b_n22 gnd__t5_b_n22 0 33.9576
rgnd_t6_b_n22 gnd__t6_b_n22 0 33.9576
rgnd_t7_b_n22 gnd__t7_b_n22 0 38.2988
rgnd_t8_b_n22 gnd__t8_b_n22 0 28.0185
rgnd_t9_b_n22 gnd__t9_b_n22 0 21.7106
rgnd_t10_b_n22 gnd__t10_b_n22 0 21.7106
rgnd_t11_b_n22 gnd__t11_b_n22 0 28.0185
rgnd_t12_b_n22 gnd__t12_b_n22 0 18.9833
rgnd_t13_b_n22 gnd__t13_b_n22 0 6.8325
rgnd_t14_b_n22 gnd__t14_b_n22 0 6.8325
rgnd_t15_b_n22 gnd__t15_b_n22 0 18.9833
rgnd_t16_b_n22 gnd__t16_b_n22 0 24.2409
rgnd_t17_b_n22 gnd__t17_b_n22 0 16.5511
rgnd_t18_b_n22 gnd__t18_b_n22 0 16.5511
rgnd_t19_b_n22 gnd__t19_b_n22 0 24.2409
rgnd_t20_b_n22 gnd__t20_b_n22 0 24.2409
rgnd_t21_b_n22 gnd__t21_b_n22 0 16.5511
rgnd_t22_b_n22 gnd__t22_b_n22 0 16.5511
rgnd_t23_b_n22 gnd__t23_b_n22 0 24.2409
rgnd_t24_b_n22 gnd__t24_b_n22 0 18.9833
rgnd_t25_b_n22 gnd__t25_b_n22 0 6.8325
rgnd_t26_b_n22 gnd__t26_b_n22 0 6.8325
rgnd_t27_b_n22 gnd__t27_b_n22 0 18.9833
rgnd_t28_b_n22 gnd__t28_b_n22 0 28.0185
rgnd_t29_b_n22 gnd__t29_b_n22 0 21.7106
rgnd_t30_b_n22 gnd__t30_b_n22 0 21.7106
rgnd_t31_b_n22 gnd__t31_b_n22 0 28.0185
rbl_0_t0_b_n22 bl_0__t0_b_n22 bl_0_b_n22 14.8304
rbl_0_t1_b_n22 bl_0__t1_b_n22 bl_0_b_n22 10.9301
rbl_0_t2_b_n22 bl_0__t2_b_n22 bl_0_b_n22 14.8304
rbl_0_t3_b_n22 bl_0__t3_b_n22 bl_0_b_n22 10.9301
rbl_1_t0_b_n22 bl_1__t0_b_n22 bl_1_b_n22 10.9301
rbl_1_t1_b_n22 bl_1__t1_b_n22 bl_1_b_n22 14.8304
rbl_1_t2_b_n22 bl_1__t2_b_n22 bl_1_b_n22 14.8304
rbl_1_t3_b_n22 bl_1__t3_b_n22 bl_1_b_n22 10.9301
rbl_2_t0_b_n22 bl_2__t0_b_n22 bl_2_b_n22 10.9301
rbl_2_t1_b_n22 bl_2__t1_b_n22 bl_2_b_n22 14.8304
rbl_2_t2_b_n22 bl_2__t2_b_n22 bl_2_b_n22 14.8304
rbl_2_t3_b_n22 bl_2__t3_b_n22 bl_2_b_n22 10.9301
rbl_3_t0_b_n22 bl_3__t0_b_n22 bl_3_b_n22 14.8304
rbl_3_t1_b_n22 bl_3__t1_b_n22 bl_3_b_n22 10.9301
rbl_3_t2_b_n22 bl_3__t2_b_n22 bl_3_b_n22 14.8304
rbl_3_t3_b_n22 bl_3__t3_b_n22 bl_3_b_n22 10.9301
rrbl_0_t0_b_n22 rbl_0__t0_b_n22 rbl_0_b_n22 36.5601
rrbl_0_t1_b_n22 rbl_0__t1_b_n22 rbl_0_b_n22 36.5601
rrbl_0_t2_b_n22 rbl_0__t2_b_n22 rbl_0_b_n22 2.99444
rrbl_0_t3_b_n22 rbl_0__t3_b_n22 rbl_0_b_n22 2.99444
rrbl_1_t0_b_n22 rbl_1__t0_b_n22 rbl_1_b_n22 36.5601
rrbl_1_t1_b_n22 rbl_1__t1_b_n22 rbl_1_b_n22 36.5601
rrbl_1_t2_b_n22 rbl_1__t2_b_n22 rbl_1_b_n22 2.99444
rrbl_1_t3_b_n22 rbl_1__t3_b_n22 rbl_1_b_n22 2.99444
rrbl_2_t0_b_n22 rbl_2__t0_b_n22 rbl_2_b_n22 36.5601
rrbl_2_t1_b_n22 rbl_2__t1_b_n22 rbl_2_b_n22 36.5601
rrbl_2_t2_b_n22 rbl_2__t2_b_n22 rbl_2_b_n22 2.99444
rrbl_2_t3_b_n22 rbl_2__t3_b_n22 rbl_2_b_n22 2.99444
rrbl_3_t0_b_n22 rbl_3__t0_b_n22 rbl_3_b_n22 36.5601
rrbl_3_t1_b_n22 rbl_3__t1_b_n22 rbl_3_b_n22 36.5601
rrbl_3_t2_b_n22 rbl_3__t2_b_n22 rbl_3_b_n22 2.99444
rrbl_3_t3_b_n22 rbl_3__t3_b_n22 rbl_3_b_n22 2.99444
rrwl_0_t0_b_n22 rwl_0__t0_b_n22 rwl_0_b_n22 38.2618
rrwl_0_t1_b_n22 rwl_0__t1_b_n22 rwl_0_b_n22 12.7539
rrwl_0_t2_b_n22 rwl_0__t2_b_n22 rwl_0_b_n22 38.2618
rrwl_0_t3_b_n22 rwl_0__t3_b_n22 rwl_0_b_n22 12.7539
rrwl_1_t0_b_n22 rwl_1__t0_b_n22 rwl_1_b_n22 38.2618
rrwl_1_t1_b_n22 rwl_1__t1_b_n22 rwl_1_b_n22 12.7539
rrwl_1_t2_b_n22 rwl_1__t2_b_n22 rwl_1_b_n22 12.7539
rrwl_1_t3_b_n22 rwl_1__t3_b_n22 rwl_1_b_n22 38.2618
rrwl_2_t0_b_n22 rwl_2__t0_b_n22 rwl_2_b_n22 12.7539
rrwl_2_t1_b_n22 rwl_2__t1_b_n22 rwl_2_b_n22 12.7539
rrwl_2_t2_b_n22 rwl_2__t2_b_n22 rwl_2_b_n22 38.2618
rrwl_2_t3_b_n22 rwl_2__t3_b_n22 rwl_2_b_n22 38.2618
rrwl_3_t0_b_n22 rwl_3__t0_b_n22 rwl_3_b_n22 38.2618
rrwl_3_t1_b_n22 rwl_3__t1_b_n22 rwl_3_b_n22 12.7539
rrwl_3_t2_b_n22 rwl_3__t2_b_n22 rwl_3_b_n22 12.7539
rrwl_3_t3_b_n22 rwl_3__t3_b_n22 rwl_3_b_n22 38.2618
rwl_0_t0_b_n22 wl_0__t0_b_n22 wl_0_b_n22 245.959
rwl_0_t1_b_n22 wl_0__t1_b_n22 wl_0_b_n22 245.959
rwl_0_t2_b_n22 wl_0__t2_b_n22 wl_0_b_n22 81.9864
rwl_0_t3_b_n22 wl_0__t3_b_n22 wl_0_b_n22 81.9864
rwl_1_t0_b_n22 wl_1__t0_b_n22 wl_1_b_n22 245.959
rwl_1_t1_b_n22 wl_1__t1_b_n22 wl_1_b_n22 81.9864
rwl_1_t2_b_n22 wl_1__t2_b_n22 wl_1_b_n22 81.9864
rwl_1_t3_b_n22 wl_1__t3_b_n22 wl_1_b_n22 245.959
rwl_2_t0_b_n22 wl_2__t0_b_n22 wl_2_b_n22 245.959
rwl_2_t1_b_n22 wl_2__t1_b_n22 wl_2_b_n22 81.9864
rwl_2_t2_b_n22 wl_2__t2_b_n22 wl_2_b_n22 81.9864
rwl_2_t3_b_n22 wl_2__t3_b_n22 wl_2_b_n22 245.959
rwl_3_t0_b_n22 wl_3__t0_b_n22 wl_3_b_n22 245.959
rwl_3_t1_b_n22 wl_3__t1_b_n22 wl_3_b_n22 81.9864
rwl_3_t2_b_n22 wl_3__t2_b_n22 wl_3_b_n22 81.9864
rwl_3_t3_b_n22 wl_3__t3_b_n22 wl_3_b_n22 245.959
c_10_b_n22 n10_b_n22 0 2.91622e-16
c_17_b_n22 n17_b_n22 0 2.91528e-16
c_18_b_n22 n18_b_n22 0 2.91528e-16
c_19_b_n22 n19_b_n22 0 2.91528e-16
c_20_b_n22 n20_b_n22 0 2.91622e-16
c_22_b_n22 n22_b_n22 0 2.91528e-16
c_23_b_n22 n23_b_n22 0 2.91528e-16
c_24_b_n22 n24_b_n22 0 2.91528e-16
c_25_b_n22 n25_b_n22 0 2.91622e-16
c_29_b_n22 n29_b_n22 0 2.91528e-16
c_30_b_n22 n30_b_n22 0 2.91528e-16
c_31_b_n22 n31_b_n22 0 2.91528e-16
c_32_b_n22 n32_b_n22 0 2.91622e-16
c_7_b_n22 n7_b_n22 0 2.91528e-16
c_8_b_n22 n8_b_n22 0 2.91528e-16
c_9_b_n22 n9_b_n22 0 2.91528e-16
cgnd_b_n22 0 0 2.48166e-15
cbl_0_b_n22 bl_0_b_n22 0 4.52661e-16
cbl_1_b_n22 bl_1_b_n22 0 4.52661e-16
cbl_2_b_n22 bl_2_b_n22 0 4.52661e-16
cbl_3_b_n22 bl_3_b_n22 0 4.52661e-16
crbl_0_b_n22 rbl_0_b_n22 0 9.14472e-16
crbl_1_b_n22 rbl_1_b_n22 0 9.14472e-16
crbl_2_b_n22 rbl_2_b_n22 0 9.14472e-16
crbl_3_b_n22 rbl_3_b_n22 0 9.17566e-16
crwl_0_b_n22 rwl_0_b_n22 0 5.19495e-16
crwl_1_b_n22 rwl_1_b_n22 0 5.11719e-16
crwl_2_b_n22 rwl_2_b_n22 0 5.11719e-16
crwl_3_b_n22 rwl_3_b_n22 0 5.19495e-16
cwl_0_b_n22 wl_0_b_n22 0 3.30388e-16
cwl_1_b_n22 wl_1_b_n22 0 3.30388e-16
cwl_2_b_n22 wl_2_b_n22 0 3.30388e-16
cwl_3_b_n22 wl_3_b_n22 0 3.30388e-16
ccc__10__9_b_n22 n10_b_n22 n9_b_n22 1.02e-17
ccc__10_bl_3_b_n22 n10_b_n22 bl_3_b_n22 1.3999e-17
ccc__10_rwl_0_b_n22 n10_b_n22 rwl_0_b_n22 4.335e-18
ccc__17__18_b_n22 n17_b_n22 n18_b_n22 1.02e-17
ccc__17_bl_0_b_n22 n17_b_n22 bl_0_b_n22 8.415e-18
ccc__17_rwl_1_b_n22 n17_b_n22 rwl_1_b_n22 1.3194e-17
ccc__18__19_b_n22 n18_b_n22 n19_b_n22 1.02e-17
ccc__18_bl_1_b_n22 n18_b_n22 bl_1_b_n22 8.415e-18
ccc__18_rwl_1_b_n22 n18_b_n22 rwl_1_b_n22 1.3194e-17
ccc__19__20_b_n22 n19_b_n22 n20_b_n22 1.02e-17
ccc__19_bl_2_b_n22 n19_b_n22 bl_2_b_n22 8.415e-18
ccc__19_rwl_1_b_n22 n19_b_n22 rwl_1_b_n22 1.3194e-17
ccc__20_bl_3_b_n22 n20_b_n22 bl_3_b_n22 8.415e-18
ccc__20_rwl_1_b_n22 n20_b_n22 rwl_1_b_n22 6.655e-18
ccc__22__23_b_n22 n22_b_n22 n23_b_n22 1.02e-17
ccc__22_bl_0_b_n22 n22_b_n22 bl_0_b_n22 8.415e-18
ccc__22_rwl_2_b_n22 n22_b_n22 rwl_2_b_n22 1.3194e-17
ccc__23__24_b_n22 n23_b_n22 n24_b_n22 1.02e-17
ccc__23_bl_1_b_n22 n23_b_n22 bl_1_b_n22 8.415e-18
ccc__23_rwl_2_b_n22 n23_b_n22 rwl_2_b_n22 1.3194e-17
ccc__24__25_b_n22 n24_b_n22 n25_b_n22 1.02e-17
ccc__24_bl_2_b_n22 n24_b_n22 bl_2_b_n22 8.415e-18
ccc__24_rwl_2_b_n22 n24_b_n22 rwl_2_b_n22 1.3194e-17
ccc__25_bl_3_b_n22 n25_b_n22 bl_3_b_n22 8.415e-18
ccc__25_rwl_2_b_n22 n25_b_n22 rwl_2_b_n22 6.655e-18
ccc__29__30_b_n22 n29_b_n22 n30_b_n22 1.02e-17
ccc__29_bl_0_b_n22 n29_b_n22 bl_0_b_n22 8.415e-18
ccc__29_rwl_3_b_n22 n29_b_n22 rwl_3_b_n22 1.3194e-17
ccc__30__31_b_n22 n30_b_n22 n31_b_n22 1.02e-17
ccc__30_bl_1_b_n22 n30_b_n22 bl_1_b_n22 8.415e-18
ccc__30_rwl_3_b_n22 n30_b_n22 rwl_3_b_n22 1.3194e-17
ccc__31__32_b_n22 n31_b_n22 n32_b_n22 1.02e-17
ccc__31_bl_2_b_n22 n31_b_n22 bl_2_b_n22 8.415e-18
ccc__31_rwl_3_b_n22 n31_b_n22 rwl_3_b_n22 1.3194e-17
ccc__32_bl_3_b_n22 n32_b_n22 bl_3_b_n22 8.415e-18
ccc__32_rwl_3_b_n22 n32_b_n22 rwl_3_b_n22 6.655e-18
ccc__7__8_b_n22 n7_b_n22 n8_b_n22 1.02e-17
ccc__7_bl_0_b_n22 n7_b_n22 bl_0_b_n22 1.3999e-17
ccc__7_rwl_0_b_n22 n7_b_n22 rwl_0_b_n22 8.961e-18
ccc__8__9_b_n22 n8_b_n22 n9_b_n22 1.02e-17
ccc__8_bl_1_b_n22 n8_b_n22 bl_1_b_n22 1.3999e-17
ccc__8_rwl_0_b_n22 n8_b_n22 rwl_0_b_n22 8.961e-18
ccc__9_bl_2_b_n22 n9_b_n22 bl_2_b_n22 1.3999e-17
ccc__9_rwl_0_b_n22 n9_b_n22 rwl_0_b_n22 8.961e-18
ccc_bl_0_rbl_0_b_n22 bl_0_b_n22 rbl_0_b_n22 1.88693e-16
ccc_bl_0_rwl_1_b_n22 bl_0_b_n22 rwl_1_b_n22 1.0093e-17
ccc_bl_0_rwl_2_b_n22 bl_0_b_n22 rwl_2_b_n22 1.0093e-17
ccc_bl_1_rbl_0_b_n22 bl_1_b_n22 rbl_0_b_n22 1.633e-16
ccc_bl_1_rbl_1_b_n22 bl_1_b_n22 rbl_1_b_n22 1.88693e-16
ccc_bl_1_rwl_1_b_n22 bl_1_b_n22 rwl_1_b_n22 1.0093e-17
ccc_bl_1_rwl_2_b_n22 bl_1_b_n22 rwl_2_b_n22 1.0093e-17
ccc_bl_2_rbl_1_b_n22 bl_2_b_n22 rbl_1_b_n22 1.633e-16
ccc_bl_2_rbl_2_b_n22 bl_2_b_n22 rbl_2_b_n22 1.88693e-16
ccc_bl_2_rwl_1_b_n22 bl_2_b_n22 rwl_1_b_n22 1.0093e-17
ccc_bl_2_rwl_2_b_n22 bl_2_b_n22 rwl_2_b_n22 1.0093e-17
ccc_bl_3_rbl_2_b_n22 bl_3_b_n22 rbl_2_b_n22 1.633e-16
ccc_bl_3_rbl_3_b_n22 bl_3_b_n22 rbl_3_b_n22 1.88693e-16
ccc_bl_3_rwl_1_b_n22 bl_3_b_n22 rwl_1_b_n22 1.0093e-17
ccc_bl_3_rwl_2_b_n22 bl_3_b_n22 rwl_2_b_n22 1.0093e-17
ccc_rbl_0_rbl_1_b_n22 rbl_0_b_n22 rbl_1_b_n22 3.432e-17
ccc_rbl_0_rwl_0_b_n22 rbl_0_b_n22 rwl_0_b_n22 4.9752e-17
ccc_rbl_0_rwl_1_b_n22 rbl_0_b_n22 rwl_1_b_n22 4.9752e-17
ccc_rbl_0_rwl_2_b_n22 rbl_0_b_n22 rwl_2_b_n22 4.9752e-17
ccc_rbl_0_rwl_3_b_n22 rbl_0_b_n22 rwl_3_b_n22 4.9752e-17
ccc_rbl_1_rbl_2_b_n22 rbl_1_b_n22 rbl_2_b_n22 3.432e-17
ccc_rbl_1_rwl_0_b_n22 rbl_1_b_n22 rwl_0_b_n22 4.9752e-17
ccc_rbl_1_rwl_1_b_n22 rbl_1_b_n22 rwl_1_b_n22 4.9752e-17
ccc_rbl_1_rwl_2_b_n22 rbl_1_b_n22 rwl_2_b_n22 4.9752e-17
ccc_rbl_1_rwl_3_b_n22 rbl_1_b_n22 rwl_3_b_n22 4.9752e-17
ccc_rbl_2_rbl_3_b_n22 rbl_2_b_n22 rbl_3_b_n22 3.432e-17
ccc_rbl_2_rwl_0_b_n22 rbl_2_b_n22 rwl_0_b_n22 4.9752e-17
ccc_rbl_2_rwl_1_b_n22 rbl_2_b_n22 rwl_1_b_n22 4.9752e-17
ccc_rbl_2_rwl_2_b_n22 rbl_2_b_n22 rwl_2_b_n22 4.9752e-17
ccc_rbl_2_rwl_3_b_n22 rbl_2_b_n22 rwl_3_b_n22 4.9752e-17
ccc_rbl_3_rwl_0_b_n22 rbl_3_b_n22 rwl_0_b_n22 3.3407e-17
ccc_rbl_3_rwl_1_b_n22 rbl_3_b_n22 rwl_1_b_n22 3.3407e-17
ccc_rbl_3_rwl_2_b_n22 rbl_3_b_n22 rwl_2_b_n22 3.3407e-17
ccc_rbl_3_rwl_3_b_n22 rbl_3_b_n22 rwl_3_b_n22 3.3407e-17
vdw_b_n22_0 wl_0_b_n22 0 dc 0
vdr_b_n22_0 rwl_0_b_n22 0 dc 0
vdw_b_n22_1 wl_1_b_n22 0 dc 0
vdr_b_n22_1 rwl_1_b_n22 0 dc 0
vdw_b_n22_2 wl_2_b_n22 0 dc 0
vdr_b_n22_2 rwl_2_b_n22 0 dc 0
vdw_b_n22_3 wl_3_b_n22 0 dc 0
vdr_b_n22_3 rwl_3_b_n22 0 dc 0
vdb_b_n22_0 bl_0_b_n22 0 dc 0
vdp_b_n22_0 rbl_0_b_n22 0 dc 0
vdb_b_n22_1 bl_1_b_n22 0 dc 0
vdp_b_n22_1 rbl_1_b_n22 0 dc 0
vdb_b_n22_2 bl_2_b_n22 0 dc 0
vdp_b_n22_2 rbl_2_b_n22 0 dc 0
vdb_b_n22_3 bl_3_b_n22 0 dc 0
vdp_b_n22_3 rbl_3_b_n22 0 dc 0
vdn_b_n22_n7 n7_b_n22 0 dc 1
vdn_b_n22_n8 n8_b_n22 0 dc 1
vdn_b_n22_n9 n9_b_n22 0 dc 1
vdn_b_n22_n10 n10_b_n22 0 dc 1
vdn_b_n22_n17 n17_b_n22 0 dc 1
vdn_b_n22_n18 n18_b_n22 0 dc 1
vdn_b_n22_n19 n19_b_n22 0 dc 1
vdn_b_n22_n20 n20_b_n22 0 dc 1
vdn_b_n22_n23 n23_b_n22 0 dc 1
vdn_b_n22_n24 n24_b_n22 0 dc 1
vdn_b_n22_n25 n25_b_n22 0 dc 1
vdn_b_n22_n29 n29_b_n22 0 dc 1
vdn_b_n22_n30 n30_b_n22 0 dc 1
vdn_b_n22_n31 n31_b_n22 0 dc 1
vdn_b_n22_n32 n32_b_n22 0 dc 1
bdr_b_n22 n22_b_n22 0 i=5e-08*min(1,max(0,(time-1e-09)/0.2n))*0.5*(1+tanh((v(n22_b_n22)-0.05)/0.01))

* ---- instance b_n23: variant b, probed storage node \$23 ----
xm1_b_n23 rwl_0__t2_b_n23 n7__t0_b_n23 rbl_0__t0_b_n23 gnd__t0_b_n23 sky130_fd_pr__nfet_01v8 L=0.15 W=0.42 nf=1 ad=0.1197 as=0.1197 pd=1.41 ps=1.41 mult=1 m=1
xm2_b_n23 rwl_0__t3_b_n23 n8__t1_b_n23 rbl_1__t1_b_n23 gnd__t1_b_n23 sky130_fd_pr__nfet_01v8 L=0.15 W=0.42 nf=1 ad=0.1197 as=0.1197 pd=1.41 ps=1.41 mult=1 m=1
xm3_b_n23 rwl_0__t1_b_n23 n9__t1_b_n23 rbl_2__t1_b_n23 gnd__t2_b_n23 sky130_fd_pr__nfet_01v8 L=0.15 W=0.42 nf=1 ad=0.1197 as=0.1197 pd=1.41 ps=1.41 mult=1 m=1
xm4_b_n23 rwl_0__t0_b_n23 n10__t1_b_n23 rbl_3__t1_b_n23 gnd__t3_b_n23 sky130_fd_pr__nfet_01v8 L=0.15 W=0.42 nf=1 ad=0.1197 as=0.1197 pd=1.41 ps=1.41 mult=1 m=1
xm5_b_n23 bl_0__t0_b_n23 wl_0__t0_b_n23 n7__t1_b_n23 gnd__t8_b_n23 sky130_fd_pr__nfet_01v8 L=0.15 W=0.42 nf=1 ad=0.0588 as=0.1197 pd=0.7 ps=1.41 mult=1 m=1
xm6_b_n23 n17__t0_b_n23 wl_1__t0_b_n23 bl_0__t1_b_n23 gnd__t20_b_n23 sky130_fd_pr__nfet_01v8 L=0.15 W=0.42 nf=1 ad=0.1197 as=0.0588 pd=1.41 ps=0.7 mult=1 m=1
xm7_b_n23 bl_1__t2_b_n23 wl_0__t3_b_n23 n8__t0_b_n23 gnd__t9_b_n23 sky130_fd_pr__nfet_01v8 L=0.15 W=0.42 nf=1 ad=0.0588 as=0.1197 pd=0.7 ps=1.41 mult=1 m=1
xm8_b_n23 n18__t0_b_n23 wl_1__t1_b_n23 bl_1__t0_b_n23 gnd__t21_b_n23 sky130_fd_pr__nfet_01v8 L=0.15 W=0.42 nf=1 ad=0.1197 as=0.0588 pd=1.41 ps=0.7 mult=1 m=1
xm9_b_n23 bl_2__t2_b_n23 wl_0__t2_b_n23 n9__t0_b_n23 gnd__t10_b_n23 sky130_fd_pr__nfet_01v8 L=0.15 W=0.42 nf=1 ad=0.0588 as=0.1197 pd=0.7 ps=1.41 mult=1 m=1
xm10_b_n23 n19__t0_b_n23 wl_1__t2_b_n23 bl_2__t0_b_n23 gnd__t22_b_n23 sky130_fd_pr__nfet_01v8 L=0.15 W=0.42 nf=1 ad=0.1197 as=0.0588 pd=1.41 ps=0.7 mult=1 m=1
xm11_b_n23 bl_3__t2_b_n23 wl_0__t1_b_n23 n10__t0_b_n23 gnd__t11_b_n23 sky130_fd_pr__nfet_01v8 L=0.15 W=0.42 nf=1 ad=0.0588 as=0.1197 pd=0.7 ps=1.41 mult=1 m=1
xm12_b_n23 n20__t0_b_n23 wl_1__t3_b_n23 bl_3__t1_b_n23 gnd__t23_b_n23 sky130_fd_pr__nfet_01v8 L=0.15 W=0.42 nf=1 ad=0.1197 as=0.0588 pd=1.41 ps=0.7 mult=1 m=1
xm13_b_n23 rbl_0__t3_b_n23 n17__t1_b_n23 rwl_1__t0_b_n23 gnd__t12_b_n23 sky130_fd_pr__nfet_01v8 L=0.15 W=0.42 nf=1 ad=0.0588 as=0.1197 pd=0.7 ps=1.41 mult=1 m=1
xm14_b_n23 rwl_2__t3_b_n23 n22__t0_b_n23 rbl_0__t2_b_n23 gnd__t24_b_n23 sky130_fd_pr__nfet_01v8 L=0.15 W=0.42 nf=1 ad=0.1197 as=0.0588 pd=1.41 ps=0.7 mult=1 m=1
xm15_b_n23 rbl_1__t3_b_n23 n18__t1_b_n23 rwl_1__t1_b_n23 gnd__t13_b_n23 sky130_fd_pr__nfet_01v8 L=0.15 W=0.42 nf=1 ad=0.0588 as=0.1197 pd=0.7 ps=1.41 mult=1 m=1
xm16_b_n23 rwl_2__t0_b_n23 n23__t0_b_n23 rbl_1__t2_b_n23 gnd__t25_b_n23 sky130_fd_pr__nfet_01v8 L=0.15 W=0.42 nf=1 ad=0.1197 as=0.0588 pd=1.41 ps=0.7 mult=1 m=1
xm17_b_n23 rbl_2__t3_b_n23 n19__t1_b_n23 rwl_1__t2_b_n23 gnd__t14_b_n23 sky130_fd_pr__nfet_01v8 L=0.15 W=0.42 nf=1 ad=0.0588 as=0.1197 pd=0.7 ps=1.41 mult=1 m=1
xm18_b_n23 rwl_2__t1_b_n23 n24__t0_b_n23 rbl_2__t2_b_n23 gnd__t26_b_n23 sky130_fd_pr__nfet_01v8 L=0.15 W=0.42 nf=1 ad=0.1197 as=0.0588 pd=1.41 ps=0.7 mult=1 m=1
xm19_b_n23 rbl_3__t3_b_n23 n20__t1_b_n23 rwl_1__t3_b_n23 gnd__t15_b_n23 sky130_fd_pr__nfet_01v8 L=0.15 W=0.42 nf=1 ad=0.0588 as=0.1197 pd=0.7 ps=1.41 mult=1 m=1
xm20_b_n23 rwl_2__t2_b_n23 n25__t0_b_n23 rbl_3__t2_b_n23 gnd__t27_b_n23 sky130_fd_pr__nfet_01v8 L=0.15 W=0.42 nf=1 ad=0.1197 as=0.0588 pd=1.41 ps=0.7 mult=1 m=1
xm21_b_n23 bl_0__t3_b_n23 wl_2__t0_b_n23 n22__t1_b_n23 gnd__t16_b_n23 sky130_fd_pr__nfet_01v8 L=0.15 W=0.42 nf=1 ad=0.0588 as=0.1197 pd=0.7 ps=1.41 mult=1 m=1
xm22_b_n23 n29__t0_b_n23 wl_3__t3_b_n23 bl_0__t2_b_n23 gnd__t28_b_n23 sky130_fd_pr__nfet_01v8 L=0.15 W=0.42 nf=1 ad=0.1197 as=0.0588 pd=1.41 ps=0.7 mult=1 m=1
xm23_b_n23 bl_1__t3_b_n23 wl_2__t1_b_n23 n23__t1_b_n23 gnd__t17_b_n23 sky130_fd_pr__nfet_01v8 L=0.15 W=0.42 nf=1 ad=0.0588 as=0.1197 pd=0.7 ps=1.41 mult=1 m=1
xm24_b_n23 n30__t0_b_n23 wl_3__t2_b_n23 bl_1__t1_b_n23 gnd__t29_b_n23 sky130_fd_pr__nfet_01v8 L=0.15 W=0.42 nf=1 ad=0.1197 as=0.0588 pd=1.41 ps=0.7 mult=1 m=1
xm25_b_n23 bl_2__t3_b_n23 wl_2__t2_b_n23 n24__t1_b_n23 gnd__t18_b_n23 sky130_fd_pr__nfet_01v8 L=0.15 W=0.42 nf=1 ad=0.0588 as=0.1197 pd=0.7 ps=1.41 mult=1 m=1
xm26_b_n23 n31__t0_b_n23 wl_3__t1_b_n23 bl_2__t1_b_n23 gnd__t30_b_n23 sky130_fd_pr__nfet_01v8 L=0.15 W=0.42 nf=1 ad=0.1197 as=0.0588 pd=1.41 ps=0.7 mult=1 m=1
xm27_b_n23 bl_3__t3_b_n23 wl_2__t3_b_n23 n25__t1_b_n23 gnd__t19_b_n23 sky130_fd_pr__nfet_01v8 L=0.15 W=0.42 nf=1 ad=0.0588 as=0.1197 pd=0.7 ps=1.41 mult=1 m=1
xm28_b_n23 n32__t0_b_n23 wl_3__t0_b_n23 bl_3__t0_b_n23 gnd__t31_b_n23 sky130_fd_pr__nfet_01v8 L=0.15 W=0.42 nf=1 ad=0.1197 as=0.0588 pd=1.41 ps=0.7 mult=1 m=1
xm29_b_n23 rbl_0__t1_b_n23 n29__t1_b_n23 rwl_3__t0_b_n23 gnd__t4_b_n23 sky130_fd_pr__nfet_01v8 L=0.15 W=0.42 nf=1 ad=0.1197 as=0.1197 pd=1.41 ps=1.41 mult=1 m=1
xm30_b_n23 rbl_1__t0_b_n23 n30__t1_b_n23 rwl_3__t1_b_n23 gnd__t5_b_n23 sky130_fd_pr__nfet_01v8 L=0.15 W=0.42 nf=1 ad=0.1197 as=0.1197 pd=1.41 ps=1.41 mult=1 m=1
xm31_b_n23 rbl_2__t0_b_n23 n31__t1_b_n23 rwl_3__t2_b_n23 gnd__t6_b_n23 sky130_fd_pr__nfet_01v8 L=0.15 W=0.42 nf=1 ad=0.1197 as=0.1197 pd=1.41 ps=1.41 mult=1 m=1
xm32_b_n23 rbl_3__t0_b_n23 n32__t1_b_n23 rwl_3__t3_b_n23 gnd__t7_b_n23 sky130_fd_pr__nfet_01v8 L=0.15 W=0.42 nf=1 ad=0.1197 as=0.1197 pd=1.41 ps=1.41 mult=1 m=1
r_10_t0_b_n23 n10__t0_b_n23 n10_b_n23 183.071
r_10_t1_b_n23 n10__t1_b_n23 n10_b_n23 183.071
r_17_t0_b_n23 n17__t0_b_n23 n17_b_n23 183.071
r_17_t1_b_n23 n17__t1_b_n23 n17_b_n23 183.071
r_18_t0_b_n23 n18__t0_b_n23 n18_b_n23 183.071
r_18_t1_b_n23 n18__t1_b_n23 n18_b_n23 183.071
r_19_t0_b_n23 n19__t0_b_n23 n19_b_n23 183.071
r_19_t1_b_n23 n19__t1_b_n23 n19_b_n23 183.071
r_20_t0_b_n23 n20__t0_b_n23 n20_b_n23 183.071
r_20_t1_b_n23 n20__t1_b_n23 n20_b_n23 183.071
r_22_t0_b_n23 n22__t0_b_n23 n22_b_n23 183.071
r_22_t1_b_n23 n22__t1_b_n23 n22_b_n23 183.071
r_23_t0_b_n23 n23__t0_b_n23 n23_b_n23 183.071
r_23_t1_b_n23 n23__t1_b_n23 n23_b_n23 183.071
r_24_t0_b_n23 n24__t0_b_n23 n24_b_n23 183.071
r_24_t1_b_n23 n24__t1_b_n23 n24_b_n23 183.071
r_25_t0_b_n23 n25__t0_b_n23 n25_b_n23 183.071
r_25_t1_b_n23 n25__t1_b_n23 n25_b_n23 183.071
r_29_t0_b_n23 n29__t0_b_n23 n29_b_n23 183.071
r_29_t1_b_n23 n29__t1_b_n23 n29_b_n23 183.071
r_30_t0_b_n23 n30__t0_b_n23 n30_b_n23 183.071
r_30_t1_b_n23 n30__t1_b_n23 n30_b_n23 183.071
r_31_t0_b_n23 n31__t0_b_n23 n31_b_n23 183.071
r_31_t1_b_n23 n31__t1_b_n23 n31_b_n23 183.071
r_32_t0_b_n23 n32__t0_b_n23 n32_b_n23 183.071
r_32_t1_b_n23 n32__t1_b_n23 n32_b_n23 183.071
r_7_t0_b_n23 n7__t0_b_n23 n7_b_n23 183.071
r_7_t1_b_n23 n7__t1_b_n23 n7_b_n23 183.071
r_8_t0_b_n23 n8__t0_b_n23 n8_b_n23 183.071
r_8_t1_b_n23 n8__t1_b_n23 n8_b_n23 183.071
r_9_t0_b_n23 n9__t0_b_n23 n9_b_n23 183.071
r_9_t1_b_n23 n9__t1_b_n23 n9_b_n23 183.071
rgnd_t0_b_n23 gnd__t0_b_n23 0 38.2988
rgnd_t1_b_n23 gnd__t1_b_n23 0 33.9576
rgnd_t2_b_n23 gnd__t2_b_n23 0 33.9576
rgnd_t3_b_n23 gnd__t3_b_n23 0 38.2988
rgnd_t4_b_n23 gnd__t4_b_n23 0 38.2988
rgnd_t5_b_n23 gnd__t5_b_n23 0 33.9576
rgnd_t6_b_n23 gnd__t6_b_n23 0 33.9576
rgnd_t7_b_n23 gnd__t7_b_n23 0 38.2988
rgnd_t8_b_n23 gnd__t8_b_n23 0 28.0185
rgnd_t9_b_n23 gnd__t9_b_n23 0 21.7106
rgnd_t10_b_n23 gnd__t10_b_n23 0 21.7106
rgnd_t11_b_n23 gnd__t11_b_n23 0 28.0185
rgnd_t12_b_n23 gnd__t12_b_n23 0 18.9833
rgnd_t13_b_n23 gnd__t13_b_n23 0 6.8325
rgnd_t14_b_n23 gnd__t14_b_n23 0 6.8325
rgnd_t15_b_n23 gnd__t15_b_n23 0 18.9833
rgnd_t16_b_n23 gnd__t16_b_n23 0 24.2409
rgnd_t17_b_n23 gnd__t17_b_n23 0 16.5511
rgnd_t18_b_n23 gnd__t18_b_n23 0 16.5511
rgnd_t19_b_n23 gnd__t19_b_n23 0 24.2409
rgnd_t20_b_n23 gnd__t20_b_n23 0 24.2409
rgnd_t21_b_n23 gnd__t21_b_n23 0 16.5511
rgnd_t22_b_n23 gnd__t22_b_n23 0 16.5511
rgnd_t23_b_n23 gnd__t23_b_n23 0 24.2409
rgnd_t24_b_n23 gnd__t24_b_n23 0 18.9833
rgnd_t25_b_n23 gnd__t25_b_n23 0 6.8325
rgnd_t26_b_n23 gnd__t26_b_n23 0 6.8325
rgnd_t27_b_n23 gnd__t27_b_n23 0 18.9833
rgnd_t28_b_n23 gnd__t28_b_n23 0 28.0185
rgnd_t29_b_n23 gnd__t29_b_n23 0 21.7106
rgnd_t30_b_n23 gnd__t30_b_n23 0 21.7106
rgnd_t31_b_n23 gnd__t31_b_n23 0 28.0185
rbl_0_t0_b_n23 bl_0__t0_b_n23 bl_0_b_n23 14.8304
rbl_0_t1_b_n23 bl_0__t1_b_n23 bl_0_b_n23 10.9301
rbl_0_t2_b_n23 bl_0__t2_b_n23 bl_0_b_n23 14.8304
rbl_0_t3_b_n23 bl_0__t3_b_n23 bl_0_b_n23 10.9301
rbl_1_t0_b_n23 bl_1__t0_b_n23 bl_1_b_n23 10.9301
rbl_1_t1_b_n23 bl_1__t1_b_n23 bl_1_b_n23 14.8304
rbl_1_t2_b_n23 bl_1__t2_b_n23 bl_1_b_n23 14.8304
rbl_1_t3_b_n23 bl_1__t3_b_n23 bl_1_b_n23 10.9301
rbl_2_t0_b_n23 bl_2__t0_b_n23 bl_2_b_n23 10.9301
rbl_2_t1_b_n23 bl_2__t1_b_n23 bl_2_b_n23 14.8304
rbl_2_t2_b_n23 bl_2__t2_b_n23 bl_2_b_n23 14.8304
rbl_2_t3_b_n23 bl_2__t3_b_n23 bl_2_b_n23 10.9301
rbl_3_t0_b_n23 bl_3__t0_b_n23 bl_3_b_n23 14.8304
rbl_3_t1_b_n23 bl_3__t1_b_n23 bl_3_b_n23 10.9301
rbl_3_t2_b_n23 bl_3__t2_b_n23 bl_3_b_n23 14.8304
rbl_3_t3_b_n23 bl_3__t3_b_n23 bl_3_b_n23 10.9301
rrbl_0_t0_b_n23 rbl_0__t0_b_n23 rbl_0_b_n23 36.5601
rrbl_0_t1_b_n23 rbl_0__t1_b_n23 rbl_0_b_n23 36.5601
rrbl_0_t2_b_n23 rbl_0__t2_b_n23 rbl_0_b_n23 2.99444
rrbl_0_t3_b_n23 rbl_0__t3_b_n23 rbl_0_b_n23 2.99444
rrbl_1_t0_b_n23 rbl_1__t0_b_n23 rbl_1_b_n23 36.5601
rrbl_1_t1_b_n23 rbl_1__t1_b_n23 rbl_1_b_n23 36.5601
rrbl_1_t2_b_n23 rbl_1__t2_b_n23 rbl_1_b_n23 2.99444
rrbl_1_t3_b_n23 rbl_1__t3_b_n23 rbl_1_b_n23 2.99444
rrbl_2_t0_b_n23 rbl_2__t0_b_n23 rbl_2_b_n23 36.5601
rrbl_2_t1_b_n23 rbl_2__t1_b_n23 rbl_2_b_n23 36.5601
rrbl_2_t2_b_n23 rbl_2__t2_b_n23 rbl_2_b_n23 2.99444
rrbl_2_t3_b_n23 rbl_2__t3_b_n23 rbl_2_b_n23 2.99444
rrbl_3_t0_b_n23 rbl_3__t0_b_n23 rbl_3_b_n23 36.5601
rrbl_3_t1_b_n23 rbl_3__t1_b_n23 rbl_3_b_n23 36.5601
rrbl_3_t2_b_n23 rbl_3__t2_b_n23 rbl_3_b_n23 2.99444
rrbl_3_t3_b_n23 rbl_3__t3_b_n23 rbl_3_b_n23 2.99444
rrwl_0_t0_b_n23 rwl_0__t0_b_n23 rwl_0_b_n23 38.2618
rrwl_0_t1_b_n23 rwl_0__t1_b_n23 rwl_0_b_n23 12.7539
rrwl_0_t2_b_n23 rwl_0__t2_b_n23 rwl_0_b_n23 38.2618
rrwl_0_t3_b_n23 rwl_0__t3_b_n23 rwl_0_b_n23 12.7539
rrwl_1_t0_b_n23 rwl_1__t0_b_n23 rwl_1_b_n23 38.2618
rrwl_1_t1_b_n23 rwl_1__t1_b_n23 rwl_1_b_n23 12.7539
rrwl_1_t2_b_n23 rwl_1__t2_b_n23 rwl_1_b_n23 12.7539
rrwl_1_t3_b_n23 rwl_1__t3_b_n23 rwl_1_b_n23 38.2618
rrwl_2_t0_b_n23 rwl_2__t0_b_n23 rwl_2_b_n23 12.7539
rrwl_2_t1_b_n23 rwl_2__t1_b_n23 rwl_2_b_n23 12.7539
rrwl_2_t2_b_n23 rwl_2__t2_b_n23 rwl_2_b_n23 38.2618
rrwl_2_t3_b_n23 rwl_2__t3_b_n23 rwl_2_b_n23 38.2618
rrwl_3_t0_b_n23 rwl_3__t0_b_n23 rwl_3_b_n23 38.2618
rrwl_3_t1_b_n23 rwl_3__t1_b_n23 rwl_3_b_n23 12.7539
rrwl_3_t2_b_n23 rwl_3__t2_b_n23 rwl_3_b_n23 12.7539
rrwl_3_t3_b_n23 rwl_3__t3_b_n23 rwl_3_b_n23 38.2618
rwl_0_t0_b_n23 wl_0__t0_b_n23 wl_0_b_n23 245.959
rwl_0_t1_b_n23 wl_0__t1_b_n23 wl_0_b_n23 245.959
rwl_0_t2_b_n23 wl_0__t2_b_n23 wl_0_b_n23 81.9864
rwl_0_t3_b_n23 wl_0__t3_b_n23 wl_0_b_n23 81.9864
rwl_1_t0_b_n23 wl_1__t0_b_n23 wl_1_b_n23 245.959
rwl_1_t1_b_n23 wl_1__t1_b_n23 wl_1_b_n23 81.9864
rwl_1_t2_b_n23 wl_1__t2_b_n23 wl_1_b_n23 81.9864
rwl_1_t3_b_n23 wl_1__t3_b_n23 wl_1_b_n23 245.959
rwl_2_t0_b_n23 wl_2__t0_b_n23 wl_2_b_n23 245.959
rwl_2_t1_b_n23 wl_2__t1_b_n23 wl_2_b_n23 81.9864
rwl_2_t2_b_n23 wl_2__t2_b_n23 wl_2_b_n23 81.9864
rwl_2_t3_b_n23 wl_2__t3_b_n23 wl_2_b_n23 245.959
rwl_3_t0_b_n23 wl_3__t0_b_n23 wl_3_b_n23 245.959
rwl_3_t1_b_n23 wl_3__t1_b_n23 wl_3_b_n23 81.9864
rwl_3_t2_b_n23 wl_3__t2_b_n23 wl_3_b_n23 81.9864
rwl_3_t3_b_n23 wl_3__t3_b_n23 wl_3_b_n23 245.959
c_10_b_n23 n10_b_n23 0 2.91622e-16
c_17_b_n23 n17_b_n23 0 2.91528e-16
c_18_b_n23 n18_b_n23 0 2.91528e-16
c_19_b_n23 n19_b_n23 0 2.91528e-16
c_20_b_n23 n20_b_n23 0 2.91622e-16
c_22_b_n23 n22_b_n23 0 2.91528e-16
c_23_b_n23 n23_b_n23 0 2.91528e-16
c_24_b_n23 n24_b_n23 0 2.91528e-16
c_25_b_n23 n25_b_n23 0 2.91622e-16
c_29_b_n23 n29_b_n23 0 2.91528e-16
c_30_b_n23 n30_b_n23 0 2.91528e-16
c_31_b_n23 n31_b_n23 0 2.91528e-16
c_32_b_n23 n32_b_n23 0 2.91622e-16
c_7_b_n23 n7_b_n23 0 2.91528e-16
c_8_b_n23 n8_b_n23 0 2.91528e-16
c_9_b_n23 n9_b_n23 0 2.91528e-16
cgnd_b_n23 0 0 2.48166e-15
cbl_0_b_n23 bl_0_b_n23 0 4.52661e-16
cbl_1_b_n23 bl_1_b_n23 0 4.52661e-16
cbl_2_b_n23 bl_2_b_n23 0 4.52661e-16
cbl_3_b_n23 bl_3_b_n23 0 4.52661e-16
crbl_0_b_n23 rbl_0_b_n23 0 9.14472e-16
crbl_1_b_n23 rbl_1_b_n23 0 9.14472e-16
crbl_2_b_n23 rbl_2_b_n23 0 9.14472e-16
crbl_3_b_n23 rbl_3_b_n23 0 9.17566e-16
crwl_0_b_n23 rwl_0_b_n23 0 5.19495e-16
crwl_1_b_n23 rwl_1_b_n23 0 5.11719e-16
crwl_2_b_n23 rwl_2_b_n23 0 5.11719e-16
crwl_3_b_n23 rwl_3_b_n23 0 5.19495e-16
cwl_0_b_n23 wl_0_b_n23 0 3.30388e-16
cwl_1_b_n23 wl_1_b_n23 0 3.30388e-16
cwl_2_b_n23 wl_2_b_n23 0 3.30388e-16
cwl_3_b_n23 wl_3_b_n23 0 3.30388e-16
ccc__10__9_b_n23 n10_b_n23 n9_b_n23 1.02e-17
ccc__10_bl_3_b_n23 n10_b_n23 bl_3_b_n23 1.3999e-17
ccc__10_rwl_0_b_n23 n10_b_n23 rwl_0_b_n23 4.335e-18
ccc__17__18_b_n23 n17_b_n23 n18_b_n23 1.02e-17
ccc__17_bl_0_b_n23 n17_b_n23 bl_0_b_n23 8.415e-18
ccc__17_rwl_1_b_n23 n17_b_n23 rwl_1_b_n23 1.3194e-17
ccc__18__19_b_n23 n18_b_n23 n19_b_n23 1.02e-17
ccc__18_bl_1_b_n23 n18_b_n23 bl_1_b_n23 8.415e-18
ccc__18_rwl_1_b_n23 n18_b_n23 rwl_1_b_n23 1.3194e-17
ccc__19__20_b_n23 n19_b_n23 n20_b_n23 1.02e-17
ccc__19_bl_2_b_n23 n19_b_n23 bl_2_b_n23 8.415e-18
ccc__19_rwl_1_b_n23 n19_b_n23 rwl_1_b_n23 1.3194e-17
ccc__20_bl_3_b_n23 n20_b_n23 bl_3_b_n23 8.415e-18
ccc__20_rwl_1_b_n23 n20_b_n23 rwl_1_b_n23 6.655e-18
ccc__22__23_b_n23 n22_b_n23 n23_b_n23 1.02e-17
ccc__22_bl_0_b_n23 n22_b_n23 bl_0_b_n23 8.415e-18
ccc__22_rwl_2_b_n23 n22_b_n23 rwl_2_b_n23 1.3194e-17
ccc__23__24_b_n23 n23_b_n23 n24_b_n23 1.02e-17
ccc__23_bl_1_b_n23 n23_b_n23 bl_1_b_n23 8.415e-18
ccc__23_rwl_2_b_n23 n23_b_n23 rwl_2_b_n23 1.3194e-17
ccc__24__25_b_n23 n24_b_n23 n25_b_n23 1.02e-17
ccc__24_bl_2_b_n23 n24_b_n23 bl_2_b_n23 8.415e-18
ccc__24_rwl_2_b_n23 n24_b_n23 rwl_2_b_n23 1.3194e-17
ccc__25_bl_3_b_n23 n25_b_n23 bl_3_b_n23 8.415e-18
ccc__25_rwl_2_b_n23 n25_b_n23 rwl_2_b_n23 6.655e-18
ccc__29__30_b_n23 n29_b_n23 n30_b_n23 1.02e-17
ccc__29_bl_0_b_n23 n29_b_n23 bl_0_b_n23 8.415e-18
ccc__29_rwl_3_b_n23 n29_b_n23 rwl_3_b_n23 1.3194e-17
ccc__30__31_b_n23 n30_b_n23 n31_b_n23 1.02e-17
ccc__30_bl_1_b_n23 n30_b_n23 bl_1_b_n23 8.415e-18
ccc__30_rwl_3_b_n23 n30_b_n23 rwl_3_b_n23 1.3194e-17
ccc__31__32_b_n23 n31_b_n23 n32_b_n23 1.02e-17
ccc__31_bl_2_b_n23 n31_b_n23 bl_2_b_n23 8.415e-18
ccc__31_rwl_3_b_n23 n31_b_n23 rwl_3_b_n23 1.3194e-17
ccc__32_bl_3_b_n23 n32_b_n23 bl_3_b_n23 8.415e-18
ccc__32_rwl_3_b_n23 n32_b_n23 rwl_3_b_n23 6.655e-18
ccc__7__8_b_n23 n7_b_n23 n8_b_n23 1.02e-17
ccc__7_bl_0_b_n23 n7_b_n23 bl_0_b_n23 1.3999e-17
ccc__7_rwl_0_b_n23 n7_b_n23 rwl_0_b_n23 8.961e-18
ccc__8__9_b_n23 n8_b_n23 n9_b_n23 1.02e-17
ccc__8_bl_1_b_n23 n8_b_n23 bl_1_b_n23 1.3999e-17
ccc__8_rwl_0_b_n23 n8_b_n23 rwl_0_b_n23 8.961e-18
ccc__9_bl_2_b_n23 n9_b_n23 bl_2_b_n23 1.3999e-17
ccc__9_rwl_0_b_n23 n9_b_n23 rwl_0_b_n23 8.961e-18
ccc_bl_0_rbl_0_b_n23 bl_0_b_n23 rbl_0_b_n23 1.88693e-16
ccc_bl_0_rwl_1_b_n23 bl_0_b_n23 rwl_1_b_n23 1.0093e-17
ccc_bl_0_rwl_2_b_n23 bl_0_b_n23 rwl_2_b_n23 1.0093e-17
ccc_bl_1_rbl_0_b_n23 bl_1_b_n23 rbl_0_b_n23 1.633e-16
ccc_bl_1_rbl_1_b_n23 bl_1_b_n23 rbl_1_b_n23 1.88693e-16
ccc_bl_1_rwl_1_b_n23 bl_1_b_n23 rwl_1_b_n23 1.0093e-17
ccc_bl_1_rwl_2_b_n23 bl_1_b_n23 rwl_2_b_n23 1.0093e-17
ccc_bl_2_rbl_1_b_n23 bl_2_b_n23 rbl_1_b_n23 1.633e-16
ccc_bl_2_rbl_2_b_n23 bl_2_b_n23 rbl_2_b_n23 1.88693e-16
ccc_bl_2_rwl_1_b_n23 bl_2_b_n23 rwl_1_b_n23 1.0093e-17
ccc_bl_2_rwl_2_b_n23 bl_2_b_n23 rwl_2_b_n23 1.0093e-17
ccc_bl_3_rbl_2_b_n23 bl_3_b_n23 rbl_2_b_n23 1.633e-16
ccc_bl_3_rbl_3_b_n23 bl_3_b_n23 rbl_3_b_n23 1.88693e-16
ccc_bl_3_rwl_1_b_n23 bl_3_b_n23 rwl_1_b_n23 1.0093e-17
ccc_bl_3_rwl_2_b_n23 bl_3_b_n23 rwl_2_b_n23 1.0093e-17
ccc_rbl_0_rbl_1_b_n23 rbl_0_b_n23 rbl_1_b_n23 3.432e-17
ccc_rbl_0_rwl_0_b_n23 rbl_0_b_n23 rwl_0_b_n23 4.9752e-17
ccc_rbl_0_rwl_1_b_n23 rbl_0_b_n23 rwl_1_b_n23 4.9752e-17
ccc_rbl_0_rwl_2_b_n23 rbl_0_b_n23 rwl_2_b_n23 4.9752e-17
ccc_rbl_0_rwl_3_b_n23 rbl_0_b_n23 rwl_3_b_n23 4.9752e-17
ccc_rbl_1_rbl_2_b_n23 rbl_1_b_n23 rbl_2_b_n23 3.432e-17
ccc_rbl_1_rwl_0_b_n23 rbl_1_b_n23 rwl_0_b_n23 4.9752e-17
ccc_rbl_1_rwl_1_b_n23 rbl_1_b_n23 rwl_1_b_n23 4.9752e-17
ccc_rbl_1_rwl_2_b_n23 rbl_1_b_n23 rwl_2_b_n23 4.9752e-17
ccc_rbl_1_rwl_3_b_n23 rbl_1_b_n23 rwl_3_b_n23 4.9752e-17
ccc_rbl_2_rbl_3_b_n23 rbl_2_b_n23 rbl_3_b_n23 3.432e-17
ccc_rbl_2_rwl_0_b_n23 rbl_2_b_n23 rwl_0_b_n23 4.9752e-17
ccc_rbl_2_rwl_1_b_n23 rbl_2_b_n23 rwl_1_b_n23 4.9752e-17
ccc_rbl_2_rwl_2_b_n23 rbl_2_b_n23 rwl_2_b_n23 4.9752e-17
ccc_rbl_2_rwl_3_b_n23 rbl_2_b_n23 rwl_3_b_n23 4.9752e-17
ccc_rbl_3_rwl_0_b_n23 rbl_3_b_n23 rwl_0_b_n23 3.3407e-17
ccc_rbl_3_rwl_1_b_n23 rbl_3_b_n23 rwl_1_b_n23 3.3407e-17
ccc_rbl_3_rwl_2_b_n23 rbl_3_b_n23 rwl_2_b_n23 3.3407e-17
ccc_rbl_3_rwl_3_b_n23 rbl_3_b_n23 rwl_3_b_n23 3.3407e-17
vdw_b_n23_0 wl_0_b_n23 0 dc 0
vdr_b_n23_0 rwl_0_b_n23 0 dc 0
vdw_b_n23_1 wl_1_b_n23 0 dc 0
vdr_b_n23_1 rwl_1_b_n23 0 dc 0
vdw_b_n23_2 wl_2_b_n23 0 dc 0
vdr_b_n23_2 rwl_2_b_n23 0 dc 0
vdw_b_n23_3 wl_3_b_n23 0 dc 0
vdr_b_n23_3 rwl_3_b_n23 0 dc 0
vdb_b_n23_0 bl_0_b_n23 0 dc 0
vdp_b_n23_0 rbl_0_b_n23 0 dc 0
vdb_b_n23_1 bl_1_b_n23 0 dc 0
vdp_b_n23_1 rbl_1_b_n23 0 dc 0
vdb_b_n23_2 bl_2_b_n23 0 dc 0
vdp_b_n23_2 rbl_2_b_n23 0 dc 0
vdb_b_n23_3 bl_3_b_n23 0 dc 0
vdp_b_n23_3 rbl_3_b_n23 0 dc 0
vdn_b_n23_n7 n7_b_n23 0 dc 1
vdn_b_n23_n8 n8_b_n23 0 dc 1
vdn_b_n23_n9 n9_b_n23 0 dc 1
vdn_b_n23_n10 n10_b_n23 0 dc 1
vdn_b_n23_n17 n17_b_n23 0 dc 1
vdn_b_n23_n18 n18_b_n23 0 dc 1
vdn_b_n23_n19 n19_b_n23 0 dc 1
vdn_b_n23_n20 n20_b_n23 0 dc 1
vdn_b_n23_n22 n22_b_n23 0 dc 1
vdn_b_n23_n24 n24_b_n23 0 dc 1
vdn_b_n23_n25 n25_b_n23 0 dc 1
vdn_b_n23_n29 n29_b_n23 0 dc 1
vdn_b_n23_n30 n30_b_n23 0 dc 1
vdn_b_n23_n31 n31_b_n23 0 dc 1
vdn_b_n23_n32 n32_b_n23 0 dc 1
bdr_b_n23 n23_b_n23 0 i=5e-08*min(1,max(0,(time-1e-09)/0.2n))*0.5*(1+tanh((v(n23_b_n23)-0.05)/0.01))

* ---- instance b_n24: variant b, probed storage node \$24 ----
xm1_b_n24 rwl_0__t2_b_n24 n7__t0_b_n24 rbl_0__t0_b_n24 gnd__t0_b_n24 sky130_fd_pr__nfet_01v8 L=0.15 W=0.42 nf=1 ad=0.1197 as=0.1197 pd=1.41 ps=1.41 mult=1 m=1
xm2_b_n24 rwl_0__t3_b_n24 n8__t1_b_n24 rbl_1__t1_b_n24 gnd__t1_b_n24 sky130_fd_pr__nfet_01v8 L=0.15 W=0.42 nf=1 ad=0.1197 as=0.1197 pd=1.41 ps=1.41 mult=1 m=1
xm3_b_n24 rwl_0__t1_b_n24 n9__t1_b_n24 rbl_2__t1_b_n24 gnd__t2_b_n24 sky130_fd_pr__nfet_01v8 L=0.15 W=0.42 nf=1 ad=0.1197 as=0.1197 pd=1.41 ps=1.41 mult=1 m=1
xm4_b_n24 rwl_0__t0_b_n24 n10__t1_b_n24 rbl_3__t1_b_n24 gnd__t3_b_n24 sky130_fd_pr__nfet_01v8 L=0.15 W=0.42 nf=1 ad=0.1197 as=0.1197 pd=1.41 ps=1.41 mult=1 m=1
xm5_b_n24 bl_0__t0_b_n24 wl_0__t0_b_n24 n7__t1_b_n24 gnd__t8_b_n24 sky130_fd_pr__nfet_01v8 L=0.15 W=0.42 nf=1 ad=0.0588 as=0.1197 pd=0.7 ps=1.41 mult=1 m=1
xm6_b_n24 n17__t0_b_n24 wl_1__t0_b_n24 bl_0__t1_b_n24 gnd__t20_b_n24 sky130_fd_pr__nfet_01v8 L=0.15 W=0.42 nf=1 ad=0.1197 as=0.0588 pd=1.41 ps=0.7 mult=1 m=1
xm7_b_n24 bl_1__t2_b_n24 wl_0__t3_b_n24 n8__t0_b_n24 gnd__t9_b_n24 sky130_fd_pr__nfet_01v8 L=0.15 W=0.42 nf=1 ad=0.0588 as=0.1197 pd=0.7 ps=1.41 mult=1 m=1
xm8_b_n24 n18__t0_b_n24 wl_1__t1_b_n24 bl_1__t0_b_n24 gnd__t21_b_n24 sky130_fd_pr__nfet_01v8 L=0.15 W=0.42 nf=1 ad=0.1197 as=0.0588 pd=1.41 ps=0.7 mult=1 m=1
xm9_b_n24 bl_2__t2_b_n24 wl_0__t2_b_n24 n9__t0_b_n24 gnd__t10_b_n24 sky130_fd_pr__nfet_01v8 L=0.15 W=0.42 nf=1 ad=0.0588 as=0.1197 pd=0.7 ps=1.41 mult=1 m=1
xm10_b_n24 n19__t0_b_n24 wl_1__t2_b_n24 bl_2__t0_b_n24 gnd__t22_b_n24 sky130_fd_pr__nfet_01v8 L=0.15 W=0.42 nf=1 ad=0.1197 as=0.0588 pd=1.41 ps=0.7 mult=1 m=1
xm11_b_n24 bl_3__t2_b_n24 wl_0__t1_b_n24 n10__t0_b_n24 gnd__t11_b_n24 sky130_fd_pr__nfet_01v8 L=0.15 W=0.42 nf=1 ad=0.0588 as=0.1197 pd=0.7 ps=1.41 mult=1 m=1
xm12_b_n24 n20__t0_b_n24 wl_1__t3_b_n24 bl_3__t1_b_n24 gnd__t23_b_n24 sky130_fd_pr__nfet_01v8 L=0.15 W=0.42 nf=1 ad=0.1197 as=0.0588 pd=1.41 ps=0.7 mult=1 m=1
xm13_b_n24 rbl_0__t3_b_n24 n17__t1_b_n24 rwl_1__t0_b_n24 gnd__t12_b_n24 sky130_fd_pr__nfet_01v8 L=0.15 W=0.42 nf=1 ad=0.0588 as=0.1197 pd=0.7 ps=1.41 mult=1 m=1
xm14_b_n24 rwl_2__t3_b_n24 n22__t0_b_n24 rbl_0__t2_b_n24 gnd__t24_b_n24 sky130_fd_pr__nfet_01v8 L=0.15 W=0.42 nf=1 ad=0.1197 as=0.0588 pd=1.41 ps=0.7 mult=1 m=1
xm15_b_n24 rbl_1__t3_b_n24 n18__t1_b_n24 rwl_1__t1_b_n24 gnd__t13_b_n24 sky130_fd_pr__nfet_01v8 L=0.15 W=0.42 nf=1 ad=0.0588 as=0.1197 pd=0.7 ps=1.41 mult=1 m=1
xm16_b_n24 rwl_2__t0_b_n24 n23__t0_b_n24 rbl_1__t2_b_n24 gnd__t25_b_n24 sky130_fd_pr__nfet_01v8 L=0.15 W=0.42 nf=1 ad=0.1197 as=0.0588 pd=1.41 ps=0.7 mult=1 m=1
xm17_b_n24 rbl_2__t3_b_n24 n19__t1_b_n24 rwl_1__t2_b_n24 gnd__t14_b_n24 sky130_fd_pr__nfet_01v8 L=0.15 W=0.42 nf=1 ad=0.0588 as=0.1197 pd=0.7 ps=1.41 mult=1 m=1
xm18_b_n24 rwl_2__t1_b_n24 n24__t0_b_n24 rbl_2__t2_b_n24 gnd__t26_b_n24 sky130_fd_pr__nfet_01v8 L=0.15 W=0.42 nf=1 ad=0.1197 as=0.0588 pd=1.41 ps=0.7 mult=1 m=1
xm19_b_n24 rbl_3__t3_b_n24 n20__t1_b_n24 rwl_1__t3_b_n24 gnd__t15_b_n24 sky130_fd_pr__nfet_01v8 L=0.15 W=0.42 nf=1 ad=0.0588 as=0.1197 pd=0.7 ps=1.41 mult=1 m=1
xm20_b_n24 rwl_2__t2_b_n24 n25__t0_b_n24 rbl_3__t2_b_n24 gnd__t27_b_n24 sky130_fd_pr__nfet_01v8 L=0.15 W=0.42 nf=1 ad=0.1197 as=0.0588 pd=1.41 ps=0.7 mult=1 m=1
xm21_b_n24 bl_0__t3_b_n24 wl_2__t0_b_n24 n22__t1_b_n24 gnd__t16_b_n24 sky130_fd_pr__nfet_01v8 L=0.15 W=0.42 nf=1 ad=0.0588 as=0.1197 pd=0.7 ps=1.41 mult=1 m=1
xm22_b_n24 n29__t0_b_n24 wl_3__t3_b_n24 bl_0__t2_b_n24 gnd__t28_b_n24 sky130_fd_pr__nfet_01v8 L=0.15 W=0.42 nf=1 ad=0.1197 as=0.0588 pd=1.41 ps=0.7 mult=1 m=1
xm23_b_n24 bl_1__t3_b_n24 wl_2__t1_b_n24 n23__t1_b_n24 gnd__t17_b_n24 sky130_fd_pr__nfet_01v8 L=0.15 W=0.42 nf=1 ad=0.0588 as=0.1197 pd=0.7 ps=1.41 mult=1 m=1
xm24_b_n24 n30__t0_b_n24 wl_3__t2_b_n24 bl_1__t1_b_n24 gnd__t29_b_n24 sky130_fd_pr__nfet_01v8 L=0.15 W=0.42 nf=1 ad=0.1197 as=0.0588 pd=1.41 ps=0.7 mult=1 m=1
xm25_b_n24 bl_2__t3_b_n24 wl_2__t2_b_n24 n24__t1_b_n24 gnd__t18_b_n24 sky130_fd_pr__nfet_01v8 L=0.15 W=0.42 nf=1 ad=0.0588 as=0.1197 pd=0.7 ps=1.41 mult=1 m=1
xm26_b_n24 n31__t0_b_n24 wl_3__t1_b_n24 bl_2__t1_b_n24 gnd__t30_b_n24 sky130_fd_pr__nfet_01v8 L=0.15 W=0.42 nf=1 ad=0.1197 as=0.0588 pd=1.41 ps=0.7 mult=1 m=1
xm27_b_n24 bl_3__t3_b_n24 wl_2__t3_b_n24 n25__t1_b_n24 gnd__t19_b_n24 sky130_fd_pr__nfet_01v8 L=0.15 W=0.42 nf=1 ad=0.0588 as=0.1197 pd=0.7 ps=1.41 mult=1 m=1
xm28_b_n24 n32__t0_b_n24 wl_3__t0_b_n24 bl_3__t0_b_n24 gnd__t31_b_n24 sky130_fd_pr__nfet_01v8 L=0.15 W=0.42 nf=1 ad=0.1197 as=0.0588 pd=1.41 ps=0.7 mult=1 m=1
xm29_b_n24 rbl_0__t1_b_n24 n29__t1_b_n24 rwl_3__t0_b_n24 gnd__t4_b_n24 sky130_fd_pr__nfet_01v8 L=0.15 W=0.42 nf=1 ad=0.1197 as=0.1197 pd=1.41 ps=1.41 mult=1 m=1
xm30_b_n24 rbl_1__t0_b_n24 n30__t1_b_n24 rwl_3__t1_b_n24 gnd__t5_b_n24 sky130_fd_pr__nfet_01v8 L=0.15 W=0.42 nf=1 ad=0.1197 as=0.1197 pd=1.41 ps=1.41 mult=1 m=1
xm31_b_n24 rbl_2__t0_b_n24 n31__t1_b_n24 rwl_3__t2_b_n24 gnd__t6_b_n24 sky130_fd_pr__nfet_01v8 L=0.15 W=0.42 nf=1 ad=0.1197 as=0.1197 pd=1.41 ps=1.41 mult=1 m=1
xm32_b_n24 rbl_3__t0_b_n24 n32__t1_b_n24 rwl_3__t3_b_n24 gnd__t7_b_n24 sky130_fd_pr__nfet_01v8 L=0.15 W=0.42 nf=1 ad=0.1197 as=0.1197 pd=1.41 ps=1.41 mult=1 m=1
r_10_t0_b_n24 n10__t0_b_n24 n10_b_n24 183.071
r_10_t1_b_n24 n10__t1_b_n24 n10_b_n24 183.071
r_17_t0_b_n24 n17__t0_b_n24 n17_b_n24 183.071
r_17_t1_b_n24 n17__t1_b_n24 n17_b_n24 183.071
r_18_t0_b_n24 n18__t0_b_n24 n18_b_n24 183.071
r_18_t1_b_n24 n18__t1_b_n24 n18_b_n24 183.071
r_19_t0_b_n24 n19__t0_b_n24 n19_b_n24 183.071
r_19_t1_b_n24 n19__t1_b_n24 n19_b_n24 183.071
r_20_t0_b_n24 n20__t0_b_n24 n20_b_n24 183.071
r_20_t1_b_n24 n20__t1_b_n24 n20_b_n24 183.071
r_22_t0_b_n24 n22__t0_b_n24 n22_b_n24 183.071
r_22_t1_b_n24 n22__t1_b_n24 n22_b_n24 183.071
r_23_t0_b_n24 n23__t0_b_n24 n23_b_n24 183.071
r_23_t1_b_n24 n23__t1_b_n24 n23_b_n24 183.071
r_24_t0_b_n24 n24__t0_b_n24 n24_b_n24 183.071
r_24_t1_b_n24 n24__t1_b_n24 n24_b_n24 183.071
r_25_t0_b_n24 n25__t0_b_n24 n25_b_n24 183.071
r_25_t1_b_n24 n25__t1_b_n24 n25_b_n24 183.071
r_29_t0_b_n24 n29__t0_b_n24 n29_b_n24 183.071
r_29_t1_b_n24 n29__t1_b_n24 n29_b_n24 183.071
r_30_t0_b_n24 n30__t0_b_n24 n30_b_n24 183.071
r_30_t1_b_n24 n30__t1_b_n24 n30_b_n24 183.071
r_31_t0_b_n24 n31__t0_b_n24 n31_b_n24 183.071
r_31_t1_b_n24 n31__t1_b_n24 n31_b_n24 183.071
r_32_t0_b_n24 n32__t0_b_n24 n32_b_n24 183.071
r_32_t1_b_n24 n32__t1_b_n24 n32_b_n24 183.071
r_7_t0_b_n24 n7__t0_b_n24 n7_b_n24 183.071
r_7_t1_b_n24 n7__t1_b_n24 n7_b_n24 183.071
r_8_t0_b_n24 n8__t0_b_n24 n8_b_n24 183.071
r_8_t1_b_n24 n8__t1_b_n24 n8_b_n24 183.071
r_9_t0_b_n24 n9__t0_b_n24 n9_b_n24 183.071
r_9_t1_b_n24 n9__t1_b_n24 n9_b_n24 183.071
rgnd_t0_b_n24 gnd__t0_b_n24 0 38.2988
rgnd_t1_b_n24 gnd__t1_b_n24 0 33.9576
rgnd_t2_b_n24 gnd__t2_b_n24 0 33.9576
rgnd_t3_b_n24 gnd__t3_b_n24 0 38.2988
rgnd_t4_b_n24 gnd__t4_b_n24 0 38.2988
rgnd_t5_b_n24 gnd__t5_b_n24 0 33.9576
rgnd_t6_b_n24 gnd__t6_b_n24 0 33.9576
rgnd_t7_b_n24 gnd__t7_b_n24 0 38.2988
rgnd_t8_b_n24 gnd__t8_b_n24 0 28.0185
rgnd_t9_b_n24 gnd__t9_b_n24 0 21.7106
rgnd_t10_b_n24 gnd__t10_b_n24 0 21.7106
rgnd_t11_b_n24 gnd__t11_b_n24 0 28.0185
rgnd_t12_b_n24 gnd__t12_b_n24 0 18.9833
rgnd_t13_b_n24 gnd__t13_b_n24 0 6.8325
rgnd_t14_b_n24 gnd__t14_b_n24 0 6.8325
rgnd_t15_b_n24 gnd__t15_b_n24 0 18.9833
rgnd_t16_b_n24 gnd__t16_b_n24 0 24.2409
rgnd_t17_b_n24 gnd__t17_b_n24 0 16.5511
rgnd_t18_b_n24 gnd__t18_b_n24 0 16.5511
rgnd_t19_b_n24 gnd__t19_b_n24 0 24.2409
rgnd_t20_b_n24 gnd__t20_b_n24 0 24.2409
rgnd_t21_b_n24 gnd__t21_b_n24 0 16.5511
rgnd_t22_b_n24 gnd__t22_b_n24 0 16.5511
rgnd_t23_b_n24 gnd__t23_b_n24 0 24.2409
rgnd_t24_b_n24 gnd__t24_b_n24 0 18.9833
rgnd_t25_b_n24 gnd__t25_b_n24 0 6.8325
rgnd_t26_b_n24 gnd__t26_b_n24 0 6.8325
rgnd_t27_b_n24 gnd__t27_b_n24 0 18.9833
rgnd_t28_b_n24 gnd__t28_b_n24 0 28.0185
rgnd_t29_b_n24 gnd__t29_b_n24 0 21.7106
rgnd_t30_b_n24 gnd__t30_b_n24 0 21.7106
rgnd_t31_b_n24 gnd__t31_b_n24 0 28.0185
rbl_0_t0_b_n24 bl_0__t0_b_n24 bl_0_b_n24 14.8304
rbl_0_t1_b_n24 bl_0__t1_b_n24 bl_0_b_n24 10.9301
rbl_0_t2_b_n24 bl_0__t2_b_n24 bl_0_b_n24 14.8304
rbl_0_t3_b_n24 bl_0__t3_b_n24 bl_0_b_n24 10.9301
rbl_1_t0_b_n24 bl_1__t0_b_n24 bl_1_b_n24 10.9301
rbl_1_t1_b_n24 bl_1__t1_b_n24 bl_1_b_n24 14.8304
rbl_1_t2_b_n24 bl_1__t2_b_n24 bl_1_b_n24 14.8304
rbl_1_t3_b_n24 bl_1__t3_b_n24 bl_1_b_n24 10.9301
rbl_2_t0_b_n24 bl_2__t0_b_n24 bl_2_b_n24 10.9301
rbl_2_t1_b_n24 bl_2__t1_b_n24 bl_2_b_n24 14.8304
rbl_2_t2_b_n24 bl_2__t2_b_n24 bl_2_b_n24 14.8304
rbl_2_t3_b_n24 bl_2__t3_b_n24 bl_2_b_n24 10.9301
rbl_3_t0_b_n24 bl_3__t0_b_n24 bl_3_b_n24 14.8304
rbl_3_t1_b_n24 bl_3__t1_b_n24 bl_3_b_n24 10.9301
rbl_3_t2_b_n24 bl_3__t2_b_n24 bl_3_b_n24 14.8304
rbl_3_t3_b_n24 bl_3__t3_b_n24 bl_3_b_n24 10.9301
rrbl_0_t0_b_n24 rbl_0__t0_b_n24 rbl_0_b_n24 36.5601
rrbl_0_t1_b_n24 rbl_0__t1_b_n24 rbl_0_b_n24 36.5601
rrbl_0_t2_b_n24 rbl_0__t2_b_n24 rbl_0_b_n24 2.99444
rrbl_0_t3_b_n24 rbl_0__t3_b_n24 rbl_0_b_n24 2.99444
rrbl_1_t0_b_n24 rbl_1__t0_b_n24 rbl_1_b_n24 36.5601
rrbl_1_t1_b_n24 rbl_1__t1_b_n24 rbl_1_b_n24 36.5601
rrbl_1_t2_b_n24 rbl_1__t2_b_n24 rbl_1_b_n24 2.99444
rrbl_1_t3_b_n24 rbl_1__t3_b_n24 rbl_1_b_n24 2.99444
rrbl_2_t0_b_n24 rbl_2__t0_b_n24 rbl_2_b_n24 36.5601
rrbl_2_t1_b_n24 rbl_2__t1_b_n24 rbl_2_b_n24 36.5601
rrbl_2_t2_b_n24 rbl_2__t2_b_n24 rbl_2_b_n24 2.99444
rrbl_2_t3_b_n24 rbl_2__t3_b_n24 rbl_2_b_n24 2.99444
rrbl_3_t0_b_n24 rbl_3__t0_b_n24 rbl_3_b_n24 36.5601
rrbl_3_t1_b_n24 rbl_3__t1_b_n24 rbl_3_b_n24 36.5601
rrbl_3_t2_b_n24 rbl_3__t2_b_n24 rbl_3_b_n24 2.99444
rrbl_3_t3_b_n24 rbl_3__t3_b_n24 rbl_3_b_n24 2.99444
rrwl_0_t0_b_n24 rwl_0__t0_b_n24 rwl_0_b_n24 38.2618
rrwl_0_t1_b_n24 rwl_0__t1_b_n24 rwl_0_b_n24 12.7539
rrwl_0_t2_b_n24 rwl_0__t2_b_n24 rwl_0_b_n24 38.2618
rrwl_0_t3_b_n24 rwl_0__t3_b_n24 rwl_0_b_n24 12.7539
rrwl_1_t0_b_n24 rwl_1__t0_b_n24 rwl_1_b_n24 38.2618
rrwl_1_t1_b_n24 rwl_1__t1_b_n24 rwl_1_b_n24 12.7539
rrwl_1_t2_b_n24 rwl_1__t2_b_n24 rwl_1_b_n24 12.7539
rrwl_1_t3_b_n24 rwl_1__t3_b_n24 rwl_1_b_n24 38.2618
rrwl_2_t0_b_n24 rwl_2__t0_b_n24 rwl_2_b_n24 12.7539
rrwl_2_t1_b_n24 rwl_2__t1_b_n24 rwl_2_b_n24 12.7539
rrwl_2_t2_b_n24 rwl_2__t2_b_n24 rwl_2_b_n24 38.2618
rrwl_2_t3_b_n24 rwl_2__t3_b_n24 rwl_2_b_n24 38.2618
rrwl_3_t0_b_n24 rwl_3__t0_b_n24 rwl_3_b_n24 38.2618
rrwl_3_t1_b_n24 rwl_3__t1_b_n24 rwl_3_b_n24 12.7539
rrwl_3_t2_b_n24 rwl_3__t2_b_n24 rwl_3_b_n24 12.7539
rrwl_3_t3_b_n24 rwl_3__t3_b_n24 rwl_3_b_n24 38.2618
rwl_0_t0_b_n24 wl_0__t0_b_n24 wl_0_b_n24 245.959
rwl_0_t1_b_n24 wl_0__t1_b_n24 wl_0_b_n24 245.959
rwl_0_t2_b_n24 wl_0__t2_b_n24 wl_0_b_n24 81.9864
rwl_0_t3_b_n24 wl_0__t3_b_n24 wl_0_b_n24 81.9864
rwl_1_t0_b_n24 wl_1__t0_b_n24 wl_1_b_n24 245.959
rwl_1_t1_b_n24 wl_1__t1_b_n24 wl_1_b_n24 81.9864
rwl_1_t2_b_n24 wl_1__t2_b_n24 wl_1_b_n24 81.9864
rwl_1_t3_b_n24 wl_1__t3_b_n24 wl_1_b_n24 245.959
rwl_2_t0_b_n24 wl_2__t0_b_n24 wl_2_b_n24 245.959
rwl_2_t1_b_n24 wl_2__t1_b_n24 wl_2_b_n24 81.9864
rwl_2_t2_b_n24 wl_2__t2_b_n24 wl_2_b_n24 81.9864
rwl_2_t3_b_n24 wl_2__t3_b_n24 wl_2_b_n24 245.959
rwl_3_t0_b_n24 wl_3__t0_b_n24 wl_3_b_n24 245.959
rwl_3_t1_b_n24 wl_3__t1_b_n24 wl_3_b_n24 81.9864
rwl_3_t2_b_n24 wl_3__t2_b_n24 wl_3_b_n24 81.9864
rwl_3_t3_b_n24 wl_3__t3_b_n24 wl_3_b_n24 245.959
c_10_b_n24 n10_b_n24 0 2.91622e-16
c_17_b_n24 n17_b_n24 0 2.91528e-16
c_18_b_n24 n18_b_n24 0 2.91528e-16
c_19_b_n24 n19_b_n24 0 2.91528e-16
c_20_b_n24 n20_b_n24 0 2.91622e-16
c_22_b_n24 n22_b_n24 0 2.91528e-16
c_23_b_n24 n23_b_n24 0 2.91528e-16
c_24_b_n24 n24_b_n24 0 2.91528e-16
c_25_b_n24 n25_b_n24 0 2.91622e-16
c_29_b_n24 n29_b_n24 0 2.91528e-16
c_30_b_n24 n30_b_n24 0 2.91528e-16
c_31_b_n24 n31_b_n24 0 2.91528e-16
c_32_b_n24 n32_b_n24 0 2.91622e-16
c_7_b_n24 n7_b_n24 0 2.91528e-16
c_8_b_n24 n8_b_n24 0 2.91528e-16
c_9_b_n24 n9_b_n24 0 2.91528e-16
cgnd_b_n24 0 0 2.48166e-15
cbl_0_b_n24 bl_0_b_n24 0 4.52661e-16
cbl_1_b_n24 bl_1_b_n24 0 4.52661e-16
cbl_2_b_n24 bl_2_b_n24 0 4.52661e-16
cbl_3_b_n24 bl_3_b_n24 0 4.52661e-16
crbl_0_b_n24 rbl_0_b_n24 0 9.14472e-16
crbl_1_b_n24 rbl_1_b_n24 0 9.14472e-16
crbl_2_b_n24 rbl_2_b_n24 0 9.14472e-16
crbl_3_b_n24 rbl_3_b_n24 0 9.17566e-16
crwl_0_b_n24 rwl_0_b_n24 0 5.19495e-16
crwl_1_b_n24 rwl_1_b_n24 0 5.11719e-16
crwl_2_b_n24 rwl_2_b_n24 0 5.11719e-16
crwl_3_b_n24 rwl_3_b_n24 0 5.19495e-16
cwl_0_b_n24 wl_0_b_n24 0 3.30388e-16
cwl_1_b_n24 wl_1_b_n24 0 3.30388e-16
cwl_2_b_n24 wl_2_b_n24 0 3.30388e-16
cwl_3_b_n24 wl_3_b_n24 0 3.30388e-16
ccc__10__9_b_n24 n10_b_n24 n9_b_n24 1.02e-17
ccc__10_bl_3_b_n24 n10_b_n24 bl_3_b_n24 1.3999e-17
ccc__10_rwl_0_b_n24 n10_b_n24 rwl_0_b_n24 4.335e-18
ccc__17__18_b_n24 n17_b_n24 n18_b_n24 1.02e-17
ccc__17_bl_0_b_n24 n17_b_n24 bl_0_b_n24 8.415e-18
ccc__17_rwl_1_b_n24 n17_b_n24 rwl_1_b_n24 1.3194e-17
ccc__18__19_b_n24 n18_b_n24 n19_b_n24 1.02e-17
ccc__18_bl_1_b_n24 n18_b_n24 bl_1_b_n24 8.415e-18
ccc__18_rwl_1_b_n24 n18_b_n24 rwl_1_b_n24 1.3194e-17
ccc__19__20_b_n24 n19_b_n24 n20_b_n24 1.02e-17
ccc__19_bl_2_b_n24 n19_b_n24 bl_2_b_n24 8.415e-18
ccc__19_rwl_1_b_n24 n19_b_n24 rwl_1_b_n24 1.3194e-17
ccc__20_bl_3_b_n24 n20_b_n24 bl_3_b_n24 8.415e-18
ccc__20_rwl_1_b_n24 n20_b_n24 rwl_1_b_n24 6.655e-18
ccc__22__23_b_n24 n22_b_n24 n23_b_n24 1.02e-17
ccc__22_bl_0_b_n24 n22_b_n24 bl_0_b_n24 8.415e-18
ccc__22_rwl_2_b_n24 n22_b_n24 rwl_2_b_n24 1.3194e-17
ccc__23__24_b_n24 n23_b_n24 n24_b_n24 1.02e-17
ccc__23_bl_1_b_n24 n23_b_n24 bl_1_b_n24 8.415e-18
ccc__23_rwl_2_b_n24 n23_b_n24 rwl_2_b_n24 1.3194e-17
ccc__24__25_b_n24 n24_b_n24 n25_b_n24 1.02e-17
ccc__24_bl_2_b_n24 n24_b_n24 bl_2_b_n24 8.415e-18
ccc__24_rwl_2_b_n24 n24_b_n24 rwl_2_b_n24 1.3194e-17
ccc__25_bl_3_b_n24 n25_b_n24 bl_3_b_n24 8.415e-18
ccc__25_rwl_2_b_n24 n25_b_n24 rwl_2_b_n24 6.655e-18
ccc__29__30_b_n24 n29_b_n24 n30_b_n24 1.02e-17
ccc__29_bl_0_b_n24 n29_b_n24 bl_0_b_n24 8.415e-18
ccc__29_rwl_3_b_n24 n29_b_n24 rwl_3_b_n24 1.3194e-17
ccc__30__31_b_n24 n30_b_n24 n31_b_n24 1.02e-17
ccc__30_bl_1_b_n24 n30_b_n24 bl_1_b_n24 8.415e-18
ccc__30_rwl_3_b_n24 n30_b_n24 rwl_3_b_n24 1.3194e-17
ccc__31__32_b_n24 n31_b_n24 n32_b_n24 1.02e-17
ccc__31_bl_2_b_n24 n31_b_n24 bl_2_b_n24 8.415e-18
ccc__31_rwl_3_b_n24 n31_b_n24 rwl_3_b_n24 1.3194e-17
ccc__32_bl_3_b_n24 n32_b_n24 bl_3_b_n24 8.415e-18
ccc__32_rwl_3_b_n24 n32_b_n24 rwl_3_b_n24 6.655e-18
ccc__7__8_b_n24 n7_b_n24 n8_b_n24 1.02e-17
ccc__7_bl_0_b_n24 n7_b_n24 bl_0_b_n24 1.3999e-17
ccc__7_rwl_0_b_n24 n7_b_n24 rwl_0_b_n24 8.961e-18
ccc__8__9_b_n24 n8_b_n24 n9_b_n24 1.02e-17
ccc__8_bl_1_b_n24 n8_b_n24 bl_1_b_n24 1.3999e-17
ccc__8_rwl_0_b_n24 n8_b_n24 rwl_0_b_n24 8.961e-18
ccc__9_bl_2_b_n24 n9_b_n24 bl_2_b_n24 1.3999e-17
ccc__9_rwl_0_b_n24 n9_b_n24 rwl_0_b_n24 8.961e-18
ccc_bl_0_rbl_0_b_n24 bl_0_b_n24 rbl_0_b_n24 1.88693e-16
ccc_bl_0_rwl_1_b_n24 bl_0_b_n24 rwl_1_b_n24 1.0093e-17
ccc_bl_0_rwl_2_b_n24 bl_0_b_n24 rwl_2_b_n24 1.0093e-17
ccc_bl_1_rbl_0_b_n24 bl_1_b_n24 rbl_0_b_n24 1.633e-16
ccc_bl_1_rbl_1_b_n24 bl_1_b_n24 rbl_1_b_n24 1.88693e-16
ccc_bl_1_rwl_1_b_n24 bl_1_b_n24 rwl_1_b_n24 1.0093e-17
ccc_bl_1_rwl_2_b_n24 bl_1_b_n24 rwl_2_b_n24 1.0093e-17
ccc_bl_2_rbl_1_b_n24 bl_2_b_n24 rbl_1_b_n24 1.633e-16
ccc_bl_2_rbl_2_b_n24 bl_2_b_n24 rbl_2_b_n24 1.88693e-16
ccc_bl_2_rwl_1_b_n24 bl_2_b_n24 rwl_1_b_n24 1.0093e-17
ccc_bl_2_rwl_2_b_n24 bl_2_b_n24 rwl_2_b_n24 1.0093e-17
ccc_bl_3_rbl_2_b_n24 bl_3_b_n24 rbl_2_b_n24 1.633e-16
ccc_bl_3_rbl_3_b_n24 bl_3_b_n24 rbl_3_b_n24 1.88693e-16
ccc_bl_3_rwl_1_b_n24 bl_3_b_n24 rwl_1_b_n24 1.0093e-17
ccc_bl_3_rwl_2_b_n24 bl_3_b_n24 rwl_2_b_n24 1.0093e-17
ccc_rbl_0_rbl_1_b_n24 rbl_0_b_n24 rbl_1_b_n24 3.432e-17
ccc_rbl_0_rwl_0_b_n24 rbl_0_b_n24 rwl_0_b_n24 4.9752e-17
ccc_rbl_0_rwl_1_b_n24 rbl_0_b_n24 rwl_1_b_n24 4.9752e-17
ccc_rbl_0_rwl_2_b_n24 rbl_0_b_n24 rwl_2_b_n24 4.9752e-17
ccc_rbl_0_rwl_3_b_n24 rbl_0_b_n24 rwl_3_b_n24 4.9752e-17
ccc_rbl_1_rbl_2_b_n24 rbl_1_b_n24 rbl_2_b_n24 3.432e-17
ccc_rbl_1_rwl_0_b_n24 rbl_1_b_n24 rwl_0_b_n24 4.9752e-17
ccc_rbl_1_rwl_1_b_n24 rbl_1_b_n24 rwl_1_b_n24 4.9752e-17
ccc_rbl_1_rwl_2_b_n24 rbl_1_b_n24 rwl_2_b_n24 4.9752e-17
ccc_rbl_1_rwl_3_b_n24 rbl_1_b_n24 rwl_3_b_n24 4.9752e-17
ccc_rbl_2_rbl_3_b_n24 rbl_2_b_n24 rbl_3_b_n24 3.432e-17
ccc_rbl_2_rwl_0_b_n24 rbl_2_b_n24 rwl_0_b_n24 4.9752e-17
ccc_rbl_2_rwl_1_b_n24 rbl_2_b_n24 rwl_1_b_n24 4.9752e-17
ccc_rbl_2_rwl_2_b_n24 rbl_2_b_n24 rwl_2_b_n24 4.9752e-17
ccc_rbl_2_rwl_3_b_n24 rbl_2_b_n24 rwl_3_b_n24 4.9752e-17
ccc_rbl_3_rwl_0_b_n24 rbl_3_b_n24 rwl_0_b_n24 3.3407e-17
ccc_rbl_3_rwl_1_b_n24 rbl_3_b_n24 rwl_1_b_n24 3.3407e-17
ccc_rbl_3_rwl_2_b_n24 rbl_3_b_n24 rwl_2_b_n24 3.3407e-17
ccc_rbl_3_rwl_3_b_n24 rbl_3_b_n24 rwl_3_b_n24 3.3407e-17
vdw_b_n24_0 wl_0_b_n24 0 dc 0
vdr_b_n24_0 rwl_0_b_n24 0 dc 0
vdw_b_n24_1 wl_1_b_n24 0 dc 0
vdr_b_n24_1 rwl_1_b_n24 0 dc 0
vdw_b_n24_2 wl_2_b_n24 0 dc 0
vdr_b_n24_2 rwl_2_b_n24 0 dc 0
vdw_b_n24_3 wl_3_b_n24 0 dc 0
vdr_b_n24_3 rwl_3_b_n24 0 dc 0
vdb_b_n24_0 bl_0_b_n24 0 dc 0
vdp_b_n24_0 rbl_0_b_n24 0 dc 0
vdb_b_n24_1 bl_1_b_n24 0 dc 0
vdp_b_n24_1 rbl_1_b_n24 0 dc 0
vdb_b_n24_2 bl_2_b_n24 0 dc 0
vdp_b_n24_2 rbl_2_b_n24 0 dc 0
vdb_b_n24_3 bl_3_b_n24 0 dc 0
vdp_b_n24_3 rbl_3_b_n24 0 dc 0
vdn_b_n24_n7 n7_b_n24 0 dc 1
vdn_b_n24_n8 n8_b_n24 0 dc 1
vdn_b_n24_n9 n9_b_n24 0 dc 1
vdn_b_n24_n10 n10_b_n24 0 dc 1
vdn_b_n24_n17 n17_b_n24 0 dc 1
vdn_b_n24_n18 n18_b_n24 0 dc 1
vdn_b_n24_n19 n19_b_n24 0 dc 1
vdn_b_n24_n20 n20_b_n24 0 dc 1
vdn_b_n24_n22 n22_b_n24 0 dc 1
vdn_b_n24_n23 n23_b_n24 0 dc 1
vdn_b_n24_n25 n25_b_n24 0 dc 1
vdn_b_n24_n29 n29_b_n24 0 dc 1
vdn_b_n24_n30 n30_b_n24 0 dc 1
vdn_b_n24_n31 n31_b_n24 0 dc 1
vdn_b_n24_n32 n32_b_n24 0 dc 1
bdr_b_n24 n24_b_n24 0 i=5e-08*min(1,max(0,(time-1e-09)/0.2n))*0.5*(1+tanh((v(n24_b_n24)-0.05)/0.01))

* ---- instance b_n25: variant b, probed storage node \$25 ----
xm1_b_n25 rwl_0__t2_b_n25 n7__t0_b_n25 rbl_0__t0_b_n25 gnd__t0_b_n25 sky130_fd_pr__nfet_01v8 L=0.15 W=0.42 nf=1 ad=0.1197 as=0.1197 pd=1.41 ps=1.41 mult=1 m=1
xm2_b_n25 rwl_0__t3_b_n25 n8__t1_b_n25 rbl_1__t1_b_n25 gnd__t1_b_n25 sky130_fd_pr__nfet_01v8 L=0.15 W=0.42 nf=1 ad=0.1197 as=0.1197 pd=1.41 ps=1.41 mult=1 m=1
xm3_b_n25 rwl_0__t1_b_n25 n9__t1_b_n25 rbl_2__t1_b_n25 gnd__t2_b_n25 sky130_fd_pr__nfet_01v8 L=0.15 W=0.42 nf=1 ad=0.1197 as=0.1197 pd=1.41 ps=1.41 mult=1 m=1
xm4_b_n25 rwl_0__t0_b_n25 n10__t1_b_n25 rbl_3__t1_b_n25 gnd__t3_b_n25 sky130_fd_pr__nfet_01v8 L=0.15 W=0.42 nf=1 ad=0.1197 as=0.1197 pd=1.41 ps=1.41 mult=1 m=1
xm5_b_n25 bl_0__t0_b_n25 wl_0__t0_b_n25 n7__t1_b_n25 gnd__t8_b_n25 sky130_fd_pr__nfet_01v8 L=0.15 W=0.42 nf=1 ad=0.0588 as=0.1197 pd=0.7 ps=1.41 mult=1 m=1
xm6_b_n25 n17__t0_b_n25 wl_1__t0_b_n25 bl_0__t1_b_n25 gnd__t20_b_n25 sky130_fd_pr__nfet_01v8 L=0.15 W=0.42 nf=1 ad=0.1197 as=0.0588 pd=1.41 ps=0.7 mult=1 m=1
xm7_b_n25 bl_1__t2_b_n25 wl_0__t3_b_n25 n8__t0_b_n25 gnd__t9_b_n25 sky130_fd_pr__nfet_01v8 L=0.15 W=0.42 nf=1 ad=0.0588 as=0.1197 pd=0.7 ps=1.41 mult=1 m=1
xm8_b_n25 n18__t0_b_n25 wl_1__t1_b_n25 bl_1__t0_b_n25 gnd__t21_b_n25 sky130_fd_pr__nfet_01v8 L=0.15 W=0.42 nf=1 ad=0.1197 as=0.0588 pd=1.41 ps=0.7 mult=1 m=1
xm9_b_n25 bl_2__t2_b_n25 wl_0__t2_b_n25 n9__t0_b_n25 gnd__t10_b_n25 sky130_fd_pr__nfet_01v8 L=0.15 W=0.42 nf=1 ad=0.0588 as=0.1197 pd=0.7 ps=1.41 mult=1 m=1
xm10_b_n25 n19__t0_b_n25 wl_1__t2_b_n25 bl_2__t0_b_n25 gnd__t22_b_n25 sky130_fd_pr__nfet_01v8 L=0.15 W=0.42 nf=1 ad=0.1197 as=0.0588 pd=1.41 ps=0.7 mult=1 m=1
xm11_b_n25 bl_3__t2_b_n25 wl_0__t1_b_n25 n10__t0_b_n25 gnd__t11_b_n25 sky130_fd_pr__nfet_01v8 L=0.15 W=0.42 nf=1 ad=0.0588 as=0.1197 pd=0.7 ps=1.41 mult=1 m=1
xm12_b_n25 n20__t0_b_n25 wl_1__t3_b_n25 bl_3__t1_b_n25 gnd__t23_b_n25 sky130_fd_pr__nfet_01v8 L=0.15 W=0.42 nf=1 ad=0.1197 as=0.0588 pd=1.41 ps=0.7 mult=1 m=1
xm13_b_n25 rbl_0__t3_b_n25 n17__t1_b_n25 rwl_1__t0_b_n25 gnd__t12_b_n25 sky130_fd_pr__nfet_01v8 L=0.15 W=0.42 nf=1 ad=0.0588 as=0.1197 pd=0.7 ps=1.41 mult=1 m=1
xm14_b_n25 rwl_2__t3_b_n25 n22__t0_b_n25 rbl_0__t2_b_n25 gnd__t24_b_n25 sky130_fd_pr__nfet_01v8 L=0.15 W=0.42 nf=1 ad=0.1197 as=0.0588 pd=1.41 ps=0.7 mult=1 m=1
xm15_b_n25 rbl_1__t3_b_n25 n18__t1_b_n25 rwl_1__t1_b_n25 gnd__t13_b_n25 sky130_fd_pr__nfet_01v8 L=0.15 W=0.42 nf=1 ad=0.0588 as=0.1197 pd=0.7 ps=1.41 mult=1 m=1
xm16_b_n25 rwl_2__t0_b_n25 n23__t0_b_n25 rbl_1__t2_b_n25 gnd__t25_b_n25 sky130_fd_pr__nfet_01v8 L=0.15 W=0.42 nf=1 ad=0.1197 as=0.0588 pd=1.41 ps=0.7 mult=1 m=1
xm17_b_n25 rbl_2__t3_b_n25 n19__t1_b_n25 rwl_1__t2_b_n25 gnd__t14_b_n25 sky130_fd_pr__nfet_01v8 L=0.15 W=0.42 nf=1 ad=0.0588 as=0.1197 pd=0.7 ps=1.41 mult=1 m=1
xm18_b_n25 rwl_2__t1_b_n25 n24__t0_b_n25 rbl_2__t2_b_n25 gnd__t26_b_n25 sky130_fd_pr__nfet_01v8 L=0.15 W=0.42 nf=1 ad=0.1197 as=0.0588 pd=1.41 ps=0.7 mult=1 m=1
xm19_b_n25 rbl_3__t3_b_n25 n20__t1_b_n25 rwl_1__t3_b_n25 gnd__t15_b_n25 sky130_fd_pr__nfet_01v8 L=0.15 W=0.42 nf=1 ad=0.0588 as=0.1197 pd=0.7 ps=1.41 mult=1 m=1
xm20_b_n25 rwl_2__t2_b_n25 n25__t0_b_n25 rbl_3__t2_b_n25 gnd__t27_b_n25 sky130_fd_pr__nfet_01v8 L=0.15 W=0.42 nf=1 ad=0.1197 as=0.0588 pd=1.41 ps=0.7 mult=1 m=1
xm21_b_n25 bl_0__t3_b_n25 wl_2__t0_b_n25 n22__t1_b_n25 gnd__t16_b_n25 sky130_fd_pr__nfet_01v8 L=0.15 W=0.42 nf=1 ad=0.0588 as=0.1197 pd=0.7 ps=1.41 mult=1 m=1
xm22_b_n25 n29__t0_b_n25 wl_3__t3_b_n25 bl_0__t2_b_n25 gnd__t28_b_n25 sky130_fd_pr__nfet_01v8 L=0.15 W=0.42 nf=1 ad=0.1197 as=0.0588 pd=1.41 ps=0.7 mult=1 m=1
xm23_b_n25 bl_1__t3_b_n25 wl_2__t1_b_n25 n23__t1_b_n25 gnd__t17_b_n25 sky130_fd_pr__nfet_01v8 L=0.15 W=0.42 nf=1 ad=0.0588 as=0.1197 pd=0.7 ps=1.41 mult=1 m=1
xm24_b_n25 n30__t0_b_n25 wl_3__t2_b_n25 bl_1__t1_b_n25 gnd__t29_b_n25 sky130_fd_pr__nfet_01v8 L=0.15 W=0.42 nf=1 ad=0.1197 as=0.0588 pd=1.41 ps=0.7 mult=1 m=1
xm25_b_n25 bl_2__t3_b_n25 wl_2__t2_b_n25 n24__t1_b_n25 gnd__t18_b_n25 sky130_fd_pr__nfet_01v8 L=0.15 W=0.42 nf=1 ad=0.0588 as=0.1197 pd=0.7 ps=1.41 mult=1 m=1
xm26_b_n25 n31__t0_b_n25 wl_3__t1_b_n25 bl_2__t1_b_n25 gnd__t30_b_n25 sky130_fd_pr__nfet_01v8 L=0.15 W=0.42 nf=1 ad=0.1197 as=0.0588 pd=1.41 ps=0.7 mult=1 m=1
xm27_b_n25 bl_3__t3_b_n25 wl_2__t3_b_n25 n25__t1_b_n25 gnd__t19_b_n25 sky130_fd_pr__nfet_01v8 L=0.15 W=0.42 nf=1 ad=0.0588 as=0.1197 pd=0.7 ps=1.41 mult=1 m=1
xm28_b_n25 n32__t0_b_n25 wl_3__t0_b_n25 bl_3__t0_b_n25 gnd__t31_b_n25 sky130_fd_pr__nfet_01v8 L=0.15 W=0.42 nf=1 ad=0.1197 as=0.0588 pd=1.41 ps=0.7 mult=1 m=1
xm29_b_n25 rbl_0__t1_b_n25 n29__t1_b_n25 rwl_3__t0_b_n25 gnd__t4_b_n25 sky130_fd_pr__nfet_01v8 L=0.15 W=0.42 nf=1 ad=0.1197 as=0.1197 pd=1.41 ps=1.41 mult=1 m=1
xm30_b_n25 rbl_1__t0_b_n25 n30__t1_b_n25 rwl_3__t1_b_n25 gnd__t5_b_n25 sky130_fd_pr__nfet_01v8 L=0.15 W=0.42 nf=1 ad=0.1197 as=0.1197 pd=1.41 ps=1.41 mult=1 m=1
xm31_b_n25 rbl_2__t0_b_n25 n31__t1_b_n25 rwl_3__t2_b_n25 gnd__t6_b_n25 sky130_fd_pr__nfet_01v8 L=0.15 W=0.42 nf=1 ad=0.1197 as=0.1197 pd=1.41 ps=1.41 mult=1 m=1
xm32_b_n25 rbl_3__t0_b_n25 n32__t1_b_n25 rwl_3__t3_b_n25 gnd__t7_b_n25 sky130_fd_pr__nfet_01v8 L=0.15 W=0.42 nf=1 ad=0.1197 as=0.1197 pd=1.41 ps=1.41 mult=1 m=1
r_10_t0_b_n25 n10__t0_b_n25 n10_b_n25 183.071
r_10_t1_b_n25 n10__t1_b_n25 n10_b_n25 183.071
r_17_t0_b_n25 n17__t0_b_n25 n17_b_n25 183.071
r_17_t1_b_n25 n17__t1_b_n25 n17_b_n25 183.071
r_18_t0_b_n25 n18__t0_b_n25 n18_b_n25 183.071
r_18_t1_b_n25 n18__t1_b_n25 n18_b_n25 183.071
r_19_t0_b_n25 n19__t0_b_n25 n19_b_n25 183.071
r_19_t1_b_n25 n19__t1_b_n25 n19_b_n25 183.071
r_20_t0_b_n25 n20__t0_b_n25 n20_b_n25 183.071
r_20_t1_b_n25 n20__t1_b_n25 n20_b_n25 183.071
r_22_t0_b_n25 n22__t0_b_n25 n22_b_n25 183.071
r_22_t1_b_n25 n22__t1_b_n25 n22_b_n25 183.071
r_23_t0_b_n25 n23__t0_b_n25 n23_b_n25 183.071
r_23_t1_b_n25 n23__t1_b_n25 n23_b_n25 183.071
r_24_t0_b_n25 n24__t0_b_n25 n24_b_n25 183.071
r_24_t1_b_n25 n24__t1_b_n25 n24_b_n25 183.071
r_25_t0_b_n25 n25__t0_b_n25 n25_b_n25 183.071
r_25_t1_b_n25 n25__t1_b_n25 n25_b_n25 183.071
r_29_t0_b_n25 n29__t0_b_n25 n29_b_n25 183.071
r_29_t1_b_n25 n29__t1_b_n25 n29_b_n25 183.071
r_30_t0_b_n25 n30__t0_b_n25 n30_b_n25 183.071
r_30_t1_b_n25 n30__t1_b_n25 n30_b_n25 183.071
r_31_t0_b_n25 n31__t0_b_n25 n31_b_n25 183.071
r_31_t1_b_n25 n31__t1_b_n25 n31_b_n25 183.071
r_32_t0_b_n25 n32__t0_b_n25 n32_b_n25 183.071
r_32_t1_b_n25 n32__t1_b_n25 n32_b_n25 183.071
r_7_t0_b_n25 n7__t0_b_n25 n7_b_n25 183.071
r_7_t1_b_n25 n7__t1_b_n25 n7_b_n25 183.071
r_8_t0_b_n25 n8__t0_b_n25 n8_b_n25 183.071
r_8_t1_b_n25 n8__t1_b_n25 n8_b_n25 183.071
r_9_t0_b_n25 n9__t0_b_n25 n9_b_n25 183.071
r_9_t1_b_n25 n9__t1_b_n25 n9_b_n25 183.071
rgnd_t0_b_n25 gnd__t0_b_n25 0 38.2988
rgnd_t1_b_n25 gnd__t1_b_n25 0 33.9576
rgnd_t2_b_n25 gnd__t2_b_n25 0 33.9576
rgnd_t3_b_n25 gnd__t3_b_n25 0 38.2988
rgnd_t4_b_n25 gnd__t4_b_n25 0 38.2988
rgnd_t5_b_n25 gnd__t5_b_n25 0 33.9576
rgnd_t6_b_n25 gnd__t6_b_n25 0 33.9576
rgnd_t7_b_n25 gnd__t7_b_n25 0 38.2988
rgnd_t8_b_n25 gnd__t8_b_n25 0 28.0185
rgnd_t9_b_n25 gnd__t9_b_n25 0 21.7106
rgnd_t10_b_n25 gnd__t10_b_n25 0 21.7106
rgnd_t11_b_n25 gnd__t11_b_n25 0 28.0185
rgnd_t12_b_n25 gnd__t12_b_n25 0 18.9833
rgnd_t13_b_n25 gnd__t13_b_n25 0 6.8325
rgnd_t14_b_n25 gnd__t14_b_n25 0 6.8325
rgnd_t15_b_n25 gnd__t15_b_n25 0 18.9833
rgnd_t16_b_n25 gnd__t16_b_n25 0 24.2409
rgnd_t17_b_n25 gnd__t17_b_n25 0 16.5511
rgnd_t18_b_n25 gnd__t18_b_n25 0 16.5511
rgnd_t19_b_n25 gnd__t19_b_n25 0 24.2409
rgnd_t20_b_n25 gnd__t20_b_n25 0 24.2409
rgnd_t21_b_n25 gnd__t21_b_n25 0 16.5511
rgnd_t22_b_n25 gnd__t22_b_n25 0 16.5511
rgnd_t23_b_n25 gnd__t23_b_n25 0 24.2409
rgnd_t24_b_n25 gnd__t24_b_n25 0 18.9833
rgnd_t25_b_n25 gnd__t25_b_n25 0 6.8325
rgnd_t26_b_n25 gnd__t26_b_n25 0 6.8325
rgnd_t27_b_n25 gnd__t27_b_n25 0 18.9833
rgnd_t28_b_n25 gnd__t28_b_n25 0 28.0185
rgnd_t29_b_n25 gnd__t29_b_n25 0 21.7106
rgnd_t30_b_n25 gnd__t30_b_n25 0 21.7106
rgnd_t31_b_n25 gnd__t31_b_n25 0 28.0185
rbl_0_t0_b_n25 bl_0__t0_b_n25 bl_0_b_n25 14.8304
rbl_0_t1_b_n25 bl_0__t1_b_n25 bl_0_b_n25 10.9301
rbl_0_t2_b_n25 bl_0__t2_b_n25 bl_0_b_n25 14.8304
rbl_0_t3_b_n25 bl_0__t3_b_n25 bl_0_b_n25 10.9301
rbl_1_t0_b_n25 bl_1__t0_b_n25 bl_1_b_n25 10.9301
rbl_1_t1_b_n25 bl_1__t1_b_n25 bl_1_b_n25 14.8304
rbl_1_t2_b_n25 bl_1__t2_b_n25 bl_1_b_n25 14.8304
rbl_1_t3_b_n25 bl_1__t3_b_n25 bl_1_b_n25 10.9301
rbl_2_t0_b_n25 bl_2__t0_b_n25 bl_2_b_n25 10.9301
rbl_2_t1_b_n25 bl_2__t1_b_n25 bl_2_b_n25 14.8304
rbl_2_t2_b_n25 bl_2__t2_b_n25 bl_2_b_n25 14.8304
rbl_2_t3_b_n25 bl_2__t3_b_n25 bl_2_b_n25 10.9301
rbl_3_t0_b_n25 bl_3__t0_b_n25 bl_3_b_n25 14.8304
rbl_3_t1_b_n25 bl_3__t1_b_n25 bl_3_b_n25 10.9301
rbl_3_t2_b_n25 bl_3__t2_b_n25 bl_3_b_n25 14.8304
rbl_3_t3_b_n25 bl_3__t3_b_n25 bl_3_b_n25 10.9301
rrbl_0_t0_b_n25 rbl_0__t0_b_n25 rbl_0_b_n25 36.5601
rrbl_0_t1_b_n25 rbl_0__t1_b_n25 rbl_0_b_n25 36.5601
rrbl_0_t2_b_n25 rbl_0__t2_b_n25 rbl_0_b_n25 2.99444
rrbl_0_t3_b_n25 rbl_0__t3_b_n25 rbl_0_b_n25 2.99444
rrbl_1_t0_b_n25 rbl_1__t0_b_n25 rbl_1_b_n25 36.5601
rrbl_1_t1_b_n25 rbl_1__t1_b_n25 rbl_1_b_n25 36.5601
rrbl_1_t2_b_n25 rbl_1__t2_b_n25 rbl_1_b_n25 2.99444
rrbl_1_t3_b_n25 rbl_1__t3_b_n25 rbl_1_b_n25 2.99444
rrbl_2_t0_b_n25 rbl_2__t0_b_n25 rbl_2_b_n25 36.5601
rrbl_2_t1_b_n25 rbl_2__t1_b_n25 rbl_2_b_n25 36.5601
rrbl_2_t2_b_n25 rbl_2__t2_b_n25 rbl_2_b_n25 2.99444
rrbl_2_t3_b_n25 rbl_2__t3_b_n25 rbl_2_b_n25 2.99444
rrbl_3_t0_b_n25 rbl_3__t0_b_n25 rbl_3_b_n25 36.5601
rrbl_3_t1_b_n25 rbl_3__t1_b_n25 rbl_3_b_n25 36.5601
rrbl_3_t2_b_n25 rbl_3__t2_b_n25 rbl_3_b_n25 2.99444
rrbl_3_t3_b_n25 rbl_3__t3_b_n25 rbl_3_b_n25 2.99444
rrwl_0_t0_b_n25 rwl_0__t0_b_n25 rwl_0_b_n25 38.2618
rrwl_0_t1_b_n25 rwl_0__t1_b_n25 rwl_0_b_n25 12.7539
rrwl_0_t2_b_n25 rwl_0__t2_b_n25 rwl_0_b_n25 38.2618
rrwl_0_t3_b_n25 rwl_0__t3_b_n25 rwl_0_b_n25 12.7539
rrwl_1_t0_b_n25 rwl_1__t0_b_n25 rwl_1_b_n25 38.2618
rrwl_1_t1_b_n25 rwl_1__t1_b_n25 rwl_1_b_n25 12.7539
rrwl_1_t2_b_n25 rwl_1__t2_b_n25 rwl_1_b_n25 12.7539
rrwl_1_t3_b_n25 rwl_1__t3_b_n25 rwl_1_b_n25 38.2618
rrwl_2_t0_b_n25 rwl_2__t0_b_n25 rwl_2_b_n25 12.7539
rrwl_2_t1_b_n25 rwl_2__t1_b_n25 rwl_2_b_n25 12.7539
rrwl_2_t2_b_n25 rwl_2__t2_b_n25 rwl_2_b_n25 38.2618
rrwl_2_t3_b_n25 rwl_2__t3_b_n25 rwl_2_b_n25 38.2618
rrwl_3_t0_b_n25 rwl_3__t0_b_n25 rwl_3_b_n25 38.2618
rrwl_3_t1_b_n25 rwl_3__t1_b_n25 rwl_3_b_n25 12.7539
rrwl_3_t2_b_n25 rwl_3__t2_b_n25 rwl_3_b_n25 12.7539
rrwl_3_t3_b_n25 rwl_3__t3_b_n25 rwl_3_b_n25 38.2618
rwl_0_t0_b_n25 wl_0__t0_b_n25 wl_0_b_n25 245.959
rwl_0_t1_b_n25 wl_0__t1_b_n25 wl_0_b_n25 245.959
rwl_0_t2_b_n25 wl_0__t2_b_n25 wl_0_b_n25 81.9864
rwl_0_t3_b_n25 wl_0__t3_b_n25 wl_0_b_n25 81.9864
rwl_1_t0_b_n25 wl_1__t0_b_n25 wl_1_b_n25 245.959
rwl_1_t1_b_n25 wl_1__t1_b_n25 wl_1_b_n25 81.9864
rwl_1_t2_b_n25 wl_1__t2_b_n25 wl_1_b_n25 81.9864
rwl_1_t3_b_n25 wl_1__t3_b_n25 wl_1_b_n25 245.959
rwl_2_t0_b_n25 wl_2__t0_b_n25 wl_2_b_n25 245.959
rwl_2_t1_b_n25 wl_2__t1_b_n25 wl_2_b_n25 81.9864
rwl_2_t2_b_n25 wl_2__t2_b_n25 wl_2_b_n25 81.9864
rwl_2_t3_b_n25 wl_2__t3_b_n25 wl_2_b_n25 245.959
rwl_3_t0_b_n25 wl_3__t0_b_n25 wl_3_b_n25 245.959
rwl_3_t1_b_n25 wl_3__t1_b_n25 wl_3_b_n25 81.9864
rwl_3_t2_b_n25 wl_3__t2_b_n25 wl_3_b_n25 81.9864
rwl_3_t3_b_n25 wl_3__t3_b_n25 wl_3_b_n25 245.959
c_10_b_n25 n10_b_n25 0 2.91622e-16
c_17_b_n25 n17_b_n25 0 2.91528e-16
c_18_b_n25 n18_b_n25 0 2.91528e-16
c_19_b_n25 n19_b_n25 0 2.91528e-16
c_20_b_n25 n20_b_n25 0 2.91622e-16
c_22_b_n25 n22_b_n25 0 2.91528e-16
c_23_b_n25 n23_b_n25 0 2.91528e-16
c_24_b_n25 n24_b_n25 0 2.91528e-16
c_25_b_n25 n25_b_n25 0 2.91622e-16
c_29_b_n25 n29_b_n25 0 2.91528e-16
c_30_b_n25 n30_b_n25 0 2.91528e-16
c_31_b_n25 n31_b_n25 0 2.91528e-16
c_32_b_n25 n32_b_n25 0 2.91622e-16
c_7_b_n25 n7_b_n25 0 2.91528e-16
c_8_b_n25 n8_b_n25 0 2.91528e-16
c_9_b_n25 n9_b_n25 0 2.91528e-16
cgnd_b_n25 0 0 2.48166e-15
cbl_0_b_n25 bl_0_b_n25 0 4.52661e-16
cbl_1_b_n25 bl_1_b_n25 0 4.52661e-16
cbl_2_b_n25 bl_2_b_n25 0 4.52661e-16
cbl_3_b_n25 bl_3_b_n25 0 4.52661e-16
crbl_0_b_n25 rbl_0_b_n25 0 9.14472e-16
crbl_1_b_n25 rbl_1_b_n25 0 9.14472e-16
crbl_2_b_n25 rbl_2_b_n25 0 9.14472e-16
crbl_3_b_n25 rbl_3_b_n25 0 9.17566e-16
crwl_0_b_n25 rwl_0_b_n25 0 5.19495e-16
crwl_1_b_n25 rwl_1_b_n25 0 5.11719e-16
crwl_2_b_n25 rwl_2_b_n25 0 5.11719e-16
crwl_3_b_n25 rwl_3_b_n25 0 5.19495e-16
cwl_0_b_n25 wl_0_b_n25 0 3.30388e-16
cwl_1_b_n25 wl_1_b_n25 0 3.30388e-16
cwl_2_b_n25 wl_2_b_n25 0 3.30388e-16
cwl_3_b_n25 wl_3_b_n25 0 3.30388e-16
ccc__10__9_b_n25 n10_b_n25 n9_b_n25 1.02e-17
ccc__10_bl_3_b_n25 n10_b_n25 bl_3_b_n25 1.3999e-17
ccc__10_rwl_0_b_n25 n10_b_n25 rwl_0_b_n25 4.335e-18
ccc__17__18_b_n25 n17_b_n25 n18_b_n25 1.02e-17
ccc__17_bl_0_b_n25 n17_b_n25 bl_0_b_n25 8.415e-18
ccc__17_rwl_1_b_n25 n17_b_n25 rwl_1_b_n25 1.3194e-17
ccc__18__19_b_n25 n18_b_n25 n19_b_n25 1.02e-17
ccc__18_bl_1_b_n25 n18_b_n25 bl_1_b_n25 8.415e-18
ccc__18_rwl_1_b_n25 n18_b_n25 rwl_1_b_n25 1.3194e-17
ccc__19__20_b_n25 n19_b_n25 n20_b_n25 1.02e-17
ccc__19_bl_2_b_n25 n19_b_n25 bl_2_b_n25 8.415e-18
ccc__19_rwl_1_b_n25 n19_b_n25 rwl_1_b_n25 1.3194e-17
ccc__20_bl_3_b_n25 n20_b_n25 bl_3_b_n25 8.415e-18
ccc__20_rwl_1_b_n25 n20_b_n25 rwl_1_b_n25 6.655e-18
ccc__22__23_b_n25 n22_b_n25 n23_b_n25 1.02e-17
ccc__22_bl_0_b_n25 n22_b_n25 bl_0_b_n25 8.415e-18
ccc__22_rwl_2_b_n25 n22_b_n25 rwl_2_b_n25 1.3194e-17
ccc__23__24_b_n25 n23_b_n25 n24_b_n25 1.02e-17
ccc__23_bl_1_b_n25 n23_b_n25 bl_1_b_n25 8.415e-18
ccc__23_rwl_2_b_n25 n23_b_n25 rwl_2_b_n25 1.3194e-17
ccc__24__25_b_n25 n24_b_n25 n25_b_n25 1.02e-17
ccc__24_bl_2_b_n25 n24_b_n25 bl_2_b_n25 8.415e-18
ccc__24_rwl_2_b_n25 n24_b_n25 rwl_2_b_n25 1.3194e-17
ccc__25_bl_3_b_n25 n25_b_n25 bl_3_b_n25 8.415e-18
ccc__25_rwl_2_b_n25 n25_b_n25 rwl_2_b_n25 6.655e-18
ccc__29__30_b_n25 n29_b_n25 n30_b_n25 1.02e-17
ccc__29_bl_0_b_n25 n29_b_n25 bl_0_b_n25 8.415e-18
ccc__29_rwl_3_b_n25 n29_b_n25 rwl_3_b_n25 1.3194e-17
ccc__30__31_b_n25 n30_b_n25 n31_b_n25 1.02e-17
ccc__30_bl_1_b_n25 n30_b_n25 bl_1_b_n25 8.415e-18
ccc__30_rwl_3_b_n25 n30_b_n25 rwl_3_b_n25 1.3194e-17
ccc__31__32_b_n25 n31_b_n25 n32_b_n25 1.02e-17
ccc__31_bl_2_b_n25 n31_b_n25 bl_2_b_n25 8.415e-18
ccc__31_rwl_3_b_n25 n31_b_n25 rwl_3_b_n25 1.3194e-17
ccc__32_bl_3_b_n25 n32_b_n25 bl_3_b_n25 8.415e-18
ccc__32_rwl_3_b_n25 n32_b_n25 rwl_3_b_n25 6.655e-18
ccc__7__8_b_n25 n7_b_n25 n8_b_n25 1.02e-17
ccc__7_bl_0_b_n25 n7_b_n25 bl_0_b_n25 1.3999e-17
ccc__7_rwl_0_b_n25 n7_b_n25 rwl_0_b_n25 8.961e-18
ccc__8__9_b_n25 n8_b_n25 n9_b_n25 1.02e-17
ccc__8_bl_1_b_n25 n8_b_n25 bl_1_b_n25 1.3999e-17
ccc__8_rwl_0_b_n25 n8_b_n25 rwl_0_b_n25 8.961e-18
ccc__9_bl_2_b_n25 n9_b_n25 bl_2_b_n25 1.3999e-17
ccc__9_rwl_0_b_n25 n9_b_n25 rwl_0_b_n25 8.961e-18
ccc_bl_0_rbl_0_b_n25 bl_0_b_n25 rbl_0_b_n25 1.88693e-16
ccc_bl_0_rwl_1_b_n25 bl_0_b_n25 rwl_1_b_n25 1.0093e-17
ccc_bl_0_rwl_2_b_n25 bl_0_b_n25 rwl_2_b_n25 1.0093e-17
ccc_bl_1_rbl_0_b_n25 bl_1_b_n25 rbl_0_b_n25 1.633e-16
ccc_bl_1_rbl_1_b_n25 bl_1_b_n25 rbl_1_b_n25 1.88693e-16
ccc_bl_1_rwl_1_b_n25 bl_1_b_n25 rwl_1_b_n25 1.0093e-17
ccc_bl_1_rwl_2_b_n25 bl_1_b_n25 rwl_2_b_n25 1.0093e-17
ccc_bl_2_rbl_1_b_n25 bl_2_b_n25 rbl_1_b_n25 1.633e-16
ccc_bl_2_rbl_2_b_n25 bl_2_b_n25 rbl_2_b_n25 1.88693e-16
ccc_bl_2_rwl_1_b_n25 bl_2_b_n25 rwl_1_b_n25 1.0093e-17
ccc_bl_2_rwl_2_b_n25 bl_2_b_n25 rwl_2_b_n25 1.0093e-17
ccc_bl_3_rbl_2_b_n25 bl_3_b_n25 rbl_2_b_n25 1.633e-16
ccc_bl_3_rbl_3_b_n25 bl_3_b_n25 rbl_3_b_n25 1.88693e-16
ccc_bl_3_rwl_1_b_n25 bl_3_b_n25 rwl_1_b_n25 1.0093e-17
ccc_bl_3_rwl_2_b_n25 bl_3_b_n25 rwl_2_b_n25 1.0093e-17
ccc_rbl_0_rbl_1_b_n25 rbl_0_b_n25 rbl_1_b_n25 3.432e-17
ccc_rbl_0_rwl_0_b_n25 rbl_0_b_n25 rwl_0_b_n25 4.9752e-17
ccc_rbl_0_rwl_1_b_n25 rbl_0_b_n25 rwl_1_b_n25 4.9752e-17
ccc_rbl_0_rwl_2_b_n25 rbl_0_b_n25 rwl_2_b_n25 4.9752e-17
ccc_rbl_0_rwl_3_b_n25 rbl_0_b_n25 rwl_3_b_n25 4.9752e-17
ccc_rbl_1_rbl_2_b_n25 rbl_1_b_n25 rbl_2_b_n25 3.432e-17
ccc_rbl_1_rwl_0_b_n25 rbl_1_b_n25 rwl_0_b_n25 4.9752e-17
ccc_rbl_1_rwl_1_b_n25 rbl_1_b_n25 rwl_1_b_n25 4.9752e-17
ccc_rbl_1_rwl_2_b_n25 rbl_1_b_n25 rwl_2_b_n25 4.9752e-17
ccc_rbl_1_rwl_3_b_n25 rbl_1_b_n25 rwl_3_b_n25 4.9752e-17
ccc_rbl_2_rbl_3_b_n25 rbl_2_b_n25 rbl_3_b_n25 3.432e-17
ccc_rbl_2_rwl_0_b_n25 rbl_2_b_n25 rwl_0_b_n25 4.9752e-17
ccc_rbl_2_rwl_1_b_n25 rbl_2_b_n25 rwl_1_b_n25 4.9752e-17
ccc_rbl_2_rwl_2_b_n25 rbl_2_b_n25 rwl_2_b_n25 4.9752e-17
ccc_rbl_2_rwl_3_b_n25 rbl_2_b_n25 rwl_3_b_n25 4.9752e-17
ccc_rbl_3_rwl_0_b_n25 rbl_3_b_n25 rwl_0_b_n25 3.3407e-17
ccc_rbl_3_rwl_1_b_n25 rbl_3_b_n25 rwl_1_b_n25 3.3407e-17
ccc_rbl_3_rwl_2_b_n25 rbl_3_b_n25 rwl_2_b_n25 3.3407e-17
ccc_rbl_3_rwl_3_b_n25 rbl_3_b_n25 rwl_3_b_n25 3.3407e-17
vdw_b_n25_0 wl_0_b_n25 0 dc 0
vdr_b_n25_0 rwl_0_b_n25 0 dc 0
vdw_b_n25_1 wl_1_b_n25 0 dc 0
vdr_b_n25_1 rwl_1_b_n25 0 dc 0
vdw_b_n25_2 wl_2_b_n25 0 dc 0
vdr_b_n25_2 rwl_2_b_n25 0 dc 0
vdw_b_n25_3 wl_3_b_n25 0 dc 0
vdr_b_n25_3 rwl_3_b_n25 0 dc 0
vdb_b_n25_0 bl_0_b_n25 0 dc 0
vdp_b_n25_0 rbl_0_b_n25 0 dc 0
vdb_b_n25_1 bl_1_b_n25 0 dc 0
vdp_b_n25_1 rbl_1_b_n25 0 dc 0
vdb_b_n25_2 bl_2_b_n25 0 dc 0
vdp_b_n25_2 rbl_2_b_n25 0 dc 0
vdb_b_n25_3 bl_3_b_n25 0 dc 0
vdp_b_n25_3 rbl_3_b_n25 0 dc 0
vdn_b_n25_n7 n7_b_n25 0 dc 1
vdn_b_n25_n8 n8_b_n25 0 dc 1
vdn_b_n25_n9 n9_b_n25 0 dc 1
vdn_b_n25_n10 n10_b_n25 0 dc 1
vdn_b_n25_n17 n17_b_n25 0 dc 1
vdn_b_n25_n18 n18_b_n25 0 dc 1
vdn_b_n25_n19 n19_b_n25 0 dc 1
vdn_b_n25_n20 n20_b_n25 0 dc 1
vdn_b_n25_n22 n22_b_n25 0 dc 1
vdn_b_n25_n23 n23_b_n25 0 dc 1
vdn_b_n25_n24 n24_b_n25 0 dc 1
vdn_b_n25_n29 n29_b_n25 0 dc 1
vdn_b_n25_n30 n30_b_n25 0 dc 1
vdn_b_n25_n31 n31_b_n25 0 dc 1
vdn_b_n25_n32 n32_b_n25 0 dc 1
bdr_b_n25 n25_b_n25 0 i=5e-08*min(1,max(0,(time-1e-09)/0.2n))*0.5*(1+tanh((v(n25_b_n25)-0.05)/0.01))

* ---- instance b_n29: variant b, probed storage node \$29 ----
xm1_b_n29 rwl_0__t2_b_n29 n7__t0_b_n29 rbl_0__t0_b_n29 gnd__t0_b_n29 sky130_fd_pr__nfet_01v8 L=0.15 W=0.42 nf=1 ad=0.1197 as=0.1197 pd=1.41 ps=1.41 mult=1 m=1
xm2_b_n29 rwl_0__t3_b_n29 n8__t1_b_n29 rbl_1__t1_b_n29 gnd__t1_b_n29 sky130_fd_pr__nfet_01v8 L=0.15 W=0.42 nf=1 ad=0.1197 as=0.1197 pd=1.41 ps=1.41 mult=1 m=1
xm3_b_n29 rwl_0__t1_b_n29 n9__t1_b_n29 rbl_2__t1_b_n29 gnd__t2_b_n29 sky130_fd_pr__nfet_01v8 L=0.15 W=0.42 nf=1 ad=0.1197 as=0.1197 pd=1.41 ps=1.41 mult=1 m=1
xm4_b_n29 rwl_0__t0_b_n29 n10__t1_b_n29 rbl_3__t1_b_n29 gnd__t3_b_n29 sky130_fd_pr__nfet_01v8 L=0.15 W=0.42 nf=1 ad=0.1197 as=0.1197 pd=1.41 ps=1.41 mult=1 m=1
xm5_b_n29 bl_0__t0_b_n29 wl_0__t0_b_n29 n7__t1_b_n29 gnd__t8_b_n29 sky130_fd_pr__nfet_01v8 L=0.15 W=0.42 nf=1 ad=0.0588 as=0.1197 pd=0.7 ps=1.41 mult=1 m=1
xm6_b_n29 n17__t0_b_n29 wl_1__t0_b_n29 bl_0__t1_b_n29 gnd__t20_b_n29 sky130_fd_pr__nfet_01v8 L=0.15 W=0.42 nf=1 ad=0.1197 as=0.0588 pd=1.41 ps=0.7 mult=1 m=1
xm7_b_n29 bl_1__t2_b_n29 wl_0__t3_b_n29 n8__t0_b_n29 gnd__t9_b_n29 sky130_fd_pr__nfet_01v8 L=0.15 W=0.42 nf=1 ad=0.0588 as=0.1197 pd=0.7 ps=1.41 mult=1 m=1
xm8_b_n29 n18__t0_b_n29 wl_1__t1_b_n29 bl_1__t0_b_n29 gnd__t21_b_n29 sky130_fd_pr__nfet_01v8 L=0.15 W=0.42 nf=1 ad=0.1197 as=0.0588 pd=1.41 ps=0.7 mult=1 m=1
xm9_b_n29 bl_2__t2_b_n29 wl_0__t2_b_n29 n9__t0_b_n29 gnd__t10_b_n29 sky130_fd_pr__nfet_01v8 L=0.15 W=0.42 nf=1 ad=0.0588 as=0.1197 pd=0.7 ps=1.41 mult=1 m=1
xm10_b_n29 n19__t0_b_n29 wl_1__t2_b_n29 bl_2__t0_b_n29 gnd__t22_b_n29 sky130_fd_pr__nfet_01v8 L=0.15 W=0.42 nf=1 ad=0.1197 as=0.0588 pd=1.41 ps=0.7 mult=1 m=1
xm11_b_n29 bl_3__t2_b_n29 wl_0__t1_b_n29 n10__t0_b_n29 gnd__t11_b_n29 sky130_fd_pr__nfet_01v8 L=0.15 W=0.42 nf=1 ad=0.0588 as=0.1197 pd=0.7 ps=1.41 mult=1 m=1
xm12_b_n29 n20__t0_b_n29 wl_1__t3_b_n29 bl_3__t1_b_n29 gnd__t23_b_n29 sky130_fd_pr__nfet_01v8 L=0.15 W=0.42 nf=1 ad=0.1197 as=0.0588 pd=1.41 ps=0.7 mult=1 m=1
xm13_b_n29 rbl_0__t3_b_n29 n17__t1_b_n29 rwl_1__t0_b_n29 gnd__t12_b_n29 sky130_fd_pr__nfet_01v8 L=0.15 W=0.42 nf=1 ad=0.0588 as=0.1197 pd=0.7 ps=1.41 mult=1 m=1
xm14_b_n29 rwl_2__t3_b_n29 n22__t0_b_n29 rbl_0__t2_b_n29 gnd__t24_b_n29 sky130_fd_pr__nfet_01v8 L=0.15 W=0.42 nf=1 ad=0.1197 as=0.0588 pd=1.41 ps=0.7 mult=1 m=1
xm15_b_n29 rbl_1__t3_b_n29 n18__t1_b_n29 rwl_1__t1_b_n29 gnd__t13_b_n29 sky130_fd_pr__nfet_01v8 L=0.15 W=0.42 nf=1 ad=0.0588 as=0.1197 pd=0.7 ps=1.41 mult=1 m=1
xm16_b_n29 rwl_2__t0_b_n29 n23__t0_b_n29 rbl_1__t2_b_n29 gnd__t25_b_n29 sky130_fd_pr__nfet_01v8 L=0.15 W=0.42 nf=1 ad=0.1197 as=0.0588 pd=1.41 ps=0.7 mult=1 m=1
xm17_b_n29 rbl_2__t3_b_n29 n19__t1_b_n29 rwl_1__t2_b_n29 gnd__t14_b_n29 sky130_fd_pr__nfet_01v8 L=0.15 W=0.42 nf=1 ad=0.0588 as=0.1197 pd=0.7 ps=1.41 mult=1 m=1
xm18_b_n29 rwl_2__t1_b_n29 n24__t0_b_n29 rbl_2__t2_b_n29 gnd__t26_b_n29 sky130_fd_pr__nfet_01v8 L=0.15 W=0.42 nf=1 ad=0.1197 as=0.0588 pd=1.41 ps=0.7 mult=1 m=1
xm19_b_n29 rbl_3__t3_b_n29 n20__t1_b_n29 rwl_1__t3_b_n29 gnd__t15_b_n29 sky130_fd_pr__nfet_01v8 L=0.15 W=0.42 nf=1 ad=0.0588 as=0.1197 pd=0.7 ps=1.41 mult=1 m=1
xm20_b_n29 rwl_2__t2_b_n29 n25__t0_b_n29 rbl_3__t2_b_n29 gnd__t27_b_n29 sky130_fd_pr__nfet_01v8 L=0.15 W=0.42 nf=1 ad=0.1197 as=0.0588 pd=1.41 ps=0.7 mult=1 m=1
xm21_b_n29 bl_0__t3_b_n29 wl_2__t0_b_n29 n22__t1_b_n29 gnd__t16_b_n29 sky130_fd_pr__nfet_01v8 L=0.15 W=0.42 nf=1 ad=0.0588 as=0.1197 pd=0.7 ps=1.41 mult=1 m=1
xm22_b_n29 n29__t0_b_n29 wl_3__t3_b_n29 bl_0__t2_b_n29 gnd__t28_b_n29 sky130_fd_pr__nfet_01v8 L=0.15 W=0.42 nf=1 ad=0.1197 as=0.0588 pd=1.41 ps=0.7 mult=1 m=1
xm23_b_n29 bl_1__t3_b_n29 wl_2__t1_b_n29 n23__t1_b_n29 gnd__t17_b_n29 sky130_fd_pr__nfet_01v8 L=0.15 W=0.42 nf=1 ad=0.0588 as=0.1197 pd=0.7 ps=1.41 mult=1 m=1
xm24_b_n29 n30__t0_b_n29 wl_3__t2_b_n29 bl_1__t1_b_n29 gnd__t29_b_n29 sky130_fd_pr__nfet_01v8 L=0.15 W=0.42 nf=1 ad=0.1197 as=0.0588 pd=1.41 ps=0.7 mult=1 m=1
xm25_b_n29 bl_2__t3_b_n29 wl_2__t2_b_n29 n24__t1_b_n29 gnd__t18_b_n29 sky130_fd_pr__nfet_01v8 L=0.15 W=0.42 nf=1 ad=0.0588 as=0.1197 pd=0.7 ps=1.41 mult=1 m=1
xm26_b_n29 n31__t0_b_n29 wl_3__t1_b_n29 bl_2__t1_b_n29 gnd__t30_b_n29 sky130_fd_pr__nfet_01v8 L=0.15 W=0.42 nf=1 ad=0.1197 as=0.0588 pd=1.41 ps=0.7 mult=1 m=1
xm27_b_n29 bl_3__t3_b_n29 wl_2__t3_b_n29 n25__t1_b_n29 gnd__t19_b_n29 sky130_fd_pr__nfet_01v8 L=0.15 W=0.42 nf=1 ad=0.0588 as=0.1197 pd=0.7 ps=1.41 mult=1 m=1
xm28_b_n29 n32__t0_b_n29 wl_3__t0_b_n29 bl_3__t0_b_n29 gnd__t31_b_n29 sky130_fd_pr__nfet_01v8 L=0.15 W=0.42 nf=1 ad=0.1197 as=0.0588 pd=1.41 ps=0.7 mult=1 m=1
xm29_b_n29 rbl_0__t1_b_n29 n29__t1_b_n29 rwl_3__t0_b_n29 gnd__t4_b_n29 sky130_fd_pr__nfet_01v8 L=0.15 W=0.42 nf=1 ad=0.1197 as=0.1197 pd=1.41 ps=1.41 mult=1 m=1
xm30_b_n29 rbl_1__t0_b_n29 n30__t1_b_n29 rwl_3__t1_b_n29 gnd__t5_b_n29 sky130_fd_pr__nfet_01v8 L=0.15 W=0.42 nf=1 ad=0.1197 as=0.1197 pd=1.41 ps=1.41 mult=1 m=1
xm31_b_n29 rbl_2__t0_b_n29 n31__t1_b_n29 rwl_3__t2_b_n29 gnd__t6_b_n29 sky130_fd_pr__nfet_01v8 L=0.15 W=0.42 nf=1 ad=0.1197 as=0.1197 pd=1.41 ps=1.41 mult=1 m=1
xm32_b_n29 rbl_3__t0_b_n29 n32__t1_b_n29 rwl_3__t3_b_n29 gnd__t7_b_n29 sky130_fd_pr__nfet_01v8 L=0.15 W=0.42 nf=1 ad=0.1197 as=0.1197 pd=1.41 ps=1.41 mult=1 m=1
r_10_t0_b_n29 n10__t0_b_n29 n10_b_n29 183.071
r_10_t1_b_n29 n10__t1_b_n29 n10_b_n29 183.071
r_17_t0_b_n29 n17__t0_b_n29 n17_b_n29 183.071
r_17_t1_b_n29 n17__t1_b_n29 n17_b_n29 183.071
r_18_t0_b_n29 n18__t0_b_n29 n18_b_n29 183.071
r_18_t1_b_n29 n18__t1_b_n29 n18_b_n29 183.071
r_19_t0_b_n29 n19__t0_b_n29 n19_b_n29 183.071
r_19_t1_b_n29 n19__t1_b_n29 n19_b_n29 183.071
r_20_t0_b_n29 n20__t0_b_n29 n20_b_n29 183.071
r_20_t1_b_n29 n20__t1_b_n29 n20_b_n29 183.071
r_22_t0_b_n29 n22__t0_b_n29 n22_b_n29 183.071
r_22_t1_b_n29 n22__t1_b_n29 n22_b_n29 183.071
r_23_t0_b_n29 n23__t0_b_n29 n23_b_n29 183.071
r_23_t1_b_n29 n23__t1_b_n29 n23_b_n29 183.071
r_24_t0_b_n29 n24__t0_b_n29 n24_b_n29 183.071
r_24_t1_b_n29 n24__t1_b_n29 n24_b_n29 183.071
r_25_t0_b_n29 n25__t0_b_n29 n25_b_n29 183.071
r_25_t1_b_n29 n25__t1_b_n29 n25_b_n29 183.071
r_29_t0_b_n29 n29__t0_b_n29 n29_b_n29 183.071
r_29_t1_b_n29 n29__t1_b_n29 n29_b_n29 183.071
r_30_t0_b_n29 n30__t0_b_n29 n30_b_n29 183.071
r_30_t1_b_n29 n30__t1_b_n29 n30_b_n29 183.071
r_31_t0_b_n29 n31__t0_b_n29 n31_b_n29 183.071
r_31_t1_b_n29 n31__t1_b_n29 n31_b_n29 183.071
r_32_t0_b_n29 n32__t0_b_n29 n32_b_n29 183.071
r_32_t1_b_n29 n32__t1_b_n29 n32_b_n29 183.071
r_7_t0_b_n29 n7__t0_b_n29 n7_b_n29 183.071
r_7_t1_b_n29 n7__t1_b_n29 n7_b_n29 183.071
r_8_t0_b_n29 n8__t0_b_n29 n8_b_n29 183.071
r_8_t1_b_n29 n8__t1_b_n29 n8_b_n29 183.071
r_9_t0_b_n29 n9__t0_b_n29 n9_b_n29 183.071
r_9_t1_b_n29 n9__t1_b_n29 n9_b_n29 183.071
rgnd_t0_b_n29 gnd__t0_b_n29 0 38.2988
rgnd_t1_b_n29 gnd__t1_b_n29 0 33.9576
rgnd_t2_b_n29 gnd__t2_b_n29 0 33.9576
rgnd_t3_b_n29 gnd__t3_b_n29 0 38.2988
rgnd_t4_b_n29 gnd__t4_b_n29 0 38.2988
rgnd_t5_b_n29 gnd__t5_b_n29 0 33.9576
rgnd_t6_b_n29 gnd__t6_b_n29 0 33.9576
rgnd_t7_b_n29 gnd__t7_b_n29 0 38.2988
rgnd_t8_b_n29 gnd__t8_b_n29 0 28.0185
rgnd_t9_b_n29 gnd__t9_b_n29 0 21.7106
rgnd_t10_b_n29 gnd__t10_b_n29 0 21.7106
rgnd_t11_b_n29 gnd__t11_b_n29 0 28.0185
rgnd_t12_b_n29 gnd__t12_b_n29 0 18.9833
rgnd_t13_b_n29 gnd__t13_b_n29 0 6.8325
rgnd_t14_b_n29 gnd__t14_b_n29 0 6.8325
rgnd_t15_b_n29 gnd__t15_b_n29 0 18.9833
rgnd_t16_b_n29 gnd__t16_b_n29 0 24.2409
rgnd_t17_b_n29 gnd__t17_b_n29 0 16.5511
rgnd_t18_b_n29 gnd__t18_b_n29 0 16.5511
rgnd_t19_b_n29 gnd__t19_b_n29 0 24.2409
rgnd_t20_b_n29 gnd__t20_b_n29 0 24.2409
rgnd_t21_b_n29 gnd__t21_b_n29 0 16.5511
rgnd_t22_b_n29 gnd__t22_b_n29 0 16.5511
rgnd_t23_b_n29 gnd__t23_b_n29 0 24.2409
rgnd_t24_b_n29 gnd__t24_b_n29 0 18.9833
rgnd_t25_b_n29 gnd__t25_b_n29 0 6.8325
rgnd_t26_b_n29 gnd__t26_b_n29 0 6.8325
rgnd_t27_b_n29 gnd__t27_b_n29 0 18.9833
rgnd_t28_b_n29 gnd__t28_b_n29 0 28.0185
rgnd_t29_b_n29 gnd__t29_b_n29 0 21.7106
rgnd_t30_b_n29 gnd__t30_b_n29 0 21.7106
rgnd_t31_b_n29 gnd__t31_b_n29 0 28.0185
rbl_0_t0_b_n29 bl_0__t0_b_n29 bl_0_b_n29 14.8304
rbl_0_t1_b_n29 bl_0__t1_b_n29 bl_0_b_n29 10.9301
rbl_0_t2_b_n29 bl_0__t2_b_n29 bl_0_b_n29 14.8304
rbl_0_t3_b_n29 bl_0__t3_b_n29 bl_0_b_n29 10.9301
rbl_1_t0_b_n29 bl_1__t0_b_n29 bl_1_b_n29 10.9301
rbl_1_t1_b_n29 bl_1__t1_b_n29 bl_1_b_n29 14.8304
rbl_1_t2_b_n29 bl_1__t2_b_n29 bl_1_b_n29 14.8304
rbl_1_t3_b_n29 bl_1__t3_b_n29 bl_1_b_n29 10.9301
rbl_2_t0_b_n29 bl_2__t0_b_n29 bl_2_b_n29 10.9301
rbl_2_t1_b_n29 bl_2__t1_b_n29 bl_2_b_n29 14.8304
rbl_2_t2_b_n29 bl_2__t2_b_n29 bl_2_b_n29 14.8304
rbl_2_t3_b_n29 bl_2__t3_b_n29 bl_2_b_n29 10.9301
rbl_3_t0_b_n29 bl_3__t0_b_n29 bl_3_b_n29 14.8304
rbl_3_t1_b_n29 bl_3__t1_b_n29 bl_3_b_n29 10.9301
rbl_3_t2_b_n29 bl_3__t2_b_n29 bl_3_b_n29 14.8304
rbl_3_t3_b_n29 bl_3__t3_b_n29 bl_3_b_n29 10.9301
rrbl_0_t0_b_n29 rbl_0__t0_b_n29 rbl_0_b_n29 36.5601
rrbl_0_t1_b_n29 rbl_0__t1_b_n29 rbl_0_b_n29 36.5601
rrbl_0_t2_b_n29 rbl_0__t2_b_n29 rbl_0_b_n29 2.99444
rrbl_0_t3_b_n29 rbl_0__t3_b_n29 rbl_0_b_n29 2.99444
rrbl_1_t0_b_n29 rbl_1__t0_b_n29 rbl_1_b_n29 36.5601
rrbl_1_t1_b_n29 rbl_1__t1_b_n29 rbl_1_b_n29 36.5601
rrbl_1_t2_b_n29 rbl_1__t2_b_n29 rbl_1_b_n29 2.99444
rrbl_1_t3_b_n29 rbl_1__t3_b_n29 rbl_1_b_n29 2.99444
rrbl_2_t0_b_n29 rbl_2__t0_b_n29 rbl_2_b_n29 36.5601
rrbl_2_t1_b_n29 rbl_2__t1_b_n29 rbl_2_b_n29 36.5601
rrbl_2_t2_b_n29 rbl_2__t2_b_n29 rbl_2_b_n29 2.99444
rrbl_2_t3_b_n29 rbl_2__t3_b_n29 rbl_2_b_n29 2.99444
rrbl_3_t0_b_n29 rbl_3__t0_b_n29 rbl_3_b_n29 36.5601
rrbl_3_t1_b_n29 rbl_3__t1_b_n29 rbl_3_b_n29 36.5601
rrbl_3_t2_b_n29 rbl_3__t2_b_n29 rbl_3_b_n29 2.99444
rrbl_3_t3_b_n29 rbl_3__t3_b_n29 rbl_3_b_n29 2.99444
rrwl_0_t0_b_n29 rwl_0__t0_b_n29 rwl_0_b_n29 38.2618
rrwl_0_t1_b_n29 rwl_0__t1_b_n29 rwl_0_b_n29 12.7539
rrwl_0_t2_b_n29 rwl_0__t2_b_n29 rwl_0_b_n29 38.2618
rrwl_0_t3_b_n29 rwl_0__t3_b_n29 rwl_0_b_n29 12.7539
rrwl_1_t0_b_n29 rwl_1__t0_b_n29 rwl_1_b_n29 38.2618
rrwl_1_t1_b_n29 rwl_1__t1_b_n29 rwl_1_b_n29 12.7539
rrwl_1_t2_b_n29 rwl_1__t2_b_n29 rwl_1_b_n29 12.7539
rrwl_1_t3_b_n29 rwl_1__t3_b_n29 rwl_1_b_n29 38.2618
rrwl_2_t0_b_n29 rwl_2__t0_b_n29 rwl_2_b_n29 12.7539
rrwl_2_t1_b_n29 rwl_2__t1_b_n29 rwl_2_b_n29 12.7539
rrwl_2_t2_b_n29 rwl_2__t2_b_n29 rwl_2_b_n29 38.2618
rrwl_2_t3_b_n29 rwl_2__t3_b_n29 rwl_2_b_n29 38.2618
rrwl_3_t0_b_n29 rwl_3__t0_b_n29 rwl_3_b_n29 38.2618
rrwl_3_t1_b_n29 rwl_3__t1_b_n29 rwl_3_b_n29 12.7539
rrwl_3_t2_b_n29 rwl_3__t2_b_n29 rwl_3_b_n29 12.7539
rrwl_3_t3_b_n29 rwl_3__t3_b_n29 rwl_3_b_n29 38.2618
rwl_0_t0_b_n29 wl_0__t0_b_n29 wl_0_b_n29 245.959
rwl_0_t1_b_n29 wl_0__t1_b_n29 wl_0_b_n29 245.959
rwl_0_t2_b_n29 wl_0__t2_b_n29 wl_0_b_n29 81.9864
rwl_0_t3_b_n29 wl_0__t3_b_n29 wl_0_b_n29 81.9864
rwl_1_t0_b_n29 wl_1__t0_b_n29 wl_1_b_n29 245.959
rwl_1_t1_b_n29 wl_1__t1_b_n29 wl_1_b_n29 81.9864
rwl_1_t2_b_n29 wl_1__t2_b_n29 wl_1_b_n29 81.9864
rwl_1_t3_b_n29 wl_1__t3_b_n29 wl_1_b_n29 245.959
rwl_2_t0_b_n29 wl_2__t0_b_n29 wl_2_b_n29 245.959
rwl_2_t1_b_n29 wl_2__t1_b_n29 wl_2_b_n29 81.9864
rwl_2_t2_b_n29 wl_2__t2_b_n29 wl_2_b_n29 81.9864
rwl_2_t3_b_n29 wl_2__t3_b_n29 wl_2_b_n29 245.959
rwl_3_t0_b_n29 wl_3__t0_b_n29 wl_3_b_n29 245.959
rwl_3_t1_b_n29 wl_3__t1_b_n29 wl_3_b_n29 81.9864
rwl_3_t2_b_n29 wl_3__t2_b_n29 wl_3_b_n29 81.9864
rwl_3_t3_b_n29 wl_3__t3_b_n29 wl_3_b_n29 245.959
c_10_b_n29 n10_b_n29 0 2.91622e-16
c_17_b_n29 n17_b_n29 0 2.91528e-16
c_18_b_n29 n18_b_n29 0 2.91528e-16
c_19_b_n29 n19_b_n29 0 2.91528e-16
c_20_b_n29 n20_b_n29 0 2.91622e-16
c_22_b_n29 n22_b_n29 0 2.91528e-16
c_23_b_n29 n23_b_n29 0 2.91528e-16
c_24_b_n29 n24_b_n29 0 2.91528e-16
c_25_b_n29 n25_b_n29 0 2.91622e-16
c_29_b_n29 n29_b_n29 0 2.91528e-16
c_30_b_n29 n30_b_n29 0 2.91528e-16
c_31_b_n29 n31_b_n29 0 2.91528e-16
c_32_b_n29 n32_b_n29 0 2.91622e-16
c_7_b_n29 n7_b_n29 0 2.91528e-16
c_8_b_n29 n8_b_n29 0 2.91528e-16
c_9_b_n29 n9_b_n29 0 2.91528e-16
cgnd_b_n29 0 0 2.48166e-15
cbl_0_b_n29 bl_0_b_n29 0 4.52661e-16
cbl_1_b_n29 bl_1_b_n29 0 4.52661e-16
cbl_2_b_n29 bl_2_b_n29 0 4.52661e-16
cbl_3_b_n29 bl_3_b_n29 0 4.52661e-16
crbl_0_b_n29 rbl_0_b_n29 0 9.14472e-16
crbl_1_b_n29 rbl_1_b_n29 0 9.14472e-16
crbl_2_b_n29 rbl_2_b_n29 0 9.14472e-16
crbl_3_b_n29 rbl_3_b_n29 0 9.17566e-16
crwl_0_b_n29 rwl_0_b_n29 0 5.19495e-16
crwl_1_b_n29 rwl_1_b_n29 0 5.11719e-16
crwl_2_b_n29 rwl_2_b_n29 0 5.11719e-16
crwl_3_b_n29 rwl_3_b_n29 0 5.19495e-16
cwl_0_b_n29 wl_0_b_n29 0 3.30388e-16
cwl_1_b_n29 wl_1_b_n29 0 3.30388e-16
cwl_2_b_n29 wl_2_b_n29 0 3.30388e-16
cwl_3_b_n29 wl_3_b_n29 0 3.30388e-16
ccc__10__9_b_n29 n10_b_n29 n9_b_n29 1.02e-17
ccc__10_bl_3_b_n29 n10_b_n29 bl_3_b_n29 1.3999e-17
ccc__10_rwl_0_b_n29 n10_b_n29 rwl_0_b_n29 4.335e-18
ccc__17__18_b_n29 n17_b_n29 n18_b_n29 1.02e-17
ccc__17_bl_0_b_n29 n17_b_n29 bl_0_b_n29 8.415e-18
ccc__17_rwl_1_b_n29 n17_b_n29 rwl_1_b_n29 1.3194e-17
ccc__18__19_b_n29 n18_b_n29 n19_b_n29 1.02e-17
ccc__18_bl_1_b_n29 n18_b_n29 bl_1_b_n29 8.415e-18
ccc__18_rwl_1_b_n29 n18_b_n29 rwl_1_b_n29 1.3194e-17
ccc__19__20_b_n29 n19_b_n29 n20_b_n29 1.02e-17
ccc__19_bl_2_b_n29 n19_b_n29 bl_2_b_n29 8.415e-18
ccc__19_rwl_1_b_n29 n19_b_n29 rwl_1_b_n29 1.3194e-17
ccc__20_bl_3_b_n29 n20_b_n29 bl_3_b_n29 8.415e-18
ccc__20_rwl_1_b_n29 n20_b_n29 rwl_1_b_n29 6.655e-18
ccc__22__23_b_n29 n22_b_n29 n23_b_n29 1.02e-17
ccc__22_bl_0_b_n29 n22_b_n29 bl_0_b_n29 8.415e-18
ccc__22_rwl_2_b_n29 n22_b_n29 rwl_2_b_n29 1.3194e-17
ccc__23__24_b_n29 n23_b_n29 n24_b_n29 1.02e-17
ccc__23_bl_1_b_n29 n23_b_n29 bl_1_b_n29 8.415e-18
ccc__23_rwl_2_b_n29 n23_b_n29 rwl_2_b_n29 1.3194e-17
ccc__24__25_b_n29 n24_b_n29 n25_b_n29 1.02e-17
ccc__24_bl_2_b_n29 n24_b_n29 bl_2_b_n29 8.415e-18
ccc__24_rwl_2_b_n29 n24_b_n29 rwl_2_b_n29 1.3194e-17
ccc__25_bl_3_b_n29 n25_b_n29 bl_3_b_n29 8.415e-18
ccc__25_rwl_2_b_n29 n25_b_n29 rwl_2_b_n29 6.655e-18
ccc__29__30_b_n29 n29_b_n29 n30_b_n29 1.02e-17
ccc__29_bl_0_b_n29 n29_b_n29 bl_0_b_n29 8.415e-18
ccc__29_rwl_3_b_n29 n29_b_n29 rwl_3_b_n29 1.3194e-17
ccc__30__31_b_n29 n30_b_n29 n31_b_n29 1.02e-17
ccc__30_bl_1_b_n29 n30_b_n29 bl_1_b_n29 8.415e-18
ccc__30_rwl_3_b_n29 n30_b_n29 rwl_3_b_n29 1.3194e-17
ccc__31__32_b_n29 n31_b_n29 n32_b_n29 1.02e-17
ccc__31_bl_2_b_n29 n31_b_n29 bl_2_b_n29 8.415e-18
ccc__31_rwl_3_b_n29 n31_b_n29 rwl_3_b_n29 1.3194e-17
ccc__32_bl_3_b_n29 n32_b_n29 bl_3_b_n29 8.415e-18
ccc__32_rwl_3_b_n29 n32_b_n29 rwl_3_b_n29 6.655e-18
ccc__7__8_b_n29 n7_b_n29 n8_b_n29 1.02e-17
ccc__7_bl_0_b_n29 n7_b_n29 bl_0_b_n29 1.3999e-17
ccc__7_rwl_0_b_n29 n7_b_n29 rwl_0_b_n29 8.961e-18
ccc__8__9_b_n29 n8_b_n29 n9_b_n29 1.02e-17
ccc__8_bl_1_b_n29 n8_b_n29 bl_1_b_n29 1.3999e-17
ccc__8_rwl_0_b_n29 n8_b_n29 rwl_0_b_n29 8.961e-18
ccc__9_bl_2_b_n29 n9_b_n29 bl_2_b_n29 1.3999e-17
ccc__9_rwl_0_b_n29 n9_b_n29 rwl_0_b_n29 8.961e-18
ccc_bl_0_rbl_0_b_n29 bl_0_b_n29 rbl_0_b_n29 1.88693e-16
ccc_bl_0_rwl_1_b_n29 bl_0_b_n29 rwl_1_b_n29 1.0093e-17
ccc_bl_0_rwl_2_b_n29 bl_0_b_n29 rwl_2_b_n29 1.0093e-17
ccc_bl_1_rbl_0_b_n29 bl_1_b_n29 rbl_0_b_n29 1.633e-16
ccc_bl_1_rbl_1_b_n29 bl_1_b_n29 rbl_1_b_n29 1.88693e-16
ccc_bl_1_rwl_1_b_n29 bl_1_b_n29 rwl_1_b_n29 1.0093e-17
ccc_bl_1_rwl_2_b_n29 bl_1_b_n29 rwl_2_b_n29 1.0093e-17
ccc_bl_2_rbl_1_b_n29 bl_2_b_n29 rbl_1_b_n29 1.633e-16
ccc_bl_2_rbl_2_b_n29 bl_2_b_n29 rbl_2_b_n29 1.88693e-16
ccc_bl_2_rwl_1_b_n29 bl_2_b_n29 rwl_1_b_n29 1.0093e-17
ccc_bl_2_rwl_2_b_n29 bl_2_b_n29 rwl_2_b_n29 1.0093e-17
ccc_bl_3_rbl_2_b_n29 bl_3_b_n29 rbl_2_b_n29 1.633e-16
ccc_bl_3_rbl_3_b_n29 bl_3_b_n29 rbl_3_b_n29 1.88693e-16
ccc_bl_3_rwl_1_b_n29 bl_3_b_n29 rwl_1_b_n29 1.0093e-17
ccc_bl_3_rwl_2_b_n29 bl_3_b_n29 rwl_2_b_n29 1.0093e-17
ccc_rbl_0_rbl_1_b_n29 rbl_0_b_n29 rbl_1_b_n29 3.432e-17
ccc_rbl_0_rwl_0_b_n29 rbl_0_b_n29 rwl_0_b_n29 4.9752e-17
ccc_rbl_0_rwl_1_b_n29 rbl_0_b_n29 rwl_1_b_n29 4.9752e-17
ccc_rbl_0_rwl_2_b_n29 rbl_0_b_n29 rwl_2_b_n29 4.9752e-17
ccc_rbl_0_rwl_3_b_n29 rbl_0_b_n29 rwl_3_b_n29 4.9752e-17
ccc_rbl_1_rbl_2_b_n29 rbl_1_b_n29 rbl_2_b_n29 3.432e-17
ccc_rbl_1_rwl_0_b_n29 rbl_1_b_n29 rwl_0_b_n29 4.9752e-17
ccc_rbl_1_rwl_1_b_n29 rbl_1_b_n29 rwl_1_b_n29 4.9752e-17
ccc_rbl_1_rwl_2_b_n29 rbl_1_b_n29 rwl_2_b_n29 4.9752e-17
ccc_rbl_1_rwl_3_b_n29 rbl_1_b_n29 rwl_3_b_n29 4.9752e-17
ccc_rbl_2_rbl_3_b_n29 rbl_2_b_n29 rbl_3_b_n29 3.432e-17
ccc_rbl_2_rwl_0_b_n29 rbl_2_b_n29 rwl_0_b_n29 4.9752e-17
ccc_rbl_2_rwl_1_b_n29 rbl_2_b_n29 rwl_1_b_n29 4.9752e-17
ccc_rbl_2_rwl_2_b_n29 rbl_2_b_n29 rwl_2_b_n29 4.9752e-17
ccc_rbl_2_rwl_3_b_n29 rbl_2_b_n29 rwl_3_b_n29 4.9752e-17
ccc_rbl_3_rwl_0_b_n29 rbl_3_b_n29 rwl_0_b_n29 3.3407e-17
ccc_rbl_3_rwl_1_b_n29 rbl_3_b_n29 rwl_1_b_n29 3.3407e-17
ccc_rbl_3_rwl_2_b_n29 rbl_3_b_n29 rwl_2_b_n29 3.3407e-17
ccc_rbl_3_rwl_3_b_n29 rbl_3_b_n29 rwl_3_b_n29 3.3407e-17
vdw_b_n29_0 wl_0_b_n29 0 dc 0
vdr_b_n29_0 rwl_0_b_n29 0 dc 0
vdw_b_n29_1 wl_1_b_n29 0 dc 0
vdr_b_n29_1 rwl_1_b_n29 0 dc 0
vdw_b_n29_2 wl_2_b_n29 0 dc 0
vdr_b_n29_2 rwl_2_b_n29 0 dc 0
vdw_b_n29_3 wl_3_b_n29 0 dc 0
vdr_b_n29_3 rwl_3_b_n29 0 dc 0
vdb_b_n29_0 bl_0_b_n29 0 dc 0
vdp_b_n29_0 rbl_0_b_n29 0 dc 0
vdb_b_n29_1 bl_1_b_n29 0 dc 0
vdp_b_n29_1 rbl_1_b_n29 0 dc 0
vdb_b_n29_2 bl_2_b_n29 0 dc 0
vdp_b_n29_2 rbl_2_b_n29 0 dc 0
vdb_b_n29_3 bl_3_b_n29 0 dc 0
vdp_b_n29_3 rbl_3_b_n29 0 dc 0
vdn_b_n29_n7 n7_b_n29 0 dc 1
vdn_b_n29_n8 n8_b_n29 0 dc 1
vdn_b_n29_n9 n9_b_n29 0 dc 1
vdn_b_n29_n10 n10_b_n29 0 dc 1
vdn_b_n29_n17 n17_b_n29 0 dc 1
vdn_b_n29_n18 n18_b_n29 0 dc 1
vdn_b_n29_n19 n19_b_n29 0 dc 1
vdn_b_n29_n20 n20_b_n29 0 dc 1
vdn_b_n29_n22 n22_b_n29 0 dc 1
vdn_b_n29_n23 n23_b_n29 0 dc 1
vdn_b_n29_n24 n24_b_n29 0 dc 1
vdn_b_n29_n25 n25_b_n29 0 dc 1
vdn_b_n29_n30 n30_b_n29 0 dc 1
vdn_b_n29_n31 n31_b_n29 0 dc 1
vdn_b_n29_n32 n32_b_n29 0 dc 1
bdr_b_n29 n29_b_n29 0 i=5e-08*min(1,max(0,(time-1e-09)/0.2n))*0.5*(1+tanh((v(n29_b_n29)-0.05)/0.01))

* ---- instance b_n30: variant b, probed storage node \$30 ----
xm1_b_n30 rwl_0__t2_b_n30 n7__t0_b_n30 rbl_0__t0_b_n30 gnd__t0_b_n30 sky130_fd_pr__nfet_01v8 L=0.15 W=0.42 nf=1 ad=0.1197 as=0.1197 pd=1.41 ps=1.41 mult=1 m=1
xm2_b_n30 rwl_0__t3_b_n30 n8__t1_b_n30 rbl_1__t1_b_n30 gnd__t1_b_n30 sky130_fd_pr__nfet_01v8 L=0.15 W=0.42 nf=1 ad=0.1197 as=0.1197 pd=1.41 ps=1.41 mult=1 m=1
xm3_b_n30 rwl_0__t1_b_n30 n9__t1_b_n30 rbl_2__t1_b_n30 gnd__t2_b_n30 sky130_fd_pr__nfet_01v8 L=0.15 W=0.42 nf=1 ad=0.1197 as=0.1197 pd=1.41 ps=1.41 mult=1 m=1
xm4_b_n30 rwl_0__t0_b_n30 n10__t1_b_n30 rbl_3__t1_b_n30 gnd__t3_b_n30 sky130_fd_pr__nfet_01v8 L=0.15 W=0.42 nf=1 ad=0.1197 as=0.1197 pd=1.41 ps=1.41 mult=1 m=1
xm5_b_n30 bl_0__t0_b_n30 wl_0__t0_b_n30 n7__t1_b_n30 gnd__t8_b_n30 sky130_fd_pr__nfet_01v8 L=0.15 W=0.42 nf=1 ad=0.0588 as=0.1197 pd=0.7 ps=1.41 mult=1 m=1
xm6_b_n30 n17__t0_b_n30 wl_1__t0_b_n30 bl_0__t1_b_n30 gnd__t20_b_n30 sky130_fd_pr__nfet_01v8 L=0.15 W=0.42 nf=1 ad=0.1197 as=0.0588 pd=1.41 ps=0.7 mult=1 m=1
xm7_b_n30 bl_1__t2_b_n30 wl_0__t3_b_n30 n8__t0_b_n30 gnd__t9_b_n30 sky130_fd_pr__nfet_01v8 L=0.15 W=0.42 nf=1 ad=0.0588 as=0.1197 pd=0.7 ps=1.41 mult=1 m=1
xm8_b_n30 n18__t0_b_n30 wl_1__t1_b_n30 bl_1__t0_b_n30 gnd__t21_b_n30 sky130_fd_pr__nfet_01v8 L=0.15 W=0.42 nf=1 ad=0.1197 as=0.0588 pd=1.41 ps=0.7 mult=1 m=1
xm9_b_n30 bl_2__t2_b_n30 wl_0__t2_b_n30 n9__t0_b_n30 gnd__t10_b_n30 sky130_fd_pr__nfet_01v8 L=0.15 W=0.42 nf=1 ad=0.0588 as=0.1197 pd=0.7 ps=1.41 mult=1 m=1
xm10_b_n30 n19__t0_b_n30 wl_1__t2_b_n30 bl_2__t0_b_n30 gnd__t22_b_n30 sky130_fd_pr__nfet_01v8 L=0.15 W=0.42 nf=1 ad=0.1197 as=0.0588 pd=1.41 ps=0.7 mult=1 m=1
xm11_b_n30 bl_3__t2_b_n30 wl_0__t1_b_n30 n10__t0_b_n30 gnd__t11_b_n30 sky130_fd_pr__nfet_01v8 L=0.15 W=0.42 nf=1 ad=0.0588 as=0.1197 pd=0.7 ps=1.41 mult=1 m=1
xm12_b_n30 n20__t0_b_n30 wl_1__t3_b_n30 bl_3__t1_b_n30 gnd__t23_b_n30 sky130_fd_pr__nfet_01v8 L=0.15 W=0.42 nf=1 ad=0.1197 as=0.0588 pd=1.41 ps=0.7 mult=1 m=1
xm13_b_n30 rbl_0__t3_b_n30 n17__t1_b_n30 rwl_1__t0_b_n30 gnd__t12_b_n30 sky130_fd_pr__nfet_01v8 L=0.15 W=0.42 nf=1 ad=0.0588 as=0.1197 pd=0.7 ps=1.41 mult=1 m=1
xm14_b_n30 rwl_2__t3_b_n30 n22__t0_b_n30 rbl_0__t2_b_n30 gnd__t24_b_n30 sky130_fd_pr__nfet_01v8 L=0.15 W=0.42 nf=1 ad=0.1197 as=0.0588 pd=1.41 ps=0.7 mult=1 m=1
xm15_b_n30 rbl_1__t3_b_n30 n18__t1_b_n30 rwl_1__t1_b_n30 gnd__t13_b_n30 sky130_fd_pr__nfet_01v8 L=0.15 W=0.42 nf=1 ad=0.0588 as=0.1197 pd=0.7 ps=1.41 mult=1 m=1
xm16_b_n30 rwl_2__t0_b_n30 n23__t0_b_n30 rbl_1__t2_b_n30 gnd__t25_b_n30 sky130_fd_pr__nfet_01v8 L=0.15 W=0.42 nf=1 ad=0.1197 as=0.0588 pd=1.41 ps=0.7 mult=1 m=1
xm17_b_n30 rbl_2__t3_b_n30 n19__t1_b_n30 rwl_1__t2_b_n30 gnd__t14_b_n30 sky130_fd_pr__nfet_01v8 L=0.15 W=0.42 nf=1 ad=0.0588 as=0.1197 pd=0.7 ps=1.41 mult=1 m=1
xm18_b_n30 rwl_2__t1_b_n30 n24__t0_b_n30 rbl_2__t2_b_n30 gnd__t26_b_n30 sky130_fd_pr__nfet_01v8 L=0.15 W=0.42 nf=1 ad=0.1197 as=0.0588 pd=1.41 ps=0.7 mult=1 m=1
xm19_b_n30 rbl_3__t3_b_n30 n20__t1_b_n30 rwl_1__t3_b_n30 gnd__t15_b_n30 sky130_fd_pr__nfet_01v8 L=0.15 W=0.42 nf=1 ad=0.0588 as=0.1197 pd=0.7 ps=1.41 mult=1 m=1
xm20_b_n30 rwl_2__t2_b_n30 n25__t0_b_n30 rbl_3__t2_b_n30 gnd__t27_b_n30 sky130_fd_pr__nfet_01v8 L=0.15 W=0.42 nf=1 ad=0.1197 as=0.0588 pd=1.41 ps=0.7 mult=1 m=1
xm21_b_n30 bl_0__t3_b_n30 wl_2__t0_b_n30 n22__t1_b_n30 gnd__t16_b_n30 sky130_fd_pr__nfet_01v8 L=0.15 W=0.42 nf=1 ad=0.0588 as=0.1197 pd=0.7 ps=1.41 mult=1 m=1
xm22_b_n30 n29__t0_b_n30 wl_3__t3_b_n30 bl_0__t2_b_n30 gnd__t28_b_n30 sky130_fd_pr__nfet_01v8 L=0.15 W=0.42 nf=1 ad=0.1197 as=0.0588 pd=1.41 ps=0.7 mult=1 m=1
xm23_b_n30 bl_1__t3_b_n30 wl_2__t1_b_n30 n23__t1_b_n30 gnd__t17_b_n30 sky130_fd_pr__nfet_01v8 L=0.15 W=0.42 nf=1 ad=0.0588 as=0.1197 pd=0.7 ps=1.41 mult=1 m=1
xm24_b_n30 n30__t0_b_n30 wl_3__t2_b_n30 bl_1__t1_b_n30 gnd__t29_b_n30 sky130_fd_pr__nfet_01v8 L=0.15 W=0.42 nf=1 ad=0.1197 as=0.0588 pd=1.41 ps=0.7 mult=1 m=1
xm25_b_n30 bl_2__t3_b_n30 wl_2__t2_b_n30 n24__t1_b_n30 gnd__t18_b_n30 sky130_fd_pr__nfet_01v8 L=0.15 W=0.42 nf=1 ad=0.0588 as=0.1197 pd=0.7 ps=1.41 mult=1 m=1
xm26_b_n30 n31__t0_b_n30 wl_3__t1_b_n30 bl_2__t1_b_n30 gnd__t30_b_n30 sky130_fd_pr__nfet_01v8 L=0.15 W=0.42 nf=1 ad=0.1197 as=0.0588 pd=1.41 ps=0.7 mult=1 m=1
xm27_b_n30 bl_3__t3_b_n30 wl_2__t3_b_n30 n25__t1_b_n30 gnd__t19_b_n30 sky130_fd_pr__nfet_01v8 L=0.15 W=0.42 nf=1 ad=0.0588 as=0.1197 pd=0.7 ps=1.41 mult=1 m=1
xm28_b_n30 n32__t0_b_n30 wl_3__t0_b_n30 bl_3__t0_b_n30 gnd__t31_b_n30 sky130_fd_pr__nfet_01v8 L=0.15 W=0.42 nf=1 ad=0.1197 as=0.0588 pd=1.41 ps=0.7 mult=1 m=1
xm29_b_n30 rbl_0__t1_b_n30 n29__t1_b_n30 rwl_3__t0_b_n30 gnd__t4_b_n30 sky130_fd_pr__nfet_01v8 L=0.15 W=0.42 nf=1 ad=0.1197 as=0.1197 pd=1.41 ps=1.41 mult=1 m=1
xm30_b_n30 rbl_1__t0_b_n30 n30__t1_b_n30 rwl_3__t1_b_n30 gnd__t5_b_n30 sky130_fd_pr__nfet_01v8 L=0.15 W=0.42 nf=1 ad=0.1197 as=0.1197 pd=1.41 ps=1.41 mult=1 m=1
xm31_b_n30 rbl_2__t0_b_n30 n31__t1_b_n30 rwl_3__t2_b_n30 gnd__t6_b_n30 sky130_fd_pr__nfet_01v8 L=0.15 W=0.42 nf=1 ad=0.1197 as=0.1197 pd=1.41 ps=1.41 mult=1 m=1
xm32_b_n30 rbl_3__t0_b_n30 n32__t1_b_n30 rwl_3__t3_b_n30 gnd__t7_b_n30 sky130_fd_pr__nfet_01v8 L=0.15 W=0.42 nf=1 ad=0.1197 as=0.1197 pd=1.41 ps=1.41 mult=1 m=1
r_10_t0_b_n30 n10__t0_b_n30 n10_b_n30 183.071
r_10_t1_b_n30 n10__t1_b_n30 n10_b_n30 183.071
r_17_t0_b_n30 n17__t0_b_n30 n17_b_n30 183.071
r_17_t1_b_n30 n17__t1_b_n30 n17_b_n30 183.071
r_18_t0_b_n30 n18__t0_b_n30 n18_b_n30 183.071
r_18_t1_b_n30 n18__t1_b_n30 n18_b_n30 183.071
r_19_t0_b_n30 n19__t0_b_n30 n19_b_n30 183.071
r_19_t1_b_n30 n19__t1_b_n30 n19_b_n30 183.071
r_20_t0_b_n30 n20__t0_b_n30 n20_b_n30 183.071
r_20_t1_b_n30 n20__t1_b_n30 n20_b_n30 183.071
r_22_t0_b_n30 n22__t0_b_n30 n22_b_n30 183.071
r_22_t1_b_n30 n22__t1_b_n30 n22_b_n30 183.071
r_23_t0_b_n30 n23__t0_b_n30 n23_b_n30 183.071
r_23_t1_b_n30 n23__t1_b_n30 n23_b_n30 183.071
r_24_t0_b_n30 n24__t0_b_n30 n24_b_n30 183.071
r_24_t1_b_n30 n24__t1_b_n30 n24_b_n30 183.071
r_25_t0_b_n30 n25__t0_b_n30 n25_b_n30 183.071
r_25_t1_b_n30 n25__t1_b_n30 n25_b_n30 183.071
r_29_t0_b_n30 n29__t0_b_n30 n29_b_n30 183.071
r_29_t1_b_n30 n29__t1_b_n30 n29_b_n30 183.071
r_30_t0_b_n30 n30__t0_b_n30 n30_b_n30 183.071
r_30_t1_b_n30 n30__t1_b_n30 n30_b_n30 183.071
r_31_t0_b_n30 n31__t0_b_n30 n31_b_n30 183.071
r_31_t1_b_n30 n31__t1_b_n30 n31_b_n30 183.071
r_32_t0_b_n30 n32__t0_b_n30 n32_b_n30 183.071
r_32_t1_b_n30 n32__t1_b_n30 n32_b_n30 183.071
r_7_t0_b_n30 n7__t0_b_n30 n7_b_n30 183.071
r_7_t1_b_n30 n7__t1_b_n30 n7_b_n30 183.071
r_8_t0_b_n30 n8__t0_b_n30 n8_b_n30 183.071
r_8_t1_b_n30 n8__t1_b_n30 n8_b_n30 183.071
r_9_t0_b_n30 n9__t0_b_n30 n9_b_n30 183.071
r_9_t1_b_n30 n9__t1_b_n30 n9_b_n30 183.071
rgnd_t0_b_n30 gnd__t0_b_n30 0 38.2988
rgnd_t1_b_n30 gnd__t1_b_n30 0 33.9576
rgnd_t2_b_n30 gnd__t2_b_n30 0 33.9576
rgnd_t3_b_n30 gnd__t3_b_n30 0 38.2988
rgnd_t4_b_n30 gnd__t4_b_n30 0 38.2988
rgnd_t5_b_n30 gnd__t5_b_n30 0 33.9576
rgnd_t6_b_n30 gnd__t6_b_n30 0 33.9576
rgnd_t7_b_n30 gnd__t7_b_n30 0 38.2988
rgnd_t8_b_n30 gnd__t8_b_n30 0 28.0185
rgnd_t9_b_n30 gnd__t9_b_n30 0 21.7106
rgnd_t10_b_n30 gnd__t10_b_n30 0 21.7106
rgnd_t11_b_n30 gnd__t11_b_n30 0 28.0185
rgnd_t12_b_n30 gnd__t12_b_n30 0 18.9833
rgnd_t13_b_n30 gnd__t13_b_n30 0 6.8325
rgnd_t14_b_n30 gnd__t14_b_n30 0 6.8325
rgnd_t15_b_n30 gnd__t15_b_n30 0 18.9833
rgnd_t16_b_n30 gnd__t16_b_n30 0 24.2409
rgnd_t17_b_n30 gnd__t17_b_n30 0 16.5511
rgnd_t18_b_n30 gnd__t18_b_n30 0 16.5511
rgnd_t19_b_n30 gnd__t19_b_n30 0 24.2409
rgnd_t20_b_n30 gnd__t20_b_n30 0 24.2409
rgnd_t21_b_n30 gnd__t21_b_n30 0 16.5511
rgnd_t22_b_n30 gnd__t22_b_n30 0 16.5511
rgnd_t23_b_n30 gnd__t23_b_n30 0 24.2409
rgnd_t24_b_n30 gnd__t24_b_n30 0 18.9833
rgnd_t25_b_n30 gnd__t25_b_n30 0 6.8325
rgnd_t26_b_n30 gnd__t26_b_n30 0 6.8325
rgnd_t27_b_n30 gnd__t27_b_n30 0 18.9833
rgnd_t28_b_n30 gnd__t28_b_n30 0 28.0185
rgnd_t29_b_n30 gnd__t29_b_n30 0 21.7106
rgnd_t30_b_n30 gnd__t30_b_n30 0 21.7106
rgnd_t31_b_n30 gnd__t31_b_n30 0 28.0185
rbl_0_t0_b_n30 bl_0__t0_b_n30 bl_0_b_n30 14.8304
rbl_0_t1_b_n30 bl_0__t1_b_n30 bl_0_b_n30 10.9301
rbl_0_t2_b_n30 bl_0__t2_b_n30 bl_0_b_n30 14.8304
rbl_0_t3_b_n30 bl_0__t3_b_n30 bl_0_b_n30 10.9301
rbl_1_t0_b_n30 bl_1__t0_b_n30 bl_1_b_n30 10.9301
rbl_1_t1_b_n30 bl_1__t1_b_n30 bl_1_b_n30 14.8304
rbl_1_t2_b_n30 bl_1__t2_b_n30 bl_1_b_n30 14.8304
rbl_1_t3_b_n30 bl_1__t3_b_n30 bl_1_b_n30 10.9301
rbl_2_t0_b_n30 bl_2__t0_b_n30 bl_2_b_n30 10.9301
rbl_2_t1_b_n30 bl_2__t1_b_n30 bl_2_b_n30 14.8304
rbl_2_t2_b_n30 bl_2__t2_b_n30 bl_2_b_n30 14.8304
rbl_2_t3_b_n30 bl_2__t3_b_n30 bl_2_b_n30 10.9301
rbl_3_t0_b_n30 bl_3__t0_b_n30 bl_3_b_n30 14.8304
rbl_3_t1_b_n30 bl_3__t1_b_n30 bl_3_b_n30 10.9301
rbl_3_t2_b_n30 bl_3__t2_b_n30 bl_3_b_n30 14.8304
rbl_3_t3_b_n30 bl_3__t3_b_n30 bl_3_b_n30 10.9301
rrbl_0_t0_b_n30 rbl_0__t0_b_n30 rbl_0_b_n30 36.5601
rrbl_0_t1_b_n30 rbl_0__t1_b_n30 rbl_0_b_n30 36.5601
rrbl_0_t2_b_n30 rbl_0__t2_b_n30 rbl_0_b_n30 2.99444
rrbl_0_t3_b_n30 rbl_0__t3_b_n30 rbl_0_b_n30 2.99444
rrbl_1_t0_b_n30 rbl_1__t0_b_n30 rbl_1_b_n30 36.5601
rrbl_1_t1_b_n30 rbl_1__t1_b_n30 rbl_1_b_n30 36.5601
rrbl_1_t2_b_n30 rbl_1__t2_b_n30 rbl_1_b_n30 2.99444
rrbl_1_t3_b_n30 rbl_1__t3_b_n30 rbl_1_b_n30 2.99444
rrbl_2_t0_b_n30 rbl_2__t0_b_n30 rbl_2_b_n30 36.5601
rrbl_2_t1_b_n30 rbl_2__t1_b_n30 rbl_2_b_n30 36.5601
rrbl_2_t2_b_n30 rbl_2__t2_b_n30 rbl_2_b_n30 2.99444
rrbl_2_t3_b_n30 rbl_2__t3_b_n30 rbl_2_b_n30 2.99444
rrbl_3_t0_b_n30 rbl_3__t0_b_n30 rbl_3_b_n30 36.5601
rrbl_3_t1_b_n30 rbl_3__t1_b_n30 rbl_3_b_n30 36.5601
rrbl_3_t2_b_n30 rbl_3__t2_b_n30 rbl_3_b_n30 2.99444
rrbl_3_t3_b_n30 rbl_3__t3_b_n30 rbl_3_b_n30 2.99444
rrwl_0_t0_b_n30 rwl_0__t0_b_n30 rwl_0_b_n30 38.2618
rrwl_0_t1_b_n30 rwl_0__t1_b_n30 rwl_0_b_n30 12.7539
rrwl_0_t2_b_n30 rwl_0__t2_b_n30 rwl_0_b_n30 38.2618
rrwl_0_t3_b_n30 rwl_0__t3_b_n30 rwl_0_b_n30 12.7539
rrwl_1_t0_b_n30 rwl_1__t0_b_n30 rwl_1_b_n30 38.2618
rrwl_1_t1_b_n30 rwl_1__t1_b_n30 rwl_1_b_n30 12.7539
rrwl_1_t2_b_n30 rwl_1__t2_b_n30 rwl_1_b_n30 12.7539
rrwl_1_t3_b_n30 rwl_1__t3_b_n30 rwl_1_b_n30 38.2618
rrwl_2_t0_b_n30 rwl_2__t0_b_n30 rwl_2_b_n30 12.7539
rrwl_2_t1_b_n30 rwl_2__t1_b_n30 rwl_2_b_n30 12.7539
rrwl_2_t2_b_n30 rwl_2__t2_b_n30 rwl_2_b_n30 38.2618
rrwl_2_t3_b_n30 rwl_2__t3_b_n30 rwl_2_b_n30 38.2618
rrwl_3_t0_b_n30 rwl_3__t0_b_n30 rwl_3_b_n30 38.2618
rrwl_3_t1_b_n30 rwl_3__t1_b_n30 rwl_3_b_n30 12.7539
rrwl_3_t2_b_n30 rwl_3__t2_b_n30 rwl_3_b_n30 12.7539
rrwl_3_t3_b_n30 rwl_3__t3_b_n30 rwl_3_b_n30 38.2618
rwl_0_t0_b_n30 wl_0__t0_b_n30 wl_0_b_n30 245.959
rwl_0_t1_b_n30 wl_0__t1_b_n30 wl_0_b_n30 245.959
rwl_0_t2_b_n30 wl_0__t2_b_n30 wl_0_b_n30 81.9864
rwl_0_t3_b_n30 wl_0__t3_b_n30 wl_0_b_n30 81.9864
rwl_1_t0_b_n30 wl_1__t0_b_n30 wl_1_b_n30 245.959
rwl_1_t1_b_n30 wl_1__t1_b_n30 wl_1_b_n30 81.9864
rwl_1_t2_b_n30 wl_1__t2_b_n30 wl_1_b_n30 81.9864
rwl_1_t3_b_n30 wl_1__t3_b_n30 wl_1_b_n30 245.959
rwl_2_t0_b_n30 wl_2__t0_b_n30 wl_2_b_n30 245.959
rwl_2_t1_b_n30 wl_2__t1_b_n30 wl_2_b_n30 81.9864
rwl_2_t2_b_n30 wl_2__t2_b_n30 wl_2_b_n30 81.9864
rwl_2_t3_b_n30 wl_2__t3_b_n30 wl_2_b_n30 245.959
rwl_3_t0_b_n30 wl_3__t0_b_n30 wl_3_b_n30 245.959
rwl_3_t1_b_n30 wl_3__t1_b_n30 wl_3_b_n30 81.9864
rwl_3_t2_b_n30 wl_3__t2_b_n30 wl_3_b_n30 81.9864
rwl_3_t3_b_n30 wl_3__t3_b_n30 wl_3_b_n30 245.959
c_10_b_n30 n10_b_n30 0 2.91622e-16
c_17_b_n30 n17_b_n30 0 2.91528e-16
c_18_b_n30 n18_b_n30 0 2.91528e-16
c_19_b_n30 n19_b_n30 0 2.91528e-16
c_20_b_n30 n20_b_n30 0 2.91622e-16
c_22_b_n30 n22_b_n30 0 2.91528e-16
c_23_b_n30 n23_b_n30 0 2.91528e-16
c_24_b_n30 n24_b_n30 0 2.91528e-16
c_25_b_n30 n25_b_n30 0 2.91622e-16
c_29_b_n30 n29_b_n30 0 2.91528e-16
c_30_b_n30 n30_b_n30 0 2.91528e-16
c_31_b_n30 n31_b_n30 0 2.91528e-16
c_32_b_n30 n32_b_n30 0 2.91622e-16
c_7_b_n30 n7_b_n30 0 2.91528e-16
c_8_b_n30 n8_b_n30 0 2.91528e-16
c_9_b_n30 n9_b_n30 0 2.91528e-16
cgnd_b_n30 0 0 2.48166e-15
cbl_0_b_n30 bl_0_b_n30 0 4.52661e-16
cbl_1_b_n30 bl_1_b_n30 0 4.52661e-16
cbl_2_b_n30 bl_2_b_n30 0 4.52661e-16
cbl_3_b_n30 bl_3_b_n30 0 4.52661e-16
crbl_0_b_n30 rbl_0_b_n30 0 9.14472e-16
crbl_1_b_n30 rbl_1_b_n30 0 9.14472e-16
crbl_2_b_n30 rbl_2_b_n30 0 9.14472e-16
crbl_3_b_n30 rbl_3_b_n30 0 9.17566e-16
crwl_0_b_n30 rwl_0_b_n30 0 5.19495e-16
crwl_1_b_n30 rwl_1_b_n30 0 5.11719e-16
crwl_2_b_n30 rwl_2_b_n30 0 5.11719e-16
crwl_3_b_n30 rwl_3_b_n30 0 5.19495e-16
cwl_0_b_n30 wl_0_b_n30 0 3.30388e-16
cwl_1_b_n30 wl_1_b_n30 0 3.30388e-16
cwl_2_b_n30 wl_2_b_n30 0 3.30388e-16
cwl_3_b_n30 wl_3_b_n30 0 3.30388e-16
ccc__10__9_b_n30 n10_b_n30 n9_b_n30 1.02e-17
ccc__10_bl_3_b_n30 n10_b_n30 bl_3_b_n30 1.3999e-17
ccc__10_rwl_0_b_n30 n10_b_n30 rwl_0_b_n30 4.335e-18
ccc__17__18_b_n30 n17_b_n30 n18_b_n30 1.02e-17
ccc__17_bl_0_b_n30 n17_b_n30 bl_0_b_n30 8.415e-18
ccc__17_rwl_1_b_n30 n17_b_n30 rwl_1_b_n30 1.3194e-17
ccc__18__19_b_n30 n18_b_n30 n19_b_n30 1.02e-17
ccc__18_bl_1_b_n30 n18_b_n30 bl_1_b_n30 8.415e-18
ccc__18_rwl_1_b_n30 n18_b_n30 rwl_1_b_n30 1.3194e-17
ccc__19__20_b_n30 n19_b_n30 n20_b_n30 1.02e-17
ccc__19_bl_2_b_n30 n19_b_n30 bl_2_b_n30 8.415e-18
ccc__19_rwl_1_b_n30 n19_b_n30 rwl_1_b_n30 1.3194e-17
ccc__20_bl_3_b_n30 n20_b_n30 bl_3_b_n30 8.415e-18
ccc__20_rwl_1_b_n30 n20_b_n30 rwl_1_b_n30 6.655e-18
ccc__22__23_b_n30 n22_b_n30 n23_b_n30 1.02e-17
ccc__22_bl_0_b_n30 n22_b_n30 bl_0_b_n30 8.415e-18
ccc__22_rwl_2_b_n30 n22_b_n30 rwl_2_b_n30 1.3194e-17
ccc__23__24_b_n30 n23_b_n30 n24_b_n30 1.02e-17
ccc__23_bl_1_b_n30 n23_b_n30 bl_1_b_n30 8.415e-18
ccc__23_rwl_2_b_n30 n23_b_n30 rwl_2_b_n30 1.3194e-17
ccc__24__25_b_n30 n24_b_n30 n25_b_n30 1.02e-17
ccc__24_bl_2_b_n30 n24_b_n30 bl_2_b_n30 8.415e-18
ccc__24_rwl_2_b_n30 n24_b_n30 rwl_2_b_n30 1.3194e-17
ccc__25_bl_3_b_n30 n25_b_n30 bl_3_b_n30 8.415e-18
ccc__25_rwl_2_b_n30 n25_b_n30 rwl_2_b_n30 6.655e-18
ccc__29__30_b_n30 n29_b_n30 n30_b_n30 1.02e-17
ccc__29_bl_0_b_n30 n29_b_n30 bl_0_b_n30 8.415e-18
ccc__29_rwl_3_b_n30 n29_b_n30 rwl_3_b_n30 1.3194e-17
ccc__30__31_b_n30 n30_b_n30 n31_b_n30 1.02e-17
ccc__30_bl_1_b_n30 n30_b_n30 bl_1_b_n30 8.415e-18
ccc__30_rwl_3_b_n30 n30_b_n30 rwl_3_b_n30 1.3194e-17
ccc__31__32_b_n30 n31_b_n30 n32_b_n30 1.02e-17
ccc__31_bl_2_b_n30 n31_b_n30 bl_2_b_n30 8.415e-18
ccc__31_rwl_3_b_n30 n31_b_n30 rwl_3_b_n30 1.3194e-17
ccc__32_bl_3_b_n30 n32_b_n30 bl_3_b_n30 8.415e-18
ccc__32_rwl_3_b_n30 n32_b_n30 rwl_3_b_n30 6.655e-18
ccc__7__8_b_n30 n7_b_n30 n8_b_n30 1.02e-17
ccc__7_bl_0_b_n30 n7_b_n30 bl_0_b_n30 1.3999e-17
ccc__7_rwl_0_b_n30 n7_b_n30 rwl_0_b_n30 8.961e-18
ccc__8__9_b_n30 n8_b_n30 n9_b_n30 1.02e-17
ccc__8_bl_1_b_n30 n8_b_n30 bl_1_b_n30 1.3999e-17
ccc__8_rwl_0_b_n30 n8_b_n30 rwl_0_b_n30 8.961e-18
ccc__9_bl_2_b_n30 n9_b_n30 bl_2_b_n30 1.3999e-17
ccc__9_rwl_0_b_n30 n9_b_n30 rwl_0_b_n30 8.961e-18
ccc_bl_0_rbl_0_b_n30 bl_0_b_n30 rbl_0_b_n30 1.88693e-16
ccc_bl_0_rwl_1_b_n30 bl_0_b_n30 rwl_1_b_n30 1.0093e-17
ccc_bl_0_rwl_2_b_n30 bl_0_b_n30 rwl_2_b_n30 1.0093e-17
ccc_bl_1_rbl_0_b_n30 bl_1_b_n30 rbl_0_b_n30 1.633e-16
ccc_bl_1_rbl_1_b_n30 bl_1_b_n30 rbl_1_b_n30 1.88693e-16
ccc_bl_1_rwl_1_b_n30 bl_1_b_n30 rwl_1_b_n30 1.0093e-17
ccc_bl_1_rwl_2_b_n30 bl_1_b_n30 rwl_2_b_n30 1.0093e-17
ccc_bl_2_rbl_1_b_n30 bl_2_b_n30 rbl_1_b_n30 1.633e-16
ccc_bl_2_rbl_2_b_n30 bl_2_b_n30 rbl_2_b_n30 1.88693e-16
ccc_bl_2_rwl_1_b_n30 bl_2_b_n30 rwl_1_b_n30 1.0093e-17
ccc_bl_2_rwl_2_b_n30 bl_2_b_n30 rwl_2_b_n30 1.0093e-17
ccc_bl_3_rbl_2_b_n30 bl_3_b_n30 rbl_2_b_n30 1.633e-16
ccc_bl_3_rbl_3_b_n30 bl_3_b_n30 rbl_3_b_n30 1.88693e-16
ccc_bl_3_rwl_1_b_n30 bl_3_b_n30 rwl_1_b_n30 1.0093e-17
ccc_bl_3_rwl_2_b_n30 bl_3_b_n30 rwl_2_b_n30 1.0093e-17
ccc_rbl_0_rbl_1_b_n30 rbl_0_b_n30 rbl_1_b_n30 3.432e-17
ccc_rbl_0_rwl_0_b_n30 rbl_0_b_n30 rwl_0_b_n30 4.9752e-17
ccc_rbl_0_rwl_1_b_n30 rbl_0_b_n30 rwl_1_b_n30 4.9752e-17
ccc_rbl_0_rwl_2_b_n30 rbl_0_b_n30 rwl_2_b_n30 4.9752e-17
ccc_rbl_0_rwl_3_b_n30 rbl_0_b_n30 rwl_3_b_n30 4.9752e-17
ccc_rbl_1_rbl_2_b_n30 rbl_1_b_n30 rbl_2_b_n30 3.432e-17
ccc_rbl_1_rwl_0_b_n30 rbl_1_b_n30 rwl_0_b_n30 4.9752e-17
ccc_rbl_1_rwl_1_b_n30 rbl_1_b_n30 rwl_1_b_n30 4.9752e-17
ccc_rbl_1_rwl_2_b_n30 rbl_1_b_n30 rwl_2_b_n30 4.9752e-17
ccc_rbl_1_rwl_3_b_n30 rbl_1_b_n30 rwl_3_b_n30 4.9752e-17
ccc_rbl_2_rbl_3_b_n30 rbl_2_b_n30 rbl_3_b_n30 3.432e-17
ccc_rbl_2_rwl_0_b_n30 rbl_2_b_n30 rwl_0_b_n30 4.9752e-17
ccc_rbl_2_rwl_1_b_n30 rbl_2_b_n30 rwl_1_b_n30 4.9752e-17
ccc_rbl_2_rwl_2_b_n30 rbl_2_b_n30 rwl_2_b_n30 4.9752e-17
ccc_rbl_2_rwl_3_b_n30 rbl_2_b_n30 rwl_3_b_n30 4.9752e-17
ccc_rbl_3_rwl_0_b_n30 rbl_3_b_n30 rwl_0_b_n30 3.3407e-17
ccc_rbl_3_rwl_1_b_n30 rbl_3_b_n30 rwl_1_b_n30 3.3407e-17
ccc_rbl_3_rwl_2_b_n30 rbl_3_b_n30 rwl_2_b_n30 3.3407e-17
ccc_rbl_3_rwl_3_b_n30 rbl_3_b_n30 rwl_3_b_n30 3.3407e-17
vdw_b_n30_0 wl_0_b_n30 0 dc 0
vdr_b_n30_0 rwl_0_b_n30 0 dc 0
vdw_b_n30_1 wl_1_b_n30 0 dc 0
vdr_b_n30_1 rwl_1_b_n30 0 dc 0
vdw_b_n30_2 wl_2_b_n30 0 dc 0
vdr_b_n30_2 rwl_2_b_n30 0 dc 0
vdw_b_n30_3 wl_3_b_n30 0 dc 0
vdr_b_n30_3 rwl_3_b_n30 0 dc 0
vdb_b_n30_0 bl_0_b_n30 0 dc 0
vdp_b_n30_0 rbl_0_b_n30 0 dc 0
vdb_b_n30_1 bl_1_b_n30 0 dc 0
vdp_b_n30_1 rbl_1_b_n30 0 dc 0
vdb_b_n30_2 bl_2_b_n30 0 dc 0
vdp_b_n30_2 rbl_2_b_n30 0 dc 0
vdb_b_n30_3 bl_3_b_n30 0 dc 0
vdp_b_n30_3 rbl_3_b_n30 0 dc 0
vdn_b_n30_n7 n7_b_n30 0 dc 1
vdn_b_n30_n8 n8_b_n30 0 dc 1
vdn_b_n30_n9 n9_b_n30 0 dc 1
vdn_b_n30_n10 n10_b_n30 0 dc 1
vdn_b_n30_n17 n17_b_n30 0 dc 1
vdn_b_n30_n18 n18_b_n30 0 dc 1
vdn_b_n30_n19 n19_b_n30 0 dc 1
vdn_b_n30_n20 n20_b_n30 0 dc 1
vdn_b_n30_n22 n22_b_n30 0 dc 1
vdn_b_n30_n23 n23_b_n30 0 dc 1
vdn_b_n30_n24 n24_b_n30 0 dc 1
vdn_b_n30_n25 n25_b_n30 0 dc 1
vdn_b_n30_n29 n29_b_n30 0 dc 1
vdn_b_n30_n31 n31_b_n30 0 dc 1
vdn_b_n30_n32 n32_b_n30 0 dc 1
bdr_b_n30 n30_b_n30 0 i=5e-08*min(1,max(0,(time-1e-09)/0.2n))*0.5*(1+tanh((v(n30_b_n30)-0.05)/0.01))

* ---- instance b_n31: variant b, probed storage node \$31 ----
xm1_b_n31 rwl_0__t2_b_n31 n7__t0_b_n31 rbl_0__t0_b_n31 gnd__t0_b_n31 sky130_fd_pr__nfet_01v8 L=0.15 W=0.42 nf=1 ad=0.1197 as=0.1197 pd=1.41 ps=1.41 mult=1 m=1
xm2_b_n31 rwl_0__t3_b_n31 n8__t1_b_n31 rbl_1__t1_b_n31 gnd__t1_b_n31 sky130_fd_pr__nfet_01v8 L=0.15 W=0.42 nf=1 ad=0.1197 as=0.1197 pd=1.41 ps=1.41 mult=1 m=1
xm3_b_n31 rwl_0__t1_b_n31 n9__t1_b_n31 rbl_2__t1_b_n31 gnd__t2_b_n31 sky130_fd_pr__nfet_01v8 L=0.15 W=0.42 nf=1 ad=0.1197 as=0.1197 pd=1.41 ps=1.41 mult=1 m=1
xm4_b_n31 rwl_0__t0_b_n31 n10__t1_b_n31 rbl_3__t1_b_n31 gnd__t3_b_n31 sky130_fd_pr__nfet_01v8 L=0.15 W=0.42 nf=1 ad=0.1197 as=0.1197 pd=1.41 ps=1.41 mult=1 m=1
xm5_b_n31 bl_0__t0_b_n31 wl_0__t0_b_n31 n7__t1_b_n31 gnd__t8_b_n31 sky130_fd_pr__nfet_01v8 L=0.15 W=0.42 nf=1 ad=0.0588 as=0.1197 pd=0.7 ps=1.41 mult=1 m=1
xm6_b_n31 n17__t0_b_n31 wl_1__t0_b_n31 bl_0__t1_b_n31 gnd__t20_b_n31 sky130_fd_pr__nfet_01v8 L=0.15 W=0.42 nf=1 ad=0.1197 as=0.0588 pd=1.41 ps=0.7 mult=1 m=1
xm7_b_n31 bl_1__t2_b_n31 wl_0__t3_b_n31 n8__t0_b_n31 gnd__t9_b_n31 sky130_fd_pr__nfet_01v8 L=0.15 W=0.42 nf=1 ad=0.0588 as=0.1197 pd=0.7 ps=1.41 mult=1 m=1
xm8_b_n31 n18__t0_b_n31 wl_1__t1_b_n31 bl_1__t0_b_n31 gnd__t21_b_n31 sky130_fd_pr__nfet_01v8 L=0.15 W=0.42 nf=1 ad=0.1197 as=0.0588 pd=1.41 ps=0.7 mult=1 m=1
xm9_b_n31 bl_2__t2_b_n31 wl_0__t2_b_n31 n9__t0_b_n31 gnd__t10_b_n31 sky130_fd_pr__nfet_01v8 L=0.15 W=0.42 nf=1 ad=0.0588 as=0.1197 pd=0.7 ps=1.41 mult=1 m=1
xm10_b_n31 n19__t0_b_n31 wl_1__t2_b_n31 bl_2__t0_b_n31 gnd__t22_b_n31 sky130_fd_pr__nfet_01v8 L=0.15 W=0.42 nf=1 ad=0.1197 as=0.0588 pd=1.41 ps=0.7 mult=1 m=1
xm11_b_n31 bl_3__t2_b_n31 wl_0__t1_b_n31 n10__t0_b_n31 gnd__t11_b_n31 sky130_fd_pr__nfet_01v8 L=0.15 W=0.42 nf=1 ad=0.0588 as=0.1197 pd=0.7 ps=1.41 mult=1 m=1
xm12_b_n31 n20__t0_b_n31 wl_1__t3_b_n31 bl_3__t1_b_n31 gnd__t23_b_n31 sky130_fd_pr__nfet_01v8 L=0.15 W=0.42 nf=1 ad=0.1197 as=0.0588 pd=1.41 ps=0.7 mult=1 m=1
xm13_b_n31 rbl_0__t3_b_n31 n17__t1_b_n31 rwl_1__t0_b_n31 gnd__t12_b_n31 sky130_fd_pr__nfet_01v8 L=0.15 W=0.42 nf=1 ad=0.0588 as=0.1197 pd=0.7 ps=1.41 mult=1 m=1
xm14_b_n31 rwl_2__t3_b_n31 n22__t0_b_n31 rbl_0__t2_b_n31 gnd__t24_b_n31 sky130_fd_pr__nfet_01v8 L=0.15 W=0.42 nf=1 ad=0.1197 as=0.0588 pd=1.41 ps=0.7 mult=1 m=1
xm15_b_n31 rbl_1__t3_b_n31 n18__t1_b_n31 rwl_1__t1_b_n31 gnd__t13_b_n31 sky130_fd_pr__nfet_01v8 L=0.15 W=0.42 nf=1 ad=0.0588 as=0.1197 pd=0.7 ps=1.41 mult=1 m=1
xm16_b_n31 rwl_2__t0_b_n31 n23__t0_b_n31 rbl_1__t2_b_n31 gnd__t25_b_n31 sky130_fd_pr__nfet_01v8 L=0.15 W=0.42 nf=1 ad=0.1197 as=0.0588 pd=1.41 ps=0.7 mult=1 m=1
xm17_b_n31 rbl_2__t3_b_n31 n19__t1_b_n31 rwl_1__t2_b_n31 gnd__t14_b_n31 sky130_fd_pr__nfet_01v8 L=0.15 W=0.42 nf=1 ad=0.0588 as=0.1197 pd=0.7 ps=1.41 mult=1 m=1
xm18_b_n31 rwl_2__t1_b_n31 n24__t0_b_n31 rbl_2__t2_b_n31 gnd__t26_b_n31 sky130_fd_pr__nfet_01v8 L=0.15 W=0.42 nf=1 ad=0.1197 as=0.0588 pd=1.41 ps=0.7 mult=1 m=1
xm19_b_n31 rbl_3__t3_b_n31 n20__t1_b_n31 rwl_1__t3_b_n31 gnd__t15_b_n31 sky130_fd_pr__nfet_01v8 L=0.15 W=0.42 nf=1 ad=0.0588 as=0.1197 pd=0.7 ps=1.41 mult=1 m=1
xm20_b_n31 rwl_2__t2_b_n31 n25__t0_b_n31 rbl_3__t2_b_n31 gnd__t27_b_n31 sky130_fd_pr__nfet_01v8 L=0.15 W=0.42 nf=1 ad=0.1197 as=0.0588 pd=1.41 ps=0.7 mult=1 m=1
xm21_b_n31 bl_0__t3_b_n31 wl_2__t0_b_n31 n22__t1_b_n31 gnd__t16_b_n31 sky130_fd_pr__nfet_01v8 L=0.15 W=0.42 nf=1 ad=0.0588 as=0.1197 pd=0.7 ps=1.41 mult=1 m=1
xm22_b_n31 n29__t0_b_n31 wl_3__t3_b_n31 bl_0__t2_b_n31 gnd__t28_b_n31 sky130_fd_pr__nfet_01v8 L=0.15 W=0.42 nf=1 ad=0.1197 as=0.0588 pd=1.41 ps=0.7 mult=1 m=1
xm23_b_n31 bl_1__t3_b_n31 wl_2__t1_b_n31 n23__t1_b_n31 gnd__t17_b_n31 sky130_fd_pr__nfet_01v8 L=0.15 W=0.42 nf=1 ad=0.0588 as=0.1197 pd=0.7 ps=1.41 mult=1 m=1
xm24_b_n31 n30__t0_b_n31 wl_3__t2_b_n31 bl_1__t1_b_n31 gnd__t29_b_n31 sky130_fd_pr__nfet_01v8 L=0.15 W=0.42 nf=1 ad=0.1197 as=0.0588 pd=1.41 ps=0.7 mult=1 m=1
xm25_b_n31 bl_2__t3_b_n31 wl_2__t2_b_n31 n24__t1_b_n31 gnd__t18_b_n31 sky130_fd_pr__nfet_01v8 L=0.15 W=0.42 nf=1 ad=0.0588 as=0.1197 pd=0.7 ps=1.41 mult=1 m=1
xm26_b_n31 n31__t0_b_n31 wl_3__t1_b_n31 bl_2__t1_b_n31 gnd__t30_b_n31 sky130_fd_pr__nfet_01v8 L=0.15 W=0.42 nf=1 ad=0.1197 as=0.0588 pd=1.41 ps=0.7 mult=1 m=1
xm27_b_n31 bl_3__t3_b_n31 wl_2__t3_b_n31 n25__t1_b_n31 gnd__t19_b_n31 sky130_fd_pr__nfet_01v8 L=0.15 W=0.42 nf=1 ad=0.0588 as=0.1197 pd=0.7 ps=1.41 mult=1 m=1
xm28_b_n31 n32__t0_b_n31 wl_3__t0_b_n31 bl_3__t0_b_n31 gnd__t31_b_n31 sky130_fd_pr__nfet_01v8 L=0.15 W=0.42 nf=1 ad=0.1197 as=0.0588 pd=1.41 ps=0.7 mult=1 m=1
xm29_b_n31 rbl_0__t1_b_n31 n29__t1_b_n31 rwl_3__t0_b_n31 gnd__t4_b_n31 sky130_fd_pr__nfet_01v8 L=0.15 W=0.42 nf=1 ad=0.1197 as=0.1197 pd=1.41 ps=1.41 mult=1 m=1
xm30_b_n31 rbl_1__t0_b_n31 n30__t1_b_n31 rwl_3__t1_b_n31 gnd__t5_b_n31 sky130_fd_pr__nfet_01v8 L=0.15 W=0.42 nf=1 ad=0.1197 as=0.1197 pd=1.41 ps=1.41 mult=1 m=1
xm31_b_n31 rbl_2__t0_b_n31 n31__t1_b_n31 rwl_3__t2_b_n31 gnd__t6_b_n31 sky130_fd_pr__nfet_01v8 L=0.15 W=0.42 nf=1 ad=0.1197 as=0.1197 pd=1.41 ps=1.41 mult=1 m=1
xm32_b_n31 rbl_3__t0_b_n31 n32__t1_b_n31 rwl_3__t3_b_n31 gnd__t7_b_n31 sky130_fd_pr__nfet_01v8 L=0.15 W=0.42 nf=1 ad=0.1197 as=0.1197 pd=1.41 ps=1.41 mult=1 m=1
r_10_t0_b_n31 n10__t0_b_n31 n10_b_n31 183.071
r_10_t1_b_n31 n10__t1_b_n31 n10_b_n31 183.071
r_17_t0_b_n31 n17__t0_b_n31 n17_b_n31 183.071
r_17_t1_b_n31 n17__t1_b_n31 n17_b_n31 183.071
r_18_t0_b_n31 n18__t0_b_n31 n18_b_n31 183.071
r_18_t1_b_n31 n18__t1_b_n31 n18_b_n31 183.071
r_19_t0_b_n31 n19__t0_b_n31 n19_b_n31 183.071
r_19_t1_b_n31 n19__t1_b_n31 n19_b_n31 183.071
r_20_t0_b_n31 n20__t0_b_n31 n20_b_n31 183.071
r_20_t1_b_n31 n20__t1_b_n31 n20_b_n31 183.071
r_22_t0_b_n31 n22__t0_b_n31 n22_b_n31 183.071
r_22_t1_b_n31 n22__t1_b_n31 n22_b_n31 183.071
r_23_t0_b_n31 n23__t0_b_n31 n23_b_n31 183.071
r_23_t1_b_n31 n23__t1_b_n31 n23_b_n31 183.071
r_24_t0_b_n31 n24__t0_b_n31 n24_b_n31 183.071
r_24_t1_b_n31 n24__t1_b_n31 n24_b_n31 183.071
r_25_t0_b_n31 n25__t0_b_n31 n25_b_n31 183.071
r_25_t1_b_n31 n25__t1_b_n31 n25_b_n31 183.071
r_29_t0_b_n31 n29__t0_b_n31 n29_b_n31 183.071
r_29_t1_b_n31 n29__t1_b_n31 n29_b_n31 183.071
r_30_t0_b_n31 n30__t0_b_n31 n30_b_n31 183.071
r_30_t1_b_n31 n30__t1_b_n31 n30_b_n31 183.071
r_31_t0_b_n31 n31__t0_b_n31 n31_b_n31 183.071
r_31_t1_b_n31 n31__t1_b_n31 n31_b_n31 183.071
r_32_t0_b_n31 n32__t0_b_n31 n32_b_n31 183.071
r_32_t1_b_n31 n32__t1_b_n31 n32_b_n31 183.071
r_7_t0_b_n31 n7__t0_b_n31 n7_b_n31 183.071
r_7_t1_b_n31 n7__t1_b_n31 n7_b_n31 183.071
r_8_t0_b_n31 n8__t0_b_n31 n8_b_n31 183.071
r_8_t1_b_n31 n8__t1_b_n31 n8_b_n31 183.071
r_9_t0_b_n31 n9__t0_b_n31 n9_b_n31 183.071
r_9_t1_b_n31 n9__t1_b_n31 n9_b_n31 183.071
rgnd_t0_b_n31 gnd__t0_b_n31 0 38.2988
rgnd_t1_b_n31 gnd__t1_b_n31 0 33.9576
rgnd_t2_b_n31 gnd__t2_b_n31 0 33.9576
rgnd_t3_b_n31 gnd__t3_b_n31 0 38.2988
rgnd_t4_b_n31 gnd__t4_b_n31 0 38.2988
rgnd_t5_b_n31 gnd__t5_b_n31 0 33.9576
rgnd_t6_b_n31 gnd__t6_b_n31 0 33.9576
rgnd_t7_b_n31 gnd__t7_b_n31 0 38.2988
rgnd_t8_b_n31 gnd__t8_b_n31 0 28.0185
rgnd_t9_b_n31 gnd__t9_b_n31 0 21.7106
rgnd_t10_b_n31 gnd__t10_b_n31 0 21.7106
rgnd_t11_b_n31 gnd__t11_b_n31 0 28.0185
rgnd_t12_b_n31 gnd__t12_b_n31 0 18.9833
rgnd_t13_b_n31 gnd__t13_b_n31 0 6.8325
rgnd_t14_b_n31 gnd__t14_b_n31 0 6.8325
rgnd_t15_b_n31 gnd__t15_b_n31 0 18.9833
rgnd_t16_b_n31 gnd__t16_b_n31 0 24.2409
rgnd_t17_b_n31 gnd__t17_b_n31 0 16.5511
rgnd_t18_b_n31 gnd__t18_b_n31 0 16.5511
rgnd_t19_b_n31 gnd__t19_b_n31 0 24.2409
rgnd_t20_b_n31 gnd__t20_b_n31 0 24.2409
rgnd_t21_b_n31 gnd__t21_b_n31 0 16.5511
rgnd_t22_b_n31 gnd__t22_b_n31 0 16.5511
rgnd_t23_b_n31 gnd__t23_b_n31 0 24.2409
rgnd_t24_b_n31 gnd__t24_b_n31 0 18.9833
rgnd_t25_b_n31 gnd__t25_b_n31 0 6.8325
rgnd_t26_b_n31 gnd__t26_b_n31 0 6.8325
rgnd_t27_b_n31 gnd__t27_b_n31 0 18.9833
rgnd_t28_b_n31 gnd__t28_b_n31 0 28.0185
rgnd_t29_b_n31 gnd__t29_b_n31 0 21.7106
rgnd_t30_b_n31 gnd__t30_b_n31 0 21.7106
rgnd_t31_b_n31 gnd__t31_b_n31 0 28.0185
rbl_0_t0_b_n31 bl_0__t0_b_n31 bl_0_b_n31 14.8304
rbl_0_t1_b_n31 bl_0__t1_b_n31 bl_0_b_n31 10.9301
rbl_0_t2_b_n31 bl_0__t2_b_n31 bl_0_b_n31 14.8304
rbl_0_t3_b_n31 bl_0__t3_b_n31 bl_0_b_n31 10.9301
rbl_1_t0_b_n31 bl_1__t0_b_n31 bl_1_b_n31 10.9301
rbl_1_t1_b_n31 bl_1__t1_b_n31 bl_1_b_n31 14.8304
rbl_1_t2_b_n31 bl_1__t2_b_n31 bl_1_b_n31 14.8304
rbl_1_t3_b_n31 bl_1__t3_b_n31 bl_1_b_n31 10.9301
rbl_2_t0_b_n31 bl_2__t0_b_n31 bl_2_b_n31 10.9301
rbl_2_t1_b_n31 bl_2__t1_b_n31 bl_2_b_n31 14.8304
rbl_2_t2_b_n31 bl_2__t2_b_n31 bl_2_b_n31 14.8304
rbl_2_t3_b_n31 bl_2__t3_b_n31 bl_2_b_n31 10.9301
rbl_3_t0_b_n31 bl_3__t0_b_n31 bl_3_b_n31 14.8304
rbl_3_t1_b_n31 bl_3__t1_b_n31 bl_3_b_n31 10.9301
rbl_3_t2_b_n31 bl_3__t2_b_n31 bl_3_b_n31 14.8304
rbl_3_t3_b_n31 bl_3__t3_b_n31 bl_3_b_n31 10.9301
rrbl_0_t0_b_n31 rbl_0__t0_b_n31 rbl_0_b_n31 36.5601
rrbl_0_t1_b_n31 rbl_0__t1_b_n31 rbl_0_b_n31 36.5601
rrbl_0_t2_b_n31 rbl_0__t2_b_n31 rbl_0_b_n31 2.99444
rrbl_0_t3_b_n31 rbl_0__t3_b_n31 rbl_0_b_n31 2.99444
rrbl_1_t0_b_n31 rbl_1__t0_b_n31 rbl_1_b_n31 36.5601
rrbl_1_t1_b_n31 rbl_1__t1_b_n31 rbl_1_b_n31 36.5601
rrbl_1_t2_b_n31 rbl_1__t2_b_n31 rbl_1_b_n31 2.99444
rrbl_1_t3_b_n31 rbl_1__t3_b_n31 rbl_1_b_n31 2.99444
rrbl_2_t0_b_n31 rbl_2__t0_b_n31 rbl_2_b_n31 36.5601
rrbl_2_t1_b_n31 rbl_2__t1_b_n31 rbl_2_b_n31 36.5601
rrbl_2_t2_b_n31 rbl_2__t2_b_n31 rbl_2_b_n31 2.99444
rrbl_2_t3_b_n31 rbl_2__t3_b_n31 rbl_2_b_n31 2.99444
rrbl_3_t0_b_n31 rbl_3__t0_b_n31 rbl_3_b_n31 36.5601
rrbl_3_t1_b_n31 rbl_3__t1_b_n31 rbl_3_b_n31 36.5601
rrbl_3_t2_b_n31 rbl_3__t2_b_n31 rbl_3_b_n31 2.99444
rrbl_3_t3_b_n31 rbl_3__t3_b_n31 rbl_3_b_n31 2.99444
rrwl_0_t0_b_n31 rwl_0__t0_b_n31 rwl_0_b_n31 38.2618
rrwl_0_t1_b_n31 rwl_0__t1_b_n31 rwl_0_b_n31 12.7539
rrwl_0_t2_b_n31 rwl_0__t2_b_n31 rwl_0_b_n31 38.2618
rrwl_0_t3_b_n31 rwl_0__t3_b_n31 rwl_0_b_n31 12.7539
rrwl_1_t0_b_n31 rwl_1__t0_b_n31 rwl_1_b_n31 38.2618
rrwl_1_t1_b_n31 rwl_1__t1_b_n31 rwl_1_b_n31 12.7539
rrwl_1_t2_b_n31 rwl_1__t2_b_n31 rwl_1_b_n31 12.7539
rrwl_1_t3_b_n31 rwl_1__t3_b_n31 rwl_1_b_n31 38.2618
rrwl_2_t0_b_n31 rwl_2__t0_b_n31 rwl_2_b_n31 12.7539
rrwl_2_t1_b_n31 rwl_2__t1_b_n31 rwl_2_b_n31 12.7539
rrwl_2_t2_b_n31 rwl_2__t2_b_n31 rwl_2_b_n31 38.2618
rrwl_2_t3_b_n31 rwl_2__t3_b_n31 rwl_2_b_n31 38.2618
rrwl_3_t0_b_n31 rwl_3__t0_b_n31 rwl_3_b_n31 38.2618
rrwl_3_t1_b_n31 rwl_3__t1_b_n31 rwl_3_b_n31 12.7539
rrwl_3_t2_b_n31 rwl_3__t2_b_n31 rwl_3_b_n31 12.7539
rrwl_3_t3_b_n31 rwl_3__t3_b_n31 rwl_3_b_n31 38.2618
rwl_0_t0_b_n31 wl_0__t0_b_n31 wl_0_b_n31 245.959
rwl_0_t1_b_n31 wl_0__t1_b_n31 wl_0_b_n31 245.959
rwl_0_t2_b_n31 wl_0__t2_b_n31 wl_0_b_n31 81.9864
rwl_0_t3_b_n31 wl_0__t3_b_n31 wl_0_b_n31 81.9864
rwl_1_t0_b_n31 wl_1__t0_b_n31 wl_1_b_n31 245.959
rwl_1_t1_b_n31 wl_1__t1_b_n31 wl_1_b_n31 81.9864
rwl_1_t2_b_n31 wl_1__t2_b_n31 wl_1_b_n31 81.9864
rwl_1_t3_b_n31 wl_1__t3_b_n31 wl_1_b_n31 245.959
rwl_2_t0_b_n31 wl_2__t0_b_n31 wl_2_b_n31 245.959
rwl_2_t1_b_n31 wl_2__t1_b_n31 wl_2_b_n31 81.9864
rwl_2_t2_b_n31 wl_2__t2_b_n31 wl_2_b_n31 81.9864
rwl_2_t3_b_n31 wl_2__t3_b_n31 wl_2_b_n31 245.959
rwl_3_t0_b_n31 wl_3__t0_b_n31 wl_3_b_n31 245.959
rwl_3_t1_b_n31 wl_3__t1_b_n31 wl_3_b_n31 81.9864
rwl_3_t2_b_n31 wl_3__t2_b_n31 wl_3_b_n31 81.9864
rwl_3_t3_b_n31 wl_3__t3_b_n31 wl_3_b_n31 245.959
c_10_b_n31 n10_b_n31 0 2.91622e-16
c_17_b_n31 n17_b_n31 0 2.91528e-16
c_18_b_n31 n18_b_n31 0 2.91528e-16
c_19_b_n31 n19_b_n31 0 2.91528e-16
c_20_b_n31 n20_b_n31 0 2.91622e-16
c_22_b_n31 n22_b_n31 0 2.91528e-16
c_23_b_n31 n23_b_n31 0 2.91528e-16
c_24_b_n31 n24_b_n31 0 2.91528e-16
c_25_b_n31 n25_b_n31 0 2.91622e-16
c_29_b_n31 n29_b_n31 0 2.91528e-16
c_30_b_n31 n30_b_n31 0 2.91528e-16
c_31_b_n31 n31_b_n31 0 2.91528e-16
c_32_b_n31 n32_b_n31 0 2.91622e-16
c_7_b_n31 n7_b_n31 0 2.91528e-16
c_8_b_n31 n8_b_n31 0 2.91528e-16
c_9_b_n31 n9_b_n31 0 2.91528e-16
cgnd_b_n31 0 0 2.48166e-15
cbl_0_b_n31 bl_0_b_n31 0 4.52661e-16
cbl_1_b_n31 bl_1_b_n31 0 4.52661e-16
cbl_2_b_n31 bl_2_b_n31 0 4.52661e-16
cbl_3_b_n31 bl_3_b_n31 0 4.52661e-16
crbl_0_b_n31 rbl_0_b_n31 0 9.14472e-16
crbl_1_b_n31 rbl_1_b_n31 0 9.14472e-16
crbl_2_b_n31 rbl_2_b_n31 0 9.14472e-16
crbl_3_b_n31 rbl_3_b_n31 0 9.17566e-16
crwl_0_b_n31 rwl_0_b_n31 0 5.19495e-16
crwl_1_b_n31 rwl_1_b_n31 0 5.11719e-16
crwl_2_b_n31 rwl_2_b_n31 0 5.11719e-16
crwl_3_b_n31 rwl_3_b_n31 0 5.19495e-16
cwl_0_b_n31 wl_0_b_n31 0 3.30388e-16
cwl_1_b_n31 wl_1_b_n31 0 3.30388e-16
cwl_2_b_n31 wl_2_b_n31 0 3.30388e-16
cwl_3_b_n31 wl_3_b_n31 0 3.30388e-16
ccc__10__9_b_n31 n10_b_n31 n9_b_n31 1.02e-17
ccc__10_bl_3_b_n31 n10_b_n31 bl_3_b_n31 1.3999e-17
ccc__10_rwl_0_b_n31 n10_b_n31 rwl_0_b_n31 4.335e-18
ccc__17__18_b_n31 n17_b_n31 n18_b_n31 1.02e-17
ccc__17_bl_0_b_n31 n17_b_n31 bl_0_b_n31 8.415e-18
ccc__17_rwl_1_b_n31 n17_b_n31 rwl_1_b_n31 1.3194e-17
ccc__18__19_b_n31 n18_b_n31 n19_b_n31 1.02e-17
ccc__18_bl_1_b_n31 n18_b_n31 bl_1_b_n31 8.415e-18
ccc__18_rwl_1_b_n31 n18_b_n31 rwl_1_b_n31 1.3194e-17
ccc__19__20_b_n31 n19_b_n31 n20_b_n31 1.02e-17
ccc__19_bl_2_b_n31 n19_b_n31 bl_2_b_n31 8.415e-18
ccc__19_rwl_1_b_n31 n19_b_n31 rwl_1_b_n31 1.3194e-17
ccc__20_bl_3_b_n31 n20_b_n31 bl_3_b_n31 8.415e-18
ccc__20_rwl_1_b_n31 n20_b_n31 rwl_1_b_n31 6.655e-18
ccc__22__23_b_n31 n22_b_n31 n23_b_n31 1.02e-17
ccc__22_bl_0_b_n31 n22_b_n31 bl_0_b_n31 8.415e-18
ccc__22_rwl_2_b_n31 n22_b_n31 rwl_2_b_n31 1.3194e-17
ccc__23__24_b_n31 n23_b_n31 n24_b_n31 1.02e-17
ccc__23_bl_1_b_n31 n23_b_n31 bl_1_b_n31 8.415e-18
ccc__23_rwl_2_b_n31 n23_b_n31 rwl_2_b_n31 1.3194e-17
ccc__24__25_b_n31 n24_b_n31 n25_b_n31 1.02e-17
ccc__24_bl_2_b_n31 n24_b_n31 bl_2_b_n31 8.415e-18
ccc__24_rwl_2_b_n31 n24_b_n31 rwl_2_b_n31 1.3194e-17
ccc__25_bl_3_b_n31 n25_b_n31 bl_3_b_n31 8.415e-18
ccc__25_rwl_2_b_n31 n25_b_n31 rwl_2_b_n31 6.655e-18
ccc__29__30_b_n31 n29_b_n31 n30_b_n31 1.02e-17
ccc__29_bl_0_b_n31 n29_b_n31 bl_0_b_n31 8.415e-18
ccc__29_rwl_3_b_n31 n29_b_n31 rwl_3_b_n31 1.3194e-17
ccc__30__31_b_n31 n30_b_n31 n31_b_n31 1.02e-17
ccc__30_bl_1_b_n31 n30_b_n31 bl_1_b_n31 8.415e-18
ccc__30_rwl_3_b_n31 n30_b_n31 rwl_3_b_n31 1.3194e-17
ccc__31__32_b_n31 n31_b_n31 n32_b_n31 1.02e-17
ccc__31_bl_2_b_n31 n31_b_n31 bl_2_b_n31 8.415e-18
ccc__31_rwl_3_b_n31 n31_b_n31 rwl_3_b_n31 1.3194e-17
ccc__32_bl_3_b_n31 n32_b_n31 bl_3_b_n31 8.415e-18
ccc__32_rwl_3_b_n31 n32_b_n31 rwl_3_b_n31 6.655e-18
ccc__7__8_b_n31 n7_b_n31 n8_b_n31 1.02e-17
ccc__7_bl_0_b_n31 n7_b_n31 bl_0_b_n31 1.3999e-17
ccc__7_rwl_0_b_n31 n7_b_n31 rwl_0_b_n31 8.961e-18
ccc__8__9_b_n31 n8_b_n31 n9_b_n31 1.02e-17
ccc__8_bl_1_b_n31 n8_b_n31 bl_1_b_n31 1.3999e-17
ccc__8_rwl_0_b_n31 n8_b_n31 rwl_0_b_n31 8.961e-18
ccc__9_bl_2_b_n31 n9_b_n31 bl_2_b_n31 1.3999e-17
ccc__9_rwl_0_b_n31 n9_b_n31 rwl_0_b_n31 8.961e-18
ccc_bl_0_rbl_0_b_n31 bl_0_b_n31 rbl_0_b_n31 1.88693e-16
ccc_bl_0_rwl_1_b_n31 bl_0_b_n31 rwl_1_b_n31 1.0093e-17
ccc_bl_0_rwl_2_b_n31 bl_0_b_n31 rwl_2_b_n31 1.0093e-17
ccc_bl_1_rbl_0_b_n31 bl_1_b_n31 rbl_0_b_n31 1.633e-16
ccc_bl_1_rbl_1_b_n31 bl_1_b_n31 rbl_1_b_n31 1.88693e-16
ccc_bl_1_rwl_1_b_n31 bl_1_b_n31 rwl_1_b_n31 1.0093e-17
ccc_bl_1_rwl_2_b_n31 bl_1_b_n31 rwl_2_b_n31 1.0093e-17
ccc_bl_2_rbl_1_b_n31 bl_2_b_n31 rbl_1_b_n31 1.633e-16
ccc_bl_2_rbl_2_b_n31 bl_2_b_n31 rbl_2_b_n31 1.88693e-16
ccc_bl_2_rwl_1_b_n31 bl_2_b_n31 rwl_1_b_n31 1.0093e-17
ccc_bl_2_rwl_2_b_n31 bl_2_b_n31 rwl_2_b_n31 1.0093e-17
ccc_bl_3_rbl_2_b_n31 bl_3_b_n31 rbl_2_b_n31 1.633e-16
ccc_bl_3_rbl_3_b_n31 bl_3_b_n31 rbl_3_b_n31 1.88693e-16
ccc_bl_3_rwl_1_b_n31 bl_3_b_n31 rwl_1_b_n31 1.0093e-17
ccc_bl_3_rwl_2_b_n31 bl_3_b_n31 rwl_2_b_n31 1.0093e-17
ccc_rbl_0_rbl_1_b_n31 rbl_0_b_n31 rbl_1_b_n31 3.432e-17
ccc_rbl_0_rwl_0_b_n31 rbl_0_b_n31 rwl_0_b_n31 4.9752e-17
ccc_rbl_0_rwl_1_b_n31 rbl_0_b_n31 rwl_1_b_n31 4.9752e-17
ccc_rbl_0_rwl_2_b_n31 rbl_0_b_n31 rwl_2_b_n31 4.9752e-17
ccc_rbl_0_rwl_3_b_n31 rbl_0_b_n31 rwl_3_b_n31 4.9752e-17
ccc_rbl_1_rbl_2_b_n31 rbl_1_b_n31 rbl_2_b_n31 3.432e-17
ccc_rbl_1_rwl_0_b_n31 rbl_1_b_n31 rwl_0_b_n31 4.9752e-17
ccc_rbl_1_rwl_1_b_n31 rbl_1_b_n31 rwl_1_b_n31 4.9752e-17
ccc_rbl_1_rwl_2_b_n31 rbl_1_b_n31 rwl_2_b_n31 4.9752e-17
ccc_rbl_1_rwl_3_b_n31 rbl_1_b_n31 rwl_3_b_n31 4.9752e-17
ccc_rbl_2_rbl_3_b_n31 rbl_2_b_n31 rbl_3_b_n31 3.432e-17
ccc_rbl_2_rwl_0_b_n31 rbl_2_b_n31 rwl_0_b_n31 4.9752e-17
ccc_rbl_2_rwl_1_b_n31 rbl_2_b_n31 rwl_1_b_n31 4.9752e-17
ccc_rbl_2_rwl_2_b_n31 rbl_2_b_n31 rwl_2_b_n31 4.9752e-17
ccc_rbl_2_rwl_3_b_n31 rbl_2_b_n31 rwl_3_b_n31 4.9752e-17
ccc_rbl_3_rwl_0_b_n31 rbl_3_b_n31 rwl_0_b_n31 3.3407e-17
ccc_rbl_3_rwl_1_b_n31 rbl_3_b_n31 rwl_1_b_n31 3.3407e-17
ccc_rbl_3_rwl_2_b_n31 rbl_3_b_n31 rwl_2_b_n31 3.3407e-17
ccc_rbl_3_rwl_3_b_n31 rbl_3_b_n31 rwl_3_b_n31 3.3407e-17
vdw_b_n31_0 wl_0_b_n31 0 dc 0
vdr_b_n31_0 rwl_0_b_n31 0 dc 0
vdw_b_n31_1 wl_1_b_n31 0 dc 0
vdr_b_n31_1 rwl_1_b_n31 0 dc 0
vdw_b_n31_2 wl_2_b_n31 0 dc 0
vdr_b_n31_2 rwl_2_b_n31 0 dc 0
vdw_b_n31_3 wl_3_b_n31 0 dc 0
vdr_b_n31_3 rwl_3_b_n31 0 dc 0
vdb_b_n31_0 bl_0_b_n31 0 dc 0
vdp_b_n31_0 rbl_0_b_n31 0 dc 0
vdb_b_n31_1 bl_1_b_n31 0 dc 0
vdp_b_n31_1 rbl_1_b_n31 0 dc 0
vdb_b_n31_2 bl_2_b_n31 0 dc 0
vdp_b_n31_2 rbl_2_b_n31 0 dc 0
vdb_b_n31_3 bl_3_b_n31 0 dc 0
vdp_b_n31_3 rbl_3_b_n31 0 dc 0
vdn_b_n31_n7 n7_b_n31 0 dc 1
vdn_b_n31_n8 n8_b_n31 0 dc 1
vdn_b_n31_n9 n9_b_n31 0 dc 1
vdn_b_n31_n10 n10_b_n31 0 dc 1
vdn_b_n31_n17 n17_b_n31 0 dc 1
vdn_b_n31_n18 n18_b_n31 0 dc 1
vdn_b_n31_n19 n19_b_n31 0 dc 1
vdn_b_n31_n20 n20_b_n31 0 dc 1
vdn_b_n31_n22 n22_b_n31 0 dc 1
vdn_b_n31_n23 n23_b_n31 0 dc 1
vdn_b_n31_n24 n24_b_n31 0 dc 1
vdn_b_n31_n25 n25_b_n31 0 dc 1
vdn_b_n31_n29 n29_b_n31 0 dc 1
vdn_b_n31_n30 n30_b_n31 0 dc 1
vdn_b_n31_n32 n32_b_n31 0 dc 1
bdr_b_n31 n31_b_n31 0 i=5e-08*min(1,max(0,(time-1e-09)/0.2n))*0.5*(1+tanh((v(n31_b_n31)-0.05)/0.01))

* ---- instance b_n32: variant b, probed storage node \$32 ----
xm1_b_n32 rwl_0__t2_b_n32 n7__t0_b_n32 rbl_0__t0_b_n32 gnd__t0_b_n32 sky130_fd_pr__nfet_01v8 L=0.15 W=0.42 nf=1 ad=0.1197 as=0.1197 pd=1.41 ps=1.41 mult=1 m=1
xm2_b_n32 rwl_0__t3_b_n32 n8__t1_b_n32 rbl_1__t1_b_n32 gnd__t1_b_n32 sky130_fd_pr__nfet_01v8 L=0.15 W=0.42 nf=1 ad=0.1197 as=0.1197 pd=1.41 ps=1.41 mult=1 m=1
xm3_b_n32 rwl_0__t1_b_n32 n9__t1_b_n32 rbl_2__t1_b_n32 gnd__t2_b_n32 sky130_fd_pr__nfet_01v8 L=0.15 W=0.42 nf=1 ad=0.1197 as=0.1197 pd=1.41 ps=1.41 mult=1 m=1
xm4_b_n32 rwl_0__t0_b_n32 n10__t1_b_n32 rbl_3__t1_b_n32 gnd__t3_b_n32 sky130_fd_pr__nfet_01v8 L=0.15 W=0.42 nf=1 ad=0.1197 as=0.1197 pd=1.41 ps=1.41 mult=1 m=1
xm5_b_n32 bl_0__t0_b_n32 wl_0__t0_b_n32 n7__t1_b_n32 gnd__t8_b_n32 sky130_fd_pr__nfet_01v8 L=0.15 W=0.42 nf=1 ad=0.0588 as=0.1197 pd=0.7 ps=1.41 mult=1 m=1
xm6_b_n32 n17__t0_b_n32 wl_1__t0_b_n32 bl_0__t1_b_n32 gnd__t20_b_n32 sky130_fd_pr__nfet_01v8 L=0.15 W=0.42 nf=1 ad=0.1197 as=0.0588 pd=1.41 ps=0.7 mult=1 m=1
xm7_b_n32 bl_1__t2_b_n32 wl_0__t3_b_n32 n8__t0_b_n32 gnd__t9_b_n32 sky130_fd_pr__nfet_01v8 L=0.15 W=0.42 nf=1 ad=0.0588 as=0.1197 pd=0.7 ps=1.41 mult=1 m=1
xm8_b_n32 n18__t0_b_n32 wl_1__t1_b_n32 bl_1__t0_b_n32 gnd__t21_b_n32 sky130_fd_pr__nfet_01v8 L=0.15 W=0.42 nf=1 ad=0.1197 as=0.0588 pd=1.41 ps=0.7 mult=1 m=1
xm9_b_n32 bl_2__t2_b_n32 wl_0__t2_b_n32 n9__t0_b_n32 gnd__t10_b_n32 sky130_fd_pr__nfet_01v8 L=0.15 W=0.42 nf=1 ad=0.0588 as=0.1197 pd=0.7 ps=1.41 mult=1 m=1
xm10_b_n32 n19__t0_b_n32 wl_1__t2_b_n32 bl_2__t0_b_n32 gnd__t22_b_n32 sky130_fd_pr__nfet_01v8 L=0.15 W=0.42 nf=1 ad=0.1197 as=0.0588 pd=1.41 ps=0.7 mult=1 m=1
xm11_b_n32 bl_3__t2_b_n32 wl_0__t1_b_n32 n10__t0_b_n32 gnd__t11_b_n32 sky130_fd_pr__nfet_01v8 L=0.15 W=0.42 nf=1 ad=0.0588 as=0.1197 pd=0.7 ps=1.41 mult=1 m=1
xm12_b_n32 n20__t0_b_n32 wl_1__t3_b_n32 bl_3__t1_b_n32 gnd__t23_b_n32 sky130_fd_pr__nfet_01v8 L=0.15 W=0.42 nf=1 ad=0.1197 as=0.0588 pd=1.41 ps=0.7 mult=1 m=1
xm13_b_n32 rbl_0__t3_b_n32 n17__t1_b_n32 rwl_1__t0_b_n32 gnd__t12_b_n32 sky130_fd_pr__nfet_01v8 L=0.15 W=0.42 nf=1 ad=0.0588 as=0.1197 pd=0.7 ps=1.41 mult=1 m=1
xm14_b_n32 rwl_2__t3_b_n32 n22__t0_b_n32 rbl_0__t2_b_n32 gnd__t24_b_n32 sky130_fd_pr__nfet_01v8 L=0.15 W=0.42 nf=1 ad=0.1197 as=0.0588 pd=1.41 ps=0.7 mult=1 m=1
xm15_b_n32 rbl_1__t3_b_n32 n18__t1_b_n32 rwl_1__t1_b_n32 gnd__t13_b_n32 sky130_fd_pr__nfet_01v8 L=0.15 W=0.42 nf=1 ad=0.0588 as=0.1197 pd=0.7 ps=1.41 mult=1 m=1
xm16_b_n32 rwl_2__t0_b_n32 n23__t0_b_n32 rbl_1__t2_b_n32 gnd__t25_b_n32 sky130_fd_pr__nfet_01v8 L=0.15 W=0.42 nf=1 ad=0.1197 as=0.0588 pd=1.41 ps=0.7 mult=1 m=1
xm17_b_n32 rbl_2__t3_b_n32 n19__t1_b_n32 rwl_1__t2_b_n32 gnd__t14_b_n32 sky130_fd_pr__nfet_01v8 L=0.15 W=0.42 nf=1 ad=0.0588 as=0.1197 pd=0.7 ps=1.41 mult=1 m=1
xm18_b_n32 rwl_2__t1_b_n32 n24__t0_b_n32 rbl_2__t2_b_n32 gnd__t26_b_n32 sky130_fd_pr__nfet_01v8 L=0.15 W=0.42 nf=1 ad=0.1197 as=0.0588 pd=1.41 ps=0.7 mult=1 m=1
xm19_b_n32 rbl_3__t3_b_n32 n20__t1_b_n32 rwl_1__t3_b_n32 gnd__t15_b_n32 sky130_fd_pr__nfet_01v8 L=0.15 W=0.42 nf=1 ad=0.0588 as=0.1197 pd=0.7 ps=1.41 mult=1 m=1
xm20_b_n32 rwl_2__t2_b_n32 n25__t0_b_n32 rbl_3__t2_b_n32 gnd__t27_b_n32 sky130_fd_pr__nfet_01v8 L=0.15 W=0.42 nf=1 ad=0.1197 as=0.0588 pd=1.41 ps=0.7 mult=1 m=1
xm21_b_n32 bl_0__t3_b_n32 wl_2__t0_b_n32 n22__t1_b_n32 gnd__t16_b_n32 sky130_fd_pr__nfet_01v8 L=0.15 W=0.42 nf=1 ad=0.0588 as=0.1197 pd=0.7 ps=1.41 mult=1 m=1
xm22_b_n32 n29__t0_b_n32 wl_3__t3_b_n32 bl_0__t2_b_n32 gnd__t28_b_n32 sky130_fd_pr__nfet_01v8 L=0.15 W=0.42 nf=1 ad=0.1197 as=0.0588 pd=1.41 ps=0.7 mult=1 m=1
xm23_b_n32 bl_1__t3_b_n32 wl_2__t1_b_n32 n23__t1_b_n32 gnd__t17_b_n32 sky130_fd_pr__nfet_01v8 L=0.15 W=0.42 nf=1 ad=0.0588 as=0.1197 pd=0.7 ps=1.41 mult=1 m=1
xm24_b_n32 n30__t0_b_n32 wl_3__t2_b_n32 bl_1__t1_b_n32 gnd__t29_b_n32 sky130_fd_pr__nfet_01v8 L=0.15 W=0.42 nf=1 ad=0.1197 as=0.0588 pd=1.41 ps=0.7 mult=1 m=1
xm25_b_n32 bl_2__t3_b_n32 wl_2__t2_b_n32 n24__t1_b_n32 gnd__t18_b_n32 sky130_fd_pr__nfet_01v8 L=0.15 W=0.42 nf=1 ad=0.0588 as=0.1197 pd=0.7 ps=1.41 mult=1 m=1
xm26_b_n32 n31__t0_b_n32 wl_3__t1_b_n32 bl_2__t1_b_n32 gnd__t30_b_n32 sky130_fd_pr__nfet_01v8 L=0.15 W=0.42 nf=1 ad=0.1197 as=0.0588 pd=1.41 ps=0.7 mult=1 m=1
xm27_b_n32 bl_3__t3_b_n32 wl_2__t3_b_n32 n25__t1_b_n32 gnd__t19_b_n32 sky130_fd_pr__nfet_01v8 L=0.15 W=0.42 nf=1 ad=0.0588 as=0.1197 pd=0.7 ps=1.41 mult=1 m=1
xm28_b_n32 n32__t0_b_n32 wl_3__t0_b_n32 bl_3__t0_b_n32 gnd__t31_b_n32 sky130_fd_pr__nfet_01v8 L=0.15 W=0.42 nf=1 ad=0.1197 as=0.0588 pd=1.41 ps=0.7 mult=1 m=1
xm29_b_n32 rbl_0__t1_b_n32 n29__t1_b_n32 rwl_3__t0_b_n32 gnd__t4_b_n32 sky130_fd_pr__nfet_01v8 L=0.15 W=0.42 nf=1 ad=0.1197 as=0.1197 pd=1.41 ps=1.41 mult=1 m=1
xm30_b_n32 rbl_1__t0_b_n32 n30__t1_b_n32 rwl_3__t1_b_n32 gnd__t5_b_n32 sky130_fd_pr__nfet_01v8 L=0.15 W=0.42 nf=1 ad=0.1197 as=0.1197 pd=1.41 ps=1.41 mult=1 m=1
xm31_b_n32 rbl_2__t0_b_n32 n31__t1_b_n32 rwl_3__t2_b_n32 gnd__t6_b_n32 sky130_fd_pr__nfet_01v8 L=0.15 W=0.42 nf=1 ad=0.1197 as=0.1197 pd=1.41 ps=1.41 mult=1 m=1
xm32_b_n32 rbl_3__t0_b_n32 n32__t1_b_n32 rwl_3__t3_b_n32 gnd__t7_b_n32 sky130_fd_pr__nfet_01v8 L=0.15 W=0.42 nf=1 ad=0.1197 as=0.1197 pd=1.41 ps=1.41 mult=1 m=1
r_10_t0_b_n32 n10__t0_b_n32 n10_b_n32 183.071
r_10_t1_b_n32 n10__t1_b_n32 n10_b_n32 183.071
r_17_t0_b_n32 n17__t0_b_n32 n17_b_n32 183.071
r_17_t1_b_n32 n17__t1_b_n32 n17_b_n32 183.071
r_18_t0_b_n32 n18__t0_b_n32 n18_b_n32 183.071
r_18_t1_b_n32 n18__t1_b_n32 n18_b_n32 183.071
r_19_t0_b_n32 n19__t0_b_n32 n19_b_n32 183.071
r_19_t1_b_n32 n19__t1_b_n32 n19_b_n32 183.071
r_20_t0_b_n32 n20__t0_b_n32 n20_b_n32 183.071
r_20_t1_b_n32 n20__t1_b_n32 n20_b_n32 183.071
r_22_t0_b_n32 n22__t0_b_n32 n22_b_n32 183.071
r_22_t1_b_n32 n22__t1_b_n32 n22_b_n32 183.071
r_23_t0_b_n32 n23__t0_b_n32 n23_b_n32 183.071
r_23_t1_b_n32 n23__t1_b_n32 n23_b_n32 183.071
r_24_t0_b_n32 n24__t0_b_n32 n24_b_n32 183.071
r_24_t1_b_n32 n24__t1_b_n32 n24_b_n32 183.071
r_25_t0_b_n32 n25__t0_b_n32 n25_b_n32 183.071
r_25_t1_b_n32 n25__t1_b_n32 n25_b_n32 183.071
r_29_t0_b_n32 n29__t0_b_n32 n29_b_n32 183.071
r_29_t1_b_n32 n29__t1_b_n32 n29_b_n32 183.071
r_30_t0_b_n32 n30__t0_b_n32 n30_b_n32 183.071
r_30_t1_b_n32 n30__t1_b_n32 n30_b_n32 183.071
r_31_t0_b_n32 n31__t0_b_n32 n31_b_n32 183.071
r_31_t1_b_n32 n31__t1_b_n32 n31_b_n32 183.071
r_32_t0_b_n32 n32__t0_b_n32 n32_b_n32 183.071
r_32_t1_b_n32 n32__t1_b_n32 n32_b_n32 183.071
r_7_t0_b_n32 n7__t0_b_n32 n7_b_n32 183.071
r_7_t1_b_n32 n7__t1_b_n32 n7_b_n32 183.071
r_8_t0_b_n32 n8__t0_b_n32 n8_b_n32 183.071
r_8_t1_b_n32 n8__t1_b_n32 n8_b_n32 183.071
r_9_t0_b_n32 n9__t0_b_n32 n9_b_n32 183.071
r_9_t1_b_n32 n9__t1_b_n32 n9_b_n32 183.071
rgnd_t0_b_n32 gnd__t0_b_n32 0 38.2988
rgnd_t1_b_n32 gnd__t1_b_n32 0 33.9576
rgnd_t2_b_n32 gnd__t2_b_n32 0 33.9576
rgnd_t3_b_n32 gnd__t3_b_n32 0 38.2988
rgnd_t4_b_n32 gnd__t4_b_n32 0 38.2988
rgnd_t5_b_n32 gnd__t5_b_n32 0 33.9576
rgnd_t6_b_n32 gnd__t6_b_n32 0 33.9576
rgnd_t7_b_n32 gnd__t7_b_n32 0 38.2988
rgnd_t8_b_n32 gnd__t8_b_n32 0 28.0185
rgnd_t9_b_n32 gnd__t9_b_n32 0 21.7106
rgnd_t10_b_n32 gnd__t10_b_n32 0 21.7106
rgnd_t11_b_n32 gnd__t11_b_n32 0 28.0185
rgnd_t12_b_n32 gnd__t12_b_n32 0 18.9833
rgnd_t13_b_n32 gnd__t13_b_n32 0 6.8325
rgnd_t14_b_n32 gnd__t14_b_n32 0 6.8325
rgnd_t15_b_n32 gnd__t15_b_n32 0 18.9833
rgnd_t16_b_n32 gnd__t16_b_n32 0 24.2409
rgnd_t17_b_n32 gnd__t17_b_n32 0 16.5511
rgnd_t18_b_n32 gnd__t18_b_n32 0 16.5511
rgnd_t19_b_n32 gnd__t19_b_n32 0 24.2409
rgnd_t20_b_n32 gnd__t20_b_n32 0 24.2409
rgnd_t21_b_n32 gnd__t21_b_n32 0 16.5511
rgnd_t22_b_n32 gnd__t22_b_n32 0 16.5511
rgnd_t23_b_n32 gnd__t23_b_n32 0 24.2409
rgnd_t24_b_n32 gnd__t24_b_n32 0 18.9833
rgnd_t25_b_n32 gnd__t25_b_n32 0 6.8325
rgnd_t26_b_n32 gnd__t26_b_n32 0 6.8325
rgnd_t27_b_n32 gnd__t27_b_n32 0 18.9833
rgnd_t28_b_n32 gnd__t28_b_n32 0 28.0185
rgnd_t29_b_n32 gnd__t29_b_n32 0 21.7106
rgnd_t30_b_n32 gnd__t30_b_n32 0 21.7106
rgnd_t31_b_n32 gnd__t31_b_n32 0 28.0185
rbl_0_t0_b_n32 bl_0__t0_b_n32 bl_0_b_n32 14.8304
rbl_0_t1_b_n32 bl_0__t1_b_n32 bl_0_b_n32 10.9301
rbl_0_t2_b_n32 bl_0__t2_b_n32 bl_0_b_n32 14.8304
rbl_0_t3_b_n32 bl_0__t3_b_n32 bl_0_b_n32 10.9301
rbl_1_t0_b_n32 bl_1__t0_b_n32 bl_1_b_n32 10.9301
rbl_1_t1_b_n32 bl_1__t1_b_n32 bl_1_b_n32 14.8304
rbl_1_t2_b_n32 bl_1__t2_b_n32 bl_1_b_n32 14.8304
rbl_1_t3_b_n32 bl_1__t3_b_n32 bl_1_b_n32 10.9301
rbl_2_t0_b_n32 bl_2__t0_b_n32 bl_2_b_n32 10.9301
rbl_2_t1_b_n32 bl_2__t1_b_n32 bl_2_b_n32 14.8304
rbl_2_t2_b_n32 bl_2__t2_b_n32 bl_2_b_n32 14.8304
rbl_2_t3_b_n32 bl_2__t3_b_n32 bl_2_b_n32 10.9301
rbl_3_t0_b_n32 bl_3__t0_b_n32 bl_3_b_n32 14.8304
rbl_3_t1_b_n32 bl_3__t1_b_n32 bl_3_b_n32 10.9301
rbl_3_t2_b_n32 bl_3__t2_b_n32 bl_3_b_n32 14.8304
rbl_3_t3_b_n32 bl_3__t3_b_n32 bl_3_b_n32 10.9301
rrbl_0_t0_b_n32 rbl_0__t0_b_n32 rbl_0_b_n32 36.5601
rrbl_0_t1_b_n32 rbl_0__t1_b_n32 rbl_0_b_n32 36.5601
rrbl_0_t2_b_n32 rbl_0__t2_b_n32 rbl_0_b_n32 2.99444
rrbl_0_t3_b_n32 rbl_0__t3_b_n32 rbl_0_b_n32 2.99444
rrbl_1_t0_b_n32 rbl_1__t0_b_n32 rbl_1_b_n32 36.5601
rrbl_1_t1_b_n32 rbl_1__t1_b_n32 rbl_1_b_n32 36.5601
rrbl_1_t2_b_n32 rbl_1__t2_b_n32 rbl_1_b_n32 2.99444
rrbl_1_t3_b_n32 rbl_1__t3_b_n32 rbl_1_b_n32 2.99444
rrbl_2_t0_b_n32 rbl_2__t0_b_n32 rbl_2_b_n32 36.5601
rrbl_2_t1_b_n32 rbl_2__t1_b_n32 rbl_2_b_n32 36.5601
rrbl_2_t2_b_n32 rbl_2__t2_b_n32 rbl_2_b_n32 2.99444
rrbl_2_t3_b_n32 rbl_2__t3_b_n32 rbl_2_b_n32 2.99444
rrbl_3_t0_b_n32 rbl_3__t0_b_n32 rbl_3_b_n32 36.5601
rrbl_3_t1_b_n32 rbl_3__t1_b_n32 rbl_3_b_n32 36.5601
rrbl_3_t2_b_n32 rbl_3__t2_b_n32 rbl_3_b_n32 2.99444
rrbl_3_t3_b_n32 rbl_3__t3_b_n32 rbl_3_b_n32 2.99444
rrwl_0_t0_b_n32 rwl_0__t0_b_n32 rwl_0_b_n32 38.2618
rrwl_0_t1_b_n32 rwl_0__t1_b_n32 rwl_0_b_n32 12.7539
rrwl_0_t2_b_n32 rwl_0__t2_b_n32 rwl_0_b_n32 38.2618
rrwl_0_t3_b_n32 rwl_0__t3_b_n32 rwl_0_b_n32 12.7539
rrwl_1_t0_b_n32 rwl_1__t0_b_n32 rwl_1_b_n32 38.2618
rrwl_1_t1_b_n32 rwl_1__t1_b_n32 rwl_1_b_n32 12.7539
rrwl_1_t2_b_n32 rwl_1__t2_b_n32 rwl_1_b_n32 12.7539
rrwl_1_t3_b_n32 rwl_1__t3_b_n32 rwl_1_b_n32 38.2618
rrwl_2_t0_b_n32 rwl_2__t0_b_n32 rwl_2_b_n32 12.7539
rrwl_2_t1_b_n32 rwl_2__t1_b_n32 rwl_2_b_n32 12.7539
rrwl_2_t2_b_n32 rwl_2__t2_b_n32 rwl_2_b_n32 38.2618
rrwl_2_t3_b_n32 rwl_2__t3_b_n32 rwl_2_b_n32 38.2618
rrwl_3_t0_b_n32 rwl_3__t0_b_n32 rwl_3_b_n32 38.2618
rrwl_3_t1_b_n32 rwl_3__t1_b_n32 rwl_3_b_n32 12.7539
rrwl_3_t2_b_n32 rwl_3__t2_b_n32 rwl_3_b_n32 12.7539
rrwl_3_t3_b_n32 rwl_3__t3_b_n32 rwl_3_b_n32 38.2618
rwl_0_t0_b_n32 wl_0__t0_b_n32 wl_0_b_n32 245.959
rwl_0_t1_b_n32 wl_0__t1_b_n32 wl_0_b_n32 245.959
rwl_0_t2_b_n32 wl_0__t2_b_n32 wl_0_b_n32 81.9864
rwl_0_t3_b_n32 wl_0__t3_b_n32 wl_0_b_n32 81.9864
rwl_1_t0_b_n32 wl_1__t0_b_n32 wl_1_b_n32 245.959
rwl_1_t1_b_n32 wl_1__t1_b_n32 wl_1_b_n32 81.9864
rwl_1_t2_b_n32 wl_1__t2_b_n32 wl_1_b_n32 81.9864
rwl_1_t3_b_n32 wl_1__t3_b_n32 wl_1_b_n32 245.959
rwl_2_t0_b_n32 wl_2__t0_b_n32 wl_2_b_n32 245.959
rwl_2_t1_b_n32 wl_2__t1_b_n32 wl_2_b_n32 81.9864
rwl_2_t2_b_n32 wl_2__t2_b_n32 wl_2_b_n32 81.9864
rwl_2_t3_b_n32 wl_2__t3_b_n32 wl_2_b_n32 245.959
rwl_3_t0_b_n32 wl_3__t0_b_n32 wl_3_b_n32 245.959
rwl_3_t1_b_n32 wl_3__t1_b_n32 wl_3_b_n32 81.9864
rwl_3_t2_b_n32 wl_3__t2_b_n32 wl_3_b_n32 81.9864
rwl_3_t3_b_n32 wl_3__t3_b_n32 wl_3_b_n32 245.959
c_10_b_n32 n10_b_n32 0 2.91622e-16
c_17_b_n32 n17_b_n32 0 2.91528e-16
c_18_b_n32 n18_b_n32 0 2.91528e-16
c_19_b_n32 n19_b_n32 0 2.91528e-16
c_20_b_n32 n20_b_n32 0 2.91622e-16
c_22_b_n32 n22_b_n32 0 2.91528e-16
c_23_b_n32 n23_b_n32 0 2.91528e-16
c_24_b_n32 n24_b_n32 0 2.91528e-16
c_25_b_n32 n25_b_n32 0 2.91622e-16
c_29_b_n32 n29_b_n32 0 2.91528e-16
c_30_b_n32 n30_b_n32 0 2.91528e-16
c_31_b_n32 n31_b_n32 0 2.91528e-16
c_32_b_n32 n32_b_n32 0 2.91622e-16
c_7_b_n32 n7_b_n32 0 2.91528e-16
c_8_b_n32 n8_b_n32 0 2.91528e-16
c_9_b_n32 n9_b_n32 0 2.91528e-16
cgnd_b_n32 0 0 2.48166e-15
cbl_0_b_n32 bl_0_b_n32 0 4.52661e-16
cbl_1_b_n32 bl_1_b_n32 0 4.52661e-16
cbl_2_b_n32 bl_2_b_n32 0 4.52661e-16
cbl_3_b_n32 bl_3_b_n32 0 4.52661e-16
crbl_0_b_n32 rbl_0_b_n32 0 9.14472e-16
crbl_1_b_n32 rbl_1_b_n32 0 9.14472e-16
crbl_2_b_n32 rbl_2_b_n32 0 9.14472e-16
crbl_3_b_n32 rbl_3_b_n32 0 9.17566e-16
crwl_0_b_n32 rwl_0_b_n32 0 5.19495e-16
crwl_1_b_n32 rwl_1_b_n32 0 5.11719e-16
crwl_2_b_n32 rwl_2_b_n32 0 5.11719e-16
crwl_3_b_n32 rwl_3_b_n32 0 5.19495e-16
cwl_0_b_n32 wl_0_b_n32 0 3.30388e-16
cwl_1_b_n32 wl_1_b_n32 0 3.30388e-16
cwl_2_b_n32 wl_2_b_n32 0 3.30388e-16
cwl_3_b_n32 wl_3_b_n32 0 3.30388e-16
ccc__10__9_b_n32 n10_b_n32 n9_b_n32 1.02e-17
ccc__10_bl_3_b_n32 n10_b_n32 bl_3_b_n32 1.3999e-17
ccc__10_rwl_0_b_n32 n10_b_n32 rwl_0_b_n32 4.335e-18
ccc__17__18_b_n32 n17_b_n32 n18_b_n32 1.02e-17
ccc__17_bl_0_b_n32 n17_b_n32 bl_0_b_n32 8.415e-18
ccc__17_rwl_1_b_n32 n17_b_n32 rwl_1_b_n32 1.3194e-17
ccc__18__19_b_n32 n18_b_n32 n19_b_n32 1.02e-17
ccc__18_bl_1_b_n32 n18_b_n32 bl_1_b_n32 8.415e-18
ccc__18_rwl_1_b_n32 n18_b_n32 rwl_1_b_n32 1.3194e-17
ccc__19__20_b_n32 n19_b_n32 n20_b_n32 1.02e-17
ccc__19_bl_2_b_n32 n19_b_n32 bl_2_b_n32 8.415e-18
ccc__19_rwl_1_b_n32 n19_b_n32 rwl_1_b_n32 1.3194e-17
ccc__20_bl_3_b_n32 n20_b_n32 bl_3_b_n32 8.415e-18
ccc__20_rwl_1_b_n32 n20_b_n32 rwl_1_b_n32 6.655e-18
ccc__22__23_b_n32 n22_b_n32 n23_b_n32 1.02e-17
ccc__22_bl_0_b_n32 n22_b_n32 bl_0_b_n32 8.415e-18
ccc__22_rwl_2_b_n32 n22_b_n32 rwl_2_b_n32 1.3194e-17
ccc__23__24_b_n32 n23_b_n32 n24_b_n32 1.02e-17
ccc__23_bl_1_b_n32 n23_b_n32 bl_1_b_n32 8.415e-18
ccc__23_rwl_2_b_n32 n23_b_n32 rwl_2_b_n32 1.3194e-17
ccc__24__25_b_n32 n24_b_n32 n25_b_n32 1.02e-17
ccc__24_bl_2_b_n32 n24_b_n32 bl_2_b_n32 8.415e-18
ccc__24_rwl_2_b_n32 n24_b_n32 rwl_2_b_n32 1.3194e-17
ccc__25_bl_3_b_n32 n25_b_n32 bl_3_b_n32 8.415e-18
ccc__25_rwl_2_b_n32 n25_b_n32 rwl_2_b_n32 6.655e-18
ccc__29__30_b_n32 n29_b_n32 n30_b_n32 1.02e-17
ccc__29_bl_0_b_n32 n29_b_n32 bl_0_b_n32 8.415e-18
ccc__29_rwl_3_b_n32 n29_b_n32 rwl_3_b_n32 1.3194e-17
ccc__30__31_b_n32 n30_b_n32 n31_b_n32 1.02e-17
ccc__30_bl_1_b_n32 n30_b_n32 bl_1_b_n32 8.415e-18
ccc__30_rwl_3_b_n32 n30_b_n32 rwl_3_b_n32 1.3194e-17
ccc__31__32_b_n32 n31_b_n32 n32_b_n32 1.02e-17
ccc__31_bl_2_b_n32 n31_b_n32 bl_2_b_n32 8.415e-18
ccc__31_rwl_3_b_n32 n31_b_n32 rwl_3_b_n32 1.3194e-17
ccc__32_bl_3_b_n32 n32_b_n32 bl_3_b_n32 8.415e-18
ccc__32_rwl_3_b_n32 n32_b_n32 rwl_3_b_n32 6.655e-18
ccc__7__8_b_n32 n7_b_n32 n8_b_n32 1.02e-17
ccc__7_bl_0_b_n32 n7_b_n32 bl_0_b_n32 1.3999e-17
ccc__7_rwl_0_b_n32 n7_b_n32 rwl_0_b_n32 8.961e-18
ccc__8__9_b_n32 n8_b_n32 n9_b_n32 1.02e-17
ccc__8_bl_1_b_n32 n8_b_n32 bl_1_b_n32 1.3999e-17
ccc__8_rwl_0_b_n32 n8_b_n32 rwl_0_b_n32 8.961e-18
ccc__9_bl_2_b_n32 n9_b_n32 bl_2_b_n32 1.3999e-17
ccc__9_rwl_0_b_n32 n9_b_n32 rwl_0_b_n32 8.961e-18
ccc_bl_0_rbl_0_b_n32 bl_0_b_n32 rbl_0_b_n32 1.88693e-16
ccc_bl_0_rwl_1_b_n32 bl_0_b_n32 rwl_1_b_n32 1.0093e-17
ccc_bl_0_rwl_2_b_n32 bl_0_b_n32 rwl_2_b_n32 1.0093e-17
ccc_bl_1_rbl_0_b_n32 bl_1_b_n32 rbl_0_b_n32 1.633e-16
ccc_bl_1_rbl_1_b_n32 bl_1_b_n32 rbl_1_b_n32 1.88693e-16
ccc_bl_1_rwl_1_b_n32 bl_1_b_n32 rwl_1_b_n32 1.0093e-17
ccc_bl_1_rwl_2_b_n32 bl_1_b_n32 rwl_2_b_n32 1.0093e-17
ccc_bl_2_rbl_1_b_n32 bl_2_b_n32 rbl_1_b_n32 1.633e-16
ccc_bl_2_rbl_2_b_n32 bl_2_b_n32 rbl_2_b_n32 1.88693e-16
ccc_bl_2_rwl_1_b_n32 bl_2_b_n32 rwl_1_b_n32 1.0093e-17
ccc_bl_2_rwl_2_b_n32 bl_2_b_n32 rwl_2_b_n32 1.0093e-17
ccc_bl_3_rbl_2_b_n32 bl_3_b_n32 rbl_2_b_n32 1.633e-16
ccc_bl_3_rbl_3_b_n32 bl_3_b_n32 rbl_3_b_n32 1.88693e-16
ccc_bl_3_rwl_1_b_n32 bl_3_b_n32 rwl_1_b_n32 1.0093e-17
ccc_bl_3_rwl_2_b_n32 bl_3_b_n32 rwl_2_b_n32 1.0093e-17
ccc_rbl_0_rbl_1_b_n32 rbl_0_b_n32 rbl_1_b_n32 3.432e-17
ccc_rbl_0_rwl_0_b_n32 rbl_0_b_n32 rwl_0_b_n32 4.9752e-17
ccc_rbl_0_rwl_1_b_n32 rbl_0_b_n32 rwl_1_b_n32 4.9752e-17
ccc_rbl_0_rwl_2_b_n32 rbl_0_b_n32 rwl_2_b_n32 4.9752e-17
ccc_rbl_0_rwl_3_b_n32 rbl_0_b_n32 rwl_3_b_n32 4.9752e-17
ccc_rbl_1_rbl_2_b_n32 rbl_1_b_n32 rbl_2_b_n32 3.432e-17
ccc_rbl_1_rwl_0_b_n32 rbl_1_b_n32 rwl_0_b_n32 4.9752e-17
ccc_rbl_1_rwl_1_b_n32 rbl_1_b_n32 rwl_1_b_n32 4.9752e-17
ccc_rbl_1_rwl_2_b_n32 rbl_1_b_n32 rwl_2_b_n32 4.9752e-17
ccc_rbl_1_rwl_3_b_n32 rbl_1_b_n32 rwl_3_b_n32 4.9752e-17
ccc_rbl_2_rbl_3_b_n32 rbl_2_b_n32 rbl_3_b_n32 3.432e-17
ccc_rbl_2_rwl_0_b_n32 rbl_2_b_n32 rwl_0_b_n32 4.9752e-17
ccc_rbl_2_rwl_1_b_n32 rbl_2_b_n32 rwl_1_b_n32 4.9752e-17
ccc_rbl_2_rwl_2_b_n32 rbl_2_b_n32 rwl_2_b_n32 4.9752e-17
ccc_rbl_2_rwl_3_b_n32 rbl_2_b_n32 rwl_3_b_n32 4.9752e-17
ccc_rbl_3_rwl_0_b_n32 rbl_3_b_n32 rwl_0_b_n32 3.3407e-17
ccc_rbl_3_rwl_1_b_n32 rbl_3_b_n32 rwl_1_b_n32 3.3407e-17
ccc_rbl_3_rwl_2_b_n32 rbl_3_b_n32 rwl_2_b_n32 3.3407e-17
ccc_rbl_3_rwl_3_b_n32 rbl_3_b_n32 rwl_3_b_n32 3.3407e-17
vdw_b_n32_0 wl_0_b_n32 0 dc 0
vdr_b_n32_0 rwl_0_b_n32 0 dc 0
vdw_b_n32_1 wl_1_b_n32 0 dc 0
vdr_b_n32_1 rwl_1_b_n32 0 dc 0
vdw_b_n32_2 wl_2_b_n32 0 dc 0
vdr_b_n32_2 rwl_2_b_n32 0 dc 0
vdw_b_n32_3 wl_3_b_n32 0 dc 0
vdr_b_n32_3 rwl_3_b_n32 0 dc 0
vdb_b_n32_0 bl_0_b_n32 0 dc 0
vdp_b_n32_0 rbl_0_b_n32 0 dc 0
vdb_b_n32_1 bl_1_b_n32 0 dc 0
vdp_b_n32_1 rbl_1_b_n32 0 dc 0
vdb_b_n32_2 bl_2_b_n32 0 dc 0
vdp_b_n32_2 rbl_2_b_n32 0 dc 0
vdb_b_n32_3 bl_3_b_n32 0 dc 0
vdp_b_n32_3 rbl_3_b_n32 0 dc 0
vdn_b_n32_n7 n7_b_n32 0 dc 1
vdn_b_n32_n8 n8_b_n32 0 dc 1
vdn_b_n32_n9 n9_b_n32 0 dc 1
vdn_b_n32_n10 n10_b_n32 0 dc 1
vdn_b_n32_n17 n17_b_n32 0 dc 1
vdn_b_n32_n18 n18_b_n32 0 dc 1
vdn_b_n32_n19 n19_b_n32 0 dc 1
vdn_b_n32_n20 n20_b_n32 0 dc 1
vdn_b_n32_n22 n22_b_n32 0 dc 1
vdn_b_n32_n23 n23_b_n32 0 dc 1
vdn_b_n32_n24 n24_b_n32 0 dc 1
vdn_b_n32_n25 n25_b_n32 0 dc 1
vdn_b_n32_n29 n29_b_n32 0 dc 1
vdn_b_n32_n30 n30_b_n32 0 dc 1
vdn_b_n32_n31 n31_b_n32 0 dc 1
bdr_b_n32 n32_b_n32 0 i=5e-08*min(1,max(0,(time-1e-09)/0.2n))*0.5*(1+tanh((v(n32_b_n32)-0.05)/0.01))

* ---- instance rate: variant a, probed storage node \$20 ----
xm1_rate rwl_0__t2_rate n7__t0_rate rbl_0__t0_rate gnd__t0_rate sky130_fd_pr__nfet_01v8 L=0.15 W=0.42 nf=1 ad=0.1197 as=0.1197 pd=1.41 ps=1.41 mult=1 m=1
xm2_rate rwl_0__t3_rate n8__t1_rate rbl_1__t1_rate gnd__t1_rate sky130_fd_pr__nfet_01v8 L=0.15 W=0.42 nf=1 ad=0.1197 as=0.1197 pd=1.41 ps=1.41 mult=1 m=1
xm3_rate rwl_0__t1_rate n9__t1_rate rbl_2__t1_rate gnd__t2_rate sky130_fd_pr__nfet_01v8 L=0.15 W=0.42 nf=1 ad=0.1197 as=0.1197 pd=1.41 ps=1.41 mult=1 m=1
xm4_rate rwl_0__t0_rate n10__t1_rate rbl_3__t1_rate gnd__t3_rate sky130_fd_pr__nfet_01v8 L=0.15 W=0.42 nf=1 ad=0.1197 as=0.1197 pd=1.41 ps=1.41 mult=1 m=1
xm5_rate bl_0__t0_rate wl_0__t0_rate n7__t1_rate gnd__t8_rate sky130_fd_pr__nfet_01v8 L=0.15 W=0.42 nf=1 ad=0.0588 as=0.1197 pd=0.7 ps=1.41 mult=1 m=1
xm6_rate n17__t0_rate wl_1__t0_rate bl_0__t1_rate gnd__t20_rate sky130_fd_pr__nfet_01v8 L=0.15 W=0.42 nf=1 ad=0.1197 as=0.0588 pd=1.41 ps=0.7 mult=1 m=1
xm7_rate bl_1__t2_rate wl_0__t3_rate n8__t0_rate gnd__t9_rate sky130_fd_pr__nfet_01v8 L=0.15 W=0.42 nf=1 ad=0.0588 as=0.1197 pd=0.7 ps=1.41 mult=1 m=1
xm8_rate n18__t0_rate wl_1__t1_rate bl_1__t0_rate gnd__t21_rate sky130_fd_pr__nfet_01v8 L=0.15 W=0.42 nf=1 ad=0.1197 as=0.0588 pd=1.41 ps=0.7 mult=1 m=1
xm9_rate bl_2__t2_rate wl_0__t2_rate n9__t0_rate gnd__t10_rate sky130_fd_pr__nfet_01v8 L=0.15 W=0.42 nf=1 ad=0.0588 as=0.1197 pd=0.7 ps=1.41 mult=1 m=1
xm10_rate n19__t0_rate wl_1__t2_rate bl_2__t0_rate gnd__t22_rate sky130_fd_pr__nfet_01v8 L=0.15 W=0.42 nf=1 ad=0.1197 as=0.0588 pd=1.41 ps=0.7 mult=1 m=1
xm11_rate bl_3__t2_rate wl_0__t1_rate n10__t0_rate gnd__t11_rate sky130_fd_pr__nfet_01v8 L=0.15 W=0.42 nf=1 ad=0.0588 as=0.1197 pd=0.7 ps=1.41 mult=1 m=1
xm12_rate n20__t0_rate wl_1__t3_rate bl_3__t1_rate gnd__t23_rate sky130_fd_pr__nfet_01v8 L=0.15 W=0.42 nf=1 ad=0.1197 as=0.0588 pd=1.41 ps=0.7 mult=1 m=1
xm13_rate rbl_0__t3_rate n17__t1_rate rwl_1__t0_rate gnd__t12_rate sky130_fd_pr__nfet_01v8 L=0.15 W=0.42 nf=1 ad=0.0588 as=0.1197 pd=0.7 ps=1.41 mult=1 m=1
xm14_rate rwl_2__t3_rate n22__t0_rate rbl_0__t2_rate gnd__t24_rate sky130_fd_pr__nfet_01v8 L=0.15 W=0.42 nf=1 ad=0.1197 as=0.0588 pd=1.41 ps=0.7 mult=1 m=1
xm15_rate rbl_1__t3_rate n18__t1_rate rwl_1__t1_rate gnd__t13_rate sky130_fd_pr__nfet_01v8 L=0.15 W=0.42 nf=1 ad=0.0588 as=0.1197 pd=0.7 ps=1.41 mult=1 m=1
xm16_rate rwl_2__t0_rate n23__t0_rate rbl_1__t2_rate gnd__t25_rate sky130_fd_pr__nfet_01v8 L=0.15 W=0.42 nf=1 ad=0.1197 as=0.0588 pd=1.41 ps=0.7 mult=1 m=1
xm17_rate rbl_2__t3_rate n19__t1_rate rwl_1__t2_rate gnd__t14_rate sky130_fd_pr__nfet_01v8 L=0.15 W=0.42 nf=1 ad=0.0588 as=0.1197 pd=0.7 ps=1.41 mult=1 m=1
xm18_rate rwl_2__t1_rate n24__t0_rate rbl_2__t2_rate gnd__t26_rate sky130_fd_pr__nfet_01v8 L=0.15 W=0.42 nf=1 ad=0.1197 as=0.0588 pd=1.41 ps=0.7 mult=1 m=1
xm19_rate rbl_3__t3_rate n20__t1_rate rwl_1__t3_rate gnd__t15_rate sky130_fd_pr__nfet_01v8 L=0.15 W=0.42 nf=1 ad=0.0588 as=0.1197 pd=0.7 ps=1.41 mult=1 m=1
xm20_rate rwl_2__t2_rate n25__t0_rate rbl_3__t2_rate gnd__t27_rate sky130_fd_pr__nfet_01v8 L=0.15 W=0.42 nf=1 ad=0.1197 as=0.0588 pd=1.41 ps=0.7 mult=1 m=1
xm21_rate bl_0__t3_rate wl_2__t0_rate n22__t1_rate gnd__t16_rate sky130_fd_pr__nfet_01v8 L=0.15 W=0.42 nf=1 ad=0.0588 as=0.1197 pd=0.7 ps=1.41 mult=1 m=1
xm22_rate n29__t0_rate wl_3__t3_rate bl_0__t2_rate gnd__t28_rate sky130_fd_pr__nfet_01v8 L=0.15 W=0.42 nf=1 ad=0.1197 as=0.0588 pd=1.41 ps=0.7 mult=1 m=1
xm23_rate bl_1__t3_rate wl_2__t1_rate n23__t1_rate gnd__t17_rate sky130_fd_pr__nfet_01v8 L=0.15 W=0.42 nf=1 ad=0.0588 as=0.1197 pd=0.7 ps=1.41 mult=1 m=1
xm24_rate n30__t0_rate wl_3__t2_rate bl_1__t1_rate gnd__t29_rate sky130_fd_pr__nfet_01v8 L=0.15 W=0.42 nf=1 ad=0.1197 as=0.0588 pd=1.41 ps=0.7 mult=1 m=1
xm25_rate bl_2__t3_rate wl_2__t2_rate n24__t1_rate gnd__t18_rate sky130_fd_pr__nfet_01v8 L=0.15 W=0.42 nf=1 ad=0.0588 as=0.1197 pd=0.7 ps=1.41 mult=1 m=1
xm26_rate n31__t0_rate wl_3__t1_rate bl_2__t1_rate gnd__t30_rate sky130_fd_pr__nfet_01v8 L=0.15 W=0.42 nf=1 ad=0.1197 as=0.0588 pd=1.41 ps=0.7 mult=1 m=1
xm27_rate bl_3__t3_rate wl_2__t3_rate n25__t1_rate gnd__t19_rate sky130_fd_pr__nfet_01v8 L=0.15 W=0.42 nf=1 ad=0.0588 as=0.1197 pd=0.7 ps=1.41 mult=1 m=1
xm28_rate n32__t0_rate wl_3__t0_rate bl_3__t0_rate gnd__t31_rate sky130_fd_pr__nfet_01v8 L=0.15 W=0.42 nf=1 ad=0.1197 as=0.0588 pd=1.41 ps=0.7 mult=1 m=1
xm29_rate rbl_0__t1_rate n29__t1_rate rwl_3__t0_rate gnd__t4_rate sky130_fd_pr__nfet_01v8 L=0.15 W=0.42 nf=1 ad=0.1197 as=0.1197 pd=1.41 ps=1.41 mult=1 m=1
xm30_rate rbl_1__t0_rate n30__t1_rate rwl_3__t1_rate gnd__t5_rate sky130_fd_pr__nfet_01v8 L=0.15 W=0.42 nf=1 ad=0.1197 as=0.1197 pd=1.41 ps=1.41 mult=1 m=1
xm31_rate rbl_2__t0_rate n31__t1_rate rwl_3__t2_rate gnd__t6_rate sky130_fd_pr__nfet_01v8 L=0.15 W=0.42 nf=1 ad=0.1197 as=0.1197 pd=1.41 ps=1.41 mult=1 m=1
xm32_rate rbl_3__t0_rate n32__t1_rate rwl_3__t3_rate gnd__t7_rate sky130_fd_pr__nfet_01v8 L=0.15 W=0.42 nf=1 ad=0.1197 as=0.1197 pd=1.41 ps=1.41 mult=1 m=1
r_10_t0_rate n10__t0_rate n10_rate 183.071
r_10_t1_rate n10__t1_rate n10_rate 183.071
r_17_t0_rate n17__t0_rate n17_rate 183.071
r_17_t1_rate n17__t1_rate n17_rate 183.071
r_18_t0_rate n18__t0_rate n18_rate 183.071
r_18_t1_rate n18__t1_rate n18_rate 183.071
r_19_t0_rate n19__t0_rate n19_rate 183.071
r_19_t1_rate n19__t1_rate n19_rate 183.071
r_20_t0_rate n20__t0_rate n20_rate 183.071
r_20_t1_rate n20__t1_rate n20_rate 183.071
r_22_t0_rate n22__t0_rate n22_rate 183.071
r_22_t1_rate n22__t1_rate n22_rate 183.071
r_23_t0_rate n23__t0_rate n23_rate 183.071
r_23_t1_rate n23__t1_rate n23_rate 183.071
r_24_t0_rate n24__t0_rate n24_rate 183.071
r_24_t1_rate n24__t1_rate n24_rate 183.071
r_25_t0_rate n25__t0_rate n25_rate 183.071
r_25_t1_rate n25__t1_rate n25_rate 183.071
r_29_t0_rate n29__t0_rate n29_rate 183.071
r_29_t1_rate n29__t1_rate n29_rate 183.071
r_30_t0_rate n30__t0_rate n30_rate 183.071
r_30_t1_rate n30__t1_rate n30_rate 183.071
r_31_t0_rate n31__t0_rate n31_rate 183.071
r_31_t1_rate n31__t1_rate n31_rate 183.071
r_32_t0_rate n32__t0_rate n32_rate 183.071
r_32_t1_rate n32__t1_rate n32_rate 183.071
r_7_t0_rate n7__t0_rate n7_rate 183.071
r_7_t1_rate n7__t1_rate n7_rate 183.071
r_8_t0_rate n8__t0_rate n8_rate 183.071
r_8_t1_rate n8__t1_rate n8_rate 183.071
r_9_t0_rate n9__t0_rate n9_rate 183.071
r_9_t1_rate n9__t1_rate n9_rate 183.071
rgnd_t0_rate gnd__t0_rate 0 38.2988
rgnd_t1_rate gnd__t1_rate 0 33.9576
rgnd_t2_rate gnd__t2_rate 0 33.9576
rgnd_t3_rate gnd__t3_rate 0 38.2988
rgnd_t4_rate gnd__t4_rate 0 38.2988
rgnd_t5_rate gnd__t5_rate 0 33.9576
rgnd_t6_rate gnd__t6_rate 0 33.9576
rgnd_t7_rate gnd__t7_rate 0 38.2988
rgnd_t8_rate gnd__t8_rate 0 28.0185
rgnd_t9_rate gnd__t9_rate 0 21.7106
rgnd_t10_rate gnd__t10_rate 0 21.7106
rgnd_t11_rate gnd__t11_rate 0 28.0185
rgnd_t12_rate gnd__t12_rate 0 18.9833
rgnd_t13_rate gnd__t13_rate 0 6.8325
rgnd_t14_rate gnd__t14_rate 0 6.8325
rgnd_t15_rate gnd__t15_rate 0 18.9833
rgnd_t16_rate gnd__t16_rate 0 24.2409
rgnd_t17_rate gnd__t17_rate 0 16.5511
rgnd_t18_rate gnd__t18_rate 0 16.5511
rgnd_t19_rate gnd__t19_rate 0 24.2409
rgnd_t20_rate gnd__t20_rate 0 24.2409
rgnd_t21_rate gnd__t21_rate 0 16.5511
rgnd_t22_rate gnd__t22_rate 0 16.5511
rgnd_t23_rate gnd__t23_rate 0 24.2409
rgnd_t24_rate gnd__t24_rate 0 18.9833
rgnd_t25_rate gnd__t25_rate 0 6.8325
rgnd_t26_rate gnd__t26_rate 0 6.8325
rgnd_t27_rate gnd__t27_rate 0 18.9833
rgnd_t28_rate gnd__t28_rate 0 28.0185
rgnd_t29_rate gnd__t29_rate 0 21.7106
rgnd_t30_rate gnd__t30_rate 0 21.7106
rgnd_t31_rate gnd__t31_rate 0 28.0185
rbl_0_t0_rate bl_0__t0_rate bl_0_rate 14.8304
rbl_0_t1_rate bl_0__t1_rate bl_0_rate 10.9301
rbl_0_t2_rate bl_0__t2_rate bl_0_rate 14.8304
rbl_0_t3_rate bl_0__t3_rate bl_0_rate 10.9301
rbl_1_t0_rate bl_1__t0_rate bl_1_rate 10.9301
rbl_1_t1_rate bl_1__t1_rate bl_1_rate 14.8304
rbl_1_t2_rate bl_1__t2_rate bl_1_rate 14.8304
rbl_1_t3_rate bl_1__t3_rate bl_1_rate 10.9301
rbl_2_t0_rate bl_2__t0_rate bl_2_rate 10.9301
rbl_2_t1_rate bl_2__t1_rate bl_2_rate 14.8304
rbl_2_t2_rate bl_2__t2_rate bl_2_rate 14.8304
rbl_2_t3_rate bl_2__t3_rate bl_2_rate 10.9301
rbl_3_t0_rate bl_3__t0_rate bl_3_rate 14.8304
rbl_3_t1_rate bl_3__t1_rate bl_3_rate 10.9301
rbl_3_t2_rate bl_3__t2_rate bl_3_rate 14.8304
rbl_3_t3_rate bl_3__t3_rate bl_3_rate 10.9301
rrbl_0_t0_rate rbl_0__t0_rate rbl_0_rate 36.5601
rrbl_0_t1_rate rbl_0__t1_rate rbl_0_rate 36.5601
rrbl_0_t2_rate rbl_0__t2_rate rbl_0_rate 2.99444
rrbl_0_t3_rate rbl_0__t3_rate rbl_0_rate 2.99444
rrbl_1_t0_rate rbl_1__t0_rate rbl_1_rate 36.5601
rrbl_1_t1_rate rbl_1__t1_rate rbl_1_rate 36.5601
rrbl_1_t2_rate rbl_1__t2_rate rbl_1_rate 2.99444
rrbl_1_t3_rate rbl_1__t3_rate rbl_1_rate 2.99444
rrbl_2_t0_rate rbl_2__t0_rate rbl_2_rate 36.5601
rrbl_2_t1_rate rbl_2__t1_rate rbl_2_rate 36.5601
rrbl_2_t2_rate rbl_2__t2_rate rbl_2_rate 2.99444
rrbl_2_t3_rate rbl_2__t3_rate rbl_2_rate 2.99444
rrbl_3_t0_rate rbl_3__t0_rate rbl_3_rate 36.5601
rrbl_3_t1_rate rbl_3__t1_rate rbl_3_rate 36.5601
rrbl_3_t2_rate rbl_3__t2_rate rbl_3_rate 2.99444
rrbl_3_t3_rate rbl_3__t3_rate rbl_3_rate 2.99444
rrwl_0_t0_rate rwl_0__t0_rate rwl_0_rate 38.2618
rrwl_0_t1_rate rwl_0__t1_rate rwl_0_rate 12.7539
rrwl_0_t2_rate rwl_0__t2_rate rwl_0_rate 38.2618
rrwl_0_t3_rate rwl_0__t3_rate rwl_0_rate 12.7539
rrwl_1_t0_rate rwl_1__t0_rate rwl_1_rate 38.2618
rrwl_1_t1_rate rwl_1__t1_rate rwl_1_rate 12.7539
rrwl_1_t2_rate rwl_1__t2_rate rwl_1_rate 12.7539
rrwl_1_t3_rate rwl_1__t3_rate rwl_1_rate 38.2618
rrwl_2_t0_rate rwl_2__t0_rate rwl_2_rate 12.7539
rrwl_2_t1_rate rwl_2__t1_rate rwl_2_rate 12.7539
rrwl_2_t2_rate rwl_2__t2_rate rwl_2_rate 38.2618
rrwl_2_t3_rate rwl_2__t3_rate rwl_2_rate 38.2618
rrwl_3_t0_rate rwl_3__t0_rate rwl_3_rate 38.2618
rrwl_3_t1_rate rwl_3__t1_rate rwl_3_rate 12.7539
rrwl_3_t2_rate rwl_3__t2_rate rwl_3_rate 12.7539
rrwl_3_t3_rate rwl_3__t3_rate rwl_3_rate 38.2618
rwl_0_t0_rate wl_0__t0_rate wl_0_rate 245.959
rwl_0_t1_rate wl_0__t1_rate wl_0_rate 245.959
rwl_0_t2_rate wl_0__t2_rate wl_0_rate 81.9864
rwl_0_t3_rate wl_0__t3_rate wl_0_rate 81.9864
rwl_1_t0_rate wl_1__t0_rate wl_1_rate 245.959
rwl_1_t1_rate wl_1__t1_rate wl_1_rate 81.9864
rwl_1_t2_rate wl_1__t2_rate wl_1_rate 81.9864
rwl_1_t3_rate wl_1__t3_rate wl_1_rate 245.959
rwl_2_t0_rate wl_2__t0_rate wl_2_rate 245.959
rwl_2_t1_rate wl_2__t1_rate wl_2_rate 81.9864
rwl_2_t2_rate wl_2__t2_rate wl_2_rate 81.9864
rwl_2_t3_rate wl_2__t3_rate wl_2_rate 245.959
rwl_3_t0_rate wl_3__t0_rate wl_3_rate 245.959
rwl_3_t1_rate wl_3__t1_rate wl_3_rate 81.9864
rwl_3_t2_rate wl_3__t2_rate wl_3_rate 81.9864
rwl_3_t3_rate wl_3__t3_rate wl_3_rate 245.959
c_10_rate n10_rate 0 2.91622e-16
c_17_rate n17_rate 0 2.91528e-16
c_18_rate n18_rate 0 2.91528e-16
c_19_rate n19_rate 0 2.91528e-16
c_20_rate n20_rate 0 2.91622e-16
c_22_rate n22_rate 0 2.91528e-16
c_23_rate n23_rate 0 2.91528e-16
c_24_rate n24_rate 0 2.91528e-16
c_25_rate n25_rate 0 2.91622e-16
c_29_rate n29_rate 0 2.91528e-16
c_30_rate n30_rate 0 2.91528e-16
c_31_rate n31_rate 0 2.91528e-16
c_32_rate n32_rate 0 2.91622e-16
c_7_rate n7_rate 0 2.91528e-16
c_8_rate n8_rate 0 2.91528e-16
c_9_rate n9_rate 0 2.91528e-16
cgnd_rate 0 0 2.48166e-15
cbl_0_rate bl_0_rate 0 4.52661e-16
cbl_1_rate bl_1_rate 0 4.52661e-16
cbl_2_rate bl_2_rate 0 4.52661e-16
cbl_3_rate bl_3_rate 0 4.52661e-16
crbl_0_rate rbl_0_rate 0 9.14472e-16
crbl_1_rate rbl_1_rate 0 9.14472e-16
crbl_2_rate rbl_2_rate 0 9.14472e-16
crbl_3_rate rbl_3_rate 0 9.17566e-16
crwl_0_rate rwl_0_rate 0 5.19495e-16
crwl_1_rate rwl_1_rate 0 5.11719e-16
crwl_2_rate rwl_2_rate 0 5.11719e-16
crwl_3_rate rwl_3_rate 0 5.19495e-16
cwl_0_rate wl_0_rate 0 3.30388e-16
cwl_1_rate wl_1_rate 0 3.30388e-16
cwl_2_rate wl_2_rate 0 3.30388e-16
cwl_3_rate wl_3_rate 0 3.30388e-16
ccc__10__9_rate n10_rate n9_rate 1.02e-17
ccc__10_bl_3_rate n10_rate bl_3_rate 1.3999e-17
ccc__10_rwl_0_rate n10_rate rwl_0_rate 4.335e-18
ccc__17__18_rate n17_rate n18_rate 1.02e-17
ccc__17_bl_0_rate n17_rate bl_0_rate 8.415e-18
ccc__17_rwl_1_rate n17_rate rwl_1_rate 1.3194e-17
ccc__18__19_rate n18_rate n19_rate 1.02e-17
ccc__18_bl_1_rate n18_rate bl_1_rate 8.415e-18
ccc__18_rwl_1_rate n18_rate rwl_1_rate 1.3194e-17
ccc__19__20_rate n19_rate n20_rate 1.02e-17
ccc__19_bl_2_rate n19_rate bl_2_rate 8.415e-18
ccc__19_rwl_1_rate n19_rate rwl_1_rate 1.3194e-17
ccc__20_bl_3_rate n20_rate bl_3_rate 8.415e-18
ccc__20_rwl_1_rate n20_rate rwl_1_rate 6.655e-18
ccc__22__23_rate n22_rate n23_rate 1.02e-17
ccc__22_bl_0_rate n22_rate bl_0_rate 8.415e-18
ccc__22_rwl_2_rate n22_rate rwl_2_rate 1.3194e-17
ccc__23__24_rate n23_rate n24_rate 1.02e-17
ccc__23_bl_1_rate n23_rate bl_1_rate 8.415e-18
ccc__23_rwl_2_rate n23_rate rwl_2_rate 1.3194e-17
ccc__24__25_rate n24_rate n25_rate 1.02e-17
ccc__24_bl_2_rate n24_rate bl_2_rate 8.415e-18
ccc__24_rwl_2_rate n24_rate rwl_2_rate 1.3194e-17
ccc__25_bl_3_rate n25_rate bl_3_rate 8.415e-18
ccc__25_rwl_2_rate n25_rate rwl_2_rate 6.655e-18
ccc__29__30_rate n29_rate n30_rate 1.02e-17
ccc__29_bl_0_rate n29_rate bl_0_rate 8.415e-18
ccc__29_rwl_3_rate n29_rate rwl_3_rate 1.3194e-17
ccc__30__31_rate n30_rate n31_rate 1.02e-17
ccc__30_bl_1_rate n30_rate bl_1_rate 8.415e-18
ccc__30_rwl_3_rate n30_rate rwl_3_rate 1.3194e-17
ccc__31__32_rate n31_rate n32_rate 1.02e-17
ccc__31_bl_2_rate n31_rate bl_2_rate 8.415e-18
ccc__31_rwl_3_rate n31_rate rwl_3_rate 1.3194e-17
ccc__32_bl_3_rate n32_rate bl_3_rate 8.415e-18
ccc__32_rwl_3_rate n32_rate rwl_3_rate 6.655e-18
ccc__7__8_rate n7_rate n8_rate 1.02e-17
ccc__7_bl_0_rate n7_rate bl_0_rate 1.3999e-17
ccc__7_rwl_0_rate n7_rate rwl_0_rate 8.961e-18
ccc__8__9_rate n8_rate n9_rate 1.02e-17
ccc__8_bl_1_rate n8_rate bl_1_rate 1.3999e-17
ccc__8_rwl_0_rate n8_rate rwl_0_rate 8.961e-18
ccc__9_bl_2_rate n9_rate bl_2_rate 1.3999e-17
ccc__9_rwl_0_rate n9_rate rwl_0_rate 8.961e-18
ccc_bl_0_rbl_0_rate bl_0_rate rbl_0_rate 1.88693e-16
ccc_bl_0_rwl_1_rate bl_0_rate rwl_1_rate 1.0093e-17
ccc_bl_0_rwl_2_rate bl_0_rate rwl_2_rate 1.0093e-17
ccc_bl_1_rbl_0_rate bl_1_rate rbl_0_rate 1.633e-16
ccc_bl_1_rbl_1_rate bl_1_rate rbl_1_rate 1.88693e-16
ccc_bl_1_rwl_1_rate bl_1_rate rwl_1_rate 1.0093e-17
ccc_bl_1_rwl_2_rate bl_1_rate rwl_2_rate 1.0093e-17
ccc_bl_2_rbl_1_rate bl_2_rate rbl_1_rate 1.633e-16
ccc_bl_2_rbl_2_rate bl_2_rate rbl_2_rate 1.88693e-16
ccc_bl_2_rwl_1_rate bl_2_rate rwl_1_rate 1.0093e-17
ccc_bl_2_rwl_2_rate bl_2_rate rwl_2_rate 1.0093e-17
ccc_bl_3_rbl_2_rate bl_3_rate rbl_2_rate 1.633e-16
ccc_bl_3_rbl_3_rate bl_3_rate rbl_3_rate 1.88693e-16
ccc_bl_3_rwl_1_rate bl_3_rate rwl_1_rate 1.0093e-17
ccc_bl_3_rwl_2_rate bl_3_rate rwl_2_rate 1.0093e-17
ccc_rbl_0_rbl_1_rate rbl_0_rate rbl_1_rate 3.432e-17
ccc_rbl_0_rwl_0_rate rbl_0_rate rwl_0_rate 4.9752e-17
ccc_rbl_0_rwl_1_rate rbl_0_rate rwl_1_rate 4.9752e-17
ccc_rbl_0_rwl_2_rate rbl_0_rate rwl_2_rate 4.9752e-17
ccc_rbl_0_rwl_3_rate rbl_0_rate rwl_3_rate 4.9752e-17
ccc_rbl_1_rbl_2_rate rbl_1_rate rbl_2_rate 3.432e-17
ccc_rbl_1_rwl_0_rate rbl_1_rate rwl_0_rate 4.9752e-17
ccc_rbl_1_rwl_1_rate rbl_1_rate rwl_1_rate 4.9752e-17
ccc_rbl_1_rwl_2_rate rbl_1_rate rwl_2_rate 4.9752e-17
ccc_rbl_1_rwl_3_rate rbl_1_rate rwl_3_rate 4.9752e-17
ccc_rbl_2_rbl_3_rate rbl_2_rate rbl_3_rate 3.432e-17
ccc_rbl_2_rwl_0_rate rbl_2_rate rwl_0_rate 4.9752e-17
ccc_rbl_2_rwl_1_rate rbl_2_rate rwl_1_rate 4.9752e-17
ccc_rbl_2_rwl_2_rate rbl_2_rate rwl_2_rate 4.9752e-17
ccc_rbl_2_rwl_3_rate rbl_2_rate rwl_3_rate 4.9752e-17
ccc_rbl_3_rwl_0_rate rbl_3_rate rwl_0_rate 3.3407e-17
ccc_rbl_3_rwl_1_rate rbl_3_rate rwl_1_rate 3.3407e-17
ccc_rbl_3_rwl_2_rate rbl_3_rate rwl_2_rate 3.3407e-17
ccc_rbl_3_rwl_3_rate rbl_3_rate rwl_3_rate 3.3407e-17
vdw_rate_0 wl_0_rate 0 dc 0
vdr_rate_0 rwl_0_rate vdd dc 0
vdw_rate_1 wl_1_rate 0 dc 0
vdr_rate_1 rwl_1_rate vdd dc 0
vdw_rate_2 wl_2_rate 0 dc 0
vdr_rate_2 rwl_2_rate vdd dc 0
vdw_rate_3 wl_3_rate 0 dc 0
vdr_rate_3 rwl_3_rate vdd dc 0
vdb_rate_0 bl_0_rate 0 dc 0
vdp_rate_0 rbl_0_rate vrbl dc 0
vdb_rate_1 bl_1_rate 0 dc 0
vdp_rate_1 rbl_1_rate vrbl dc 0
vdb_rate_2 bl_2_rate 0 dc 0
vdp_rate_2 rbl_2_rate vrbl dc 0
vdb_rate_3 bl_3_rate 0 dc 0
vdp_rate_3 rbl_3_rate vrbl dc 0
vdn_rate_n7 n7_rate 0 dc 1
vdn_rate_n8 n8_rate 0 dc 1
vdn_rate_n9 n9_rate 0 dc 1
vdn_rate_n10 n10_rate 0 dc 1
vdn_rate_n17 n17_rate 0 dc 1
vdn_rate_n18 n18_rate 0 dc 1
vdn_rate_n19 n19_rate 0 dc 1
vdn_rate_n22 n22_rate 0 dc 1
vdn_rate_n23 n23_rate 0 dc 1
vdn_rate_n24 n24_rate 0 dc 1
vdn_rate_n25 n25_rate 0 dc 1
vdn_rate_n29 n29_rate 0 dc 1
vdn_rate_n30 n30_rate 0 dc 1
vdn_rate_n31 n31_rate 0 dc 1
vdn_rate_n32 n32_rate 0 dc 1
bdr_rate n20_rate 0 i=1e-08*min(1,max(0,(time-1e-09)/0.2n))*0.5*(1+tanh((v(n20_rate)-0.05)/0.01))

* ---- instance ctl: ideal 1 fF control ----
cctl_ctl ctl_hub 0 1e-15
bdr_ctl ctl_hub 0 i=5e-08*min(1,max(0,(time-1e-09)/0.2n))*0.5*(1+tanh((v(ctl_hub)-0.05)/0.01))

* initial conditions (tran uic): probed node at 1.1 V, everything else at its idle level
.ic v(gnd__t0_a_n7)=0 v(gnd__t1_a_n7)=0 v(gnd__t10_a_n7)=0 v(gnd__t11_a_n7)=0
.ic v(gnd__t12_a_n7)=0 v(gnd__t13_a_n7)=0 v(gnd__t14_a_n7)=0 v(gnd__t15_a_n7)=0
.ic v(gnd__t16_a_n7)=0 v(gnd__t17_a_n7)=0 v(gnd__t18_a_n7)=0 v(gnd__t19_a_n7)=0
.ic v(gnd__t2_a_n7)=0 v(gnd__t20_a_n7)=0 v(gnd__t21_a_n7)=0 v(gnd__t22_a_n7)=0
.ic v(gnd__t23_a_n7)=0 v(gnd__t24_a_n7)=0 v(gnd__t25_a_n7)=0 v(gnd__t26_a_n7)=0
.ic v(gnd__t27_a_n7)=0 v(gnd__t28_a_n7)=0 v(gnd__t29_a_n7)=0 v(gnd__t3_a_n7)=0
.ic v(gnd__t30_a_n7)=0 v(gnd__t31_a_n7)=0 v(gnd__t4_a_n7)=0 v(gnd__t5_a_n7)=0
.ic v(gnd__t6_a_n7)=0 v(gnd__t7_a_n7)=0 v(gnd__t8_a_n7)=0 v(gnd__t9_a_n7)=0
.ic v(n10_a_n7)=1 v(n10__t0_a_n7)=1 v(n10__t1_a_n7)=1 v(n17_a_n7)=1
.ic v(n17__t0_a_n7)=1 v(n17__t1_a_n7)=1 v(n18_a_n7)=1 v(n18__t0_a_n7)=1
.ic v(n18__t1_a_n7)=1 v(n19_a_n7)=1 v(n19__t0_a_n7)=1 v(n19__t1_a_n7)=1
.ic v(n20_a_n7)=1 v(n20__t0_a_n7)=1 v(n20__t1_a_n7)=1 v(n22_a_n7)=1
.ic v(n22__t0_a_n7)=1 v(n22__t1_a_n7)=1 v(n23_a_n7)=1 v(n23__t0_a_n7)=1
.ic v(n23__t1_a_n7)=1 v(n24_a_n7)=1 v(n24__t0_a_n7)=1 v(n24__t1_a_n7)=1
.ic v(n25_a_n7)=1 v(n25__t0_a_n7)=1 v(n25__t1_a_n7)=1 v(n29_a_n7)=1
.ic v(n29__t0_a_n7)=1 v(n29__t1_a_n7)=1 v(n30_a_n7)=1 v(n30__t0_a_n7)=1
.ic v(n30__t1_a_n7)=1 v(n31_a_n7)=1 v(n31__t0_a_n7)=1 v(n31__t1_a_n7)=1
.ic v(n32_a_n7)=1 v(n32__t0_a_n7)=1 v(n32__t1_a_n7)=1 v(n7_a_n7)=1.1
.ic v(n7__t0_a_n7)=1.1 v(n7__t1_a_n7)=1.1 v(n8_a_n7)=1 v(n8__t0_a_n7)=1
.ic v(n8__t1_a_n7)=1 v(n9_a_n7)=1 v(n9__t0_a_n7)=1 v(n9__t1_a_n7)=1
.ic v(bl_0_a_n7)=0 v(bl_0__t0_a_n7)=0 v(bl_0__t1_a_n7)=0 v(bl_0__t2_a_n7)=0
.ic v(bl_0__t3_a_n7)=0 v(bl_1_a_n7)=0 v(bl_1__t0_a_n7)=0 v(bl_1__t1_a_n7)=0
.ic v(bl_1__t2_a_n7)=0 v(bl_1__t3_a_n7)=0 v(bl_2_a_n7)=0 v(bl_2__t0_a_n7)=0
.ic v(bl_2__t1_a_n7)=0 v(bl_2__t2_a_n7)=0 v(bl_2__t3_a_n7)=0 v(bl_3_a_n7)=0
.ic v(bl_3__t0_a_n7)=0 v(bl_3__t1_a_n7)=0 v(bl_3__t2_a_n7)=0 v(bl_3__t3_a_n7)=0
.ic v(rbl_0_a_n7)=0.9 v(rbl_0__t0_a_n7)=0.9 v(rbl_0__t1_a_n7)=0.9 v(rbl_0__t2_a_n7)=0.9
.ic v(rbl_0__t3_a_n7)=0.9 v(rbl_1_a_n7)=0.9 v(rbl_1__t0_a_n7)=0.9 v(rbl_1__t1_a_n7)=0.9
.ic v(rbl_1__t2_a_n7)=0.9 v(rbl_1__t3_a_n7)=0.9 v(rbl_2_a_n7)=0.9 v(rbl_2__t0_a_n7)=0.9
.ic v(rbl_2__t1_a_n7)=0.9 v(rbl_2__t2_a_n7)=0.9 v(rbl_2__t3_a_n7)=0.9 v(rbl_3_a_n7)=0.9
.ic v(rbl_3__t0_a_n7)=0.9 v(rbl_3__t1_a_n7)=0.9 v(rbl_3__t2_a_n7)=0.9 v(rbl_3__t3_a_n7)=0.9
.ic v(rwl_0_a_n7)=1.8 v(rwl_0__t0_a_n7)=1.8 v(rwl_0__t1_a_n7)=1.8 v(rwl_0__t2_a_n7)=1.8
.ic v(rwl_0__t3_a_n7)=1.8 v(rwl_1_a_n7)=1.8 v(rwl_1__t0_a_n7)=1.8 v(rwl_1__t1_a_n7)=1.8
.ic v(rwl_1__t2_a_n7)=1.8 v(rwl_1__t3_a_n7)=1.8 v(rwl_2_a_n7)=1.8 v(rwl_2__t0_a_n7)=1.8
.ic v(rwl_2__t1_a_n7)=1.8 v(rwl_2__t2_a_n7)=1.8 v(rwl_2__t3_a_n7)=1.8 v(rwl_3_a_n7)=1.8
.ic v(rwl_3__t0_a_n7)=1.8 v(rwl_3__t1_a_n7)=1.8 v(rwl_3__t2_a_n7)=1.8 v(rwl_3__t3_a_n7)=1.8
.ic v(wl_0_a_n7)=0 v(wl_0__t0_a_n7)=0 v(wl_0__t1_a_n7)=0 v(wl_0__t2_a_n7)=0
.ic v(wl_0__t3_a_n7)=0 v(wl_1_a_n7)=0 v(wl_1__t0_a_n7)=0 v(wl_1__t1_a_n7)=0
.ic v(wl_1__t2_a_n7)=0 v(wl_1__t3_a_n7)=0 v(wl_2_a_n7)=0 v(wl_2__t0_a_n7)=0
.ic v(wl_2__t1_a_n7)=0 v(wl_2__t2_a_n7)=0 v(wl_2__t3_a_n7)=0 v(wl_3_a_n7)=0
.ic v(wl_3__t0_a_n7)=0 v(wl_3__t1_a_n7)=0 v(wl_3__t2_a_n7)=0 v(wl_3__t3_a_n7)=0
.ic v(gnd__t0_a_n8)=0 v(gnd__t1_a_n8)=0 v(gnd__t10_a_n8)=0 v(gnd__t11_a_n8)=0
.ic v(gnd__t12_a_n8)=0 v(gnd__t13_a_n8)=0 v(gnd__t14_a_n8)=0 v(gnd__t15_a_n8)=0
.ic v(gnd__t16_a_n8)=0 v(gnd__t17_a_n8)=0 v(gnd__t18_a_n8)=0 v(gnd__t19_a_n8)=0
.ic v(gnd__t2_a_n8)=0 v(gnd__t20_a_n8)=0 v(gnd__t21_a_n8)=0 v(gnd__t22_a_n8)=0
.ic v(gnd__t23_a_n8)=0 v(gnd__t24_a_n8)=0 v(gnd__t25_a_n8)=0 v(gnd__t26_a_n8)=0
.ic v(gnd__t27_a_n8)=0 v(gnd__t28_a_n8)=0 v(gnd__t29_a_n8)=0 v(gnd__t3_a_n8)=0
.ic v(gnd__t30_a_n8)=0 v(gnd__t31_a_n8)=0 v(gnd__t4_a_n8)=0 v(gnd__t5_a_n8)=0
.ic v(gnd__t6_a_n8)=0 v(gnd__t7_a_n8)=0 v(gnd__t8_a_n8)=0 v(gnd__t9_a_n8)=0
.ic v(n10_a_n8)=1 v(n10__t0_a_n8)=1 v(n10__t1_a_n8)=1 v(n17_a_n8)=1
.ic v(n17__t0_a_n8)=1 v(n17__t1_a_n8)=1 v(n18_a_n8)=1 v(n18__t0_a_n8)=1
.ic v(n18__t1_a_n8)=1 v(n19_a_n8)=1 v(n19__t0_a_n8)=1 v(n19__t1_a_n8)=1
.ic v(n20_a_n8)=1 v(n20__t0_a_n8)=1 v(n20__t1_a_n8)=1 v(n22_a_n8)=1
.ic v(n22__t0_a_n8)=1 v(n22__t1_a_n8)=1 v(n23_a_n8)=1 v(n23__t0_a_n8)=1
.ic v(n23__t1_a_n8)=1 v(n24_a_n8)=1 v(n24__t0_a_n8)=1 v(n24__t1_a_n8)=1
.ic v(n25_a_n8)=1 v(n25__t0_a_n8)=1 v(n25__t1_a_n8)=1 v(n29_a_n8)=1
.ic v(n29__t0_a_n8)=1 v(n29__t1_a_n8)=1 v(n30_a_n8)=1 v(n30__t0_a_n8)=1
.ic v(n30__t1_a_n8)=1 v(n31_a_n8)=1 v(n31__t0_a_n8)=1 v(n31__t1_a_n8)=1
.ic v(n32_a_n8)=1 v(n32__t0_a_n8)=1 v(n32__t1_a_n8)=1 v(n7_a_n8)=1
.ic v(n7__t0_a_n8)=1 v(n7__t1_a_n8)=1 v(n8_a_n8)=1.1 v(n8__t0_a_n8)=1.1
.ic v(n8__t1_a_n8)=1.1 v(n9_a_n8)=1 v(n9__t0_a_n8)=1 v(n9__t1_a_n8)=1
.ic v(bl_0_a_n8)=0 v(bl_0__t0_a_n8)=0 v(bl_0__t1_a_n8)=0 v(bl_0__t2_a_n8)=0
.ic v(bl_0__t3_a_n8)=0 v(bl_1_a_n8)=0 v(bl_1__t0_a_n8)=0 v(bl_1__t1_a_n8)=0
.ic v(bl_1__t2_a_n8)=0 v(bl_1__t3_a_n8)=0 v(bl_2_a_n8)=0 v(bl_2__t0_a_n8)=0
.ic v(bl_2__t1_a_n8)=0 v(bl_2__t2_a_n8)=0 v(bl_2__t3_a_n8)=0 v(bl_3_a_n8)=0
.ic v(bl_3__t0_a_n8)=0 v(bl_3__t1_a_n8)=0 v(bl_3__t2_a_n8)=0 v(bl_3__t3_a_n8)=0
.ic v(rbl_0_a_n8)=0.9 v(rbl_0__t0_a_n8)=0.9 v(rbl_0__t1_a_n8)=0.9 v(rbl_0__t2_a_n8)=0.9
.ic v(rbl_0__t3_a_n8)=0.9 v(rbl_1_a_n8)=0.9 v(rbl_1__t0_a_n8)=0.9 v(rbl_1__t1_a_n8)=0.9
.ic v(rbl_1__t2_a_n8)=0.9 v(rbl_1__t3_a_n8)=0.9 v(rbl_2_a_n8)=0.9 v(rbl_2__t0_a_n8)=0.9
.ic v(rbl_2__t1_a_n8)=0.9 v(rbl_2__t2_a_n8)=0.9 v(rbl_2__t3_a_n8)=0.9 v(rbl_3_a_n8)=0.9
.ic v(rbl_3__t0_a_n8)=0.9 v(rbl_3__t1_a_n8)=0.9 v(rbl_3__t2_a_n8)=0.9 v(rbl_3__t3_a_n8)=0.9
.ic v(rwl_0_a_n8)=1.8 v(rwl_0__t0_a_n8)=1.8 v(rwl_0__t1_a_n8)=1.8 v(rwl_0__t2_a_n8)=1.8
.ic v(rwl_0__t3_a_n8)=1.8 v(rwl_1_a_n8)=1.8 v(rwl_1__t0_a_n8)=1.8 v(rwl_1__t1_a_n8)=1.8
.ic v(rwl_1__t2_a_n8)=1.8 v(rwl_1__t3_a_n8)=1.8 v(rwl_2_a_n8)=1.8 v(rwl_2__t0_a_n8)=1.8
.ic v(rwl_2__t1_a_n8)=1.8 v(rwl_2__t2_a_n8)=1.8 v(rwl_2__t3_a_n8)=1.8 v(rwl_3_a_n8)=1.8
.ic v(rwl_3__t0_a_n8)=1.8 v(rwl_3__t1_a_n8)=1.8 v(rwl_3__t2_a_n8)=1.8 v(rwl_3__t3_a_n8)=1.8
.ic v(wl_0_a_n8)=0 v(wl_0__t0_a_n8)=0 v(wl_0__t1_a_n8)=0 v(wl_0__t2_a_n8)=0
.ic v(wl_0__t3_a_n8)=0 v(wl_1_a_n8)=0 v(wl_1__t0_a_n8)=0 v(wl_1__t1_a_n8)=0
.ic v(wl_1__t2_a_n8)=0 v(wl_1__t3_a_n8)=0 v(wl_2_a_n8)=0 v(wl_2__t0_a_n8)=0
.ic v(wl_2__t1_a_n8)=0 v(wl_2__t2_a_n8)=0 v(wl_2__t3_a_n8)=0 v(wl_3_a_n8)=0
.ic v(wl_3__t0_a_n8)=0 v(wl_3__t1_a_n8)=0 v(wl_3__t2_a_n8)=0 v(wl_3__t3_a_n8)=0
.ic v(gnd__t0_a_n9)=0 v(gnd__t1_a_n9)=0 v(gnd__t10_a_n9)=0 v(gnd__t11_a_n9)=0
.ic v(gnd__t12_a_n9)=0 v(gnd__t13_a_n9)=0 v(gnd__t14_a_n9)=0 v(gnd__t15_a_n9)=0
.ic v(gnd__t16_a_n9)=0 v(gnd__t17_a_n9)=0 v(gnd__t18_a_n9)=0 v(gnd__t19_a_n9)=0
.ic v(gnd__t2_a_n9)=0 v(gnd__t20_a_n9)=0 v(gnd__t21_a_n9)=0 v(gnd__t22_a_n9)=0
.ic v(gnd__t23_a_n9)=0 v(gnd__t24_a_n9)=0 v(gnd__t25_a_n9)=0 v(gnd__t26_a_n9)=0
.ic v(gnd__t27_a_n9)=0 v(gnd__t28_a_n9)=0 v(gnd__t29_a_n9)=0 v(gnd__t3_a_n9)=0
.ic v(gnd__t30_a_n9)=0 v(gnd__t31_a_n9)=0 v(gnd__t4_a_n9)=0 v(gnd__t5_a_n9)=0
.ic v(gnd__t6_a_n9)=0 v(gnd__t7_a_n9)=0 v(gnd__t8_a_n9)=0 v(gnd__t9_a_n9)=0
.ic v(n10_a_n9)=1 v(n10__t0_a_n9)=1 v(n10__t1_a_n9)=1 v(n17_a_n9)=1
.ic v(n17__t0_a_n9)=1 v(n17__t1_a_n9)=1 v(n18_a_n9)=1 v(n18__t0_a_n9)=1
.ic v(n18__t1_a_n9)=1 v(n19_a_n9)=1 v(n19__t0_a_n9)=1 v(n19__t1_a_n9)=1
.ic v(n20_a_n9)=1 v(n20__t0_a_n9)=1 v(n20__t1_a_n9)=1 v(n22_a_n9)=1
.ic v(n22__t0_a_n9)=1 v(n22__t1_a_n9)=1 v(n23_a_n9)=1 v(n23__t0_a_n9)=1
.ic v(n23__t1_a_n9)=1 v(n24_a_n9)=1 v(n24__t0_a_n9)=1 v(n24__t1_a_n9)=1
.ic v(n25_a_n9)=1 v(n25__t0_a_n9)=1 v(n25__t1_a_n9)=1 v(n29_a_n9)=1
.ic v(n29__t0_a_n9)=1 v(n29__t1_a_n9)=1 v(n30_a_n9)=1 v(n30__t0_a_n9)=1
.ic v(n30__t1_a_n9)=1 v(n31_a_n9)=1 v(n31__t0_a_n9)=1 v(n31__t1_a_n9)=1
.ic v(n32_a_n9)=1 v(n32__t0_a_n9)=1 v(n32__t1_a_n9)=1 v(n7_a_n9)=1
.ic v(n7__t0_a_n9)=1 v(n7__t1_a_n9)=1 v(n8_a_n9)=1 v(n8__t0_a_n9)=1
.ic v(n8__t1_a_n9)=1 v(n9_a_n9)=1.1 v(n9__t0_a_n9)=1.1 v(n9__t1_a_n9)=1.1
.ic v(bl_0_a_n9)=0 v(bl_0__t0_a_n9)=0 v(bl_0__t1_a_n9)=0 v(bl_0__t2_a_n9)=0
.ic v(bl_0__t3_a_n9)=0 v(bl_1_a_n9)=0 v(bl_1__t0_a_n9)=0 v(bl_1__t1_a_n9)=0
.ic v(bl_1__t2_a_n9)=0 v(bl_1__t3_a_n9)=0 v(bl_2_a_n9)=0 v(bl_2__t0_a_n9)=0
.ic v(bl_2__t1_a_n9)=0 v(bl_2__t2_a_n9)=0 v(bl_2__t3_a_n9)=0 v(bl_3_a_n9)=0
.ic v(bl_3__t0_a_n9)=0 v(bl_3__t1_a_n9)=0 v(bl_3__t2_a_n9)=0 v(bl_3__t3_a_n9)=0
.ic v(rbl_0_a_n9)=0.9 v(rbl_0__t0_a_n9)=0.9 v(rbl_0__t1_a_n9)=0.9 v(rbl_0__t2_a_n9)=0.9
.ic v(rbl_0__t3_a_n9)=0.9 v(rbl_1_a_n9)=0.9 v(rbl_1__t0_a_n9)=0.9 v(rbl_1__t1_a_n9)=0.9
.ic v(rbl_1__t2_a_n9)=0.9 v(rbl_1__t3_a_n9)=0.9 v(rbl_2_a_n9)=0.9 v(rbl_2__t0_a_n9)=0.9
.ic v(rbl_2__t1_a_n9)=0.9 v(rbl_2__t2_a_n9)=0.9 v(rbl_2__t3_a_n9)=0.9 v(rbl_3_a_n9)=0.9
.ic v(rbl_3__t0_a_n9)=0.9 v(rbl_3__t1_a_n9)=0.9 v(rbl_3__t2_a_n9)=0.9 v(rbl_3__t3_a_n9)=0.9
.ic v(rwl_0_a_n9)=1.8 v(rwl_0__t0_a_n9)=1.8 v(rwl_0__t1_a_n9)=1.8 v(rwl_0__t2_a_n9)=1.8
.ic v(rwl_0__t3_a_n9)=1.8 v(rwl_1_a_n9)=1.8 v(rwl_1__t0_a_n9)=1.8 v(rwl_1__t1_a_n9)=1.8
.ic v(rwl_1__t2_a_n9)=1.8 v(rwl_1__t3_a_n9)=1.8 v(rwl_2_a_n9)=1.8 v(rwl_2__t0_a_n9)=1.8
.ic v(rwl_2__t1_a_n9)=1.8 v(rwl_2__t2_a_n9)=1.8 v(rwl_2__t3_a_n9)=1.8 v(rwl_3_a_n9)=1.8
.ic v(rwl_3__t0_a_n9)=1.8 v(rwl_3__t1_a_n9)=1.8 v(rwl_3__t2_a_n9)=1.8 v(rwl_3__t3_a_n9)=1.8
.ic v(wl_0_a_n9)=0 v(wl_0__t0_a_n9)=0 v(wl_0__t1_a_n9)=0 v(wl_0__t2_a_n9)=0
.ic v(wl_0__t3_a_n9)=0 v(wl_1_a_n9)=0 v(wl_1__t0_a_n9)=0 v(wl_1__t1_a_n9)=0
.ic v(wl_1__t2_a_n9)=0 v(wl_1__t3_a_n9)=0 v(wl_2_a_n9)=0 v(wl_2__t0_a_n9)=0
.ic v(wl_2__t1_a_n9)=0 v(wl_2__t2_a_n9)=0 v(wl_2__t3_a_n9)=0 v(wl_3_a_n9)=0
.ic v(wl_3__t0_a_n9)=0 v(wl_3__t1_a_n9)=0 v(wl_3__t2_a_n9)=0 v(wl_3__t3_a_n9)=0
.ic v(gnd__t0_a_n10)=0 v(gnd__t1_a_n10)=0 v(gnd__t10_a_n10)=0 v(gnd__t11_a_n10)=0
.ic v(gnd__t12_a_n10)=0 v(gnd__t13_a_n10)=0 v(gnd__t14_a_n10)=0 v(gnd__t15_a_n10)=0
.ic v(gnd__t16_a_n10)=0 v(gnd__t17_a_n10)=0 v(gnd__t18_a_n10)=0 v(gnd__t19_a_n10)=0
.ic v(gnd__t2_a_n10)=0 v(gnd__t20_a_n10)=0 v(gnd__t21_a_n10)=0 v(gnd__t22_a_n10)=0
.ic v(gnd__t23_a_n10)=0 v(gnd__t24_a_n10)=0 v(gnd__t25_a_n10)=0 v(gnd__t26_a_n10)=0
.ic v(gnd__t27_a_n10)=0 v(gnd__t28_a_n10)=0 v(gnd__t29_a_n10)=0 v(gnd__t3_a_n10)=0
.ic v(gnd__t30_a_n10)=0 v(gnd__t31_a_n10)=0 v(gnd__t4_a_n10)=0 v(gnd__t5_a_n10)=0
.ic v(gnd__t6_a_n10)=0 v(gnd__t7_a_n10)=0 v(gnd__t8_a_n10)=0 v(gnd__t9_a_n10)=0
.ic v(n10_a_n10)=1.1 v(n10__t0_a_n10)=1.1 v(n10__t1_a_n10)=1.1 v(n17_a_n10)=1
.ic v(n17__t0_a_n10)=1 v(n17__t1_a_n10)=1 v(n18_a_n10)=1 v(n18__t0_a_n10)=1
.ic v(n18__t1_a_n10)=1 v(n19_a_n10)=1 v(n19__t0_a_n10)=1 v(n19__t1_a_n10)=1
.ic v(n20_a_n10)=1 v(n20__t0_a_n10)=1 v(n20__t1_a_n10)=1 v(n22_a_n10)=1
.ic v(n22__t0_a_n10)=1 v(n22__t1_a_n10)=1 v(n23_a_n10)=1 v(n23__t0_a_n10)=1
.ic v(n23__t1_a_n10)=1 v(n24_a_n10)=1 v(n24__t0_a_n10)=1 v(n24__t1_a_n10)=1
.ic v(n25_a_n10)=1 v(n25__t0_a_n10)=1 v(n25__t1_a_n10)=1 v(n29_a_n10)=1
.ic v(n29__t0_a_n10)=1 v(n29__t1_a_n10)=1 v(n30_a_n10)=1 v(n30__t0_a_n10)=1
.ic v(n30__t1_a_n10)=1 v(n31_a_n10)=1 v(n31__t0_a_n10)=1 v(n31__t1_a_n10)=1
.ic v(n32_a_n10)=1 v(n32__t0_a_n10)=1 v(n32__t1_a_n10)=1 v(n7_a_n10)=1
.ic v(n7__t0_a_n10)=1 v(n7__t1_a_n10)=1 v(n8_a_n10)=1 v(n8__t0_a_n10)=1
.ic v(n8__t1_a_n10)=1 v(n9_a_n10)=1 v(n9__t0_a_n10)=1 v(n9__t1_a_n10)=1
.ic v(bl_0_a_n10)=0 v(bl_0__t0_a_n10)=0 v(bl_0__t1_a_n10)=0 v(bl_0__t2_a_n10)=0
.ic v(bl_0__t3_a_n10)=0 v(bl_1_a_n10)=0 v(bl_1__t0_a_n10)=0 v(bl_1__t1_a_n10)=0
.ic v(bl_1__t2_a_n10)=0 v(bl_1__t3_a_n10)=0 v(bl_2_a_n10)=0 v(bl_2__t0_a_n10)=0
.ic v(bl_2__t1_a_n10)=0 v(bl_2__t2_a_n10)=0 v(bl_2__t3_a_n10)=0 v(bl_3_a_n10)=0
.ic v(bl_3__t0_a_n10)=0 v(bl_3__t1_a_n10)=0 v(bl_3__t2_a_n10)=0 v(bl_3__t3_a_n10)=0
.ic v(rbl_0_a_n10)=0.9 v(rbl_0__t0_a_n10)=0.9 v(rbl_0__t1_a_n10)=0.9 v(rbl_0__t2_a_n10)=0.9
.ic v(rbl_0__t3_a_n10)=0.9 v(rbl_1_a_n10)=0.9 v(rbl_1__t0_a_n10)=0.9 v(rbl_1__t1_a_n10)=0.9
.ic v(rbl_1__t2_a_n10)=0.9 v(rbl_1__t3_a_n10)=0.9 v(rbl_2_a_n10)=0.9 v(rbl_2__t0_a_n10)=0.9
.ic v(rbl_2__t1_a_n10)=0.9 v(rbl_2__t2_a_n10)=0.9 v(rbl_2__t3_a_n10)=0.9 v(rbl_3_a_n10)=0.9
.ic v(rbl_3__t0_a_n10)=0.9 v(rbl_3__t1_a_n10)=0.9 v(rbl_3__t2_a_n10)=0.9 v(rbl_3__t3_a_n10)=0.9
.ic v(rwl_0_a_n10)=1.8 v(rwl_0__t0_a_n10)=1.8 v(rwl_0__t1_a_n10)=1.8 v(rwl_0__t2_a_n10)=1.8
.ic v(rwl_0__t3_a_n10)=1.8 v(rwl_1_a_n10)=1.8 v(rwl_1__t0_a_n10)=1.8 v(rwl_1__t1_a_n10)=1.8
.ic v(rwl_1__t2_a_n10)=1.8 v(rwl_1__t3_a_n10)=1.8 v(rwl_2_a_n10)=1.8 v(rwl_2__t0_a_n10)=1.8
.ic v(rwl_2__t1_a_n10)=1.8 v(rwl_2__t2_a_n10)=1.8 v(rwl_2__t3_a_n10)=1.8 v(rwl_3_a_n10)=1.8
.ic v(rwl_3__t0_a_n10)=1.8 v(rwl_3__t1_a_n10)=1.8 v(rwl_3__t2_a_n10)=1.8 v(rwl_3__t3_a_n10)=1.8
.ic v(wl_0_a_n10)=0 v(wl_0__t0_a_n10)=0 v(wl_0__t1_a_n10)=0 v(wl_0__t2_a_n10)=0
.ic v(wl_0__t3_a_n10)=0 v(wl_1_a_n10)=0 v(wl_1__t0_a_n10)=0 v(wl_1__t1_a_n10)=0
.ic v(wl_1__t2_a_n10)=0 v(wl_1__t3_a_n10)=0 v(wl_2_a_n10)=0 v(wl_2__t0_a_n10)=0
.ic v(wl_2__t1_a_n10)=0 v(wl_2__t2_a_n10)=0 v(wl_2__t3_a_n10)=0 v(wl_3_a_n10)=0
.ic v(wl_3__t0_a_n10)=0 v(wl_3__t1_a_n10)=0 v(wl_3__t2_a_n10)=0 v(wl_3__t3_a_n10)=0
.ic v(gnd__t0_a_n17)=0 v(gnd__t1_a_n17)=0 v(gnd__t10_a_n17)=0 v(gnd__t11_a_n17)=0
.ic v(gnd__t12_a_n17)=0 v(gnd__t13_a_n17)=0 v(gnd__t14_a_n17)=0 v(gnd__t15_a_n17)=0
.ic v(gnd__t16_a_n17)=0 v(gnd__t17_a_n17)=0 v(gnd__t18_a_n17)=0 v(gnd__t19_a_n17)=0
.ic v(gnd__t2_a_n17)=0 v(gnd__t20_a_n17)=0 v(gnd__t21_a_n17)=0 v(gnd__t22_a_n17)=0
.ic v(gnd__t23_a_n17)=0 v(gnd__t24_a_n17)=0 v(gnd__t25_a_n17)=0 v(gnd__t26_a_n17)=0
.ic v(gnd__t27_a_n17)=0 v(gnd__t28_a_n17)=0 v(gnd__t29_a_n17)=0 v(gnd__t3_a_n17)=0
.ic v(gnd__t30_a_n17)=0 v(gnd__t31_a_n17)=0 v(gnd__t4_a_n17)=0 v(gnd__t5_a_n17)=0
.ic v(gnd__t6_a_n17)=0 v(gnd__t7_a_n17)=0 v(gnd__t8_a_n17)=0 v(gnd__t9_a_n17)=0
.ic v(n10_a_n17)=1 v(n10__t0_a_n17)=1 v(n10__t1_a_n17)=1 v(n17_a_n17)=1.1
.ic v(n17__t0_a_n17)=1.1 v(n17__t1_a_n17)=1.1 v(n18_a_n17)=1 v(n18__t0_a_n17)=1
.ic v(n18__t1_a_n17)=1 v(n19_a_n17)=1 v(n19__t0_a_n17)=1 v(n19__t1_a_n17)=1
.ic v(n20_a_n17)=1 v(n20__t0_a_n17)=1 v(n20__t1_a_n17)=1 v(n22_a_n17)=1
.ic v(n22__t0_a_n17)=1 v(n22__t1_a_n17)=1 v(n23_a_n17)=1 v(n23__t0_a_n17)=1
.ic v(n23__t1_a_n17)=1 v(n24_a_n17)=1 v(n24__t0_a_n17)=1 v(n24__t1_a_n17)=1
.ic v(n25_a_n17)=1 v(n25__t0_a_n17)=1 v(n25__t1_a_n17)=1 v(n29_a_n17)=1
.ic v(n29__t0_a_n17)=1 v(n29__t1_a_n17)=1 v(n30_a_n17)=1 v(n30__t0_a_n17)=1
.ic v(n30__t1_a_n17)=1 v(n31_a_n17)=1 v(n31__t0_a_n17)=1 v(n31__t1_a_n17)=1
.ic v(n32_a_n17)=1 v(n32__t0_a_n17)=1 v(n32__t1_a_n17)=1 v(n7_a_n17)=1
.ic v(n7__t0_a_n17)=1 v(n7__t1_a_n17)=1 v(n8_a_n17)=1 v(n8__t0_a_n17)=1
.ic v(n8__t1_a_n17)=1 v(n9_a_n17)=1 v(n9__t0_a_n17)=1 v(n9__t1_a_n17)=1
.ic v(bl_0_a_n17)=0 v(bl_0__t0_a_n17)=0 v(bl_0__t1_a_n17)=0 v(bl_0__t2_a_n17)=0
.ic v(bl_0__t3_a_n17)=0 v(bl_1_a_n17)=0 v(bl_1__t0_a_n17)=0 v(bl_1__t1_a_n17)=0
.ic v(bl_1__t2_a_n17)=0 v(bl_1__t3_a_n17)=0 v(bl_2_a_n17)=0 v(bl_2__t0_a_n17)=0
.ic v(bl_2__t1_a_n17)=0 v(bl_2__t2_a_n17)=0 v(bl_2__t3_a_n17)=0 v(bl_3_a_n17)=0
.ic v(bl_3__t0_a_n17)=0 v(bl_3__t1_a_n17)=0 v(bl_3__t2_a_n17)=0 v(bl_3__t3_a_n17)=0
.ic v(rbl_0_a_n17)=0.9 v(rbl_0__t0_a_n17)=0.9 v(rbl_0__t1_a_n17)=0.9 v(rbl_0__t2_a_n17)=0.9
.ic v(rbl_0__t3_a_n17)=0.9 v(rbl_1_a_n17)=0.9 v(rbl_1__t0_a_n17)=0.9 v(rbl_1__t1_a_n17)=0.9
.ic v(rbl_1__t2_a_n17)=0.9 v(rbl_1__t3_a_n17)=0.9 v(rbl_2_a_n17)=0.9 v(rbl_2__t0_a_n17)=0.9
.ic v(rbl_2__t1_a_n17)=0.9 v(rbl_2__t2_a_n17)=0.9 v(rbl_2__t3_a_n17)=0.9 v(rbl_3_a_n17)=0.9
.ic v(rbl_3__t0_a_n17)=0.9 v(rbl_3__t1_a_n17)=0.9 v(rbl_3__t2_a_n17)=0.9 v(rbl_3__t3_a_n17)=0.9
.ic v(rwl_0_a_n17)=1.8 v(rwl_0__t0_a_n17)=1.8 v(rwl_0__t1_a_n17)=1.8 v(rwl_0__t2_a_n17)=1.8
.ic v(rwl_0__t3_a_n17)=1.8 v(rwl_1_a_n17)=1.8 v(rwl_1__t0_a_n17)=1.8 v(rwl_1__t1_a_n17)=1.8
.ic v(rwl_1__t2_a_n17)=1.8 v(rwl_1__t3_a_n17)=1.8 v(rwl_2_a_n17)=1.8 v(rwl_2__t0_a_n17)=1.8
.ic v(rwl_2__t1_a_n17)=1.8 v(rwl_2__t2_a_n17)=1.8 v(rwl_2__t3_a_n17)=1.8 v(rwl_3_a_n17)=1.8
.ic v(rwl_3__t0_a_n17)=1.8 v(rwl_3__t1_a_n17)=1.8 v(rwl_3__t2_a_n17)=1.8 v(rwl_3__t3_a_n17)=1.8
.ic v(wl_0_a_n17)=0 v(wl_0__t0_a_n17)=0 v(wl_0__t1_a_n17)=0 v(wl_0__t2_a_n17)=0
.ic v(wl_0__t3_a_n17)=0 v(wl_1_a_n17)=0 v(wl_1__t0_a_n17)=0 v(wl_1__t1_a_n17)=0
.ic v(wl_1__t2_a_n17)=0 v(wl_1__t3_a_n17)=0 v(wl_2_a_n17)=0 v(wl_2__t0_a_n17)=0
.ic v(wl_2__t1_a_n17)=0 v(wl_2__t2_a_n17)=0 v(wl_2__t3_a_n17)=0 v(wl_3_a_n17)=0
.ic v(wl_3__t0_a_n17)=0 v(wl_3__t1_a_n17)=0 v(wl_3__t2_a_n17)=0 v(wl_3__t3_a_n17)=0
.ic v(gnd__t0_a_n18)=0 v(gnd__t1_a_n18)=0 v(gnd__t10_a_n18)=0 v(gnd__t11_a_n18)=0
.ic v(gnd__t12_a_n18)=0 v(gnd__t13_a_n18)=0 v(gnd__t14_a_n18)=0 v(gnd__t15_a_n18)=0
.ic v(gnd__t16_a_n18)=0 v(gnd__t17_a_n18)=0 v(gnd__t18_a_n18)=0 v(gnd__t19_a_n18)=0
.ic v(gnd__t2_a_n18)=0 v(gnd__t20_a_n18)=0 v(gnd__t21_a_n18)=0 v(gnd__t22_a_n18)=0
.ic v(gnd__t23_a_n18)=0 v(gnd__t24_a_n18)=0 v(gnd__t25_a_n18)=0 v(gnd__t26_a_n18)=0
.ic v(gnd__t27_a_n18)=0 v(gnd__t28_a_n18)=0 v(gnd__t29_a_n18)=0 v(gnd__t3_a_n18)=0
.ic v(gnd__t30_a_n18)=0 v(gnd__t31_a_n18)=0 v(gnd__t4_a_n18)=0 v(gnd__t5_a_n18)=0
.ic v(gnd__t6_a_n18)=0 v(gnd__t7_a_n18)=0 v(gnd__t8_a_n18)=0 v(gnd__t9_a_n18)=0
.ic v(n10_a_n18)=1 v(n10__t0_a_n18)=1 v(n10__t1_a_n18)=1 v(n17_a_n18)=1
.ic v(n17__t0_a_n18)=1 v(n17__t1_a_n18)=1 v(n18_a_n18)=1.1 v(n18__t0_a_n18)=1.1
.ic v(n18__t1_a_n18)=1.1 v(n19_a_n18)=1 v(n19__t0_a_n18)=1 v(n19__t1_a_n18)=1
.ic v(n20_a_n18)=1 v(n20__t0_a_n18)=1 v(n20__t1_a_n18)=1 v(n22_a_n18)=1
.ic v(n22__t0_a_n18)=1 v(n22__t1_a_n18)=1 v(n23_a_n18)=1 v(n23__t0_a_n18)=1
.ic v(n23__t1_a_n18)=1 v(n24_a_n18)=1 v(n24__t0_a_n18)=1 v(n24__t1_a_n18)=1
.ic v(n25_a_n18)=1 v(n25__t0_a_n18)=1 v(n25__t1_a_n18)=1 v(n29_a_n18)=1
.ic v(n29__t0_a_n18)=1 v(n29__t1_a_n18)=1 v(n30_a_n18)=1 v(n30__t0_a_n18)=1
.ic v(n30__t1_a_n18)=1 v(n31_a_n18)=1 v(n31__t0_a_n18)=1 v(n31__t1_a_n18)=1
.ic v(n32_a_n18)=1 v(n32__t0_a_n18)=1 v(n32__t1_a_n18)=1 v(n7_a_n18)=1
.ic v(n7__t0_a_n18)=1 v(n7__t1_a_n18)=1 v(n8_a_n18)=1 v(n8__t0_a_n18)=1
.ic v(n8__t1_a_n18)=1 v(n9_a_n18)=1 v(n9__t0_a_n18)=1 v(n9__t1_a_n18)=1
.ic v(bl_0_a_n18)=0 v(bl_0__t0_a_n18)=0 v(bl_0__t1_a_n18)=0 v(bl_0__t2_a_n18)=0
.ic v(bl_0__t3_a_n18)=0 v(bl_1_a_n18)=0 v(bl_1__t0_a_n18)=0 v(bl_1__t1_a_n18)=0
.ic v(bl_1__t2_a_n18)=0 v(bl_1__t3_a_n18)=0 v(bl_2_a_n18)=0 v(bl_2__t0_a_n18)=0
.ic v(bl_2__t1_a_n18)=0 v(bl_2__t2_a_n18)=0 v(bl_2__t3_a_n18)=0 v(bl_3_a_n18)=0
.ic v(bl_3__t0_a_n18)=0 v(bl_3__t1_a_n18)=0 v(bl_3__t2_a_n18)=0 v(bl_3__t3_a_n18)=0
.ic v(rbl_0_a_n18)=0.9 v(rbl_0__t0_a_n18)=0.9 v(rbl_0__t1_a_n18)=0.9 v(rbl_0__t2_a_n18)=0.9
.ic v(rbl_0__t3_a_n18)=0.9 v(rbl_1_a_n18)=0.9 v(rbl_1__t0_a_n18)=0.9 v(rbl_1__t1_a_n18)=0.9
.ic v(rbl_1__t2_a_n18)=0.9 v(rbl_1__t3_a_n18)=0.9 v(rbl_2_a_n18)=0.9 v(rbl_2__t0_a_n18)=0.9
.ic v(rbl_2__t1_a_n18)=0.9 v(rbl_2__t2_a_n18)=0.9 v(rbl_2__t3_a_n18)=0.9 v(rbl_3_a_n18)=0.9
.ic v(rbl_3__t0_a_n18)=0.9 v(rbl_3__t1_a_n18)=0.9 v(rbl_3__t2_a_n18)=0.9 v(rbl_3__t3_a_n18)=0.9
.ic v(rwl_0_a_n18)=1.8 v(rwl_0__t0_a_n18)=1.8 v(rwl_0__t1_a_n18)=1.8 v(rwl_0__t2_a_n18)=1.8
.ic v(rwl_0__t3_a_n18)=1.8 v(rwl_1_a_n18)=1.8 v(rwl_1__t0_a_n18)=1.8 v(rwl_1__t1_a_n18)=1.8
.ic v(rwl_1__t2_a_n18)=1.8 v(rwl_1__t3_a_n18)=1.8 v(rwl_2_a_n18)=1.8 v(rwl_2__t0_a_n18)=1.8
.ic v(rwl_2__t1_a_n18)=1.8 v(rwl_2__t2_a_n18)=1.8 v(rwl_2__t3_a_n18)=1.8 v(rwl_3_a_n18)=1.8
.ic v(rwl_3__t0_a_n18)=1.8 v(rwl_3__t1_a_n18)=1.8 v(rwl_3__t2_a_n18)=1.8 v(rwl_3__t3_a_n18)=1.8
.ic v(wl_0_a_n18)=0 v(wl_0__t0_a_n18)=0 v(wl_0__t1_a_n18)=0 v(wl_0__t2_a_n18)=0
.ic v(wl_0__t3_a_n18)=0 v(wl_1_a_n18)=0 v(wl_1__t0_a_n18)=0 v(wl_1__t1_a_n18)=0
.ic v(wl_1__t2_a_n18)=0 v(wl_1__t3_a_n18)=0 v(wl_2_a_n18)=0 v(wl_2__t0_a_n18)=0
.ic v(wl_2__t1_a_n18)=0 v(wl_2__t2_a_n18)=0 v(wl_2__t3_a_n18)=0 v(wl_3_a_n18)=0
.ic v(wl_3__t0_a_n18)=0 v(wl_3__t1_a_n18)=0 v(wl_3__t2_a_n18)=0 v(wl_3__t3_a_n18)=0
.ic v(gnd__t0_a_n19)=0 v(gnd__t1_a_n19)=0 v(gnd__t10_a_n19)=0 v(gnd__t11_a_n19)=0
.ic v(gnd__t12_a_n19)=0 v(gnd__t13_a_n19)=0 v(gnd__t14_a_n19)=0 v(gnd__t15_a_n19)=0
.ic v(gnd__t16_a_n19)=0 v(gnd__t17_a_n19)=0 v(gnd__t18_a_n19)=0 v(gnd__t19_a_n19)=0
.ic v(gnd__t2_a_n19)=0 v(gnd__t20_a_n19)=0 v(gnd__t21_a_n19)=0 v(gnd__t22_a_n19)=0
.ic v(gnd__t23_a_n19)=0 v(gnd__t24_a_n19)=0 v(gnd__t25_a_n19)=0 v(gnd__t26_a_n19)=0
.ic v(gnd__t27_a_n19)=0 v(gnd__t28_a_n19)=0 v(gnd__t29_a_n19)=0 v(gnd__t3_a_n19)=0
.ic v(gnd__t30_a_n19)=0 v(gnd__t31_a_n19)=0 v(gnd__t4_a_n19)=0 v(gnd__t5_a_n19)=0
.ic v(gnd__t6_a_n19)=0 v(gnd__t7_a_n19)=0 v(gnd__t8_a_n19)=0 v(gnd__t9_a_n19)=0
.ic v(n10_a_n19)=1 v(n10__t0_a_n19)=1 v(n10__t1_a_n19)=1 v(n17_a_n19)=1
.ic v(n17__t0_a_n19)=1 v(n17__t1_a_n19)=1 v(n18_a_n19)=1 v(n18__t0_a_n19)=1
.ic v(n18__t1_a_n19)=1 v(n19_a_n19)=1.1 v(n19__t0_a_n19)=1.1 v(n19__t1_a_n19)=1.1
.ic v(n20_a_n19)=1 v(n20__t0_a_n19)=1 v(n20__t1_a_n19)=1 v(n22_a_n19)=1
.ic v(n22__t0_a_n19)=1 v(n22__t1_a_n19)=1 v(n23_a_n19)=1 v(n23__t0_a_n19)=1
.ic v(n23__t1_a_n19)=1 v(n24_a_n19)=1 v(n24__t0_a_n19)=1 v(n24__t1_a_n19)=1
.ic v(n25_a_n19)=1 v(n25__t0_a_n19)=1 v(n25__t1_a_n19)=1 v(n29_a_n19)=1
.ic v(n29__t0_a_n19)=1 v(n29__t1_a_n19)=1 v(n30_a_n19)=1 v(n30__t0_a_n19)=1
.ic v(n30__t1_a_n19)=1 v(n31_a_n19)=1 v(n31__t0_a_n19)=1 v(n31__t1_a_n19)=1
.ic v(n32_a_n19)=1 v(n32__t0_a_n19)=1 v(n32__t1_a_n19)=1 v(n7_a_n19)=1
.ic v(n7__t0_a_n19)=1 v(n7__t1_a_n19)=1 v(n8_a_n19)=1 v(n8__t0_a_n19)=1
.ic v(n8__t1_a_n19)=1 v(n9_a_n19)=1 v(n9__t0_a_n19)=1 v(n9__t1_a_n19)=1
.ic v(bl_0_a_n19)=0 v(bl_0__t0_a_n19)=0 v(bl_0__t1_a_n19)=0 v(bl_0__t2_a_n19)=0
.ic v(bl_0__t3_a_n19)=0 v(bl_1_a_n19)=0 v(bl_1__t0_a_n19)=0 v(bl_1__t1_a_n19)=0
.ic v(bl_1__t2_a_n19)=0 v(bl_1__t3_a_n19)=0 v(bl_2_a_n19)=0 v(bl_2__t0_a_n19)=0
.ic v(bl_2__t1_a_n19)=0 v(bl_2__t2_a_n19)=0 v(bl_2__t3_a_n19)=0 v(bl_3_a_n19)=0
.ic v(bl_3__t0_a_n19)=0 v(bl_3__t1_a_n19)=0 v(bl_3__t2_a_n19)=0 v(bl_3__t3_a_n19)=0
.ic v(rbl_0_a_n19)=0.9 v(rbl_0__t0_a_n19)=0.9 v(rbl_0__t1_a_n19)=0.9 v(rbl_0__t2_a_n19)=0.9
.ic v(rbl_0__t3_a_n19)=0.9 v(rbl_1_a_n19)=0.9 v(rbl_1__t0_a_n19)=0.9 v(rbl_1__t1_a_n19)=0.9
.ic v(rbl_1__t2_a_n19)=0.9 v(rbl_1__t3_a_n19)=0.9 v(rbl_2_a_n19)=0.9 v(rbl_2__t0_a_n19)=0.9
.ic v(rbl_2__t1_a_n19)=0.9 v(rbl_2__t2_a_n19)=0.9 v(rbl_2__t3_a_n19)=0.9 v(rbl_3_a_n19)=0.9
.ic v(rbl_3__t0_a_n19)=0.9 v(rbl_3__t1_a_n19)=0.9 v(rbl_3__t2_a_n19)=0.9 v(rbl_3__t3_a_n19)=0.9
.ic v(rwl_0_a_n19)=1.8 v(rwl_0__t0_a_n19)=1.8 v(rwl_0__t1_a_n19)=1.8 v(rwl_0__t2_a_n19)=1.8
.ic v(rwl_0__t3_a_n19)=1.8 v(rwl_1_a_n19)=1.8 v(rwl_1__t0_a_n19)=1.8 v(rwl_1__t1_a_n19)=1.8
.ic v(rwl_1__t2_a_n19)=1.8 v(rwl_1__t3_a_n19)=1.8 v(rwl_2_a_n19)=1.8 v(rwl_2__t0_a_n19)=1.8
.ic v(rwl_2__t1_a_n19)=1.8 v(rwl_2__t2_a_n19)=1.8 v(rwl_2__t3_a_n19)=1.8 v(rwl_3_a_n19)=1.8
.ic v(rwl_3__t0_a_n19)=1.8 v(rwl_3__t1_a_n19)=1.8 v(rwl_3__t2_a_n19)=1.8 v(rwl_3__t3_a_n19)=1.8
.ic v(wl_0_a_n19)=0 v(wl_0__t0_a_n19)=0 v(wl_0__t1_a_n19)=0 v(wl_0__t2_a_n19)=0
.ic v(wl_0__t3_a_n19)=0 v(wl_1_a_n19)=0 v(wl_1__t0_a_n19)=0 v(wl_1__t1_a_n19)=0
.ic v(wl_1__t2_a_n19)=0 v(wl_1__t3_a_n19)=0 v(wl_2_a_n19)=0 v(wl_2__t0_a_n19)=0
.ic v(wl_2__t1_a_n19)=0 v(wl_2__t2_a_n19)=0 v(wl_2__t3_a_n19)=0 v(wl_3_a_n19)=0
.ic v(wl_3__t0_a_n19)=0 v(wl_3__t1_a_n19)=0 v(wl_3__t2_a_n19)=0 v(wl_3__t3_a_n19)=0
.ic v(gnd__t0_a_n20)=0 v(gnd__t1_a_n20)=0 v(gnd__t10_a_n20)=0 v(gnd__t11_a_n20)=0
.ic v(gnd__t12_a_n20)=0 v(gnd__t13_a_n20)=0 v(gnd__t14_a_n20)=0 v(gnd__t15_a_n20)=0
.ic v(gnd__t16_a_n20)=0 v(gnd__t17_a_n20)=0 v(gnd__t18_a_n20)=0 v(gnd__t19_a_n20)=0
.ic v(gnd__t2_a_n20)=0 v(gnd__t20_a_n20)=0 v(gnd__t21_a_n20)=0 v(gnd__t22_a_n20)=0
.ic v(gnd__t23_a_n20)=0 v(gnd__t24_a_n20)=0 v(gnd__t25_a_n20)=0 v(gnd__t26_a_n20)=0
.ic v(gnd__t27_a_n20)=0 v(gnd__t28_a_n20)=0 v(gnd__t29_a_n20)=0 v(gnd__t3_a_n20)=0
.ic v(gnd__t30_a_n20)=0 v(gnd__t31_a_n20)=0 v(gnd__t4_a_n20)=0 v(gnd__t5_a_n20)=0
.ic v(gnd__t6_a_n20)=0 v(gnd__t7_a_n20)=0 v(gnd__t8_a_n20)=0 v(gnd__t9_a_n20)=0
.ic v(n10_a_n20)=1 v(n10__t0_a_n20)=1 v(n10__t1_a_n20)=1 v(n17_a_n20)=1
.ic v(n17__t0_a_n20)=1 v(n17__t1_a_n20)=1 v(n18_a_n20)=1 v(n18__t0_a_n20)=1
.ic v(n18__t1_a_n20)=1 v(n19_a_n20)=1 v(n19__t0_a_n20)=1 v(n19__t1_a_n20)=1
.ic v(n20_a_n20)=1.1 v(n20__t0_a_n20)=1.1 v(n20__t1_a_n20)=1.1 v(n22_a_n20)=1
.ic v(n22__t0_a_n20)=1 v(n22__t1_a_n20)=1 v(n23_a_n20)=1 v(n23__t0_a_n20)=1
.ic v(n23__t1_a_n20)=1 v(n24_a_n20)=1 v(n24__t0_a_n20)=1 v(n24__t1_a_n20)=1
.ic v(n25_a_n20)=1 v(n25__t0_a_n20)=1 v(n25__t1_a_n20)=1 v(n29_a_n20)=1
.ic v(n29__t0_a_n20)=1 v(n29__t1_a_n20)=1 v(n30_a_n20)=1 v(n30__t0_a_n20)=1
.ic v(n30__t1_a_n20)=1 v(n31_a_n20)=1 v(n31__t0_a_n20)=1 v(n31__t1_a_n20)=1
.ic v(n32_a_n20)=1 v(n32__t0_a_n20)=1 v(n32__t1_a_n20)=1 v(n7_a_n20)=1
.ic v(n7__t0_a_n20)=1 v(n7__t1_a_n20)=1 v(n8_a_n20)=1 v(n8__t0_a_n20)=1
.ic v(n8__t1_a_n20)=1 v(n9_a_n20)=1 v(n9__t0_a_n20)=1 v(n9__t1_a_n20)=1
.ic v(bl_0_a_n20)=0 v(bl_0__t0_a_n20)=0 v(bl_0__t1_a_n20)=0 v(bl_0__t2_a_n20)=0
.ic v(bl_0__t3_a_n20)=0 v(bl_1_a_n20)=0 v(bl_1__t0_a_n20)=0 v(bl_1__t1_a_n20)=0
.ic v(bl_1__t2_a_n20)=0 v(bl_1__t3_a_n20)=0 v(bl_2_a_n20)=0 v(bl_2__t0_a_n20)=0
.ic v(bl_2__t1_a_n20)=0 v(bl_2__t2_a_n20)=0 v(bl_2__t3_a_n20)=0 v(bl_3_a_n20)=0
.ic v(bl_3__t0_a_n20)=0 v(bl_3__t1_a_n20)=0 v(bl_3__t2_a_n20)=0 v(bl_3__t3_a_n20)=0
.ic v(rbl_0_a_n20)=0.9 v(rbl_0__t0_a_n20)=0.9 v(rbl_0__t1_a_n20)=0.9 v(rbl_0__t2_a_n20)=0.9
.ic v(rbl_0__t3_a_n20)=0.9 v(rbl_1_a_n20)=0.9 v(rbl_1__t0_a_n20)=0.9 v(rbl_1__t1_a_n20)=0.9
.ic v(rbl_1__t2_a_n20)=0.9 v(rbl_1__t3_a_n20)=0.9 v(rbl_2_a_n20)=0.9 v(rbl_2__t0_a_n20)=0.9
.ic v(rbl_2__t1_a_n20)=0.9 v(rbl_2__t2_a_n20)=0.9 v(rbl_2__t3_a_n20)=0.9 v(rbl_3_a_n20)=0.9
.ic v(rbl_3__t0_a_n20)=0.9 v(rbl_3__t1_a_n20)=0.9 v(rbl_3__t2_a_n20)=0.9 v(rbl_3__t3_a_n20)=0.9
.ic v(rwl_0_a_n20)=1.8 v(rwl_0__t0_a_n20)=1.8 v(rwl_0__t1_a_n20)=1.8 v(rwl_0__t2_a_n20)=1.8
.ic v(rwl_0__t3_a_n20)=1.8 v(rwl_1_a_n20)=1.8 v(rwl_1__t0_a_n20)=1.8 v(rwl_1__t1_a_n20)=1.8
.ic v(rwl_1__t2_a_n20)=1.8 v(rwl_1__t3_a_n20)=1.8 v(rwl_2_a_n20)=1.8 v(rwl_2__t0_a_n20)=1.8
.ic v(rwl_2__t1_a_n20)=1.8 v(rwl_2__t2_a_n20)=1.8 v(rwl_2__t3_a_n20)=1.8 v(rwl_3_a_n20)=1.8
.ic v(rwl_3__t0_a_n20)=1.8 v(rwl_3__t1_a_n20)=1.8 v(rwl_3__t2_a_n20)=1.8 v(rwl_3__t3_a_n20)=1.8
.ic v(wl_0_a_n20)=0 v(wl_0__t0_a_n20)=0 v(wl_0__t1_a_n20)=0 v(wl_0__t2_a_n20)=0
.ic v(wl_0__t3_a_n20)=0 v(wl_1_a_n20)=0 v(wl_1__t0_a_n20)=0 v(wl_1__t1_a_n20)=0
.ic v(wl_1__t2_a_n20)=0 v(wl_1__t3_a_n20)=0 v(wl_2_a_n20)=0 v(wl_2__t0_a_n20)=0
.ic v(wl_2__t1_a_n20)=0 v(wl_2__t2_a_n20)=0 v(wl_2__t3_a_n20)=0 v(wl_3_a_n20)=0
.ic v(wl_3__t0_a_n20)=0 v(wl_3__t1_a_n20)=0 v(wl_3__t2_a_n20)=0 v(wl_3__t3_a_n20)=0
.ic v(gnd__t0_a_n22)=0 v(gnd__t1_a_n22)=0 v(gnd__t10_a_n22)=0 v(gnd__t11_a_n22)=0
.ic v(gnd__t12_a_n22)=0 v(gnd__t13_a_n22)=0 v(gnd__t14_a_n22)=0 v(gnd__t15_a_n22)=0
.ic v(gnd__t16_a_n22)=0 v(gnd__t17_a_n22)=0 v(gnd__t18_a_n22)=0 v(gnd__t19_a_n22)=0
.ic v(gnd__t2_a_n22)=0 v(gnd__t20_a_n22)=0 v(gnd__t21_a_n22)=0 v(gnd__t22_a_n22)=0
.ic v(gnd__t23_a_n22)=0 v(gnd__t24_a_n22)=0 v(gnd__t25_a_n22)=0 v(gnd__t26_a_n22)=0
.ic v(gnd__t27_a_n22)=0 v(gnd__t28_a_n22)=0 v(gnd__t29_a_n22)=0 v(gnd__t3_a_n22)=0
.ic v(gnd__t30_a_n22)=0 v(gnd__t31_a_n22)=0 v(gnd__t4_a_n22)=0 v(gnd__t5_a_n22)=0
.ic v(gnd__t6_a_n22)=0 v(gnd__t7_a_n22)=0 v(gnd__t8_a_n22)=0 v(gnd__t9_a_n22)=0
.ic v(n10_a_n22)=1 v(n10__t0_a_n22)=1 v(n10__t1_a_n22)=1 v(n17_a_n22)=1
.ic v(n17__t0_a_n22)=1 v(n17__t1_a_n22)=1 v(n18_a_n22)=1 v(n18__t0_a_n22)=1
.ic v(n18__t1_a_n22)=1 v(n19_a_n22)=1 v(n19__t0_a_n22)=1 v(n19__t1_a_n22)=1
.ic v(n20_a_n22)=1 v(n20__t0_a_n22)=1 v(n20__t1_a_n22)=1 v(n22_a_n22)=1.1
.ic v(n22__t0_a_n22)=1.1 v(n22__t1_a_n22)=1.1 v(n23_a_n22)=1 v(n23__t0_a_n22)=1
.ic v(n23__t1_a_n22)=1 v(n24_a_n22)=1 v(n24__t0_a_n22)=1 v(n24__t1_a_n22)=1
.ic v(n25_a_n22)=1 v(n25__t0_a_n22)=1 v(n25__t1_a_n22)=1 v(n29_a_n22)=1
.ic v(n29__t0_a_n22)=1 v(n29__t1_a_n22)=1 v(n30_a_n22)=1 v(n30__t0_a_n22)=1
.ic v(n30__t1_a_n22)=1 v(n31_a_n22)=1 v(n31__t0_a_n22)=1 v(n31__t1_a_n22)=1
.ic v(n32_a_n22)=1 v(n32__t0_a_n22)=1 v(n32__t1_a_n22)=1 v(n7_a_n22)=1
.ic v(n7__t0_a_n22)=1 v(n7__t1_a_n22)=1 v(n8_a_n22)=1 v(n8__t0_a_n22)=1
.ic v(n8__t1_a_n22)=1 v(n9_a_n22)=1 v(n9__t0_a_n22)=1 v(n9__t1_a_n22)=1
.ic v(bl_0_a_n22)=0 v(bl_0__t0_a_n22)=0 v(bl_0__t1_a_n22)=0 v(bl_0__t2_a_n22)=0
.ic v(bl_0__t3_a_n22)=0 v(bl_1_a_n22)=0 v(bl_1__t0_a_n22)=0 v(bl_1__t1_a_n22)=0
.ic v(bl_1__t2_a_n22)=0 v(bl_1__t3_a_n22)=0 v(bl_2_a_n22)=0 v(bl_2__t0_a_n22)=0
.ic v(bl_2__t1_a_n22)=0 v(bl_2__t2_a_n22)=0 v(bl_2__t3_a_n22)=0 v(bl_3_a_n22)=0
.ic v(bl_3__t0_a_n22)=0 v(bl_3__t1_a_n22)=0 v(bl_3__t2_a_n22)=0 v(bl_3__t3_a_n22)=0
.ic v(rbl_0_a_n22)=0.9 v(rbl_0__t0_a_n22)=0.9 v(rbl_0__t1_a_n22)=0.9 v(rbl_0__t2_a_n22)=0.9
.ic v(rbl_0__t3_a_n22)=0.9 v(rbl_1_a_n22)=0.9 v(rbl_1__t0_a_n22)=0.9 v(rbl_1__t1_a_n22)=0.9
.ic v(rbl_1__t2_a_n22)=0.9 v(rbl_1__t3_a_n22)=0.9 v(rbl_2_a_n22)=0.9 v(rbl_2__t0_a_n22)=0.9
.ic v(rbl_2__t1_a_n22)=0.9 v(rbl_2__t2_a_n22)=0.9 v(rbl_2__t3_a_n22)=0.9 v(rbl_3_a_n22)=0.9
.ic v(rbl_3__t0_a_n22)=0.9 v(rbl_3__t1_a_n22)=0.9 v(rbl_3__t2_a_n22)=0.9 v(rbl_3__t3_a_n22)=0.9
.ic v(rwl_0_a_n22)=1.8 v(rwl_0__t0_a_n22)=1.8 v(rwl_0__t1_a_n22)=1.8 v(rwl_0__t2_a_n22)=1.8
.ic v(rwl_0__t3_a_n22)=1.8 v(rwl_1_a_n22)=1.8 v(rwl_1__t0_a_n22)=1.8 v(rwl_1__t1_a_n22)=1.8
.ic v(rwl_1__t2_a_n22)=1.8 v(rwl_1__t3_a_n22)=1.8 v(rwl_2_a_n22)=1.8 v(rwl_2__t0_a_n22)=1.8
.ic v(rwl_2__t1_a_n22)=1.8 v(rwl_2__t2_a_n22)=1.8 v(rwl_2__t3_a_n22)=1.8 v(rwl_3_a_n22)=1.8
.ic v(rwl_3__t0_a_n22)=1.8 v(rwl_3__t1_a_n22)=1.8 v(rwl_3__t2_a_n22)=1.8 v(rwl_3__t3_a_n22)=1.8
.ic v(wl_0_a_n22)=0 v(wl_0__t0_a_n22)=0 v(wl_0__t1_a_n22)=0 v(wl_0__t2_a_n22)=0
.ic v(wl_0__t3_a_n22)=0 v(wl_1_a_n22)=0 v(wl_1__t0_a_n22)=0 v(wl_1__t1_a_n22)=0
.ic v(wl_1__t2_a_n22)=0 v(wl_1__t3_a_n22)=0 v(wl_2_a_n22)=0 v(wl_2__t0_a_n22)=0
.ic v(wl_2__t1_a_n22)=0 v(wl_2__t2_a_n22)=0 v(wl_2__t3_a_n22)=0 v(wl_3_a_n22)=0
.ic v(wl_3__t0_a_n22)=0 v(wl_3__t1_a_n22)=0 v(wl_3__t2_a_n22)=0 v(wl_3__t3_a_n22)=0
.ic v(gnd__t0_a_n23)=0 v(gnd__t1_a_n23)=0 v(gnd__t10_a_n23)=0 v(gnd__t11_a_n23)=0
.ic v(gnd__t12_a_n23)=0 v(gnd__t13_a_n23)=0 v(gnd__t14_a_n23)=0 v(gnd__t15_a_n23)=0
.ic v(gnd__t16_a_n23)=0 v(gnd__t17_a_n23)=0 v(gnd__t18_a_n23)=0 v(gnd__t19_a_n23)=0
.ic v(gnd__t2_a_n23)=0 v(gnd__t20_a_n23)=0 v(gnd__t21_a_n23)=0 v(gnd__t22_a_n23)=0
.ic v(gnd__t23_a_n23)=0 v(gnd__t24_a_n23)=0 v(gnd__t25_a_n23)=0 v(gnd__t26_a_n23)=0
.ic v(gnd__t27_a_n23)=0 v(gnd__t28_a_n23)=0 v(gnd__t29_a_n23)=0 v(gnd__t3_a_n23)=0
.ic v(gnd__t30_a_n23)=0 v(gnd__t31_a_n23)=0 v(gnd__t4_a_n23)=0 v(gnd__t5_a_n23)=0
.ic v(gnd__t6_a_n23)=0 v(gnd__t7_a_n23)=0 v(gnd__t8_a_n23)=0 v(gnd__t9_a_n23)=0
.ic v(n10_a_n23)=1 v(n10__t0_a_n23)=1 v(n10__t1_a_n23)=1 v(n17_a_n23)=1
.ic v(n17__t0_a_n23)=1 v(n17__t1_a_n23)=1 v(n18_a_n23)=1 v(n18__t0_a_n23)=1
.ic v(n18__t1_a_n23)=1 v(n19_a_n23)=1 v(n19__t0_a_n23)=1 v(n19__t1_a_n23)=1
.ic v(n20_a_n23)=1 v(n20__t0_a_n23)=1 v(n20__t1_a_n23)=1 v(n22_a_n23)=1
.ic v(n22__t0_a_n23)=1 v(n22__t1_a_n23)=1 v(n23_a_n23)=1.1 v(n23__t0_a_n23)=1.1
.ic v(n23__t1_a_n23)=1.1 v(n24_a_n23)=1 v(n24__t0_a_n23)=1 v(n24__t1_a_n23)=1
.ic v(n25_a_n23)=1 v(n25__t0_a_n23)=1 v(n25__t1_a_n23)=1 v(n29_a_n23)=1
.ic v(n29__t0_a_n23)=1 v(n29__t1_a_n23)=1 v(n30_a_n23)=1 v(n30__t0_a_n23)=1
.ic v(n30__t1_a_n23)=1 v(n31_a_n23)=1 v(n31__t0_a_n23)=1 v(n31__t1_a_n23)=1
.ic v(n32_a_n23)=1 v(n32__t0_a_n23)=1 v(n32__t1_a_n23)=1 v(n7_a_n23)=1
.ic v(n7__t0_a_n23)=1 v(n7__t1_a_n23)=1 v(n8_a_n23)=1 v(n8__t0_a_n23)=1
.ic v(n8__t1_a_n23)=1 v(n9_a_n23)=1 v(n9__t0_a_n23)=1 v(n9__t1_a_n23)=1
.ic v(bl_0_a_n23)=0 v(bl_0__t0_a_n23)=0 v(bl_0__t1_a_n23)=0 v(bl_0__t2_a_n23)=0
.ic v(bl_0__t3_a_n23)=0 v(bl_1_a_n23)=0 v(bl_1__t0_a_n23)=0 v(bl_1__t1_a_n23)=0
.ic v(bl_1__t2_a_n23)=0 v(bl_1__t3_a_n23)=0 v(bl_2_a_n23)=0 v(bl_2__t0_a_n23)=0
.ic v(bl_2__t1_a_n23)=0 v(bl_2__t2_a_n23)=0 v(bl_2__t3_a_n23)=0 v(bl_3_a_n23)=0
.ic v(bl_3__t0_a_n23)=0 v(bl_3__t1_a_n23)=0 v(bl_3__t2_a_n23)=0 v(bl_3__t3_a_n23)=0
.ic v(rbl_0_a_n23)=0.9 v(rbl_0__t0_a_n23)=0.9 v(rbl_0__t1_a_n23)=0.9 v(rbl_0__t2_a_n23)=0.9
.ic v(rbl_0__t3_a_n23)=0.9 v(rbl_1_a_n23)=0.9 v(rbl_1__t0_a_n23)=0.9 v(rbl_1__t1_a_n23)=0.9
.ic v(rbl_1__t2_a_n23)=0.9 v(rbl_1__t3_a_n23)=0.9 v(rbl_2_a_n23)=0.9 v(rbl_2__t0_a_n23)=0.9
.ic v(rbl_2__t1_a_n23)=0.9 v(rbl_2__t2_a_n23)=0.9 v(rbl_2__t3_a_n23)=0.9 v(rbl_3_a_n23)=0.9
.ic v(rbl_3__t0_a_n23)=0.9 v(rbl_3__t1_a_n23)=0.9 v(rbl_3__t2_a_n23)=0.9 v(rbl_3__t3_a_n23)=0.9
.ic v(rwl_0_a_n23)=1.8 v(rwl_0__t0_a_n23)=1.8 v(rwl_0__t1_a_n23)=1.8 v(rwl_0__t2_a_n23)=1.8
.ic v(rwl_0__t3_a_n23)=1.8 v(rwl_1_a_n23)=1.8 v(rwl_1__t0_a_n23)=1.8 v(rwl_1__t1_a_n23)=1.8
.ic v(rwl_1__t2_a_n23)=1.8 v(rwl_1__t3_a_n23)=1.8 v(rwl_2_a_n23)=1.8 v(rwl_2__t0_a_n23)=1.8
.ic v(rwl_2__t1_a_n23)=1.8 v(rwl_2__t2_a_n23)=1.8 v(rwl_2__t3_a_n23)=1.8 v(rwl_3_a_n23)=1.8
.ic v(rwl_3__t0_a_n23)=1.8 v(rwl_3__t1_a_n23)=1.8 v(rwl_3__t2_a_n23)=1.8 v(rwl_3__t3_a_n23)=1.8
.ic v(wl_0_a_n23)=0 v(wl_0__t0_a_n23)=0 v(wl_0__t1_a_n23)=0 v(wl_0__t2_a_n23)=0
.ic v(wl_0__t3_a_n23)=0 v(wl_1_a_n23)=0 v(wl_1__t0_a_n23)=0 v(wl_1__t1_a_n23)=0
.ic v(wl_1__t2_a_n23)=0 v(wl_1__t3_a_n23)=0 v(wl_2_a_n23)=0 v(wl_2__t0_a_n23)=0
.ic v(wl_2__t1_a_n23)=0 v(wl_2__t2_a_n23)=0 v(wl_2__t3_a_n23)=0 v(wl_3_a_n23)=0
.ic v(wl_3__t0_a_n23)=0 v(wl_3__t1_a_n23)=0 v(wl_3__t2_a_n23)=0 v(wl_3__t3_a_n23)=0
.ic v(gnd__t0_a_n24)=0 v(gnd__t1_a_n24)=0 v(gnd__t10_a_n24)=0 v(gnd__t11_a_n24)=0
.ic v(gnd__t12_a_n24)=0 v(gnd__t13_a_n24)=0 v(gnd__t14_a_n24)=0 v(gnd__t15_a_n24)=0
.ic v(gnd__t16_a_n24)=0 v(gnd__t17_a_n24)=0 v(gnd__t18_a_n24)=0 v(gnd__t19_a_n24)=0
.ic v(gnd__t2_a_n24)=0 v(gnd__t20_a_n24)=0 v(gnd__t21_a_n24)=0 v(gnd__t22_a_n24)=0
.ic v(gnd__t23_a_n24)=0 v(gnd__t24_a_n24)=0 v(gnd__t25_a_n24)=0 v(gnd__t26_a_n24)=0
.ic v(gnd__t27_a_n24)=0 v(gnd__t28_a_n24)=0 v(gnd__t29_a_n24)=0 v(gnd__t3_a_n24)=0
.ic v(gnd__t30_a_n24)=0 v(gnd__t31_a_n24)=0 v(gnd__t4_a_n24)=0 v(gnd__t5_a_n24)=0
.ic v(gnd__t6_a_n24)=0 v(gnd__t7_a_n24)=0 v(gnd__t8_a_n24)=0 v(gnd__t9_a_n24)=0
.ic v(n10_a_n24)=1 v(n10__t0_a_n24)=1 v(n10__t1_a_n24)=1 v(n17_a_n24)=1
.ic v(n17__t0_a_n24)=1 v(n17__t1_a_n24)=1 v(n18_a_n24)=1 v(n18__t0_a_n24)=1
.ic v(n18__t1_a_n24)=1 v(n19_a_n24)=1 v(n19__t0_a_n24)=1 v(n19__t1_a_n24)=1
.ic v(n20_a_n24)=1 v(n20__t0_a_n24)=1 v(n20__t1_a_n24)=1 v(n22_a_n24)=1
.ic v(n22__t0_a_n24)=1 v(n22__t1_a_n24)=1 v(n23_a_n24)=1 v(n23__t0_a_n24)=1
.ic v(n23__t1_a_n24)=1 v(n24_a_n24)=1.1 v(n24__t0_a_n24)=1.1 v(n24__t1_a_n24)=1.1
.ic v(n25_a_n24)=1 v(n25__t0_a_n24)=1 v(n25__t1_a_n24)=1 v(n29_a_n24)=1
.ic v(n29__t0_a_n24)=1 v(n29__t1_a_n24)=1 v(n30_a_n24)=1 v(n30__t0_a_n24)=1
.ic v(n30__t1_a_n24)=1 v(n31_a_n24)=1 v(n31__t0_a_n24)=1 v(n31__t1_a_n24)=1
.ic v(n32_a_n24)=1 v(n32__t0_a_n24)=1 v(n32__t1_a_n24)=1 v(n7_a_n24)=1
.ic v(n7__t0_a_n24)=1 v(n7__t1_a_n24)=1 v(n8_a_n24)=1 v(n8__t0_a_n24)=1
.ic v(n8__t1_a_n24)=1 v(n9_a_n24)=1 v(n9__t0_a_n24)=1 v(n9__t1_a_n24)=1
.ic v(bl_0_a_n24)=0 v(bl_0__t0_a_n24)=0 v(bl_0__t1_a_n24)=0 v(bl_0__t2_a_n24)=0
.ic v(bl_0__t3_a_n24)=0 v(bl_1_a_n24)=0 v(bl_1__t0_a_n24)=0 v(bl_1__t1_a_n24)=0
.ic v(bl_1__t2_a_n24)=0 v(bl_1__t3_a_n24)=0 v(bl_2_a_n24)=0 v(bl_2__t0_a_n24)=0
.ic v(bl_2__t1_a_n24)=0 v(bl_2__t2_a_n24)=0 v(bl_2__t3_a_n24)=0 v(bl_3_a_n24)=0
.ic v(bl_3__t0_a_n24)=0 v(bl_3__t1_a_n24)=0 v(bl_3__t2_a_n24)=0 v(bl_3__t3_a_n24)=0
.ic v(rbl_0_a_n24)=0.9 v(rbl_0__t0_a_n24)=0.9 v(rbl_0__t1_a_n24)=0.9 v(rbl_0__t2_a_n24)=0.9
.ic v(rbl_0__t3_a_n24)=0.9 v(rbl_1_a_n24)=0.9 v(rbl_1__t0_a_n24)=0.9 v(rbl_1__t1_a_n24)=0.9
.ic v(rbl_1__t2_a_n24)=0.9 v(rbl_1__t3_a_n24)=0.9 v(rbl_2_a_n24)=0.9 v(rbl_2__t0_a_n24)=0.9
.ic v(rbl_2__t1_a_n24)=0.9 v(rbl_2__t2_a_n24)=0.9 v(rbl_2__t3_a_n24)=0.9 v(rbl_3_a_n24)=0.9
.ic v(rbl_3__t0_a_n24)=0.9 v(rbl_3__t1_a_n24)=0.9 v(rbl_3__t2_a_n24)=0.9 v(rbl_3__t3_a_n24)=0.9
.ic v(rwl_0_a_n24)=1.8 v(rwl_0__t0_a_n24)=1.8 v(rwl_0__t1_a_n24)=1.8 v(rwl_0__t2_a_n24)=1.8
.ic v(rwl_0__t3_a_n24)=1.8 v(rwl_1_a_n24)=1.8 v(rwl_1__t0_a_n24)=1.8 v(rwl_1__t1_a_n24)=1.8
.ic v(rwl_1__t2_a_n24)=1.8 v(rwl_1__t3_a_n24)=1.8 v(rwl_2_a_n24)=1.8 v(rwl_2__t0_a_n24)=1.8
.ic v(rwl_2__t1_a_n24)=1.8 v(rwl_2__t2_a_n24)=1.8 v(rwl_2__t3_a_n24)=1.8 v(rwl_3_a_n24)=1.8
.ic v(rwl_3__t0_a_n24)=1.8 v(rwl_3__t1_a_n24)=1.8 v(rwl_3__t2_a_n24)=1.8 v(rwl_3__t3_a_n24)=1.8
.ic v(wl_0_a_n24)=0 v(wl_0__t0_a_n24)=0 v(wl_0__t1_a_n24)=0 v(wl_0__t2_a_n24)=0
.ic v(wl_0__t3_a_n24)=0 v(wl_1_a_n24)=0 v(wl_1__t0_a_n24)=0 v(wl_1__t1_a_n24)=0
.ic v(wl_1__t2_a_n24)=0 v(wl_1__t3_a_n24)=0 v(wl_2_a_n24)=0 v(wl_2__t0_a_n24)=0
.ic v(wl_2__t1_a_n24)=0 v(wl_2__t2_a_n24)=0 v(wl_2__t3_a_n24)=0 v(wl_3_a_n24)=0
.ic v(wl_3__t0_a_n24)=0 v(wl_3__t1_a_n24)=0 v(wl_3__t2_a_n24)=0 v(wl_3__t3_a_n24)=0
.ic v(gnd__t0_a_n25)=0 v(gnd__t1_a_n25)=0 v(gnd__t10_a_n25)=0 v(gnd__t11_a_n25)=0
.ic v(gnd__t12_a_n25)=0 v(gnd__t13_a_n25)=0 v(gnd__t14_a_n25)=0 v(gnd__t15_a_n25)=0
.ic v(gnd__t16_a_n25)=0 v(gnd__t17_a_n25)=0 v(gnd__t18_a_n25)=0 v(gnd__t19_a_n25)=0
.ic v(gnd__t2_a_n25)=0 v(gnd__t20_a_n25)=0 v(gnd__t21_a_n25)=0 v(gnd__t22_a_n25)=0
.ic v(gnd__t23_a_n25)=0 v(gnd__t24_a_n25)=0 v(gnd__t25_a_n25)=0 v(gnd__t26_a_n25)=0
.ic v(gnd__t27_a_n25)=0 v(gnd__t28_a_n25)=0 v(gnd__t29_a_n25)=0 v(gnd__t3_a_n25)=0
.ic v(gnd__t30_a_n25)=0 v(gnd__t31_a_n25)=0 v(gnd__t4_a_n25)=0 v(gnd__t5_a_n25)=0
.ic v(gnd__t6_a_n25)=0 v(gnd__t7_a_n25)=0 v(gnd__t8_a_n25)=0 v(gnd__t9_a_n25)=0
.ic v(n10_a_n25)=1 v(n10__t0_a_n25)=1 v(n10__t1_a_n25)=1 v(n17_a_n25)=1
.ic v(n17__t0_a_n25)=1 v(n17__t1_a_n25)=1 v(n18_a_n25)=1 v(n18__t0_a_n25)=1
.ic v(n18__t1_a_n25)=1 v(n19_a_n25)=1 v(n19__t0_a_n25)=1 v(n19__t1_a_n25)=1
.ic v(n20_a_n25)=1 v(n20__t0_a_n25)=1 v(n20__t1_a_n25)=1 v(n22_a_n25)=1
.ic v(n22__t0_a_n25)=1 v(n22__t1_a_n25)=1 v(n23_a_n25)=1 v(n23__t0_a_n25)=1
.ic v(n23__t1_a_n25)=1 v(n24_a_n25)=1 v(n24__t0_a_n25)=1 v(n24__t1_a_n25)=1
.ic v(n25_a_n25)=1.1 v(n25__t0_a_n25)=1.1 v(n25__t1_a_n25)=1.1 v(n29_a_n25)=1
.ic v(n29__t0_a_n25)=1 v(n29__t1_a_n25)=1 v(n30_a_n25)=1 v(n30__t0_a_n25)=1
.ic v(n30__t1_a_n25)=1 v(n31_a_n25)=1 v(n31__t0_a_n25)=1 v(n31__t1_a_n25)=1
.ic v(n32_a_n25)=1 v(n32__t0_a_n25)=1 v(n32__t1_a_n25)=1 v(n7_a_n25)=1
.ic v(n7__t0_a_n25)=1 v(n7__t1_a_n25)=1 v(n8_a_n25)=1 v(n8__t0_a_n25)=1
.ic v(n8__t1_a_n25)=1 v(n9_a_n25)=1 v(n9__t0_a_n25)=1 v(n9__t1_a_n25)=1
.ic v(bl_0_a_n25)=0 v(bl_0__t0_a_n25)=0 v(bl_0__t1_a_n25)=0 v(bl_0__t2_a_n25)=0
.ic v(bl_0__t3_a_n25)=0 v(bl_1_a_n25)=0 v(bl_1__t0_a_n25)=0 v(bl_1__t1_a_n25)=0
.ic v(bl_1__t2_a_n25)=0 v(bl_1__t3_a_n25)=0 v(bl_2_a_n25)=0 v(bl_2__t0_a_n25)=0
.ic v(bl_2__t1_a_n25)=0 v(bl_2__t2_a_n25)=0 v(bl_2__t3_a_n25)=0 v(bl_3_a_n25)=0
.ic v(bl_3__t0_a_n25)=0 v(bl_3__t1_a_n25)=0 v(bl_3__t2_a_n25)=0 v(bl_3__t3_a_n25)=0
.ic v(rbl_0_a_n25)=0.9 v(rbl_0__t0_a_n25)=0.9 v(rbl_0__t1_a_n25)=0.9 v(rbl_0__t2_a_n25)=0.9
.ic v(rbl_0__t3_a_n25)=0.9 v(rbl_1_a_n25)=0.9 v(rbl_1__t0_a_n25)=0.9 v(rbl_1__t1_a_n25)=0.9
.ic v(rbl_1__t2_a_n25)=0.9 v(rbl_1__t3_a_n25)=0.9 v(rbl_2_a_n25)=0.9 v(rbl_2__t0_a_n25)=0.9
.ic v(rbl_2__t1_a_n25)=0.9 v(rbl_2__t2_a_n25)=0.9 v(rbl_2__t3_a_n25)=0.9 v(rbl_3_a_n25)=0.9
.ic v(rbl_3__t0_a_n25)=0.9 v(rbl_3__t1_a_n25)=0.9 v(rbl_3__t2_a_n25)=0.9 v(rbl_3__t3_a_n25)=0.9
.ic v(rwl_0_a_n25)=1.8 v(rwl_0__t0_a_n25)=1.8 v(rwl_0__t1_a_n25)=1.8 v(rwl_0__t2_a_n25)=1.8
.ic v(rwl_0__t3_a_n25)=1.8 v(rwl_1_a_n25)=1.8 v(rwl_1__t0_a_n25)=1.8 v(rwl_1__t1_a_n25)=1.8
.ic v(rwl_1__t2_a_n25)=1.8 v(rwl_1__t3_a_n25)=1.8 v(rwl_2_a_n25)=1.8 v(rwl_2__t0_a_n25)=1.8
.ic v(rwl_2__t1_a_n25)=1.8 v(rwl_2__t2_a_n25)=1.8 v(rwl_2__t3_a_n25)=1.8 v(rwl_3_a_n25)=1.8
.ic v(rwl_3__t0_a_n25)=1.8 v(rwl_3__t1_a_n25)=1.8 v(rwl_3__t2_a_n25)=1.8 v(rwl_3__t3_a_n25)=1.8
.ic v(wl_0_a_n25)=0 v(wl_0__t0_a_n25)=0 v(wl_0__t1_a_n25)=0 v(wl_0__t2_a_n25)=0
.ic v(wl_0__t3_a_n25)=0 v(wl_1_a_n25)=0 v(wl_1__t0_a_n25)=0 v(wl_1__t1_a_n25)=0
.ic v(wl_1__t2_a_n25)=0 v(wl_1__t3_a_n25)=0 v(wl_2_a_n25)=0 v(wl_2__t0_a_n25)=0
.ic v(wl_2__t1_a_n25)=0 v(wl_2__t2_a_n25)=0 v(wl_2__t3_a_n25)=0 v(wl_3_a_n25)=0
.ic v(wl_3__t0_a_n25)=0 v(wl_3__t1_a_n25)=0 v(wl_3__t2_a_n25)=0 v(wl_3__t3_a_n25)=0
.ic v(gnd__t0_a_n29)=0 v(gnd__t1_a_n29)=0 v(gnd__t10_a_n29)=0 v(gnd__t11_a_n29)=0
.ic v(gnd__t12_a_n29)=0 v(gnd__t13_a_n29)=0 v(gnd__t14_a_n29)=0 v(gnd__t15_a_n29)=0
.ic v(gnd__t16_a_n29)=0 v(gnd__t17_a_n29)=0 v(gnd__t18_a_n29)=0 v(gnd__t19_a_n29)=0
.ic v(gnd__t2_a_n29)=0 v(gnd__t20_a_n29)=0 v(gnd__t21_a_n29)=0 v(gnd__t22_a_n29)=0
.ic v(gnd__t23_a_n29)=0 v(gnd__t24_a_n29)=0 v(gnd__t25_a_n29)=0 v(gnd__t26_a_n29)=0
.ic v(gnd__t27_a_n29)=0 v(gnd__t28_a_n29)=0 v(gnd__t29_a_n29)=0 v(gnd__t3_a_n29)=0
.ic v(gnd__t30_a_n29)=0 v(gnd__t31_a_n29)=0 v(gnd__t4_a_n29)=0 v(gnd__t5_a_n29)=0
.ic v(gnd__t6_a_n29)=0 v(gnd__t7_a_n29)=0 v(gnd__t8_a_n29)=0 v(gnd__t9_a_n29)=0
.ic v(n10_a_n29)=1 v(n10__t0_a_n29)=1 v(n10__t1_a_n29)=1 v(n17_a_n29)=1
.ic v(n17__t0_a_n29)=1 v(n17__t1_a_n29)=1 v(n18_a_n29)=1 v(n18__t0_a_n29)=1
.ic v(n18__t1_a_n29)=1 v(n19_a_n29)=1 v(n19__t0_a_n29)=1 v(n19__t1_a_n29)=1
.ic v(n20_a_n29)=1 v(n20__t0_a_n29)=1 v(n20__t1_a_n29)=1 v(n22_a_n29)=1
.ic v(n22__t0_a_n29)=1 v(n22__t1_a_n29)=1 v(n23_a_n29)=1 v(n23__t0_a_n29)=1
.ic v(n23__t1_a_n29)=1 v(n24_a_n29)=1 v(n24__t0_a_n29)=1 v(n24__t1_a_n29)=1
.ic v(n25_a_n29)=1 v(n25__t0_a_n29)=1 v(n25__t1_a_n29)=1 v(n29_a_n29)=1.1
.ic v(n29__t0_a_n29)=1.1 v(n29__t1_a_n29)=1.1 v(n30_a_n29)=1 v(n30__t0_a_n29)=1
.ic v(n30__t1_a_n29)=1 v(n31_a_n29)=1 v(n31__t0_a_n29)=1 v(n31__t1_a_n29)=1
.ic v(n32_a_n29)=1 v(n32__t0_a_n29)=1 v(n32__t1_a_n29)=1 v(n7_a_n29)=1
.ic v(n7__t0_a_n29)=1 v(n7__t1_a_n29)=1 v(n8_a_n29)=1 v(n8__t0_a_n29)=1
.ic v(n8__t1_a_n29)=1 v(n9_a_n29)=1 v(n9__t0_a_n29)=1 v(n9__t1_a_n29)=1
.ic v(bl_0_a_n29)=0 v(bl_0__t0_a_n29)=0 v(bl_0__t1_a_n29)=0 v(bl_0__t2_a_n29)=0
.ic v(bl_0__t3_a_n29)=0 v(bl_1_a_n29)=0 v(bl_1__t0_a_n29)=0 v(bl_1__t1_a_n29)=0
.ic v(bl_1__t2_a_n29)=0 v(bl_1__t3_a_n29)=0 v(bl_2_a_n29)=0 v(bl_2__t0_a_n29)=0
.ic v(bl_2__t1_a_n29)=0 v(bl_2__t2_a_n29)=0 v(bl_2__t3_a_n29)=0 v(bl_3_a_n29)=0
.ic v(bl_3__t0_a_n29)=0 v(bl_3__t1_a_n29)=0 v(bl_3__t2_a_n29)=0 v(bl_3__t3_a_n29)=0
.ic v(rbl_0_a_n29)=0.9 v(rbl_0__t0_a_n29)=0.9 v(rbl_0__t1_a_n29)=0.9 v(rbl_0__t2_a_n29)=0.9
.ic v(rbl_0__t3_a_n29)=0.9 v(rbl_1_a_n29)=0.9 v(rbl_1__t0_a_n29)=0.9 v(rbl_1__t1_a_n29)=0.9
.ic v(rbl_1__t2_a_n29)=0.9 v(rbl_1__t3_a_n29)=0.9 v(rbl_2_a_n29)=0.9 v(rbl_2__t0_a_n29)=0.9
.ic v(rbl_2__t1_a_n29)=0.9 v(rbl_2__t2_a_n29)=0.9 v(rbl_2__t3_a_n29)=0.9 v(rbl_3_a_n29)=0.9
.ic v(rbl_3__t0_a_n29)=0.9 v(rbl_3__t1_a_n29)=0.9 v(rbl_3__t2_a_n29)=0.9 v(rbl_3__t3_a_n29)=0.9
.ic v(rwl_0_a_n29)=1.8 v(rwl_0__t0_a_n29)=1.8 v(rwl_0__t1_a_n29)=1.8 v(rwl_0__t2_a_n29)=1.8
.ic v(rwl_0__t3_a_n29)=1.8 v(rwl_1_a_n29)=1.8 v(rwl_1__t0_a_n29)=1.8 v(rwl_1__t1_a_n29)=1.8
.ic v(rwl_1__t2_a_n29)=1.8 v(rwl_1__t3_a_n29)=1.8 v(rwl_2_a_n29)=1.8 v(rwl_2__t0_a_n29)=1.8
.ic v(rwl_2__t1_a_n29)=1.8 v(rwl_2__t2_a_n29)=1.8 v(rwl_2__t3_a_n29)=1.8 v(rwl_3_a_n29)=1.8
.ic v(rwl_3__t0_a_n29)=1.8 v(rwl_3__t1_a_n29)=1.8 v(rwl_3__t2_a_n29)=1.8 v(rwl_3__t3_a_n29)=1.8
.ic v(wl_0_a_n29)=0 v(wl_0__t0_a_n29)=0 v(wl_0__t1_a_n29)=0 v(wl_0__t2_a_n29)=0
.ic v(wl_0__t3_a_n29)=0 v(wl_1_a_n29)=0 v(wl_1__t0_a_n29)=0 v(wl_1__t1_a_n29)=0
.ic v(wl_1__t2_a_n29)=0 v(wl_1__t3_a_n29)=0 v(wl_2_a_n29)=0 v(wl_2__t0_a_n29)=0
.ic v(wl_2__t1_a_n29)=0 v(wl_2__t2_a_n29)=0 v(wl_2__t3_a_n29)=0 v(wl_3_a_n29)=0
.ic v(wl_3__t0_a_n29)=0 v(wl_3__t1_a_n29)=0 v(wl_3__t2_a_n29)=0 v(wl_3__t3_a_n29)=0
.ic v(gnd__t0_a_n30)=0 v(gnd__t1_a_n30)=0 v(gnd__t10_a_n30)=0 v(gnd__t11_a_n30)=0
.ic v(gnd__t12_a_n30)=0 v(gnd__t13_a_n30)=0 v(gnd__t14_a_n30)=0 v(gnd__t15_a_n30)=0
.ic v(gnd__t16_a_n30)=0 v(gnd__t17_a_n30)=0 v(gnd__t18_a_n30)=0 v(gnd__t19_a_n30)=0
.ic v(gnd__t2_a_n30)=0 v(gnd__t20_a_n30)=0 v(gnd__t21_a_n30)=0 v(gnd__t22_a_n30)=0
.ic v(gnd__t23_a_n30)=0 v(gnd__t24_a_n30)=0 v(gnd__t25_a_n30)=0 v(gnd__t26_a_n30)=0
.ic v(gnd__t27_a_n30)=0 v(gnd__t28_a_n30)=0 v(gnd__t29_a_n30)=0 v(gnd__t3_a_n30)=0
.ic v(gnd__t30_a_n30)=0 v(gnd__t31_a_n30)=0 v(gnd__t4_a_n30)=0 v(gnd__t5_a_n30)=0
.ic v(gnd__t6_a_n30)=0 v(gnd__t7_a_n30)=0 v(gnd__t8_a_n30)=0 v(gnd__t9_a_n30)=0
.ic v(n10_a_n30)=1 v(n10__t0_a_n30)=1 v(n10__t1_a_n30)=1 v(n17_a_n30)=1
.ic v(n17__t0_a_n30)=1 v(n17__t1_a_n30)=1 v(n18_a_n30)=1 v(n18__t0_a_n30)=1
.ic v(n18__t1_a_n30)=1 v(n19_a_n30)=1 v(n19__t0_a_n30)=1 v(n19__t1_a_n30)=1
.ic v(n20_a_n30)=1 v(n20__t0_a_n30)=1 v(n20__t1_a_n30)=1 v(n22_a_n30)=1
.ic v(n22__t0_a_n30)=1 v(n22__t1_a_n30)=1 v(n23_a_n30)=1 v(n23__t0_a_n30)=1
.ic v(n23__t1_a_n30)=1 v(n24_a_n30)=1 v(n24__t0_a_n30)=1 v(n24__t1_a_n30)=1
.ic v(n25_a_n30)=1 v(n25__t0_a_n30)=1 v(n25__t1_a_n30)=1 v(n29_a_n30)=1
.ic v(n29__t0_a_n30)=1 v(n29__t1_a_n30)=1 v(n30_a_n30)=1.1 v(n30__t0_a_n30)=1.1
.ic v(n30__t1_a_n30)=1.1 v(n31_a_n30)=1 v(n31__t0_a_n30)=1 v(n31__t1_a_n30)=1
.ic v(n32_a_n30)=1 v(n32__t0_a_n30)=1 v(n32__t1_a_n30)=1 v(n7_a_n30)=1
.ic v(n7__t0_a_n30)=1 v(n7__t1_a_n30)=1 v(n8_a_n30)=1 v(n8__t0_a_n30)=1
.ic v(n8__t1_a_n30)=1 v(n9_a_n30)=1 v(n9__t0_a_n30)=1 v(n9__t1_a_n30)=1
.ic v(bl_0_a_n30)=0 v(bl_0__t0_a_n30)=0 v(bl_0__t1_a_n30)=0 v(bl_0__t2_a_n30)=0
.ic v(bl_0__t3_a_n30)=0 v(bl_1_a_n30)=0 v(bl_1__t0_a_n30)=0 v(bl_1__t1_a_n30)=0
.ic v(bl_1__t2_a_n30)=0 v(bl_1__t3_a_n30)=0 v(bl_2_a_n30)=0 v(bl_2__t0_a_n30)=0
.ic v(bl_2__t1_a_n30)=0 v(bl_2__t2_a_n30)=0 v(bl_2__t3_a_n30)=0 v(bl_3_a_n30)=0
.ic v(bl_3__t0_a_n30)=0 v(bl_3__t1_a_n30)=0 v(bl_3__t2_a_n30)=0 v(bl_3__t3_a_n30)=0
.ic v(rbl_0_a_n30)=0.9 v(rbl_0__t0_a_n30)=0.9 v(rbl_0__t1_a_n30)=0.9 v(rbl_0__t2_a_n30)=0.9
.ic v(rbl_0__t3_a_n30)=0.9 v(rbl_1_a_n30)=0.9 v(rbl_1__t0_a_n30)=0.9 v(rbl_1__t1_a_n30)=0.9
.ic v(rbl_1__t2_a_n30)=0.9 v(rbl_1__t3_a_n30)=0.9 v(rbl_2_a_n30)=0.9 v(rbl_2__t0_a_n30)=0.9
.ic v(rbl_2__t1_a_n30)=0.9 v(rbl_2__t2_a_n30)=0.9 v(rbl_2__t3_a_n30)=0.9 v(rbl_3_a_n30)=0.9
.ic v(rbl_3__t0_a_n30)=0.9 v(rbl_3__t1_a_n30)=0.9 v(rbl_3__t2_a_n30)=0.9 v(rbl_3__t3_a_n30)=0.9
.ic v(rwl_0_a_n30)=1.8 v(rwl_0__t0_a_n30)=1.8 v(rwl_0__t1_a_n30)=1.8 v(rwl_0__t2_a_n30)=1.8
.ic v(rwl_0__t3_a_n30)=1.8 v(rwl_1_a_n30)=1.8 v(rwl_1__t0_a_n30)=1.8 v(rwl_1__t1_a_n30)=1.8
.ic v(rwl_1__t2_a_n30)=1.8 v(rwl_1__t3_a_n30)=1.8 v(rwl_2_a_n30)=1.8 v(rwl_2__t0_a_n30)=1.8
.ic v(rwl_2__t1_a_n30)=1.8 v(rwl_2__t2_a_n30)=1.8 v(rwl_2__t3_a_n30)=1.8 v(rwl_3_a_n30)=1.8
.ic v(rwl_3__t0_a_n30)=1.8 v(rwl_3__t1_a_n30)=1.8 v(rwl_3__t2_a_n30)=1.8 v(rwl_3__t3_a_n30)=1.8
.ic v(wl_0_a_n30)=0 v(wl_0__t0_a_n30)=0 v(wl_0__t1_a_n30)=0 v(wl_0__t2_a_n30)=0
.ic v(wl_0__t3_a_n30)=0 v(wl_1_a_n30)=0 v(wl_1__t0_a_n30)=0 v(wl_1__t1_a_n30)=0
.ic v(wl_1__t2_a_n30)=0 v(wl_1__t3_a_n30)=0 v(wl_2_a_n30)=0 v(wl_2__t0_a_n30)=0
.ic v(wl_2__t1_a_n30)=0 v(wl_2__t2_a_n30)=0 v(wl_2__t3_a_n30)=0 v(wl_3_a_n30)=0
.ic v(wl_3__t0_a_n30)=0 v(wl_3__t1_a_n30)=0 v(wl_3__t2_a_n30)=0 v(wl_3__t3_a_n30)=0
.ic v(gnd__t0_a_n31)=0 v(gnd__t1_a_n31)=0 v(gnd__t10_a_n31)=0 v(gnd__t11_a_n31)=0
.ic v(gnd__t12_a_n31)=0 v(gnd__t13_a_n31)=0 v(gnd__t14_a_n31)=0 v(gnd__t15_a_n31)=0
.ic v(gnd__t16_a_n31)=0 v(gnd__t17_a_n31)=0 v(gnd__t18_a_n31)=0 v(gnd__t19_a_n31)=0
.ic v(gnd__t2_a_n31)=0 v(gnd__t20_a_n31)=0 v(gnd__t21_a_n31)=0 v(gnd__t22_a_n31)=0
.ic v(gnd__t23_a_n31)=0 v(gnd__t24_a_n31)=0 v(gnd__t25_a_n31)=0 v(gnd__t26_a_n31)=0
.ic v(gnd__t27_a_n31)=0 v(gnd__t28_a_n31)=0 v(gnd__t29_a_n31)=0 v(gnd__t3_a_n31)=0
.ic v(gnd__t30_a_n31)=0 v(gnd__t31_a_n31)=0 v(gnd__t4_a_n31)=0 v(gnd__t5_a_n31)=0
.ic v(gnd__t6_a_n31)=0 v(gnd__t7_a_n31)=0 v(gnd__t8_a_n31)=0 v(gnd__t9_a_n31)=0
.ic v(n10_a_n31)=1 v(n10__t0_a_n31)=1 v(n10__t1_a_n31)=1 v(n17_a_n31)=1
.ic v(n17__t0_a_n31)=1 v(n17__t1_a_n31)=1 v(n18_a_n31)=1 v(n18__t0_a_n31)=1
.ic v(n18__t1_a_n31)=1 v(n19_a_n31)=1 v(n19__t0_a_n31)=1 v(n19__t1_a_n31)=1
.ic v(n20_a_n31)=1 v(n20__t0_a_n31)=1 v(n20__t1_a_n31)=1 v(n22_a_n31)=1
.ic v(n22__t0_a_n31)=1 v(n22__t1_a_n31)=1 v(n23_a_n31)=1 v(n23__t0_a_n31)=1
.ic v(n23__t1_a_n31)=1 v(n24_a_n31)=1 v(n24__t0_a_n31)=1 v(n24__t1_a_n31)=1
.ic v(n25_a_n31)=1 v(n25__t0_a_n31)=1 v(n25__t1_a_n31)=1 v(n29_a_n31)=1
.ic v(n29__t0_a_n31)=1 v(n29__t1_a_n31)=1 v(n30_a_n31)=1 v(n30__t0_a_n31)=1
.ic v(n30__t1_a_n31)=1 v(n31_a_n31)=1.1 v(n31__t0_a_n31)=1.1 v(n31__t1_a_n31)=1.1
.ic v(n32_a_n31)=1 v(n32__t0_a_n31)=1 v(n32__t1_a_n31)=1 v(n7_a_n31)=1
.ic v(n7__t0_a_n31)=1 v(n7__t1_a_n31)=1 v(n8_a_n31)=1 v(n8__t0_a_n31)=1
.ic v(n8__t1_a_n31)=1 v(n9_a_n31)=1 v(n9__t0_a_n31)=1 v(n9__t1_a_n31)=1
.ic v(bl_0_a_n31)=0 v(bl_0__t0_a_n31)=0 v(bl_0__t1_a_n31)=0 v(bl_0__t2_a_n31)=0
.ic v(bl_0__t3_a_n31)=0 v(bl_1_a_n31)=0 v(bl_1__t0_a_n31)=0 v(bl_1__t1_a_n31)=0
.ic v(bl_1__t2_a_n31)=0 v(bl_1__t3_a_n31)=0 v(bl_2_a_n31)=0 v(bl_2__t0_a_n31)=0
.ic v(bl_2__t1_a_n31)=0 v(bl_2__t2_a_n31)=0 v(bl_2__t3_a_n31)=0 v(bl_3_a_n31)=0
.ic v(bl_3__t0_a_n31)=0 v(bl_3__t1_a_n31)=0 v(bl_3__t2_a_n31)=0 v(bl_3__t3_a_n31)=0
.ic v(rbl_0_a_n31)=0.9 v(rbl_0__t0_a_n31)=0.9 v(rbl_0__t1_a_n31)=0.9 v(rbl_0__t2_a_n31)=0.9
.ic v(rbl_0__t3_a_n31)=0.9 v(rbl_1_a_n31)=0.9 v(rbl_1__t0_a_n31)=0.9 v(rbl_1__t1_a_n31)=0.9
.ic v(rbl_1__t2_a_n31)=0.9 v(rbl_1__t3_a_n31)=0.9 v(rbl_2_a_n31)=0.9 v(rbl_2__t0_a_n31)=0.9
.ic v(rbl_2__t1_a_n31)=0.9 v(rbl_2__t2_a_n31)=0.9 v(rbl_2__t3_a_n31)=0.9 v(rbl_3_a_n31)=0.9
.ic v(rbl_3__t0_a_n31)=0.9 v(rbl_3__t1_a_n31)=0.9 v(rbl_3__t2_a_n31)=0.9 v(rbl_3__t3_a_n31)=0.9
.ic v(rwl_0_a_n31)=1.8 v(rwl_0__t0_a_n31)=1.8 v(rwl_0__t1_a_n31)=1.8 v(rwl_0__t2_a_n31)=1.8
.ic v(rwl_0__t3_a_n31)=1.8 v(rwl_1_a_n31)=1.8 v(rwl_1__t0_a_n31)=1.8 v(rwl_1__t1_a_n31)=1.8
.ic v(rwl_1__t2_a_n31)=1.8 v(rwl_1__t3_a_n31)=1.8 v(rwl_2_a_n31)=1.8 v(rwl_2__t0_a_n31)=1.8
.ic v(rwl_2__t1_a_n31)=1.8 v(rwl_2__t2_a_n31)=1.8 v(rwl_2__t3_a_n31)=1.8 v(rwl_3_a_n31)=1.8
.ic v(rwl_3__t0_a_n31)=1.8 v(rwl_3__t1_a_n31)=1.8 v(rwl_3__t2_a_n31)=1.8 v(rwl_3__t3_a_n31)=1.8
.ic v(wl_0_a_n31)=0 v(wl_0__t0_a_n31)=0 v(wl_0__t1_a_n31)=0 v(wl_0__t2_a_n31)=0
.ic v(wl_0__t3_a_n31)=0 v(wl_1_a_n31)=0 v(wl_1__t0_a_n31)=0 v(wl_1__t1_a_n31)=0
.ic v(wl_1__t2_a_n31)=0 v(wl_1__t3_a_n31)=0 v(wl_2_a_n31)=0 v(wl_2__t0_a_n31)=0
.ic v(wl_2__t1_a_n31)=0 v(wl_2__t2_a_n31)=0 v(wl_2__t3_a_n31)=0 v(wl_3_a_n31)=0
.ic v(wl_3__t0_a_n31)=0 v(wl_3__t1_a_n31)=0 v(wl_3__t2_a_n31)=0 v(wl_3__t3_a_n31)=0
.ic v(gnd__t0_a_n32)=0 v(gnd__t1_a_n32)=0 v(gnd__t10_a_n32)=0 v(gnd__t11_a_n32)=0
.ic v(gnd__t12_a_n32)=0 v(gnd__t13_a_n32)=0 v(gnd__t14_a_n32)=0 v(gnd__t15_a_n32)=0
.ic v(gnd__t16_a_n32)=0 v(gnd__t17_a_n32)=0 v(gnd__t18_a_n32)=0 v(gnd__t19_a_n32)=0
.ic v(gnd__t2_a_n32)=0 v(gnd__t20_a_n32)=0 v(gnd__t21_a_n32)=0 v(gnd__t22_a_n32)=0
.ic v(gnd__t23_a_n32)=0 v(gnd__t24_a_n32)=0 v(gnd__t25_a_n32)=0 v(gnd__t26_a_n32)=0
.ic v(gnd__t27_a_n32)=0 v(gnd__t28_a_n32)=0 v(gnd__t29_a_n32)=0 v(gnd__t3_a_n32)=0
.ic v(gnd__t30_a_n32)=0 v(gnd__t31_a_n32)=0 v(gnd__t4_a_n32)=0 v(gnd__t5_a_n32)=0
.ic v(gnd__t6_a_n32)=0 v(gnd__t7_a_n32)=0 v(gnd__t8_a_n32)=0 v(gnd__t9_a_n32)=0
.ic v(n10_a_n32)=1 v(n10__t0_a_n32)=1 v(n10__t1_a_n32)=1 v(n17_a_n32)=1
.ic v(n17__t0_a_n32)=1 v(n17__t1_a_n32)=1 v(n18_a_n32)=1 v(n18__t0_a_n32)=1
.ic v(n18__t1_a_n32)=1 v(n19_a_n32)=1 v(n19__t0_a_n32)=1 v(n19__t1_a_n32)=1
.ic v(n20_a_n32)=1 v(n20__t0_a_n32)=1 v(n20__t1_a_n32)=1 v(n22_a_n32)=1
.ic v(n22__t0_a_n32)=1 v(n22__t1_a_n32)=1 v(n23_a_n32)=1 v(n23__t0_a_n32)=1
.ic v(n23__t1_a_n32)=1 v(n24_a_n32)=1 v(n24__t0_a_n32)=1 v(n24__t1_a_n32)=1
.ic v(n25_a_n32)=1 v(n25__t0_a_n32)=1 v(n25__t1_a_n32)=1 v(n29_a_n32)=1
.ic v(n29__t0_a_n32)=1 v(n29__t1_a_n32)=1 v(n30_a_n32)=1 v(n30__t0_a_n32)=1
.ic v(n30__t1_a_n32)=1 v(n31_a_n32)=1 v(n31__t0_a_n32)=1 v(n31__t1_a_n32)=1
.ic v(n32_a_n32)=1.1 v(n32__t0_a_n32)=1.1 v(n32__t1_a_n32)=1.1 v(n7_a_n32)=1
.ic v(n7__t0_a_n32)=1 v(n7__t1_a_n32)=1 v(n8_a_n32)=1 v(n8__t0_a_n32)=1
.ic v(n8__t1_a_n32)=1 v(n9_a_n32)=1 v(n9__t0_a_n32)=1 v(n9__t1_a_n32)=1
.ic v(bl_0_a_n32)=0 v(bl_0__t0_a_n32)=0 v(bl_0__t1_a_n32)=0 v(bl_0__t2_a_n32)=0
.ic v(bl_0__t3_a_n32)=0 v(bl_1_a_n32)=0 v(bl_1__t0_a_n32)=0 v(bl_1__t1_a_n32)=0
.ic v(bl_1__t2_a_n32)=0 v(bl_1__t3_a_n32)=0 v(bl_2_a_n32)=0 v(bl_2__t0_a_n32)=0
.ic v(bl_2__t1_a_n32)=0 v(bl_2__t2_a_n32)=0 v(bl_2__t3_a_n32)=0 v(bl_3_a_n32)=0
.ic v(bl_3__t0_a_n32)=0 v(bl_3__t1_a_n32)=0 v(bl_3__t2_a_n32)=0 v(bl_3__t3_a_n32)=0
.ic v(rbl_0_a_n32)=0.9 v(rbl_0__t0_a_n32)=0.9 v(rbl_0__t1_a_n32)=0.9 v(rbl_0__t2_a_n32)=0.9
.ic v(rbl_0__t3_a_n32)=0.9 v(rbl_1_a_n32)=0.9 v(rbl_1__t0_a_n32)=0.9 v(rbl_1__t1_a_n32)=0.9
.ic v(rbl_1__t2_a_n32)=0.9 v(rbl_1__t3_a_n32)=0.9 v(rbl_2_a_n32)=0.9 v(rbl_2__t0_a_n32)=0.9
.ic v(rbl_2__t1_a_n32)=0.9 v(rbl_2__t2_a_n32)=0.9 v(rbl_2__t3_a_n32)=0.9 v(rbl_3_a_n32)=0.9
.ic v(rbl_3__t0_a_n32)=0.9 v(rbl_3__t1_a_n32)=0.9 v(rbl_3__t2_a_n32)=0.9 v(rbl_3__t3_a_n32)=0.9
.ic v(rwl_0_a_n32)=1.8 v(rwl_0__t0_a_n32)=1.8 v(rwl_0__t1_a_n32)=1.8 v(rwl_0__t2_a_n32)=1.8
.ic v(rwl_0__t3_a_n32)=1.8 v(rwl_1_a_n32)=1.8 v(rwl_1__t0_a_n32)=1.8 v(rwl_1__t1_a_n32)=1.8
.ic v(rwl_1__t2_a_n32)=1.8 v(rwl_1__t3_a_n32)=1.8 v(rwl_2_a_n32)=1.8 v(rwl_2__t0_a_n32)=1.8
.ic v(rwl_2__t1_a_n32)=1.8 v(rwl_2__t2_a_n32)=1.8 v(rwl_2__t3_a_n32)=1.8 v(rwl_3_a_n32)=1.8
.ic v(rwl_3__t0_a_n32)=1.8 v(rwl_3__t1_a_n32)=1.8 v(rwl_3__t2_a_n32)=1.8 v(rwl_3__t3_a_n32)=1.8
.ic v(wl_0_a_n32)=0 v(wl_0__t0_a_n32)=0 v(wl_0__t1_a_n32)=0 v(wl_0__t2_a_n32)=0
.ic v(wl_0__t3_a_n32)=0 v(wl_1_a_n32)=0 v(wl_1__t0_a_n32)=0 v(wl_1__t1_a_n32)=0
.ic v(wl_1__t2_a_n32)=0 v(wl_1__t3_a_n32)=0 v(wl_2_a_n32)=0 v(wl_2__t0_a_n32)=0
.ic v(wl_2__t1_a_n32)=0 v(wl_2__t2_a_n32)=0 v(wl_2__t3_a_n32)=0 v(wl_3_a_n32)=0
.ic v(wl_3__t0_a_n32)=0 v(wl_3__t1_a_n32)=0 v(wl_3__t2_a_n32)=0 v(wl_3__t3_a_n32)=0
.ic v(gnd__t0_p_n7)=0 v(gnd__t1_p_n7)=0 v(gnd__t10_p_n7)=0 v(gnd__t11_p_n7)=0
.ic v(gnd__t12_p_n7)=0 v(gnd__t13_p_n7)=0 v(gnd__t14_p_n7)=0 v(gnd__t15_p_n7)=0
.ic v(gnd__t16_p_n7)=0 v(gnd__t17_p_n7)=0 v(gnd__t18_p_n7)=0 v(gnd__t19_p_n7)=0
.ic v(gnd__t2_p_n7)=0 v(gnd__t20_p_n7)=0 v(gnd__t21_p_n7)=0 v(gnd__t22_p_n7)=0
.ic v(gnd__t23_p_n7)=0 v(gnd__t24_p_n7)=0 v(gnd__t25_p_n7)=0 v(gnd__t26_p_n7)=0
.ic v(gnd__t27_p_n7)=0 v(gnd__t28_p_n7)=0 v(gnd__t29_p_n7)=0 v(gnd__t3_p_n7)=0
.ic v(gnd__t30_p_n7)=0 v(gnd__t31_p_n7)=0 v(gnd__t4_p_n7)=0 v(gnd__t5_p_n7)=0
.ic v(gnd__t6_p_n7)=0 v(gnd__t7_p_n7)=0 v(gnd__t8_p_n7)=0 v(gnd__t9_p_n7)=0
.ic v(n10_p_n7)=1 v(n10__t0_p_n7)=1 v(n10__t1_p_n7)=1 v(n17_p_n7)=1
.ic v(n17__t0_p_n7)=1 v(n17__t1_p_n7)=1 v(n18_p_n7)=1 v(n18__t0_p_n7)=1
.ic v(n18__t1_p_n7)=1 v(n19_p_n7)=1 v(n19__t0_p_n7)=1 v(n19__t1_p_n7)=1
.ic v(n20_p_n7)=1 v(n20__t0_p_n7)=1 v(n20__t1_p_n7)=1 v(n22_p_n7)=1
.ic v(n22__t0_p_n7)=1 v(n22__t1_p_n7)=1 v(n23_p_n7)=1 v(n23__t0_p_n7)=1
.ic v(n23__t1_p_n7)=1 v(n24_p_n7)=1 v(n24__t0_p_n7)=1 v(n24__t1_p_n7)=1
.ic v(n25_p_n7)=1 v(n25__t0_p_n7)=1 v(n25__t1_p_n7)=1 v(n29_p_n7)=1
.ic v(n29__t0_p_n7)=1 v(n29__t1_p_n7)=1 v(n30_p_n7)=1 v(n30__t0_p_n7)=1
.ic v(n30__t1_p_n7)=1 v(n31_p_n7)=1 v(n31__t0_p_n7)=1 v(n31__t1_p_n7)=1
.ic v(n32_p_n7)=1 v(n32__t0_p_n7)=1 v(n32__t1_p_n7)=1 v(n7_p_n7)=1.1
.ic v(n7__t0_p_n7)=1.1 v(n7__t1_p_n7)=1.1 v(n8_p_n7)=1 v(n8__t0_p_n7)=1
.ic v(n8__t1_p_n7)=1 v(n9_p_n7)=1 v(n9__t0_p_n7)=1 v(n9__t1_p_n7)=1
.ic v(bl_0_p_n7)=0 v(bl_0__t0_p_n7)=0 v(bl_0__t1_p_n7)=0 v(bl_0__t2_p_n7)=0
.ic v(bl_0__t3_p_n7)=0 v(bl_1_p_n7)=0 v(bl_1__t0_p_n7)=0 v(bl_1__t1_p_n7)=0
.ic v(bl_1__t2_p_n7)=0 v(bl_1__t3_p_n7)=0 v(bl_2_p_n7)=0 v(bl_2__t0_p_n7)=0
.ic v(bl_2__t1_p_n7)=0 v(bl_2__t2_p_n7)=0 v(bl_2__t3_p_n7)=0 v(bl_3_p_n7)=0
.ic v(bl_3__t0_p_n7)=0 v(bl_3__t1_p_n7)=0 v(bl_3__t2_p_n7)=0 v(bl_3__t3_p_n7)=0
.ic v(rbl_0_p_n7)=0.9 v(rbl_0__t0_p_n7)=0.9 v(rbl_0__t1_p_n7)=0.9 v(rbl_0__t2_p_n7)=0.9
.ic v(rbl_0__t3_p_n7)=0.9 v(rbl_1_p_n7)=0.9 v(rbl_1__t0_p_n7)=0.9 v(rbl_1__t1_p_n7)=0.9
.ic v(rbl_1__t2_p_n7)=0.9 v(rbl_1__t3_p_n7)=0.9 v(rbl_2_p_n7)=0.9 v(rbl_2__t0_p_n7)=0.9
.ic v(rbl_2__t1_p_n7)=0.9 v(rbl_2__t2_p_n7)=0.9 v(rbl_2__t3_p_n7)=0.9 v(rbl_3_p_n7)=0.9
.ic v(rbl_3__t0_p_n7)=0.9 v(rbl_3__t1_p_n7)=0.9 v(rbl_3__t2_p_n7)=0.9 v(rbl_3__t3_p_n7)=0.9
.ic v(rwl_0_p_n7)=1.8 v(rwl_0__t0_p_n7)=1.8 v(rwl_0__t1_p_n7)=1.8 v(rwl_0__t2_p_n7)=1.8
.ic v(rwl_0__t3_p_n7)=1.8 v(rwl_1_p_n7)=1.8 v(rwl_1__t0_p_n7)=1.8 v(rwl_1__t1_p_n7)=1.8
.ic v(rwl_1__t2_p_n7)=1.8 v(rwl_1__t3_p_n7)=1.8 v(rwl_2_p_n7)=1.8 v(rwl_2__t0_p_n7)=1.8
.ic v(rwl_2__t1_p_n7)=1.8 v(rwl_2__t2_p_n7)=1.8 v(rwl_2__t3_p_n7)=1.8 v(rwl_3_p_n7)=1.8
.ic v(rwl_3__t0_p_n7)=1.8 v(rwl_3__t1_p_n7)=1.8 v(rwl_3__t2_p_n7)=1.8 v(rwl_3__t3_p_n7)=1.8
.ic v(wl_0_p_n7)=0 v(wl_0__t0_p_n7)=0 v(wl_0__t1_p_n7)=0 v(wl_0__t2_p_n7)=0
.ic v(wl_0__t3_p_n7)=0 v(wl_1_p_n7)=0 v(wl_1__t0_p_n7)=0 v(wl_1__t1_p_n7)=0
.ic v(wl_1__t2_p_n7)=0 v(wl_1__t3_p_n7)=0 v(wl_2_p_n7)=0 v(wl_2__t0_p_n7)=0
.ic v(wl_2__t1_p_n7)=0 v(wl_2__t2_p_n7)=0 v(wl_2__t3_p_n7)=0 v(wl_3_p_n7)=0
.ic v(wl_3__t0_p_n7)=0 v(wl_3__t1_p_n7)=0 v(wl_3__t2_p_n7)=0 v(wl_3__t3_p_n7)=0
.ic v(gnd__t0_p_n8)=0 v(gnd__t1_p_n8)=0 v(gnd__t10_p_n8)=0 v(gnd__t11_p_n8)=0
.ic v(gnd__t12_p_n8)=0 v(gnd__t13_p_n8)=0 v(gnd__t14_p_n8)=0 v(gnd__t15_p_n8)=0
.ic v(gnd__t16_p_n8)=0 v(gnd__t17_p_n8)=0 v(gnd__t18_p_n8)=0 v(gnd__t19_p_n8)=0
.ic v(gnd__t2_p_n8)=0 v(gnd__t20_p_n8)=0 v(gnd__t21_p_n8)=0 v(gnd__t22_p_n8)=0
.ic v(gnd__t23_p_n8)=0 v(gnd__t24_p_n8)=0 v(gnd__t25_p_n8)=0 v(gnd__t26_p_n8)=0
.ic v(gnd__t27_p_n8)=0 v(gnd__t28_p_n8)=0 v(gnd__t29_p_n8)=0 v(gnd__t3_p_n8)=0
.ic v(gnd__t30_p_n8)=0 v(gnd__t31_p_n8)=0 v(gnd__t4_p_n8)=0 v(gnd__t5_p_n8)=0
.ic v(gnd__t6_p_n8)=0 v(gnd__t7_p_n8)=0 v(gnd__t8_p_n8)=0 v(gnd__t9_p_n8)=0
.ic v(n10_p_n8)=1 v(n10__t0_p_n8)=1 v(n10__t1_p_n8)=1 v(n17_p_n8)=1
.ic v(n17__t0_p_n8)=1 v(n17__t1_p_n8)=1 v(n18_p_n8)=1 v(n18__t0_p_n8)=1
.ic v(n18__t1_p_n8)=1 v(n19_p_n8)=1 v(n19__t0_p_n8)=1 v(n19__t1_p_n8)=1
.ic v(n20_p_n8)=1 v(n20__t0_p_n8)=1 v(n20__t1_p_n8)=1 v(n22_p_n8)=1
.ic v(n22__t0_p_n8)=1 v(n22__t1_p_n8)=1 v(n23_p_n8)=1 v(n23__t0_p_n8)=1
.ic v(n23__t1_p_n8)=1 v(n24_p_n8)=1 v(n24__t0_p_n8)=1 v(n24__t1_p_n8)=1
.ic v(n25_p_n8)=1 v(n25__t0_p_n8)=1 v(n25__t1_p_n8)=1 v(n29_p_n8)=1
.ic v(n29__t0_p_n8)=1 v(n29__t1_p_n8)=1 v(n30_p_n8)=1 v(n30__t0_p_n8)=1
.ic v(n30__t1_p_n8)=1 v(n31_p_n8)=1 v(n31__t0_p_n8)=1 v(n31__t1_p_n8)=1
.ic v(n32_p_n8)=1 v(n32__t0_p_n8)=1 v(n32__t1_p_n8)=1 v(n7_p_n8)=1
.ic v(n7__t0_p_n8)=1 v(n7__t1_p_n8)=1 v(n8_p_n8)=1.1 v(n8__t0_p_n8)=1.1
.ic v(n8__t1_p_n8)=1.1 v(n9_p_n8)=1 v(n9__t0_p_n8)=1 v(n9__t1_p_n8)=1
.ic v(bl_0_p_n8)=0 v(bl_0__t0_p_n8)=0 v(bl_0__t1_p_n8)=0 v(bl_0__t2_p_n8)=0
.ic v(bl_0__t3_p_n8)=0 v(bl_1_p_n8)=0 v(bl_1__t0_p_n8)=0 v(bl_1__t1_p_n8)=0
.ic v(bl_1__t2_p_n8)=0 v(bl_1__t3_p_n8)=0 v(bl_2_p_n8)=0 v(bl_2__t0_p_n8)=0
.ic v(bl_2__t1_p_n8)=0 v(bl_2__t2_p_n8)=0 v(bl_2__t3_p_n8)=0 v(bl_3_p_n8)=0
.ic v(bl_3__t0_p_n8)=0 v(bl_3__t1_p_n8)=0 v(bl_3__t2_p_n8)=0 v(bl_3__t3_p_n8)=0
.ic v(rbl_0_p_n8)=0.9 v(rbl_0__t0_p_n8)=0.9 v(rbl_0__t1_p_n8)=0.9 v(rbl_0__t2_p_n8)=0.9
.ic v(rbl_0__t3_p_n8)=0.9 v(rbl_1_p_n8)=0.9 v(rbl_1__t0_p_n8)=0.9 v(rbl_1__t1_p_n8)=0.9
.ic v(rbl_1__t2_p_n8)=0.9 v(rbl_1__t3_p_n8)=0.9 v(rbl_2_p_n8)=0.9 v(rbl_2__t0_p_n8)=0.9
.ic v(rbl_2__t1_p_n8)=0.9 v(rbl_2__t2_p_n8)=0.9 v(rbl_2__t3_p_n8)=0.9 v(rbl_3_p_n8)=0.9
.ic v(rbl_3__t0_p_n8)=0.9 v(rbl_3__t1_p_n8)=0.9 v(rbl_3__t2_p_n8)=0.9 v(rbl_3__t3_p_n8)=0.9
.ic v(rwl_0_p_n8)=1.8 v(rwl_0__t0_p_n8)=1.8 v(rwl_0__t1_p_n8)=1.8 v(rwl_0__t2_p_n8)=1.8
.ic v(rwl_0__t3_p_n8)=1.8 v(rwl_1_p_n8)=1.8 v(rwl_1__t0_p_n8)=1.8 v(rwl_1__t1_p_n8)=1.8
.ic v(rwl_1__t2_p_n8)=1.8 v(rwl_1__t3_p_n8)=1.8 v(rwl_2_p_n8)=1.8 v(rwl_2__t0_p_n8)=1.8
.ic v(rwl_2__t1_p_n8)=1.8 v(rwl_2__t2_p_n8)=1.8 v(rwl_2__t3_p_n8)=1.8 v(rwl_3_p_n8)=1.8
.ic v(rwl_3__t0_p_n8)=1.8 v(rwl_3__t1_p_n8)=1.8 v(rwl_3__t2_p_n8)=1.8 v(rwl_3__t3_p_n8)=1.8
.ic v(wl_0_p_n8)=0 v(wl_0__t0_p_n8)=0 v(wl_0__t1_p_n8)=0 v(wl_0__t2_p_n8)=0
.ic v(wl_0__t3_p_n8)=0 v(wl_1_p_n8)=0 v(wl_1__t0_p_n8)=0 v(wl_1__t1_p_n8)=0
.ic v(wl_1__t2_p_n8)=0 v(wl_1__t3_p_n8)=0 v(wl_2_p_n8)=0 v(wl_2__t0_p_n8)=0
.ic v(wl_2__t1_p_n8)=0 v(wl_2__t2_p_n8)=0 v(wl_2__t3_p_n8)=0 v(wl_3_p_n8)=0
.ic v(wl_3__t0_p_n8)=0 v(wl_3__t1_p_n8)=0 v(wl_3__t2_p_n8)=0 v(wl_3__t3_p_n8)=0
.ic v(gnd__t0_p_n9)=0 v(gnd__t1_p_n9)=0 v(gnd__t10_p_n9)=0 v(gnd__t11_p_n9)=0
.ic v(gnd__t12_p_n9)=0 v(gnd__t13_p_n9)=0 v(gnd__t14_p_n9)=0 v(gnd__t15_p_n9)=0
.ic v(gnd__t16_p_n9)=0 v(gnd__t17_p_n9)=0 v(gnd__t18_p_n9)=0 v(gnd__t19_p_n9)=0
.ic v(gnd__t2_p_n9)=0 v(gnd__t20_p_n9)=0 v(gnd__t21_p_n9)=0 v(gnd__t22_p_n9)=0
.ic v(gnd__t23_p_n9)=0 v(gnd__t24_p_n9)=0 v(gnd__t25_p_n9)=0 v(gnd__t26_p_n9)=0
.ic v(gnd__t27_p_n9)=0 v(gnd__t28_p_n9)=0 v(gnd__t29_p_n9)=0 v(gnd__t3_p_n9)=0
.ic v(gnd__t30_p_n9)=0 v(gnd__t31_p_n9)=0 v(gnd__t4_p_n9)=0 v(gnd__t5_p_n9)=0
.ic v(gnd__t6_p_n9)=0 v(gnd__t7_p_n9)=0 v(gnd__t8_p_n9)=0 v(gnd__t9_p_n9)=0
.ic v(n10_p_n9)=1 v(n10__t0_p_n9)=1 v(n10__t1_p_n9)=1 v(n17_p_n9)=1
.ic v(n17__t0_p_n9)=1 v(n17__t1_p_n9)=1 v(n18_p_n9)=1 v(n18__t0_p_n9)=1
.ic v(n18__t1_p_n9)=1 v(n19_p_n9)=1 v(n19__t0_p_n9)=1 v(n19__t1_p_n9)=1
.ic v(n20_p_n9)=1 v(n20__t0_p_n9)=1 v(n20__t1_p_n9)=1 v(n22_p_n9)=1
.ic v(n22__t0_p_n9)=1 v(n22__t1_p_n9)=1 v(n23_p_n9)=1 v(n23__t0_p_n9)=1
.ic v(n23__t1_p_n9)=1 v(n24_p_n9)=1 v(n24__t0_p_n9)=1 v(n24__t1_p_n9)=1
.ic v(n25_p_n9)=1 v(n25__t0_p_n9)=1 v(n25__t1_p_n9)=1 v(n29_p_n9)=1
.ic v(n29__t0_p_n9)=1 v(n29__t1_p_n9)=1 v(n30_p_n9)=1 v(n30__t0_p_n9)=1
.ic v(n30__t1_p_n9)=1 v(n31_p_n9)=1 v(n31__t0_p_n9)=1 v(n31__t1_p_n9)=1
.ic v(n32_p_n9)=1 v(n32__t0_p_n9)=1 v(n32__t1_p_n9)=1 v(n7_p_n9)=1
.ic v(n7__t0_p_n9)=1 v(n7__t1_p_n9)=1 v(n8_p_n9)=1 v(n8__t0_p_n9)=1
.ic v(n8__t1_p_n9)=1 v(n9_p_n9)=1.1 v(n9__t0_p_n9)=1.1 v(n9__t1_p_n9)=1.1
.ic v(bl_0_p_n9)=0 v(bl_0__t0_p_n9)=0 v(bl_0__t1_p_n9)=0 v(bl_0__t2_p_n9)=0
.ic v(bl_0__t3_p_n9)=0 v(bl_1_p_n9)=0 v(bl_1__t0_p_n9)=0 v(bl_1__t1_p_n9)=0
.ic v(bl_1__t2_p_n9)=0 v(bl_1__t3_p_n9)=0 v(bl_2_p_n9)=0 v(bl_2__t0_p_n9)=0
.ic v(bl_2__t1_p_n9)=0 v(bl_2__t2_p_n9)=0 v(bl_2__t3_p_n9)=0 v(bl_3_p_n9)=0
.ic v(bl_3__t0_p_n9)=0 v(bl_3__t1_p_n9)=0 v(bl_3__t2_p_n9)=0 v(bl_3__t3_p_n9)=0
.ic v(rbl_0_p_n9)=0.9 v(rbl_0__t0_p_n9)=0.9 v(rbl_0__t1_p_n9)=0.9 v(rbl_0__t2_p_n9)=0.9
.ic v(rbl_0__t3_p_n9)=0.9 v(rbl_1_p_n9)=0.9 v(rbl_1__t0_p_n9)=0.9 v(rbl_1__t1_p_n9)=0.9
.ic v(rbl_1__t2_p_n9)=0.9 v(rbl_1__t3_p_n9)=0.9 v(rbl_2_p_n9)=0.9 v(rbl_2__t0_p_n9)=0.9
.ic v(rbl_2__t1_p_n9)=0.9 v(rbl_2__t2_p_n9)=0.9 v(rbl_2__t3_p_n9)=0.9 v(rbl_3_p_n9)=0.9
.ic v(rbl_3__t0_p_n9)=0.9 v(rbl_3__t1_p_n9)=0.9 v(rbl_3__t2_p_n9)=0.9 v(rbl_3__t3_p_n9)=0.9
.ic v(rwl_0_p_n9)=1.8 v(rwl_0__t0_p_n9)=1.8 v(rwl_0__t1_p_n9)=1.8 v(rwl_0__t2_p_n9)=1.8
.ic v(rwl_0__t3_p_n9)=1.8 v(rwl_1_p_n9)=1.8 v(rwl_1__t0_p_n9)=1.8 v(rwl_1__t1_p_n9)=1.8
.ic v(rwl_1__t2_p_n9)=1.8 v(rwl_1__t3_p_n9)=1.8 v(rwl_2_p_n9)=1.8 v(rwl_2__t0_p_n9)=1.8
.ic v(rwl_2__t1_p_n9)=1.8 v(rwl_2__t2_p_n9)=1.8 v(rwl_2__t3_p_n9)=1.8 v(rwl_3_p_n9)=1.8
.ic v(rwl_3__t0_p_n9)=1.8 v(rwl_3__t1_p_n9)=1.8 v(rwl_3__t2_p_n9)=1.8 v(rwl_3__t3_p_n9)=1.8
.ic v(wl_0_p_n9)=0 v(wl_0__t0_p_n9)=0 v(wl_0__t1_p_n9)=0 v(wl_0__t2_p_n9)=0
.ic v(wl_0__t3_p_n9)=0 v(wl_1_p_n9)=0 v(wl_1__t0_p_n9)=0 v(wl_1__t1_p_n9)=0
.ic v(wl_1__t2_p_n9)=0 v(wl_1__t3_p_n9)=0 v(wl_2_p_n9)=0 v(wl_2__t0_p_n9)=0
.ic v(wl_2__t1_p_n9)=0 v(wl_2__t2_p_n9)=0 v(wl_2__t3_p_n9)=0 v(wl_3_p_n9)=0
.ic v(wl_3__t0_p_n9)=0 v(wl_3__t1_p_n9)=0 v(wl_3__t2_p_n9)=0 v(wl_3__t3_p_n9)=0
.ic v(gnd__t0_p_n10)=0 v(gnd__t1_p_n10)=0 v(gnd__t10_p_n10)=0 v(gnd__t11_p_n10)=0
.ic v(gnd__t12_p_n10)=0 v(gnd__t13_p_n10)=0 v(gnd__t14_p_n10)=0 v(gnd__t15_p_n10)=0
.ic v(gnd__t16_p_n10)=0 v(gnd__t17_p_n10)=0 v(gnd__t18_p_n10)=0 v(gnd__t19_p_n10)=0
.ic v(gnd__t2_p_n10)=0 v(gnd__t20_p_n10)=0 v(gnd__t21_p_n10)=0 v(gnd__t22_p_n10)=0
.ic v(gnd__t23_p_n10)=0 v(gnd__t24_p_n10)=0 v(gnd__t25_p_n10)=0 v(gnd__t26_p_n10)=0
.ic v(gnd__t27_p_n10)=0 v(gnd__t28_p_n10)=0 v(gnd__t29_p_n10)=0 v(gnd__t3_p_n10)=0
.ic v(gnd__t30_p_n10)=0 v(gnd__t31_p_n10)=0 v(gnd__t4_p_n10)=0 v(gnd__t5_p_n10)=0
.ic v(gnd__t6_p_n10)=0 v(gnd__t7_p_n10)=0 v(gnd__t8_p_n10)=0 v(gnd__t9_p_n10)=0
.ic v(n10_p_n10)=1.1 v(n10__t0_p_n10)=1.1 v(n10__t1_p_n10)=1.1 v(n17_p_n10)=1
.ic v(n17__t0_p_n10)=1 v(n17__t1_p_n10)=1 v(n18_p_n10)=1 v(n18__t0_p_n10)=1
.ic v(n18__t1_p_n10)=1 v(n19_p_n10)=1 v(n19__t0_p_n10)=1 v(n19__t1_p_n10)=1
.ic v(n20_p_n10)=1 v(n20__t0_p_n10)=1 v(n20__t1_p_n10)=1 v(n22_p_n10)=1
.ic v(n22__t0_p_n10)=1 v(n22__t1_p_n10)=1 v(n23_p_n10)=1 v(n23__t0_p_n10)=1
.ic v(n23__t1_p_n10)=1 v(n24_p_n10)=1 v(n24__t0_p_n10)=1 v(n24__t1_p_n10)=1
.ic v(n25_p_n10)=1 v(n25__t0_p_n10)=1 v(n25__t1_p_n10)=1 v(n29_p_n10)=1
.ic v(n29__t0_p_n10)=1 v(n29__t1_p_n10)=1 v(n30_p_n10)=1 v(n30__t0_p_n10)=1
.ic v(n30__t1_p_n10)=1 v(n31_p_n10)=1 v(n31__t0_p_n10)=1 v(n31__t1_p_n10)=1
.ic v(n32_p_n10)=1 v(n32__t0_p_n10)=1 v(n32__t1_p_n10)=1 v(n7_p_n10)=1
.ic v(n7__t0_p_n10)=1 v(n7__t1_p_n10)=1 v(n8_p_n10)=1 v(n8__t0_p_n10)=1
.ic v(n8__t1_p_n10)=1 v(n9_p_n10)=1 v(n9__t0_p_n10)=1 v(n9__t1_p_n10)=1
.ic v(bl_0_p_n10)=0 v(bl_0__t0_p_n10)=0 v(bl_0__t1_p_n10)=0 v(bl_0__t2_p_n10)=0
.ic v(bl_0__t3_p_n10)=0 v(bl_1_p_n10)=0 v(bl_1__t0_p_n10)=0 v(bl_1__t1_p_n10)=0
.ic v(bl_1__t2_p_n10)=0 v(bl_1__t3_p_n10)=0 v(bl_2_p_n10)=0 v(bl_2__t0_p_n10)=0
.ic v(bl_2__t1_p_n10)=0 v(bl_2__t2_p_n10)=0 v(bl_2__t3_p_n10)=0 v(bl_3_p_n10)=0
.ic v(bl_3__t0_p_n10)=0 v(bl_3__t1_p_n10)=0 v(bl_3__t2_p_n10)=0 v(bl_3__t3_p_n10)=0
.ic v(rbl_0_p_n10)=0.9 v(rbl_0__t0_p_n10)=0.9 v(rbl_0__t1_p_n10)=0.9 v(rbl_0__t2_p_n10)=0.9
.ic v(rbl_0__t3_p_n10)=0.9 v(rbl_1_p_n10)=0.9 v(rbl_1__t0_p_n10)=0.9 v(rbl_1__t1_p_n10)=0.9
.ic v(rbl_1__t2_p_n10)=0.9 v(rbl_1__t3_p_n10)=0.9 v(rbl_2_p_n10)=0.9 v(rbl_2__t0_p_n10)=0.9
.ic v(rbl_2__t1_p_n10)=0.9 v(rbl_2__t2_p_n10)=0.9 v(rbl_2__t3_p_n10)=0.9 v(rbl_3_p_n10)=0.9
.ic v(rbl_3__t0_p_n10)=0.9 v(rbl_3__t1_p_n10)=0.9 v(rbl_3__t2_p_n10)=0.9 v(rbl_3__t3_p_n10)=0.9
.ic v(rwl_0_p_n10)=1.8 v(rwl_0__t0_p_n10)=1.8 v(rwl_0__t1_p_n10)=1.8 v(rwl_0__t2_p_n10)=1.8
.ic v(rwl_0__t3_p_n10)=1.8 v(rwl_1_p_n10)=1.8 v(rwl_1__t0_p_n10)=1.8 v(rwl_1__t1_p_n10)=1.8
.ic v(rwl_1__t2_p_n10)=1.8 v(rwl_1__t3_p_n10)=1.8 v(rwl_2_p_n10)=1.8 v(rwl_2__t0_p_n10)=1.8
.ic v(rwl_2__t1_p_n10)=1.8 v(rwl_2__t2_p_n10)=1.8 v(rwl_2__t3_p_n10)=1.8 v(rwl_3_p_n10)=1.8
.ic v(rwl_3__t0_p_n10)=1.8 v(rwl_3__t1_p_n10)=1.8 v(rwl_3__t2_p_n10)=1.8 v(rwl_3__t3_p_n10)=1.8
.ic v(wl_0_p_n10)=0 v(wl_0__t0_p_n10)=0 v(wl_0__t1_p_n10)=0 v(wl_0__t2_p_n10)=0
.ic v(wl_0__t3_p_n10)=0 v(wl_1_p_n10)=0 v(wl_1__t0_p_n10)=0 v(wl_1__t1_p_n10)=0
.ic v(wl_1__t2_p_n10)=0 v(wl_1__t3_p_n10)=0 v(wl_2_p_n10)=0 v(wl_2__t0_p_n10)=0
.ic v(wl_2__t1_p_n10)=0 v(wl_2__t2_p_n10)=0 v(wl_2__t3_p_n10)=0 v(wl_3_p_n10)=0
.ic v(wl_3__t0_p_n10)=0 v(wl_3__t1_p_n10)=0 v(wl_3__t2_p_n10)=0 v(wl_3__t3_p_n10)=0
.ic v(gnd__t0_p_n17)=0 v(gnd__t1_p_n17)=0 v(gnd__t10_p_n17)=0 v(gnd__t11_p_n17)=0
.ic v(gnd__t12_p_n17)=0 v(gnd__t13_p_n17)=0 v(gnd__t14_p_n17)=0 v(gnd__t15_p_n17)=0
.ic v(gnd__t16_p_n17)=0 v(gnd__t17_p_n17)=0 v(gnd__t18_p_n17)=0 v(gnd__t19_p_n17)=0
.ic v(gnd__t2_p_n17)=0 v(gnd__t20_p_n17)=0 v(gnd__t21_p_n17)=0 v(gnd__t22_p_n17)=0
.ic v(gnd__t23_p_n17)=0 v(gnd__t24_p_n17)=0 v(gnd__t25_p_n17)=0 v(gnd__t26_p_n17)=0
.ic v(gnd__t27_p_n17)=0 v(gnd__t28_p_n17)=0 v(gnd__t29_p_n17)=0 v(gnd__t3_p_n17)=0
.ic v(gnd__t30_p_n17)=0 v(gnd__t31_p_n17)=0 v(gnd__t4_p_n17)=0 v(gnd__t5_p_n17)=0
.ic v(gnd__t6_p_n17)=0 v(gnd__t7_p_n17)=0 v(gnd__t8_p_n17)=0 v(gnd__t9_p_n17)=0
.ic v(n10_p_n17)=1 v(n10__t0_p_n17)=1 v(n10__t1_p_n17)=1 v(n17_p_n17)=1.1
.ic v(n17__t0_p_n17)=1.1 v(n17__t1_p_n17)=1.1 v(n18_p_n17)=1 v(n18__t0_p_n17)=1
.ic v(n18__t1_p_n17)=1 v(n19_p_n17)=1 v(n19__t0_p_n17)=1 v(n19__t1_p_n17)=1
.ic v(n20_p_n17)=1 v(n20__t0_p_n17)=1 v(n20__t1_p_n17)=1 v(n22_p_n17)=1
.ic v(n22__t0_p_n17)=1 v(n22__t1_p_n17)=1 v(n23_p_n17)=1 v(n23__t0_p_n17)=1
.ic v(n23__t1_p_n17)=1 v(n24_p_n17)=1 v(n24__t0_p_n17)=1 v(n24__t1_p_n17)=1
.ic v(n25_p_n17)=1 v(n25__t0_p_n17)=1 v(n25__t1_p_n17)=1 v(n29_p_n17)=1
.ic v(n29__t0_p_n17)=1 v(n29__t1_p_n17)=1 v(n30_p_n17)=1 v(n30__t0_p_n17)=1
.ic v(n30__t1_p_n17)=1 v(n31_p_n17)=1 v(n31__t0_p_n17)=1 v(n31__t1_p_n17)=1
.ic v(n32_p_n17)=1 v(n32__t0_p_n17)=1 v(n32__t1_p_n17)=1 v(n7_p_n17)=1
.ic v(n7__t0_p_n17)=1 v(n7__t1_p_n17)=1 v(n8_p_n17)=1 v(n8__t0_p_n17)=1
.ic v(n8__t1_p_n17)=1 v(n9_p_n17)=1 v(n9__t0_p_n17)=1 v(n9__t1_p_n17)=1
.ic v(bl_0_p_n17)=0 v(bl_0__t0_p_n17)=0 v(bl_0__t1_p_n17)=0 v(bl_0__t2_p_n17)=0
.ic v(bl_0__t3_p_n17)=0 v(bl_1_p_n17)=0 v(bl_1__t0_p_n17)=0 v(bl_1__t1_p_n17)=0
.ic v(bl_1__t2_p_n17)=0 v(bl_1__t3_p_n17)=0 v(bl_2_p_n17)=0 v(bl_2__t0_p_n17)=0
.ic v(bl_2__t1_p_n17)=0 v(bl_2__t2_p_n17)=0 v(bl_2__t3_p_n17)=0 v(bl_3_p_n17)=0
.ic v(bl_3__t0_p_n17)=0 v(bl_3__t1_p_n17)=0 v(bl_3__t2_p_n17)=0 v(bl_3__t3_p_n17)=0
.ic v(rbl_0_p_n17)=0.9 v(rbl_0__t0_p_n17)=0.9 v(rbl_0__t1_p_n17)=0.9 v(rbl_0__t2_p_n17)=0.9
.ic v(rbl_0__t3_p_n17)=0.9 v(rbl_1_p_n17)=0.9 v(rbl_1__t0_p_n17)=0.9 v(rbl_1__t1_p_n17)=0.9
.ic v(rbl_1__t2_p_n17)=0.9 v(rbl_1__t3_p_n17)=0.9 v(rbl_2_p_n17)=0.9 v(rbl_2__t0_p_n17)=0.9
.ic v(rbl_2__t1_p_n17)=0.9 v(rbl_2__t2_p_n17)=0.9 v(rbl_2__t3_p_n17)=0.9 v(rbl_3_p_n17)=0.9
.ic v(rbl_3__t0_p_n17)=0.9 v(rbl_3__t1_p_n17)=0.9 v(rbl_3__t2_p_n17)=0.9 v(rbl_3__t3_p_n17)=0.9
.ic v(rwl_0_p_n17)=1.8 v(rwl_0__t0_p_n17)=1.8 v(rwl_0__t1_p_n17)=1.8 v(rwl_0__t2_p_n17)=1.8
.ic v(rwl_0__t3_p_n17)=1.8 v(rwl_1_p_n17)=1.8 v(rwl_1__t0_p_n17)=1.8 v(rwl_1__t1_p_n17)=1.8
.ic v(rwl_1__t2_p_n17)=1.8 v(rwl_1__t3_p_n17)=1.8 v(rwl_2_p_n17)=1.8 v(rwl_2__t0_p_n17)=1.8
.ic v(rwl_2__t1_p_n17)=1.8 v(rwl_2__t2_p_n17)=1.8 v(rwl_2__t3_p_n17)=1.8 v(rwl_3_p_n17)=1.8
.ic v(rwl_3__t0_p_n17)=1.8 v(rwl_3__t1_p_n17)=1.8 v(rwl_3__t2_p_n17)=1.8 v(rwl_3__t3_p_n17)=1.8
.ic v(wl_0_p_n17)=0 v(wl_0__t0_p_n17)=0 v(wl_0__t1_p_n17)=0 v(wl_0__t2_p_n17)=0
.ic v(wl_0__t3_p_n17)=0 v(wl_1_p_n17)=0 v(wl_1__t0_p_n17)=0 v(wl_1__t1_p_n17)=0
.ic v(wl_1__t2_p_n17)=0 v(wl_1__t3_p_n17)=0 v(wl_2_p_n17)=0 v(wl_2__t0_p_n17)=0
.ic v(wl_2__t1_p_n17)=0 v(wl_2__t2_p_n17)=0 v(wl_2__t3_p_n17)=0 v(wl_3_p_n17)=0
.ic v(wl_3__t0_p_n17)=0 v(wl_3__t1_p_n17)=0 v(wl_3__t2_p_n17)=0 v(wl_3__t3_p_n17)=0
.ic v(gnd__t0_p_n18)=0 v(gnd__t1_p_n18)=0 v(gnd__t10_p_n18)=0 v(gnd__t11_p_n18)=0
.ic v(gnd__t12_p_n18)=0 v(gnd__t13_p_n18)=0 v(gnd__t14_p_n18)=0 v(gnd__t15_p_n18)=0
.ic v(gnd__t16_p_n18)=0 v(gnd__t17_p_n18)=0 v(gnd__t18_p_n18)=0 v(gnd__t19_p_n18)=0
.ic v(gnd__t2_p_n18)=0 v(gnd__t20_p_n18)=0 v(gnd__t21_p_n18)=0 v(gnd__t22_p_n18)=0
.ic v(gnd__t23_p_n18)=0 v(gnd__t24_p_n18)=0 v(gnd__t25_p_n18)=0 v(gnd__t26_p_n18)=0
.ic v(gnd__t27_p_n18)=0 v(gnd__t28_p_n18)=0 v(gnd__t29_p_n18)=0 v(gnd__t3_p_n18)=0
.ic v(gnd__t30_p_n18)=0 v(gnd__t31_p_n18)=0 v(gnd__t4_p_n18)=0 v(gnd__t5_p_n18)=0
.ic v(gnd__t6_p_n18)=0 v(gnd__t7_p_n18)=0 v(gnd__t8_p_n18)=0 v(gnd__t9_p_n18)=0
.ic v(n10_p_n18)=1 v(n10__t0_p_n18)=1 v(n10__t1_p_n18)=1 v(n17_p_n18)=1
.ic v(n17__t0_p_n18)=1 v(n17__t1_p_n18)=1 v(n18_p_n18)=1.1 v(n18__t0_p_n18)=1.1
.ic v(n18__t1_p_n18)=1.1 v(n19_p_n18)=1 v(n19__t0_p_n18)=1 v(n19__t1_p_n18)=1
.ic v(n20_p_n18)=1 v(n20__t0_p_n18)=1 v(n20__t1_p_n18)=1 v(n22_p_n18)=1
.ic v(n22__t0_p_n18)=1 v(n22__t1_p_n18)=1 v(n23_p_n18)=1 v(n23__t0_p_n18)=1
.ic v(n23__t1_p_n18)=1 v(n24_p_n18)=1 v(n24__t0_p_n18)=1 v(n24__t1_p_n18)=1
.ic v(n25_p_n18)=1 v(n25__t0_p_n18)=1 v(n25__t1_p_n18)=1 v(n29_p_n18)=1
.ic v(n29__t0_p_n18)=1 v(n29__t1_p_n18)=1 v(n30_p_n18)=1 v(n30__t0_p_n18)=1
.ic v(n30__t1_p_n18)=1 v(n31_p_n18)=1 v(n31__t0_p_n18)=1 v(n31__t1_p_n18)=1
.ic v(n32_p_n18)=1 v(n32__t0_p_n18)=1 v(n32__t1_p_n18)=1 v(n7_p_n18)=1
.ic v(n7__t0_p_n18)=1 v(n7__t1_p_n18)=1 v(n8_p_n18)=1 v(n8__t0_p_n18)=1
.ic v(n8__t1_p_n18)=1 v(n9_p_n18)=1 v(n9__t0_p_n18)=1 v(n9__t1_p_n18)=1
.ic v(bl_0_p_n18)=0 v(bl_0__t0_p_n18)=0 v(bl_0__t1_p_n18)=0 v(bl_0__t2_p_n18)=0
.ic v(bl_0__t3_p_n18)=0 v(bl_1_p_n18)=0 v(bl_1__t0_p_n18)=0 v(bl_1__t1_p_n18)=0
.ic v(bl_1__t2_p_n18)=0 v(bl_1__t3_p_n18)=0 v(bl_2_p_n18)=0 v(bl_2__t0_p_n18)=0
.ic v(bl_2__t1_p_n18)=0 v(bl_2__t2_p_n18)=0 v(bl_2__t3_p_n18)=0 v(bl_3_p_n18)=0
.ic v(bl_3__t0_p_n18)=0 v(bl_3__t1_p_n18)=0 v(bl_3__t2_p_n18)=0 v(bl_3__t3_p_n18)=0
.ic v(rbl_0_p_n18)=0.9 v(rbl_0__t0_p_n18)=0.9 v(rbl_0__t1_p_n18)=0.9 v(rbl_0__t2_p_n18)=0.9
.ic v(rbl_0__t3_p_n18)=0.9 v(rbl_1_p_n18)=0.9 v(rbl_1__t0_p_n18)=0.9 v(rbl_1__t1_p_n18)=0.9
.ic v(rbl_1__t2_p_n18)=0.9 v(rbl_1__t3_p_n18)=0.9 v(rbl_2_p_n18)=0.9 v(rbl_2__t0_p_n18)=0.9
.ic v(rbl_2__t1_p_n18)=0.9 v(rbl_2__t2_p_n18)=0.9 v(rbl_2__t3_p_n18)=0.9 v(rbl_3_p_n18)=0.9
.ic v(rbl_3__t0_p_n18)=0.9 v(rbl_3__t1_p_n18)=0.9 v(rbl_3__t2_p_n18)=0.9 v(rbl_3__t3_p_n18)=0.9
.ic v(rwl_0_p_n18)=1.8 v(rwl_0__t0_p_n18)=1.8 v(rwl_0__t1_p_n18)=1.8 v(rwl_0__t2_p_n18)=1.8
.ic v(rwl_0__t3_p_n18)=1.8 v(rwl_1_p_n18)=1.8 v(rwl_1__t0_p_n18)=1.8 v(rwl_1__t1_p_n18)=1.8
.ic v(rwl_1__t2_p_n18)=1.8 v(rwl_1__t3_p_n18)=1.8 v(rwl_2_p_n18)=1.8 v(rwl_2__t0_p_n18)=1.8
.ic v(rwl_2__t1_p_n18)=1.8 v(rwl_2__t2_p_n18)=1.8 v(rwl_2__t3_p_n18)=1.8 v(rwl_3_p_n18)=1.8
.ic v(rwl_3__t0_p_n18)=1.8 v(rwl_3__t1_p_n18)=1.8 v(rwl_3__t2_p_n18)=1.8 v(rwl_3__t3_p_n18)=1.8
.ic v(wl_0_p_n18)=0 v(wl_0__t0_p_n18)=0 v(wl_0__t1_p_n18)=0 v(wl_0__t2_p_n18)=0
.ic v(wl_0__t3_p_n18)=0 v(wl_1_p_n18)=0 v(wl_1__t0_p_n18)=0 v(wl_1__t1_p_n18)=0
.ic v(wl_1__t2_p_n18)=0 v(wl_1__t3_p_n18)=0 v(wl_2_p_n18)=0 v(wl_2__t0_p_n18)=0
.ic v(wl_2__t1_p_n18)=0 v(wl_2__t2_p_n18)=0 v(wl_2__t3_p_n18)=0 v(wl_3_p_n18)=0
.ic v(wl_3__t0_p_n18)=0 v(wl_3__t1_p_n18)=0 v(wl_3__t2_p_n18)=0 v(wl_3__t3_p_n18)=0
.ic v(gnd__t0_p_n19)=0 v(gnd__t1_p_n19)=0 v(gnd__t10_p_n19)=0 v(gnd__t11_p_n19)=0
.ic v(gnd__t12_p_n19)=0 v(gnd__t13_p_n19)=0 v(gnd__t14_p_n19)=0 v(gnd__t15_p_n19)=0
.ic v(gnd__t16_p_n19)=0 v(gnd__t17_p_n19)=0 v(gnd__t18_p_n19)=0 v(gnd__t19_p_n19)=0
.ic v(gnd__t2_p_n19)=0 v(gnd__t20_p_n19)=0 v(gnd__t21_p_n19)=0 v(gnd__t22_p_n19)=0
.ic v(gnd__t23_p_n19)=0 v(gnd__t24_p_n19)=0 v(gnd__t25_p_n19)=0 v(gnd__t26_p_n19)=0
.ic v(gnd__t27_p_n19)=0 v(gnd__t28_p_n19)=0 v(gnd__t29_p_n19)=0 v(gnd__t3_p_n19)=0
.ic v(gnd__t30_p_n19)=0 v(gnd__t31_p_n19)=0 v(gnd__t4_p_n19)=0 v(gnd__t5_p_n19)=0
.ic v(gnd__t6_p_n19)=0 v(gnd__t7_p_n19)=0 v(gnd__t8_p_n19)=0 v(gnd__t9_p_n19)=0
.ic v(n10_p_n19)=1 v(n10__t0_p_n19)=1 v(n10__t1_p_n19)=1 v(n17_p_n19)=1
.ic v(n17__t0_p_n19)=1 v(n17__t1_p_n19)=1 v(n18_p_n19)=1 v(n18__t0_p_n19)=1
.ic v(n18__t1_p_n19)=1 v(n19_p_n19)=1.1 v(n19__t0_p_n19)=1.1 v(n19__t1_p_n19)=1.1
.ic v(n20_p_n19)=1 v(n20__t0_p_n19)=1 v(n20__t1_p_n19)=1 v(n22_p_n19)=1
.ic v(n22__t0_p_n19)=1 v(n22__t1_p_n19)=1 v(n23_p_n19)=1 v(n23__t0_p_n19)=1
.ic v(n23__t1_p_n19)=1 v(n24_p_n19)=1 v(n24__t0_p_n19)=1 v(n24__t1_p_n19)=1
.ic v(n25_p_n19)=1 v(n25__t0_p_n19)=1 v(n25__t1_p_n19)=1 v(n29_p_n19)=1
.ic v(n29__t0_p_n19)=1 v(n29__t1_p_n19)=1 v(n30_p_n19)=1 v(n30__t0_p_n19)=1
.ic v(n30__t1_p_n19)=1 v(n31_p_n19)=1 v(n31__t0_p_n19)=1 v(n31__t1_p_n19)=1
.ic v(n32_p_n19)=1 v(n32__t0_p_n19)=1 v(n32__t1_p_n19)=1 v(n7_p_n19)=1
.ic v(n7__t0_p_n19)=1 v(n7__t1_p_n19)=1 v(n8_p_n19)=1 v(n8__t0_p_n19)=1
.ic v(n8__t1_p_n19)=1 v(n9_p_n19)=1 v(n9__t0_p_n19)=1 v(n9__t1_p_n19)=1
.ic v(bl_0_p_n19)=0 v(bl_0__t0_p_n19)=0 v(bl_0__t1_p_n19)=0 v(bl_0__t2_p_n19)=0
.ic v(bl_0__t3_p_n19)=0 v(bl_1_p_n19)=0 v(bl_1__t0_p_n19)=0 v(bl_1__t1_p_n19)=0
.ic v(bl_1__t2_p_n19)=0 v(bl_1__t3_p_n19)=0 v(bl_2_p_n19)=0 v(bl_2__t0_p_n19)=0
.ic v(bl_2__t1_p_n19)=0 v(bl_2__t2_p_n19)=0 v(bl_2__t3_p_n19)=0 v(bl_3_p_n19)=0
.ic v(bl_3__t0_p_n19)=0 v(bl_3__t1_p_n19)=0 v(bl_3__t2_p_n19)=0 v(bl_3__t3_p_n19)=0
.ic v(rbl_0_p_n19)=0.9 v(rbl_0__t0_p_n19)=0.9 v(rbl_0__t1_p_n19)=0.9 v(rbl_0__t2_p_n19)=0.9
.ic v(rbl_0__t3_p_n19)=0.9 v(rbl_1_p_n19)=0.9 v(rbl_1__t0_p_n19)=0.9 v(rbl_1__t1_p_n19)=0.9
.ic v(rbl_1__t2_p_n19)=0.9 v(rbl_1__t3_p_n19)=0.9 v(rbl_2_p_n19)=0.9 v(rbl_2__t0_p_n19)=0.9
.ic v(rbl_2__t1_p_n19)=0.9 v(rbl_2__t2_p_n19)=0.9 v(rbl_2__t3_p_n19)=0.9 v(rbl_3_p_n19)=0.9
.ic v(rbl_3__t0_p_n19)=0.9 v(rbl_3__t1_p_n19)=0.9 v(rbl_3__t2_p_n19)=0.9 v(rbl_3__t3_p_n19)=0.9
.ic v(rwl_0_p_n19)=1.8 v(rwl_0__t0_p_n19)=1.8 v(rwl_0__t1_p_n19)=1.8 v(rwl_0__t2_p_n19)=1.8
.ic v(rwl_0__t3_p_n19)=1.8 v(rwl_1_p_n19)=1.8 v(rwl_1__t0_p_n19)=1.8 v(rwl_1__t1_p_n19)=1.8
.ic v(rwl_1__t2_p_n19)=1.8 v(rwl_1__t3_p_n19)=1.8 v(rwl_2_p_n19)=1.8 v(rwl_2__t0_p_n19)=1.8
.ic v(rwl_2__t1_p_n19)=1.8 v(rwl_2__t2_p_n19)=1.8 v(rwl_2__t3_p_n19)=1.8 v(rwl_3_p_n19)=1.8
.ic v(rwl_3__t0_p_n19)=1.8 v(rwl_3__t1_p_n19)=1.8 v(rwl_3__t2_p_n19)=1.8 v(rwl_3__t3_p_n19)=1.8
.ic v(wl_0_p_n19)=0 v(wl_0__t0_p_n19)=0 v(wl_0__t1_p_n19)=0 v(wl_0__t2_p_n19)=0
.ic v(wl_0__t3_p_n19)=0 v(wl_1_p_n19)=0 v(wl_1__t0_p_n19)=0 v(wl_1__t1_p_n19)=0
.ic v(wl_1__t2_p_n19)=0 v(wl_1__t3_p_n19)=0 v(wl_2_p_n19)=0 v(wl_2__t0_p_n19)=0
.ic v(wl_2__t1_p_n19)=0 v(wl_2__t2_p_n19)=0 v(wl_2__t3_p_n19)=0 v(wl_3_p_n19)=0
.ic v(wl_3__t0_p_n19)=0 v(wl_3__t1_p_n19)=0 v(wl_3__t2_p_n19)=0 v(wl_3__t3_p_n19)=0
.ic v(gnd__t0_p_n20)=0 v(gnd__t1_p_n20)=0 v(gnd__t10_p_n20)=0 v(gnd__t11_p_n20)=0
.ic v(gnd__t12_p_n20)=0 v(gnd__t13_p_n20)=0 v(gnd__t14_p_n20)=0 v(gnd__t15_p_n20)=0
.ic v(gnd__t16_p_n20)=0 v(gnd__t17_p_n20)=0 v(gnd__t18_p_n20)=0 v(gnd__t19_p_n20)=0
.ic v(gnd__t2_p_n20)=0 v(gnd__t20_p_n20)=0 v(gnd__t21_p_n20)=0 v(gnd__t22_p_n20)=0
.ic v(gnd__t23_p_n20)=0 v(gnd__t24_p_n20)=0 v(gnd__t25_p_n20)=0 v(gnd__t26_p_n20)=0
.ic v(gnd__t27_p_n20)=0 v(gnd__t28_p_n20)=0 v(gnd__t29_p_n20)=0 v(gnd__t3_p_n20)=0
.ic v(gnd__t30_p_n20)=0 v(gnd__t31_p_n20)=0 v(gnd__t4_p_n20)=0 v(gnd__t5_p_n20)=0
.ic v(gnd__t6_p_n20)=0 v(gnd__t7_p_n20)=0 v(gnd__t8_p_n20)=0 v(gnd__t9_p_n20)=0
.ic v(n10_p_n20)=1 v(n10__t0_p_n20)=1 v(n10__t1_p_n20)=1 v(n17_p_n20)=1
.ic v(n17__t0_p_n20)=1 v(n17__t1_p_n20)=1 v(n18_p_n20)=1 v(n18__t0_p_n20)=1
.ic v(n18__t1_p_n20)=1 v(n19_p_n20)=1 v(n19__t0_p_n20)=1 v(n19__t1_p_n20)=1
.ic v(n20_p_n20)=1.1 v(n20__t0_p_n20)=1.1 v(n20__t1_p_n20)=1.1 v(n22_p_n20)=1
.ic v(n22__t0_p_n20)=1 v(n22__t1_p_n20)=1 v(n23_p_n20)=1 v(n23__t0_p_n20)=1
.ic v(n23__t1_p_n20)=1 v(n24_p_n20)=1 v(n24__t0_p_n20)=1 v(n24__t1_p_n20)=1
.ic v(n25_p_n20)=1 v(n25__t0_p_n20)=1 v(n25__t1_p_n20)=1 v(n29_p_n20)=1
.ic v(n29__t0_p_n20)=1 v(n29__t1_p_n20)=1 v(n30_p_n20)=1 v(n30__t0_p_n20)=1
.ic v(n30__t1_p_n20)=1 v(n31_p_n20)=1 v(n31__t0_p_n20)=1 v(n31__t1_p_n20)=1
.ic v(n32_p_n20)=1 v(n32__t0_p_n20)=1 v(n32__t1_p_n20)=1 v(n7_p_n20)=1
.ic v(n7__t0_p_n20)=1 v(n7__t1_p_n20)=1 v(n8_p_n20)=1 v(n8__t0_p_n20)=1
.ic v(n8__t1_p_n20)=1 v(n9_p_n20)=1 v(n9__t0_p_n20)=1 v(n9__t1_p_n20)=1
.ic v(bl_0_p_n20)=0 v(bl_0__t0_p_n20)=0 v(bl_0__t1_p_n20)=0 v(bl_0__t2_p_n20)=0
.ic v(bl_0__t3_p_n20)=0 v(bl_1_p_n20)=0 v(bl_1__t0_p_n20)=0 v(bl_1__t1_p_n20)=0
.ic v(bl_1__t2_p_n20)=0 v(bl_1__t3_p_n20)=0 v(bl_2_p_n20)=0 v(bl_2__t0_p_n20)=0
.ic v(bl_2__t1_p_n20)=0 v(bl_2__t2_p_n20)=0 v(bl_2__t3_p_n20)=0 v(bl_3_p_n20)=0
.ic v(bl_3__t0_p_n20)=0 v(bl_3__t1_p_n20)=0 v(bl_3__t2_p_n20)=0 v(bl_3__t3_p_n20)=0
.ic v(rbl_0_p_n20)=0.9 v(rbl_0__t0_p_n20)=0.9 v(rbl_0__t1_p_n20)=0.9 v(rbl_0__t2_p_n20)=0.9
.ic v(rbl_0__t3_p_n20)=0.9 v(rbl_1_p_n20)=0.9 v(rbl_1__t0_p_n20)=0.9 v(rbl_1__t1_p_n20)=0.9
.ic v(rbl_1__t2_p_n20)=0.9 v(rbl_1__t3_p_n20)=0.9 v(rbl_2_p_n20)=0.9 v(rbl_2__t0_p_n20)=0.9
.ic v(rbl_2__t1_p_n20)=0.9 v(rbl_2__t2_p_n20)=0.9 v(rbl_2__t3_p_n20)=0.9 v(rbl_3_p_n20)=0.9
.ic v(rbl_3__t0_p_n20)=0.9 v(rbl_3__t1_p_n20)=0.9 v(rbl_3__t2_p_n20)=0.9 v(rbl_3__t3_p_n20)=0.9
.ic v(rwl_0_p_n20)=1.8 v(rwl_0__t0_p_n20)=1.8 v(rwl_0__t1_p_n20)=1.8 v(rwl_0__t2_p_n20)=1.8
.ic v(rwl_0__t3_p_n20)=1.8 v(rwl_1_p_n20)=1.8 v(rwl_1__t0_p_n20)=1.8 v(rwl_1__t1_p_n20)=1.8
.ic v(rwl_1__t2_p_n20)=1.8 v(rwl_1__t3_p_n20)=1.8 v(rwl_2_p_n20)=1.8 v(rwl_2__t0_p_n20)=1.8
.ic v(rwl_2__t1_p_n20)=1.8 v(rwl_2__t2_p_n20)=1.8 v(rwl_2__t3_p_n20)=1.8 v(rwl_3_p_n20)=1.8
.ic v(rwl_3__t0_p_n20)=1.8 v(rwl_3__t1_p_n20)=1.8 v(rwl_3__t2_p_n20)=1.8 v(rwl_3__t3_p_n20)=1.8
.ic v(wl_0_p_n20)=0 v(wl_0__t0_p_n20)=0 v(wl_0__t1_p_n20)=0 v(wl_0__t2_p_n20)=0
.ic v(wl_0__t3_p_n20)=0 v(wl_1_p_n20)=0 v(wl_1__t0_p_n20)=0 v(wl_1__t1_p_n20)=0
.ic v(wl_1__t2_p_n20)=0 v(wl_1__t3_p_n20)=0 v(wl_2_p_n20)=0 v(wl_2__t0_p_n20)=0
.ic v(wl_2__t1_p_n20)=0 v(wl_2__t2_p_n20)=0 v(wl_2__t3_p_n20)=0 v(wl_3_p_n20)=0
.ic v(wl_3__t0_p_n20)=0 v(wl_3__t1_p_n20)=0 v(wl_3__t2_p_n20)=0 v(wl_3__t3_p_n20)=0
.ic v(gnd__t0_p_n22)=0 v(gnd__t1_p_n22)=0 v(gnd__t10_p_n22)=0 v(gnd__t11_p_n22)=0
.ic v(gnd__t12_p_n22)=0 v(gnd__t13_p_n22)=0 v(gnd__t14_p_n22)=0 v(gnd__t15_p_n22)=0
.ic v(gnd__t16_p_n22)=0 v(gnd__t17_p_n22)=0 v(gnd__t18_p_n22)=0 v(gnd__t19_p_n22)=0
.ic v(gnd__t2_p_n22)=0 v(gnd__t20_p_n22)=0 v(gnd__t21_p_n22)=0 v(gnd__t22_p_n22)=0
.ic v(gnd__t23_p_n22)=0 v(gnd__t24_p_n22)=0 v(gnd__t25_p_n22)=0 v(gnd__t26_p_n22)=0
.ic v(gnd__t27_p_n22)=0 v(gnd__t28_p_n22)=0 v(gnd__t29_p_n22)=0 v(gnd__t3_p_n22)=0
.ic v(gnd__t30_p_n22)=0 v(gnd__t31_p_n22)=0 v(gnd__t4_p_n22)=0 v(gnd__t5_p_n22)=0
.ic v(gnd__t6_p_n22)=0 v(gnd__t7_p_n22)=0 v(gnd__t8_p_n22)=0 v(gnd__t9_p_n22)=0
.ic v(n10_p_n22)=1 v(n10__t0_p_n22)=1 v(n10__t1_p_n22)=1 v(n17_p_n22)=1
.ic v(n17__t0_p_n22)=1 v(n17__t1_p_n22)=1 v(n18_p_n22)=1 v(n18__t0_p_n22)=1
.ic v(n18__t1_p_n22)=1 v(n19_p_n22)=1 v(n19__t0_p_n22)=1 v(n19__t1_p_n22)=1
.ic v(n20_p_n22)=1 v(n20__t0_p_n22)=1 v(n20__t1_p_n22)=1 v(n22_p_n22)=1.1
.ic v(n22__t0_p_n22)=1.1 v(n22__t1_p_n22)=1.1 v(n23_p_n22)=1 v(n23__t0_p_n22)=1
.ic v(n23__t1_p_n22)=1 v(n24_p_n22)=1 v(n24__t0_p_n22)=1 v(n24__t1_p_n22)=1
.ic v(n25_p_n22)=1 v(n25__t0_p_n22)=1 v(n25__t1_p_n22)=1 v(n29_p_n22)=1
.ic v(n29__t0_p_n22)=1 v(n29__t1_p_n22)=1 v(n30_p_n22)=1 v(n30__t0_p_n22)=1
.ic v(n30__t1_p_n22)=1 v(n31_p_n22)=1 v(n31__t0_p_n22)=1 v(n31__t1_p_n22)=1
.ic v(n32_p_n22)=1 v(n32__t0_p_n22)=1 v(n32__t1_p_n22)=1 v(n7_p_n22)=1
.ic v(n7__t0_p_n22)=1 v(n7__t1_p_n22)=1 v(n8_p_n22)=1 v(n8__t0_p_n22)=1
.ic v(n8__t1_p_n22)=1 v(n9_p_n22)=1 v(n9__t0_p_n22)=1 v(n9__t1_p_n22)=1
.ic v(bl_0_p_n22)=0 v(bl_0__t0_p_n22)=0 v(bl_0__t1_p_n22)=0 v(bl_0__t2_p_n22)=0
.ic v(bl_0__t3_p_n22)=0 v(bl_1_p_n22)=0 v(bl_1__t0_p_n22)=0 v(bl_1__t1_p_n22)=0
.ic v(bl_1__t2_p_n22)=0 v(bl_1__t3_p_n22)=0 v(bl_2_p_n22)=0 v(bl_2__t0_p_n22)=0
.ic v(bl_2__t1_p_n22)=0 v(bl_2__t2_p_n22)=0 v(bl_2__t3_p_n22)=0 v(bl_3_p_n22)=0
.ic v(bl_3__t0_p_n22)=0 v(bl_3__t1_p_n22)=0 v(bl_3__t2_p_n22)=0 v(bl_3__t3_p_n22)=0
.ic v(rbl_0_p_n22)=0.9 v(rbl_0__t0_p_n22)=0.9 v(rbl_0__t1_p_n22)=0.9 v(rbl_0__t2_p_n22)=0.9
.ic v(rbl_0__t3_p_n22)=0.9 v(rbl_1_p_n22)=0.9 v(rbl_1__t0_p_n22)=0.9 v(rbl_1__t1_p_n22)=0.9
.ic v(rbl_1__t2_p_n22)=0.9 v(rbl_1__t3_p_n22)=0.9 v(rbl_2_p_n22)=0.9 v(rbl_2__t0_p_n22)=0.9
.ic v(rbl_2__t1_p_n22)=0.9 v(rbl_2__t2_p_n22)=0.9 v(rbl_2__t3_p_n22)=0.9 v(rbl_3_p_n22)=0.9
.ic v(rbl_3__t0_p_n22)=0.9 v(rbl_3__t1_p_n22)=0.9 v(rbl_3__t2_p_n22)=0.9 v(rbl_3__t3_p_n22)=0.9
.ic v(rwl_0_p_n22)=1.8 v(rwl_0__t0_p_n22)=1.8 v(rwl_0__t1_p_n22)=1.8 v(rwl_0__t2_p_n22)=1.8
.ic v(rwl_0__t3_p_n22)=1.8 v(rwl_1_p_n22)=1.8 v(rwl_1__t0_p_n22)=1.8 v(rwl_1__t1_p_n22)=1.8
.ic v(rwl_1__t2_p_n22)=1.8 v(rwl_1__t3_p_n22)=1.8 v(rwl_2_p_n22)=1.8 v(rwl_2__t0_p_n22)=1.8
.ic v(rwl_2__t1_p_n22)=1.8 v(rwl_2__t2_p_n22)=1.8 v(rwl_2__t3_p_n22)=1.8 v(rwl_3_p_n22)=1.8
.ic v(rwl_3__t0_p_n22)=1.8 v(rwl_3__t1_p_n22)=1.8 v(rwl_3__t2_p_n22)=1.8 v(rwl_3__t3_p_n22)=1.8
.ic v(wl_0_p_n22)=0 v(wl_0__t0_p_n22)=0 v(wl_0__t1_p_n22)=0 v(wl_0__t2_p_n22)=0
.ic v(wl_0__t3_p_n22)=0 v(wl_1_p_n22)=0 v(wl_1__t0_p_n22)=0 v(wl_1__t1_p_n22)=0
.ic v(wl_1__t2_p_n22)=0 v(wl_1__t3_p_n22)=0 v(wl_2_p_n22)=0 v(wl_2__t0_p_n22)=0
.ic v(wl_2__t1_p_n22)=0 v(wl_2__t2_p_n22)=0 v(wl_2__t3_p_n22)=0 v(wl_3_p_n22)=0
.ic v(wl_3__t0_p_n22)=0 v(wl_3__t1_p_n22)=0 v(wl_3__t2_p_n22)=0 v(wl_3__t3_p_n22)=0
.ic v(gnd__t0_p_n23)=0 v(gnd__t1_p_n23)=0 v(gnd__t10_p_n23)=0 v(gnd__t11_p_n23)=0
.ic v(gnd__t12_p_n23)=0 v(gnd__t13_p_n23)=0 v(gnd__t14_p_n23)=0 v(gnd__t15_p_n23)=0
.ic v(gnd__t16_p_n23)=0 v(gnd__t17_p_n23)=0 v(gnd__t18_p_n23)=0 v(gnd__t19_p_n23)=0
.ic v(gnd__t2_p_n23)=0 v(gnd__t20_p_n23)=0 v(gnd__t21_p_n23)=0 v(gnd__t22_p_n23)=0
.ic v(gnd__t23_p_n23)=0 v(gnd__t24_p_n23)=0 v(gnd__t25_p_n23)=0 v(gnd__t26_p_n23)=0
.ic v(gnd__t27_p_n23)=0 v(gnd__t28_p_n23)=0 v(gnd__t29_p_n23)=0 v(gnd__t3_p_n23)=0
.ic v(gnd__t30_p_n23)=0 v(gnd__t31_p_n23)=0 v(gnd__t4_p_n23)=0 v(gnd__t5_p_n23)=0
.ic v(gnd__t6_p_n23)=0 v(gnd__t7_p_n23)=0 v(gnd__t8_p_n23)=0 v(gnd__t9_p_n23)=0
.ic v(n10_p_n23)=1 v(n10__t0_p_n23)=1 v(n10__t1_p_n23)=1 v(n17_p_n23)=1
.ic v(n17__t0_p_n23)=1 v(n17__t1_p_n23)=1 v(n18_p_n23)=1 v(n18__t0_p_n23)=1
.ic v(n18__t1_p_n23)=1 v(n19_p_n23)=1 v(n19__t0_p_n23)=1 v(n19__t1_p_n23)=1
.ic v(n20_p_n23)=1 v(n20__t0_p_n23)=1 v(n20__t1_p_n23)=1 v(n22_p_n23)=1
.ic v(n22__t0_p_n23)=1 v(n22__t1_p_n23)=1 v(n23_p_n23)=1.1 v(n23__t0_p_n23)=1.1
.ic v(n23__t1_p_n23)=1.1 v(n24_p_n23)=1 v(n24__t0_p_n23)=1 v(n24__t1_p_n23)=1
.ic v(n25_p_n23)=1 v(n25__t0_p_n23)=1 v(n25__t1_p_n23)=1 v(n29_p_n23)=1
.ic v(n29__t0_p_n23)=1 v(n29__t1_p_n23)=1 v(n30_p_n23)=1 v(n30__t0_p_n23)=1
.ic v(n30__t1_p_n23)=1 v(n31_p_n23)=1 v(n31__t0_p_n23)=1 v(n31__t1_p_n23)=1
.ic v(n32_p_n23)=1 v(n32__t0_p_n23)=1 v(n32__t1_p_n23)=1 v(n7_p_n23)=1
.ic v(n7__t0_p_n23)=1 v(n7__t1_p_n23)=1 v(n8_p_n23)=1 v(n8__t0_p_n23)=1
.ic v(n8__t1_p_n23)=1 v(n9_p_n23)=1 v(n9__t0_p_n23)=1 v(n9__t1_p_n23)=1
.ic v(bl_0_p_n23)=0 v(bl_0__t0_p_n23)=0 v(bl_0__t1_p_n23)=0 v(bl_0__t2_p_n23)=0
.ic v(bl_0__t3_p_n23)=0 v(bl_1_p_n23)=0 v(bl_1__t0_p_n23)=0 v(bl_1__t1_p_n23)=0
.ic v(bl_1__t2_p_n23)=0 v(bl_1__t3_p_n23)=0 v(bl_2_p_n23)=0 v(bl_2__t0_p_n23)=0
.ic v(bl_2__t1_p_n23)=0 v(bl_2__t2_p_n23)=0 v(bl_2__t3_p_n23)=0 v(bl_3_p_n23)=0
.ic v(bl_3__t0_p_n23)=0 v(bl_3__t1_p_n23)=0 v(bl_3__t2_p_n23)=0 v(bl_3__t3_p_n23)=0
.ic v(rbl_0_p_n23)=0.9 v(rbl_0__t0_p_n23)=0.9 v(rbl_0__t1_p_n23)=0.9 v(rbl_0__t2_p_n23)=0.9
.ic v(rbl_0__t3_p_n23)=0.9 v(rbl_1_p_n23)=0.9 v(rbl_1__t0_p_n23)=0.9 v(rbl_1__t1_p_n23)=0.9
.ic v(rbl_1__t2_p_n23)=0.9 v(rbl_1__t3_p_n23)=0.9 v(rbl_2_p_n23)=0.9 v(rbl_2__t0_p_n23)=0.9
.ic v(rbl_2__t1_p_n23)=0.9 v(rbl_2__t2_p_n23)=0.9 v(rbl_2__t3_p_n23)=0.9 v(rbl_3_p_n23)=0.9
.ic v(rbl_3__t0_p_n23)=0.9 v(rbl_3__t1_p_n23)=0.9 v(rbl_3__t2_p_n23)=0.9 v(rbl_3__t3_p_n23)=0.9
.ic v(rwl_0_p_n23)=1.8 v(rwl_0__t0_p_n23)=1.8 v(rwl_0__t1_p_n23)=1.8 v(rwl_0__t2_p_n23)=1.8
.ic v(rwl_0__t3_p_n23)=1.8 v(rwl_1_p_n23)=1.8 v(rwl_1__t0_p_n23)=1.8 v(rwl_1__t1_p_n23)=1.8
.ic v(rwl_1__t2_p_n23)=1.8 v(rwl_1__t3_p_n23)=1.8 v(rwl_2_p_n23)=1.8 v(rwl_2__t0_p_n23)=1.8
.ic v(rwl_2__t1_p_n23)=1.8 v(rwl_2__t2_p_n23)=1.8 v(rwl_2__t3_p_n23)=1.8 v(rwl_3_p_n23)=1.8
.ic v(rwl_3__t0_p_n23)=1.8 v(rwl_3__t1_p_n23)=1.8 v(rwl_3__t2_p_n23)=1.8 v(rwl_3__t3_p_n23)=1.8
.ic v(wl_0_p_n23)=0 v(wl_0__t0_p_n23)=0 v(wl_0__t1_p_n23)=0 v(wl_0__t2_p_n23)=0
.ic v(wl_0__t3_p_n23)=0 v(wl_1_p_n23)=0 v(wl_1__t0_p_n23)=0 v(wl_1__t1_p_n23)=0
.ic v(wl_1__t2_p_n23)=0 v(wl_1__t3_p_n23)=0 v(wl_2_p_n23)=0 v(wl_2__t0_p_n23)=0
.ic v(wl_2__t1_p_n23)=0 v(wl_2__t2_p_n23)=0 v(wl_2__t3_p_n23)=0 v(wl_3_p_n23)=0
.ic v(wl_3__t0_p_n23)=0 v(wl_3__t1_p_n23)=0 v(wl_3__t2_p_n23)=0 v(wl_3__t3_p_n23)=0
.ic v(gnd__t0_p_n24)=0 v(gnd__t1_p_n24)=0 v(gnd__t10_p_n24)=0 v(gnd__t11_p_n24)=0
.ic v(gnd__t12_p_n24)=0 v(gnd__t13_p_n24)=0 v(gnd__t14_p_n24)=0 v(gnd__t15_p_n24)=0
.ic v(gnd__t16_p_n24)=0 v(gnd__t17_p_n24)=0 v(gnd__t18_p_n24)=0 v(gnd__t19_p_n24)=0
.ic v(gnd__t2_p_n24)=0 v(gnd__t20_p_n24)=0 v(gnd__t21_p_n24)=0 v(gnd__t22_p_n24)=0
.ic v(gnd__t23_p_n24)=0 v(gnd__t24_p_n24)=0 v(gnd__t25_p_n24)=0 v(gnd__t26_p_n24)=0
.ic v(gnd__t27_p_n24)=0 v(gnd__t28_p_n24)=0 v(gnd__t29_p_n24)=0 v(gnd__t3_p_n24)=0
.ic v(gnd__t30_p_n24)=0 v(gnd__t31_p_n24)=0 v(gnd__t4_p_n24)=0 v(gnd__t5_p_n24)=0
.ic v(gnd__t6_p_n24)=0 v(gnd__t7_p_n24)=0 v(gnd__t8_p_n24)=0 v(gnd__t9_p_n24)=0
.ic v(n10_p_n24)=1 v(n10__t0_p_n24)=1 v(n10__t1_p_n24)=1 v(n17_p_n24)=1
.ic v(n17__t0_p_n24)=1 v(n17__t1_p_n24)=1 v(n18_p_n24)=1 v(n18__t0_p_n24)=1
.ic v(n18__t1_p_n24)=1 v(n19_p_n24)=1 v(n19__t0_p_n24)=1 v(n19__t1_p_n24)=1
.ic v(n20_p_n24)=1 v(n20__t0_p_n24)=1 v(n20__t1_p_n24)=1 v(n22_p_n24)=1
.ic v(n22__t0_p_n24)=1 v(n22__t1_p_n24)=1 v(n23_p_n24)=1 v(n23__t0_p_n24)=1
.ic v(n23__t1_p_n24)=1 v(n24_p_n24)=1.1 v(n24__t0_p_n24)=1.1 v(n24__t1_p_n24)=1.1
.ic v(n25_p_n24)=1 v(n25__t0_p_n24)=1 v(n25__t1_p_n24)=1 v(n29_p_n24)=1
.ic v(n29__t0_p_n24)=1 v(n29__t1_p_n24)=1 v(n30_p_n24)=1 v(n30__t0_p_n24)=1
.ic v(n30__t1_p_n24)=1 v(n31_p_n24)=1 v(n31__t0_p_n24)=1 v(n31__t1_p_n24)=1
.ic v(n32_p_n24)=1 v(n32__t0_p_n24)=1 v(n32__t1_p_n24)=1 v(n7_p_n24)=1
.ic v(n7__t0_p_n24)=1 v(n7__t1_p_n24)=1 v(n8_p_n24)=1 v(n8__t0_p_n24)=1
.ic v(n8__t1_p_n24)=1 v(n9_p_n24)=1 v(n9__t0_p_n24)=1 v(n9__t1_p_n24)=1
.ic v(bl_0_p_n24)=0 v(bl_0__t0_p_n24)=0 v(bl_0__t1_p_n24)=0 v(bl_0__t2_p_n24)=0
.ic v(bl_0__t3_p_n24)=0 v(bl_1_p_n24)=0 v(bl_1__t0_p_n24)=0 v(bl_1__t1_p_n24)=0
.ic v(bl_1__t2_p_n24)=0 v(bl_1__t3_p_n24)=0 v(bl_2_p_n24)=0 v(bl_2__t0_p_n24)=0
.ic v(bl_2__t1_p_n24)=0 v(bl_2__t2_p_n24)=0 v(bl_2__t3_p_n24)=0 v(bl_3_p_n24)=0
.ic v(bl_3__t0_p_n24)=0 v(bl_3__t1_p_n24)=0 v(bl_3__t2_p_n24)=0 v(bl_3__t3_p_n24)=0
.ic v(rbl_0_p_n24)=0.9 v(rbl_0__t0_p_n24)=0.9 v(rbl_0__t1_p_n24)=0.9 v(rbl_0__t2_p_n24)=0.9
.ic v(rbl_0__t3_p_n24)=0.9 v(rbl_1_p_n24)=0.9 v(rbl_1__t0_p_n24)=0.9 v(rbl_1__t1_p_n24)=0.9
.ic v(rbl_1__t2_p_n24)=0.9 v(rbl_1__t3_p_n24)=0.9 v(rbl_2_p_n24)=0.9 v(rbl_2__t0_p_n24)=0.9
.ic v(rbl_2__t1_p_n24)=0.9 v(rbl_2__t2_p_n24)=0.9 v(rbl_2__t3_p_n24)=0.9 v(rbl_3_p_n24)=0.9
.ic v(rbl_3__t0_p_n24)=0.9 v(rbl_3__t1_p_n24)=0.9 v(rbl_3__t2_p_n24)=0.9 v(rbl_3__t3_p_n24)=0.9
.ic v(rwl_0_p_n24)=1.8 v(rwl_0__t0_p_n24)=1.8 v(rwl_0__t1_p_n24)=1.8 v(rwl_0__t2_p_n24)=1.8
.ic v(rwl_0__t3_p_n24)=1.8 v(rwl_1_p_n24)=1.8 v(rwl_1__t0_p_n24)=1.8 v(rwl_1__t1_p_n24)=1.8
.ic v(rwl_1__t2_p_n24)=1.8 v(rwl_1__t3_p_n24)=1.8 v(rwl_2_p_n24)=1.8 v(rwl_2__t0_p_n24)=1.8
.ic v(rwl_2__t1_p_n24)=1.8 v(rwl_2__t2_p_n24)=1.8 v(rwl_2__t3_p_n24)=1.8 v(rwl_3_p_n24)=1.8
.ic v(rwl_3__t0_p_n24)=1.8 v(rwl_3__t1_p_n24)=1.8 v(rwl_3__t2_p_n24)=1.8 v(rwl_3__t3_p_n24)=1.8
.ic v(wl_0_p_n24)=0 v(wl_0__t0_p_n24)=0 v(wl_0__t1_p_n24)=0 v(wl_0__t2_p_n24)=0
.ic v(wl_0__t3_p_n24)=0 v(wl_1_p_n24)=0 v(wl_1__t0_p_n24)=0 v(wl_1__t1_p_n24)=0
.ic v(wl_1__t2_p_n24)=0 v(wl_1__t3_p_n24)=0 v(wl_2_p_n24)=0 v(wl_2__t0_p_n24)=0
.ic v(wl_2__t1_p_n24)=0 v(wl_2__t2_p_n24)=0 v(wl_2__t3_p_n24)=0 v(wl_3_p_n24)=0
.ic v(wl_3__t0_p_n24)=0 v(wl_3__t1_p_n24)=0 v(wl_3__t2_p_n24)=0 v(wl_3__t3_p_n24)=0
.ic v(gnd__t0_p_n25)=0 v(gnd__t1_p_n25)=0 v(gnd__t10_p_n25)=0 v(gnd__t11_p_n25)=0
.ic v(gnd__t12_p_n25)=0 v(gnd__t13_p_n25)=0 v(gnd__t14_p_n25)=0 v(gnd__t15_p_n25)=0
.ic v(gnd__t16_p_n25)=0 v(gnd__t17_p_n25)=0 v(gnd__t18_p_n25)=0 v(gnd__t19_p_n25)=0
.ic v(gnd__t2_p_n25)=0 v(gnd__t20_p_n25)=0 v(gnd__t21_p_n25)=0 v(gnd__t22_p_n25)=0
.ic v(gnd__t23_p_n25)=0 v(gnd__t24_p_n25)=0 v(gnd__t25_p_n25)=0 v(gnd__t26_p_n25)=0
.ic v(gnd__t27_p_n25)=0 v(gnd__t28_p_n25)=0 v(gnd__t29_p_n25)=0 v(gnd__t3_p_n25)=0
.ic v(gnd__t30_p_n25)=0 v(gnd__t31_p_n25)=0 v(gnd__t4_p_n25)=0 v(gnd__t5_p_n25)=0
.ic v(gnd__t6_p_n25)=0 v(gnd__t7_p_n25)=0 v(gnd__t8_p_n25)=0 v(gnd__t9_p_n25)=0
.ic v(n10_p_n25)=1 v(n10__t0_p_n25)=1 v(n10__t1_p_n25)=1 v(n17_p_n25)=1
.ic v(n17__t0_p_n25)=1 v(n17__t1_p_n25)=1 v(n18_p_n25)=1 v(n18__t0_p_n25)=1
.ic v(n18__t1_p_n25)=1 v(n19_p_n25)=1 v(n19__t0_p_n25)=1 v(n19__t1_p_n25)=1
.ic v(n20_p_n25)=1 v(n20__t0_p_n25)=1 v(n20__t1_p_n25)=1 v(n22_p_n25)=1
.ic v(n22__t0_p_n25)=1 v(n22__t1_p_n25)=1 v(n23_p_n25)=1 v(n23__t0_p_n25)=1
.ic v(n23__t1_p_n25)=1 v(n24_p_n25)=1 v(n24__t0_p_n25)=1 v(n24__t1_p_n25)=1
.ic v(n25_p_n25)=1.1 v(n25__t0_p_n25)=1.1 v(n25__t1_p_n25)=1.1 v(n29_p_n25)=1
.ic v(n29__t0_p_n25)=1 v(n29__t1_p_n25)=1 v(n30_p_n25)=1 v(n30__t0_p_n25)=1
.ic v(n30__t1_p_n25)=1 v(n31_p_n25)=1 v(n31__t0_p_n25)=1 v(n31__t1_p_n25)=1
.ic v(n32_p_n25)=1 v(n32__t0_p_n25)=1 v(n32__t1_p_n25)=1 v(n7_p_n25)=1
.ic v(n7__t0_p_n25)=1 v(n7__t1_p_n25)=1 v(n8_p_n25)=1 v(n8__t0_p_n25)=1
.ic v(n8__t1_p_n25)=1 v(n9_p_n25)=1 v(n9__t0_p_n25)=1 v(n9__t1_p_n25)=1
.ic v(bl_0_p_n25)=0 v(bl_0__t0_p_n25)=0 v(bl_0__t1_p_n25)=0 v(bl_0__t2_p_n25)=0
.ic v(bl_0__t3_p_n25)=0 v(bl_1_p_n25)=0 v(bl_1__t0_p_n25)=0 v(bl_1__t1_p_n25)=0
.ic v(bl_1__t2_p_n25)=0 v(bl_1__t3_p_n25)=0 v(bl_2_p_n25)=0 v(bl_2__t0_p_n25)=0
.ic v(bl_2__t1_p_n25)=0 v(bl_2__t2_p_n25)=0 v(bl_2__t3_p_n25)=0 v(bl_3_p_n25)=0
.ic v(bl_3__t0_p_n25)=0 v(bl_3__t1_p_n25)=0 v(bl_3__t2_p_n25)=0 v(bl_3__t3_p_n25)=0
.ic v(rbl_0_p_n25)=0.9 v(rbl_0__t0_p_n25)=0.9 v(rbl_0__t1_p_n25)=0.9 v(rbl_0__t2_p_n25)=0.9
.ic v(rbl_0__t3_p_n25)=0.9 v(rbl_1_p_n25)=0.9 v(rbl_1__t0_p_n25)=0.9 v(rbl_1__t1_p_n25)=0.9
.ic v(rbl_1__t2_p_n25)=0.9 v(rbl_1__t3_p_n25)=0.9 v(rbl_2_p_n25)=0.9 v(rbl_2__t0_p_n25)=0.9
.ic v(rbl_2__t1_p_n25)=0.9 v(rbl_2__t2_p_n25)=0.9 v(rbl_2__t3_p_n25)=0.9 v(rbl_3_p_n25)=0.9
.ic v(rbl_3__t0_p_n25)=0.9 v(rbl_3__t1_p_n25)=0.9 v(rbl_3__t2_p_n25)=0.9 v(rbl_3__t3_p_n25)=0.9
.ic v(rwl_0_p_n25)=1.8 v(rwl_0__t0_p_n25)=1.8 v(rwl_0__t1_p_n25)=1.8 v(rwl_0__t2_p_n25)=1.8
.ic v(rwl_0__t3_p_n25)=1.8 v(rwl_1_p_n25)=1.8 v(rwl_1__t0_p_n25)=1.8 v(rwl_1__t1_p_n25)=1.8
.ic v(rwl_1__t2_p_n25)=1.8 v(rwl_1__t3_p_n25)=1.8 v(rwl_2_p_n25)=1.8 v(rwl_2__t0_p_n25)=1.8
.ic v(rwl_2__t1_p_n25)=1.8 v(rwl_2__t2_p_n25)=1.8 v(rwl_2__t3_p_n25)=1.8 v(rwl_3_p_n25)=1.8
.ic v(rwl_3__t0_p_n25)=1.8 v(rwl_3__t1_p_n25)=1.8 v(rwl_3__t2_p_n25)=1.8 v(rwl_3__t3_p_n25)=1.8
.ic v(wl_0_p_n25)=0 v(wl_0__t0_p_n25)=0 v(wl_0__t1_p_n25)=0 v(wl_0__t2_p_n25)=0
.ic v(wl_0__t3_p_n25)=0 v(wl_1_p_n25)=0 v(wl_1__t0_p_n25)=0 v(wl_1__t1_p_n25)=0
.ic v(wl_1__t2_p_n25)=0 v(wl_1__t3_p_n25)=0 v(wl_2_p_n25)=0 v(wl_2__t0_p_n25)=0
.ic v(wl_2__t1_p_n25)=0 v(wl_2__t2_p_n25)=0 v(wl_2__t3_p_n25)=0 v(wl_3_p_n25)=0
.ic v(wl_3__t0_p_n25)=0 v(wl_3__t1_p_n25)=0 v(wl_3__t2_p_n25)=0 v(wl_3__t3_p_n25)=0
.ic v(gnd__t0_p_n29)=0 v(gnd__t1_p_n29)=0 v(gnd__t10_p_n29)=0 v(gnd__t11_p_n29)=0
.ic v(gnd__t12_p_n29)=0 v(gnd__t13_p_n29)=0 v(gnd__t14_p_n29)=0 v(gnd__t15_p_n29)=0
.ic v(gnd__t16_p_n29)=0 v(gnd__t17_p_n29)=0 v(gnd__t18_p_n29)=0 v(gnd__t19_p_n29)=0
.ic v(gnd__t2_p_n29)=0 v(gnd__t20_p_n29)=0 v(gnd__t21_p_n29)=0 v(gnd__t22_p_n29)=0
.ic v(gnd__t23_p_n29)=0 v(gnd__t24_p_n29)=0 v(gnd__t25_p_n29)=0 v(gnd__t26_p_n29)=0
.ic v(gnd__t27_p_n29)=0 v(gnd__t28_p_n29)=0 v(gnd__t29_p_n29)=0 v(gnd__t3_p_n29)=0
.ic v(gnd__t30_p_n29)=0 v(gnd__t31_p_n29)=0 v(gnd__t4_p_n29)=0 v(gnd__t5_p_n29)=0
.ic v(gnd__t6_p_n29)=0 v(gnd__t7_p_n29)=0 v(gnd__t8_p_n29)=0 v(gnd__t9_p_n29)=0
.ic v(n10_p_n29)=1 v(n10__t0_p_n29)=1 v(n10__t1_p_n29)=1 v(n17_p_n29)=1
.ic v(n17__t0_p_n29)=1 v(n17__t1_p_n29)=1 v(n18_p_n29)=1 v(n18__t0_p_n29)=1
.ic v(n18__t1_p_n29)=1 v(n19_p_n29)=1 v(n19__t0_p_n29)=1 v(n19__t1_p_n29)=1
.ic v(n20_p_n29)=1 v(n20__t0_p_n29)=1 v(n20__t1_p_n29)=1 v(n22_p_n29)=1
.ic v(n22__t0_p_n29)=1 v(n22__t1_p_n29)=1 v(n23_p_n29)=1 v(n23__t0_p_n29)=1
.ic v(n23__t1_p_n29)=1 v(n24_p_n29)=1 v(n24__t0_p_n29)=1 v(n24__t1_p_n29)=1
.ic v(n25_p_n29)=1 v(n25__t0_p_n29)=1 v(n25__t1_p_n29)=1 v(n29_p_n29)=1.1
.ic v(n29__t0_p_n29)=1.1 v(n29__t1_p_n29)=1.1 v(n30_p_n29)=1 v(n30__t0_p_n29)=1
.ic v(n30__t1_p_n29)=1 v(n31_p_n29)=1 v(n31__t0_p_n29)=1 v(n31__t1_p_n29)=1
.ic v(n32_p_n29)=1 v(n32__t0_p_n29)=1 v(n32__t1_p_n29)=1 v(n7_p_n29)=1
.ic v(n7__t0_p_n29)=1 v(n7__t1_p_n29)=1 v(n8_p_n29)=1 v(n8__t0_p_n29)=1
.ic v(n8__t1_p_n29)=1 v(n9_p_n29)=1 v(n9__t0_p_n29)=1 v(n9__t1_p_n29)=1
.ic v(bl_0_p_n29)=0 v(bl_0__t0_p_n29)=0 v(bl_0__t1_p_n29)=0 v(bl_0__t2_p_n29)=0
.ic v(bl_0__t3_p_n29)=0 v(bl_1_p_n29)=0 v(bl_1__t0_p_n29)=0 v(bl_1__t1_p_n29)=0
.ic v(bl_1__t2_p_n29)=0 v(bl_1__t3_p_n29)=0 v(bl_2_p_n29)=0 v(bl_2__t0_p_n29)=0
.ic v(bl_2__t1_p_n29)=0 v(bl_2__t2_p_n29)=0 v(bl_2__t3_p_n29)=0 v(bl_3_p_n29)=0
.ic v(bl_3__t0_p_n29)=0 v(bl_3__t1_p_n29)=0 v(bl_3__t2_p_n29)=0 v(bl_3__t3_p_n29)=0
.ic v(rbl_0_p_n29)=0.9 v(rbl_0__t0_p_n29)=0.9 v(rbl_0__t1_p_n29)=0.9 v(rbl_0__t2_p_n29)=0.9
.ic v(rbl_0__t3_p_n29)=0.9 v(rbl_1_p_n29)=0.9 v(rbl_1__t0_p_n29)=0.9 v(rbl_1__t1_p_n29)=0.9
.ic v(rbl_1__t2_p_n29)=0.9 v(rbl_1__t3_p_n29)=0.9 v(rbl_2_p_n29)=0.9 v(rbl_2__t0_p_n29)=0.9
.ic v(rbl_2__t1_p_n29)=0.9 v(rbl_2__t2_p_n29)=0.9 v(rbl_2__t3_p_n29)=0.9 v(rbl_3_p_n29)=0.9
.ic v(rbl_3__t0_p_n29)=0.9 v(rbl_3__t1_p_n29)=0.9 v(rbl_3__t2_p_n29)=0.9 v(rbl_3__t3_p_n29)=0.9
.ic v(rwl_0_p_n29)=1.8 v(rwl_0__t0_p_n29)=1.8 v(rwl_0__t1_p_n29)=1.8 v(rwl_0__t2_p_n29)=1.8
.ic v(rwl_0__t3_p_n29)=1.8 v(rwl_1_p_n29)=1.8 v(rwl_1__t0_p_n29)=1.8 v(rwl_1__t1_p_n29)=1.8
.ic v(rwl_1__t2_p_n29)=1.8 v(rwl_1__t3_p_n29)=1.8 v(rwl_2_p_n29)=1.8 v(rwl_2__t0_p_n29)=1.8
.ic v(rwl_2__t1_p_n29)=1.8 v(rwl_2__t2_p_n29)=1.8 v(rwl_2__t3_p_n29)=1.8 v(rwl_3_p_n29)=1.8
.ic v(rwl_3__t0_p_n29)=1.8 v(rwl_3__t1_p_n29)=1.8 v(rwl_3__t2_p_n29)=1.8 v(rwl_3__t3_p_n29)=1.8
.ic v(wl_0_p_n29)=0 v(wl_0__t0_p_n29)=0 v(wl_0__t1_p_n29)=0 v(wl_0__t2_p_n29)=0
.ic v(wl_0__t3_p_n29)=0 v(wl_1_p_n29)=0 v(wl_1__t0_p_n29)=0 v(wl_1__t1_p_n29)=0
.ic v(wl_1__t2_p_n29)=0 v(wl_1__t3_p_n29)=0 v(wl_2_p_n29)=0 v(wl_2__t0_p_n29)=0
.ic v(wl_2__t1_p_n29)=0 v(wl_2__t2_p_n29)=0 v(wl_2__t3_p_n29)=0 v(wl_3_p_n29)=0
.ic v(wl_3__t0_p_n29)=0 v(wl_3__t1_p_n29)=0 v(wl_3__t2_p_n29)=0 v(wl_3__t3_p_n29)=0
.ic v(gnd__t0_p_n30)=0 v(gnd__t1_p_n30)=0 v(gnd__t10_p_n30)=0 v(gnd__t11_p_n30)=0
.ic v(gnd__t12_p_n30)=0 v(gnd__t13_p_n30)=0 v(gnd__t14_p_n30)=0 v(gnd__t15_p_n30)=0
.ic v(gnd__t16_p_n30)=0 v(gnd__t17_p_n30)=0 v(gnd__t18_p_n30)=0 v(gnd__t19_p_n30)=0
.ic v(gnd__t2_p_n30)=0 v(gnd__t20_p_n30)=0 v(gnd__t21_p_n30)=0 v(gnd__t22_p_n30)=0
.ic v(gnd__t23_p_n30)=0 v(gnd__t24_p_n30)=0 v(gnd__t25_p_n30)=0 v(gnd__t26_p_n30)=0
.ic v(gnd__t27_p_n30)=0 v(gnd__t28_p_n30)=0 v(gnd__t29_p_n30)=0 v(gnd__t3_p_n30)=0
.ic v(gnd__t30_p_n30)=0 v(gnd__t31_p_n30)=0 v(gnd__t4_p_n30)=0 v(gnd__t5_p_n30)=0
.ic v(gnd__t6_p_n30)=0 v(gnd__t7_p_n30)=0 v(gnd__t8_p_n30)=0 v(gnd__t9_p_n30)=0
.ic v(n10_p_n30)=1 v(n10__t0_p_n30)=1 v(n10__t1_p_n30)=1 v(n17_p_n30)=1
.ic v(n17__t0_p_n30)=1 v(n17__t1_p_n30)=1 v(n18_p_n30)=1 v(n18__t0_p_n30)=1
.ic v(n18__t1_p_n30)=1 v(n19_p_n30)=1 v(n19__t0_p_n30)=1 v(n19__t1_p_n30)=1
.ic v(n20_p_n30)=1 v(n20__t0_p_n30)=1 v(n20__t1_p_n30)=1 v(n22_p_n30)=1
.ic v(n22__t0_p_n30)=1 v(n22__t1_p_n30)=1 v(n23_p_n30)=1 v(n23__t0_p_n30)=1
.ic v(n23__t1_p_n30)=1 v(n24_p_n30)=1 v(n24__t0_p_n30)=1 v(n24__t1_p_n30)=1
.ic v(n25_p_n30)=1 v(n25__t0_p_n30)=1 v(n25__t1_p_n30)=1 v(n29_p_n30)=1
.ic v(n29__t0_p_n30)=1 v(n29__t1_p_n30)=1 v(n30_p_n30)=1.1 v(n30__t0_p_n30)=1.1
.ic v(n30__t1_p_n30)=1.1 v(n31_p_n30)=1 v(n31__t0_p_n30)=1 v(n31__t1_p_n30)=1
.ic v(n32_p_n30)=1 v(n32__t0_p_n30)=1 v(n32__t1_p_n30)=1 v(n7_p_n30)=1
.ic v(n7__t0_p_n30)=1 v(n7__t1_p_n30)=1 v(n8_p_n30)=1 v(n8__t0_p_n30)=1
.ic v(n8__t1_p_n30)=1 v(n9_p_n30)=1 v(n9__t0_p_n30)=1 v(n9__t1_p_n30)=1
.ic v(bl_0_p_n30)=0 v(bl_0__t0_p_n30)=0 v(bl_0__t1_p_n30)=0 v(bl_0__t2_p_n30)=0
.ic v(bl_0__t3_p_n30)=0 v(bl_1_p_n30)=0 v(bl_1__t0_p_n30)=0 v(bl_1__t1_p_n30)=0
.ic v(bl_1__t2_p_n30)=0 v(bl_1__t3_p_n30)=0 v(bl_2_p_n30)=0 v(bl_2__t0_p_n30)=0
.ic v(bl_2__t1_p_n30)=0 v(bl_2__t2_p_n30)=0 v(bl_2__t3_p_n30)=0 v(bl_3_p_n30)=0
.ic v(bl_3__t0_p_n30)=0 v(bl_3__t1_p_n30)=0 v(bl_3__t2_p_n30)=0 v(bl_3__t3_p_n30)=0
.ic v(rbl_0_p_n30)=0.9 v(rbl_0__t0_p_n30)=0.9 v(rbl_0__t1_p_n30)=0.9 v(rbl_0__t2_p_n30)=0.9
.ic v(rbl_0__t3_p_n30)=0.9 v(rbl_1_p_n30)=0.9 v(rbl_1__t0_p_n30)=0.9 v(rbl_1__t1_p_n30)=0.9
.ic v(rbl_1__t2_p_n30)=0.9 v(rbl_1__t3_p_n30)=0.9 v(rbl_2_p_n30)=0.9 v(rbl_2__t0_p_n30)=0.9
.ic v(rbl_2__t1_p_n30)=0.9 v(rbl_2__t2_p_n30)=0.9 v(rbl_2__t3_p_n30)=0.9 v(rbl_3_p_n30)=0.9
.ic v(rbl_3__t0_p_n30)=0.9 v(rbl_3__t1_p_n30)=0.9 v(rbl_3__t2_p_n30)=0.9 v(rbl_3__t3_p_n30)=0.9
.ic v(rwl_0_p_n30)=1.8 v(rwl_0__t0_p_n30)=1.8 v(rwl_0__t1_p_n30)=1.8 v(rwl_0__t2_p_n30)=1.8
.ic v(rwl_0__t3_p_n30)=1.8 v(rwl_1_p_n30)=1.8 v(rwl_1__t0_p_n30)=1.8 v(rwl_1__t1_p_n30)=1.8
.ic v(rwl_1__t2_p_n30)=1.8 v(rwl_1__t3_p_n30)=1.8 v(rwl_2_p_n30)=1.8 v(rwl_2__t0_p_n30)=1.8
.ic v(rwl_2__t1_p_n30)=1.8 v(rwl_2__t2_p_n30)=1.8 v(rwl_2__t3_p_n30)=1.8 v(rwl_3_p_n30)=1.8
.ic v(rwl_3__t0_p_n30)=1.8 v(rwl_3__t1_p_n30)=1.8 v(rwl_3__t2_p_n30)=1.8 v(rwl_3__t3_p_n30)=1.8
.ic v(wl_0_p_n30)=0 v(wl_0__t0_p_n30)=0 v(wl_0__t1_p_n30)=0 v(wl_0__t2_p_n30)=0
.ic v(wl_0__t3_p_n30)=0 v(wl_1_p_n30)=0 v(wl_1__t0_p_n30)=0 v(wl_1__t1_p_n30)=0
.ic v(wl_1__t2_p_n30)=0 v(wl_1__t3_p_n30)=0 v(wl_2_p_n30)=0 v(wl_2__t0_p_n30)=0
.ic v(wl_2__t1_p_n30)=0 v(wl_2__t2_p_n30)=0 v(wl_2__t3_p_n30)=0 v(wl_3_p_n30)=0
.ic v(wl_3__t0_p_n30)=0 v(wl_3__t1_p_n30)=0 v(wl_3__t2_p_n30)=0 v(wl_3__t3_p_n30)=0
.ic v(gnd__t0_p_n31)=0 v(gnd__t1_p_n31)=0 v(gnd__t10_p_n31)=0 v(gnd__t11_p_n31)=0
.ic v(gnd__t12_p_n31)=0 v(gnd__t13_p_n31)=0 v(gnd__t14_p_n31)=0 v(gnd__t15_p_n31)=0
.ic v(gnd__t16_p_n31)=0 v(gnd__t17_p_n31)=0 v(gnd__t18_p_n31)=0 v(gnd__t19_p_n31)=0
.ic v(gnd__t2_p_n31)=0 v(gnd__t20_p_n31)=0 v(gnd__t21_p_n31)=0 v(gnd__t22_p_n31)=0
.ic v(gnd__t23_p_n31)=0 v(gnd__t24_p_n31)=0 v(gnd__t25_p_n31)=0 v(gnd__t26_p_n31)=0
.ic v(gnd__t27_p_n31)=0 v(gnd__t28_p_n31)=0 v(gnd__t29_p_n31)=0 v(gnd__t3_p_n31)=0
.ic v(gnd__t30_p_n31)=0 v(gnd__t31_p_n31)=0 v(gnd__t4_p_n31)=0 v(gnd__t5_p_n31)=0
.ic v(gnd__t6_p_n31)=0 v(gnd__t7_p_n31)=0 v(gnd__t8_p_n31)=0 v(gnd__t9_p_n31)=0
.ic v(n10_p_n31)=1 v(n10__t0_p_n31)=1 v(n10__t1_p_n31)=1 v(n17_p_n31)=1
.ic v(n17__t0_p_n31)=1 v(n17__t1_p_n31)=1 v(n18_p_n31)=1 v(n18__t0_p_n31)=1
.ic v(n18__t1_p_n31)=1 v(n19_p_n31)=1 v(n19__t0_p_n31)=1 v(n19__t1_p_n31)=1
.ic v(n20_p_n31)=1 v(n20__t0_p_n31)=1 v(n20__t1_p_n31)=1 v(n22_p_n31)=1
.ic v(n22__t0_p_n31)=1 v(n22__t1_p_n31)=1 v(n23_p_n31)=1 v(n23__t0_p_n31)=1
.ic v(n23__t1_p_n31)=1 v(n24_p_n31)=1 v(n24__t0_p_n31)=1 v(n24__t1_p_n31)=1
.ic v(n25_p_n31)=1 v(n25__t0_p_n31)=1 v(n25__t1_p_n31)=1 v(n29_p_n31)=1
.ic v(n29__t0_p_n31)=1 v(n29__t1_p_n31)=1 v(n30_p_n31)=1 v(n30__t0_p_n31)=1
.ic v(n30__t1_p_n31)=1 v(n31_p_n31)=1.1 v(n31__t0_p_n31)=1.1 v(n31__t1_p_n31)=1.1
.ic v(n32_p_n31)=1 v(n32__t0_p_n31)=1 v(n32__t1_p_n31)=1 v(n7_p_n31)=1
.ic v(n7__t0_p_n31)=1 v(n7__t1_p_n31)=1 v(n8_p_n31)=1 v(n8__t0_p_n31)=1
.ic v(n8__t1_p_n31)=1 v(n9_p_n31)=1 v(n9__t0_p_n31)=1 v(n9__t1_p_n31)=1
.ic v(bl_0_p_n31)=0 v(bl_0__t0_p_n31)=0 v(bl_0__t1_p_n31)=0 v(bl_0__t2_p_n31)=0
.ic v(bl_0__t3_p_n31)=0 v(bl_1_p_n31)=0 v(bl_1__t0_p_n31)=0 v(bl_1__t1_p_n31)=0
.ic v(bl_1__t2_p_n31)=0 v(bl_1__t3_p_n31)=0 v(bl_2_p_n31)=0 v(bl_2__t0_p_n31)=0
.ic v(bl_2__t1_p_n31)=0 v(bl_2__t2_p_n31)=0 v(bl_2__t3_p_n31)=0 v(bl_3_p_n31)=0
.ic v(bl_3__t0_p_n31)=0 v(bl_3__t1_p_n31)=0 v(bl_3__t2_p_n31)=0 v(bl_3__t3_p_n31)=0
.ic v(rbl_0_p_n31)=0.9 v(rbl_0__t0_p_n31)=0.9 v(rbl_0__t1_p_n31)=0.9 v(rbl_0__t2_p_n31)=0.9
.ic v(rbl_0__t3_p_n31)=0.9 v(rbl_1_p_n31)=0.9 v(rbl_1__t0_p_n31)=0.9 v(rbl_1__t1_p_n31)=0.9
.ic v(rbl_1__t2_p_n31)=0.9 v(rbl_1__t3_p_n31)=0.9 v(rbl_2_p_n31)=0.9 v(rbl_2__t0_p_n31)=0.9
.ic v(rbl_2__t1_p_n31)=0.9 v(rbl_2__t2_p_n31)=0.9 v(rbl_2__t3_p_n31)=0.9 v(rbl_3_p_n31)=0.9
.ic v(rbl_3__t0_p_n31)=0.9 v(rbl_3__t1_p_n31)=0.9 v(rbl_3__t2_p_n31)=0.9 v(rbl_3__t3_p_n31)=0.9
.ic v(rwl_0_p_n31)=1.8 v(rwl_0__t0_p_n31)=1.8 v(rwl_0__t1_p_n31)=1.8 v(rwl_0__t2_p_n31)=1.8
.ic v(rwl_0__t3_p_n31)=1.8 v(rwl_1_p_n31)=1.8 v(rwl_1__t0_p_n31)=1.8 v(rwl_1__t1_p_n31)=1.8
.ic v(rwl_1__t2_p_n31)=1.8 v(rwl_1__t3_p_n31)=1.8 v(rwl_2_p_n31)=1.8 v(rwl_2__t0_p_n31)=1.8
.ic v(rwl_2__t1_p_n31)=1.8 v(rwl_2__t2_p_n31)=1.8 v(rwl_2__t3_p_n31)=1.8 v(rwl_3_p_n31)=1.8
.ic v(rwl_3__t0_p_n31)=1.8 v(rwl_3__t1_p_n31)=1.8 v(rwl_3__t2_p_n31)=1.8 v(rwl_3__t3_p_n31)=1.8
.ic v(wl_0_p_n31)=0 v(wl_0__t0_p_n31)=0 v(wl_0__t1_p_n31)=0 v(wl_0__t2_p_n31)=0
.ic v(wl_0__t3_p_n31)=0 v(wl_1_p_n31)=0 v(wl_1__t0_p_n31)=0 v(wl_1__t1_p_n31)=0
.ic v(wl_1__t2_p_n31)=0 v(wl_1__t3_p_n31)=0 v(wl_2_p_n31)=0 v(wl_2__t0_p_n31)=0
.ic v(wl_2__t1_p_n31)=0 v(wl_2__t2_p_n31)=0 v(wl_2__t3_p_n31)=0 v(wl_3_p_n31)=0
.ic v(wl_3__t0_p_n31)=0 v(wl_3__t1_p_n31)=0 v(wl_3__t2_p_n31)=0 v(wl_3__t3_p_n31)=0
.ic v(gnd__t0_p_n32)=0 v(gnd__t1_p_n32)=0 v(gnd__t10_p_n32)=0 v(gnd__t11_p_n32)=0
.ic v(gnd__t12_p_n32)=0 v(gnd__t13_p_n32)=0 v(gnd__t14_p_n32)=0 v(gnd__t15_p_n32)=0
.ic v(gnd__t16_p_n32)=0 v(gnd__t17_p_n32)=0 v(gnd__t18_p_n32)=0 v(gnd__t19_p_n32)=0
.ic v(gnd__t2_p_n32)=0 v(gnd__t20_p_n32)=0 v(gnd__t21_p_n32)=0 v(gnd__t22_p_n32)=0
.ic v(gnd__t23_p_n32)=0 v(gnd__t24_p_n32)=0 v(gnd__t25_p_n32)=0 v(gnd__t26_p_n32)=0
.ic v(gnd__t27_p_n32)=0 v(gnd__t28_p_n32)=0 v(gnd__t29_p_n32)=0 v(gnd__t3_p_n32)=0
.ic v(gnd__t30_p_n32)=0 v(gnd__t31_p_n32)=0 v(gnd__t4_p_n32)=0 v(gnd__t5_p_n32)=0
.ic v(gnd__t6_p_n32)=0 v(gnd__t7_p_n32)=0 v(gnd__t8_p_n32)=0 v(gnd__t9_p_n32)=0
.ic v(n10_p_n32)=1 v(n10__t0_p_n32)=1 v(n10__t1_p_n32)=1 v(n17_p_n32)=1
.ic v(n17__t0_p_n32)=1 v(n17__t1_p_n32)=1 v(n18_p_n32)=1 v(n18__t0_p_n32)=1
.ic v(n18__t1_p_n32)=1 v(n19_p_n32)=1 v(n19__t0_p_n32)=1 v(n19__t1_p_n32)=1
.ic v(n20_p_n32)=1 v(n20__t0_p_n32)=1 v(n20__t1_p_n32)=1 v(n22_p_n32)=1
.ic v(n22__t0_p_n32)=1 v(n22__t1_p_n32)=1 v(n23_p_n32)=1 v(n23__t0_p_n32)=1
.ic v(n23__t1_p_n32)=1 v(n24_p_n32)=1 v(n24__t0_p_n32)=1 v(n24__t1_p_n32)=1
.ic v(n25_p_n32)=1 v(n25__t0_p_n32)=1 v(n25__t1_p_n32)=1 v(n29_p_n32)=1
.ic v(n29__t0_p_n32)=1 v(n29__t1_p_n32)=1 v(n30_p_n32)=1 v(n30__t0_p_n32)=1
.ic v(n30__t1_p_n32)=1 v(n31_p_n32)=1 v(n31__t0_p_n32)=1 v(n31__t1_p_n32)=1
.ic v(n32_p_n32)=1.1 v(n32__t0_p_n32)=1.1 v(n32__t1_p_n32)=1.1 v(n7_p_n32)=1
.ic v(n7__t0_p_n32)=1 v(n7__t1_p_n32)=1 v(n8_p_n32)=1 v(n8__t0_p_n32)=1
.ic v(n8__t1_p_n32)=1 v(n9_p_n32)=1 v(n9__t0_p_n32)=1 v(n9__t1_p_n32)=1
.ic v(bl_0_p_n32)=0 v(bl_0__t0_p_n32)=0 v(bl_0__t1_p_n32)=0 v(bl_0__t2_p_n32)=0
.ic v(bl_0__t3_p_n32)=0 v(bl_1_p_n32)=0 v(bl_1__t0_p_n32)=0 v(bl_1__t1_p_n32)=0
.ic v(bl_1__t2_p_n32)=0 v(bl_1__t3_p_n32)=0 v(bl_2_p_n32)=0 v(bl_2__t0_p_n32)=0
.ic v(bl_2__t1_p_n32)=0 v(bl_2__t2_p_n32)=0 v(bl_2__t3_p_n32)=0 v(bl_3_p_n32)=0
.ic v(bl_3__t0_p_n32)=0 v(bl_3__t1_p_n32)=0 v(bl_3__t2_p_n32)=0 v(bl_3__t3_p_n32)=0
.ic v(rbl_0_p_n32)=0.9 v(rbl_0__t0_p_n32)=0.9 v(rbl_0__t1_p_n32)=0.9 v(rbl_0__t2_p_n32)=0.9
.ic v(rbl_0__t3_p_n32)=0.9 v(rbl_1_p_n32)=0.9 v(rbl_1__t0_p_n32)=0.9 v(rbl_1__t1_p_n32)=0.9
.ic v(rbl_1__t2_p_n32)=0.9 v(rbl_1__t3_p_n32)=0.9 v(rbl_2_p_n32)=0.9 v(rbl_2__t0_p_n32)=0.9
.ic v(rbl_2__t1_p_n32)=0.9 v(rbl_2__t2_p_n32)=0.9 v(rbl_2__t3_p_n32)=0.9 v(rbl_3_p_n32)=0.9
.ic v(rbl_3__t0_p_n32)=0.9 v(rbl_3__t1_p_n32)=0.9 v(rbl_3__t2_p_n32)=0.9 v(rbl_3__t3_p_n32)=0.9
.ic v(rwl_0_p_n32)=1.8 v(rwl_0__t0_p_n32)=1.8 v(rwl_0__t1_p_n32)=1.8 v(rwl_0__t2_p_n32)=1.8
.ic v(rwl_0__t3_p_n32)=1.8 v(rwl_1_p_n32)=1.8 v(rwl_1__t0_p_n32)=1.8 v(rwl_1__t1_p_n32)=1.8
.ic v(rwl_1__t2_p_n32)=1.8 v(rwl_1__t3_p_n32)=1.8 v(rwl_2_p_n32)=1.8 v(rwl_2__t0_p_n32)=1.8
.ic v(rwl_2__t1_p_n32)=1.8 v(rwl_2__t2_p_n32)=1.8 v(rwl_2__t3_p_n32)=1.8 v(rwl_3_p_n32)=1.8
.ic v(rwl_3__t0_p_n32)=1.8 v(rwl_3__t1_p_n32)=1.8 v(rwl_3__t2_p_n32)=1.8 v(rwl_3__t3_p_n32)=1.8
.ic v(wl_0_p_n32)=0 v(wl_0__t0_p_n32)=0 v(wl_0__t1_p_n32)=0 v(wl_0__t2_p_n32)=0
.ic v(wl_0__t3_p_n32)=0 v(wl_1_p_n32)=0 v(wl_1__t0_p_n32)=0 v(wl_1__t1_p_n32)=0
.ic v(wl_1__t2_p_n32)=0 v(wl_1__t3_p_n32)=0 v(wl_2_p_n32)=0 v(wl_2__t0_p_n32)=0
.ic v(wl_2__t1_p_n32)=0 v(wl_2__t2_p_n32)=0 v(wl_2__t3_p_n32)=0 v(wl_3_p_n32)=0
.ic v(wl_3__t0_p_n32)=0 v(wl_3__t1_p_n32)=0 v(wl_3__t2_p_n32)=0 v(wl_3__t3_p_n32)=0
.ic v(gnd__t0_b_n7)=0 v(gnd__t1_b_n7)=0 v(gnd__t10_b_n7)=0 v(gnd__t11_b_n7)=0
.ic v(gnd__t12_b_n7)=0 v(gnd__t13_b_n7)=0 v(gnd__t14_b_n7)=0 v(gnd__t15_b_n7)=0
.ic v(gnd__t16_b_n7)=0 v(gnd__t17_b_n7)=0 v(gnd__t18_b_n7)=0 v(gnd__t19_b_n7)=0
.ic v(gnd__t2_b_n7)=0 v(gnd__t20_b_n7)=0 v(gnd__t21_b_n7)=0 v(gnd__t22_b_n7)=0
.ic v(gnd__t23_b_n7)=0 v(gnd__t24_b_n7)=0 v(gnd__t25_b_n7)=0 v(gnd__t26_b_n7)=0
.ic v(gnd__t27_b_n7)=0 v(gnd__t28_b_n7)=0 v(gnd__t29_b_n7)=0 v(gnd__t3_b_n7)=0
.ic v(gnd__t30_b_n7)=0 v(gnd__t31_b_n7)=0 v(gnd__t4_b_n7)=0 v(gnd__t5_b_n7)=0
.ic v(gnd__t6_b_n7)=0 v(gnd__t7_b_n7)=0 v(gnd__t8_b_n7)=0 v(gnd__t9_b_n7)=0
.ic v(n10_b_n7)=1 v(n10__t0_b_n7)=1 v(n10__t1_b_n7)=1 v(n17_b_n7)=1
.ic v(n17__t0_b_n7)=1 v(n17__t1_b_n7)=1 v(n18_b_n7)=1 v(n18__t0_b_n7)=1
.ic v(n18__t1_b_n7)=1 v(n19_b_n7)=1 v(n19__t0_b_n7)=1 v(n19__t1_b_n7)=1
.ic v(n20_b_n7)=1 v(n20__t0_b_n7)=1 v(n20__t1_b_n7)=1 v(n22_b_n7)=1
.ic v(n22__t0_b_n7)=1 v(n22__t1_b_n7)=1 v(n23_b_n7)=1 v(n23__t0_b_n7)=1
.ic v(n23__t1_b_n7)=1 v(n24_b_n7)=1 v(n24__t0_b_n7)=1 v(n24__t1_b_n7)=1
.ic v(n25_b_n7)=1 v(n25__t0_b_n7)=1 v(n25__t1_b_n7)=1 v(n29_b_n7)=1
.ic v(n29__t0_b_n7)=1 v(n29__t1_b_n7)=1 v(n30_b_n7)=1 v(n30__t0_b_n7)=1
.ic v(n30__t1_b_n7)=1 v(n31_b_n7)=1 v(n31__t0_b_n7)=1 v(n31__t1_b_n7)=1
.ic v(n32_b_n7)=1 v(n32__t0_b_n7)=1 v(n32__t1_b_n7)=1 v(n7_b_n7)=1.1
.ic v(n7__t0_b_n7)=1.1 v(n7__t1_b_n7)=1.1 v(n8_b_n7)=1 v(n8__t0_b_n7)=1
.ic v(n8__t1_b_n7)=1 v(n9_b_n7)=1 v(n9__t0_b_n7)=1 v(n9__t1_b_n7)=1
.ic v(bl_0_b_n7)=0 v(bl_0__t0_b_n7)=0 v(bl_0__t1_b_n7)=0 v(bl_0__t2_b_n7)=0
.ic v(bl_0__t3_b_n7)=0 v(bl_1_b_n7)=0 v(bl_1__t0_b_n7)=0 v(bl_1__t1_b_n7)=0
.ic v(bl_1__t2_b_n7)=0 v(bl_1__t3_b_n7)=0 v(bl_2_b_n7)=0 v(bl_2__t0_b_n7)=0
.ic v(bl_2__t1_b_n7)=0 v(bl_2__t2_b_n7)=0 v(bl_2__t3_b_n7)=0 v(bl_3_b_n7)=0
.ic v(bl_3__t0_b_n7)=0 v(bl_3__t1_b_n7)=0 v(bl_3__t2_b_n7)=0 v(bl_3__t3_b_n7)=0
.ic v(rbl_0_b_n7)=0 v(rbl_0__t0_b_n7)=0 v(rbl_0__t1_b_n7)=0 v(rbl_0__t2_b_n7)=0
.ic v(rbl_0__t3_b_n7)=0 v(rbl_1_b_n7)=0 v(rbl_1__t0_b_n7)=0 v(rbl_1__t1_b_n7)=0
.ic v(rbl_1__t2_b_n7)=0 v(rbl_1__t3_b_n7)=0 v(rbl_2_b_n7)=0 v(rbl_2__t0_b_n7)=0
.ic v(rbl_2__t1_b_n7)=0 v(rbl_2__t2_b_n7)=0 v(rbl_2__t3_b_n7)=0 v(rbl_3_b_n7)=0
.ic v(rbl_3__t0_b_n7)=0 v(rbl_3__t1_b_n7)=0 v(rbl_3__t2_b_n7)=0 v(rbl_3__t3_b_n7)=0
.ic v(rwl_0_b_n7)=0 v(rwl_0__t0_b_n7)=0 v(rwl_0__t1_b_n7)=0 v(rwl_0__t2_b_n7)=0
.ic v(rwl_0__t3_b_n7)=0 v(rwl_1_b_n7)=0 v(rwl_1__t0_b_n7)=0 v(rwl_1__t1_b_n7)=0
.ic v(rwl_1__t2_b_n7)=0 v(rwl_1__t3_b_n7)=0 v(rwl_2_b_n7)=0 v(rwl_2__t0_b_n7)=0
.ic v(rwl_2__t1_b_n7)=0 v(rwl_2__t2_b_n7)=0 v(rwl_2__t3_b_n7)=0 v(rwl_3_b_n7)=0
.ic v(rwl_3__t0_b_n7)=0 v(rwl_3__t1_b_n7)=0 v(rwl_3__t2_b_n7)=0 v(rwl_3__t3_b_n7)=0
.ic v(wl_0_b_n7)=0 v(wl_0__t0_b_n7)=0 v(wl_0__t1_b_n7)=0 v(wl_0__t2_b_n7)=0
.ic v(wl_0__t3_b_n7)=0 v(wl_1_b_n7)=0 v(wl_1__t0_b_n7)=0 v(wl_1__t1_b_n7)=0
.ic v(wl_1__t2_b_n7)=0 v(wl_1__t3_b_n7)=0 v(wl_2_b_n7)=0 v(wl_2__t0_b_n7)=0
.ic v(wl_2__t1_b_n7)=0 v(wl_2__t2_b_n7)=0 v(wl_2__t3_b_n7)=0 v(wl_3_b_n7)=0
.ic v(wl_3__t0_b_n7)=0 v(wl_3__t1_b_n7)=0 v(wl_3__t2_b_n7)=0 v(wl_3__t3_b_n7)=0
.ic v(gnd__t0_b_n8)=0 v(gnd__t1_b_n8)=0 v(gnd__t10_b_n8)=0 v(gnd__t11_b_n8)=0
.ic v(gnd__t12_b_n8)=0 v(gnd__t13_b_n8)=0 v(gnd__t14_b_n8)=0 v(gnd__t15_b_n8)=0
.ic v(gnd__t16_b_n8)=0 v(gnd__t17_b_n8)=0 v(gnd__t18_b_n8)=0 v(gnd__t19_b_n8)=0
.ic v(gnd__t2_b_n8)=0 v(gnd__t20_b_n8)=0 v(gnd__t21_b_n8)=0 v(gnd__t22_b_n8)=0
.ic v(gnd__t23_b_n8)=0 v(gnd__t24_b_n8)=0 v(gnd__t25_b_n8)=0 v(gnd__t26_b_n8)=0
.ic v(gnd__t27_b_n8)=0 v(gnd__t28_b_n8)=0 v(gnd__t29_b_n8)=0 v(gnd__t3_b_n8)=0
.ic v(gnd__t30_b_n8)=0 v(gnd__t31_b_n8)=0 v(gnd__t4_b_n8)=0 v(gnd__t5_b_n8)=0
.ic v(gnd__t6_b_n8)=0 v(gnd__t7_b_n8)=0 v(gnd__t8_b_n8)=0 v(gnd__t9_b_n8)=0
.ic v(n10_b_n8)=1 v(n10__t0_b_n8)=1 v(n10__t1_b_n8)=1 v(n17_b_n8)=1
.ic v(n17__t0_b_n8)=1 v(n17__t1_b_n8)=1 v(n18_b_n8)=1 v(n18__t0_b_n8)=1
.ic v(n18__t1_b_n8)=1 v(n19_b_n8)=1 v(n19__t0_b_n8)=1 v(n19__t1_b_n8)=1
.ic v(n20_b_n8)=1 v(n20__t0_b_n8)=1 v(n20__t1_b_n8)=1 v(n22_b_n8)=1
.ic v(n22__t0_b_n8)=1 v(n22__t1_b_n8)=1 v(n23_b_n8)=1 v(n23__t0_b_n8)=1
.ic v(n23__t1_b_n8)=1 v(n24_b_n8)=1 v(n24__t0_b_n8)=1 v(n24__t1_b_n8)=1
.ic v(n25_b_n8)=1 v(n25__t0_b_n8)=1 v(n25__t1_b_n8)=1 v(n29_b_n8)=1
.ic v(n29__t0_b_n8)=1 v(n29__t1_b_n8)=1 v(n30_b_n8)=1 v(n30__t0_b_n8)=1
.ic v(n30__t1_b_n8)=1 v(n31_b_n8)=1 v(n31__t0_b_n8)=1 v(n31__t1_b_n8)=1
.ic v(n32_b_n8)=1 v(n32__t0_b_n8)=1 v(n32__t1_b_n8)=1 v(n7_b_n8)=1
.ic v(n7__t0_b_n8)=1 v(n7__t1_b_n8)=1 v(n8_b_n8)=1.1 v(n8__t0_b_n8)=1.1
.ic v(n8__t1_b_n8)=1.1 v(n9_b_n8)=1 v(n9__t0_b_n8)=1 v(n9__t1_b_n8)=1
.ic v(bl_0_b_n8)=0 v(bl_0__t0_b_n8)=0 v(bl_0__t1_b_n8)=0 v(bl_0__t2_b_n8)=0
.ic v(bl_0__t3_b_n8)=0 v(bl_1_b_n8)=0 v(bl_1__t0_b_n8)=0 v(bl_1__t1_b_n8)=0
.ic v(bl_1__t2_b_n8)=0 v(bl_1__t3_b_n8)=0 v(bl_2_b_n8)=0 v(bl_2__t0_b_n8)=0
.ic v(bl_2__t1_b_n8)=0 v(bl_2__t2_b_n8)=0 v(bl_2__t3_b_n8)=0 v(bl_3_b_n8)=0
.ic v(bl_3__t0_b_n8)=0 v(bl_3__t1_b_n8)=0 v(bl_3__t2_b_n8)=0 v(bl_3__t3_b_n8)=0
.ic v(rbl_0_b_n8)=0 v(rbl_0__t0_b_n8)=0 v(rbl_0__t1_b_n8)=0 v(rbl_0__t2_b_n8)=0
.ic v(rbl_0__t3_b_n8)=0 v(rbl_1_b_n8)=0 v(rbl_1__t0_b_n8)=0 v(rbl_1__t1_b_n8)=0
.ic v(rbl_1__t2_b_n8)=0 v(rbl_1__t3_b_n8)=0 v(rbl_2_b_n8)=0 v(rbl_2__t0_b_n8)=0
.ic v(rbl_2__t1_b_n8)=0 v(rbl_2__t2_b_n8)=0 v(rbl_2__t3_b_n8)=0 v(rbl_3_b_n8)=0
.ic v(rbl_3__t0_b_n8)=0 v(rbl_3__t1_b_n8)=0 v(rbl_3__t2_b_n8)=0 v(rbl_3__t3_b_n8)=0
.ic v(rwl_0_b_n8)=0 v(rwl_0__t0_b_n8)=0 v(rwl_0__t1_b_n8)=0 v(rwl_0__t2_b_n8)=0
.ic v(rwl_0__t3_b_n8)=0 v(rwl_1_b_n8)=0 v(rwl_1__t0_b_n8)=0 v(rwl_1__t1_b_n8)=0
.ic v(rwl_1__t2_b_n8)=0 v(rwl_1__t3_b_n8)=0 v(rwl_2_b_n8)=0 v(rwl_2__t0_b_n8)=0
.ic v(rwl_2__t1_b_n8)=0 v(rwl_2__t2_b_n8)=0 v(rwl_2__t3_b_n8)=0 v(rwl_3_b_n8)=0
.ic v(rwl_3__t0_b_n8)=0 v(rwl_3__t1_b_n8)=0 v(rwl_3__t2_b_n8)=0 v(rwl_3__t3_b_n8)=0
.ic v(wl_0_b_n8)=0 v(wl_0__t0_b_n8)=0 v(wl_0__t1_b_n8)=0 v(wl_0__t2_b_n8)=0
.ic v(wl_0__t3_b_n8)=0 v(wl_1_b_n8)=0 v(wl_1__t0_b_n8)=0 v(wl_1__t1_b_n8)=0
.ic v(wl_1__t2_b_n8)=0 v(wl_1__t3_b_n8)=0 v(wl_2_b_n8)=0 v(wl_2__t0_b_n8)=0
.ic v(wl_2__t1_b_n8)=0 v(wl_2__t2_b_n8)=0 v(wl_2__t3_b_n8)=0 v(wl_3_b_n8)=0
.ic v(wl_3__t0_b_n8)=0 v(wl_3__t1_b_n8)=0 v(wl_3__t2_b_n8)=0 v(wl_3__t3_b_n8)=0
.ic v(gnd__t0_b_n9)=0 v(gnd__t1_b_n9)=0 v(gnd__t10_b_n9)=0 v(gnd__t11_b_n9)=0
.ic v(gnd__t12_b_n9)=0 v(gnd__t13_b_n9)=0 v(gnd__t14_b_n9)=0 v(gnd__t15_b_n9)=0
.ic v(gnd__t16_b_n9)=0 v(gnd__t17_b_n9)=0 v(gnd__t18_b_n9)=0 v(gnd__t19_b_n9)=0
.ic v(gnd__t2_b_n9)=0 v(gnd__t20_b_n9)=0 v(gnd__t21_b_n9)=0 v(gnd__t22_b_n9)=0
.ic v(gnd__t23_b_n9)=0 v(gnd__t24_b_n9)=0 v(gnd__t25_b_n9)=0 v(gnd__t26_b_n9)=0
.ic v(gnd__t27_b_n9)=0 v(gnd__t28_b_n9)=0 v(gnd__t29_b_n9)=0 v(gnd__t3_b_n9)=0
.ic v(gnd__t30_b_n9)=0 v(gnd__t31_b_n9)=0 v(gnd__t4_b_n9)=0 v(gnd__t5_b_n9)=0
.ic v(gnd__t6_b_n9)=0 v(gnd__t7_b_n9)=0 v(gnd__t8_b_n9)=0 v(gnd__t9_b_n9)=0
.ic v(n10_b_n9)=1 v(n10__t0_b_n9)=1 v(n10__t1_b_n9)=1 v(n17_b_n9)=1
.ic v(n17__t0_b_n9)=1 v(n17__t1_b_n9)=1 v(n18_b_n9)=1 v(n18__t0_b_n9)=1
.ic v(n18__t1_b_n9)=1 v(n19_b_n9)=1 v(n19__t0_b_n9)=1 v(n19__t1_b_n9)=1
.ic v(n20_b_n9)=1 v(n20__t0_b_n9)=1 v(n20__t1_b_n9)=1 v(n22_b_n9)=1
.ic v(n22__t0_b_n9)=1 v(n22__t1_b_n9)=1 v(n23_b_n9)=1 v(n23__t0_b_n9)=1
.ic v(n23__t1_b_n9)=1 v(n24_b_n9)=1 v(n24__t0_b_n9)=1 v(n24__t1_b_n9)=1
.ic v(n25_b_n9)=1 v(n25__t0_b_n9)=1 v(n25__t1_b_n9)=1 v(n29_b_n9)=1
.ic v(n29__t0_b_n9)=1 v(n29__t1_b_n9)=1 v(n30_b_n9)=1 v(n30__t0_b_n9)=1
.ic v(n30__t1_b_n9)=1 v(n31_b_n9)=1 v(n31__t0_b_n9)=1 v(n31__t1_b_n9)=1
.ic v(n32_b_n9)=1 v(n32__t0_b_n9)=1 v(n32__t1_b_n9)=1 v(n7_b_n9)=1
.ic v(n7__t0_b_n9)=1 v(n7__t1_b_n9)=1 v(n8_b_n9)=1 v(n8__t0_b_n9)=1
.ic v(n8__t1_b_n9)=1 v(n9_b_n9)=1.1 v(n9__t0_b_n9)=1.1 v(n9__t1_b_n9)=1.1
.ic v(bl_0_b_n9)=0 v(bl_0__t0_b_n9)=0 v(bl_0__t1_b_n9)=0 v(bl_0__t2_b_n9)=0
.ic v(bl_0__t3_b_n9)=0 v(bl_1_b_n9)=0 v(bl_1__t0_b_n9)=0 v(bl_1__t1_b_n9)=0
.ic v(bl_1__t2_b_n9)=0 v(bl_1__t3_b_n9)=0 v(bl_2_b_n9)=0 v(bl_2__t0_b_n9)=0
.ic v(bl_2__t1_b_n9)=0 v(bl_2__t2_b_n9)=0 v(bl_2__t3_b_n9)=0 v(bl_3_b_n9)=0
.ic v(bl_3__t0_b_n9)=0 v(bl_3__t1_b_n9)=0 v(bl_3__t2_b_n9)=0 v(bl_3__t3_b_n9)=0
.ic v(rbl_0_b_n9)=0 v(rbl_0__t0_b_n9)=0 v(rbl_0__t1_b_n9)=0 v(rbl_0__t2_b_n9)=0
.ic v(rbl_0__t3_b_n9)=0 v(rbl_1_b_n9)=0 v(rbl_1__t0_b_n9)=0 v(rbl_1__t1_b_n9)=0
.ic v(rbl_1__t2_b_n9)=0 v(rbl_1__t3_b_n9)=0 v(rbl_2_b_n9)=0 v(rbl_2__t0_b_n9)=0
.ic v(rbl_2__t1_b_n9)=0 v(rbl_2__t2_b_n9)=0 v(rbl_2__t3_b_n9)=0 v(rbl_3_b_n9)=0
.ic v(rbl_3__t0_b_n9)=0 v(rbl_3__t1_b_n9)=0 v(rbl_3__t2_b_n9)=0 v(rbl_3__t3_b_n9)=0
.ic v(rwl_0_b_n9)=0 v(rwl_0__t0_b_n9)=0 v(rwl_0__t1_b_n9)=0 v(rwl_0__t2_b_n9)=0
.ic v(rwl_0__t3_b_n9)=0 v(rwl_1_b_n9)=0 v(rwl_1__t0_b_n9)=0 v(rwl_1__t1_b_n9)=0
.ic v(rwl_1__t2_b_n9)=0 v(rwl_1__t3_b_n9)=0 v(rwl_2_b_n9)=0 v(rwl_2__t0_b_n9)=0
.ic v(rwl_2__t1_b_n9)=0 v(rwl_2__t2_b_n9)=0 v(rwl_2__t3_b_n9)=0 v(rwl_3_b_n9)=0
.ic v(rwl_3__t0_b_n9)=0 v(rwl_3__t1_b_n9)=0 v(rwl_3__t2_b_n9)=0 v(rwl_3__t3_b_n9)=0
.ic v(wl_0_b_n9)=0 v(wl_0__t0_b_n9)=0 v(wl_0__t1_b_n9)=0 v(wl_0__t2_b_n9)=0
.ic v(wl_0__t3_b_n9)=0 v(wl_1_b_n9)=0 v(wl_1__t0_b_n9)=0 v(wl_1__t1_b_n9)=0
.ic v(wl_1__t2_b_n9)=0 v(wl_1__t3_b_n9)=0 v(wl_2_b_n9)=0 v(wl_2__t0_b_n9)=0
.ic v(wl_2__t1_b_n9)=0 v(wl_2__t2_b_n9)=0 v(wl_2__t3_b_n9)=0 v(wl_3_b_n9)=0
.ic v(wl_3__t0_b_n9)=0 v(wl_3__t1_b_n9)=0 v(wl_3__t2_b_n9)=0 v(wl_3__t3_b_n9)=0
.ic v(gnd__t0_b_n10)=0 v(gnd__t1_b_n10)=0 v(gnd__t10_b_n10)=0 v(gnd__t11_b_n10)=0
.ic v(gnd__t12_b_n10)=0 v(gnd__t13_b_n10)=0 v(gnd__t14_b_n10)=0 v(gnd__t15_b_n10)=0
.ic v(gnd__t16_b_n10)=0 v(gnd__t17_b_n10)=0 v(gnd__t18_b_n10)=0 v(gnd__t19_b_n10)=0
.ic v(gnd__t2_b_n10)=0 v(gnd__t20_b_n10)=0 v(gnd__t21_b_n10)=0 v(gnd__t22_b_n10)=0
.ic v(gnd__t23_b_n10)=0 v(gnd__t24_b_n10)=0 v(gnd__t25_b_n10)=0 v(gnd__t26_b_n10)=0
.ic v(gnd__t27_b_n10)=0 v(gnd__t28_b_n10)=0 v(gnd__t29_b_n10)=0 v(gnd__t3_b_n10)=0
.ic v(gnd__t30_b_n10)=0 v(gnd__t31_b_n10)=0 v(gnd__t4_b_n10)=0 v(gnd__t5_b_n10)=0
.ic v(gnd__t6_b_n10)=0 v(gnd__t7_b_n10)=0 v(gnd__t8_b_n10)=0 v(gnd__t9_b_n10)=0
.ic v(n10_b_n10)=1.1 v(n10__t0_b_n10)=1.1 v(n10__t1_b_n10)=1.1 v(n17_b_n10)=1
.ic v(n17__t0_b_n10)=1 v(n17__t1_b_n10)=1 v(n18_b_n10)=1 v(n18__t0_b_n10)=1
.ic v(n18__t1_b_n10)=1 v(n19_b_n10)=1 v(n19__t0_b_n10)=1 v(n19__t1_b_n10)=1
.ic v(n20_b_n10)=1 v(n20__t0_b_n10)=1 v(n20__t1_b_n10)=1 v(n22_b_n10)=1
.ic v(n22__t0_b_n10)=1 v(n22__t1_b_n10)=1 v(n23_b_n10)=1 v(n23__t0_b_n10)=1
.ic v(n23__t1_b_n10)=1 v(n24_b_n10)=1 v(n24__t0_b_n10)=1 v(n24__t1_b_n10)=1
.ic v(n25_b_n10)=1 v(n25__t0_b_n10)=1 v(n25__t1_b_n10)=1 v(n29_b_n10)=1
.ic v(n29__t0_b_n10)=1 v(n29__t1_b_n10)=1 v(n30_b_n10)=1 v(n30__t0_b_n10)=1
.ic v(n30__t1_b_n10)=1 v(n31_b_n10)=1 v(n31__t0_b_n10)=1 v(n31__t1_b_n10)=1
.ic v(n32_b_n10)=1 v(n32__t0_b_n10)=1 v(n32__t1_b_n10)=1 v(n7_b_n10)=1
.ic v(n7__t0_b_n10)=1 v(n7__t1_b_n10)=1 v(n8_b_n10)=1 v(n8__t0_b_n10)=1
.ic v(n8__t1_b_n10)=1 v(n9_b_n10)=1 v(n9__t0_b_n10)=1 v(n9__t1_b_n10)=1
.ic v(bl_0_b_n10)=0 v(bl_0__t0_b_n10)=0 v(bl_0__t1_b_n10)=0 v(bl_0__t2_b_n10)=0
.ic v(bl_0__t3_b_n10)=0 v(bl_1_b_n10)=0 v(bl_1__t0_b_n10)=0 v(bl_1__t1_b_n10)=0
.ic v(bl_1__t2_b_n10)=0 v(bl_1__t3_b_n10)=0 v(bl_2_b_n10)=0 v(bl_2__t0_b_n10)=0
.ic v(bl_2__t1_b_n10)=0 v(bl_2__t2_b_n10)=0 v(bl_2__t3_b_n10)=0 v(bl_3_b_n10)=0
.ic v(bl_3__t0_b_n10)=0 v(bl_3__t1_b_n10)=0 v(bl_3__t2_b_n10)=0 v(bl_3__t3_b_n10)=0
.ic v(rbl_0_b_n10)=0 v(rbl_0__t0_b_n10)=0 v(rbl_0__t1_b_n10)=0 v(rbl_0__t2_b_n10)=0
.ic v(rbl_0__t3_b_n10)=0 v(rbl_1_b_n10)=0 v(rbl_1__t0_b_n10)=0 v(rbl_1__t1_b_n10)=0
.ic v(rbl_1__t2_b_n10)=0 v(rbl_1__t3_b_n10)=0 v(rbl_2_b_n10)=0 v(rbl_2__t0_b_n10)=0
.ic v(rbl_2__t1_b_n10)=0 v(rbl_2__t2_b_n10)=0 v(rbl_2__t3_b_n10)=0 v(rbl_3_b_n10)=0
.ic v(rbl_3__t0_b_n10)=0 v(rbl_3__t1_b_n10)=0 v(rbl_3__t2_b_n10)=0 v(rbl_3__t3_b_n10)=0
.ic v(rwl_0_b_n10)=0 v(rwl_0__t0_b_n10)=0 v(rwl_0__t1_b_n10)=0 v(rwl_0__t2_b_n10)=0
.ic v(rwl_0__t3_b_n10)=0 v(rwl_1_b_n10)=0 v(rwl_1__t0_b_n10)=0 v(rwl_1__t1_b_n10)=0
.ic v(rwl_1__t2_b_n10)=0 v(rwl_1__t3_b_n10)=0 v(rwl_2_b_n10)=0 v(rwl_2__t0_b_n10)=0
.ic v(rwl_2__t1_b_n10)=0 v(rwl_2__t2_b_n10)=0 v(rwl_2__t3_b_n10)=0 v(rwl_3_b_n10)=0
.ic v(rwl_3__t0_b_n10)=0 v(rwl_3__t1_b_n10)=0 v(rwl_3__t2_b_n10)=0 v(rwl_3__t3_b_n10)=0
.ic v(wl_0_b_n10)=0 v(wl_0__t0_b_n10)=0 v(wl_0__t1_b_n10)=0 v(wl_0__t2_b_n10)=0
.ic v(wl_0__t3_b_n10)=0 v(wl_1_b_n10)=0 v(wl_1__t0_b_n10)=0 v(wl_1__t1_b_n10)=0
.ic v(wl_1__t2_b_n10)=0 v(wl_1__t3_b_n10)=0 v(wl_2_b_n10)=0 v(wl_2__t0_b_n10)=0
.ic v(wl_2__t1_b_n10)=0 v(wl_2__t2_b_n10)=0 v(wl_2__t3_b_n10)=0 v(wl_3_b_n10)=0
.ic v(wl_3__t0_b_n10)=0 v(wl_3__t1_b_n10)=0 v(wl_3__t2_b_n10)=0 v(wl_3__t3_b_n10)=0
.ic v(gnd__t0_b_n17)=0 v(gnd__t1_b_n17)=0 v(gnd__t10_b_n17)=0 v(gnd__t11_b_n17)=0
.ic v(gnd__t12_b_n17)=0 v(gnd__t13_b_n17)=0 v(gnd__t14_b_n17)=0 v(gnd__t15_b_n17)=0
.ic v(gnd__t16_b_n17)=0 v(gnd__t17_b_n17)=0 v(gnd__t18_b_n17)=0 v(gnd__t19_b_n17)=0
.ic v(gnd__t2_b_n17)=0 v(gnd__t20_b_n17)=0 v(gnd__t21_b_n17)=0 v(gnd__t22_b_n17)=0
.ic v(gnd__t23_b_n17)=0 v(gnd__t24_b_n17)=0 v(gnd__t25_b_n17)=0 v(gnd__t26_b_n17)=0
.ic v(gnd__t27_b_n17)=0 v(gnd__t28_b_n17)=0 v(gnd__t29_b_n17)=0 v(gnd__t3_b_n17)=0
.ic v(gnd__t30_b_n17)=0 v(gnd__t31_b_n17)=0 v(gnd__t4_b_n17)=0 v(gnd__t5_b_n17)=0
.ic v(gnd__t6_b_n17)=0 v(gnd__t7_b_n17)=0 v(gnd__t8_b_n17)=0 v(gnd__t9_b_n17)=0
.ic v(n10_b_n17)=1 v(n10__t0_b_n17)=1 v(n10__t1_b_n17)=1 v(n17_b_n17)=1.1
.ic v(n17__t0_b_n17)=1.1 v(n17__t1_b_n17)=1.1 v(n18_b_n17)=1 v(n18__t0_b_n17)=1
.ic v(n18__t1_b_n17)=1 v(n19_b_n17)=1 v(n19__t0_b_n17)=1 v(n19__t1_b_n17)=1
.ic v(n20_b_n17)=1 v(n20__t0_b_n17)=1 v(n20__t1_b_n17)=1 v(n22_b_n17)=1
.ic v(n22__t0_b_n17)=1 v(n22__t1_b_n17)=1 v(n23_b_n17)=1 v(n23__t0_b_n17)=1
.ic v(n23__t1_b_n17)=1 v(n24_b_n17)=1 v(n24__t0_b_n17)=1 v(n24__t1_b_n17)=1
.ic v(n25_b_n17)=1 v(n25__t0_b_n17)=1 v(n25__t1_b_n17)=1 v(n29_b_n17)=1
.ic v(n29__t0_b_n17)=1 v(n29__t1_b_n17)=1 v(n30_b_n17)=1 v(n30__t0_b_n17)=1
.ic v(n30__t1_b_n17)=1 v(n31_b_n17)=1 v(n31__t0_b_n17)=1 v(n31__t1_b_n17)=1
.ic v(n32_b_n17)=1 v(n32__t0_b_n17)=1 v(n32__t1_b_n17)=1 v(n7_b_n17)=1
.ic v(n7__t0_b_n17)=1 v(n7__t1_b_n17)=1 v(n8_b_n17)=1 v(n8__t0_b_n17)=1
.ic v(n8__t1_b_n17)=1 v(n9_b_n17)=1 v(n9__t0_b_n17)=1 v(n9__t1_b_n17)=1
.ic v(bl_0_b_n17)=0 v(bl_0__t0_b_n17)=0 v(bl_0__t1_b_n17)=0 v(bl_0__t2_b_n17)=0
.ic v(bl_0__t3_b_n17)=0 v(bl_1_b_n17)=0 v(bl_1__t0_b_n17)=0 v(bl_1__t1_b_n17)=0
.ic v(bl_1__t2_b_n17)=0 v(bl_1__t3_b_n17)=0 v(bl_2_b_n17)=0 v(bl_2__t0_b_n17)=0
.ic v(bl_2__t1_b_n17)=0 v(bl_2__t2_b_n17)=0 v(bl_2__t3_b_n17)=0 v(bl_3_b_n17)=0
.ic v(bl_3__t0_b_n17)=0 v(bl_3__t1_b_n17)=0 v(bl_3__t2_b_n17)=0 v(bl_3__t3_b_n17)=0
.ic v(rbl_0_b_n17)=0 v(rbl_0__t0_b_n17)=0 v(rbl_0__t1_b_n17)=0 v(rbl_0__t2_b_n17)=0
.ic v(rbl_0__t3_b_n17)=0 v(rbl_1_b_n17)=0 v(rbl_1__t0_b_n17)=0 v(rbl_1__t1_b_n17)=0
.ic v(rbl_1__t2_b_n17)=0 v(rbl_1__t3_b_n17)=0 v(rbl_2_b_n17)=0 v(rbl_2__t0_b_n17)=0
.ic v(rbl_2__t1_b_n17)=0 v(rbl_2__t2_b_n17)=0 v(rbl_2__t3_b_n17)=0 v(rbl_3_b_n17)=0
.ic v(rbl_3__t0_b_n17)=0 v(rbl_3__t1_b_n17)=0 v(rbl_3__t2_b_n17)=0 v(rbl_3__t3_b_n17)=0
.ic v(rwl_0_b_n17)=0 v(rwl_0__t0_b_n17)=0 v(rwl_0__t1_b_n17)=0 v(rwl_0__t2_b_n17)=0
.ic v(rwl_0__t3_b_n17)=0 v(rwl_1_b_n17)=0 v(rwl_1__t0_b_n17)=0 v(rwl_1__t1_b_n17)=0
.ic v(rwl_1__t2_b_n17)=0 v(rwl_1__t3_b_n17)=0 v(rwl_2_b_n17)=0 v(rwl_2__t0_b_n17)=0
.ic v(rwl_2__t1_b_n17)=0 v(rwl_2__t2_b_n17)=0 v(rwl_2__t3_b_n17)=0 v(rwl_3_b_n17)=0
.ic v(rwl_3__t0_b_n17)=0 v(rwl_3__t1_b_n17)=0 v(rwl_3__t2_b_n17)=0 v(rwl_3__t3_b_n17)=0
.ic v(wl_0_b_n17)=0 v(wl_0__t0_b_n17)=0 v(wl_0__t1_b_n17)=0 v(wl_0__t2_b_n17)=0
.ic v(wl_0__t3_b_n17)=0 v(wl_1_b_n17)=0 v(wl_1__t0_b_n17)=0 v(wl_1__t1_b_n17)=0
.ic v(wl_1__t2_b_n17)=0 v(wl_1__t3_b_n17)=0 v(wl_2_b_n17)=0 v(wl_2__t0_b_n17)=0
.ic v(wl_2__t1_b_n17)=0 v(wl_2__t2_b_n17)=0 v(wl_2__t3_b_n17)=0 v(wl_3_b_n17)=0
.ic v(wl_3__t0_b_n17)=0 v(wl_3__t1_b_n17)=0 v(wl_3__t2_b_n17)=0 v(wl_3__t3_b_n17)=0
.ic v(gnd__t0_b_n18)=0 v(gnd__t1_b_n18)=0 v(gnd__t10_b_n18)=0 v(gnd__t11_b_n18)=0
.ic v(gnd__t12_b_n18)=0 v(gnd__t13_b_n18)=0 v(gnd__t14_b_n18)=0 v(gnd__t15_b_n18)=0
.ic v(gnd__t16_b_n18)=0 v(gnd__t17_b_n18)=0 v(gnd__t18_b_n18)=0 v(gnd__t19_b_n18)=0
.ic v(gnd__t2_b_n18)=0 v(gnd__t20_b_n18)=0 v(gnd__t21_b_n18)=0 v(gnd__t22_b_n18)=0
.ic v(gnd__t23_b_n18)=0 v(gnd__t24_b_n18)=0 v(gnd__t25_b_n18)=0 v(gnd__t26_b_n18)=0
.ic v(gnd__t27_b_n18)=0 v(gnd__t28_b_n18)=0 v(gnd__t29_b_n18)=0 v(gnd__t3_b_n18)=0
.ic v(gnd__t30_b_n18)=0 v(gnd__t31_b_n18)=0 v(gnd__t4_b_n18)=0 v(gnd__t5_b_n18)=0
.ic v(gnd__t6_b_n18)=0 v(gnd__t7_b_n18)=0 v(gnd__t8_b_n18)=0 v(gnd__t9_b_n18)=0
.ic v(n10_b_n18)=1 v(n10__t0_b_n18)=1 v(n10__t1_b_n18)=1 v(n17_b_n18)=1
.ic v(n17__t0_b_n18)=1 v(n17__t1_b_n18)=1 v(n18_b_n18)=1.1 v(n18__t0_b_n18)=1.1
.ic v(n18__t1_b_n18)=1.1 v(n19_b_n18)=1 v(n19__t0_b_n18)=1 v(n19__t1_b_n18)=1
.ic v(n20_b_n18)=1 v(n20__t0_b_n18)=1 v(n20__t1_b_n18)=1 v(n22_b_n18)=1
.ic v(n22__t0_b_n18)=1 v(n22__t1_b_n18)=1 v(n23_b_n18)=1 v(n23__t0_b_n18)=1
.ic v(n23__t1_b_n18)=1 v(n24_b_n18)=1 v(n24__t0_b_n18)=1 v(n24__t1_b_n18)=1
.ic v(n25_b_n18)=1 v(n25__t0_b_n18)=1 v(n25__t1_b_n18)=1 v(n29_b_n18)=1
.ic v(n29__t0_b_n18)=1 v(n29__t1_b_n18)=1 v(n30_b_n18)=1 v(n30__t0_b_n18)=1
.ic v(n30__t1_b_n18)=1 v(n31_b_n18)=1 v(n31__t0_b_n18)=1 v(n31__t1_b_n18)=1
.ic v(n32_b_n18)=1 v(n32__t0_b_n18)=1 v(n32__t1_b_n18)=1 v(n7_b_n18)=1
.ic v(n7__t0_b_n18)=1 v(n7__t1_b_n18)=1 v(n8_b_n18)=1 v(n8__t0_b_n18)=1
.ic v(n8__t1_b_n18)=1 v(n9_b_n18)=1 v(n9__t0_b_n18)=1 v(n9__t1_b_n18)=1
.ic v(bl_0_b_n18)=0 v(bl_0__t0_b_n18)=0 v(bl_0__t1_b_n18)=0 v(bl_0__t2_b_n18)=0
.ic v(bl_0__t3_b_n18)=0 v(bl_1_b_n18)=0 v(bl_1__t0_b_n18)=0 v(bl_1__t1_b_n18)=0
.ic v(bl_1__t2_b_n18)=0 v(bl_1__t3_b_n18)=0 v(bl_2_b_n18)=0 v(bl_2__t0_b_n18)=0
.ic v(bl_2__t1_b_n18)=0 v(bl_2__t2_b_n18)=0 v(bl_2__t3_b_n18)=0 v(bl_3_b_n18)=0
.ic v(bl_3__t0_b_n18)=0 v(bl_3__t1_b_n18)=0 v(bl_3__t2_b_n18)=0 v(bl_3__t3_b_n18)=0
.ic v(rbl_0_b_n18)=0 v(rbl_0__t0_b_n18)=0 v(rbl_0__t1_b_n18)=0 v(rbl_0__t2_b_n18)=0
.ic v(rbl_0__t3_b_n18)=0 v(rbl_1_b_n18)=0 v(rbl_1__t0_b_n18)=0 v(rbl_1__t1_b_n18)=0
.ic v(rbl_1__t2_b_n18)=0 v(rbl_1__t3_b_n18)=0 v(rbl_2_b_n18)=0 v(rbl_2__t0_b_n18)=0
.ic v(rbl_2__t1_b_n18)=0 v(rbl_2__t2_b_n18)=0 v(rbl_2__t3_b_n18)=0 v(rbl_3_b_n18)=0
.ic v(rbl_3__t0_b_n18)=0 v(rbl_3__t1_b_n18)=0 v(rbl_3__t2_b_n18)=0 v(rbl_3__t3_b_n18)=0
.ic v(rwl_0_b_n18)=0 v(rwl_0__t0_b_n18)=0 v(rwl_0__t1_b_n18)=0 v(rwl_0__t2_b_n18)=0
.ic v(rwl_0__t3_b_n18)=0 v(rwl_1_b_n18)=0 v(rwl_1__t0_b_n18)=0 v(rwl_1__t1_b_n18)=0
.ic v(rwl_1__t2_b_n18)=0 v(rwl_1__t3_b_n18)=0 v(rwl_2_b_n18)=0 v(rwl_2__t0_b_n18)=0
.ic v(rwl_2__t1_b_n18)=0 v(rwl_2__t2_b_n18)=0 v(rwl_2__t3_b_n18)=0 v(rwl_3_b_n18)=0
.ic v(rwl_3__t0_b_n18)=0 v(rwl_3__t1_b_n18)=0 v(rwl_3__t2_b_n18)=0 v(rwl_3__t3_b_n18)=0
.ic v(wl_0_b_n18)=0 v(wl_0__t0_b_n18)=0 v(wl_0__t1_b_n18)=0 v(wl_0__t2_b_n18)=0
.ic v(wl_0__t3_b_n18)=0 v(wl_1_b_n18)=0 v(wl_1__t0_b_n18)=0 v(wl_1__t1_b_n18)=0
.ic v(wl_1__t2_b_n18)=0 v(wl_1__t3_b_n18)=0 v(wl_2_b_n18)=0 v(wl_2__t0_b_n18)=0
.ic v(wl_2__t1_b_n18)=0 v(wl_2__t2_b_n18)=0 v(wl_2__t3_b_n18)=0 v(wl_3_b_n18)=0
.ic v(wl_3__t0_b_n18)=0 v(wl_3__t1_b_n18)=0 v(wl_3__t2_b_n18)=0 v(wl_3__t3_b_n18)=0
.ic v(gnd__t0_b_n19)=0 v(gnd__t1_b_n19)=0 v(gnd__t10_b_n19)=0 v(gnd__t11_b_n19)=0
.ic v(gnd__t12_b_n19)=0 v(gnd__t13_b_n19)=0 v(gnd__t14_b_n19)=0 v(gnd__t15_b_n19)=0
.ic v(gnd__t16_b_n19)=0 v(gnd__t17_b_n19)=0 v(gnd__t18_b_n19)=0 v(gnd__t19_b_n19)=0
.ic v(gnd__t2_b_n19)=0 v(gnd__t20_b_n19)=0 v(gnd__t21_b_n19)=0 v(gnd__t22_b_n19)=0
.ic v(gnd__t23_b_n19)=0 v(gnd__t24_b_n19)=0 v(gnd__t25_b_n19)=0 v(gnd__t26_b_n19)=0
.ic v(gnd__t27_b_n19)=0 v(gnd__t28_b_n19)=0 v(gnd__t29_b_n19)=0 v(gnd__t3_b_n19)=0
.ic v(gnd__t30_b_n19)=0 v(gnd__t31_b_n19)=0 v(gnd__t4_b_n19)=0 v(gnd__t5_b_n19)=0
.ic v(gnd__t6_b_n19)=0 v(gnd__t7_b_n19)=0 v(gnd__t8_b_n19)=0 v(gnd__t9_b_n19)=0
.ic v(n10_b_n19)=1 v(n10__t0_b_n19)=1 v(n10__t1_b_n19)=1 v(n17_b_n19)=1
.ic v(n17__t0_b_n19)=1 v(n17__t1_b_n19)=1 v(n18_b_n19)=1 v(n18__t0_b_n19)=1
.ic v(n18__t1_b_n19)=1 v(n19_b_n19)=1.1 v(n19__t0_b_n19)=1.1 v(n19__t1_b_n19)=1.1
.ic v(n20_b_n19)=1 v(n20__t0_b_n19)=1 v(n20__t1_b_n19)=1 v(n22_b_n19)=1
.ic v(n22__t0_b_n19)=1 v(n22__t1_b_n19)=1 v(n23_b_n19)=1 v(n23__t0_b_n19)=1
.ic v(n23__t1_b_n19)=1 v(n24_b_n19)=1 v(n24__t0_b_n19)=1 v(n24__t1_b_n19)=1
.ic v(n25_b_n19)=1 v(n25__t0_b_n19)=1 v(n25__t1_b_n19)=1 v(n29_b_n19)=1
.ic v(n29__t0_b_n19)=1 v(n29__t1_b_n19)=1 v(n30_b_n19)=1 v(n30__t0_b_n19)=1
.ic v(n30__t1_b_n19)=1 v(n31_b_n19)=1 v(n31__t0_b_n19)=1 v(n31__t1_b_n19)=1
.ic v(n32_b_n19)=1 v(n32__t0_b_n19)=1 v(n32__t1_b_n19)=1 v(n7_b_n19)=1
.ic v(n7__t0_b_n19)=1 v(n7__t1_b_n19)=1 v(n8_b_n19)=1 v(n8__t0_b_n19)=1
.ic v(n8__t1_b_n19)=1 v(n9_b_n19)=1 v(n9__t0_b_n19)=1 v(n9__t1_b_n19)=1
.ic v(bl_0_b_n19)=0 v(bl_0__t0_b_n19)=0 v(bl_0__t1_b_n19)=0 v(bl_0__t2_b_n19)=0
.ic v(bl_0__t3_b_n19)=0 v(bl_1_b_n19)=0 v(bl_1__t0_b_n19)=0 v(bl_1__t1_b_n19)=0
.ic v(bl_1__t2_b_n19)=0 v(bl_1__t3_b_n19)=0 v(bl_2_b_n19)=0 v(bl_2__t0_b_n19)=0
.ic v(bl_2__t1_b_n19)=0 v(bl_2__t2_b_n19)=0 v(bl_2__t3_b_n19)=0 v(bl_3_b_n19)=0
.ic v(bl_3__t0_b_n19)=0 v(bl_3__t1_b_n19)=0 v(bl_3__t2_b_n19)=0 v(bl_3__t3_b_n19)=0
.ic v(rbl_0_b_n19)=0 v(rbl_0__t0_b_n19)=0 v(rbl_0__t1_b_n19)=0 v(rbl_0__t2_b_n19)=0
.ic v(rbl_0__t3_b_n19)=0 v(rbl_1_b_n19)=0 v(rbl_1__t0_b_n19)=0 v(rbl_1__t1_b_n19)=0
.ic v(rbl_1__t2_b_n19)=0 v(rbl_1__t3_b_n19)=0 v(rbl_2_b_n19)=0 v(rbl_2__t0_b_n19)=0
.ic v(rbl_2__t1_b_n19)=0 v(rbl_2__t2_b_n19)=0 v(rbl_2__t3_b_n19)=0 v(rbl_3_b_n19)=0
.ic v(rbl_3__t0_b_n19)=0 v(rbl_3__t1_b_n19)=0 v(rbl_3__t2_b_n19)=0 v(rbl_3__t3_b_n19)=0
.ic v(rwl_0_b_n19)=0 v(rwl_0__t0_b_n19)=0 v(rwl_0__t1_b_n19)=0 v(rwl_0__t2_b_n19)=0
.ic v(rwl_0__t3_b_n19)=0 v(rwl_1_b_n19)=0 v(rwl_1__t0_b_n19)=0 v(rwl_1__t1_b_n19)=0
.ic v(rwl_1__t2_b_n19)=0 v(rwl_1__t3_b_n19)=0 v(rwl_2_b_n19)=0 v(rwl_2__t0_b_n19)=0
.ic v(rwl_2__t1_b_n19)=0 v(rwl_2__t2_b_n19)=0 v(rwl_2__t3_b_n19)=0 v(rwl_3_b_n19)=0
.ic v(rwl_3__t0_b_n19)=0 v(rwl_3__t1_b_n19)=0 v(rwl_3__t2_b_n19)=0 v(rwl_3__t3_b_n19)=0
.ic v(wl_0_b_n19)=0 v(wl_0__t0_b_n19)=0 v(wl_0__t1_b_n19)=0 v(wl_0__t2_b_n19)=0
.ic v(wl_0__t3_b_n19)=0 v(wl_1_b_n19)=0 v(wl_1__t0_b_n19)=0 v(wl_1__t1_b_n19)=0
.ic v(wl_1__t2_b_n19)=0 v(wl_1__t3_b_n19)=0 v(wl_2_b_n19)=0 v(wl_2__t0_b_n19)=0
.ic v(wl_2__t1_b_n19)=0 v(wl_2__t2_b_n19)=0 v(wl_2__t3_b_n19)=0 v(wl_3_b_n19)=0
.ic v(wl_3__t0_b_n19)=0 v(wl_3__t1_b_n19)=0 v(wl_3__t2_b_n19)=0 v(wl_3__t3_b_n19)=0
.ic v(gnd__t0_b_n20)=0 v(gnd__t1_b_n20)=0 v(gnd__t10_b_n20)=0 v(gnd__t11_b_n20)=0
.ic v(gnd__t12_b_n20)=0 v(gnd__t13_b_n20)=0 v(gnd__t14_b_n20)=0 v(gnd__t15_b_n20)=0
.ic v(gnd__t16_b_n20)=0 v(gnd__t17_b_n20)=0 v(gnd__t18_b_n20)=0 v(gnd__t19_b_n20)=0
.ic v(gnd__t2_b_n20)=0 v(gnd__t20_b_n20)=0 v(gnd__t21_b_n20)=0 v(gnd__t22_b_n20)=0
.ic v(gnd__t23_b_n20)=0 v(gnd__t24_b_n20)=0 v(gnd__t25_b_n20)=0 v(gnd__t26_b_n20)=0
.ic v(gnd__t27_b_n20)=0 v(gnd__t28_b_n20)=0 v(gnd__t29_b_n20)=0 v(gnd__t3_b_n20)=0
.ic v(gnd__t30_b_n20)=0 v(gnd__t31_b_n20)=0 v(gnd__t4_b_n20)=0 v(gnd__t5_b_n20)=0
.ic v(gnd__t6_b_n20)=0 v(gnd__t7_b_n20)=0 v(gnd__t8_b_n20)=0 v(gnd__t9_b_n20)=0
.ic v(n10_b_n20)=1 v(n10__t0_b_n20)=1 v(n10__t1_b_n20)=1 v(n17_b_n20)=1
.ic v(n17__t0_b_n20)=1 v(n17__t1_b_n20)=1 v(n18_b_n20)=1 v(n18__t0_b_n20)=1
.ic v(n18__t1_b_n20)=1 v(n19_b_n20)=1 v(n19__t0_b_n20)=1 v(n19__t1_b_n20)=1
.ic v(n20_b_n20)=1.1 v(n20__t0_b_n20)=1.1 v(n20__t1_b_n20)=1.1 v(n22_b_n20)=1
.ic v(n22__t0_b_n20)=1 v(n22__t1_b_n20)=1 v(n23_b_n20)=1 v(n23__t0_b_n20)=1
.ic v(n23__t1_b_n20)=1 v(n24_b_n20)=1 v(n24__t0_b_n20)=1 v(n24__t1_b_n20)=1
.ic v(n25_b_n20)=1 v(n25__t0_b_n20)=1 v(n25__t1_b_n20)=1 v(n29_b_n20)=1
.ic v(n29__t0_b_n20)=1 v(n29__t1_b_n20)=1 v(n30_b_n20)=1 v(n30__t0_b_n20)=1
.ic v(n30__t1_b_n20)=1 v(n31_b_n20)=1 v(n31__t0_b_n20)=1 v(n31__t1_b_n20)=1
.ic v(n32_b_n20)=1 v(n32__t0_b_n20)=1 v(n32__t1_b_n20)=1 v(n7_b_n20)=1
.ic v(n7__t0_b_n20)=1 v(n7__t1_b_n20)=1 v(n8_b_n20)=1 v(n8__t0_b_n20)=1
.ic v(n8__t1_b_n20)=1 v(n9_b_n20)=1 v(n9__t0_b_n20)=1 v(n9__t1_b_n20)=1
.ic v(bl_0_b_n20)=0 v(bl_0__t0_b_n20)=0 v(bl_0__t1_b_n20)=0 v(bl_0__t2_b_n20)=0
.ic v(bl_0__t3_b_n20)=0 v(bl_1_b_n20)=0 v(bl_1__t0_b_n20)=0 v(bl_1__t1_b_n20)=0
.ic v(bl_1__t2_b_n20)=0 v(bl_1__t3_b_n20)=0 v(bl_2_b_n20)=0 v(bl_2__t0_b_n20)=0
.ic v(bl_2__t1_b_n20)=0 v(bl_2__t2_b_n20)=0 v(bl_2__t3_b_n20)=0 v(bl_3_b_n20)=0
.ic v(bl_3__t0_b_n20)=0 v(bl_3__t1_b_n20)=0 v(bl_3__t2_b_n20)=0 v(bl_3__t3_b_n20)=0
.ic v(rbl_0_b_n20)=0 v(rbl_0__t0_b_n20)=0 v(rbl_0__t1_b_n20)=0 v(rbl_0__t2_b_n20)=0
.ic v(rbl_0__t3_b_n20)=0 v(rbl_1_b_n20)=0 v(rbl_1__t0_b_n20)=0 v(rbl_1__t1_b_n20)=0
.ic v(rbl_1__t2_b_n20)=0 v(rbl_1__t3_b_n20)=0 v(rbl_2_b_n20)=0 v(rbl_2__t0_b_n20)=0
.ic v(rbl_2__t1_b_n20)=0 v(rbl_2__t2_b_n20)=0 v(rbl_2__t3_b_n20)=0 v(rbl_3_b_n20)=0
.ic v(rbl_3__t0_b_n20)=0 v(rbl_3__t1_b_n20)=0 v(rbl_3__t2_b_n20)=0 v(rbl_3__t3_b_n20)=0
.ic v(rwl_0_b_n20)=0 v(rwl_0__t0_b_n20)=0 v(rwl_0__t1_b_n20)=0 v(rwl_0__t2_b_n20)=0
.ic v(rwl_0__t3_b_n20)=0 v(rwl_1_b_n20)=0 v(rwl_1__t0_b_n20)=0 v(rwl_1__t1_b_n20)=0
.ic v(rwl_1__t2_b_n20)=0 v(rwl_1__t3_b_n20)=0 v(rwl_2_b_n20)=0 v(rwl_2__t0_b_n20)=0
.ic v(rwl_2__t1_b_n20)=0 v(rwl_2__t2_b_n20)=0 v(rwl_2__t3_b_n20)=0 v(rwl_3_b_n20)=0
.ic v(rwl_3__t0_b_n20)=0 v(rwl_3__t1_b_n20)=0 v(rwl_3__t2_b_n20)=0 v(rwl_3__t3_b_n20)=0
.ic v(wl_0_b_n20)=0 v(wl_0__t0_b_n20)=0 v(wl_0__t1_b_n20)=0 v(wl_0__t2_b_n20)=0
.ic v(wl_0__t3_b_n20)=0 v(wl_1_b_n20)=0 v(wl_1__t0_b_n20)=0 v(wl_1__t1_b_n20)=0
.ic v(wl_1__t2_b_n20)=0 v(wl_1__t3_b_n20)=0 v(wl_2_b_n20)=0 v(wl_2__t0_b_n20)=0
.ic v(wl_2__t1_b_n20)=0 v(wl_2__t2_b_n20)=0 v(wl_2__t3_b_n20)=0 v(wl_3_b_n20)=0
.ic v(wl_3__t0_b_n20)=0 v(wl_3__t1_b_n20)=0 v(wl_3__t2_b_n20)=0 v(wl_3__t3_b_n20)=0
.ic v(gnd__t0_b_n22)=0 v(gnd__t1_b_n22)=0 v(gnd__t10_b_n22)=0 v(gnd__t11_b_n22)=0
.ic v(gnd__t12_b_n22)=0 v(gnd__t13_b_n22)=0 v(gnd__t14_b_n22)=0 v(gnd__t15_b_n22)=0
.ic v(gnd__t16_b_n22)=0 v(gnd__t17_b_n22)=0 v(gnd__t18_b_n22)=0 v(gnd__t19_b_n22)=0
.ic v(gnd__t2_b_n22)=0 v(gnd__t20_b_n22)=0 v(gnd__t21_b_n22)=0 v(gnd__t22_b_n22)=0
.ic v(gnd__t23_b_n22)=0 v(gnd__t24_b_n22)=0 v(gnd__t25_b_n22)=0 v(gnd__t26_b_n22)=0
.ic v(gnd__t27_b_n22)=0 v(gnd__t28_b_n22)=0 v(gnd__t29_b_n22)=0 v(gnd__t3_b_n22)=0
.ic v(gnd__t30_b_n22)=0 v(gnd__t31_b_n22)=0 v(gnd__t4_b_n22)=0 v(gnd__t5_b_n22)=0
.ic v(gnd__t6_b_n22)=0 v(gnd__t7_b_n22)=0 v(gnd__t8_b_n22)=0 v(gnd__t9_b_n22)=0
.ic v(n10_b_n22)=1 v(n10__t0_b_n22)=1 v(n10__t1_b_n22)=1 v(n17_b_n22)=1
.ic v(n17__t0_b_n22)=1 v(n17__t1_b_n22)=1 v(n18_b_n22)=1 v(n18__t0_b_n22)=1
.ic v(n18__t1_b_n22)=1 v(n19_b_n22)=1 v(n19__t0_b_n22)=1 v(n19__t1_b_n22)=1
.ic v(n20_b_n22)=1 v(n20__t0_b_n22)=1 v(n20__t1_b_n22)=1 v(n22_b_n22)=1.1
.ic v(n22__t0_b_n22)=1.1 v(n22__t1_b_n22)=1.1 v(n23_b_n22)=1 v(n23__t0_b_n22)=1
.ic v(n23__t1_b_n22)=1 v(n24_b_n22)=1 v(n24__t0_b_n22)=1 v(n24__t1_b_n22)=1
.ic v(n25_b_n22)=1 v(n25__t0_b_n22)=1 v(n25__t1_b_n22)=1 v(n29_b_n22)=1
.ic v(n29__t0_b_n22)=1 v(n29__t1_b_n22)=1 v(n30_b_n22)=1 v(n30__t0_b_n22)=1
.ic v(n30__t1_b_n22)=1 v(n31_b_n22)=1 v(n31__t0_b_n22)=1 v(n31__t1_b_n22)=1
.ic v(n32_b_n22)=1 v(n32__t0_b_n22)=1 v(n32__t1_b_n22)=1 v(n7_b_n22)=1
.ic v(n7__t0_b_n22)=1 v(n7__t1_b_n22)=1 v(n8_b_n22)=1 v(n8__t0_b_n22)=1
.ic v(n8__t1_b_n22)=1 v(n9_b_n22)=1 v(n9__t0_b_n22)=1 v(n9__t1_b_n22)=1
.ic v(bl_0_b_n22)=0 v(bl_0__t0_b_n22)=0 v(bl_0__t1_b_n22)=0 v(bl_0__t2_b_n22)=0
.ic v(bl_0__t3_b_n22)=0 v(bl_1_b_n22)=0 v(bl_1__t0_b_n22)=0 v(bl_1__t1_b_n22)=0
.ic v(bl_1__t2_b_n22)=0 v(bl_1__t3_b_n22)=0 v(bl_2_b_n22)=0 v(bl_2__t0_b_n22)=0
.ic v(bl_2__t1_b_n22)=0 v(bl_2__t2_b_n22)=0 v(bl_2__t3_b_n22)=0 v(bl_3_b_n22)=0
.ic v(bl_3__t0_b_n22)=0 v(bl_3__t1_b_n22)=0 v(bl_3__t2_b_n22)=0 v(bl_3__t3_b_n22)=0
.ic v(rbl_0_b_n22)=0 v(rbl_0__t0_b_n22)=0 v(rbl_0__t1_b_n22)=0 v(rbl_0__t2_b_n22)=0
.ic v(rbl_0__t3_b_n22)=0 v(rbl_1_b_n22)=0 v(rbl_1__t0_b_n22)=0 v(rbl_1__t1_b_n22)=0
.ic v(rbl_1__t2_b_n22)=0 v(rbl_1__t3_b_n22)=0 v(rbl_2_b_n22)=0 v(rbl_2__t0_b_n22)=0
.ic v(rbl_2__t1_b_n22)=0 v(rbl_2__t2_b_n22)=0 v(rbl_2__t3_b_n22)=0 v(rbl_3_b_n22)=0
.ic v(rbl_3__t0_b_n22)=0 v(rbl_3__t1_b_n22)=0 v(rbl_3__t2_b_n22)=0 v(rbl_3__t3_b_n22)=0
.ic v(rwl_0_b_n22)=0 v(rwl_0__t0_b_n22)=0 v(rwl_0__t1_b_n22)=0 v(rwl_0__t2_b_n22)=0
.ic v(rwl_0__t3_b_n22)=0 v(rwl_1_b_n22)=0 v(rwl_1__t0_b_n22)=0 v(rwl_1__t1_b_n22)=0
.ic v(rwl_1__t2_b_n22)=0 v(rwl_1__t3_b_n22)=0 v(rwl_2_b_n22)=0 v(rwl_2__t0_b_n22)=0
.ic v(rwl_2__t1_b_n22)=0 v(rwl_2__t2_b_n22)=0 v(rwl_2__t3_b_n22)=0 v(rwl_3_b_n22)=0
.ic v(rwl_3__t0_b_n22)=0 v(rwl_3__t1_b_n22)=0 v(rwl_3__t2_b_n22)=0 v(rwl_3__t3_b_n22)=0
.ic v(wl_0_b_n22)=0 v(wl_0__t0_b_n22)=0 v(wl_0__t1_b_n22)=0 v(wl_0__t2_b_n22)=0
.ic v(wl_0__t3_b_n22)=0 v(wl_1_b_n22)=0 v(wl_1__t0_b_n22)=0 v(wl_1__t1_b_n22)=0
.ic v(wl_1__t2_b_n22)=0 v(wl_1__t3_b_n22)=0 v(wl_2_b_n22)=0 v(wl_2__t0_b_n22)=0
.ic v(wl_2__t1_b_n22)=0 v(wl_2__t2_b_n22)=0 v(wl_2__t3_b_n22)=0 v(wl_3_b_n22)=0
.ic v(wl_3__t0_b_n22)=0 v(wl_3__t1_b_n22)=0 v(wl_3__t2_b_n22)=0 v(wl_3__t3_b_n22)=0
.ic v(gnd__t0_b_n23)=0 v(gnd__t1_b_n23)=0 v(gnd__t10_b_n23)=0 v(gnd__t11_b_n23)=0
.ic v(gnd__t12_b_n23)=0 v(gnd__t13_b_n23)=0 v(gnd__t14_b_n23)=0 v(gnd__t15_b_n23)=0
.ic v(gnd__t16_b_n23)=0 v(gnd__t17_b_n23)=0 v(gnd__t18_b_n23)=0 v(gnd__t19_b_n23)=0
.ic v(gnd__t2_b_n23)=0 v(gnd__t20_b_n23)=0 v(gnd__t21_b_n23)=0 v(gnd__t22_b_n23)=0
.ic v(gnd__t23_b_n23)=0 v(gnd__t24_b_n23)=0 v(gnd__t25_b_n23)=0 v(gnd__t26_b_n23)=0
.ic v(gnd__t27_b_n23)=0 v(gnd__t28_b_n23)=0 v(gnd__t29_b_n23)=0 v(gnd__t3_b_n23)=0
.ic v(gnd__t30_b_n23)=0 v(gnd__t31_b_n23)=0 v(gnd__t4_b_n23)=0 v(gnd__t5_b_n23)=0
.ic v(gnd__t6_b_n23)=0 v(gnd__t7_b_n23)=0 v(gnd__t8_b_n23)=0 v(gnd__t9_b_n23)=0
.ic v(n10_b_n23)=1 v(n10__t0_b_n23)=1 v(n10__t1_b_n23)=1 v(n17_b_n23)=1
.ic v(n17__t0_b_n23)=1 v(n17__t1_b_n23)=1 v(n18_b_n23)=1 v(n18__t0_b_n23)=1
.ic v(n18__t1_b_n23)=1 v(n19_b_n23)=1 v(n19__t0_b_n23)=1 v(n19__t1_b_n23)=1
.ic v(n20_b_n23)=1 v(n20__t0_b_n23)=1 v(n20__t1_b_n23)=1 v(n22_b_n23)=1
.ic v(n22__t0_b_n23)=1 v(n22__t1_b_n23)=1 v(n23_b_n23)=1.1 v(n23__t0_b_n23)=1.1
.ic v(n23__t1_b_n23)=1.1 v(n24_b_n23)=1 v(n24__t0_b_n23)=1 v(n24__t1_b_n23)=1
.ic v(n25_b_n23)=1 v(n25__t0_b_n23)=1 v(n25__t1_b_n23)=1 v(n29_b_n23)=1
.ic v(n29__t0_b_n23)=1 v(n29__t1_b_n23)=1 v(n30_b_n23)=1 v(n30__t0_b_n23)=1
.ic v(n30__t1_b_n23)=1 v(n31_b_n23)=1 v(n31__t0_b_n23)=1 v(n31__t1_b_n23)=1
.ic v(n32_b_n23)=1 v(n32__t0_b_n23)=1 v(n32__t1_b_n23)=1 v(n7_b_n23)=1
.ic v(n7__t0_b_n23)=1 v(n7__t1_b_n23)=1 v(n8_b_n23)=1 v(n8__t0_b_n23)=1
.ic v(n8__t1_b_n23)=1 v(n9_b_n23)=1 v(n9__t0_b_n23)=1 v(n9__t1_b_n23)=1
.ic v(bl_0_b_n23)=0 v(bl_0__t0_b_n23)=0 v(bl_0__t1_b_n23)=0 v(bl_0__t2_b_n23)=0
.ic v(bl_0__t3_b_n23)=0 v(bl_1_b_n23)=0 v(bl_1__t0_b_n23)=0 v(bl_1__t1_b_n23)=0
.ic v(bl_1__t2_b_n23)=0 v(bl_1__t3_b_n23)=0 v(bl_2_b_n23)=0 v(bl_2__t0_b_n23)=0
.ic v(bl_2__t1_b_n23)=0 v(bl_2__t2_b_n23)=0 v(bl_2__t3_b_n23)=0 v(bl_3_b_n23)=0
.ic v(bl_3__t0_b_n23)=0 v(bl_3__t1_b_n23)=0 v(bl_3__t2_b_n23)=0 v(bl_3__t3_b_n23)=0
.ic v(rbl_0_b_n23)=0 v(rbl_0__t0_b_n23)=0 v(rbl_0__t1_b_n23)=0 v(rbl_0__t2_b_n23)=0
.ic v(rbl_0__t3_b_n23)=0 v(rbl_1_b_n23)=0 v(rbl_1__t0_b_n23)=0 v(rbl_1__t1_b_n23)=0
.ic v(rbl_1__t2_b_n23)=0 v(rbl_1__t3_b_n23)=0 v(rbl_2_b_n23)=0 v(rbl_2__t0_b_n23)=0
.ic v(rbl_2__t1_b_n23)=0 v(rbl_2__t2_b_n23)=0 v(rbl_2__t3_b_n23)=0 v(rbl_3_b_n23)=0
.ic v(rbl_3__t0_b_n23)=0 v(rbl_3__t1_b_n23)=0 v(rbl_3__t2_b_n23)=0 v(rbl_3__t3_b_n23)=0
.ic v(rwl_0_b_n23)=0 v(rwl_0__t0_b_n23)=0 v(rwl_0__t1_b_n23)=0 v(rwl_0__t2_b_n23)=0
.ic v(rwl_0__t3_b_n23)=0 v(rwl_1_b_n23)=0 v(rwl_1__t0_b_n23)=0 v(rwl_1__t1_b_n23)=0
.ic v(rwl_1__t2_b_n23)=0 v(rwl_1__t3_b_n23)=0 v(rwl_2_b_n23)=0 v(rwl_2__t0_b_n23)=0
.ic v(rwl_2__t1_b_n23)=0 v(rwl_2__t2_b_n23)=0 v(rwl_2__t3_b_n23)=0 v(rwl_3_b_n23)=0
.ic v(rwl_3__t0_b_n23)=0 v(rwl_3__t1_b_n23)=0 v(rwl_3__t2_b_n23)=0 v(rwl_3__t3_b_n23)=0
.ic v(wl_0_b_n23)=0 v(wl_0__t0_b_n23)=0 v(wl_0__t1_b_n23)=0 v(wl_0__t2_b_n23)=0
.ic v(wl_0__t3_b_n23)=0 v(wl_1_b_n23)=0 v(wl_1__t0_b_n23)=0 v(wl_1__t1_b_n23)=0
.ic v(wl_1__t2_b_n23)=0 v(wl_1__t3_b_n23)=0 v(wl_2_b_n23)=0 v(wl_2__t0_b_n23)=0
.ic v(wl_2__t1_b_n23)=0 v(wl_2__t2_b_n23)=0 v(wl_2__t3_b_n23)=0 v(wl_3_b_n23)=0
.ic v(wl_3__t0_b_n23)=0 v(wl_3__t1_b_n23)=0 v(wl_3__t2_b_n23)=0 v(wl_3__t3_b_n23)=0
.ic v(gnd__t0_b_n24)=0 v(gnd__t1_b_n24)=0 v(gnd__t10_b_n24)=0 v(gnd__t11_b_n24)=0
.ic v(gnd__t12_b_n24)=0 v(gnd__t13_b_n24)=0 v(gnd__t14_b_n24)=0 v(gnd__t15_b_n24)=0
.ic v(gnd__t16_b_n24)=0 v(gnd__t17_b_n24)=0 v(gnd__t18_b_n24)=0 v(gnd__t19_b_n24)=0
.ic v(gnd__t2_b_n24)=0 v(gnd__t20_b_n24)=0 v(gnd__t21_b_n24)=0 v(gnd__t22_b_n24)=0
.ic v(gnd__t23_b_n24)=0 v(gnd__t24_b_n24)=0 v(gnd__t25_b_n24)=0 v(gnd__t26_b_n24)=0
.ic v(gnd__t27_b_n24)=0 v(gnd__t28_b_n24)=0 v(gnd__t29_b_n24)=0 v(gnd__t3_b_n24)=0
.ic v(gnd__t30_b_n24)=0 v(gnd__t31_b_n24)=0 v(gnd__t4_b_n24)=0 v(gnd__t5_b_n24)=0
.ic v(gnd__t6_b_n24)=0 v(gnd__t7_b_n24)=0 v(gnd__t8_b_n24)=0 v(gnd__t9_b_n24)=0
.ic v(n10_b_n24)=1 v(n10__t0_b_n24)=1 v(n10__t1_b_n24)=1 v(n17_b_n24)=1
.ic v(n17__t0_b_n24)=1 v(n17__t1_b_n24)=1 v(n18_b_n24)=1 v(n18__t0_b_n24)=1
.ic v(n18__t1_b_n24)=1 v(n19_b_n24)=1 v(n19__t0_b_n24)=1 v(n19__t1_b_n24)=1
.ic v(n20_b_n24)=1 v(n20__t0_b_n24)=1 v(n20__t1_b_n24)=1 v(n22_b_n24)=1
.ic v(n22__t0_b_n24)=1 v(n22__t1_b_n24)=1 v(n23_b_n24)=1 v(n23__t0_b_n24)=1
.ic v(n23__t1_b_n24)=1 v(n24_b_n24)=1.1 v(n24__t0_b_n24)=1.1 v(n24__t1_b_n24)=1.1
.ic v(n25_b_n24)=1 v(n25__t0_b_n24)=1 v(n25__t1_b_n24)=1 v(n29_b_n24)=1
.ic v(n29__t0_b_n24)=1 v(n29__t1_b_n24)=1 v(n30_b_n24)=1 v(n30__t0_b_n24)=1
.ic v(n30__t1_b_n24)=1 v(n31_b_n24)=1 v(n31__t0_b_n24)=1 v(n31__t1_b_n24)=1
.ic v(n32_b_n24)=1 v(n32__t0_b_n24)=1 v(n32__t1_b_n24)=1 v(n7_b_n24)=1
.ic v(n7__t0_b_n24)=1 v(n7__t1_b_n24)=1 v(n8_b_n24)=1 v(n8__t0_b_n24)=1
.ic v(n8__t1_b_n24)=1 v(n9_b_n24)=1 v(n9__t0_b_n24)=1 v(n9__t1_b_n24)=1
.ic v(bl_0_b_n24)=0 v(bl_0__t0_b_n24)=0 v(bl_0__t1_b_n24)=0 v(bl_0__t2_b_n24)=0
.ic v(bl_0__t3_b_n24)=0 v(bl_1_b_n24)=0 v(bl_1__t0_b_n24)=0 v(bl_1__t1_b_n24)=0
.ic v(bl_1__t2_b_n24)=0 v(bl_1__t3_b_n24)=0 v(bl_2_b_n24)=0 v(bl_2__t0_b_n24)=0
.ic v(bl_2__t1_b_n24)=0 v(bl_2__t2_b_n24)=0 v(bl_2__t3_b_n24)=0 v(bl_3_b_n24)=0
.ic v(bl_3__t0_b_n24)=0 v(bl_3__t1_b_n24)=0 v(bl_3__t2_b_n24)=0 v(bl_3__t3_b_n24)=0
.ic v(rbl_0_b_n24)=0 v(rbl_0__t0_b_n24)=0 v(rbl_0__t1_b_n24)=0 v(rbl_0__t2_b_n24)=0
.ic v(rbl_0__t3_b_n24)=0 v(rbl_1_b_n24)=0 v(rbl_1__t0_b_n24)=0 v(rbl_1__t1_b_n24)=0
.ic v(rbl_1__t2_b_n24)=0 v(rbl_1__t3_b_n24)=0 v(rbl_2_b_n24)=0 v(rbl_2__t0_b_n24)=0
.ic v(rbl_2__t1_b_n24)=0 v(rbl_2__t2_b_n24)=0 v(rbl_2__t3_b_n24)=0 v(rbl_3_b_n24)=0
.ic v(rbl_3__t0_b_n24)=0 v(rbl_3__t1_b_n24)=0 v(rbl_3__t2_b_n24)=0 v(rbl_3__t3_b_n24)=0
.ic v(rwl_0_b_n24)=0 v(rwl_0__t0_b_n24)=0 v(rwl_0__t1_b_n24)=0 v(rwl_0__t2_b_n24)=0
.ic v(rwl_0__t3_b_n24)=0 v(rwl_1_b_n24)=0 v(rwl_1__t0_b_n24)=0 v(rwl_1__t1_b_n24)=0
.ic v(rwl_1__t2_b_n24)=0 v(rwl_1__t3_b_n24)=0 v(rwl_2_b_n24)=0 v(rwl_2__t0_b_n24)=0
.ic v(rwl_2__t1_b_n24)=0 v(rwl_2__t2_b_n24)=0 v(rwl_2__t3_b_n24)=0 v(rwl_3_b_n24)=0
.ic v(rwl_3__t0_b_n24)=0 v(rwl_3__t1_b_n24)=0 v(rwl_3__t2_b_n24)=0 v(rwl_3__t3_b_n24)=0
.ic v(wl_0_b_n24)=0 v(wl_0__t0_b_n24)=0 v(wl_0__t1_b_n24)=0 v(wl_0__t2_b_n24)=0
.ic v(wl_0__t3_b_n24)=0 v(wl_1_b_n24)=0 v(wl_1__t0_b_n24)=0 v(wl_1__t1_b_n24)=0
.ic v(wl_1__t2_b_n24)=0 v(wl_1__t3_b_n24)=0 v(wl_2_b_n24)=0 v(wl_2__t0_b_n24)=0
.ic v(wl_2__t1_b_n24)=0 v(wl_2__t2_b_n24)=0 v(wl_2__t3_b_n24)=0 v(wl_3_b_n24)=0
.ic v(wl_3__t0_b_n24)=0 v(wl_3__t1_b_n24)=0 v(wl_3__t2_b_n24)=0 v(wl_3__t3_b_n24)=0
.ic v(gnd__t0_b_n25)=0 v(gnd__t1_b_n25)=0 v(gnd__t10_b_n25)=0 v(gnd__t11_b_n25)=0
.ic v(gnd__t12_b_n25)=0 v(gnd__t13_b_n25)=0 v(gnd__t14_b_n25)=0 v(gnd__t15_b_n25)=0
.ic v(gnd__t16_b_n25)=0 v(gnd__t17_b_n25)=0 v(gnd__t18_b_n25)=0 v(gnd__t19_b_n25)=0
.ic v(gnd__t2_b_n25)=0 v(gnd__t20_b_n25)=0 v(gnd__t21_b_n25)=0 v(gnd__t22_b_n25)=0
.ic v(gnd__t23_b_n25)=0 v(gnd__t24_b_n25)=0 v(gnd__t25_b_n25)=0 v(gnd__t26_b_n25)=0
.ic v(gnd__t27_b_n25)=0 v(gnd__t28_b_n25)=0 v(gnd__t29_b_n25)=0 v(gnd__t3_b_n25)=0
.ic v(gnd__t30_b_n25)=0 v(gnd__t31_b_n25)=0 v(gnd__t4_b_n25)=0 v(gnd__t5_b_n25)=0
.ic v(gnd__t6_b_n25)=0 v(gnd__t7_b_n25)=0 v(gnd__t8_b_n25)=0 v(gnd__t9_b_n25)=0
.ic v(n10_b_n25)=1 v(n10__t0_b_n25)=1 v(n10__t1_b_n25)=1 v(n17_b_n25)=1
.ic v(n17__t0_b_n25)=1 v(n17__t1_b_n25)=1 v(n18_b_n25)=1 v(n18__t0_b_n25)=1
.ic v(n18__t1_b_n25)=1 v(n19_b_n25)=1 v(n19__t0_b_n25)=1 v(n19__t1_b_n25)=1
.ic v(n20_b_n25)=1 v(n20__t0_b_n25)=1 v(n20__t1_b_n25)=1 v(n22_b_n25)=1
.ic v(n22__t0_b_n25)=1 v(n22__t1_b_n25)=1 v(n23_b_n25)=1 v(n23__t0_b_n25)=1
.ic v(n23__t1_b_n25)=1 v(n24_b_n25)=1 v(n24__t0_b_n25)=1 v(n24__t1_b_n25)=1
.ic v(n25_b_n25)=1.1 v(n25__t0_b_n25)=1.1 v(n25__t1_b_n25)=1.1 v(n29_b_n25)=1
.ic v(n29__t0_b_n25)=1 v(n29__t1_b_n25)=1 v(n30_b_n25)=1 v(n30__t0_b_n25)=1
.ic v(n30__t1_b_n25)=1 v(n31_b_n25)=1 v(n31__t0_b_n25)=1 v(n31__t1_b_n25)=1
.ic v(n32_b_n25)=1 v(n32__t0_b_n25)=1 v(n32__t1_b_n25)=1 v(n7_b_n25)=1
.ic v(n7__t0_b_n25)=1 v(n7__t1_b_n25)=1 v(n8_b_n25)=1 v(n8__t0_b_n25)=1
.ic v(n8__t1_b_n25)=1 v(n9_b_n25)=1 v(n9__t0_b_n25)=1 v(n9__t1_b_n25)=1
.ic v(bl_0_b_n25)=0 v(bl_0__t0_b_n25)=0 v(bl_0__t1_b_n25)=0 v(bl_0__t2_b_n25)=0
.ic v(bl_0__t3_b_n25)=0 v(bl_1_b_n25)=0 v(bl_1__t0_b_n25)=0 v(bl_1__t1_b_n25)=0
.ic v(bl_1__t2_b_n25)=0 v(bl_1__t3_b_n25)=0 v(bl_2_b_n25)=0 v(bl_2__t0_b_n25)=0
.ic v(bl_2__t1_b_n25)=0 v(bl_2__t2_b_n25)=0 v(bl_2__t3_b_n25)=0 v(bl_3_b_n25)=0
.ic v(bl_3__t0_b_n25)=0 v(bl_3__t1_b_n25)=0 v(bl_3__t2_b_n25)=0 v(bl_3__t3_b_n25)=0
.ic v(rbl_0_b_n25)=0 v(rbl_0__t0_b_n25)=0 v(rbl_0__t1_b_n25)=0 v(rbl_0__t2_b_n25)=0
.ic v(rbl_0__t3_b_n25)=0 v(rbl_1_b_n25)=0 v(rbl_1__t0_b_n25)=0 v(rbl_1__t1_b_n25)=0
.ic v(rbl_1__t2_b_n25)=0 v(rbl_1__t3_b_n25)=0 v(rbl_2_b_n25)=0 v(rbl_2__t0_b_n25)=0
.ic v(rbl_2__t1_b_n25)=0 v(rbl_2__t2_b_n25)=0 v(rbl_2__t3_b_n25)=0 v(rbl_3_b_n25)=0
.ic v(rbl_3__t0_b_n25)=0 v(rbl_3__t1_b_n25)=0 v(rbl_3__t2_b_n25)=0 v(rbl_3__t3_b_n25)=0
.ic v(rwl_0_b_n25)=0 v(rwl_0__t0_b_n25)=0 v(rwl_0__t1_b_n25)=0 v(rwl_0__t2_b_n25)=0
.ic v(rwl_0__t3_b_n25)=0 v(rwl_1_b_n25)=0 v(rwl_1__t0_b_n25)=0 v(rwl_1__t1_b_n25)=0
.ic v(rwl_1__t2_b_n25)=0 v(rwl_1__t3_b_n25)=0 v(rwl_2_b_n25)=0 v(rwl_2__t0_b_n25)=0
.ic v(rwl_2__t1_b_n25)=0 v(rwl_2__t2_b_n25)=0 v(rwl_2__t3_b_n25)=0 v(rwl_3_b_n25)=0
.ic v(rwl_3__t0_b_n25)=0 v(rwl_3__t1_b_n25)=0 v(rwl_3__t2_b_n25)=0 v(rwl_3__t3_b_n25)=0
.ic v(wl_0_b_n25)=0 v(wl_0__t0_b_n25)=0 v(wl_0__t1_b_n25)=0 v(wl_0__t2_b_n25)=0
.ic v(wl_0__t3_b_n25)=0 v(wl_1_b_n25)=0 v(wl_1__t0_b_n25)=0 v(wl_1__t1_b_n25)=0
.ic v(wl_1__t2_b_n25)=0 v(wl_1__t3_b_n25)=0 v(wl_2_b_n25)=0 v(wl_2__t0_b_n25)=0
.ic v(wl_2__t1_b_n25)=0 v(wl_2__t2_b_n25)=0 v(wl_2__t3_b_n25)=0 v(wl_3_b_n25)=0
.ic v(wl_3__t0_b_n25)=0 v(wl_3__t1_b_n25)=0 v(wl_3__t2_b_n25)=0 v(wl_3__t3_b_n25)=0
.ic v(gnd__t0_b_n29)=0 v(gnd__t1_b_n29)=0 v(gnd__t10_b_n29)=0 v(gnd__t11_b_n29)=0
.ic v(gnd__t12_b_n29)=0 v(gnd__t13_b_n29)=0 v(gnd__t14_b_n29)=0 v(gnd__t15_b_n29)=0
.ic v(gnd__t16_b_n29)=0 v(gnd__t17_b_n29)=0 v(gnd__t18_b_n29)=0 v(gnd__t19_b_n29)=0
.ic v(gnd__t2_b_n29)=0 v(gnd__t20_b_n29)=0 v(gnd__t21_b_n29)=0 v(gnd__t22_b_n29)=0
.ic v(gnd__t23_b_n29)=0 v(gnd__t24_b_n29)=0 v(gnd__t25_b_n29)=0 v(gnd__t26_b_n29)=0
.ic v(gnd__t27_b_n29)=0 v(gnd__t28_b_n29)=0 v(gnd__t29_b_n29)=0 v(gnd__t3_b_n29)=0
.ic v(gnd__t30_b_n29)=0 v(gnd__t31_b_n29)=0 v(gnd__t4_b_n29)=0 v(gnd__t5_b_n29)=0
.ic v(gnd__t6_b_n29)=0 v(gnd__t7_b_n29)=0 v(gnd__t8_b_n29)=0 v(gnd__t9_b_n29)=0
.ic v(n10_b_n29)=1 v(n10__t0_b_n29)=1 v(n10__t1_b_n29)=1 v(n17_b_n29)=1
.ic v(n17__t0_b_n29)=1 v(n17__t1_b_n29)=1 v(n18_b_n29)=1 v(n18__t0_b_n29)=1
.ic v(n18__t1_b_n29)=1 v(n19_b_n29)=1 v(n19__t0_b_n29)=1 v(n19__t1_b_n29)=1
.ic v(n20_b_n29)=1 v(n20__t0_b_n29)=1 v(n20__t1_b_n29)=1 v(n22_b_n29)=1
.ic v(n22__t0_b_n29)=1 v(n22__t1_b_n29)=1 v(n23_b_n29)=1 v(n23__t0_b_n29)=1
.ic v(n23__t1_b_n29)=1 v(n24_b_n29)=1 v(n24__t0_b_n29)=1 v(n24__t1_b_n29)=1
.ic v(n25_b_n29)=1 v(n25__t0_b_n29)=1 v(n25__t1_b_n29)=1 v(n29_b_n29)=1.1
.ic v(n29__t0_b_n29)=1.1 v(n29__t1_b_n29)=1.1 v(n30_b_n29)=1 v(n30__t0_b_n29)=1
.ic v(n30__t1_b_n29)=1 v(n31_b_n29)=1 v(n31__t0_b_n29)=1 v(n31__t1_b_n29)=1
.ic v(n32_b_n29)=1 v(n32__t0_b_n29)=1 v(n32__t1_b_n29)=1 v(n7_b_n29)=1
.ic v(n7__t0_b_n29)=1 v(n7__t1_b_n29)=1 v(n8_b_n29)=1 v(n8__t0_b_n29)=1
.ic v(n8__t1_b_n29)=1 v(n9_b_n29)=1 v(n9__t0_b_n29)=1 v(n9__t1_b_n29)=1
.ic v(bl_0_b_n29)=0 v(bl_0__t0_b_n29)=0 v(bl_0__t1_b_n29)=0 v(bl_0__t2_b_n29)=0
.ic v(bl_0__t3_b_n29)=0 v(bl_1_b_n29)=0 v(bl_1__t0_b_n29)=0 v(bl_1__t1_b_n29)=0
.ic v(bl_1__t2_b_n29)=0 v(bl_1__t3_b_n29)=0 v(bl_2_b_n29)=0 v(bl_2__t0_b_n29)=0
.ic v(bl_2__t1_b_n29)=0 v(bl_2__t2_b_n29)=0 v(bl_2__t3_b_n29)=0 v(bl_3_b_n29)=0
.ic v(bl_3__t0_b_n29)=0 v(bl_3__t1_b_n29)=0 v(bl_3__t2_b_n29)=0 v(bl_3__t3_b_n29)=0
.ic v(rbl_0_b_n29)=0 v(rbl_0__t0_b_n29)=0 v(rbl_0__t1_b_n29)=0 v(rbl_0__t2_b_n29)=0
.ic v(rbl_0__t3_b_n29)=0 v(rbl_1_b_n29)=0 v(rbl_1__t0_b_n29)=0 v(rbl_1__t1_b_n29)=0
.ic v(rbl_1__t2_b_n29)=0 v(rbl_1__t3_b_n29)=0 v(rbl_2_b_n29)=0 v(rbl_2__t0_b_n29)=0
.ic v(rbl_2__t1_b_n29)=0 v(rbl_2__t2_b_n29)=0 v(rbl_2__t3_b_n29)=0 v(rbl_3_b_n29)=0
.ic v(rbl_3__t0_b_n29)=0 v(rbl_3__t1_b_n29)=0 v(rbl_3__t2_b_n29)=0 v(rbl_3__t3_b_n29)=0
.ic v(rwl_0_b_n29)=0 v(rwl_0__t0_b_n29)=0 v(rwl_0__t1_b_n29)=0 v(rwl_0__t2_b_n29)=0
.ic v(rwl_0__t3_b_n29)=0 v(rwl_1_b_n29)=0 v(rwl_1__t0_b_n29)=0 v(rwl_1__t1_b_n29)=0
.ic v(rwl_1__t2_b_n29)=0 v(rwl_1__t3_b_n29)=0 v(rwl_2_b_n29)=0 v(rwl_2__t0_b_n29)=0
.ic v(rwl_2__t1_b_n29)=0 v(rwl_2__t2_b_n29)=0 v(rwl_2__t3_b_n29)=0 v(rwl_3_b_n29)=0
.ic v(rwl_3__t0_b_n29)=0 v(rwl_3__t1_b_n29)=0 v(rwl_3__t2_b_n29)=0 v(rwl_3__t3_b_n29)=0
.ic v(wl_0_b_n29)=0 v(wl_0__t0_b_n29)=0 v(wl_0__t1_b_n29)=0 v(wl_0__t2_b_n29)=0
.ic v(wl_0__t3_b_n29)=0 v(wl_1_b_n29)=0 v(wl_1__t0_b_n29)=0 v(wl_1__t1_b_n29)=0
.ic v(wl_1__t2_b_n29)=0 v(wl_1__t3_b_n29)=0 v(wl_2_b_n29)=0 v(wl_2__t0_b_n29)=0
.ic v(wl_2__t1_b_n29)=0 v(wl_2__t2_b_n29)=0 v(wl_2__t3_b_n29)=0 v(wl_3_b_n29)=0
.ic v(wl_3__t0_b_n29)=0 v(wl_3__t1_b_n29)=0 v(wl_3__t2_b_n29)=0 v(wl_3__t3_b_n29)=0
.ic v(gnd__t0_b_n30)=0 v(gnd__t1_b_n30)=0 v(gnd__t10_b_n30)=0 v(gnd__t11_b_n30)=0
.ic v(gnd__t12_b_n30)=0 v(gnd__t13_b_n30)=0 v(gnd__t14_b_n30)=0 v(gnd__t15_b_n30)=0
.ic v(gnd__t16_b_n30)=0 v(gnd__t17_b_n30)=0 v(gnd__t18_b_n30)=0 v(gnd__t19_b_n30)=0
.ic v(gnd__t2_b_n30)=0 v(gnd__t20_b_n30)=0 v(gnd__t21_b_n30)=0 v(gnd__t22_b_n30)=0
.ic v(gnd__t23_b_n30)=0 v(gnd__t24_b_n30)=0 v(gnd__t25_b_n30)=0 v(gnd__t26_b_n30)=0
.ic v(gnd__t27_b_n30)=0 v(gnd__t28_b_n30)=0 v(gnd__t29_b_n30)=0 v(gnd__t3_b_n30)=0
.ic v(gnd__t30_b_n30)=0 v(gnd__t31_b_n30)=0 v(gnd__t4_b_n30)=0 v(gnd__t5_b_n30)=0
.ic v(gnd__t6_b_n30)=0 v(gnd__t7_b_n30)=0 v(gnd__t8_b_n30)=0 v(gnd__t9_b_n30)=0
.ic v(n10_b_n30)=1 v(n10__t0_b_n30)=1 v(n10__t1_b_n30)=1 v(n17_b_n30)=1
.ic v(n17__t0_b_n30)=1 v(n17__t1_b_n30)=1 v(n18_b_n30)=1 v(n18__t0_b_n30)=1
.ic v(n18__t1_b_n30)=1 v(n19_b_n30)=1 v(n19__t0_b_n30)=1 v(n19__t1_b_n30)=1
.ic v(n20_b_n30)=1 v(n20__t0_b_n30)=1 v(n20__t1_b_n30)=1 v(n22_b_n30)=1
.ic v(n22__t0_b_n30)=1 v(n22__t1_b_n30)=1 v(n23_b_n30)=1 v(n23__t0_b_n30)=1
.ic v(n23__t1_b_n30)=1 v(n24_b_n30)=1 v(n24__t0_b_n30)=1 v(n24__t1_b_n30)=1
.ic v(n25_b_n30)=1 v(n25__t0_b_n30)=1 v(n25__t1_b_n30)=1 v(n29_b_n30)=1
.ic v(n29__t0_b_n30)=1 v(n29__t1_b_n30)=1 v(n30_b_n30)=1.1 v(n30__t0_b_n30)=1.1
.ic v(n30__t1_b_n30)=1.1 v(n31_b_n30)=1 v(n31__t0_b_n30)=1 v(n31__t1_b_n30)=1
.ic v(n32_b_n30)=1 v(n32__t0_b_n30)=1 v(n32__t1_b_n30)=1 v(n7_b_n30)=1
.ic v(n7__t0_b_n30)=1 v(n7__t1_b_n30)=1 v(n8_b_n30)=1 v(n8__t0_b_n30)=1
.ic v(n8__t1_b_n30)=1 v(n9_b_n30)=1 v(n9__t0_b_n30)=1 v(n9__t1_b_n30)=1
.ic v(bl_0_b_n30)=0 v(bl_0__t0_b_n30)=0 v(bl_0__t1_b_n30)=0 v(bl_0__t2_b_n30)=0
.ic v(bl_0__t3_b_n30)=0 v(bl_1_b_n30)=0 v(bl_1__t0_b_n30)=0 v(bl_1__t1_b_n30)=0
.ic v(bl_1__t2_b_n30)=0 v(bl_1__t3_b_n30)=0 v(bl_2_b_n30)=0 v(bl_2__t0_b_n30)=0
.ic v(bl_2__t1_b_n30)=0 v(bl_2__t2_b_n30)=0 v(bl_2__t3_b_n30)=0 v(bl_3_b_n30)=0
.ic v(bl_3__t0_b_n30)=0 v(bl_3__t1_b_n30)=0 v(bl_3__t2_b_n30)=0 v(bl_3__t3_b_n30)=0
.ic v(rbl_0_b_n30)=0 v(rbl_0__t0_b_n30)=0 v(rbl_0__t1_b_n30)=0 v(rbl_0__t2_b_n30)=0
.ic v(rbl_0__t3_b_n30)=0 v(rbl_1_b_n30)=0 v(rbl_1__t0_b_n30)=0 v(rbl_1__t1_b_n30)=0
.ic v(rbl_1__t2_b_n30)=0 v(rbl_1__t3_b_n30)=0 v(rbl_2_b_n30)=0 v(rbl_2__t0_b_n30)=0
.ic v(rbl_2__t1_b_n30)=0 v(rbl_2__t2_b_n30)=0 v(rbl_2__t3_b_n30)=0 v(rbl_3_b_n30)=0
.ic v(rbl_3__t0_b_n30)=0 v(rbl_3__t1_b_n30)=0 v(rbl_3__t2_b_n30)=0 v(rbl_3__t3_b_n30)=0
.ic v(rwl_0_b_n30)=0 v(rwl_0__t0_b_n30)=0 v(rwl_0__t1_b_n30)=0 v(rwl_0__t2_b_n30)=0
.ic v(rwl_0__t3_b_n30)=0 v(rwl_1_b_n30)=0 v(rwl_1__t0_b_n30)=0 v(rwl_1__t1_b_n30)=0
.ic v(rwl_1__t2_b_n30)=0 v(rwl_1__t3_b_n30)=0 v(rwl_2_b_n30)=0 v(rwl_2__t0_b_n30)=0
.ic v(rwl_2__t1_b_n30)=0 v(rwl_2__t2_b_n30)=0 v(rwl_2__t3_b_n30)=0 v(rwl_3_b_n30)=0
.ic v(rwl_3__t0_b_n30)=0 v(rwl_3__t1_b_n30)=0 v(rwl_3__t2_b_n30)=0 v(rwl_3__t3_b_n30)=0
.ic v(wl_0_b_n30)=0 v(wl_0__t0_b_n30)=0 v(wl_0__t1_b_n30)=0 v(wl_0__t2_b_n30)=0
.ic v(wl_0__t3_b_n30)=0 v(wl_1_b_n30)=0 v(wl_1__t0_b_n30)=0 v(wl_1__t1_b_n30)=0
.ic v(wl_1__t2_b_n30)=0 v(wl_1__t3_b_n30)=0 v(wl_2_b_n30)=0 v(wl_2__t0_b_n30)=0
.ic v(wl_2__t1_b_n30)=0 v(wl_2__t2_b_n30)=0 v(wl_2__t3_b_n30)=0 v(wl_3_b_n30)=0
.ic v(wl_3__t0_b_n30)=0 v(wl_3__t1_b_n30)=0 v(wl_3__t2_b_n30)=0 v(wl_3__t3_b_n30)=0
.ic v(gnd__t0_b_n31)=0 v(gnd__t1_b_n31)=0 v(gnd__t10_b_n31)=0 v(gnd__t11_b_n31)=0
.ic v(gnd__t12_b_n31)=0 v(gnd__t13_b_n31)=0 v(gnd__t14_b_n31)=0 v(gnd__t15_b_n31)=0
.ic v(gnd__t16_b_n31)=0 v(gnd__t17_b_n31)=0 v(gnd__t18_b_n31)=0 v(gnd__t19_b_n31)=0
.ic v(gnd__t2_b_n31)=0 v(gnd__t20_b_n31)=0 v(gnd__t21_b_n31)=0 v(gnd__t22_b_n31)=0
.ic v(gnd__t23_b_n31)=0 v(gnd__t24_b_n31)=0 v(gnd__t25_b_n31)=0 v(gnd__t26_b_n31)=0
.ic v(gnd__t27_b_n31)=0 v(gnd__t28_b_n31)=0 v(gnd__t29_b_n31)=0 v(gnd__t3_b_n31)=0
.ic v(gnd__t30_b_n31)=0 v(gnd__t31_b_n31)=0 v(gnd__t4_b_n31)=0 v(gnd__t5_b_n31)=0
.ic v(gnd__t6_b_n31)=0 v(gnd__t7_b_n31)=0 v(gnd__t8_b_n31)=0 v(gnd__t9_b_n31)=0
.ic v(n10_b_n31)=1 v(n10__t0_b_n31)=1 v(n10__t1_b_n31)=1 v(n17_b_n31)=1
.ic v(n17__t0_b_n31)=1 v(n17__t1_b_n31)=1 v(n18_b_n31)=1 v(n18__t0_b_n31)=1
.ic v(n18__t1_b_n31)=1 v(n19_b_n31)=1 v(n19__t0_b_n31)=1 v(n19__t1_b_n31)=1
.ic v(n20_b_n31)=1 v(n20__t0_b_n31)=1 v(n20__t1_b_n31)=1 v(n22_b_n31)=1
.ic v(n22__t0_b_n31)=1 v(n22__t1_b_n31)=1 v(n23_b_n31)=1 v(n23__t0_b_n31)=1
.ic v(n23__t1_b_n31)=1 v(n24_b_n31)=1 v(n24__t0_b_n31)=1 v(n24__t1_b_n31)=1
.ic v(n25_b_n31)=1 v(n25__t0_b_n31)=1 v(n25__t1_b_n31)=1 v(n29_b_n31)=1
.ic v(n29__t0_b_n31)=1 v(n29__t1_b_n31)=1 v(n30_b_n31)=1 v(n30__t0_b_n31)=1
.ic v(n30__t1_b_n31)=1 v(n31_b_n31)=1.1 v(n31__t0_b_n31)=1.1 v(n31__t1_b_n31)=1.1
.ic v(n32_b_n31)=1 v(n32__t0_b_n31)=1 v(n32__t1_b_n31)=1 v(n7_b_n31)=1
.ic v(n7__t0_b_n31)=1 v(n7__t1_b_n31)=1 v(n8_b_n31)=1 v(n8__t0_b_n31)=1
.ic v(n8__t1_b_n31)=1 v(n9_b_n31)=1 v(n9__t0_b_n31)=1 v(n9__t1_b_n31)=1
.ic v(bl_0_b_n31)=0 v(bl_0__t0_b_n31)=0 v(bl_0__t1_b_n31)=0 v(bl_0__t2_b_n31)=0
.ic v(bl_0__t3_b_n31)=0 v(bl_1_b_n31)=0 v(bl_1__t0_b_n31)=0 v(bl_1__t1_b_n31)=0
.ic v(bl_1__t2_b_n31)=0 v(bl_1__t3_b_n31)=0 v(bl_2_b_n31)=0 v(bl_2__t0_b_n31)=0
.ic v(bl_2__t1_b_n31)=0 v(bl_2__t2_b_n31)=0 v(bl_2__t3_b_n31)=0 v(bl_3_b_n31)=0
.ic v(bl_3__t0_b_n31)=0 v(bl_3__t1_b_n31)=0 v(bl_3__t2_b_n31)=0 v(bl_3__t3_b_n31)=0
.ic v(rbl_0_b_n31)=0 v(rbl_0__t0_b_n31)=0 v(rbl_0__t1_b_n31)=0 v(rbl_0__t2_b_n31)=0
.ic v(rbl_0__t3_b_n31)=0 v(rbl_1_b_n31)=0 v(rbl_1__t0_b_n31)=0 v(rbl_1__t1_b_n31)=0
.ic v(rbl_1__t2_b_n31)=0 v(rbl_1__t3_b_n31)=0 v(rbl_2_b_n31)=0 v(rbl_2__t0_b_n31)=0
.ic v(rbl_2__t1_b_n31)=0 v(rbl_2__t2_b_n31)=0 v(rbl_2__t3_b_n31)=0 v(rbl_3_b_n31)=0
.ic v(rbl_3__t0_b_n31)=0 v(rbl_3__t1_b_n31)=0 v(rbl_3__t2_b_n31)=0 v(rbl_3__t3_b_n31)=0
.ic v(rwl_0_b_n31)=0 v(rwl_0__t0_b_n31)=0 v(rwl_0__t1_b_n31)=0 v(rwl_0__t2_b_n31)=0
.ic v(rwl_0__t3_b_n31)=0 v(rwl_1_b_n31)=0 v(rwl_1__t0_b_n31)=0 v(rwl_1__t1_b_n31)=0
.ic v(rwl_1__t2_b_n31)=0 v(rwl_1__t3_b_n31)=0 v(rwl_2_b_n31)=0 v(rwl_2__t0_b_n31)=0
.ic v(rwl_2__t1_b_n31)=0 v(rwl_2__t2_b_n31)=0 v(rwl_2__t3_b_n31)=0 v(rwl_3_b_n31)=0
.ic v(rwl_3__t0_b_n31)=0 v(rwl_3__t1_b_n31)=0 v(rwl_3__t2_b_n31)=0 v(rwl_3__t3_b_n31)=0
.ic v(wl_0_b_n31)=0 v(wl_0__t0_b_n31)=0 v(wl_0__t1_b_n31)=0 v(wl_0__t2_b_n31)=0
.ic v(wl_0__t3_b_n31)=0 v(wl_1_b_n31)=0 v(wl_1__t0_b_n31)=0 v(wl_1__t1_b_n31)=0
.ic v(wl_1__t2_b_n31)=0 v(wl_1__t3_b_n31)=0 v(wl_2_b_n31)=0 v(wl_2__t0_b_n31)=0
.ic v(wl_2__t1_b_n31)=0 v(wl_2__t2_b_n31)=0 v(wl_2__t3_b_n31)=0 v(wl_3_b_n31)=0
.ic v(wl_3__t0_b_n31)=0 v(wl_3__t1_b_n31)=0 v(wl_3__t2_b_n31)=0 v(wl_3__t3_b_n31)=0
.ic v(gnd__t0_b_n32)=0 v(gnd__t1_b_n32)=0 v(gnd__t10_b_n32)=0 v(gnd__t11_b_n32)=0
.ic v(gnd__t12_b_n32)=0 v(gnd__t13_b_n32)=0 v(gnd__t14_b_n32)=0 v(gnd__t15_b_n32)=0
.ic v(gnd__t16_b_n32)=0 v(gnd__t17_b_n32)=0 v(gnd__t18_b_n32)=0 v(gnd__t19_b_n32)=0
.ic v(gnd__t2_b_n32)=0 v(gnd__t20_b_n32)=0 v(gnd__t21_b_n32)=0 v(gnd__t22_b_n32)=0
.ic v(gnd__t23_b_n32)=0 v(gnd__t24_b_n32)=0 v(gnd__t25_b_n32)=0 v(gnd__t26_b_n32)=0
.ic v(gnd__t27_b_n32)=0 v(gnd__t28_b_n32)=0 v(gnd__t29_b_n32)=0 v(gnd__t3_b_n32)=0
.ic v(gnd__t30_b_n32)=0 v(gnd__t31_b_n32)=0 v(gnd__t4_b_n32)=0 v(gnd__t5_b_n32)=0
.ic v(gnd__t6_b_n32)=0 v(gnd__t7_b_n32)=0 v(gnd__t8_b_n32)=0 v(gnd__t9_b_n32)=0
.ic v(n10_b_n32)=1 v(n10__t0_b_n32)=1 v(n10__t1_b_n32)=1 v(n17_b_n32)=1
.ic v(n17__t0_b_n32)=1 v(n17__t1_b_n32)=1 v(n18_b_n32)=1 v(n18__t0_b_n32)=1
.ic v(n18__t1_b_n32)=1 v(n19_b_n32)=1 v(n19__t0_b_n32)=1 v(n19__t1_b_n32)=1
.ic v(n20_b_n32)=1 v(n20__t0_b_n32)=1 v(n20__t1_b_n32)=1 v(n22_b_n32)=1
.ic v(n22__t0_b_n32)=1 v(n22__t1_b_n32)=1 v(n23_b_n32)=1 v(n23__t0_b_n32)=1
.ic v(n23__t1_b_n32)=1 v(n24_b_n32)=1 v(n24__t0_b_n32)=1 v(n24__t1_b_n32)=1
.ic v(n25_b_n32)=1 v(n25__t0_b_n32)=1 v(n25__t1_b_n32)=1 v(n29_b_n32)=1
.ic v(n29__t0_b_n32)=1 v(n29__t1_b_n32)=1 v(n30_b_n32)=1 v(n30__t0_b_n32)=1
.ic v(n30__t1_b_n32)=1 v(n31_b_n32)=1 v(n31__t0_b_n32)=1 v(n31__t1_b_n32)=1
.ic v(n32_b_n32)=1.1 v(n32__t0_b_n32)=1.1 v(n32__t1_b_n32)=1.1 v(n7_b_n32)=1
.ic v(n7__t0_b_n32)=1 v(n7__t1_b_n32)=1 v(n8_b_n32)=1 v(n8__t0_b_n32)=1
.ic v(n8__t1_b_n32)=1 v(n9_b_n32)=1 v(n9__t0_b_n32)=1 v(n9__t1_b_n32)=1
.ic v(bl_0_b_n32)=0 v(bl_0__t0_b_n32)=0 v(bl_0__t1_b_n32)=0 v(bl_0__t2_b_n32)=0
.ic v(bl_0__t3_b_n32)=0 v(bl_1_b_n32)=0 v(bl_1__t0_b_n32)=0 v(bl_1__t1_b_n32)=0
.ic v(bl_1__t2_b_n32)=0 v(bl_1__t3_b_n32)=0 v(bl_2_b_n32)=0 v(bl_2__t0_b_n32)=0
.ic v(bl_2__t1_b_n32)=0 v(bl_2__t2_b_n32)=0 v(bl_2__t3_b_n32)=0 v(bl_3_b_n32)=0
.ic v(bl_3__t0_b_n32)=0 v(bl_3__t1_b_n32)=0 v(bl_3__t2_b_n32)=0 v(bl_3__t3_b_n32)=0
.ic v(rbl_0_b_n32)=0 v(rbl_0__t0_b_n32)=0 v(rbl_0__t1_b_n32)=0 v(rbl_0__t2_b_n32)=0
.ic v(rbl_0__t3_b_n32)=0 v(rbl_1_b_n32)=0 v(rbl_1__t0_b_n32)=0 v(rbl_1__t1_b_n32)=0
.ic v(rbl_1__t2_b_n32)=0 v(rbl_1__t3_b_n32)=0 v(rbl_2_b_n32)=0 v(rbl_2__t0_b_n32)=0
.ic v(rbl_2__t1_b_n32)=0 v(rbl_2__t2_b_n32)=0 v(rbl_2__t3_b_n32)=0 v(rbl_3_b_n32)=0
.ic v(rbl_3__t0_b_n32)=0 v(rbl_3__t1_b_n32)=0 v(rbl_3__t2_b_n32)=0 v(rbl_3__t3_b_n32)=0
.ic v(rwl_0_b_n32)=0 v(rwl_0__t0_b_n32)=0 v(rwl_0__t1_b_n32)=0 v(rwl_0__t2_b_n32)=0
.ic v(rwl_0__t3_b_n32)=0 v(rwl_1_b_n32)=0 v(rwl_1__t0_b_n32)=0 v(rwl_1__t1_b_n32)=0
.ic v(rwl_1__t2_b_n32)=0 v(rwl_1__t3_b_n32)=0 v(rwl_2_b_n32)=0 v(rwl_2__t0_b_n32)=0
.ic v(rwl_2__t1_b_n32)=0 v(rwl_2__t2_b_n32)=0 v(rwl_2__t3_b_n32)=0 v(rwl_3_b_n32)=0
.ic v(rwl_3__t0_b_n32)=0 v(rwl_3__t1_b_n32)=0 v(rwl_3__t2_b_n32)=0 v(rwl_3__t3_b_n32)=0
.ic v(wl_0_b_n32)=0 v(wl_0__t0_b_n32)=0 v(wl_0__t1_b_n32)=0 v(wl_0__t2_b_n32)=0
.ic v(wl_0__t3_b_n32)=0 v(wl_1_b_n32)=0 v(wl_1__t0_b_n32)=0 v(wl_1__t1_b_n32)=0
.ic v(wl_1__t2_b_n32)=0 v(wl_1__t3_b_n32)=0 v(wl_2_b_n32)=0 v(wl_2__t0_b_n32)=0
.ic v(wl_2__t1_b_n32)=0 v(wl_2__t2_b_n32)=0 v(wl_2__t3_b_n32)=0 v(wl_3_b_n32)=0
.ic v(wl_3__t0_b_n32)=0 v(wl_3__t1_b_n32)=0 v(wl_3__t2_b_n32)=0 v(wl_3__t3_b_n32)=0
.ic v(gnd__t0_rate)=0 v(gnd__t1_rate)=0 v(gnd__t10_rate)=0 v(gnd__t11_rate)=0
.ic v(gnd__t12_rate)=0 v(gnd__t13_rate)=0 v(gnd__t14_rate)=0 v(gnd__t15_rate)=0
.ic v(gnd__t16_rate)=0 v(gnd__t17_rate)=0 v(gnd__t18_rate)=0 v(gnd__t19_rate)=0
.ic v(gnd__t2_rate)=0 v(gnd__t20_rate)=0 v(gnd__t21_rate)=0 v(gnd__t22_rate)=0
.ic v(gnd__t23_rate)=0 v(gnd__t24_rate)=0 v(gnd__t25_rate)=0 v(gnd__t26_rate)=0
.ic v(gnd__t27_rate)=0 v(gnd__t28_rate)=0 v(gnd__t29_rate)=0 v(gnd__t3_rate)=0
.ic v(gnd__t30_rate)=0 v(gnd__t31_rate)=0 v(gnd__t4_rate)=0 v(gnd__t5_rate)=0
.ic v(gnd__t6_rate)=0 v(gnd__t7_rate)=0 v(gnd__t8_rate)=0 v(gnd__t9_rate)=0
.ic v(n10_rate)=1 v(n10__t0_rate)=1 v(n10__t1_rate)=1 v(n17_rate)=1
.ic v(n17__t0_rate)=1 v(n17__t1_rate)=1 v(n18_rate)=1 v(n18__t0_rate)=1
.ic v(n18__t1_rate)=1 v(n19_rate)=1 v(n19__t0_rate)=1 v(n19__t1_rate)=1
.ic v(n20_rate)=1.1 v(n20__t0_rate)=1.1 v(n20__t1_rate)=1.1 v(n22_rate)=1
.ic v(n22__t0_rate)=1 v(n22__t1_rate)=1 v(n23_rate)=1 v(n23__t0_rate)=1
.ic v(n23__t1_rate)=1 v(n24_rate)=1 v(n24__t0_rate)=1 v(n24__t1_rate)=1
.ic v(n25_rate)=1 v(n25__t0_rate)=1 v(n25__t1_rate)=1 v(n29_rate)=1
.ic v(n29__t0_rate)=1 v(n29__t1_rate)=1 v(n30_rate)=1 v(n30__t0_rate)=1
.ic v(n30__t1_rate)=1 v(n31_rate)=1 v(n31__t0_rate)=1 v(n31__t1_rate)=1
.ic v(n32_rate)=1 v(n32__t0_rate)=1 v(n32__t1_rate)=1 v(n7_rate)=1
.ic v(n7__t0_rate)=1 v(n7__t1_rate)=1 v(n8_rate)=1 v(n8__t0_rate)=1
.ic v(n8__t1_rate)=1 v(n9_rate)=1 v(n9__t0_rate)=1 v(n9__t1_rate)=1
.ic v(bl_0_rate)=0 v(bl_0__t0_rate)=0 v(bl_0__t1_rate)=0 v(bl_0__t2_rate)=0
.ic v(bl_0__t3_rate)=0 v(bl_1_rate)=0 v(bl_1__t0_rate)=0 v(bl_1__t1_rate)=0
.ic v(bl_1__t2_rate)=0 v(bl_1__t3_rate)=0 v(bl_2_rate)=0 v(bl_2__t0_rate)=0
.ic v(bl_2__t1_rate)=0 v(bl_2__t2_rate)=0 v(bl_2__t3_rate)=0 v(bl_3_rate)=0
.ic v(bl_3__t0_rate)=0 v(bl_3__t1_rate)=0 v(bl_3__t2_rate)=0 v(bl_3__t3_rate)=0
.ic v(rbl_0_rate)=0.9 v(rbl_0__t0_rate)=0.9 v(rbl_0__t1_rate)=0.9 v(rbl_0__t2_rate)=0.9
.ic v(rbl_0__t3_rate)=0.9 v(rbl_1_rate)=0.9 v(rbl_1__t0_rate)=0.9 v(rbl_1__t1_rate)=0.9
.ic v(rbl_1__t2_rate)=0.9 v(rbl_1__t3_rate)=0.9 v(rbl_2_rate)=0.9 v(rbl_2__t0_rate)=0.9
.ic v(rbl_2__t1_rate)=0.9 v(rbl_2__t2_rate)=0.9 v(rbl_2__t3_rate)=0.9 v(rbl_3_rate)=0.9
.ic v(rbl_3__t0_rate)=0.9 v(rbl_3__t1_rate)=0.9 v(rbl_3__t2_rate)=0.9 v(rbl_3__t3_rate)=0.9
.ic v(rwl_0_rate)=1.8 v(rwl_0__t0_rate)=1.8 v(rwl_0__t1_rate)=1.8 v(rwl_0__t2_rate)=1.8
.ic v(rwl_0__t3_rate)=1.8 v(rwl_1_rate)=1.8 v(rwl_1__t0_rate)=1.8 v(rwl_1__t1_rate)=1.8
.ic v(rwl_1__t2_rate)=1.8 v(rwl_1__t3_rate)=1.8 v(rwl_2_rate)=1.8 v(rwl_2__t0_rate)=1.8
.ic v(rwl_2__t1_rate)=1.8 v(rwl_2__t2_rate)=1.8 v(rwl_2__t3_rate)=1.8 v(rwl_3_rate)=1.8
.ic v(rwl_3__t0_rate)=1.8 v(rwl_3__t1_rate)=1.8 v(rwl_3__t2_rate)=1.8 v(rwl_3__t3_rate)=1.8
.ic v(wl_0_rate)=0 v(wl_0__t0_rate)=0 v(wl_0__t1_rate)=0 v(wl_0__t2_rate)=0
.ic v(wl_0__t3_rate)=0 v(wl_1_rate)=0 v(wl_1__t0_rate)=0 v(wl_1__t1_rate)=0
.ic v(wl_1__t2_rate)=0 v(wl_1__t3_rate)=0 v(wl_2_rate)=0 v(wl_2__t0_rate)=0
.ic v(wl_2__t1_rate)=0 v(wl_2__t2_rate)=0 v(wl_2__t3_rate)=0 v(wl_3_rate)=0
.ic v(wl_3__t0_rate)=0 v(wl_3__t1_rate)=0 v(wl_3__t2_rate)=0 v(wl_3__t3_rate)=0
.ic v(ctl_hub)=1.1
