* closed_loop_d5030.spice -- repeated closed-loop refresh, dwell 5030 ns x 10 cycles (the ratified refresh-interval bound (5.03 us)), issue #147
* GENERATED by gen_closed_loop.py; do not edit by hand.
*
* PROPOSED/UNRATIFIED SCOPE: 27 C and 125 C, tt/ss/ff/sf/fs, VDD 1.8 V (spec/operating-range-decision-PROPOSED.md).
* One continuous transient per instance: 4 rows written ONCE through M_WR (each cell starting at the opposite of its
* data), then closed-loop refresh of every row each dwell: precharge -> select -> latch enable -> latch COMPLEMENT
* node drives WBL -> WWL pulse. No .ic reset and no ideal expected-data source after the initial write; the actual
* latch decision is written back and carried into the next cycle. Instance name <waveform>_<row0..row3 data>.
* Waveforms: ana = sim/refresh-op analog baseline; rtl = UNCHANGED phase-sequencer strobes + latch-hold adapter;
* late = EXPERIMENTAL UNAPPROVED rtl with RWL released after WWL fall; nowb = ana with write-back WWL pulses deleted.
*
* ASSUMPTIONS (labelled, none is a spec value): ideal drivers and 100 ohm switches, C_WBL = 10 fF (not extracted),
* ideal matched dummy reference load, VREF = VRBL - 100 mV, 4-row column, C_RBL = extracted 4-row worst net,
* C_SN = extracted array MINIMUM wiring C, global corners only, NO mismatch, no device-level column/row driver.

.options method=trap gmin=1e-15 abstol=1e-15 chgtol=1e-18
.param VDD   = 1.8
.param VRBL  = 0.9
.param C_RBL = 9.55559e-16   $ extracted_4row_worst_total_ff, layout/gain_cell_2t_array.parasitics.summary.json
.param C_WBL = 1e-14   $ ASSUMPTION (not extracted)
.param C_SN  = 5.38402e-16   $ comparison.c_sn.array_min_total_ff (wiring only; array-context, issue #89)
vdd   vdd 0 dc {VDD}
vprea prea 0 dc {VRBL}
vpref pref 0 dc 0.8
vrwld rwl_des 0 dc {VDD}
.model swpre sw(vt=0.9 vh=0.1 ron=100 roff=1e12)
.model swwbl sw(vt=0.9 vh=0.1 ron=100 roff=1e12)

* ---- shared control sources, waveform ana (source variant baseline_analog, write-back True) ----
vctl_ana ctl_ana 0 pwl(0 {VDD} 5.0491e-06 {VDD} 5.0492e-06 0 5.0851e-06 0 5.0852e-06 {VDD} 5.0891e-06 {VDD} 5.0892e-06 0 5.1251e-06 0 5.1252e-06 {VDD} 5.1291e-06 {VDD} 5.1292e-06 0 5.1651e-06 0 5.1652e-06 {VDD} 5.1691e-06 {VDD} 5.1692e-06 0 5.2051e-06 0 5.2052e-06 {VDD} 1.00791e-05 {VDD} 1.00792e-05 0 1.01151e-05 0 1.01152e-05 {VDD} 1.01191e-05 {VDD} 1.01192e-05 0 1.01551e-05 0 1.01552e-05 {VDD} 1.01591e-05 {VDD} 1.01592e-05 0 1.01951e-05 0 1.01952e-05 {VDD} 1.01991e-05 {VDD} 1.01992e-05 0 1.02351e-05 0 1.02352e-05 {VDD} 1.51091e-05 {VDD} 1.51092e-05 0 1.51451e-05 0 1.51452e-05 {VDD} 1.51491e-05 {VDD} 1.51492e-05 0 1.51851e-05 0 1.51852e-05 {VDD} 1.51891e-05 {VDD} 1.51892e-05 0 1.52251e-05 0 1.52252e-05 {VDD} 1.52291e-05 {VDD} 1.52292e-05 0 1.52651e-05 0 1.52652e-05 {VDD} 2.01391e-05 {VDD} 2.01392e-05 0 2.01751e-05 0 2.01752e-05 {VDD} 2.01791e-05 {VDD} 2.01792e-05 0 2.02151e-05 0 2.02152e-05 {VDD} 2.02191e-05 {VDD} 2.02192e-05 0 2.02551e-05 0 2.02552e-05 {VDD} 2.02591e-05 {VDD} 2.02592e-05 0 2.02951e-05 0 2.02952e-05 {VDD} 2.51691e-05 {VDD} 2.51692e-05 0 2.52051e-05 0 2.52052e-05 {VDD} 2.52091e-05 {VDD} 2.52092e-05 0 2.52451e-05 0 2.52452e-05 {VDD} 2.52491e-05 {VDD} 2.52492e-05 0 2.52851e-05 0 2.52852e-05 {VDD} 2.52891e-05 {VDD} 2.52892e-05 0 2.53251e-05 0 2.53252e-05 {VDD} 3.01991e-05 {VDD} 3.01992e-05 0 3.02351e-05 0 3.02352e-05 {VDD} 3.02391e-05 {VDD} 3.02392e-05 0 3.02751e-05 0 3.02752e-05 {VDD} 3.02791e-05 {VDD} 3.02792e-05 0 3.03151e-05 0 3.03152e-05 {VDD} 3.03191e-05 {VDD} 3.03192e-05 0 3.03551e-05 0 3.03552e-05 {VDD} 3.52291e-05 {VDD} 3.52292e-05 0 3.52651e-05 0 3.52652e-05 {VDD} 3.52691e-05 {VDD} 3.52692e-05 0 3.53051e-05 0 3.53052e-05 {VDD} 3.53091e-05 {VDD} 3.53092e-05 0 3.53451e-05 0 3.53452e-05 {VDD} 3.53491e-05 {VDD} 3.53492e-05 0 3.53851e-05 0 3.53852e-05 {VDD} 4.02591e-05 {VDD} 4.02592e-05 0 4.02951e-05 0 4.02952e-05 {VDD} 4.02991e-05 {VDD} 4.02992e-05 0 4.03351e-05 0 4.03352e-05 {VDD} 4.03391e-05 {VDD} 4.03392e-05 0 4.03751e-05 0 4.03752e-05 {VDD} 4.03791e-05 {VDD} 4.03792e-05 0 4.04151e-05 0 4.04152e-05 {VDD} 4.52891e-05 {VDD} 4.52892e-05 0 4.53251e-05 0 4.53252e-05 {VDD} 4.53291e-05 {VDD} 4.53292e-05 0 4.53651e-05 0 4.53652e-05 {VDD} 4.53691e-05 {VDD} 4.53692e-05 0 4.54051e-05 0 4.54052e-05 {VDD} 4.54091e-05 {VDD} 4.54092e-05 0 4.54451e-05 0 4.54452e-05 {VDD} 5.03191e-05 {VDD} 5.03192e-05 0 5.03551e-05 0 5.03552e-05 {VDD} 5.03591e-05 {VDD} 5.03592e-05 0 5.03951e-05 0 5.03952e-05 {VDD} 5.03991e-05 {VDD} 5.03992e-05 0 5.04351e-05 0 5.04352e-05 {VDD} 5.04391e-05 {VDD} 5.04392e-05 0 5.04751e-05 0 5.04752e-05 {VDD})
ven_ana en_ana 0 pwl(0 0 5.0611e-06 0 5.0612e-06 {VDD} 5.0841e-06 {VDD} 5.0842e-06 0 5.1011e-06 0 5.1012e-06 {VDD} 5.1241e-06 {VDD} 5.1242e-06 0 5.1411e-06 0 5.1412e-06 {VDD} 5.1641e-06 {VDD} 5.1642e-06 0 5.1811e-06 0 5.1812e-06 {VDD} 5.2041e-06 {VDD} 5.2042e-06 0 1.00911e-05 0 1.00912e-05 {VDD} 1.01141e-05 {VDD} 1.01142e-05 0 1.01311e-05 0 1.01312e-05 {VDD} 1.01541e-05 {VDD} 1.01542e-05 0 1.01711e-05 0 1.01712e-05 {VDD} 1.01941e-05 {VDD} 1.01942e-05 0 1.02111e-05 0 1.02112e-05 {VDD} 1.02341e-05 {VDD} 1.02342e-05 0 1.51211e-05 0 1.51212e-05 {VDD} 1.51441e-05 {VDD} 1.51442e-05 0 1.51611e-05 0 1.51612e-05 {VDD} 1.51841e-05 {VDD} 1.51842e-05 0 1.52011e-05 0 1.52012e-05 {VDD} 1.52241e-05 {VDD} 1.52242e-05 0 1.52411e-05 0 1.52412e-05 {VDD} 1.52641e-05 {VDD} 1.52642e-05 0 2.01511e-05 0 2.01512e-05 {VDD} 2.01741e-05 {VDD} 2.01742e-05 0 2.01911e-05 0 2.01912e-05 {VDD} 2.02141e-05 {VDD} 2.02142e-05 0 2.02311e-05 0 2.02312e-05 {VDD} 2.02541e-05 {VDD} 2.02542e-05 0 2.02711e-05 0 2.02712e-05 {VDD} 2.02941e-05 {VDD} 2.02942e-05 0 2.51811e-05 0 2.51812e-05 {VDD} 2.52041e-05 {VDD} 2.52042e-05 0 2.52211e-05 0 2.52212e-05 {VDD} 2.52441e-05 {VDD} 2.52442e-05 0 2.52611e-05 0 2.52612e-05 {VDD} 2.52841e-05 {VDD} 2.52842e-05 0 2.53011e-05 0 2.53012e-05 {VDD} 2.53241e-05 {VDD} 2.53242e-05 0 3.02111e-05 0 3.02112e-05 {VDD} 3.02341e-05 {VDD} 3.02342e-05 0 3.02511e-05 0 3.02512e-05 {VDD} 3.02741e-05 {VDD} 3.02742e-05 0 3.02911e-05 0 3.02912e-05 {VDD} 3.03141e-05 {VDD} 3.03142e-05 0 3.03311e-05 0 3.03312e-05 {VDD} 3.03541e-05 {VDD} 3.03542e-05 0 3.52411e-05 0 3.52412e-05 {VDD} 3.52641e-05 {VDD} 3.52642e-05 0 3.52811e-05 0 3.52812e-05 {VDD} 3.53041e-05 {VDD} 3.53042e-05 0 3.53211e-05 0 3.53212e-05 {VDD} 3.53441e-05 {VDD} 3.53442e-05 0 3.53611e-05 0 3.53612e-05 {VDD} 3.53841e-05 {VDD} 3.53842e-05 0 4.02711e-05 0 4.02712e-05 {VDD} 4.02941e-05 {VDD} 4.02942e-05 0 4.03111e-05 0 4.03112e-05 {VDD} 4.03341e-05 {VDD} 4.03342e-05 0 4.03511e-05 0 4.03512e-05 {VDD} 4.03741e-05 {VDD} 4.03742e-05 0 4.03911e-05 0 4.03912e-05 {VDD} 4.04141e-05 {VDD} 4.04142e-05 0 4.53011e-05 0 4.53012e-05 {VDD} 4.53241e-05 {VDD} 4.53242e-05 0 4.53411e-05 0 4.53412e-05 {VDD} 4.53641e-05 {VDD} 4.53642e-05 0 4.53811e-05 0 4.53812e-05 {VDD} 4.54041e-05 {VDD} 4.54042e-05 0 4.54211e-05 0 4.54212e-05 {VDD} 4.54441e-05 {VDD} 4.54442e-05 0 5.03311e-05 0 5.03312e-05 {VDD} 5.03541e-05 {VDD} 5.03542e-05 0 5.03711e-05 0 5.03712e-05 {VDD} 5.03941e-05 {VDD} 5.03942e-05 0 5.04111e-05 0 5.04112e-05 {VDD} 5.04341e-05 {VDD} 5.04342e-05 0 5.04511e-05 0 5.04512e-05 {VDD} 5.04741e-05 {VDD} 5.04742e-05 0)
venb_ana enb_ana 0 pwl(0 {VDD} 5.0611e-06 {VDD} 5.0612e-06 0 5.0841e-06 0 5.0842e-06 {VDD} 5.1011e-06 {VDD} 5.1012e-06 0 5.1241e-06 0 5.1242e-06 {VDD} 5.1411e-06 {VDD} 5.1412e-06 0 5.1641e-06 0 5.1642e-06 {VDD} 5.1811e-06 {VDD} 5.1812e-06 0 5.2041e-06 0 5.2042e-06 {VDD} 1.00911e-05 {VDD} 1.00912e-05 0 1.01141e-05 0 1.01142e-05 {VDD} 1.01311e-05 {VDD} 1.01312e-05 0 1.01541e-05 0 1.01542e-05 {VDD} 1.01711e-05 {VDD} 1.01712e-05 0 1.01941e-05 0 1.01942e-05 {VDD} 1.02111e-05 {VDD} 1.02112e-05 0 1.02341e-05 0 1.02342e-05 {VDD} 1.51211e-05 {VDD} 1.51212e-05 0 1.51441e-05 0 1.51442e-05 {VDD} 1.51611e-05 {VDD} 1.51612e-05 0 1.51841e-05 0 1.51842e-05 {VDD} 1.52011e-05 {VDD} 1.52012e-05 0 1.52241e-05 0 1.52242e-05 {VDD} 1.52411e-05 {VDD} 1.52412e-05 0 1.52641e-05 0 1.52642e-05 {VDD} 2.01511e-05 {VDD} 2.01512e-05 0 2.01741e-05 0 2.01742e-05 {VDD} 2.01911e-05 {VDD} 2.01912e-05 0 2.02141e-05 0 2.02142e-05 {VDD} 2.02311e-05 {VDD} 2.02312e-05 0 2.02541e-05 0 2.02542e-05 {VDD} 2.02711e-05 {VDD} 2.02712e-05 0 2.02941e-05 0 2.02942e-05 {VDD} 2.51811e-05 {VDD} 2.51812e-05 0 2.52041e-05 0 2.52042e-05 {VDD} 2.52211e-05 {VDD} 2.52212e-05 0 2.52441e-05 0 2.52442e-05 {VDD} 2.52611e-05 {VDD} 2.52612e-05 0 2.52841e-05 0 2.52842e-05 {VDD} 2.53011e-05 {VDD} 2.53012e-05 0 2.53241e-05 0 2.53242e-05 {VDD} 3.02111e-05 {VDD} 3.02112e-05 0 3.02341e-05 0 3.02342e-05 {VDD} 3.02511e-05 {VDD} 3.02512e-05 0 3.02741e-05 0 3.02742e-05 {VDD} 3.02911e-05 {VDD} 3.02912e-05 0 3.03141e-05 0 3.03142e-05 {VDD} 3.03311e-05 {VDD} 3.03312e-05 0 3.03541e-05 0 3.03542e-05 {VDD} 3.52411e-05 {VDD} 3.52412e-05 0 3.52641e-05 0 3.52642e-05 {VDD} 3.52811e-05 {VDD} 3.52812e-05 0 3.53041e-05 0 3.53042e-05 {VDD} 3.53211e-05 {VDD} 3.53212e-05 0 3.53441e-05 0 3.53442e-05 {VDD} 3.53611e-05 {VDD} 3.53612e-05 0 3.53841e-05 0 3.53842e-05 {VDD} 4.02711e-05 {VDD} 4.02712e-05 0 4.02941e-05 0 4.02942e-05 {VDD} 4.03111e-05 {VDD} 4.03112e-05 0 4.03341e-05 0 4.03342e-05 {VDD} 4.03511e-05 {VDD} 4.03512e-05 0 4.03741e-05 0 4.03742e-05 {VDD} 4.03911e-05 {VDD} 4.03912e-05 0 4.04141e-05 0 4.04142e-05 {VDD} 4.53011e-05 {VDD} 4.53012e-05 0 4.53241e-05 0 4.53242e-05 {VDD} 4.53411e-05 {VDD} 4.53412e-05 0 4.53641e-05 0 4.53642e-05 {VDD} 4.53811e-05 {VDD} 4.53812e-05 0 4.54041e-05 0 4.54042e-05 {VDD} 4.54211e-05 {VDD} 4.54212e-05 0 4.54441e-05 0 4.54442e-05 {VDD} 5.03311e-05 {VDD} 5.03312e-05 0 5.03541e-05 0 5.03542e-05 {VDD} 5.03711e-05 {VDD} 5.03712e-05 0 5.03941e-05 0 5.03942e-05 {VDD} 5.04111e-05 {VDD} 5.04112e-05 0 5.04341e-05 0 5.04342e-05 {VDD} 5.04511e-05 {VDD} 5.04512e-05 0 5.04741e-05 0 5.04742e-05 {VDD})
vwbc_ana wbc_ana 0 pwl(0 0 5.0621e-06 0 5.0622e-06 {VDD} 5.0841e-06 {VDD} 5.0842e-06 0 5.1021e-06 0 5.1022e-06 {VDD} 5.1241e-06 {VDD} 5.1242e-06 0 5.1421e-06 0 5.1422e-06 {VDD} 5.1641e-06 {VDD} 5.1642e-06 0 5.1821e-06 0 5.1822e-06 {VDD} 5.2041e-06 {VDD} 5.2042e-06 0 1.00921e-05 0 1.00922e-05 {VDD} 1.01141e-05 {VDD} 1.01142e-05 0 1.01321e-05 0 1.01322e-05 {VDD} 1.01541e-05 {VDD} 1.01542e-05 0 1.01721e-05 0 1.01722e-05 {VDD} 1.01941e-05 {VDD} 1.01942e-05 0 1.02121e-05 0 1.02122e-05 {VDD} 1.02341e-05 {VDD} 1.02342e-05 0 1.51221e-05 0 1.51222e-05 {VDD} 1.51441e-05 {VDD} 1.51442e-05 0 1.51621e-05 0 1.51622e-05 {VDD} 1.51841e-05 {VDD} 1.51842e-05 0 1.52021e-05 0 1.52022e-05 {VDD} 1.52241e-05 {VDD} 1.52242e-05 0 1.52421e-05 0 1.52422e-05 {VDD} 1.52641e-05 {VDD} 1.52642e-05 0 2.01521e-05 0 2.01522e-05 {VDD} 2.01741e-05 {VDD} 2.01742e-05 0 2.01921e-05 0 2.01922e-05 {VDD} 2.02141e-05 {VDD} 2.02142e-05 0 2.02321e-05 0 2.02322e-05 {VDD} 2.02541e-05 {VDD} 2.02542e-05 0 2.02721e-05 0 2.02722e-05 {VDD} 2.02941e-05 {VDD} 2.02942e-05 0 2.51821e-05 0 2.51822e-05 {VDD} 2.52041e-05 {VDD} 2.52042e-05 0 2.52221e-05 0 2.52222e-05 {VDD} 2.52441e-05 {VDD} 2.52442e-05 0 2.52621e-05 0 2.52622e-05 {VDD} 2.52841e-05 {VDD} 2.52842e-05 0 2.53021e-05 0 2.53022e-05 {VDD} 2.53241e-05 {VDD} 2.53242e-05 0 3.02121e-05 0 3.02122e-05 {VDD} 3.02341e-05 {VDD} 3.02342e-05 0 3.02521e-05 0 3.02522e-05 {VDD} 3.02741e-05 {VDD} 3.02742e-05 0 3.02921e-05 0 3.02922e-05 {VDD} 3.03141e-05 {VDD} 3.03142e-05 0 3.03321e-05 0 3.03322e-05 {VDD} 3.03541e-05 {VDD} 3.03542e-05 0 3.52421e-05 0 3.52422e-05 {VDD} 3.52641e-05 {VDD} 3.52642e-05 0 3.52821e-05 0 3.52822e-05 {VDD} 3.53041e-05 {VDD} 3.53042e-05 0 3.53221e-05 0 3.53222e-05 {VDD} 3.53441e-05 {VDD} 3.53442e-05 0 3.53621e-05 0 3.53622e-05 {VDD} 3.53841e-05 {VDD} 3.53842e-05 0 4.02721e-05 0 4.02722e-05 {VDD} 4.02941e-05 {VDD} 4.02942e-05 0 4.03121e-05 0 4.03122e-05 {VDD} 4.03341e-05 {VDD} 4.03342e-05 0 4.03521e-05 0 4.03522e-05 {VDD} 4.03741e-05 {VDD} 4.03742e-05 0 4.03921e-05 0 4.03922e-05 {VDD} 4.04141e-05 {VDD} 4.04142e-05 0 4.53021e-05 0 4.53022e-05 {VDD} 4.53241e-05 {VDD} 4.53242e-05 0 4.53421e-05 0 4.53422e-05 {VDD} 4.53641e-05 {VDD} 4.53642e-05 0 4.53821e-05 0 4.53822e-05 {VDD} 4.54041e-05 {VDD} 4.54042e-05 0 4.54221e-05 0 4.54222e-05 {VDD} 4.54441e-05 {VDD} 4.54442e-05 0 5.03321e-05 0 5.03322e-05 {VDD} 5.03541e-05 {VDD} 5.03542e-05 0 5.03721e-05 0 5.03722e-05 {VDD} 5.03941e-05 {VDD} 5.03942e-05 0 5.04121e-05 0 5.04122e-05 {VDD} 5.04341e-05 {VDD} 5.04342e-05 0 5.04521e-05 0 5.04522e-05 {VDD} 5.04741e-05 {VDD} 5.04742e-05 0)
vbpk_ana bpk_ana 0 pwl(0 {VDD} 5.0621e-06 {VDD} 5.0622e-06 0 5.0841e-06 0 5.0842e-06 {VDD} 5.1021e-06 {VDD} 5.1022e-06 0 5.1241e-06 0 5.1242e-06 {VDD} 5.1421e-06 {VDD} 5.1422e-06 0 5.1641e-06 0 5.1642e-06 {VDD} 5.1821e-06 {VDD} 5.1822e-06 0 5.2041e-06 0 5.2042e-06 {VDD} 1.00921e-05 {VDD} 1.00922e-05 0 1.01141e-05 0 1.01142e-05 {VDD} 1.01321e-05 {VDD} 1.01322e-05 0 1.01541e-05 0 1.01542e-05 {VDD} 1.01721e-05 {VDD} 1.01722e-05 0 1.01941e-05 0 1.01942e-05 {VDD} 1.02121e-05 {VDD} 1.02122e-05 0 1.02341e-05 0 1.02342e-05 {VDD} 1.51221e-05 {VDD} 1.51222e-05 0 1.51441e-05 0 1.51442e-05 {VDD} 1.51621e-05 {VDD} 1.51622e-05 0 1.51841e-05 0 1.51842e-05 {VDD} 1.52021e-05 {VDD} 1.52022e-05 0 1.52241e-05 0 1.52242e-05 {VDD} 1.52421e-05 {VDD} 1.52422e-05 0 1.52641e-05 0 1.52642e-05 {VDD} 2.01521e-05 {VDD} 2.01522e-05 0 2.01741e-05 0 2.01742e-05 {VDD} 2.01921e-05 {VDD} 2.01922e-05 0 2.02141e-05 0 2.02142e-05 {VDD} 2.02321e-05 {VDD} 2.02322e-05 0 2.02541e-05 0 2.02542e-05 {VDD} 2.02721e-05 {VDD} 2.02722e-05 0 2.02941e-05 0 2.02942e-05 {VDD} 2.51821e-05 {VDD} 2.51822e-05 0 2.52041e-05 0 2.52042e-05 {VDD} 2.52221e-05 {VDD} 2.52222e-05 0 2.52441e-05 0 2.52442e-05 {VDD} 2.52621e-05 {VDD} 2.52622e-05 0 2.52841e-05 0 2.52842e-05 {VDD} 2.53021e-05 {VDD} 2.53022e-05 0 2.53241e-05 0 2.53242e-05 {VDD} 3.02121e-05 {VDD} 3.02122e-05 0 3.02341e-05 0 3.02342e-05 {VDD} 3.02521e-05 {VDD} 3.02522e-05 0 3.02741e-05 0 3.02742e-05 {VDD} 3.02921e-05 {VDD} 3.02922e-05 0 3.03141e-05 0 3.03142e-05 {VDD} 3.03321e-05 {VDD} 3.03322e-05 0 3.03541e-05 0 3.03542e-05 {VDD} 3.52421e-05 {VDD} 3.52422e-05 0 3.52641e-05 0 3.52642e-05 {VDD} 3.52821e-05 {VDD} 3.52822e-05 0 3.53041e-05 0 3.53042e-05 {VDD} 3.53221e-05 {VDD} 3.53222e-05 0 3.53441e-05 0 3.53442e-05 {VDD} 3.53621e-05 {VDD} 3.53622e-05 0 3.53841e-05 0 3.53842e-05 {VDD} 4.02721e-05 {VDD} 4.02722e-05 0 4.02941e-05 0 4.02942e-05 {VDD} 4.03121e-05 {VDD} 4.03122e-05 0 4.03341e-05 0 4.03342e-05 {VDD} 4.03521e-05 {VDD} 4.03522e-05 0 4.03741e-05 0 4.03742e-05 {VDD} 4.03921e-05 {VDD} 4.03922e-05 0 4.04141e-05 0 4.04142e-05 {VDD} 4.53021e-05 {VDD} 4.53022e-05 0 4.53241e-05 0 4.53242e-05 {VDD} 4.53421e-05 {VDD} 4.53422e-05 0 4.53641e-05 0 4.53642e-05 {VDD} 4.53821e-05 {VDD} 4.53822e-05 0 4.54041e-05 0 4.54042e-05 {VDD} 4.54221e-05 {VDD} 4.54222e-05 0 4.54441e-05 0 4.54442e-05 {VDD} 5.03321e-05 {VDD} 5.03322e-05 0 5.03541e-05 0 5.03542e-05 {VDD} 5.03721e-05 {VDD} 5.03722e-05 0 5.03941e-05 0 5.03942e-05 {VDD} 5.04121e-05 {VDD} 5.04122e-05 0 5.04341e-05 0 5.04342e-05 {VDD} 5.04521e-05 {VDD} 5.04522e-05 0 5.04741e-05 0 5.04742e-05 {VDD})   $ ideal initial-write/park driver connected except during write-back
vrws0_ana rwls0_ana 0 pwl(0 {VDD} 5.0511e-06 {VDD} 5.0512e-06 0 5.0841e-06 0 5.0842e-06 {VDD} 1.00811e-05 {VDD} 1.00812e-05 0 1.01141e-05 0 1.01142e-05 {VDD} 1.51111e-05 {VDD} 1.51112e-05 0 1.51441e-05 0 1.51442e-05 {VDD} 2.01411e-05 {VDD} 2.01412e-05 0 2.01741e-05 0 2.01742e-05 {VDD} 2.51711e-05 {VDD} 2.51712e-05 0 2.52041e-05 0 2.52042e-05 {VDD} 3.02011e-05 {VDD} 3.02012e-05 0 3.02341e-05 0 3.02342e-05 {VDD} 3.52311e-05 {VDD} 3.52312e-05 0 3.52641e-05 0 3.52642e-05 {VDD} 4.02611e-05 {VDD} 4.02612e-05 0 4.02941e-05 0 4.02942e-05 {VDD} 4.52911e-05 {VDD} 4.52912e-05 0 4.53241e-05 0 4.53242e-05 {VDD} 5.03211e-05 {VDD} 5.03212e-05 0 5.03541e-05 0 5.03542e-05 {VDD})
vwl0_ana wl0_ana 0 pwl(0 0 1e-09 0 1.1e-09 {VDD} 2.1e-08 {VDD} 2.11e-08 0 5.0621e-06 0 5.0622e-06 {VDD} 5.0821e-06 {VDD} 5.0822e-06 0 1.00921e-05 0 1.00922e-05 {VDD} 1.01121e-05 {VDD} 1.01122e-05 0 1.51221e-05 0 1.51222e-05 {VDD} 1.51421e-05 {VDD} 1.51422e-05 0 2.01521e-05 0 2.01522e-05 {VDD} 2.01721e-05 {VDD} 2.01722e-05 0 2.51821e-05 0 2.51822e-05 {VDD} 2.52021e-05 {VDD} 2.52022e-05 0 3.02121e-05 0 3.02122e-05 {VDD} 3.02321e-05 {VDD} 3.02322e-05 0 3.52421e-05 0 3.52422e-05 {VDD} 3.52621e-05 {VDD} 3.52622e-05 0 4.02721e-05 0 4.02722e-05 {VDD} 4.02921e-05 {VDD} 4.02922e-05 0 4.53021e-05 0 4.53022e-05 {VDD} 4.53221e-05 {VDD} 4.53222e-05 0 5.03321e-05 0 5.03322e-05 {VDD} 5.03521e-05 {VDD} 5.03522e-05 0)
vrws1_ana rwls1_ana 0 pwl(0 {VDD} 5.0911e-06 {VDD} 5.0912e-06 0 5.1241e-06 0 5.1242e-06 {VDD} 1.01211e-05 {VDD} 1.01212e-05 0 1.01541e-05 0 1.01542e-05 {VDD} 1.51511e-05 {VDD} 1.51512e-05 0 1.51841e-05 0 1.51842e-05 {VDD} 2.01811e-05 {VDD} 2.01812e-05 0 2.02141e-05 0 2.02142e-05 {VDD} 2.52111e-05 {VDD} 2.52112e-05 0 2.52441e-05 0 2.52442e-05 {VDD} 3.02411e-05 {VDD} 3.02412e-05 0 3.02741e-05 0 3.02742e-05 {VDD} 3.52711e-05 {VDD} 3.52712e-05 0 3.53041e-05 0 3.53042e-05 {VDD} 4.03011e-05 {VDD} 4.03012e-05 0 4.03341e-05 0 4.03342e-05 {VDD} 4.53311e-05 {VDD} 4.53312e-05 0 4.53641e-05 0 4.53642e-05 {VDD} 5.03611e-05 {VDD} 5.03612e-05 0 5.03941e-05 0 5.03942e-05 {VDD})
vwl1_ana wl1_ana 0 pwl(0 0 4.1e-08 0 4.11e-08 {VDD} 6.1e-08 {VDD} 6.11e-08 0 5.1021e-06 0 5.1022e-06 {VDD} 5.1221e-06 {VDD} 5.1222e-06 0 1.01321e-05 0 1.01322e-05 {VDD} 1.01521e-05 {VDD} 1.01522e-05 0 1.51621e-05 0 1.51622e-05 {VDD} 1.51821e-05 {VDD} 1.51822e-05 0 2.01921e-05 0 2.01922e-05 {VDD} 2.02121e-05 {VDD} 2.02122e-05 0 2.52221e-05 0 2.52222e-05 {VDD} 2.52421e-05 {VDD} 2.52422e-05 0 3.02521e-05 0 3.02522e-05 {VDD} 3.02721e-05 {VDD} 3.02722e-05 0 3.52821e-05 0 3.52822e-05 {VDD} 3.53021e-05 {VDD} 3.53022e-05 0 4.03121e-05 0 4.03122e-05 {VDD} 4.03321e-05 {VDD} 4.03322e-05 0 4.53421e-05 0 4.53422e-05 {VDD} 4.53621e-05 {VDD} 4.53622e-05 0 5.03721e-05 0 5.03722e-05 {VDD} 5.03921e-05 {VDD} 5.03922e-05 0)
vrws2_ana rwls2_ana 0 pwl(0 {VDD} 5.1311e-06 {VDD} 5.1312e-06 0 5.1641e-06 0 5.1642e-06 {VDD} 1.01611e-05 {VDD} 1.01612e-05 0 1.01941e-05 0 1.01942e-05 {VDD} 1.51911e-05 {VDD} 1.51912e-05 0 1.52241e-05 0 1.52242e-05 {VDD} 2.02211e-05 {VDD} 2.02212e-05 0 2.02541e-05 0 2.02542e-05 {VDD} 2.52511e-05 {VDD} 2.52512e-05 0 2.52841e-05 0 2.52842e-05 {VDD} 3.02811e-05 {VDD} 3.02812e-05 0 3.03141e-05 0 3.03142e-05 {VDD} 3.53111e-05 {VDD} 3.53112e-05 0 3.53441e-05 0 3.53442e-05 {VDD} 4.03411e-05 {VDD} 4.03412e-05 0 4.03741e-05 0 4.03742e-05 {VDD} 4.53711e-05 {VDD} 4.53712e-05 0 4.54041e-05 0 4.54042e-05 {VDD} 5.04011e-05 {VDD} 5.04012e-05 0 5.04341e-05 0 5.04342e-05 {VDD})
vwl2_ana wl2_ana 0 pwl(0 0 8.1e-08 0 8.11e-08 {VDD} 1.01e-07 {VDD} 1.011e-07 0 5.1421e-06 0 5.1422e-06 {VDD} 5.1621e-06 {VDD} 5.1622e-06 0 1.01721e-05 0 1.01722e-05 {VDD} 1.01921e-05 {VDD} 1.01922e-05 0 1.52021e-05 0 1.52022e-05 {VDD} 1.52221e-05 {VDD} 1.52222e-05 0 2.02321e-05 0 2.02322e-05 {VDD} 2.02521e-05 {VDD} 2.02522e-05 0 2.52621e-05 0 2.52622e-05 {VDD} 2.52821e-05 {VDD} 2.52822e-05 0 3.02921e-05 0 3.02922e-05 {VDD} 3.03121e-05 {VDD} 3.03122e-05 0 3.53221e-05 0 3.53222e-05 {VDD} 3.53421e-05 {VDD} 3.53422e-05 0 4.03521e-05 0 4.03522e-05 {VDD} 4.03721e-05 {VDD} 4.03722e-05 0 4.53821e-05 0 4.53822e-05 {VDD} 4.54021e-05 {VDD} 4.54022e-05 0 5.04121e-05 0 5.04122e-05 {VDD} 5.04321e-05 {VDD} 5.04322e-05 0)
vrws3_ana rwls3_ana 0 pwl(0 {VDD} 5.1711e-06 {VDD} 5.1712e-06 0 5.2041e-06 0 5.2042e-06 {VDD} 1.02011e-05 {VDD} 1.02012e-05 0 1.02341e-05 0 1.02342e-05 {VDD} 1.52311e-05 {VDD} 1.52312e-05 0 1.52641e-05 0 1.52642e-05 {VDD} 2.02611e-05 {VDD} 2.02612e-05 0 2.02941e-05 0 2.02942e-05 {VDD} 2.52911e-05 {VDD} 2.52912e-05 0 2.53241e-05 0 2.53242e-05 {VDD} 3.03211e-05 {VDD} 3.03212e-05 0 3.03541e-05 0 3.03542e-05 {VDD} 3.53511e-05 {VDD} 3.53512e-05 0 3.53841e-05 0 3.53842e-05 {VDD} 4.03811e-05 {VDD} 4.03812e-05 0 4.04141e-05 0 4.04142e-05 {VDD} 4.54111e-05 {VDD} 4.54112e-05 0 4.54441e-05 0 4.54442e-05 {VDD} 5.04411e-05 {VDD} 5.04412e-05 0 5.04741e-05 0 5.04742e-05 {VDD})
vwl3_ana wl3_ana 0 pwl(0 0 1.21e-07 0 1.211e-07 {VDD} 1.41e-07 {VDD} 1.411e-07 0 5.1821e-06 0 5.1822e-06 {VDD} 5.2021e-06 {VDD} 5.2022e-06 0 1.02121e-05 0 1.02122e-05 {VDD} 1.02321e-05 {VDD} 1.02322e-05 0 1.52421e-05 0 1.52422e-05 {VDD} 1.52621e-05 {VDD} 1.52622e-05 0 2.02721e-05 0 2.02722e-05 {VDD} 2.02921e-05 {VDD} 2.02922e-05 0 2.53021e-05 0 2.53022e-05 {VDD} 2.53221e-05 {VDD} 2.53222e-05 0 3.03321e-05 0 3.03322e-05 {VDD} 3.03521e-05 {VDD} 3.03522e-05 0 3.53621e-05 0 3.53622e-05 {VDD} 3.53821e-05 {VDD} 3.53822e-05 0 4.03921e-05 0 4.03922e-05 {VDD} 4.04121e-05 {VDD} 4.04122e-05 0 4.54221e-05 0 4.54222e-05 {VDD} 4.54421e-05 {VDD} 4.54422e-05 0 5.04521e-05 0 5.04522e-05 {VDD} 5.04721e-05 {VDD} 5.04722e-05 0)
* ---- shared control sources, waveform rtl (source variant rtl_hold, write-back True) ----
vctl_rtl ctl_rtl 0 pwl(0 {VDD} 5.0511e-06 {VDD} 5.0512e-06 0 5.0841e-06 0 5.0842e-06 {VDD} 5.0911e-06 {VDD} 5.0912e-06 0 5.1241e-06 0 5.1242e-06 {VDD} 5.1311e-06 {VDD} 5.1312e-06 0 5.1641e-06 0 5.1642e-06 {VDD} 5.1711e-06 {VDD} 5.1712e-06 0 5.2041e-06 0 5.2042e-06 {VDD} 1.00811e-05 {VDD} 1.00812e-05 0 1.01141e-05 0 1.01142e-05 {VDD} 1.01211e-05 {VDD} 1.01212e-05 0 1.01541e-05 0 1.01542e-05 {VDD} 1.01611e-05 {VDD} 1.01612e-05 0 1.01941e-05 0 1.01942e-05 {VDD} 1.02011e-05 {VDD} 1.02012e-05 0 1.02341e-05 0 1.02342e-05 {VDD} 1.51111e-05 {VDD} 1.51112e-05 0 1.51441e-05 0 1.51442e-05 {VDD} 1.51511e-05 {VDD} 1.51512e-05 0 1.51841e-05 0 1.51842e-05 {VDD} 1.51911e-05 {VDD} 1.51912e-05 0 1.52241e-05 0 1.52242e-05 {VDD} 1.52311e-05 {VDD} 1.52312e-05 0 1.52641e-05 0 1.52642e-05 {VDD} 2.01411e-05 {VDD} 2.01412e-05 0 2.01741e-05 0 2.01742e-05 {VDD} 2.01811e-05 {VDD} 2.01812e-05 0 2.02141e-05 0 2.02142e-05 {VDD} 2.02211e-05 {VDD} 2.02212e-05 0 2.02541e-05 0 2.02542e-05 {VDD} 2.02611e-05 {VDD} 2.02612e-05 0 2.02941e-05 0 2.02942e-05 {VDD} 2.51711e-05 {VDD} 2.51712e-05 0 2.52041e-05 0 2.52042e-05 {VDD} 2.52111e-05 {VDD} 2.52112e-05 0 2.52441e-05 0 2.52442e-05 {VDD} 2.52511e-05 {VDD} 2.52512e-05 0 2.52841e-05 0 2.52842e-05 {VDD} 2.52911e-05 {VDD} 2.52912e-05 0 2.53241e-05 0 2.53242e-05 {VDD} 3.02011e-05 {VDD} 3.02012e-05 0 3.02341e-05 0 3.02342e-05 {VDD} 3.02411e-05 {VDD} 3.02412e-05 0 3.02741e-05 0 3.02742e-05 {VDD} 3.02811e-05 {VDD} 3.02812e-05 0 3.03141e-05 0 3.03142e-05 {VDD} 3.03211e-05 {VDD} 3.03212e-05 0 3.03541e-05 0 3.03542e-05 {VDD} 3.52311e-05 {VDD} 3.52312e-05 0 3.52641e-05 0 3.52642e-05 {VDD} 3.52711e-05 {VDD} 3.52712e-05 0 3.53041e-05 0 3.53042e-05 {VDD} 3.53111e-05 {VDD} 3.53112e-05 0 3.53441e-05 0 3.53442e-05 {VDD} 3.53511e-05 {VDD} 3.53512e-05 0 3.53841e-05 0 3.53842e-05 {VDD} 4.02611e-05 {VDD} 4.02612e-05 0 4.02941e-05 0 4.02942e-05 {VDD} 4.03011e-05 {VDD} 4.03012e-05 0 4.03341e-05 0 4.03342e-05 {VDD} 4.03411e-05 {VDD} 4.03412e-05 0 4.03741e-05 0 4.03742e-05 {VDD} 4.03811e-05 {VDD} 4.03812e-05 0 4.04141e-05 0 4.04142e-05 {VDD} 4.52911e-05 {VDD} 4.52912e-05 0 4.53241e-05 0 4.53242e-05 {VDD} 4.53311e-05 {VDD} 4.53312e-05 0 4.53641e-05 0 4.53642e-05 {VDD} 4.53711e-05 {VDD} 4.53712e-05 0 4.54041e-05 0 4.54042e-05 {VDD} 4.54111e-05 {VDD} 4.54112e-05 0 4.54441e-05 0 4.54442e-05 {VDD} 5.03211e-05 {VDD} 5.03212e-05 0 5.03541e-05 0 5.03542e-05 {VDD} 5.03611e-05 {VDD} 5.03612e-05 0 5.03941e-05 0 5.03942e-05 {VDD} 5.04011e-05 {VDD} 5.04012e-05 0 5.04341e-05 0 5.04342e-05 {VDD} 5.04411e-05 {VDD} 5.04412e-05 0 5.04741e-05 0 5.04742e-05 {VDD})
ven_rtl en_rtl 0 pwl(0 0 5.0601e-06 0 5.0602e-06 {VDD} 5.0831e-06 {VDD} 5.0832e-06 0 5.1001e-06 0 5.1002e-06 {VDD} 5.1231e-06 {VDD} 5.1232e-06 0 5.1401e-06 0 5.1402e-06 {VDD} 5.1631e-06 {VDD} 5.1632e-06 0 5.1801e-06 0 5.1802e-06 {VDD} 5.2031e-06 {VDD} 5.2032e-06 0 1.00901e-05 0 1.00902e-05 {VDD} 1.01131e-05 {VDD} 1.01132e-05 0 1.01301e-05 0 1.01302e-05 {VDD} 1.01531e-05 {VDD} 1.01532e-05 0 1.01701e-05 0 1.01702e-05 {VDD} 1.01931e-05 {VDD} 1.01932e-05 0 1.02101e-05 0 1.02102e-05 {VDD} 1.02331e-05 {VDD} 1.02332e-05 0 1.51201e-05 0 1.51202e-05 {VDD} 1.51431e-05 {VDD} 1.51432e-05 0 1.51601e-05 0 1.51602e-05 {VDD} 1.51831e-05 {VDD} 1.51832e-05 0 1.52001e-05 0 1.52002e-05 {VDD} 1.52231e-05 {VDD} 1.52232e-05 0 1.52401e-05 0 1.52402e-05 {VDD} 1.52631e-05 {VDD} 1.52632e-05 0 2.01501e-05 0 2.01502e-05 {VDD} 2.01731e-05 {VDD} 2.01732e-05 0 2.01901e-05 0 2.01902e-05 {VDD} 2.02131e-05 {VDD} 2.02132e-05 0 2.02301e-05 0 2.02302e-05 {VDD} 2.02531e-05 {VDD} 2.02532e-05 0 2.02701e-05 0 2.02702e-05 {VDD} 2.02931e-05 {VDD} 2.02932e-05 0 2.51801e-05 0 2.51802e-05 {VDD} 2.52031e-05 {VDD} 2.52032e-05 0 2.52201e-05 0 2.52202e-05 {VDD} 2.52431e-05 {VDD} 2.52432e-05 0 2.52601e-05 0 2.52602e-05 {VDD} 2.52831e-05 {VDD} 2.52832e-05 0 2.53001e-05 0 2.53002e-05 {VDD} 2.53231e-05 {VDD} 2.53232e-05 0 3.02101e-05 0 3.02102e-05 {VDD} 3.02331e-05 {VDD} 3.02332e-05 0 3.02501e-05 0 3.02502e-05 {VDD} 3.02731e-05 {VDD} 3.02732e-05 0 3.02901e-05 0 3.02902e-05 {VDD} 3.03131e-05 {VDD} 3.03132e-05 0 3.03301e-05 0 3.03302e-05 {VDD} 3.03531e-05 {VDD} 3.03532e-05 0 3.52401e-05 0 3.52402e-05 {VDD} 3.52631e-05 {VDD} 3.52632e-05 0 3.52801e-05 0 3.52802e-05 {VDD} 3.53031e-05 {VDD} 3.53032e-05 0 3.53201e-05 0 3.53202e-05 {VDD} 3.53431e-05 {VDD} 3.53432e-05 0 3.53601e-05 0 3.53602e-05 {VDD} 3.53831e-05 {VDD} 3.53832e-05 0 4.02701e-05 0 4.02702e-05 {VDD} 4.02931e-05 {VDD} 4.02932e-05 0 4.03101e-05 0 4.03102e-05 {VDD} 4.03331e-05 {VDD} 4.03332e-05 0 4.03501e-05 0 4.03502e-05 {VDD} 4.03731e-05 {VDD} 4.03732e-05 0 4.03901e-05 0 4.03902e-05 {VDD} 4.04131e-05 {VDD} 4.04132e-05 0 4.53001e-05 0 4.53002e-05 {VDD} 4.53231e-05 {VDD} 4.53232e-05 0 4.53401e-05 0 4.53402e-05 {VDD} 4.53631e-05 {VDD} 4.53632e-05 0 4.53801e-05 0 4.53802e-05 {VDD} 4.54031e-05 {VDD} 4.54032e-05 0 4.54201e-05 0 4.54202e-05 {VDD} 4.54431e-05 {VDD} 4.54432e-05 0 5.03301e-05 0 5.03302e-05 {VDD} 5.03531e-05 {VDD} 5.03532e-05 0 5.03701e-05 0 5.03702e-05 {VDD} 5.03931e-05 {VDD} 5.03932e-05 0 5.04101e-05 0 5.04102e-05 {VDD} 5.04331e-05 {VDD} 5.04332e-05 0 5.04501e-05 0 5.04502e-05 {VDD} 5.04731e-05 {VDD} 5.04732e-05 0)
venb_rtl enb_rtl 0 pwl(0 {VDD} 5.0601e-06 {VDD} 5.0602e-06 0 5.0831e-06 0 5.0832e-06 {VDD} 5.1001e-06 {VDD} 5.1002e-06 0 5.1231e-06 0 5.1232e-06 {VDD} 5.1401e-06 {VDD} 5.1402e-06 0 5.1631e-06 0 5.1632e-06 {VDD} 5.1801e-06 {VDD} 5.1802e-06 0 5.2031e-06 0 5.2032e-06 {VDD} 1.00901e-05 {VDD} 1.00902e-05 0 1.01131e-05 0 1.01132e-05 {VDD} 1.01301e-05 {VDD} 1.01302e-05 0 1.01531e-05 0 1.01532e-05 {VDD} 1.01701e-05 {VDD} 1.01702e-05 0 1.01931e-05 0 1.01932e-05 {VDD} 1.02101e-05 {VDD} 1.02102e-05 0 1.02331e-05 0 1.02332e-05 {VDD} 1.51201e-05 {VDD} 1.51202e-05 0 1.51431e-05 0 1.51432e-05 {VDD} 1.51601e-05 {VDD} 1.51602e-05 0 1.51831e-05 0 1.51832e-05 {VDD} 1.52001e-05 {VDD} 1.52002e-05 0 1.52231e-05 0 1.52232e-05 {VDD} 1.52401e-05 {VDD} 1.52402e-05 0 1.52631e-05 0 1.52632e-05 {VDD} 2.01501e-05 {VDD} 2.01502e-05 0 2.01731e-05 0 2.01732e-05 {VDD} 2.01901e-05 {VDD} 2.01902e-05 0 2.02131e-05 0 2.02132e-05 {VDD} 2.02301e-05 {VDD} 2.02302e-05 0 2.02531e-05 0 2.02532e-05 {VDD} 2.02701e-05 {VDD} 2.02702e-05 0 2.02931e-05 0 2.02932e-05 {VDD} 2.51801e-05 {VDD} 2.51802e-05 0 2.52031e-05 0 2.52032e-05 {VDD} 2.52201e-05 {VDD} 2.52202e-05 0 2.52431e-05 0 2.52432e-05 {VDD} 2.52601e-05 {VDD} 2.52602e-05 0 2.52831e-05 0 2.52832e-05 {VDD} 2.53001e-05 {VDD} 2.53002e-05 0 2.53231e-05 0 2.53232e-05 {VDD} 3.02101e-05 {VDD} 3.02102e-05 0 3.02331e-05 0 3.02332e-05 {VDD} 3.02501e-05 {VDD} 3.02502e-05 0 3.02731e-05 0 3.02732e-05 {VDD} 3.02901e-05 {VDD} 3.02902e-05 0 3.03131e-05 0 3.03132e-05 {VDD} 3.03301e-05 {VDD} 3.03302e-05 0 3.03531e-05 0 3.03532e-05 {VDD} 3.52401e-05 {VDD} 3.52402e-05 0 3.52631e-05 0 3.52632e-05 {VDD} 3.52801e-05 {VDD} 3.52802e-05 0 3.53031e-05 0 3.53032e-05 {VDD} 3.53201e-05 {VDD} 3.53202e-05 0 3.53431e-05 0 3.53432e-05 {VDD} 3.53601e-05 {VDD} 3.53602e-05 0 3.53831e-05 0 3.53832e-05 {VDD} 4.02701e-05 {VDD} 4.02702e-05 0 4.02931e-05 0 4.02932e-05 {VDD} 4.03101e-05 {VDD} 4.03102e-05 0 4.03331e-05 0 4.03332e-05 {VDD} 4.03501e-05 {VDD} 4.03502e-05 0 4.03731e-05 0 4.03732e-05 {VDD} 4.03901e-05 {VDD} 4.03902e-05 0 4.04131e-05 0 4.04132e-05 {VDD} 4.53001e-05 {VDD} 4.53002e-05 0 4.53231e-05 0 4.53232e-05 {VDD} 4.53401e-05 {VDD} 4.53402e-05 0 4.53631e-05 0 4.53632e-05 {VDD} 4.53801e-05 {VDD} 4.53802e-05 0 4.54031e-05 0 4.54032e-05 {VDD} 4.54201e-05 {VDD} 4.54202e-05 0 4.54431e-05 0 4.54432e-05 {VDD} 5.03301e-05 {VDD} 5.03302e-05 0 5.03531e-05 0 5.03532e-05 {VDD} 5.03701e-05 {VDD} 5.03702e-05 0 5.03931e-05 0 5.03932e-05 {VDD} 5.04101e-05 {VDD} 5.04102e-05 0 5.04331e-05 0 5.04332e-05 {VDD} 5.04501e-05 {VDD} 5.04502e-05 0 5.04731e-05 0 5.04732e-05 {VDD})
vwbc_rtl wbc_rtl 0 pwl(0 0 5.0611e-06 0 5.0612e-06 {VDD} 5.0831e-06 {VDD} 5.0832e-06 0 5.1011e-06 0 5.1012e-06 {VDD} 5.1231e-06 {VDD} 5.1232e-06 0 5.1411e-06 0 5.1412e-06 {VDD} 5.1631e-06 {VDD} 5.1632e-06 0 5.1811e-06 0 5.1812e-06 {VDD} 5.2031e-06 {VDD} 5.2032e-06 0 1.00911e-05 0 1.00912e-05 {VDD} 1.01131e-05 {VDD} 1.01132e-05 0 1.01311e-05 0 1.01312e-05 {VDD} 1.01531e-05 {VDD} 1.01532e-05 0 1.01711e-05 0 1.01712e-05 {VDD} 1.01931e-05 {VDD} 1.01932e-05 0 1.02111e-05 0 1.02112e-05 {VDD} 1.02331e-05 {VDD} 1.02332e-05 0 1.51211e-05 0 1.51212e-05 {VDD} 1.51431e-05 {VDD} 1.51432e-05 0 1.51611e-05 0 1.51612e-05 {VDD} 1.51831e-05 {VDD} 1.51832e-05 0 1.52011e-05 0 1.52012e-05 {VDD} 1.52231e-05 {VDD} 1.52232e-05 0 1.52411e-05 0 1.52412e-05 {VDD} 1.52631e-05 {VDD} 1.52632e-05 0 2.01511e-05 0 2.01512e-05 {VDD} 2.01731e-05 {VDD} 2.01732e-05 0 2.01911e-05 0 2.01912e-05 {VDD} 2.02131e-05 {VDD} 2.02132e-05 0 2.02311e-05 0 2.02312e-05 {VDD} 2.02531e-05 {VDD} 2.02532e-05 0 2.02711e-05 0 2.02712e-05 {VDD} 2.02931e-05 {VDD} 2.02932e-05 0 2.51811e-05 0 2.51812e-05 {VDD} 2.52031e-05 {VDD} 2.52032e-05 0 2.52211e-05 0 2.52212e-05 {VDD} 2.52431e-05 {VDD} 2.52432e-05 0 2.52611e-05 0 2.52612e-05 {VDD} 2.52831e-05 {VDD} 2.52832e-05 0 2.53011e-05 0 2.53012e-05 {VDD} 2.53231e-05 {VDD} 2.53232e-05 0 3.02111e-05 0 3.02112e-05 {VDD} 3.02331e-05 {VDD} 3.02332e-05 0 3.02511e-05 0 3.02512e-05 {VDD} 3.02731e-05 {VDD} 3.02732e-05 0 3.02911e-05 0 3.02912e-05 {VDD} 3.03131e-05 {VDD} 3.03132e-05 0 3.03311e-05 0 3.03312e-05 {VDD} 3.03531e-05 {VDD} 3.03532e-05 0 3.52411e-05 0 3.52412e-05 {VDD} 3.52631e-05 {VDD} 3.52632e-05 0 3.52811e-05 0 3.52812e-05 {VDD} 3.53031e-05 {VDD} 3.53032e-05 0 3.53211e-05 0 3.53212e-05 {VDD} 3.53431e-05 {VDD} 3.53432e-05 0 3.53611e-05 0 3.53612e-05 {VDD} 3.53831e-05 {VDD} 3.53832e-05 0 4.02711e-05 0 4.02712e-05 {VDD} 4.02931e-05 {VDD} 4.02932e-05 0 4.03111e-05 0 4.03112e-05 {VDD} 4.03331e-05 {VDD} 4.03332e-05 0 4.03511e-05 0 4.03512e-05 {VDD} 4.03731e-05 {VDD} 4.03732e-05 0 4.03911e-05 0 4.03912e-05 {VDD} 4.04131e-05 {VDD} 4.04132e-05 0 4.53011e-05 0 4.53012e-05 {VDD} 4.53231e-05 {VDD} 4.53232e-05 0 4.53411e-05 0 4.53412e-05 {VDD} 4.53631e-05 {VDD} 4.53632e-05 0 4.53811e-05 0 4.53812e-05 {VDD} 4.54031e-05 {VDD} 4.54032e-05 0 4.54211e-05 0 4.54212e-05 {VDD} 4.54431e-05 {VDD} 4.54432e-05 0 5.03311e-05 0 5.03312e-05 {VDD} 5.03531e-05 {VDD} 5.03532e-05 0 5.03711e-05 0 5.03712e-05 {VDD} 5.03931e-05 {VDD} 5.03932e-05 0 5.04111e-05 0 5.04112e-05 {VDD} 5.04331e-05 {VDD} 5.04332e-05 0 5.04511e-05 0 5.04512e-05 {VDD} 5.04731e-05 {VDD} 5.04732e-05 0)
vbpk_rtl bpk_rtl 0 pwl(0 {VDD} 5.0611e-06 {VDD} 5.0612e-06 0 5.0831e-06 0 5.0832e-06 {VDD} 5.1011e-06 {VDD} 5.1012e-06 0 5.1231e-06 0 5.1232e-06 {VDD} 5.1411e-06 {VDD} 5.1412e-06 0 5.1631e-06 0 5.1632e-06 {VDD} 5.1811e-06 {VDD} 5.1812e-06 0 5.2031e-06 0 5.2032e-06 {VDD} 1.00911e-05 {VDD} 1.00912e-05 0 1.01131e-05 0 1.01132e-05 {VDD} 1.01311e-05 {VDD} 1.01312e-05 0 1.01531e-05 0 1.01532e-05 {VDD} 1.01711e-05 {VDD} 1.01712e-05 0 1.01931e-05 0 1.01932e-05 {VDD} 1.02111e-05 {VDD} 1.02112e-05 0 1.02331e-05 0 1.02332e-05 {VDD} 1.51211e-05 {VDD} 1.51212e-05 0 1.51431e-05 0 1.51432e-05 {VDD} 1.51611e-05 {VDD} 1.51612e-05 0 1.51831e-05 0 1.51832e-05 {VDD} 1.52011e-05 {VDD} 1.52012e-05 0 1.52231e-05 0 1.52232e-05 {VDD} 1.52411e-05 {VDD} 1.52412e-05 0 1.52631e-05 0 1.52632e-05 {VDD} 2.01511e-05 {VDD} 2.01512e-05 0 2.01731e-05 0 2.01732e-05 {VDD} 2.01911e-05 {VDD} 2.01912e-05 0 2.02131e-05 0 2.02132e-05 {VDD} 2.02311e-05 {VDD} 2.02312e-05 0 2.02531e-05 0 2.02532e-05 {VDD} 2.02711e-05 {VDD} 2.02712e-05 0 2.02931e-05 0 2.02932e-05 {VDD} 2.51811e-05 {VDD} 2.51812e-05 0 2.52031e-05 0 2.52032e-05 {VDD} 2.52211e-05 {VDD} 2.52212e-05 0 2.52431e-05 0 2.52432e-05 {VDD} 2.52611e-05 {VDD} 2.52612e-05 0 2.52831e-05 0 2.52832e-05 {VDD} 2.53011e-05 {VDD} 2.53012e-05 0 2.53231e-05 0 2.53232e-05 {VDD} 3.02111e-05 {VDD} 3.02112e-05 0 3.02331e-05 0 3.02332e-05 {VDD} 3.02511e-05 {VDD} 3.02512e-05 0 3.02731e-05 0 3.02732e-05 {VDD} 3.02911e-05 {VDD} 3.02912e-05 0 3.03131e-05 0 3.03132e-05 {VDD} 3.03311e-05 {VDD} 3.03312e-05 0 3.03531e-05 0 3.03532e-05 {VDD} 3.52411e-05 {VDD} 3.52412e-05 0 3.52631e-05 0 3.52632e-05 {VDD} 3.52811e-05 {VDD} 3.52812e-05 0 3.53031e-05 0 3.53032e-05 {VDD} 3.53211e-05 {VDD} 3.53212e-05 0 3.53431e-05 0 3.53432e-05 {VDD} 3.53611e-05 {VDD} 3.53612e-05 0 3.53831e-05 0 3.53832e-05 {VDD} 4.02711e-05 {VDD} 4.02712e-05 0 4.02931e-05 0 4.02932e-05 {VDD} 4.03111e-05 {VDD} 4.03112e-05 0 4.03331e-05 0 4.03332e-05 {VDD} 4.03511e-05 {VDD} 4.03512e-05 0 4.03731e-05 0 4.03732e-05 {VDD} 4.03911e-05 {VDD} 4.03912e-05 0 4.04131e-05 0 4.04132e-05 {VDD} 4.53011e-05 {VDD} 4.53012e-05 0 4.53231e-05 0 4.53232e-05 {VDD} 4.53411e-05 {VDD} 4.53412e-05 0 4.53631e-05 0 4.53632e-05 {VDD} 4.53811e-05 {VDD} 4.53812e-05 0 4.54031e-05 0 4.54032e-05 {VDD} 4.54211e-05 {VDD} 4.54212e-05 0 4.54431e-05 0 4.54432e-05 {VDD} 5.03311e-05 {VDD} 5.03312e-05 0 5.03531e-05 0 5.03532e-05 {VDD} 5.03711e-05 {VDD} 5.03712e-05 0 5.03931e-05 0 5.03932e-05 {VDD} 5.04111e-05 {VDD} 5.04112e-05 0 5.04331e-05 0 5.04332e-05 {VDD} 5.04511e-05 {VDD} 5.04512e-05 0 5.04731e-05 0 5.04732e-05 {VDD})   $ ideal initial-write/park driver connected except during write-back
vrws0_rtl rwls0_rtl 0 pwl(0 {VDD} 5.0511e-06 {VDD} 5.0512e-06 0 5.0611e-06 0 5.0612e-06 {VDD} 1.00811e-05 {VDD} 1.00812e-05 0 1.00911e-05 0 1.00912e-05 {VDD} 1.51111e-05 {VDD} 1.51112e-05 0 1.51211e-05 0 1.51212e-05 {VDD} 2.01411e-05 {VDD} 2.01412e-05 0 2.01511e-05 0 2.01512e-05 {VDD} 2.51711e-05 {VDD} 2.51712e-05 0 2.51811e-05 0 2.51812e-05 {VDD} 3.02011e-05 {VDD} 3.02012e-05 0 3.02111e-05 0 3.02112e-05 {VDD} 3.52311e-05 {VDD} 3.52312e-05 0 3.52411e-05 0 3.52412e-05 {VDD} 4.02611e-05 {VDD} 4.02612e-05 0 4.02711e-05 0 4.02712e-05 {VDD} 4.52911e-05 {VDD} 4.52912e-05 0 4.53011e-05 0 4.53012e-05 {VDD} 5.03211e-05 {VDD} 5.03212e-05 0 5.03311e-05 0 5.03312e-05 {VDD})
vwl0_rtl wl0_rtl 0 pwl(0 0 1e-09 0 1.1e-09 {VDD} 2.1e-08 {VDD} 2.11e-08 0 5.0611e-06 0 5.0612e-06 {VDD} 5.0811e-06 {VDD} 5.0812e-06 0 1.00911e-05 0 1.00912e-05 {VDD} 1.01111e-05 {VDD} 1.01112e-05 0 1.51211e-05 0 1.51212e-05 {VDD} 1.51411e-05 {VDD} 1.51412e-05 0 2.01511e-05 0 2.01512e-05 {VDD} 2.01711e-05 {VDD} 2.01712e-05 0 2.51811e-05 0 2.51812e-05 {VDD} 2.52011e-05 {VDD} 2.52012e-05 0 3.02111e-05 0 3.02112e-05 {VDD} 3.02311e-05 {VDD} 3.02312e-05 0 3.52411e-05 0 3.52412e-05 {VDD} 3.52611e-05 {VDD} 3.52612e-05 0 4.02711e-05 0 4.02712e-05 {VDD} 4.02911e-05 {VDD} 4.02912e-05 0 4.53011e-05 0 4.53012e-05 {VDD} 4.53211e-05 {VDD} 4.53212e-05 0 5.03311e-05 0 5.03312e-05 {VDD} 5.03511e-05 {VDD} 5.03512e-05 0)
vrws1_rtl rwls1_rtl 0 pwl(0 {VDD} 5.0911e-06 {VDD} 5.0912e-06 0 5.1011e-06 0 5.1012e-06 {VDD} 1.01211e-05 {VDD} 1.01212e-05 0 1.01311e-05 0 1.01312e-05 {VDD} 1.51511e-05 {VDD} 1.51512e-05 0 1.51611e-05 0 1.51612e-05 {VDD} 2.01811e-05 {VDD} 2.01812e-05 0 2.01911e-05 0 2.01912e-05 {VDD} 2.52111e-05 {VDD} 2.52112e-05 0 2.52211e-05 0 2.52212e-05 {VDD} 3.02411e-05 {VDD} 3.02412e-05 0 3.02511e-05 0 3.02512e-05 {VDD} 3.52711e-05 {VDD} 3.52712e-05 0 3.52811e-05 0 3.52812e-05 {VDD} 4.03011e-05 {VDD} 4.03012e-05 0 4.03111e-05 0 4.03112e-05 {VDD} 4.53311e-05 {VDD} 4.53312e-05 0 4.53411e-05 0 4.53412e-05 {VDD} 5.03611e-05 {VDD} 5.03612e-05 0 5.03711e-05 0 5.03712e-05 {VDD})
vwl1_rtl wl1_rtl 0 pwl(0 0 4.1e-08 0 4.11e-08 {VDD} 6.1e-08 {VDD} 6.11e-08 0 5.1011e-06 0 5.1012e-06 {VDD} 5.1211e-06 {VDD} 5.1212e-06 0 1.01311e-05 0 1.01312e-05 {VDD} 1.01511e-05 {VDD} 1.01512e-05 0 1.51611e-05 0 1.51612e-05 {VDD} 1.51811e-05 {VDD} 1.51812e-05 0 2.01911e-05 0 2.01912e-05 {VDD} 2.02111e-05 {VDD} 2.02112e-05 0 2.52211e-05 0 2.52212e-05 {VDD} 2.52411e-05 {VDD} 2.52412e-05 0 3.02511e-05 0 3.02512e-05 {VDD} 3.02711e-05 {VDD} 3.02712e-05 0 3.52811e-05 0 3.52812e-05 {VDD} 3.53011e-05 {VDD} 3.53012e-05 0 4.03111e-05 0 4.03112e-05 {VDD} 4.03311e-05 {VDD} 4.03312e-05 0 4.53411e-05 0 4.53412e-05 {VDD} 4.53611e-05 {VDD} 4.53612e-05 0 5.03711e-05 0 5.03712e-05 {VDD} 5.03911e-05 {VDD} 5.03912e-05 0)
vrws2_rtl rwls2_rtl 0 pwl(0 {VDD} 5.1311e-06 {VDD} 5.1312e-06 0 5.1411e-06 0 5.1412e-06 {VDD} 1.01611e-05 {VDD} 1.01612e-05 0 1.01711e-05 0 1.01712e-05 {VDD} 1.51911e-05 {VDD} 1.51912e-05 0 1.52011e-05 0 1.52012e-05 {VDD} 2.02211e-05 {VDD} 2.02212e-05 0 2.02311e-05 0 2.02312e-05 {VDD} 2.52511e-05 {VDD} 2.52512e-05 0 2.52611e-05 0 2.52612e-05 {VDD} 3.02811e-05 {VDD} 3.02812e-05 0 3.02911e-05 0 3.02912e-05 {VDD} 3.53111e-05 {VDD} 3.53112e-05 0 3.53211e-05 0 3.53212e-05 {VDD} 4.03411e-05 {VDD} 4.03412e-05 0 4.03511e-05 0 4.03512e-05 {VDD} 4.53711e-05 {VDD} 4.53712e-05 0 4.53811e-05 0 4.53812e-05 {VDD} 5.04011e-05 {VDD} 5.04012e-05 0 5.04111e-05 0 5.04112e-05 {VDD})
vwl2_rtl wl2_rtl 0 pwl(0 0 8.1e-08 0 8.11e-08 {VDD} 1.01e-07 {VDD} 1.011e-07 0 5.1411e-06 0 5.1412e-06 {VDD} 5.1611e-06 {VDD} 5.1612e-06 0 1.01711e-05 0 1.01712e-05 {VDD} 1.01911e-05 {VDD} 1.01912e-05 0 1.52011e-05 0 1.52012e-05 {VDD} 1.52211e-05 {VDD} 1.52212e-05 0 2.02311e-05 0 2.02312e-05 {VDD} 2.02511e-05 {VDD} 2.02512e-05 0 2.52611e-05 0 2.52612e-05 {VDD} 2.52811e-05 {VDD} 2.52812e-05 0 3.02911e-05 0 3.02912e-05 {VDD} 3.03111e-05 {VDD} 3.03112e-05 0 3.53211e-05 0 3.53212e-05 {VDD} 3.53411e-05 {VDD} 3.53412e-05 0 4.03511e-05 0 4.03512e-05 {VDD} 4.03711e-05 {VDD} 4.03712e-05 0 4.53811e-05 0 4.53812e-05 {VDD} 4.54011e-05 {VDD} 4.54012e-05 0 5.04111e-05 0 5.04112e-05 {VDD} 5.04311e-05 {VDD} 5.04312e-05 0)
vrws3_rtl rwls3_rtl 0 pwl(0 {VDD} 5.1711e-06 {VDD} 5.1712e-06 0 5.1811e-06 0 5.1812e-06 {VDD} 1.02011e-05 {VDD} 1.02012e-05 0 1.02111e-05 0 1.02112e-05 {VDD} 1.52311e-05 {VDD} 1.52312e-05 0 1.52411e-05 0 1.52412e-05 {VDD} 2.02611e-05 {VDD} 2.02612e-05 0 2.02711e-05 0 2.02712e-05 {VDD} 2.52911e-05 {VDD} 2.52912e-05 0 2.53011e-05 0 2.53012e-05 {VDD} 3.03211e-05 {VDD} 3.03212e-05 0 3.03311e-05 0 3.03312e-05 {VDD} 3.53511e-05 {VDD} 3.53512e-05 0 3.53611e-05 0 3.53612e-05 {VDD} 4.03811e-05 {VDD} 4.03812e-05 0 4.03911e-05 0 4.03912e-05 {VDD} 4.54111e-05 {VDD} 4.54112e-05 0 4.54211e-05 0 4.54212e-05 {VDD} 5.04411e-05 {VDD} 5.04412e-05 0 5.04511e-05 0 5.04512e-05 {VDD})
vwl3_rtl wl3_rtl 0 pwl(0 0 1.21e-07 0 1.211e-07 {VDD} 1.41e-07 {VDD} 1.411e-07 0 5.1811e-06 0 5.1812e-06 {VDD} 5.2011e-06 {VDD} 5.2012e-06 0 1.02111e-05 0 1.02112e-05 {VDD} 1.02311e-05 {VDD} 1.02312e-05 0 1.52411e-05 0 1.52412e-05 {VDD} 1.52611e-05 {VDD} 1.52612e-05 0 2.02711e-05 0 2.02712e-05 {VDD} 2.02911e-05 {VDD} 2.02912e-05 0 2.53011e-05 0 2.53012e-05 {VDD} 2.53211e-05 {VDD} 2.53212e-05 0 3.03311e-05 0 3.03312e-05 {VDD} 3.03511e-05 {VDD} 3.03512e-05 0 3.53611e-05 0 3.53612e-05 {VDD} 3.53811e-05 {VDD} 3.53812e-05 0 4.03911e-05 0 4.03912e-05 {VDD} 4.04111e-05 {VDD} 4.04112e-05 0 4.54211e-05 0 4.54212e-05 {VDD} 4.54411e-05 {VDD} 4.54412e-05 0 5.04511e-05 0 5.04512e-05 {VDD} 5.04711e-05 {VDD} 5.04712e-05 0)
* ---- shared control sources, waveform late (source variant rwl_late_hold, write-back True) ----
vctl_late ctl_late 0 pwl(0 {VDD} 5.0511e-06 {VDD} 5.0512e-06 0 5.0841e-06 0 5.0842e-06 {VDD} 5.0911e-06 {VDD} 5.0912e-06 0 5.1241e-06 0 5.1242e-06 {VDD} 5.1311e-06 {VDD} 5.1312e-06 0 5.1641e-06 0 5.1642e-06 {VDD} 5.1711e-06 {VDD} 5.1712e-06 0 5.2041e-06 0 5.2042e-06 {VDD} 1.00811e-05 {VDD} 1.00812e-05 0 1.01141e-05 0 1.01142e-05 {VDD} 1.01211e-05 {VDD} 1.01212e-05 0 1.01541e-05 0 1.01542e-05 {VDD} 1.01611e-05 {VDD} 1.01612e-05 0 1.01941e-05 0 1.01942e-05 {VDD} 1.02011e-05 {VDD} 1.02012e-05 0 1.02341e-05 0 1.02342e-05 {VDD} 1.51111e-05 {VDD} 1.51112e-05 0 1.51441e-05 0 1.51442e-05 {VDD} 1.51511e-05 {VDD} 1.51512e-05 0 1.51841e-05 0 1.51842e-05 {VDD} 1.51911e-05 {VDD} 1.51912e-05 0 1.52241e-05 0 1.52242e-05 {VDD} 1.52311e-05 {VDD} 1.52312e-05 0 1.52641e-05 0 1.52642e-05 {VDD} 2.01411e-05 {VDD} 2.01412e-05 0 2.01741e-05 0 2.01742e-05 {VDD} 2.01811e-05 {VDD} 2.01812e-05 0 2.02141e-05 0 2.02142e-05 {VDD} 2.02211e-05 {VDD} 2.02212e-05 0 2.02541e-05 0 2.02542e-05 {VDD} 2.02611e-05 {VDD} 2.02612e-05 0 2.02941e-05 0 2.02942e-05 {VDD} 2.51711e-05 {VDD} 2.51712e-05 0 2.52041e-05 0 2.52042e-05 {VDD} 2.52111e-05 {VDD} 2.52112e-05 0 2.52441e-05 0 2.52442e-05 {VDD} 2.52511e-05 {VDD} 2.52512e-05 0 2.52841e-05 0 2.52842e-05 {VDD} 2.52911e-05 {VDD} 2.52912e-05 0 2.53241e-05 0 2.53242e-05 {VDD} 3.02011e-05 {VDD} 3.02012e-05 0 3.02341e-05 0 3.02342e-05 {VDD} 3.02411e-05 {VDD} 3.02412e-05 0 3.02741e-05 0 3.02742e-05 {VDD} 3.02811e-05 {VDD} 3.02812e-05 0 3.03141e-05 0 3.03142e-05 {VDD} 3.03211e-05 {VDD} 3.03212e-05 0 3.03541e-05 0 3.03542e-05 {VDD} 3.52311e-05 {VDD} 3.52312e-05 0 3.52641e-05 0 3.52642e-05 {VDD} 3.52711e-05 {VDD} 3.52712e-05 0 3.53041e-05 0 3.53042e-05 {VDD} 3.53111e-05 {VDD} 3.53112e-05 0 3.53441e-05 0 3.53442e-05 {VDD} 3.53511e-05 {VDD} 3.53512e-05 0 3.53841e-05 0 3.53842e-05 {VDD} 4.02611e-05 {VDD} 4.02612e-05 0 4.02941e-05 0 4.02942e-05 {VDD} 4.03011e-05 {VDD} 4.03012e-05 0 4.03341e-05 0 4.03342e-05 {VDD} 4.03411e-05 {VDD} 4.03412e-05 0 4.03741e-05 0 4.03742e-05 {VDD} 4.03811e-05 {VDD} 4.03812e-05 0 4.04141e-05 0 4.04142e-05 {VDD} 4.52911e-05 {VDD} 4.52912e-05 0 4.53241e-05 0 4.53242e-05 {VDD} 4.53311e-05 {VDD} 4.53312e-05 0 4.53641e-05 0 4.53642e-05 {VDD} 4.53711e-05 {VDD} 4.53712e-05 0 4.54041e-05 0 4.54042e-05 {VDD} 4.54111e-05 {VDD} 4.54112e-05 0 4.54441e-05 0 4.54442e-05 {VDD} 5.03211e-05 {VDD} 5.03212e-05 0 5.03541e-05 0 5.03542e-05 {VDD} 5.03611e-05 {VDD} 5.03612e-05 0 5.03941e-05 0 5.03942e-05 {VDD} 5.04011e-05 {VDD} 5.04012e-05 0 5.04341e-05 0 5.04342e-05 {VDD} 5.04411e-05 {VDD} 5.04412e-05 0 5.04741e-05 0 5.04742e-05 {VDD})
ven_late en_late 0 pwl(0 0 5.0601e-06 0 5.0602e-06 {VDD} 5.0831e-06 {VDD} 5.0832e-06 0 5.1001e-06 0 5.1002e-06 {VDD} 5.1231e-06 {VDD} 5.1232e-06 0 5.1401e-06 0 5.1402e-06 {VDD} 5.1631e-06 {VDD} 5.1632e-06 0 5.1801e-06 0 5.1802e-06 {VDD} 5.2031e-06 {VDD} 5.2032e-06 0 1.00901e-05 0 1.00902e-05 {VDD} 1.01131e-05 {VDD} 1.01132e-05 0 1.01301e-05 0 1.01302e-05 {VDD} 1.01531e-05 {VDD} 1.01532e-05 0 1.01701e-05 0 1.01702e-05 {VDD} 1.01931e-05 {VDD} 1.01932e-05 0 1.02101e-05 0 1.02102e-05 {VDD} 1.02331e-05 {VDD} 1.02332e-05 0 1.51201e-05 0 1.51202e-05 {VDD} 1.51431e-05 {VDD} 1.51432e-05 0 1.51601e-05 0 1.51602e-05 {VDD} 1.51831e-05 {VDD} 1.51832e-05 0 1.52001e-05 0 1.52002e-05 {VDD} 1.52231e-05 {VDD} 1.52232e-05 0 1.52401e-05 0 1.52402e-05 {VDD} 1.52631e-05 {VDD} 1.52632e-05 0 2.01501e-05 0 2.01502e-05 {VDD} 2.01731e-05 {VDD} 2.01732e-05 0 2.01901e-05 0 2.01902e-05 {VDD} 2.02131e-05 {VDD} 2.02132e-05 0 2.02301e-05 0 2.02302e-05 {VDD} 2.02531e-05 {VDD} 2.02532e-05 0 2.02701e-05 0 2.02702e-05 {VDD} 2.02931e-05 {VDD} 2.02932e-05 0 2.51801e-05 0 2.51802e-05 {VDD} 2.52031e-05 {VDD} 2.52032e-05 0 2.52201e-05 0 2.52202e-05 {VDD} 2.52431e-05 {VDD} 2.52432e-05 0 2.52601e-05 0 2.52602e-05 {VDD} 2.52831e-05 {VDD} 2.52832e-05 0 2.53001e-05 0 2.53002e-05 {VDD} 2.53231e-05 {VDD} 2.53232e-05 0 3.02101e-05 0 3.02102e-05 {VDD} 3.02331e-05 {VDD} 3.02332e-05 0 3.02501e-05 0 3.02502e-05 {VDD} 3.02731e-05 {VDD} 3.02732e-05 0 3.02901e-05 0 3.02902e-05 {VDD} 3.03131e-05 {VDD} 3.03132e-05 0 3.03301e-05 0 3.03302e-05 {VDD} 3.03531e-05 {VDD} 3.03532e-05 0 3.52401e-05 0 3.52402e-05 {VDD} 3.52631e-05 {VDD} 3.52632e-05 0 3.52801e-05 0 3.52802e-05 {VDD} 3.53031e-05 {VDD} 3.53032e-05 0 3.53201e-05 0 3.53202e-05 {VDD} 3.53431e-05 {VDD} 3.53432e-05 0 3.53601e-05 0 3.53602e-05 {VDD} 3.53831e-05 {VDD} 3.53832e-05 0 4.02701e-05 0 4.02702e-05 {VDD} 4.02931e-05 {VDD} 4.02932e-05 0 4.03101e-05 0 4.03102e-05 {VDD} 4.03331e-05 {VDD} 4.03332e-05 0 4.03501e-05 0 4.03502e-05 {VDD} 4.03731e-05 {VDD} 4.03732e-05 0 4.03901e-05 0 4.03902e-05 {VDD} 4.04131e-05 {VDD} 4.04132e-05 0 4.53001e-05 0 4.53002e-05 {VDD} 4.53231e-05 {VDD} 4.53232e-05 0 4.53401e-05 0 4.53402e-05 {VDD} 4.53631e-05 {VDD} 4.53632e-05 0 4.53801e-05 0 4.53802e-05 {VDD} 4.54031e-05 {VDD} 4.54032e-05 0 4.54201e-05 0 4.54202e-05 {VDD} 4.54431e-05 {VDD} 4.54432e-05 0 5.03301e-05 0 5.03302e-05 {VDD} 5.03531e-05 {VDD} 5.03532e-05 0 5.03701e-05 0 5.03702e-05 {VDD} 5.03931e-05 {VDD} 5.03932e-05 0 5.04101e-05 0 5.04102e-05 {VDD} 5.04331e-05 {VDD} 5.04332e-05 0 5.04501e-05 0 5.04502e-05 {VDD} 5.04731e-05 {VDD} 5.04732e-05 0)
venb_late enb_late 0 pwl(0 {VDD} 5.0601e-06 {VDD} 5.0602e-06 0 5.0831e-06 0 5.0832e-06 {VDD} 5.1001e-06 {VDD} 5.1002e-06 0 5.1231e-06 0 5.1232e-06 {VDD} 5.1401e-06 {VDD} 5.1402e-06 0 5.1631e-06 0 5.1632e-06 {VDD} 5.1801e-06 {VDD} 5.1802e-06 0 5.2031e-06 0 5.2032e-06 {VDD} 1.00901e-05 {VDD} 1.00902e-05 0 1.01131e-05 0 1.01132e-05 {VDD} 1.01301e-05 {VDD} 1.01302e-05 0 1.01531e-05 0 1.01532e-05 {VDD} 1.01701e-05 {VDD} 1.01702e-05 0 1.01931e-05 0 1.01932e-05 {VDD} 1.02101e-05 {VDD} 1.02102e-05 0 1.02331e-05 0 1.02332e-05 {VDD} 1.51201e-05 {VDD} 1.51202e-05 0 1.51431e-05 0 1.51432e-05 {VDD} 1.51601e-05 {VDD} 1.51602e-05 0 1.51831e-05 0 1.51832e-05 {VDD} 1.52001e-05 {VDD} 1.52002e-05 0 1.52231e-05 0 1.52232e-05 {VDD} 1.52401e-05 {VDD} 1.52402e-05 0 1.52631e-05 0 1.52632e-05 {VDD} 2.01501e-05 {VDD} 2.01502e-05 0 2.01731e-05 0 2.01732e-05 {VDD} 2.01901e-05 {VDD} 2.01902e-05 0 2.02131e-05 0 2.02132e-05 {VDD} 2.02301e-05 {VDD} 2.02302e-05 0 2.02531e-05 0 2.02532e-05 {VDD} 2.02701e-05 {VDD} 2.02702e-05 0 2.02931e-05 0 2.02932e-05 {VDD} 2.51801e-05 {VDD} 2.51802e-05 0 2.52031e-05 0 2.52032e-05 {VDD} 2.52201e-05 {VDD} 2.52202e-05 0 2.52431e-05 0 2.52432e-05 {VDD} 2.52601e-05 {VDD} 2.52602e-05 0 2.52831e-05 0 2.52832e-05 {VDD} 2.53001e-05 {VDD} 2.53002e-05 0 2.53231e-05 0 2.53232e-05 {VDD} 3.02101e-05 {VDD} 3.02102e-05 0 3.02331e-05 0 3.02332e-05 {VDD} 3.02501e-05 {VDD} 3.02502e-05 0 3.02731e-05 0 3.02732e-05 {VDD} 3.02901e-05 {VDD} 3.02902e-05 0 3.03131e-05 0 3.03132e-05 {VDD} 3.03301e-05 {VDD} 3.03302e-05 0 3.03531e-05 0 3.03532e-05 {VDD} 3.52401e-05 {VDD} 3.52402e-05 0 3.52631e-05 0 3.52632e-05 {VDD} 3.52801e-05 {VDD} 3.52802e-05 0 3.53031e-05 0 3.53032e-05 {VDD} 3.53201e-05 {VDD} 3.53202e-05 0 3.53431e-05 0 3.53432e-05 {VDD} 3.53601e-05 {VDD} 3.53602e-05 0 3.53831e-05 0 3.53832e-05 {VDD} 4.02701e-05 {VDD} 4.02702e-05 0 4.02931e-05 0 4.02932e-05 {VDD} 4.03101e-05 {VDD} 4.03102e-05 0 4.03331e-05 0 4.03332e-05 {VDD} 4.03501e-05 {VDD} 4.03502e-05 0 4.03731e-05 0 4.03732e-05 {VDD} 4.03901e-05 {VDD} 4.03902e-05 0 4.04131e-05 0 4.04132e-05 {VDD} 4.53001e-05 {VDD} 4.53002e-05 0 4.53231e-05 0 4.53232e-05 {VDD} 4.53401e-05 {VDD} 4.53402e-05 0 4.53631e-05 0 4.53632e-05 {VDD} 4.53801e-05 {VDD} 4.53802e-05 0 4.54031e-05 0 4.54032e-05 {VDD} 4.54201e-05 {VDD} 4.54202e-05 0 4.54431e-05 0 4.54432e-05 {VDD} 5.03301e-05 {VDD} 5.03302e-05 0 5.03531e-05 0 5.03532e-05 {VDD} 5.03701e-05 {VDD} 5.03702e-05 0 5.03931e-05 0 5.03932e-05 {VDD} 5.04101e-05 {VDD} 5.04102e-05 0 5.04331e-05 0 5.04332e-05 {VDD} 5.04501e-05 {VDD} 5.04502e-05 0 5.04731e-05 0 5.04732e-05 {VDD})
vwbc_late wbc_late 0 pwl(0 0 5.0611e-06 0 5.0612e-06 {VDD} 5.0831e-06 {VDD} 5.0832e-06 0 5.1011e-06 0 5.1012e-06 {VDD} 5.1231e-06 {VDD} 5.1232e-06 0 5.1411e-06 0 5.1412e-06 {VDD} 5.1631e-06 {VDD} 5.1632e-06 0 5.1811e-06 0 5.1812e-06 {VDD} 5.2031e-06 {VDD} 5.2032e-06 0 1.00911e-05 0 1.00912e-05 {VDD} 1.01131e-05 {VDD} 1.01132e-05 0 1.01311e-05 0 1.01312e-05 {VDD} 1.01531e-05 {VDD} 1.01532e-05 0 1.01711e-05 0 1.01712e-05 {VDD} 1.01931e-05 {VDD} 1.01932e-05 0 1.02111e-05 0 1.02112e-05 {VDD} 1.02331e-05 {VDD} 1.02332e-05 0 1.51211e-05 0 1.51212e-05 {VDD} 1.51431e-05 {VDD} 1.51432e-05 0 1.51611e-05 0 1.51612e-05 {VDD} 1.51831e-05 {VDD} 1.51832e-05 0 1.52011e-05 0 1.52012e-05 {VDD} 1.52231e-05 {VDD} 1.52232e-05 0 1.52411e-05 0 1.52412e-05 {VDD} 1.52631e-05 {VDD} 1.52632e-05 0 2.01511e-05 0 2.01512e-05 {VDD} 2.01731e-05 {VDD} 2.01732e-05 0 2.01911e-05 0 2.01912e-05 {VDD} 2.02131e-05 {VDD} 2.02132e-05 0 2.02311e-05 0 2.02312e-05 {VDD} 2.02531e-05 {VDD} 2.02532e-05 0 2.02711e-05 0 2.02712e-05 {VDD} 2.02931e-05 {VDD} 2.02932e-05 0 2.51811e-05 0 2.51812e-05 {VDD} 2.52031e-05 {VDD} 2.52032e-05 0 2.52211e-05 0 2.52212e-05 {VDD} 2.52431e-05 {VDD} 2.52432e-05 0 2.52611e-05 0 2.52612e-05 {VDD} 2.52831e-05 {VDD} 2.52832e-05 0 2.53011e-05 0 2.53012e-05 {VDD} 2.53231e-05 {VDD} 2.53232e-05 0 3.02111e-05 0 3.02112e-05 {VDD} 3.02331e-05 {VDD} 3.02332e-05 0 3.02511e-05 0 3.02512e-05 {VDD} 3.02731e-05 {VDD} 3.02732e-05 0 3.02911e-05 0 3.02912e-05 {VDD} 3.03131e-05 {VDD} 3.03132e-05 0 3.03311e-05 0 3.03312e-05 {VDD} 3.03531e-05 {VDD} 3.03532e-05 0 3.52411e-05 0 3.52412e-05 {VDD} 3.52631e-05 {VDD} 3.52632e-05 0 3.52811e-05 0 3.52812e-05 {VDD} 3.53031e-05 {VDD} 3.53032e-05 0 3.53211e-05 0 3.53212e-05 {VDD} 3.53431e-05 {VDD} 3.53432e-05 0 3.53611e-05 0 3.53612e-05 {VDD} 3.53831e-05 {VDD} 3.53832e-05 0 4.02711e-05 0 4.02712e-05 {VDD} 4.02931e-05 {VDD} 4.02932e-05 0 4.03111e-05 0 4.03112e-05 {VDD} 4.03331e-05 {VDD} 4.03332e-05 0 4.03511e-05 0 4.03512e-05 {VDD} 4.03731e-05 {VDD} 4.03732e-05 0 4.03911e-05 0 4.03912e-05 {VDD} 4.04131e-05 {VDD} 4.04132e-05 0 4.53011e-05 0 4.53012e-05 {VDD} 4.53231e-05 {VDD} 4.53232e-05 0 4.53411e-05 0 4.53412e-05 {VDD} 4.53631e-05 {VDD} 4.53632e-05 0 4.53811e-05 0 4.53812e-05 {VDD} 4.54031e-05 {VDD} 4.54032e-05 0 4.54211e-05 0 4.54212e-05 {VDD} 4.54431e-05 {VDD} 4.54432e-05 0 5.03311e-05 0 5.03312e-05 {VDD} 5.03531e-05 {VDD} 5.03532e-05 0 5.03711e-05 0 5.03712e-05 {VDD} 5.03931e-05 {VDD} 5.03932e-05 0 5.04111e-05 0 5.04112e-05 {VDD} 5.04331e-05 {VDD} 5.04332e-05 0 5.04511e-05 0 5.04512e-05 {VDD} 5.04731e-05 {VDD} 5.04732e-05 0)
vbpk_late bpk_late 0 pwl(0 {VDD} 5.0611e-06 {VDD} 5.0612e-06 0 5.0831e-06 0 5.0832e-06 {VDD} 5.1011e-06 {VDD} 5.1012e-06 0 5.1231e-06 0 5.1232e-06 {VDD} 5.1411e-06 {VDD} 5.1412e-06 0 5.1631e-06 0 5.1632e-06 {VDD} 5.1811e-06 {VDD} 5.1812e-06 0 5.2031e-06 0 5.2032e-06 {VDD} 1.00911e-05 {VDD} 1.00912e-05 0 1.01131e-05 0 1.01132e-05 {VDD} 1.01311e-05 {VDD} 1.01312e-05 0 1.01531e-05 0 1.01532e-05 {VDD} 1.01711e-05 {VDD} 1.01712e-05 0 1.01931e-05 0 1.01932e-05 {VDD} 1.02111e-05 {VDD} 1.02112e-05 0 1.02331e-05 0 1.02332e-05 {VDD} 1.51211e-05 {VDD} 1.51212e-05 0 1.51431e-05 0 1.51432e-05 {VDD} 1.51611e-05 {VDD} 1.51612e-05 0 1.51831e-05 0 1.51832e-05 {VDD} 1.52011e-05 {VDD} 1.52012e-05 0 1.52231e-05 0 1.52232e-05 {VDD} 1.52411e-05 {VDD} 1.52412e-05 0 1.52631e-05 0 1.52632e-05 {VDD} 2.01511e-05 {VDD} 2.01512e-05 0 2.01731e-05 0 2.01732e-05 {VDD} 2.01911e-05 {VDD} 2.01912e-05 0 2.02131e-05 0 2.02132e-05 {VDD} 2.02311e-05 {VDD} 2.02312e-05 0 2.02531e-05 0 2.02532e-05 {VDD} 2.02711e-05 {VDD} 2.02712e-05 0 2.02931e-05 0 2.02932e-05 {VDD} 2.51811e-05 {VDD} 2.51812e-05 0 2.52031e-05 0 2.52032e-05 {VDD} 2.52211e-05 {VDD} 2.52212e-05 0 2.52431e-05 0 2.52432e-05 {VDD} 2.52611e-05 {VDD} 2.52612e-05 0 2.52831e-05 0 2.52832e-05 {VDD} 2.53011e-05 {VDD} 2.53012e-05 0 2.53231e-05 0 2.53232e-05 {VDD} 3.02111e-05 {VDD} 3.02112e-05 0 3.02331e-05 0 3.02332e-05 {VDD} 3.02511e-05 {VDD} 3.02512e-05 0 3.02731e-05 0 3.02732e-05 {VDD} 3.02911e-05 {VDD} 3.02912e-05 0 3.03131e-05 0 3.03132e-05 {VDD} 3.03311e-05 {VDD} 3.03312e-05 0 3.03531e-05 0 3.03532e-05 {VDD} 3.52411e-05 {VDD} 3.52412e-05 0 3.52631e-05 0 3.52632e-05 {VDD} 3.52811e-05 {VDD} 3.52812e-05 0 3.53031e-05 0 3.53032e-05 {VDD} 3.53211e-05 {VDD} 3.53212e-05 0 3.53431e-05 0 3.53432e-05 {VDD} 3.53611e-05 {VDD} 3.53612e-05 0 3.53831e-05 0 3.53832e-05 {VDD} 4.02711e-05 {VDD} 4.02712e-05 0 4.02931e-05 0 4.02932e-05 {VDD} 4.03111e-05 {VDD} 4.03112e-05 0 4.03331e-05 0 4.03332e-05 {VDD} 4.03511e-05 {VDD} 4.03512e-05 0 4.03731e-05 0 4.03732e-05 {VDD} 4.03911e-05 {VDD} 4.03912e-05 0 4.04131e-05 0 4.04132e-05 {VDD} 4.53011e-05 {VDD} 4.53012e-05 0 4.53231e-05 0 4.53232e-05 {VDD} 4.53411e-05 {VDD} 4.53412e-05 0 4.53631e-05 0 4.53632e-05 {VDD} 4.53811e-05 {VDD} 4.53812e-05 0 4.54031e-05 0 4.54032e-05 {VDD} 4.54211e-05 {VDD} 4.54212e-05 0 4.54431e-05 0 4.54432e-05 {VDD} 5.03311e-05 {VDD} 5.03312e-05 0 5.03531e-05 0 5.03532e-05 {VDD} 5.03711e-05 {VDD} 5.03712e-05 0 5.03931e-05 0 5.03932e-05 {VDD} 5.04111e-05 {VDD} 5.04112e-05 0 5.04331e-05 0 5.04332e-05 {VDD} 5.04511e-05 {VDD} 5.04512e-05 0 5.04731e-05 0 5.04732e-05 {VDD})   $ ideal initial-write/park driver connected except during write-back
vrws0_late rwls0_late 0 pwl(0 {VDD} 5.0511e-06 {VDD} 5.0512e-06 0 5.0831e-06 0 5.0832e-06 {VDD} 1.00811e-05 {VDD} 1.00812e-05 0 1.01131e-05 0 1.01132e-05 {VDD} 1.51111e-05 {VDD} 1.51112e-05 0 1.51431e-05 0 1.51432e-05 {VDD} 2.01411e-05 {VDD} 2.01412e-05 0 2.01731e-05 0 2.01732e-05 {VDD} 2.51711e-05 {VDD} 2.51712e-05 0 2.52031e-05 0 2.52032e-05 {VDD} 3.02011e-05 {VDD} 3.02012e-05 0 3.02331e-05 0 3.02332e-05 {VDD} 3.52311e-05 {VDD} 3.52312e-05 0 3.52631e-05 0 3.52632e-05 {VDD} 4.02611e-05 {VDD} 4.02612e-05 0 4.02931e-05 0 4.02932e-05 {VDD} 4.52911e-05 {VDD} 4.52912e-05 0 4.53231e-05 0 4.53232e-05 {VDD} 5.03211e-05 {VDD} 5.03212e-05 0 5.03531e-05 0 5.03532e-05 {VDD})
vwl0_late wl0_late 0 pwl(0 0 1e-09 0 1.1e-09 {VDD} 2.1e-08 {VDD} 2.11e-08 0 5.0611e-06 0 5.0612e-06 {VDD} 5.0811e-06 {VDD} 5.0812e-06 0 1.00911e-05 0 1.00912e-05 {VDD} 1.01111e-05 {VDD} 1.01112e-05 0 1.51211e-05 0 1.51212e-05 {VDD} 1.51411e-05 {VDD} 1.51412e-05 0 2.01511e-05 0 2.01512e-05 {VDD} 2.01711e-05 {VDD} 2.01712e-05 0 2.51811e-05 0 2.51812e-05 {VDD} 2.52011e-05 {VDD} 2.52012e-05 0 3.02111e-05 0 3.02112e-05 {VDD} 3.02311e-05 {VDD} 3.02312e-05 0 3.52411e-05 0 3.52412e-05 {VDD} 3.52611e-05 {VDD} 3.52612e-05 0 4.02711e-05 0 4.02712e-05 {VDD} 4.02911e-05 {VDD} 4.02912e-05 0 4.53011e-05 0 4.53012e-05 {VDD} 4.53211e-05 {VDD} 4.53212e-05 0 5.03311e-05 0 5.03312e-05 {VDD} 5.03511e-05 {VDD} 5.03512e-05 0)
vrws1_late rwls1_late 0 pwl(0 {VDD} 5.0911e-06 {VDD} 5.0912e-06 0 5.1231e-06 0 5.1232e-06 {VDD} 1.01211e-05 {VDD} 1.01212e-05 0 1.01531e-05 0 1.01532e-05 {VDD} 1.51511e-05 {VDD} 1.51512e-05 0 1.51831e-05 0 1.51832e-05 {VDD} 2.01811e-05 {VDD} 2.01812e-05 0 2.02131e-05 0 2.02132e-05 {VDD} 2.52111e-05 {VDD} 2.52112e-05 0 2.52431e-05 0 2.52432e-05 {VDD} 3.02411e-05 {VDD} 3.02412e-05 0 3.02731e-05 0 3.02732e-05 {VDD} 3.52711e-05 {VDD} 3.52712e-05 0 3.53031e-05 0 3.53032e-05 {VDD} 4.03011e-05 {VDD} 4.03012e-05 0 4.03331e-05 0 4.03332e-05 {VDD} 4.53311e-05 {VDD} 4.53312e-05 0 4.53631e-05 0 4.53632e-05 {VDD} 5.03611e-05 {VDD} 5.03612e-05 0 5.03931e-05 0 5.03932e-05 {VDD})
vwl1_late wl1_late 0 pwl(0 0 4.1e-08 0 4.11e-08 {VDD} 6.1e-08 {VDD} 6.11e-08 0 5.1011e-06 0 5.1012e-06 {VDD} 5.1211e-06 {VDD} 5.1212e-06 0 1.01311e-05 0 1.01312e-05 {VDD} 1.01511e-05 {VDD} 1.01512e-05 0 1.51611e-05 0 1.51612e-05 {VDD} 1.51811e-05 {VDD} 1.51812e-05 0 2.01911e-05 0 2.01912e-05 {VDD} 2.02111e-05 {VDD} 2.02112e-05 0 2.52211e-05 0 2.52212e-05 {VDD} 2.52411e-05 {VDD} 2.52412e-05 0 3.02511e-05 0 3.02512e-05 {VDD} 3.02711e-05 {VDD} 3.02712e-05 0 3.52811e-05 0 3.52812e-05 {VDD} 3.53011e-05 {VDD} 3.53012e-05 0 4.03111e-05 0 4.03112e-05 {VDD} 4.03311e-05 {VDD} 4.03312e-05 0 4.53411e-05 0 4.53412e-05 {VDD} 4.53611e-05 {VDD} 4.53612e-05 0 5.03711e-05 0 5.03712e-05 {VDD} 5.03911e-05 {VDD} 5.03912e-05 0)
vrws2_late rwls2_late 0 pwl(0 {VDD} 5.1311e-06 {VDD} 5.1312e-06 0 5.1631e-06 0 5.1632e-06 {VDD} 1.01611e-05 {VDD} 1.01612e-05 0 1.01931e-05 0 1.01932e-05 {VDD} 1.51911e-05 {VDD} 1.51912e-05 0 1.52231e-05 0 1.52232e-05 {VDD} 2.02211e-05 {VDD} 2.02212e-05 0 2.02531e-05 0 2.02532e-05 {VDD} 2.52511e-05 {VDD} 2.52512e-05 0 2.52831e-05 0 2.52832e-05 {VDD} 3.02811e-05 {VDD} 3.02812e-05 0 3.03131e-05 0 3.03132e-05 {VDD} 3.53111e-05 {VDD} 3.53112e-05 0 3.53431e-05 0 3.53432e-05 {VDD} 4.03411e-05 {VDD} 4.03412e-05 0 4.03731e-05 0 4.03732e-05 {VDD} 4.53711e-05 {VDD} 4.53712e-05 0 4.54031e-05 0 4.54032e-05 {VDD} 5.04011e-05 {VDD} 5.04012e-05 0 5.04331e-05 0 5.04332e-05 {VDD})
vwl2_late wl2_late 0 pwl(0 0 8.1e-08 0 8.11e-08 {VDD} 1.01e-07 {VDD} 1.011e-07 0 5.1411e-06 0 5.1412e-06 {VDD} 5.1611e-06 {VDD} 5.1612e-06 0 1.01711e-05 0 1.01712e-05 {VDD} 1.01911e-05 {VDD} 1.01912e-05 0 1.52011e-05 0 1.52012e-05 {VDD} 1.52211e-05 {VDD} 1.52212e-05 0 2.02311e-05 0 2.02312e-05 {VDD} 2.02511e-05 {VDD} 2.02512e-05 0 2.52611e-05 0 2.52612e-05 {VDD} 2.52811e-05 {VDD} 2.52812e-05 0 3.02911e-05 0 3.02912e-05 {VDD} 3.03111e-05 {VDD} 3.03112e-05 0 3.53211e-05 0 3.53212e-05 {VDD} 3.53411e-05 {VDD} 3.53412e-05 0 4.03511e-05 0 4.03512e-05 {VDD} 4.03711e-05 {VDD} 4.03712e-05 0 4.53811e-05 0 4.53812e-05 {VDD} 4.54011e-05 {VDD} 4.54012e-05 0 5.04111e-05 0 5.04112e-05 {VDD} 5.04311e-05 {VDD} 5.04312e-05 0)
vrws3_late rwls3_late 0 pwl(0 {VDD} 5.1711e-06 {VDD} 5.1712e-06 0 5.2031e-06 0 5.2032e-06 {VDD} 1.02011e-05 {VDD} 1.02012e-05 0 1.02331e-05 0 1.02332e-05 {VDD} 1.52311e-05 {VDD} 1.52312e-05 0 1.52631e-05 0 1.52632e-05 {VDD} 2.02611e-05 {VDD} 2.02612e-05 0 2.02931e-05 0 2.02932e-05 {VDD} 2.52911e-05 {VDD} 2.52912e-05 0 2.53231e-05 0 2.53232e-05 {VDD} 3.03211e-05 {VDD} 3.03212e-05 0 3.03531e-05 0 3.03532e-05 {VDD} 3.53511e-05 {VDD} 3.53512e-05 0 3.53831e-05 0 3.53832e-05 {VDD} 4.03811e-05 {VDD} 4.03812e-05 0 4.04131e-05 0 4.04132e-05 {VDD} 4.54111e-05 {VDD} 4.54112e-05 0 4.54431e-05 0 4.54432e-05 {VDD} 5.04411e-05 {VDD} 5.04412e-05 0 5.04731e-05 0 5.04732e-05 {VDD})
vwl3_late wl3_late 0 pwl(0 0 1.21e-07 0 1.211e-07 {VDD} 1.41e-07 {VDD} 1.411e-07 0 5.1811e-06 0 5.1812e-06 {VDD} 5.2011e-06 {VDD} 5.2012e-06 0 1.02111e-05 0 1.02112e-05 {VDD} 1.02311e-05 {VDD} 1.02312e-05 0 1.52411e-05 0 1.52412e-05 {VDD} 1.52611e-05 {VDD} 1.52612e-05 0 2.02711e-05 0 2.02712e-05 {VDD} 2.02911e-05 {VDD} 2.02912e-05 0 2.53011e-05 0 2.53012e-05 {VDD} 2.53211e-05 {VDD} 2.53212e-05 0 3.03311e-05 0 3.03312e-05 {VDD} 3.03511e-05 {VDD} 3.03512e-05 0 3.53611e-05 0 3.53612e-05 {VDD} 3.53811e-05 {VDD} 3.53812e-05 0 4.03911e-05 0 4.03912e-05 {VDD} 4.04111e-05 {VDD} 4.04112e-05 0 4.54211e-05 0 4.54212e-05 {VDD} 4.54411e-05 {VDD} 4.54412e-05 0 5.04511e-05 0 5.04512e-05 {VDD} 5.04711e-05 {VDD} 5.04712e-05 0)
* ---- shared control sources, waveform nowb (source variant baseline_analog, write-back False) ----
vctl_nowb ctl_nowb 0 pwl(0 {VDD} 5.0491e-06 {VDD} 5.0492e-06 0 5.0851e-06 0 5.0852e-06 {VDD} 5.0891e-06 {VDD} 5.0892e-06 0 5.1251e-06 0 5.1252e-06 {VDD} 5.1291e-06 {VDD} 5.1292e-06 0 5.1651e-06 0 5.1652e-06 {VDD} 5.1691e-06 {VDD} 5.1692e-06 0 5.2051e-06 0 5.2052e-06 {VDD} 1.00791e-05 {VDD} 1.00792e-05 0 1.01151e-05 0 1.01152e-05 {VDD} 1.01191e-05 {VDD} 1.01192e-05 0 1.01551e-05 0 1.01552e-05 {VDD} 1.01591e-05 {VDD} 1.01592e-05 0 1.01951e-05 0 1.01952e-05 {VDD} 1.01991e-05 {VDD} 1.01992e-05 0 1.02351e-05 0 1.02352e-05 {VDD} 1.51091e-05 {VDD} 1.51092e-05 0 1.51451e-05 0 1.51452e-05 {VDD} 1.51491e-05 {VDD} 1.51492e-05 0 1.51851e-05 0 1.51852e-05 {VDD} 1.51891e-05 {VDD} 1.51892e-05 0 1.52251e-05 0 1.52252e-05 {VDD} 1.52291e-05 {VDD} 1.52292e-05 0 1.52651e-05 0 1.52652e-05 {VDD} 2.01391e-05 {VDD} 2.01392e-05 0 2.01751e-05 0 2.01752e-05 {VDD} 2.01791e-05 {VDD} 2.01792e-05 0 2.02151e-05 0 2.02152e-05 {VDD} 2.02191e-05 {VDD} 2.02192e-05 0 2.02551e-05 0 2.02552e-05 {VDD} 2.02591e-05 {VDD} 2.02592e-05 0 2.02951e-05 0 2.02952e-05 {VDD} 2.51691e-05 {VDD} 2.51692e-05 0 2.52051e-05 0 2.52052e-05 {VDD} 2.52091e-05 {VDD} 2.52092e-05 0 2.52451e-05 0 2.52452e-05 {VDD} 2.52491e-05 {VDD} 2.52492e-05 0 2.52851e-05 0 2.52852e-05 {VDD} 2.52891e-05 {VDD} 2.52892e-05 0 2.53251e-05 0 2.53252e-05 {VDD} 3.01991e-05 {VDD} 3.01992e-05 0 3.02351e-05 0 3.02352e-05 {VDD} 3.02391e-05 {VDD} 3.02392e-05 0 3.02751e-05 0 3.02752e-05 {VDD} 3.02791e-05 {VDD} 3.02792e-05 0 3.03151e-05 0 3.03152e-05 {VDD} 3.03191e-05 {VDD} 3.03192e-05 0 3.03551e-05 0 3.03552e-05 {VDD} 3.52291e-05 {VDD} 3.52292e-05 0 3.52651e-05 0 3.52652e-05 {VDD} 3.52691e-05 {VDD} 3.52692e-05 0 3.53051e-05 0 3.53052e-05 {VDD} 3.53091e-05 {VDD} 3.53092e-05 0 3.53451e-05 0 3.53452e-05 {VDD} 3.53491e-05 {VDD} 3.53492e-05 0 3.53851e-05 0 3.53852e-05 {VDD} 4.02591e-05 {VDD} 4.02592e-05 0 4.02951e-05 0 4.02952e-05 {VDD} 4.02991e-05 {VDD} 4.02992e-05 0 4.03351e-05 0 4.03352e-05 {VDD} 4.03391e-05 {VDD} 4.03392e-05 0 4.03751e-05 0 4.03752e-05 {VDD} 4.03791e-05 {VDD} 4.03792e-05 0 4.04151e-05 0 4.04152e-05 {VDD} 4.52891e-05 {VDD} 4.52892e-05 0 4.53251e-05 0 4.53252e-05 {VDD} 4.53291e-05 {VDD} 4.53292e-05 0 4.53651e-05 0 4.53652e-05 {VDD} 4.53691e-05 {VDD} 4.53692e-05 0 4.54051e-05 0 4.54052e-05 {VDD} 4.54091e-05 {VDD} 4.54092e-05 0 4.54451e-05 0 4.54452e-05 {VDD} 5.03191e-05 {VDD} 5.03192e-05 0 5.03551e-05 0 5.03552e-05 {VDD} 5.03591e-05 {VDD} 5.03592e-05 0 5.03951e-05 0 5.03952e-05 {VDD} 5.03991e-05 {VDD} 5.03992e-05 0 5.04351e-05 0 5.04352e-05 {VDD} 5.04391e-05 {VDD} 5.04392e-05 0 5.04751e-05 0 5.04752e-05 {VDD})
ven_nowb en_nowb 0 pwl(0 0 5.0611e-06 0 5.0612e-06 {VDD} 5.0841e-06 {VDD} 5.0842e-06 0 5.1011e-06 0 5.1012e-06 {VDD} 5.1241e-06 {VDD} 5.1242e-06 0 5.1411e-06 0 5.1412e-06 {VDD} 5.1641e-06 {VDD} 5.1642e-06 0 5.1811e-06 0 5.1812e-06 {VDD} 5.2041e-06 {VDD} 5.2042e-06 0 1.00911e-05 0 1.00912e-05 {VDD} 1.01141e-05 {VDD} 1.01142e-05 0 1.01311e-05 0 1.01312e-05 {VDD} 1.01541e-05 {VDD} 1.01542e-05 0 1.01711e-05 0 1.01712e-05 {VDD} 1.01941e-05 {VDD} 1.01942e-05 0 1.02111e-05 0 1.02112e-05 {VDD} 1.02341e-05 {VDD} 1.02342e-05 0 1.51211e-05 0 1.51212e-05 {VDD} 1.51441e-05 {VDD} 1.51442e-05 0 1.51611e-05 0 1.51612e-05 {VDD} 1.51841e-05 {VDD} 1.51842e-05 0 1.52011e-05 0 1.52012e-05 {VDD} 1.52241e-05 {VDD} 1.52242e-05 0 1.52411e-05 0 1.52412e-05 {VDD} 1.52641e-05 {VDD} 1.52642e-05 0 2.01511e-05 0 2.01512e-05 {VDD} 2.01741e-05 {VDD} 2.01742e-05 0 2.01911e-05 0 2.01912e-05 {VDD} 2.02141e-05 {VDD} 2.02142e-05 0 2.02311e-05 0 2.02312e-05 {VDD} 2.02541e-05 {VDD} 2.02542e-05 0 2.02711e-05 0 2.02712e-05 {VDD} 2.02941e-05 {VDD} 2.02942e-05 0 2.51811e-05 0 2.51812e-05 {VDD} 2.52041e-05 {VDD} 2.52042e-05 0 2.52211e-05 0 2.52212e-05 {VDD} 2.52441e-05 {VDD} 2.52442e-05 0 2.52611e-05 0 2.52612e-05 {VDD} 2.52841e-05 {VDD} 2.52842e-05 0 2.53011e-05 0 2.53012e-05 {VDD} 2.53241e-05 {VDD} 2.53242e-05 0 3.02111e-05 0 3.02112e-05 {VDD} 3.02341e-05 {VDD} 3.02342e-05 0 3.02511e-05 0 3.02512e-05 {VDD} 3.02741e-05 {VDD} 3.02742e-05 0 3.02911e-05 0 3.02912e-05 {VDD} 3.03141e-05 {VDD} 3.03142e-05 0 3.03311e-05 0 3.03312e-05 {VDD} 3.03541e-05 {VDD} 3.03542e-05 0 3.52411e-05 0 3.52412e-05 {VDD} 3.52641e-05 {VDD} 3.52642e-05 0 3.52811e-05 0 3.52812e-05 {VDD} 3.53041e-05 {VDD} 3.53042e-05 0 3.53211e-05 0 3.53212e-05 {VDD} 3.53441e-05 {VDD} 3.53442e-05 0 3.53611e-05 0 3.53612e-05 {VDD} 3.53841e-05 {VDD} 3.53842e-05 0 4.02711e-05 0 4.02712e-05 {VDD} 4.02941e-05 {VDD} 4.02942e-05 0 4.03111e-05 0 4.03112e-05 {VDD} 4.03341e-05 {VDD} 4.03342e-05 0 4.03511e-05 0 4.03512e-05 {VDD} 4.03741e-05 {VDD} 4.03742e-05 0 4.03911e-05 0 4.03912e-05 {VDD} 4.04141e-05 {VDD} 4.04142e-05 0 4.53011e-05 0 4.53012e-05 {VDD} 4.53241e-05 {VDD} 4.53242e-05 0 4.53411e-05 0 4.53412e-05 {VDD} 4.53641e-05 {VDD} 4.53642e-05 0 4.53811e-05 0 4.53812e-05 {VDD} 4.54041e-05 {VDD} 4.54042e-05 0 4.54211e-05 0 4.54212e-05 {VDD} 4.54441e-05 {VDD} 4.54442e-05 0 5.03311e-05 0 5.03312e-05 {VDD} 5.03541e-05 {VDD} 5.03542e-05 0 5.03711e-05 0 5.03712e-05 {VDD} 5.03941e-05 {VDD} 5.03942e-05 0 5.04111e-05 0 5.04112e-05 {VDD} 5.04341e-05 {VDD} 5.04342e-05 0 5.04511e-05 0 5.04512e-05 {VDD} 5.04741e-05 {VDD} 5.04742e-05 0)
venb_nowb enb_nowb 0 pwl(0 {VDD} 5.0611e-06 {VDD} 5.0612e-06 0 5.0841e-06 0 5.0842e-06 {VDD} 5.1011e-06 {VDD} 5.1012e-06 0 5.1241e-06 0 5.1242e-06 {VDD} 5.1411e-06 {VDD} 5.1412e-06 0 5.1641e-06 0 5.1642e-06 {VDD} 5.1811e-06 {VDD} 5.1812e-06 0 5.2041e-06 0 5.2042e-06 {VDD} 1.00911e-05 {VDD} 1.00912e-05 0 1.01141e-05 0 1.01142e-05 {VDD} 1.01311e-05 {VDD} 1.01312e-05 0 1.01541e-05 0 1.01542e-05 {VDD} 1.01711e-05 {VDD} 1.01712e-05 0 1.01941e-05 0 1.01942e-05 {VDD} 1.02111e-05 {VDD} 1.02112e-05 0 1.02341e-05 0 1.02342e-05 {VDD} 1.51211e-05 {VDD} 1.51212e-05 0 1.51441e-05 0 1.51442e-05 {VDD} 1.51611e-05 {VDD} 1.51612e-05 0 1.51841e-05 0 1.51842e-05 {VDD} 1.52011e-05 {VDD} 1.52012e-05 0 1.52241e-05 0 1.52242e-05 {VDD} 1.52411e-05 {VDD} 1.52412e-05 0 1.52641e-05 0 1.52642e-05 {VDD} 2.01511e-05 {VDD} 2.01512e-05 0 2.01741e-05 0 2.01742e-05 {VDD} 2.01911e-05 {VDD} 2.01912e-05 0 2.02141e-05 0 2.02142e-05 {VDD} 2.02311e-05 {VDD} 2.02312e-05 0 2.02541e-05 0 2.02542e-05 {VDD} 2.02711e-05 {VDD} 2.02712e-05 0 2.02941e-05 0 2.02942e-05 {VDD} 2.51811e-05 {VDD} 2.51812e-05 0 2.52041e-05 0 2.52042e-05 {VDD} 2.52211e-05 {VDD} 2.52212e-05 0 2.52441e-05 0 2.52442e-05 {VDD} 2.52611e-05 {VDD} 2.52612e-05 0 2.52841e-05 0 2.52842e-05 {VDD} 2.53011e-05 {VDD} 2.53012e-05 0 2.53241e-05 0 2.53242e-05 {VDD} 3.02111e-05 {VDD} 3.02112e-05 0 3.02341e-05 0 3.02342e-05 {VDD} 3.02511e-05 {VDD} 3.02512e-05 0 3.02741e-05 0 3.02742e-05 {VDD} 3.02911e-05 {VDD} 3.02912e-05 0 3.03141e-05 0 3.03142e-05 {VDD} 3.03311e-05 {VDD} 3.03312e-05 0 3.03541e-05 0 3.03542e-05 {VDD} 3.52411e-05 {VDD} 3.52412e-05 0 3.52641e-05 0 3.52642e-05 {VDD} 3.52811e-05 {VDD} 3.52812e-05 0 3.53041e-05 0 3.53042e-05 {VDD} 3.53211e-05 {VDD} 3.53212e-05 0 3.53441e-05 0 3.53442e-05 {VDD} 3.53611e-05 {VDD} 3.53612e-05 0 3.53841e-05 0 3.53842e-05 {VDD} 4.02711e-05 {VDD} 4.02712e-05 0 4.02941e-05 0 4.02942e-05 {VDD} 4.03111e-05 {VDD} 4.03112e-05 0 4.03341e-05 0 4.03342e-05 {VDD} 4.03511e-05 {VDD} 4.03512e-05 0 4.03741e-05 0 4.03742e-05 {VDD} 4.03911e-05 {VDD} 4.03912e-05 0 4.04141e-05 0 4.04142e-05 {VDD} 4.53011e-05 {VDD} 4.53012e-05 0 4.53241e-05 0 4.53242e-05 {VDD} 4.53411e-05 {VDD} 4.53412e-05 0 4.53641e-05 0 4.53642e-05 {VDD} 4.53811e-05 {VDD} 4.53812e-05 0 4.54041e-05 0 4.54042e-05 {VDD} 4.54211e-05 {VDD} 4.54212e-05 0 4.54441e-05 0 4.54442e-05 {VDD} 5.03311e-05 {VDD} 5.03312e-05 0 5.03541e-05 0 5.03542e-05 {VDD} 5.03711e-05 {VDD} 5.03712e-05 0 5.03941e-05 0 5.03942e-05 {VDD} 5.04111e-05 {VDD} 5.04112e-05 0 5.04341e-05 0 5.04342e-05 {VDD} 5.04511e-05 {VDD} 5.04512e-05 0 5.04741e-05 0 5.04742e-05 {VDD})
vwbc_nowb wbc_nowb 0 pwl(0 0 5.0621e-06 0 5.0622e-06 {VDD} 5.0841e-06 {VDD} 5.0842e-06 0 5.1021e-06 0 5.1022e-06 {VDD} 5.1241e-06 {VDD} 5.1242e-06 0 5.1421e-06 0 5.1422e-06 {VDD} 5.1641e-06 {VDD} 5.1642e-06 0 5.1821e-06 0 5.1822e-06 {VDD} 5.2041e-06 {VDD} 5.2042e-06 0 1.00921e-05 0 1.00922e-05 {VDD} 1.01141e-05 {VDD} 1.01142e-05 0 1.01321e-05 0 1.01322e-05 {VDD} 1.01541e-05 {VDD} 1.01542e-05 0 1.01721e-05 0 1.01722e-05 {VDD} 1.01941e-05 {VDD} 1.01942e-05 0 1.02121e-05 0 1.02122e-05 {VDD} 1.02341e-05 {VDD} 1.02342e-05 0 1.51221e-05 0 1.51222e-05 {VDD} 1.51441e-05 {VDD} 1.51442e-05 0 1.51621e-05 0 1.51622e-05 {VDD} 1.51841e-05 {VDD} 1.51842e-05 0 1.52021e-05 0 1.52022e-05 {VDD} 1.52241e-05 {VDD} 1.52242e-05 0 1.52421e-05 0 1.52422e-05 {VDD} 1.52641e-05 {VDD} 1.52642e-05 0 2.01521e-05 0 2.01522e-05 {VDD} 2.01741e-05 {VDD} 2.01742e-05 0 2.01921e-05 0 2.01922e-05 {VDD} 2.02141e-05 {VDD} 2.02142e-05 0 2.02321e-05 0 2.02322e-05 {VDD} 2.02541e-05 {VDD} 2.02542e-05 0 2.02721e-05 0 2.02722e-05 {VDD} 2.02941e-05 {VDD} 2.02942e-05 0 2.51821e-05 0 2.51822e-05 {VDD} 2.52041e-05 {VDD} 2.52042e-05 0 2.52221e-05 0 2.52222e-05 {VDD} 2.52441e-05 {VDD} 2.52442e-05 0 2.52621e-05 0 2.52622e-05 {VDD} 2.52841e-05 {VDD} 2.52842e-05 0 2.53021e-05 0 2.53022e-05 {VDD} 2.53241e-05 {VDD} 2.53242e-05 0 3.02121e-05 0 3.02122e-05 {VDD} 3.02341e-05 {VDD} 3.02342e-05 0 3.02521e-05 0 3.02522e-05 {VDD} 3.02741e-05 {VDD} 3.02742e-05 0 3.02921e-05 0 3.02922e-05 {VDD} 3.03141e-05 {VDD} 3.03142e-05 0 3.03321e-05 0 3.03322e-05 {VDD} 3.03541e-05 {VDD} 3.03542e-05 0 3.52421e-05 0 3.52422e-05 {VDD} 3.52641e-05 {VDD} 3.52642e-05 0 3.52821e-05 0 3.52822e-05 {VDD} 3.53041e-05 {VDD} 3.53042e-05 0 3.53221e-05 0 3.53222e-05 {VDD} 3.53441e-05 {VDD} 3.53442e-05 0 3.53621e-05 0 3.53622e-05 {VDD} 3.53841e-05 {VDD} 3.53842e-05 0 4.02721e-05 0 4.02722e-05 {VDD} 4.02941e-05 {VDD} 4.02942e-05 0 4.03121e-05 0 4.03122e-05 {VDD} 4.03341e-05 {VDD} 4.03342e-05 0 4.03521e-05 0 4.03522e-05 {VDD} 4.03741e-05 {VDD} 4.03742e-05 0 4.03921e-05 0 4.03922e-05 {VDD} 4.04141e-05 {VDD} 4.04142e-05 0 4.53021e-05 0 4.53022e-05 {VDD} 4.53241e-05 {VDD} 4.53242e-05 0 4.53421e-05 0 4.53422e-05 {VDD} 4.53641e-05 {VDD} 4.53642e-05 0 4.53821e-05 0 4.53822e-05 {VDD} 4.54041e-05 {VDD} 4.54042e-05 0 4.54221e-05 0 4.54222e-05 {VDD} 4.54441e-05 {VDD} 4.54442e-05 0 5.03321e-05 0 5.03322e-05 {VDD} 5.03541e-05 {VDD} 5.03542e-05 0 5.03721e-05 0 5.03722e-05 {VDD} 5.03941e-05 {VDD} 5.03942e-05 0 5.04121e-05 0 5.04122e-05 {VDD} 5.04341e-05 {VDD} 5.04342e-05 0 5.04521e-05 0 5.04522e-05 {VDD} 5.04741e-05 {VDD} 5.04742e-05 0)
vbpk_nowb bpk_nowb 0 pwl(0 {VDD} 5.0621e-06 {VDD} 5.0622e-06 0 5.0841e-06 0 5.0842e-06 {VDD} 5.1021e-06 {VDD} 5.1022e-06 0 5.1241e-06 0 5.1242e-06 {VDD} 5.1421e-06 {VDD} 5.1422e-06 0 5.1641e-06 0 5.1642e-06 {VDD} 5.1821e-06 {VDD} 5.1822e-06 0 5.2041e-06 0 5.2042e-06 {VDD} 1.00921e-05 {VDD} 1.00922e-05 0 1.01141e-05 0 1.01142e-05 {VDD} 1.01321e-05 {VDD} 1.01322e-05 0 1.01541e-05 0 1.01542e-05 {VDD} 1.01721e-05 {VDD} 1.01722e-05 0 1.01941e-05 0 1.01942e-05 {VDD} 1.02121e-05 {VDD} 1.02122e-05 0 1.02341e-05 0 1.02342e-05 {VDD} 1.51221e-05 {VDD} 1.51222e-05 0 1.51441e-05 0 1.51442e-05 {VDD} 1.51621e-05 {VDD} 1.51622e-05 0 1.51841e-05 0 1.51842e-05 {VDD} 1.52021e-05 {VDD} 1.52022e-05 0 1.52241e-05 0 1.52242e-05 {VDD} 1.52421e-05 {VDD} 1.52422e-05 0 1.52641e-05 0 1.52642e-05 {VDD} 2.01521e-05 {VDD} 2.01522e-05 0 2.01741e-05 0 2.01742e-05 {VDD} 2.01921e-05 {VDD} 2.01922e-05 0 2.02141e-05 0 2.02142e-05 {VDD} 2.02321e-05 {VDD} 2.02322e-05 0 2.02541e-05 0 2.02542e-05 {VDD} 2.02721e-05 {VDD} 2.02722e-05 0 2.02941e-05 0 2.02942e-05 {VDD} 2.51821e-05 {VDD} 2.51822e-05 0 2.52041e-05 0 2.52042e-05 {VDD} 2.52221e-05 {VDD} 2.52222e-05 0 2.52441e-05 0 2.52442e-05 {VDD} 2.52621e-05 {VDD} 2.52622e-05 0 2.52841e-05 0 2.52842e-05 {VDD} 2.53021e-05 {VDD} 2.53022e-05 0 2.53241e-05 0 2.53242e-05 {VDD} 3.02121e-05 {VDD} 3.02122e-05 0 3.02341e-05 0 3.02342e-05 {VDD} 3.02521e-05 {VDD} 3.02522e-05 0 3.02741e-05 0 3.02742e-05 {VDD} 3.02921e-05 {VDD} 3.02922e-05 0 3.03141e-05 0 3.03142e-05 {VDD} 3.03321e-05 {VDD} 3.03322e-05 0 3.03541e-05 0 3.03542e-05 {VDD} 3.52421e-05 {VDD} 3.52422e-05 0 3.52641e-05 0 3.52642e-05 {VDD} 3.52821e-05 {VDD} 3.52822e-05 0 3.53041e-05 0 3.53042e-05 {VDD} 3.53221e-05 {VDD} 3.53222e-05 0 3.53441e-05 0 3.53442e-05 {VDD} 3.53621e-05 {VDD} 3.53622e-05 0 3.53841e-05 0 3.53842e-05 {VDD} 4.02721e-05 {VDD} 4.02722e-05 0 4.02941e-05 0 4.02942e-05 {VDD} 4.03121e-05 {VDD} 4.03122e-05 0 4.03341e-05 0 4.03342e-05 {VDD} 4.03521e-05 {VDD} 4.03522e-05 0 4.03741e-05 0 4.03742e-05 {VDD} 4.03921e-05 {VDD} 4.03922e-05 0 4.04141e-05 0 4.04142e-05 {VDD} 4.53021e-05 {VDD} 4.53022e-05 0 4.53241e-05 0 4.53242e-05 {VDD} 4.53421e-05 {VDD} 4.53422e-05 0 4.53641e-05 0 4.53642e-05 {VDD} 4.53821e-05 {VDD} 4.53822e-05 0 4.54041e-05 0 4.54042e-05 {VDD} 4.54221e-05 {VDD} 4.54222e-05 0 4.54441e-05 0 4.54442e-05 {VDD} 5.03321e-05 {VDD} 5.03322e-05 0 5.03541e-05 0 5.03542e-05 {VDD} 5.03721e-05 {VDD} 5.03722e-05 0 5.03941e-05 0 5.03942e-05 {VDD} 5.04121e-05 {VDD} 5.04122e-05 0 5.04341e-05 0 5.04342e-05 {VDD} 5.04521e-05 {VDD} 5.04522e-05 0 5.04741e-05 0 5.04742e-05 {VDD})   $ ideal initial-write/park driver connected except during write-back
vrws0_nowb rwls0_nowb 0 pwl(0 {VDD} 5.0511e-06 {VDD} 5.0512e-06 0 5.0841e-06 0 5.0842e-06 {VDD} 1.00811e-05 {VDD} 1.00812e-05 0 1.01141e-05 0 1.01142e-05 {VDD} 1.51111e-05 {VDD} 1.51112e-05 0 1.51441e-05 0 1.51442e-05 {VDD} 2.01411e-05 {VDD} 2.01412e-05 0 2.01741e-05 0 2.01742e-05 {VDD} 2.51711e-05 {VDD} 2.51712e-05 0 2.52041e-05 0 2.52042e-05 {VDD} 3.02011e-05 {VDD} 3.02012e-05 0 3.02341e-05 0 3.02342e-05 {VDD} 3.52311e-05 {VDD} 3.52312e-05 0 3.52641e-05 0 3.52642e-05 {VDD} 4.02611e-05 {VDD} 4.02612e-05 0 4.02941e-05 0 4.02942e-05 {VDD} 4.52911e-05 {VDD} 4.52912e-05 0 4.53241e-05 0 4.53242e-05 {VDD} 5.03211e-05 {VDD} 5.03212e-05 0 5.03541e-05 0 5.03542e-05 {VDD})
vwl0_nowb wl0_nowb 0 pwl(0 0 1e-09 0 1.1e-09 {VDD} 2.1e-08 {VDD} 2.11e-08 0)
vrws1_nowb rwls1_nowb 0 pwl(0 {VDD} 5.0911e-06 {VDD} 5.0912e-06 0 5.1241e-06 0 5.1242e-06 {VDD} 1.01211e-05 {VDD} 1.01212e-05 0 1.01541e-05 0 1.01542e-05 {VDD} 1.51511e-05 {VDD} 1.51512e-05 0 1.51841e-05 0 1.51842e-05 {VDD} 2.01811e-05 {VDD} 2.01812e-05 0 2.02141e-05 0 2.02142e-05 {VDD} 2.52111e-05 {VDD} 2.52112e-05 0 2.52441e-05 0 2.52442e-05 {VDD} 3.02411e-05 {VDD} 3.02412e-05 0 3.02741e-05 0 3.02742e-05 {VDD} 3.52711e-05 {VDD} 3.52712e-05 0 3.53041e-05 0 3.53042e-05 {VDD} 4.03011e-05 {VDD} 4.03012e-05 0 4.03341e-05 0 4.03342e-05 {VDD} 4.53311e-05 {VDD} 4.53312e-05 0 4.53641e-05 0 4.53642e-05 {VDD} 5.03611e-05 {VDD} 5.03612e-05 0 5.03941e-05 0 5.03942e-05 {VDD})
vwl1_nowb wl1_nowb 0 pwl(0 0 4.1e-08 0 4.11e-08 {VDD} 6.1e-08 {VDD} 6.11e-08 0)
vrws2_nowb rwls2_nowb 0 pwl(0 {VDD} 5.1311e-06 {VDD} 5.1312e-06 0 5.1641e-06 0 5.1642e-06 {VDD} 1.01611e-05 {VDD} 1.01612e-05 0 1.01941e-05 0 1.01942e-05 {VDD} 1.51911e-05 {VDD} 1.51912e-05 0 1.52241e-05 0 1.52242e-05 {VDD} 2.02211e-05 {VDD} 2.02212e-05 0 2.02541e-05 0 2.02542e-05 {VDD} 2.52511e-05 {VDD} 2.52512e-05 0 2.52841e-05 0 2.52842e-05 {VDD} 3.02811e-05 {VDD} 3.02812e-05 0 3.03141e-05 0 3.03142e-05 {VDD} 3.53111e-05 {VDD} 3.53112e-05 0 3.53441e-05 0 3.53442e-05 {VDD} 4.03411e-05 {VDD} 4.03412e-05 0 4.03741e-05 0 4.03742e-05 {VDD} 4.53711e-05 {VDD} 4.53712e-05 0 4.54041e-05 0 4.54042e-05 {VDD} 5.04011e-05 {VDD} 5.04012e-05 0 5.04341e-05 0 5.04342e-05 {VDD})
vwl2_nowb wl2_nowb 0 pwl(0 0 8.1e-08 0 8.11e-08 {VDD} 1.01e-07 {VDD} 1.011e-07 0)
vrws3_nowb rwls3_nowb 0 pwl(0 {VDD} 5.1711e-06 {VDD} 5.1712e-06 0 5.2041e-06 0 5.2042e-06 {VDD} 1.02011e-05 {VDD} 1.02012e-05 0 1.02341e-05 0 1.02342e-05 {VDD} 1.52311e-05 {VDD} 1.52312e-05 0 1.52641e-05 0 1.52642e-05 {VDD} 2.02611e-05 {VDD} 2.02612e-05 0 2.02941e-05 0 2.02942e-05 {VDD} 2.52911e-05 {VDD} 2.52912e-05 0 2.53241e-05 0 2.53242e-05 {VDD} 3.03211e-05 {VDD} 3.03212e-05 0 3.03541e-05 0 3.03542e-05 {VDD} 3.53511e-05 {VDD} 3.53512e-05 0 3.53841e-05 0 3.53842e-05 {VDD} 4.03811e-05 {VDD} 4.03812e-05 0 4.04141e-05 0 4.04142e-05 {VDD} 4.54111e-05 {VDD} 4.54112e-05 0 4.54441e-05 0 4.54442e-05 {VDD} 5.04411e-05 {VDD} 5.04412e-05 0 5.04741e-05 0 5.04742e-05 {VDD})
vwl3_nowb wl3_nowb 0 pwl(0 0 1.21e-07 0 1.211e-07 {VDD} 1.41e-07 {VDD} 1.411e-07 0)
vbld0000 bld0000 0 pwl(0 0)
vbld0010 bld0010 0 pwl(0 0 8.05e-08 0 8.06e-08 {VDD} 1.031e-07 {VDD} 1.032e-07 0)
vbld0101 bld0101 0 pwl(0 0 4.05e-08 0 4.06e-08 {VDD} 6.31e-08 {VDD} 6.32e-08 0 1.205e-07 0 1.206e-07 {VDD} 1.431e-07 {VDD} 1.432e-07 0)
vbld0111 bld0111 0 pwl(0 0 4.05e-08 0 4.06e-08 {VDD} 6.31e-08 {VDD} 6.32e-08 0 8.05e-08 0 8.06e-08 {VDD} 1.031e-07 {VDD} 1.032e-07 0 1.205e-07 0 1.206e-07 {VDD} 1.431e-07 {VDD} 1.432e-07 0)
vbld1000 bld1000 0 pwl(0 0 5e-10 0 6e-10 {VDD} 2.31e-08 {VDD} 2.32e-08 0)
vbld1010 bld1010 0 pwl(0 0 5e-10 0 6e-10 {VDD} 2.31e-08 {VDD} 2.32e-08 0 8.05e-08 0 8.06e-08 {VDD} 1.031e-07 {VDD} 1.032e-07 0)
vbld1101 bld1101 0 pwl(0 0 5e-10 0 6e-10 {VDD} 2.31e-08 {VDD} 2.32e-08 0 4.05e-08 0 4.06e-08 {VDD} 6.31e-08 {VDD} 6.32e-08 0 1.205e-07 0 1.206e-07 {VDD} 1.431e-07 {VDD} 1.432e-07 0)
vbld1111 bld1111 0 pwl(0 0 5e-10 0 6e-10 {VDD} 2.31e-08 {VDD} 2.32e-08 0 4.05e-08 0 4.06e-08 {VDD} 6.31e-08 {VDD} 6.32e-08 0 8.05e-08 0 8.06e-08 {VDD} 1.031e-07 {VDD} 1.032e-07 0 1.205e-07 0 1.206e-07 {VDD} 1.431e-07 {VDD} 1.432e-07 0)

* ---- instance 0: ana_1111 (main) ----
sbi_ana_1111 bld1111 wbl_ana_1111 bpk_ana 0 swwbl
swb_ana_1111 ref_ana_1111 wbl_ana_1111 wbc_ana 0 swwbl
cwbl_ana_1111 wbl_ana_1111 0 {C_WBL}
spa_ana_1111 prea rbl_ana_1111 ctl_ana 0 swpre
spr_ana_1111 pref ref_ana_1111 ctl_ana 0 swpre
crbl_ana_1111 rbl_ana_1111 0 {C_RBL}
cref_ana_1111 ref_ana_1111 0 {C_RBL}   $ ASSUMPTION: ideal matched dummy load
XMWR_ana_1111_0 sn_ana_1111_0 wl0_ana wbl_ana_1111 0 sky130_fd_pr__nfet_01v8 L=0.15 W=0.42 nf=1 ad=0.1974 as=0.1974 pd=1.78 ps=1.78 nrd=0.69047619047619  nrs=0.69047619047619 sa=0 sb=0 sd=0 mult=1 m=1
XMRD_ana_1111_0 rbl_ana_1111 sn_ana_1111_0 rwls0_ana 0 sky130_fd_pr__nfet_01v8 L=0.15 W=0.42 nf=1 ad=0.1974 as=0.1974 pd=1.78 ps=1.78 nrd=0.69047619047619  nrs=0.69047619047619 sa=0 sb=0 sd=0 mult=1 m=1
csn_ana_1111_0 sn_ana_1111_0 0 {C_SN}
XMWR_ana_1111_1 sn_ana_1111_1 wl1_ana wbl_ana_1111 0 sky130_fd_pr__nfet_01v8 L=0.15 W=0.42 nf=1 ad=0.1974 as=0.1974 pd=1.78 ps=1.78 nrd=0.69047619047619  nrs=0.69047619047619 sa=0 sb=0 sd=0 mult=1 m=1
XMRD_ana_1111_1 rbl_ana_1111 sn_ana_1111_1 rwls1_ana 0 sky130_fd_pr__nfet_01v8 L=0.15 W=0.42 nf=1 ad=0.1974 as=0.1974 pd=1.78 ps=1.78 nrd=0.69047619047619  nrs=0.69047619047619 sa=0 sb=0 sd=0 mult=1 m=1
csn_ana_1111_1 sn_ana_1111_1 0 {C_SN}
XMWR_ana_1111_2 sn_ana_1111_2 wl2_ana wbl_ana_1111 0 sky130_fd_pr__nfet_01v8 L=0.15 W=0.42 nf=1 ad=0.1974 as=0.1974 pd=1.78 ps=1.78 nrd=0.69047619047619  nrs=0.69047619047619 sa=0 sb=0 sd=0 mult=1 m=1
XMRD_ana_1111_2 rbl_ana_1111 sn_ana_1111_2 rwls2_ana 0 sky130_fd_pr__nfet_01v8 L=0.15 W=0.42 nf=1 ad=0.1974 as=0.1974 pd=1.78 ps=1.78 nrd=0.69047619047619  nrs=0.69047619047619 sa=0 sb=0 sd=0 mult=1 m=1
csn_ana_1111_2 sn_ana_1111_2 0 {C_SN}
XMWR_ana_1111_3 sn_ana_1111_3 wl3_ana wbl_ana_1111 0 sky130_fd_pr__nfet_01v8 L=0.15 W=0.42 nf=1 ad=0.1974 as=0.1974 pd=1.78 ps=1.78 nrd=0.69047619047619  nrs=0.69047619047619 sa=0 sb=0 sd=0 mult=1 m=1
XMRD_ana_1111_3 rbl_ana_1111 sn_ana_1111_3 rwls3_ana 0 sky130_fd_pr__nfet_01v8 L=0.15 W=0.42 nf=1 ad=0.1974 as=0.1974 pd=1.78 ps=1.78 nrd=0.69047619047619  nrs=0.69047619047619 sa=0 sb=0 sd=0 mult=1 m=1
csn_ana_1111_3 sn_ana_1111_3 0 {C_SN}
XMN1_ana_1111 rbl_ana_1111 ref_ana_1111 vn_ana_1111 0 sky130_fd_pr__nfet_01v8 L=0.15 W=1 nf=1 ad=0.29 as=0.29 pd=2.58 ps=2.58 nrd=0.29 nrs=0.29 sa=0 sb=0 sd=0 mult=1 m=1
XMN2_ana_1111 ref_ana_1111 rbl_ana_1111 vn_ana_1111 0 sky130_fd_pr__nfet_01v8 L=0.15 W=1 nf=1 ad=0.29 as=0.29 pd=2.58 ps=2.58 nrd=0.29 nrs=0.29 sa=0 sb=0 sd=0 mult=1 m=1
XMP1_ana_1111 rbl_ana_1111 ref_ana_1111 vp_ana_1111 vdd sky130_fd_pr__pfet_01v8 L=0.15 W=2 nf=1 ad=0.58 as=0.58 pd=4.58 ps=4.58 nrd=0.145 nrs=0.145 sa=0 sb=0 sd=0 mult=1 m=1
XMP2_ana_1111 ref_ana_1111 rbl_ana_1111 vp_ana_1111 vdd sky130_fd_pr__pfet_01v8 L=0.15 W=2 nf=1 ad=0.58 as=0.58 pd=4.58 ps=4.58 nrd=0.145 nrs=0.145 sa=0 sb=0 sd=0 mult=1 m=1
XMNF_ana_1111 vn_ana_1111 en_ana 0 0 sky130_fd_pr__nfet_01v8 L=0.15 W=2 nf=1 ad=0.58 as=0.58 pd=4.58 ps=4.58 nrd=0.145 nrs=0.145 sa=0 sb=0 sd=0 mult=1 m=1
XMPH_ana_1111 vp_ana_1111 enb_ana vdd vdd sky130_fd_pr__pfet_01v8 L=0.15 W=4 nf=1 ad=1.16 as=1.16 pd=8.58 ps=8.58 nrd=0.0725 nrs=0.0725 sa=0 sb=0 sd=0 mult=1 m=1
bd_ana_1111 d_ana_1111 0 v=v(rbl_ana_1111)-v(ref_ana_1111)

* ---- instance 1: ana_0000 (main) ----
sbi_ana_0000 bld0000 wbl_ana_0000 bpk_ana 0 swwbl
swb_ana_0000 ref_ana_0000 wbl_ana_0000 wbc_ana 0 swwbl
cwbl_ana_0000 wbl_ana_0000 0 {C_WBL}
spa_ana_0000 prea rbl_ana_0000 ctl_ana 0 swpre
spr_ana_0000 pref ref_ana_0000 ctl_ana 0 swpre
crbl_ana_0000 rbl_ana_0000 0 {C_RBL}
cref_ana_0000 ref_ana_0000 0 {C_RBL}   $ ASSUMPTION: ideal matched dummy load
XMWR_ana_0000_0 sn_ana_0000_0 wl0_ana wbl_ana_0000 0 sky130_fd_pr__nfet_01v8 L=0.15 W=0.42 nf=1 ad=0.1974 as=0.1974 pd=1.78 ps=1.78 nrd=0.69047619047619  nrs=0.69047619047619 sa=0 sb=0 sd=0 mult=1 m=1
XMRD_ana_0000_0 rbl_ana_0000 sn_ana_0000_0 rwls0_ana 0 sky130_fd_pr__nfet_01v8 L=0.15 W=0.42 nf=1 ad=0.1974 as=0.1974 pd=1.78 ps=1.78 nrd=0.69047619047619  nrs=0.69047619047619 sa=0 sb=0 sd=0 mult=1 m=1
csn_ana_0000_0 sn_ana_0000_0 0 {C_SN}
XMWR_ana_0000_1 sn_ana_0000_1 wl1_ana wbl_ana_0000 0 sky130_fd_pr__nfet_01v8 L=0.15 W=0.42 nf=1 ad=0.1974 as=0.1974 pd=1.78 ps=1.78 nrd=0.69047619047619  nrs=0.69047619047619 sa=0 sb=0 sd=0 mult=1 m=1
XMRD_ana_0000_1 rbl_ana_0000 sn_ana_0000_1 rwls1_ana 0 sky130_fd_pr__nfet_01v8 L=0.15 W=0.42 nf=1 ad=0.1974 as=0.1974 pd=1.78 ps=1.78 nrd=0.69047619047619  nrs=0.69047619047619 sa=0 sb=0 sd=0 mult=1 m=1
csn_ana_0000_1 sn_ana_0000_1 0 {C_SN}
XMWR_ana_0000_2 sn_ana_0000_2 wl2_ana wbl_ana_0000 0 sky130_fd_pr__nfet_01v8 L=0.15 W=0.42 nf=1 ad=0.1974 as=0.1974 pd=1.78 ps=1.78 nrd=0.69047619047619  nrs=0.69047619047619 sa=0 sb=0 sd=0 mult=1 m=1
XMRD_ana_0000_2 rbl_ana_0000 sn_ana_0000_2 rwls2_ana 0 sky130_fd_pr__nfet_01v8 L=0.15 W=0.42 nf=1 ad=0.1974 as=0.1974 pd=1.78 ps=1.78 nrd=0.69047619047619  nrs=0.69047619047619 sa=0 sb=0 sd=0 mult=1 m=1
csn_ana_0000_2 sn_ana_0000_2 0 {C_SN}
XMWR_ana_0000_3 sn_ana_0000_3 wl3_ana wbl_ana_0000 0 sky130_fd_pr__nfet_01v8 L=0.15 W=0.42 nf=1 ad=0.1974 as=0.1974 pd=1.78 ps=1.78 nrd=0.69047619047619  nrs=0.69047619047619 sa=0 sb=0 sd=0 mult=1 m=1
XMRD_ana_0000_3 rbl_ana_0000 sn_ana_0000_3 rwls3_ana 0 sky130_fd_pr__nfet_01v8 L=0.15 W=0.42 nf=1 ad=0.1974 as=0.1974 pd=1.78 ps=1.78 nrd=0.69047619047619  nrs=0.69047619047619 sa=0 sb=0 sd=0 mult=1 m=1
csn_ana_0000_3 sn_ana_0000_3 0 {C_SN}
XMN1_ana_0000 rbl_ana_0000 ref_ana_0000 vn_ana_0000 0 sky130_fd_pr__nfet_01v8 L=0.15 W=1 nf=1 ad=0.29 as=0.29 pd=2.58 ps=2.58 nrd=0.29 nrs=0.29 sa=0 sb=0 sd=0 mult=1 m=1
XMN2_ana_0000 ref_ana_0000 rbl_ana_0000 vn_ana_0000 0 sky130_fd_pr__nfet_01v8 L=0.15 W=1 nf=1 ad=0.29 as=0.29 pd=2.58 ps=2.58 nrd=0.29 nrs=0.29 sa=0 sb=0 sd=0 mult=1 m=1
XMP1_ana_0000 rbl_ana_0000 ref_ana_0000 vp_ana_0000 vdd sky130_fd_pr__pfet_01v8 L=0.15 W=2 nf=1 ad=0.58 as=0.58 pd=4.58 ps=4.58 nrd=0.145 nrs=0.145 sa=0 sb=0 sd=0 mult=1 m=1
XMP2_ana_0000 ref_ana_0000 rbl_ana_0000 vp_ana_0000 vdd sky130_fd_pr__pfet_01v8 L=0.15 W=2 nf=1 ad=0.58 as=0.58 pd=4.58 ps=4.58 nrd=0.145 nrs=0.145 sa=0 sb=0 sd=0 mult=1 m=1
XMNF_ana_0000 vn_ana_0000 en_ana 0 0 sky130_fd_pr__nfet_01v8 L=0.15 W=2 nf=1 ad=0.58 as=0.58 pd=4.58 ps=4.58 nrd=0.145 nrs=0.145 sa=0 sb=0 sd=0 mult=1 m=1
XMPH_ana_0000 vp_ana_0000 enb_ana vdd vdd sky130_fd_pr__pfet_01v8 L=0.15 W=4 nf=1 ad=1.16 as=1.16 pd=8.58 ps=8.58 nrd=0.0725 nrs=0.0725 sa=0 sb=0 sd=0 mult=1 m=1
bd_ana_0000 d_ana_0000 0 v=v(rbl_ana_0000)-v(ref_ana_0000)

* ---- instance 2: ana_1000 (main) ----
sbi_ana_1000 bld1000 wbl_ana_1000 bpk_ana 0 swwbl
swb_ana_1000 ref_ana_1000 wbl_ana_1000 wbc_ana 0 swwbl
cwbl_ana_1000 wbl_ana_1000 0 {C_WBL}
spa_ana_1000 prea rbl_ana_1000 ctl_ana 0 swpre
spr_ana_1000 pref ref_ana_1000 ctl_ana 0 swpre
crbl_ana_1000 rbl_ana_1000 0 {C_RBL}
cref_ana_1000 ref_ana_1000 0 {C_RBL}   $ ASSUMPTION: ideal matched dummy load
XMWR_ana_1000_0 sn_ana_1000_0 wl0_ana wbl_ana_1000 0 sky130_fd_pr__nfet_01v8 L=0.15 W=0.42 nf=1 ad=0.1974 as=0.1974 pd=1.78 ps=1.78 nrd=0.69047619047619  nrs=0.69047619047619 sa=0 sb=0 sd=0 mult=1 m=1
XMRD_ana_1000_0 rbl_ana_1000 sn_ana_1000_0 rwls0_ana 0 sky130_fd_pr__nfet_01v8 L=0.15 W=0.42 nf=1 ad=0.1974 as=0.1974 pd=1.78 ps=1.78 nrd=0.69047619047619  nrs=0.69047619047619 sa=0 sb=0 sd=0 mult=1 m=1
csn_ana_1000_0 sn_ana_1000_0 0 {C_SN}
XMWR_ana_1000_1 sn_ana_1000_1 wl1_ana wbl_ana_1000 0 sky130_fd_pr__nfet_01v8 L=0.15 W=0.42 nf=1 ad=0.1974 as=0.1974 pd=1.78 ps=1.78 nrd=0.69047619047619  nrs=0.69047619047619 sa=0 sb=0 sd=0 mult=1 m=1
XMRD_ana_1000_1 rbl_ana_1000 sn_ana_1000_1 rwls1_ana 0 sky130_fd_pr__nfet_01v8 L=0.15 W=0.42 nf=1 ad=0.1974 as=0.1974 pd=1.78 ps=1.78 nrd=0.69047619047619  nrs=0.69047619047619 sa=0 sb=0 sd=0 mult=1 m=1
csn_ana_1000_1 sn_ana_1000_1 0 {C_SN}
XMWR_ana_1000_2 sn_ana_1000_2 wl2_ana wbl_ana_1000 0 sky130_fd_pr__nfet_01v8 L=0.15 W=0.42 nf=1 ad=0.1974 as=0.1974 pd=1.78 ps=1.78 nrd=0.69047619047619  nrs=0.69047619047619 sa=0 sb=0 sd=0 mult=1 m=1
XMRD_ana_1000_2 rbl_ana_1000 sn_ana_1000_2 rwls2_ana 0 sky130_fd_pr__nfet_01v8 L=0.15 W=0.42 nf=1 ad=0.1974 as=0.1974 pd=1.78 ps=1.78 nrd=0.69047619047619  nrs=0.69047619047619 sa=0 sb=0 sd=0 mult=1 m=1
csn_ana_1000_2 sn_ana_1000_2 0 {C_SN}
XMWR_ana_1000_3 sn_ana_1000_3 wl3_ana wbl_ana_1000 0 sky130_fd_pr__nfet_01v8 L=0.15 W=0.42 nf=1 ad=0.1974 as=0.1974 pd=1.78 ps=1.78 nrd=0.69047619047619  nrs=0.69047619047619 sa=0 sb=0 sd=0 mult=1 m=1
XMRD_ana_1000_3 rbl_ana_1000 sn_ana_1000_3 rwls3_ana 0 sky130_fd_pr__nfet_01v8 L=0.15 W=0.42 nf=1 ad=0.1974 as=0.1974 pd=1.78 ps=1.78 nrd=0.69047619047619  nrs=0.69047619047619 sa=0 sb=0 sd=0 mult=1 m=1
csn_ana_1000_3 sn_ana_1000_3 0 {C_SN}
XMN1_ana_1000 rbl_ana_1000 ref_ana_1000 vn_ana_1000 0 sky130_fd_pr__nfet_01v8 L=0.15 W=1 nf=1 ad=0.29 as=0.29 pd=2.58 ps=2.58 nrd=0.29 nrs=0.29 sa=0 sb=0 sd=0 mult=1 m=1
XMN2_ana_1000 ref_ana_1000 rbl_ana_1000 vn_ana_1000 0 sky130_fd_pr__nfet_01v8 L=0.15 W=1 nf=1 ad=0.29 as=0.29 pd=2.58 ps=2.58 nrd=0.29 nrs=0.29 sa=0 sb=0 sd=0 mult=1 m=1
XMP1_ana_1000 rbl_ana_1000 ref_ana_1000 vp_ana_1000 vdd sky130_fd_pr__pfet_01v8 L=0.15 W=2 nf=1 ad=0.58 as=0.58 pd=4.58 ps=4.58 nrd=0.145 nrs=0.145 sa=0 sb=0 sd=0 mult=1 m=1
XMP2_ana_1000 ref_ana_1000 rbl_ana_1000 vp_ana_1000 vdd sky130_fd_pr__pfet_01v8 L=0.15 W=2 nf=1 ad=0.58 as=0.58 pd=4.58 ps=4.58 nrd=0.145 nrs=0.145 sa=0 sb=0 sd=0 mult=1 m=1
XMNF_ana_1000 vn_ana_1000 en_ana 0 0 sky130_fd_pr__nfet_01v8 L=0.15 W=2 nf=1 ad=0.58 as=0.58 pd=4.58 ps=4.58 nrd=0.145 nrs=0.145 sa=0 sb=0 sd=0 mult=1 m=1
XMPH_ana_1000 vp_ana_1000 enb_ana vdd vdd sky130_fd_pr__pfet_01v8 L=0.15 W=4 nf=1 ad=1.16 as=1.16 pd=8.58 ps=8.58 nrd=0.0725 nrs=0.0725 sa=0 sb=0 sd=0 mult=1 m=1
bd_ana_1000 d_ana_1000 0 v=v(rbl_ana_1000)-v(ref_ana_1000)

* ---- instance 3: ana_0111 (main) ----
sbi_ana_0111 bld0111 wbl_ana_0111 bpk_ana 0 swwbl
swb_ana_0111 ref_ana_0111 wbl_ana_0111 wbc_ana 0 swwbl
cwbl_ana_0111 wbl_ana_0111 0 {C_WBL}
spa_ana_0111 prea rbl_ana_0111 ctl_ana 0 swpre
spr_ana_0111 pref ref_ana_0111 ctl_ana 0 swpre
crbl_ana_0111 rbl_ana_0111 0 {C_RBL}
cref_ana_0111 ref_ana_0111 0 {C_RBL}   $ ASSUMPTION: ideal matched dummy load
XMWR_ana_0111_0 sn_ana_0111_0 wl0_ana wbl_ana_0111 0 sky130_fd_pr__nfet_01v8 L=0.15 W=0.42 nf=1 ad=0.1974 as=0.1974 pd=1.78 ps=1.78 nrd=0.69047619047619  nrs=0.69047619047619 sa=0 sb=0 sd=0 mult=1 m=1
XMRD_ana_0111_0 rbl_ana_0111 sn_ana_0111_0 rwls0_ana 0 sky130_fd_pr__nfet_01v8 L=0.15 W=0.42 nf=1 ad=0.1974 as=0.1974 pd=1.78 ps=1.78 nrd=0.69047619047619  nrs=0.69047619047619 sa=0 sb=0 sd=0 mult=1 m=1
csn_ana_0111_0 sn_ana_0111_0 0 {C_SN}
XMWR_ana_0111_1 sn_ana_0111_1 wl1_ana wbl_ana_0111 0 sky130_fd_pr__nfet_01v8 L=0.15 W=0.42 nf=1 ad=0.1974 as=0.1974 pd=1.78 ps=1.78 nrd=0.69047619047619  nrs=0.69047619047619 sa=0 sb=0 sd=0 mult=1 m=1
XMRD_ana_0111_1 rbl_ana_0111 sn_ana_0111_1 rwls1_ana 0 sky130_fd_pr__nfet_01v8 L=0.15 W=0.42 nf=1 ad=0.1974 as=0.1974 pd=1.78 ps=1.78 nrd=0.69047619047619  nrs=0.69047619047619 sa=0 sb=0 sd=0 mult=1 m=1
csn_ana_0111_1 sn_ana_0111_1 0 {C_SN}
XMWR_ana_0111_2 sn_ana_0111_2 wl2_ana wbl_ana_0111 0 sky130_fd_pr__nfet_01v8 L=0.15 W=0.42 nf=1 ad=0.1974 as=0.1974 pd=1.78 ps=1.78 nrd=0.69047619047619  nrs=0.69047619047619 sa=0 sb=0 sd=0 mult=1 m=1
XMRD_ana_0111_2 rbl_ana_0111 sn_ana_0111_2 rwls2_ana 0 sky130_fd_pr__nfet_01v8 L=0.15 W=0.42 nf=1 ad=0.1974 as=0.1974 pd=1.78 ps=1.78 nrd=0.69047619047619  nrs=0.69047619047619 sa=0 sb=0 sd=0 mult=1 m=1
csn_ana_0111_2 sn_ana_0111_2 0 {C_SN}
XMWR_ana_0111_3 sn_ana_0111_3 wl3_ana wbl_ana_0111 0 sky130_fd_pr__nfet_01v8 L=0.15 W=0.42 nf=1 ad=0.1974 as=0.1974 pd=1.78 ps=1.78 nrd=0.69047619047619  nrs=0.69047619047619 sa=0 sb=0 sd=0 mult=1 m=1
XMRD_ana_0111_3 rbl_ana_0111 sn_ana_0111_3 rwls3_ana 0 sky130_fd_pr__nfet_01v8 L=0.15 W=0.42 nf=1 ad=0.1974 as=0.1974 pd=1.78 ps=1.78 nrd=0.69047619047619  nrs=0.69047619047619 sa=0 sb=0 sd=0 mult=1 m=1
csn_ana_0111_3 sn_ana_0111_3 0 {C_SN}
XMN1_ana_0111 rbl_ana_0111 ref_ana_0111 vn_ana_0111 0 sky130_fd_pr__nfet_01v8 L=0.15 W=1 nf=1 ad=0.29 as=0.29 pd=2.58 ps=2.58 nrd=0.29 nrs=0.29 sa=0 sb=0 sd=0 mult=1 m=1
XMN2_ana_0111 ref_ana_0111 rbl_ana_0111 vn_ana_0111 0 sky130_fd_pr__nfet_01v8 L=0.15 W=1 nf=1 ad=0.29 as=0.29 pd=2.58 ps=2.58 nrd=0.29 nrs=0.29 sa=0 sb=0 sd=0 mult=1 m=1
XMP1_ana_0111 rbl_ana_0111 ref_ana_0111 vp_ana_0111 vdd sky130_fd_pr__pfet_01v8 L=0.15 W=2 nf=1 ad=0.58 as=0.58 pd=4.58 ps=4.58 nrd=0.145 nrs=0.145 sa=0 sb=0 sd=0 mult=1 m=1
XMP2_ana_0111 ref_ana_0111 rbl_ana_0111 vp_ana_0111 vdd sky130_fd_pr__pfet_01v8 L=0.15 W=2 nf=1 ad=0.58 as=0.58 pd=4.58 ps=4.58 nrd=0.145 nrs=0.145 sa=0 sb=0 sd=0 mult=1 m=1
XMNF_ana_0111 vn_ana_0111 en_ana 0 0 sky130_fd_pr__nfet_01v8 L=0.15 W=2 nf=1 ad=0.58 as=0.58 pd=4.58 ps=4.58 nrd=0.145 nrs=0.145 sa=0 sb=0 sd=0 mult=1 m=1
XMPH_ana_0111 vp_ana_0111 enb_ana vdd vdd sky130_fd_pr__pfet_01v8 L=0.15 W=4 nf=1 ad=1.16 as=1.16 pd=8.58 ps=8.58 nrd=0.0725 nrs=0.0725 sa=0 sb=0 sd=0 mult=1 m=1
bd_ana_0111 d_ana_0111 0 v=v(rbl_ana_0111)-v(ref_ana_0111)

* ---- instance 4: ana_1010 (main) ----
sbi_ana_1010 bld1010 wbl_ana_1010 bpk_ana 0 swwbl
swb_ana_1010 ref_ana_1010 wbl_ana_1010 wbc_ana 0 swwbl
cwbl_ana_1010 wbl_ana_1010 0 {C_WBL}
spa_ana_1010 prea rbl_ana_1010 ctl_ana 0 swpre
spr_ana_1010 pref ref_ana_1010 ctl_ana 0 swpre
crbl_ana_1010 rbl_ana_1010 0 {C_RBL}
cref_ana_1010 ref_ana_1010 0 {C_RBL}   $ ASSUMPTION: ideal matched dummy load
XMWR_ana_1010_0 sn_ana_1010_0 wl0_ana wbl_ana_1010 0 sky130_fd_pr__nfet_01v8 L=0.15 W=0.42 nf=1 ad=0.1974 as=0.1974 pd=1.78 ps=1.78 nrd=0.69047619047619  nrs=0.69047619047619 sa=0 sb=0 sd=0 mult=1 m=1
XMRD_ana_1010_0 rbl_ana_1010 sn_ana_1010_0 rwls0_ana 0 sky130_fd_pr__nfet_01v8 L=0.15 W=0.42 nf=1 ad=0.1974 as=0.1974 pd=1.78 ps=1.78 nrd=0.69047619047619  nrs=0.69047619047619 sa=0 sb=0 sd=0 mult=1 m=1
csn_ana_1010_0 sn_ana_1010_0 0 {C_SN}
XMWR_ana_1010_1 sn_ana_1010_1 wl1_ana wbl_ana_1010 0 sky130_fd_pr__nfet_01v8 L=0.15 W=0.42 nf=1 ad=0.1974 as=0.1974 pd=1.78 ps=1.78 nrd=0.69047619047619  nrs=0.69047619047619 sa=0 sb=0 sd=0 mult=1 m=1
XMRD_ana_1010_1 rbl_ana_1010 sn_ana_1010_1 rwls1_ana 0 sky130_fd_pr__nfet_01v8 L=0.15 W=0.42 nf=1 ad=0.1974 as=0.1974 pd=1.78 ps=1.78 nrd=0.69047619047619  nrs=0.69047619047619 sa=0 sb=0 sd=0 mult=1 m=1
csn_ana_1010_1 sn_ana_1010_1 0 {C_SN}
XMWR_ana_1010_2 sn_ana_1010_2 wl2_ana wbl_ana_1010 0 sky130_fd_pr__nfet_01v8 L=0.15 W=0.42 nf=1 ad=0.1974 as=0.1974 pd=1.78 ps=1.78 nrd=0.69047619047619  nrs=0.69047619047619 sa=0 sb=0 sd=0 mult=1 m=1
XMRD_ana_1010_2 rbl_ana_1010 sn_ana_1010_2 rwls2_ana 0 sky130_fd_pr__nfet_01v8 L=0.15 W=0.42 nf=1 ad=0.1974 as=0.1974 pd=1.78 ps=1.78 nrd=0.69047619047619  nrs=0.69047619047619 sa=0 sb=0 sd=0 mult=1 m=1
csn_ana_1010_2 sn_ana_1010_2 0 {C_SN}
XMWR_ana_1010_3 sn_ana_1010_3 wl3_ana wbl_ana_1010 0 sky130_fd_pr__nfet_01v8 L=0.15 W=0.42 nf=1 ad=0.1974 as=0.1974 pd=1.78 ps=1.78 nrd=0.69047619047619  nrs=0.69047619047619 sa=0 sb=0 sd=0 mult=1 m=1
XMRD_ana_1010_3 rbl_ana_1010 sn_ana_1010_3 rwls3_ana 0 sky130_fd_pr__nfet_01v8 L=0.15 W=0.42 nf=1 ad=0.1974 as=0.1974 pd=1.78 ps=1.78 nrd=0.69047619047619  nrs=0.69047619047619 sa=0 sb=0 sd=0 mult=1 m=1
csn_ana_1010_3 sn_ana_1010_3 0 {C_SN}
XMN1_ana_1010 rbl_ana_1010 ref_ana_1010 vn_ana_1010 0 sky130_fd_pr__nfet_01v8 L=0.15 W=1 nf=1 ad=0.29 as=0.29 pd=2.58 ps=2.58 nrd=0.29 nrs=0.29 sa=0 sb=0 sd=0 mult=1 m=1
XMN2_ana_1010 ref_ana_1010 rbl_ana_1010 vn_ana_1010 0 sky130_fd_pr__nfet_01v8 L=0.15 W=1 nf=1 ad=0.29 as=0.29 pd=2.58 ps=2.58 nrd=0.29 nrs=0.29 sa=0 sb=0 sd=0 mult=1 m=1
XMP1_ana_1010 rbl_ana_1010 ref_ana_1010 vp_ana_1010 vdd sky130_fd_pr__pfet_01v8 L=0.15 W=2 nf=1 ad=0.58 as=0.58 pd=4.58 ps=4.58 nrd=0.145 nrs=0.145 sa=0 sb=0 sd=0 mult=1 m=1
XMP2_ana_1010 ref_ana_1010 rbl_ana_1010 vp_ana_1010 vdd sky130_fd_pr__pfet_01v8 L=0.15 W=2 nf=1 ad=0.58 as=0.58 pd=4.58 ps=4.58 nrd=0.145 nrs=0.145 sa=0 sb=0 sd=0 mult=1 m=1
XMNF_ana_1010 vn_ana_1010 en_ana 0 0 sky130_fd_pr__nfet_01v8 L=0.15 W=2 nf=1 ad=0.58 as=0.58 pd=4.58 ps=4.58 nrd=0.145 nrs=0.145 sa=0 sb=0 sd=0 mult=1 m=1
XMPH_ana_1010 vp_ana_1010 enb_ana vdd vdd sky130_fd_pr__pfet_01v8 L=0.15 W=4 nf=1 ad=1.16 as=1.16 pd=8.58 ps=8.58 nrd=0.0725 nrs=0.0725 sa=0 sb=0 sd=0 mult=1 m=1
bd_ana_1010 d_ana_1010 0 v=v(rbl_ana_1010)-v(ref_ana_1010)

* ---- instance 5: ana_0101 (main) ----
sbi_ana_0101 bld0101 wbl_ana_0101 bpk_ana 0 swwbl
swb_ana_0101 ref_ana_0101 wbl_ana_0101 wbc_ana 0 swwbl
cwbl_ana_0101 wbl_ana_0101 0 {C_WBL}
spa_ana_0101 prea rbl_ana_0101 ctl_ana 0 swpre
spr_ana_0101 pref ref_ana_0101 ctl_ana 0 swpre
crbl_ana_0101 rbl_ana_0101 0 {C_RBL}
cref_ana_0101 ref_ana_0101 0 {C_RBL}   $ ASSUMPTION: ideal matched dummy load
XMWR_ana_0101_0 sn_ana_0101_0 wl0_ana wbl_ana_0101 0 sky130_fd_pr__nfet_01v8 L=0.15 W=0.42 nf=1 ad=0.1974 as=0.1974 pd=1.78 ps=1.78 nrd=0.69047619047619  nrs=0.69047619047619 sa=0 sb=0 sd=0 mult=1 m=1
XMRD_ana_0101_0 rbl_ana_0101 sn_ana_0101_0 rwls0_ana 0 sky130_fd_pr__nfet_01v8 L=0.15 W=0.42 nf=1 ad=0.1974 as=0.1974 pd=1.78 ps=1.78 nrd=0.69047619047619  nrs=0.69047619047619 sa=0 sb=0 sd=0 mult=1 m=1
csn_ana_0101_0 sn_ana_0101_0 0 {C_SN}
XMWR_ana_0101_1 sn_ana_0101_1 wl1_ana wbl_ana_0101 0 sky130_fd_pr__nfet_01v8 L=0.15 W=0.42 nf=1 ad=0.1974 as=0.1974 pd=1.78 ps=1.78 nrd=0.69047619047619  nrs=0.69047619047619 sa=0 sb=0 sd=0 mult=1 m=1
XMRD_ana_0101_1 rbl_ana_0101 sn_ana_0101_1 rwls1_ana 0 sky130_fd_pr__nfet_01v8 L=0.15 W=0.42 nf=1 ad=0.1974 as=0.1974 pd=1.78 ps=1.78 nrd=0.69047619047619  nrs=0.69047619047619 sa=0 sb=0 sd=0 mult=1 m=1
csn_ana_0101_1 sn_ana_0101_1 0 {C_SN}
XMWR_ana_0101_2 sn_ana_0101_2 wl2_ana wbl_ana_0101 0 sky130_fd_pr__nfet_01v8 L=0.15 W=0.42 nf=1 ad=0.1974 as=0.1974 pd=1.78 ps=1.78 nrd=0.69047619047619  nrs=0.69047619047619 sa=0 sb=0 sd=0 mult=1 m=1
XMRD_ana_0101_2 rbl_ana_0101 sn_ana_0101_2 rwls2_ana 0 sky130_fd_pr__nfet_01v8 L=0.15 W=0.42 nf=1 ad=0.1974 as=0.1974 pd=1.78 ps=1.78 nrd=0.69047619047619  nrs=0.69047619047619 sa=0 sb=0 sd=0 mult=1 m=1
csn_ana_0101_2 sn_ana_0101_2 0 {C_SN}
XMWR_ana_0101_3 sn_ana_0101_3 wl3_ana wbl_ana_0101 0 sky130_fd_pr__nfet_01v8 L=0.15 W=0.42 nf=1 ad=0.1974 as=0.1974 pd=1.78 ps=1.78 nrd=0.69047619047619  nrs=0.69047619047619 sa=0 sb=0 sd=0 mult=1 m=1
XMRD_ana_0101_3 rbl_ana_0101 sn_ana_0101_3 rwls3_ana 0 sky130_fd_pr__nfet_01v8 L=0.15 W=0.42 nf=1 ad=0.1974 as=0.1974 pd=1.78 ps=1.78 nrd=0.69047619047619  nrs=0.69047619047619 sa=0 sb=0 sd=0 mult=1 m=1
csn_ana_0101_3 sn_ana_0101_3 0 {C_SN}
XMN1_ana_0101 rbl_ana_0101 ref_ana_0101 vn_ana_0101 0 sky130_fd_pr__nfet_01v8 L=0.15 W=1 nf=1 ad=0.29 as=0.29 pd=2.58 ps=2.58 nrd=0.29 nrs=0.29 sa=0 sb=0 sd=0 mult=1 m=1
XMN2_ana_0101 ref_ana_0101 rbl_ana_0101 vn_ana_0101 0 sky130_fd_pr__nfet_01v8 L=0.15 W=1 nf=1 ad=0.29 as=0.29 pd=2.58 ps=2.58 nrd=0.29 nrs=0.29 sa=0 sb=0 sd=0 mult=1 m=1
XMP1_ana_0101 rbl_ana_0101 ref_ana_0101 vp_ana_0101 vdd sky130_fd_pr__pfet_01v8 L=0.15 W=2 nf=1 ad=0.58 as=0.58 pd=4.58 ps=4.58 nrd=0.145 nrs=0.145 sa=0 sb=0 sd=0 mult=1 m=1
XMP2_ana_0101 ref_ana_0101 rbl_ana_0101 vp_ana_0101 vdd sky130_fd_pr__pfet_01v8 L=0.15 W=2 nf=1 ad=0.58 as=0.58 pd=4.58 ps=4.58 nrd=0.145 nrs=0.145 sa=0 sb=0 sd=0 mult=1 m=1
XMNF_ana_0101 vn_ana_0101 en_ana 0 0 sky130_fd_pr__nfet_01v8 L=0.15 W=2 nf=1 ad=0.58 as=0.58 pd=4.58 ps=4.58 nrd=0.145 nrs=0.145 sa=0 sb=0 sd=0 mult=1 m=1
XMPH_ana_0101 vp_ana_0101 enb_ana vdd vdd sky130_fd_pr__pfet_01v8 L=0.15 W=4 nf=1 ad=1.16 as=1.16 pd=8.58 ps=8.58 nrd=0.0725 nrs=0.0725 sa=0 sb=0 sd=0 mult=1 m=1
bd_ana_0101 d_ana_0101 0 v=v(rbl_ana_0101)-v(ref_ana_0101)

* ---- instance 6: ana_1101 (main) ----
sbi_ana_1101 bld1101 wbl_ana_1101 bpk_ana 0 swwbl
swb_ana_1101 ref_ana_1101 wbl_ana_1101 wbc_ana 0 swwbl
cwbl_ana_1101 wbl_ana_1101 0 {C_WBL}
spa_ana_1101 prea rbl_ana_1101 ctl_ana 0 swpre
spr_ana_1101 pref ref_ana_1101 ctl_ana 0 swpre
crbl_ana_1101 rbl_ana_1101 0 {C_RBL}
cref_ana_1101 ref_ana_1101 0 {C_RBL}   $ ASSUMPTION: ideal matched dummy load
XMWR_ana_1101_0 sn_ana_1101_0 wl0_ana wbl_ana_1101 0 sky130_fd_pr__nfet_01v8 L=0.15 W=0.42 nf=1 ad=0.1974 as=0.1974 pd=1.78 ps=1.78 nrd=0.69047619047619  nrs=0.69047619047619 sa=0 sb=0 sd=0 mult=1 m=1
XMRD_ana_1101_0 rbl_ana_1101 sn_ana_1101_0 rwls0_ana 0 sky130_fd_pr__nfet_01v8 L=0.15 W=0.42 nf=1 ad=0.1974 as=0.1974 pd=1.78 ps=1.78 nrd=0.69047619047619  nrs=0.69047619047619 sa=0 sb=0 sd=0 mult=1 m=1
csn_ana_1101_0 sn_ana_1101_0 0 {C_SN}
XMWR_ana_1101_1 sn_ana_1101_1 wl1_ana wbl_ana_1101 0 sky130_fd_pr__nfet_01v8 L=0.15 W=0.42 nf=1 ad=0.1974 as=0.1974 pd=1.78 ps=1.78 nrd=0.69047619047619  nrs=0.69047619047619 sa=0 sb=0 sd=0 mult=1 m=1
XMRD_ana_1101_1 rbl_ana_1101 sn_ana_1101_1 rwls1_ana 0 sky130_fd_pr__nfet_01v8 L=0.15 W=0.42 nf=1 ad=0.1974 as=0.1974 pd=1.78 ps=1.78 nrd=0.69047619047619  nrs=0.69047619047619 sa=0 sb=0 sd=0 mult=1 m=1
csn_ana_1101_1 sn_ana_1101_1 0 {C_SN}
XMWR_ana_1101_2 sn_ana_1101_2 wl2_ana wbl_ana_1101 0 sky130_fd_pr__nfet_01v8 L=0.15 W=0.42 nf=1 ad=0.1974 as=0.1974 pd=1.78 ps=1.78 nrd=0.69047619047619  nrs=0.69047619047619 sa=0 sb=0 sd=0 mult=1 m=1
XMRD_ana_1101_2 rbl_ana_1101 sn_ana_1101_2 rwls2_ana 0 sky130_fd_pr__nfet_01v8 L=0.15 W=0.42 nf=1 ad=0.1974 as=0.1974 pd=1.78 ps=1.78 nrd=0.69047619047619  nrs=0.69047619047619 sa=0 sb=0 sd=0 mult=1 m=1
csn_ana_1101_2 sn_ana_1101_2 0 {C_SN}
XMWR_ana_1101_3 sn_ana_1101_3 wl3_ana wbl_ana_1101 0 sky130_fd_pr__nfet_01v8 L=0.15 W=0.42 nf=1 ad=0.1974 as=0.1974 pd=1.78 ps=1.78 nrd=0.69047619047619  nrs=0.69047619047619 sa=0 sb=0 sd=0 mult=1 m=1
XMRD_ana_1101_3 rbl_ana_1101 sn_ana_1101_3 rwls3_ana 0 sky130_fd_pr__nfet_01v8 L=0.15 W=0.42 nf=1 ad=0.1974 as=0.1974 pd=1.78 ps=1.78 nrd=0.69047619047619  nrs=0.69047619047619 sa=0 sb=0 sd=0 mult=1 m=1
csn_ana_1101_3 sn_ana_1101_3 0 {C_SN}
XMN1_ana_1101 rbl_ana_1101 ref_ana_1101 vn_ana_1101 0 sky130_fd_pr__nfet_01v8 L=0.15 W=1 nf=1 ad=0.29 as=0.29 pd=2.58 ps=2.58 nrd=0.29 nrs=0.29 sa=0 sb=0 sd=0 mult=1 m=1
XMN2_ana_1101 ref_ana_1101 rbl_ana_1101 vn_ana_1101 0 sky130_fd_pr__nfet_01v8 L=0.15 W=1 nf=1 ad=0.29 as=0.29 pd=2.58 ps=2.58 nrd=0.29 nrs=0.29 sa=0 sb=0 sd=0 mult=1 m=1
XMP1_ana_1101 rbl_ana_1101 ref_ana_1101 vp_ana_1101 vdd sky130_fd_pr__pfet_01v8 L=0.15 W=2 nf=1 ad=0.58 as=0.58 pd=4.58 ps=4.58 nrd=0.145 nrs=0.145 sa=0 sb=0 sd=0 mult=1 m=1
XMP2_ana_1101 ref_ana_1101 rbl_ana_1101 vp_ana_1101 vdd sky130_fd_pr__pfet_01v8 L=0.15 W=2 nf=1 ad=0.58 as=0.58 pd=4.58 ps=4.58 nrd=0.145 nrs=0.145 sa=0 sb=0 sd=0 mult=1 m=1
XMNF_ana_1101 vn_ana_1101 en_ana 0 0 sky130_fd_pr__nfet_01v8 L=0.15 W=2 nf=1 ad=0.58 as=0.58 pd=4.58 ps=4.58 nrd=0.145 nrs=0.145 sa=0 sb=0 sd=0 mult=1 m=1
XMPH_ana_1101 vp_ana_1101 enb_ana vdd vdd sky130_fd_pr__pfet_01v8 L=0.15 W=4 nf=1 ad=1.16 as=1.16 pd=8.58 ps=8.58 nrd=0.0725 nrs=0.0725 sa=0 sb=0 sd=0 mult=1 m=1
bd_ana_1101 d_ana_1101 0 v=v(rbl_ana_1101)-v(ref_ana_1101)

* ---- instance 7: ana_0010 (main) ----
sbi_ana_0010 bld0010 wbl_ana_0010 bpk_ana 0 swwbl
swb_ana_0010 ref_ana_0010 wbl_ana_0010 wbc_ana 0 swwbl
cwbl_ana_0010 wbl_ana_0010 0 {C_WBL}
spa_ana_0010 prea rbl_ana_0010 ctl_ana 0 swpre
spr_ana_0010 pref ref_ana_0010 ctl_ana 0 swpre
crbl_ana_0010 rbl_ana_0010 0 {C_RBL}
cref_ana_0010 ref_ana_0010 0 {C_RBL}   $ ASSUMPTION: ideal matched dummy load
XMWR_ana_0010_0 sn_ana_0010_0 wl0_ana wbl_ana_0010 0 sky130_fd_pr__nfet_01v8 L=0.15 W=0.42 nf=1 ad=0.1974 as=0.1974 pd=1.78 ps=1.78 nrd=0.69047619047619  nrs=0.69047619047619 sa=0 sb=0 sd=0 mult=1 m=1
XMRD_ana_0010_0 rbl_ana_0010 sn_ana_0010_0 rwls0_ana 0 sky130_fd_pr__nfet_01v8 L=0.15 W=0.42 nf=1 ad=0.1974 as=0.1974 pd=1.78 ps=1.78 nrd=0.69047619047619  nrs=0.69047619047619 sa=0 sb=0 sd=0 mult=1 m=1
csn_ana_0010_0 sn_ana_0010_0 0 {C_SN}
XMWR_ana_0010_1 sn_ana_0010_1 wl1_ana wbl_ana_0010 0 sky130_fd_pr__nfet_01v8 L=0.15 W=0.42 nf=1 ad=0.1974 as=0.1974 pd=1.78 ps=1.78 nrd=0.69047619047619  nrs=0.69047619047619 sa=0 sb=0 sd=0 mult=1 m=1
XMRD_ana_0010_1 rbl_ana_0010 sn_ana_0010_1 rwls1_ana 0 sky130_fd_pr__nfet_01v8 L=0.15 W=0.42 nf=1 ad=0.1974 as=0.1974 pd=1.78 ps=1.78 nrd=0.69047619047619  nrs=0.69047619047619 sa=0 sb=0 sd=0 mult=1 m=1
csn_ana_0010_1 sn_ana_0010_1 0 {C_SN}
XMWR_ana_0010_2 sn_ana_0010_2 wl2_ana wbl_ana_0010 0 sky130_fd_pr__nfet_01v8 L=0.15 W=0.42 nf=1 ad=0.1974 as=0.1974 pd=1.78 ps=1.78 nrd=0.69047619047619  nrs=0.69047619047619 sa=0 sb=0 sd=0 mult=1 m=1
XMRD_ana_0010_2 rbl_ana_0010 sn_ana_0010_2 rwls2_ana 0 sky130_fd_pr__nfet_01v8 L=0.15 W=0.42 nf=1 ad=0.1974 as=0.1974 pd=1.78 ps=1.78 nrd=0.69047619047619  nrs=0.69047619047619 sa=0 sb=0 sd=0 mult=1 m=1
csn_ana_0010_2 sn_ana_0010_2 0 {C_SN}
XMWR_ana_0010_3 sn_ana_0010_3 wl3_ana wbl_ana_0010 0 sky130_fd_pr__nfet_01v8 L=0.15 W=0.42 nf=1 ad=0.1974 as=0.1974 pd=1.78 ps=1.78 nrd=0.69047619047619  nrs=0.69047619047619 sa=0 sb=0 sd=0 mult=1 m=1
XMRD_ana_0010_3 rbl_ana_0010 sn_ana_0010_3 rwls3_ana 0 sky130_fd_pr__nfet_01v8 L=0.15 W=0.42 nf=1 ad=0.1974 as=0.1974 pd=1.78 ps=1.78 nrd=0.69047619047619  nrs=0.69047619047619 sa=0 sb=0 sd=0 mult=1 m=1
csn_ana_0010_3 sn_ana_0010_3 0 {C_SN}
XMN1_ana_0010 rbl_ana_0010 ref_ana_0010 vn_ana_0010 0 sky130_fd_pr__nfet_01v8 L=0.15 W=1 nf=1 ad=0.29 as=0.29 pd=2.58 ps=2.58 nrd=0.29 nrs=0.29 sa=0 sb=0 sd=0 mult=1 m=1
XMN2_ana_0010 ref_ana_0010 rbl_ana_0010 vn_ana_0010 0 sky130_fd_pr__nfet_01v8 L=0.15 W=1 nf=1 ad=0.29 as=0.29 pd=2.58 ps=2.58 nrd=0.29 nrs=0.29 sa=0 sb=0 sd=0 mult=1 m=1
XMP1_ana_0010 rbl_ana_0010 ref_ana_0010 vp_ana_0010 vdd sky130_fd_pr__pfet_01v8 L=0.15 W=2 nf=1 ad=0.58 as=0.58 pd=4.58 ps=4.58 nrd=0.145 nrs=0.145 sa=0 sb=0 sd=0 mult=1 m=1
XMP2_ana_0010 ref_ana_0010 rbl_ana_0010 vp_ana_0010 vdd sky130_fd_pr__pfet_01v8 L=0.15 W=2 nf=1 ad=0.58 as=0.58 pd=4.58 ps=4.58 nrd=0.145 nrs=0.145 sa=0 sb=0 sd=0 mult=1 m=1
XMNF_ana_0010 vn_ana_0010 en_ana 0 0 sky130_fd_pr__nfet_01v8 L=0.15 W=2 nf=1 ad=0.58 as=0.58 pd=4.58 ps=4.58 nrd=0.145 nrs=0.145 sa=0 sb=0 sd=0 mult=1 m=1
XMPH_ana_0010 vp_ana_0010 enb_ana vdd vdd sky130_fd_pr__pfet_01v8 L=0.15 W=4 nf=1 ad=1.16 as=1.16 pd=8.58 ps=8.58 nrd=0.0725 nrs=0.0725 sa=0 sb=0 sd=0 mult=1 m=1
bd_ana_0010 d_ana_0010 0 v=v(rbl_ana_0010)-v(ref_ana_0010)

* ---- instance 8: rtl_1111 (control_rtl_unchanged) ----
sbi_rtl_1111 bld1111 wbl_rtl_1111 bpk_rtl 0 swwbl
swb_rtl_1111 ref_rtl_1111 wbl_rtl_1111 wbc_rtl 0 swwbl
cwbl_rtl_1111 wbl_rtl_1111 0 {C_WBL}
spa_rtl_1111 prea rbl_rtl_1111 ctl_rtl 0 swpre
spr_rtl_1111 pref ref_rtl_1111 ctl_rtl 0 swpre
crbl_rtl_1111 rbl_rtl_1111 0 {C_RBL}
cref_rtl_1111 ref_rtl_1111 0 {C_RBL}   $ ASSUMPTION: ideal matched dummy load
XMWR_rtl_1111_0 sn_rtl_1111_0 wl0_rtl wbl_rtl_1111 0 sky130_fd_pr__nfet_01v8 L=0.15 W=0.42 nf=1 ad=0.1974 as=0.1974 pd=1.78 ps=1.78 nrd=0.69047619047619  nrs=0.69047619047619 sa=0 sb=0 sd=0 mult=1 m=1
XMRD_rtl_1111_0 rbl_rtl_1111 sn_rtl_1111_0 rwls0_rtl 0 sky130_fd_pr__nfet_01v8 L=0.15 W=0.42 nf=1 ad=0.1974 as=0.1974 pd=1.78 ps=1.78 nrd=0.69047619047619  nrs=0.69047619047619 sa=0 sb=0 sd=0 mult=1 m=1
csn_rtl_1111_0 sn_rtl_1111_0 0 {C_SN}
XMWR_rtl_1111_1 sn_rtl_1111_1 wl1_rtl wbl_rtl_1111 0 sky130_fd_pr__nfet_01v8 L=0.15 W=0.42 nf=1 ad=0.1974 as=0.1974 pd=1.78 ps=1.78 nrd=0.69047619047619  nrs=0.69047619047619 sa=0 sb=0 sd=0 mult=1 m=1
XMRD_rtl_1111_1 rbl_rtl_1111 sn_rtl_1111_1 rwls1_rtl 0 sky130_fd_pr__nfet_01v8 L=0.15 W=0.42 nf=1 ad=0.1974 as=0.1974 pd=1.78 ps=1.78 nrd=0.69047619047619  nrs=0.69047619047619 sa=0 sb=0 sd=0 mult=1 m=1
csn_rtl_1111_1 sn_rtl_1111_1 0 {C_SN}
XMWR_rtl_1111_2 sn_rtl_1111_2 wl2_rtl wbl_rtl_1111 0 sky130_fd_pr__nfet_01v8 L=0.15 W=0.42 nf=1 ad=0.1974 as=0.1974 pd=1.78 ps=1.78 nrd=0.69047619047619  nrs=0.69047619047619 sa=0 sb=0 sd=0 mult=1 m=1
XMRD_rtl_1111_2 rbl_rtl_1111 sn_rtl_1111_2 rwls2_rtl 0 sky130_fd_pr__nfet_01v8 L=0.15 W=0.42 nf=1 ad=0.1974 as=0.1974 pd=1.78 ps=1.78 nrd=0.69047619047619  nrs=0.69047619047619 sa=0 sb=0 sd=0 mult=1 m=1
csn_rtl_1111_2 sn_rtl_1111_2 0 {C_SN}
XMWR_rtl_1111_3 sn_rtl_1111_3 wl3_rtl wbl_rtl_1111 0 sky130_fd_pr__nfet_01v8 L=0.15 W=0.42 nf=1 ad=0.1974 as=0.1974 pd=1.78 ps=1.78 nrd=0.69047619047619  nrs=0.69047619047619 sa=0 sb=0 sd=0 mult=1 m=1
XMRD_rtl_1111_3 rbl_rtl_1111 sn_rtl_1111_3 rwls3_rtl 0 sky130_fd_pr__nfet_01v8 L=0.15 W=0.42 nf=1 ad=0.1974 as=0.1974 pd=1.78 ps=1.78 nrd=0.69047619047619  nrs=0.69047619047619 sa=0 sb=0 sd=0 mult=1 m=1
csn_rtl_1111_3 sn_rtl_1111_3 0 {C_SN}
XMN1_rtl_1111 rbl_rtl_1111 ref_rtl_1111 vn_rtl_1111 0 sky130_fd_pr__nfet_01v8 L=0.15 W=1 nf=1 ad=0.29 as=0.29 pd=2.58 ps=2.58 nrd=0.29 nrs=0.29 sa=0 sb=0 sd=0 mult=1 m=1
XMN2_rtl_1111 ref_rtl_1111 rbl_rtl_1111 vn_rtl_1111 0 sky130_fd_pr__nfet_01v8 L=0.15 W=1 nf=1 ad=0.29 as=0.29 pd=2.58 ps=2.58 nrd=0.29 nrs=0.29 sa=0 sb=0 sd=0 mult=1 m=1
XMP1_rtl_1111 rbl_rtl_1111 ref_rtl_1111 vp_rtl_1111 vdd sky130_fd_pr__pfet_01v8 L=0.15 W=2 nf=1 ad=0.58 as=0.58 pd=4.58 ps=4.58 nrd=0.145 nrs=0.145 sa=0 sb=0 sd=0 mult=1 m=1
XMP2_rtl_1111 ref_rtl_1111 rbl_rtl_1111 vp_rtl_1111 vdd sky130_fd_pr__pfet_01v8 L=0.15 W=2 nf=1 ad=0.58 as=0.58 pd=4.58 ps=4.58 nrd=0.145 nrs=0.145 sa=0 sb=0 sd=0 mult=1 m=1
XMNF_rtl_1111 vn_rtl_1111 en_rtl 0 0 sky130_fd_pr__nfet_01v8 L=0.15 W=2 nf=1 ad=0.58 as=0.58 pd=4.58 ps=4.58 nrd=0.145 nrs=0.145 sa=0 sb=0 sd=0 mult=1 m=1
XMPH_rtl_1111 vp_rtl_1111 enb_rtl vdd vdd sky130_fd_pr__pfet_01v8 L=0.15 W=4 nf=1 ad=1.16 as=1.16 pd=8.58 ps=8.58 nrd=0.0725 nrs=0.0725 sa=0 sb=0 sd=0 mult=1 m=1
bd_rtl_1111 d_rtl_1111 0 v=v(rbl_rtl_1111)-v(ref_rtl_1111)

* ---- instance 9: rtl_0000 (control_rtl_unchanged) ----
sbi_rtl_0000 bld0000 wbl_rtl_0000 bpk_rtl 0 swwbl
swb_rtl_0000 ref_rtl_0000 wbl_rtl_0000 wbc_rtl 0 swwbl
cwbl_rtl_0000 wbl_rtl_0000 0 {C_WBL}
spa_rtl_0000 prea rbl_rtl_0000 ctl_rtl 0 swpre
spr_rtl_0000 pref ref_rtl_0000 ctl_rtl 0 swpre
crbl_rtl_0000 rbl_rtl_0000 0 {C_RBL}
cref_rtl_0000 ref_rtl_0000 0 {C_RBL}   $ ASSUMPTION: ideal matched dummy load
XMWR_rtl_0000_0 sn_rtl_0000_0 wl0_rtl wbl_rtl_0000 0 sky130_fd_pr__nfet_01v8 L=0.15 W=0.42 nf=1 ad=0.1974 as=0.1974 pd=1.78 ps=1.78 nrd=0.69047619047619  nrs=0.69047619047619 sa=0 sb=0 sd=0 mult=1 m=1
XMRD_rtl_0000_0 rbl_rtl_0000 sn_rtl_0000_0 rwls0_rtl 0 sky130_fd_pr__nfet_01v8 L=0.15 W=0.42 nf=1 ad=0.1974 as=0.1974 pd=1.78 ps=1.78 nrd=0.69047619047619  nrs=0.69047619047619 sa=0 sb=0 sd=0 mult=1 m=1
csn_rtl_0000_0 sn_rtl_0000_0 0 {C_SN}
XMWR_rtl_0000_1 sn_rtl_0000_1 wl1_rtl wbl_rtl_0000 0 sky130_fd_pr__nfet_01v8 L=0.15 W=0.42 nf=1 ad=0.1974 as=0.1974 pd=1.78 ps=1.78 nrd=0.69047619047619  nrs=0.69047619047619 sa=0 sb=0 sd=0 mult=1 m=1
XMRD_rtl_0000_1 rbl_rtl_0000 sn_rtl_0000_1 rwls1_rtl 0 sky130_fd_pr__nfet_01v8 L=0.15 W=0.42 nf=1 ad=0.1974 as=0.1974 pd=1.78 ps=1.78 nrd=0.69047619047619  nrs=0.69047619047619 sa=0 sb=0 sd=0 mult=1 m=1
csn_rtl_0000_1 sn_rtl_0000_1 0 {C_SN}
XMWR_rtl_0000_2 sn_rtl_0000_2 wl2_rtl wbl_rtl_0000 0 sky130_fd_pr__nfet_01v8 L=0.15 W=0.42 nf=1 ad=0.1974 as=0.1974 pd=1.78 ps=1.78 nrd=0.69047619047619  nrs=0.69047619047619 sa=0 sb=0 sd=0 mult=1 m=1
XMRD_rtl_0000_2 rbl_rtl_0000 sn_rtl_0000_2 rwls2_rtl 0 sky130_fd_pr__nfet_01v8 L=0.15 W=0.42 nf=1 ad=0.1974 as=0.1974 pd=1.78 ps=1.78 nrd=0.69047619047619  nrs=0.69047619047619 sa=0 sb=0 sd=0 mult=1 m=1
csn_rtl_0000_2 sn_rtl_0000_2 0 {C_SN}
XMWR_rtl_0000_3 sn_rtl_0000_3 wl3_rtl wbl_rtl_0000 0 sky130_fd_pr__nfet_01v8 L=0.15 W=0.42 nf=1 ad=0.1974 as=0.1974 pd=1.78 ps=1.78 nrd=0.69047619047619  nrs=0.69047619047619 sa=0 sb=0 sd=0 mult=1 m=1
XMRD_rtl_0000_3 rbl_rtl_0000 sn_rtl_0000_3 rwls3_rtl 0 sky130_fd_pr__nfet_01v8 L=0.15 W=0.42 nf=1 ad=0.1974 as=0.1974 pd=1.78 ps=1.78 nrd=0.69047619047619  nrs=0.69047619047619 sa=0 sb=0 sd=0 mult=1 m=1
csn_rtl_0000_3 sn_rtl_0000_3 0 {C_SN}
XMN1_rtl_0000 rbl_rtl_0000 ref_rtl_0000 vn_rtl_0000 0 sky130_fd_pr__nfet_01v8 L=0.15 W=1 nf=1 ad=0.29 as=0.29 pd=2.58 ps=2.58 nrd=0.29 nrs=0.29 sa=0 sb=0 sd=0 mult=1 m=1
XMN2_rtl_0000 ref_rtl_0000 rbl_rtl_0000 vn_rtl_0000 0 sky130_fd_pr__nfet_01v8 L=0.15 W=1 nf=1 ad=0.29 as=0.29 pd=2.58 ps=2.58 nrd=0.29 nrs=0.29 sa=0 sb=0 sd=0 mult=1 m=1
XMP1_rtl_0000 rbl_rtl_0000 ref_rtl_0000 vp_rtl_0000 vdd sky130_fd_pr__pfet_01v8 L=0.15 W=2 nf=1 ad=0.58 as=0.58 pd=4.58 ps=4.58 nrd=0.145 nrs=0.145 sa=0 sb=0 sd=0 mult=1 m=1
XMP2_rtl_0000 ref_rtl_0000 rbl_rtl_0000 vp_rtl_0000 vdd sky130_fd_pr__pfet_01v8 L=0.15 W=2 nf=1 ad=0.58 as=0.58 pd=4.58 ps=4.58 nrd=0.145 nrs=0.145 sa=0 sb=0 sd=0 mult=1 m=1
XMNF_rtl_0000 vn_rtl_0000 en_rtl 0 0 sky130_fd_pr__nfet_01v8 L=0.15 W=2 nf=1 ad=0.58 as=0.58 pd=4.58 ps=4.58 nrd=0.145 nrs=0.145 sa=0 sb=0 sd=0 mult=1 m=1
XMPH_rtl_0000 vp_rtl_0000 enb_rtl vdd vdd sky130_fd_pr__pfet_01v8 L=0.15 W=4 nf=1 ad=1.16 as=1.16 pd=8.58 ps=8.58 nrd=0.0725 nrs=0.0725 sa=0 sb=0 sd=0 mult=1 m=1
bd_rtl_0000 d_rtl_0000 0 v=v(rbl_rtl_0000)-v(ref_rtl_0000)

* ---- instance 10: rtl_1010 (control_rtl_unchanged) ----
sbi_rtl_1010 bld1010 wbl_rtl_1010 bpk_rtl 0 swwbl
swb_rtl_1010 ref_rtl_1010 wbl_rtl_1010 wbc_rtl 0 swwbl
cwbl_rtl_1010 wbl_rtl_1010 0 {C_WBL}
spa_rtl_1010 prea rbl_rtl_1010 ctl_rtl 0 swpre
spr_rtl_1010 pref ref_rtl_1010 ctl_rtl 0 swpre
crbl_rtl_1010 rbl_rtl_1010 0 {C_RBL}
cref_rtl_1010 ref_rtl_1010 0 {C_RBL}   $ ASSUMPTION: ideal matched dummy load
XMWR_rtl_1010_0 sn_rtl_1010_0 wl0_rtl wbl_rtl_1010 0 sky130_fd_pr__nfet_01v8 L=0.15 W=0.42 nf=1 ad=0.1974 as=0.1974 pd=1.78 ps=1.78 nrd=0.69047619047619  nrs=0.69047619047619 sa=0 sb=0 sd=0 mult=1 m=1
XMRD_rtl_1010_0 rbl_rtl_1010 sn_rtl_1010_0 rwls0_rtl 0 sky130_fd_pr__nfet_01v8 L=0.15 W=0.42 nf=1 ad=0.1974 as=0.1974 pd=1.78 ps=1.78 nrd=0.69047619047619  nrs=0.69047619047619 sa=0 sb=0 sd=0 mult=1 m=1
csn_rtl_1010_0 sn_rtl_1010_0 0 {C_SN}
XMWR_rtl_1010_1 sn_rtl_1010_1 wl1_rtl wbl_rtl_1010 0 sky130_fd_pr__nfet_01v8 L=0.15 W=0.42 nf=1 ad=0.1974 as=0.1974 pd=1.78 ps=1.78 nrd=0.69047619047619  nrs=0.69047619047619 sa=0 sb=0 sd=0 mult=1 m=1
XMRD_rtl_1010_1 rbl_rtl_1010 sn_rtl_1010_1 rwls1_rtl 0 sky130_fd_pr__nfet_01v8 L=0.15 W=0.42 nf=1 ad=0.1974 as=0.1974 pd=1.78 ps=1.78 nrd=0.69047619047619  nrs=0.69047619047619 sa=0 sb=0 sd=0 mult=1 m=1
csn_rtl_1010_1 sn_rtl_1010_1 0 {C_SN}
XMWR_rtl_1010_2 sn_rtl_1010_2 wl2_rtl wbl_rtl_1010 0 sky130_fd_pr__nfet_01v8 L=0.15 W=0.42 nf=1 ad=0.1974 as=0.1974 pd=1.78 ps=1.78 nrd=0.69047619047619  nrs=0.69047619047619 sa=0 sb=0 sd=0 mult=1 m=1
XMRD_rtl_1010_2 rbl_rtl_1010 sn_rtl_1010_2 rwls2_rtl 0 sky130_fd_pr__nfet_01v8 L=0.15 W=0.42 nf=1 ad=0.1974 as=0.1974 pd=1.78 ps=1.78 nrd=0.69047619047619  nrs=0.69047619047619 sa=0 sb=0 sd=0 mult=1 m=1
csn_rtl_1010_2 sn_rtl_1010_2 0 {C_SN}
XMWR_rtl_1010_3 sn_rtl_1010_3 wl3_rtl wbl_rtl_1010 0 sky130_fd_pr__nfet_01v8 L=0.15 W=0.42 nf=1 ad=0.1974 as=0.1974 pd=1.78 ps=1.78 nrd=0.69047619047619  nrs=0.69047619047619 sa=0 sb=0 sd=0 mult=1 m=1
XMRD_rtl_1010_3 rbl_rtl_1010 sn_rtl_1010_3 rwls3_rtl 0 sky130_fd_pr__nfet_01v8 L=0.15 W=0.42 nf=1 ad=0.1974 as=0.1974 pd=1.78 ps=1.78 nrd=0.69047619047619  nrs=0.69047619047619 sa=0 sb=0 sd=0 mult=1 m=1
csn_rtl_1010_3 sn_rtl_1010_3 0 {C_SN}
XMN1_rtl_1010 rbl_rtl_1010 ref_rtl_1010 vn_rtl_1010 0 sky130_fd_pr__nfet_01v8 L=0.15 W=1 nf=1 ad=0.29 as=0.29 pd=2.58 ps=2.58 nrd=0.29 nrs=0.29 sa=0 sb=0 sd=0 mult=1 m=1
XMN2_rtl_1010 ref_rtl_1010 rbl_rtl_1010 vn_rtl_1010 0 sky130_fd_pr__nfet_01v8 L=0.15 W=1 nf=1 ad=0.29 as=0.29 pd=2.58 ps=2.58 nrd=0.29 nrs=0.29 sa=0 sb=0 sd=0 mult=1 m=1
XMP1_rtl_1010 rbl_rtl_1010 ref_rtl_1010 vp_rtl_1010 vdd sky130_fd_pr__pfet_01v8 L=0.15 W=2 nf=1 ad=0.58 as=0.58 pd=4.58 ps=4.58 nrd=0.145 nrs=0.145 sa=0 sb=0 sd=0 mult=1 m=1
XMP2_rtl_1010 ref_rtl_1010 rbl_rtl_1010 vp_rtl_1010 vdd sky130_fd_pr__pfet_01v8 L=0.15 W=2 nf=1 ad=0.58 as=0.58 pd=4.58 ps=4.58 nrd=0.145 nrs=0.145 sa=0 sb=0 sd=0 mult=1 m=1
XMNF_rtl_1010 vn_rtl_1010 en_rtl 0 0 sky130_fd_pr__nfet_01v8 L=0.15 W=2 nf=1 ad=0.58 as=0.58 pd=4.58 ps=4.58 nrd=0.145 nrs=0.145 sa=0 sb=0 sd=0 mult=1 m=1
XMPH_rtl_1010 vp_rtl_1010 enb_rtl vdd vdd sky130_fd_pr__pfet_01v8 L=0.15 W=4 nf=1 ad=1.16 as=1.16 pd=8.58 ps=8.58 nrd=0.0725 nrs=0.0725 sa=0 sb=0 sd=0 mult=1 m=1
bd_rtl_1010 d_rtl_1010 0 v=v(rbl_rtl_1010)-v(ref_rtl_1010)

* ---- instance 11: rtl_0101 (control_rtl_unchanged) ----
sbi_rtl_0101 bld0101 wbl_rtl_0101 bpk_rtl 0 swwbl
swb_rtl_0101 ref_rtl_0101 wbl_rtl_0101 wbc_rtl 0 swwbl
cwbl_rtl_0101 wbl_rtl_0101 0 {C_WBL}
spa_rtl_0101 prea rbl_rtl_0101 ctl_rtl 0 swpre
spr_rtl_0101 pref ref_rtl_0101 ctl_rtl 0 swpre
crbl_rtl_0101 rbl_rtl_0101 0 {C_RBL}
cref_rtl_0101 ref_rtl_0101 0 {C_RBL}   $ ASSUMPTION: ideal matched dummy load
XMWR_rtl_0101_0 sn_rtl_0101_0 wl0_rtl wbl_rtl_0101 0 sky130_fd_pr__nfet_01v8 L=0.15 W=0.42 nf=1 ad=0.1974 as=0.1974 pd=1.78 ps=1.78 nrd=0.69047619047619  nrs=0.69047619047619 sa=0 sb=0 sd=0 mult=1 m=1
XMRD_rtl_0101_0 rbl_rtl_0101 sn_rtl_0101_0 rwls0_rtl 0 sky130_fd_pr__nfet_01v8 L=0.15 W=0.42 nf=1 ad=0.1974 as=0.1974 pd=1.78 ps=1.78 nrd=0.69047619047619  nrs=0.69047619047619 sa=0 sb=0 sd=0 mult=1 m=1
csn_rtl_0101_0 sn_rtl_0101_0 0 {C_SN}
XMWR_rtl_0101_1 sn_rtl_0101_1 wl1_rtl wbl_rtl_0101 0 sky130_fd_pr__nfet_01v8 L=0.15 W=0.42 nf=1 ad=0.1974 as=0.1974 pd=1.78 ps=1.78 nrd=0.69047619047619  nrs=0.69047619047619 sa=0 sb=0 sd=0 mult=1 m=1
XMRD_rtl_0101_1 rbl_rtl_0101 sn_rtl_0101_1 rwls1_rtl 0 sky130_fd_pr__nfet_01v8 L=0.15 W=0.42 nf=1 ad=0.1974 as=0.1974 pd=1.78 ps=1.78 nrd=0.69047619047619  nrs=0.69047619047619 sa=0 sb=0 sd=0 mult=1 m=1
csn_rtl_0101_1 sn_rtl_0101_1 0 {C_SN}
XMWR_rtl_0101_2 sn_rtl_0101_2 wl2_rtl wbl_rtl_0101 0 sky130_fd_pr__nfet_01v8 L=0.15 W=0.42 nf=1 ad=0.1974 as=0.1974 pd=1.78 ps=1.78 nrd=0.69047619047619  nrs=0.69047619047619 sa=0 sb=0 sd=0 mult=1 m=1
XMRD_rtl_0101_2 rbl_rtl_0101 sn_rtl_0101_2 rwls2_rtl 0 sky130_fd_pr__nfet_01v8 L=0.15 W=0.42 nf=1 ad=0.1974 as=0.1974 pd=1.78 ps=1.78 nrd=0.69047619047619  nrs=0.69047619047619 sa=0 sb=0 sd=0 mult=1 m=1
csn_rtl_0101_2 sn_rtl_0101_2 0 {C_SN}
XMWR_rtl_0101_3 sn_rtl_0101_3 wl3_rtl wbl_rtl_0101 0 sky130_fd_pr__nfet_01v8 L=0.15 W=0.42 nf=1 ad=0.1974 as=0.1974 pd=1.78 ps=1.78 nrd=0.69047619047619  nrs=0.69047619047619 sa=0 sb=0 sd=0 mult=1 m=1
XMRD_rtl_0101_3 rbl_rtl_0101 sn_rtl_0101_3 rwls3_rtl 0 sky130_fd_pr__nfet_01v8 L=0.15 W=0.42 nf=1 ad=0.1974 as=0.1974 pd=1.78 ps=1.78 nrd=0.69047619047619  nrs=0.69047619047619 sa=0 sb=0 sd=0 mult=1 m=1
csn_rtl_0101_3 sn_rtl_0101_3 0 {C_SN}
XMN1_rtl_0101 rbl_rtl_0101 ref_rtl_0101 vn_rtl_0101 0 sky130_fd_pr__nfet_01v8 L=0.15 W=1 nf=1 ad=0.29 as=0.29 pd=2.58 ps=2.58 nrd=0.29 nrs=0.29 sa=0 sb=0 sd=0 mult=1 m=1
XMN2_rtl_0101 ref_rtl_0101 rbl_rtl_0101 vn_rtl_0101 0 sky130_fd_pr__nfet_01v8 L=0.15 W=1 nf=1 ad=0.29 as=0.29 pd=2.58 ps=2.58 nrd=0.29 nrs=0.29 sa=0 sb=0 sd=0 mult=1 m=1
XMP1_rtl_0101 rbl_rtl_0101 ref_rtl_0101 vp_rtl_0101 vdd sky130_fd_pr__pfet_01v8 L=0.15 W=2 nf=1 ad=0.58 as=0.58 pd=4.58 ps=4.58 nrd=0.145 nrs=0.145 sa=0 sb=0 sd=0 mult=1 m=1
XMP2_rtl_0101 ref_rtl_0101 rbl_rtl_0101 vp_rtl_0101 vdd sky130_fd_pr__pfet_01v8 L=0.15 W=2 nf=1 ad=0.58 as=0.58 pd=4.58 ps=4.58 nrd=0.145 nrs=0.145 sa=0 sb=0 sd=0 mult=1 m=1
XMNF_rtl_0101 vn_rtl_0101 en_rtl 0 0 sky130_fd_pr__nfet_01v8 L=0.15 W=2 nf=1 ad=0.58 as=0.58 pd=4.58 ps=4.58 nrd=0.145 nrs=0.145 sa=0 sb=0 sd=0 mult=1 m=1
XMPH_rtl_0101 vp_rtl_0101 enb_rtl vdd vdd sky130_fd_pr__pfet_01v8 L=0.15 W=4 nf=1 ad=1.16 as=1.16 pd=8.58 ps=8.58 nrd=0.0725 nrs=0.0725 sa=0 sb=0 sd=0 mult=1 m=1
bd_rtl_0101 d_rtl_0101 0 v=v(rbl_rtl_0101)-v(ref_rtl_0101)

* ---- instance 12: late_1111 (experimental_unapproved) ----
sbi_late_1111 bld1111 wbl_late_1111 bpk_late 0 swwbl
swb_late_1111 ref_late_1111 wbl_late_1111 wbc_late 0 swwbl
cwbl_late_1111 wbl_late_1111 0 {C_WBL}
spa_late_1111 prea rbl_late_1111 ctl_late 0 swpre
spr_late_1111 pref ref_late_1111 ctl_late 0 swpre
crbl_late_1111 rbl_late_1111 0 {C_RBL}
cref_late_1111 ref_late_1111 0 {C_RBL}   $ ASSUMPTION: ideal matched dummy load
XMWR_late_1111_0 sn_late_1111_0 wl0_late wbl_late_1111 0 sky130_fd_pr__nfet_01v8 L=0.15 W=0.42 nf=1 ad=0.1974 as=0.1974 pd=1.78 ps=1.78 nrd=0.69047619047619  nrs=0.69047619047619 sa=0 sb=0 sd=0 mult=1 m=1
XMRD_late_1111_0 rbl_late_1111 sn_late_1111_0 rwls0_late 0 sky130_fd_pr__nfet_01v8 L=0.15 W=0.42 nf=1 ad=0.1974 as=0.1974 pd=1.78 ps=1.78 nrd=0.69047619047619  nrs=0.69047619047619 sa=0 sb=0 sd=0 mult=1 m=1
csn_late_1111_0 sn_late_1111_0 0 {C_SN}
XMWR_late_1111_1 sn_late_1111_1 wl1_late wbl_late_1111 0 sky130_fd_pr__nfet_01v8 L=0.15 W=0.42 nf=1 ad=0.1974 as=0.1974 pd=1.78 ps=1.78 nrd=0.69047619047619  nrs=0.69047619047619 sa=0 sb=0 sd=0 mult=1 m=1
XMRD_late_1111_1 rbl_late_1111 sn_late_1111_1 rwls1_late 0 sky130_fd_pr__nfet_01v8 L=0.15 W=0.42 nf=1 ad=0.1974 as=0.1974 pd=1.78 ps=1.78 nrd=0.69047619047619  nrs=0.69047619047619 sa=0 sb=0 sd=0 mult=1 m=1
csn_late_1111_1 sn_late_1111_1 0 {C_SN}
XMWR_late_1111_2 sn_late_1111_2 wl2_late wbl_late_1111 0 sky130_fd_pr__nfet_01v8 L=0.15 W=0.42 nf=1 ad=0.1974 as=0.1974 pd=1.78 ps=1.78 nrd=0.69047619047619  nrs=0.69047619047619 sa=0 sb=0 sd=0 mult=1 m=1
XMRD_late_1111_2 rbl_late_1111 sn_late_1111_2 rwls2_late 0 sky130_fd_pr__nfet_01v8 L=0.15 W=0.42 nf=1 ad=0.1974 as=0.1974 pd=1.78 ps=1.78 nrd=0.69047619047619  nrs=0.69047619047619 sa=0 sb=0 sd=0 mult=1 m=1
csn_late_1111_2 sn_late_1111_2 0 {C_SN}
XMWR_late_1111_3 sn_late_1111_3 wl3_late wbl_late_1111 0 sky130_fd_pr__nfet_01v8 L=0.15 W=0.42 nf=1 ad=0.1974 as=0.1974 pd=1.78 ps=1.78 nrd=0.69047619047619  nrs=0.69047619047619 sa=0 sb=0 sd=0 mult=1 m=1
XMRD_late_1111_3 rbl_late_1111 sn_late_1111_3 rwls3_late 0 sky130_fd_pr__nfet_01v8 L=0.15 W=0.42 nf=1 ad=0.1974 as=0.1974 pd=1.78 ps=1.78 nrd=0.69047619047619  nrs=0.69047619047619 sa=0 sb=0 sd=0 mult=1 m=1
csn_late_1111_3 sn_late_1111_3 0 {C_SN}
XMN1_late_1111 rbl_late_1111 ref_late_1111 vn_late_1111 0 sky130_fd_pr__nfet_01v8 L=0.15 W=1 nf=1 ad=0.29 as=0.29 pd=2.58 ps=2.58 nrd=0.29 nrs=0.29 sa=0 sb=0 sd=0 mult=1 m=1
XMN2_late_1111 ref_late_1111 rbl_late_1111 vn_late_1111 0 sky130_fd_pr__nfet_01v8 L=0.15 W=1 nf=1 ad=0.29 as=0.29 pd=2.58 ps=2.58 nrd=0.29 nrs=0.29 sa=0 sb=0 sd=0 mult=1 m=1
XMP1_late_1111 rbl_late_1111 ref_late_1111 vp_late_1111 vdd sky130_fd_pr__pfet_01v8 L=0.15 W=2 nf=1 ad=0.58 as=0.58 pd=4.58 ps=4.58 nrd=0.145 nrs=0.145 sa=0 sb=0 sd=0 mult=1 m=1
XMP2_late_1111 ref_late_1111 rbl_late_1111 vp_late_1111 vdd sky130_fd_pr__pfet_01v8 L=0.15 W=2 nf=1 ad=0.58 as=0.58 pd=4.58 ps=4.58 nrd=0.145 nrs=0.145 sa=0 sb=0 sd=0 mult=1 m=1
XMNF_late_1111 vn_late_1111 en_late 0 0 sky130_fd_pr__nfet_01v8 L=0.15 W=2 nf=1 ad=0.58 as=0.58 pd=4.58 ps=4.58 nrd=0.145 nrs=0.145 sa=0 sb=0 sd=0 mult=1 m=1
XMPH_late_1111 vp_late_1111 enb_late vdd vdd sky130_fd_pr__pfet_01v8 L=0.15 W=4 nf=1 ad=1.16 as=1.16 pd=8.58 ps=8.58 nrd=0.0725 nrs=0.0725 sa=0 sb=0 sd=0 mult=1 m=1
bd_late_1111 d_late_1111 0 v=v(rbl_late_1111)-v(ref_late_1111)

* ---- instance 13: late_0000 (experimental_unapproved) ----
sbi_late_0000 bld0000 wbl_late_0000 bpk_late 0 swwbl
swb_late_0000 ref_late_0000 wbl_late_0000 wbc_late 0 swwbl
cwbl_late_0000 wbl_late_0000 0 {C_WBL}
spa_late_0000 prea rbl_late_0000 ctl_late 0 swpre
spr_late_0000 pref ref_late_0000 ctl_late 0 swpre
crbl_late_0000 rbl_late_0000 0 {C_RBL}
cref_late_0000 ref_late_0000 0 {C_RBL}   $ ASSUMPTION: ideal matched dummy load
XMWR_late_0000_0 sn_late_0000_0 wl0_late wbl_late_0000 0 sky130_fd_pr__nfet_01v8 L=0.15 W=0.42 nf=1 ad=0.1974 as=0.1974 pd=1.78 ps=1.78 nrd=0.69047619047619  nrs=0.69047619047619 sa=0 sb=0 sd=0 mult=1 m=1
XMRD_late_0000_0 rbl_late_0000 sn_late_0000_0 rwls0_late 0 sky130_fd_pr__nfet_01v8 L=0.15 W=0.42 nf=1 ad=0.1974 as=0.1974 pd=1.78 ps=1.78 nrd=0.69047619047619  nrs=0.69047619047619 sa=0 sb=0 sd=0 mult=1 m=1
csn_late_0000_0 sn_late_0000_0 0 {C_SN}
XMWR_late_0000_1 sn_late_0000_1 wl1_late wbl_late_0000 0 sky130_fd_pr__nfet_01v8 L=0.15 W=0.42 nf=1 ad=0.1974 as=0.1974 pd=1.78 ps=1.78 nrd=0.69047619047619  nrs=0.69047619047619 sa=0 sb=0 sd=0 mult=1 m=1
XMRD_late_0000_1 rbl_late_0000 sn_late_0000_1 rwls1_late 0 sky130_fd_pr__nfet_01v8 L=0.15 W=0.42 nf=1 ad=0.1974 as=0.1974 pd=1.78 ps=1.78 nrd=0.69047619047619  nrs=0.69047619047619 sa=0 sb=0 sd=0 mult=1 m=1
csn_late_0000_1 sn_late_0000_1 0 {C_SN}
XMWR_late_0000_2 sn_late_0000_2 wl2_late wbl_late_0000 0 sky130_fd_pr__nfet_01v8 L=0.15 W=0.42 nf=1 ad=0.1974 as=0.1974 pd=1.78 ps=1.78 nrd=0.69047619047619  nrs=0.69047619047619 sa=0 sb=0 sd=0 mult=1 m=1
XMRD_late_0000_2 rbl_late_0000 sn_late_0000_2 rwls2_late 0 sky130_fd_pr__nfet_01v8 L=0.15 W=0.42 nf=1 ad=0.1974 as=0.1974 pd=1.78 ps=1.78 nrd=0.69047619047619  nrs=0.69047619047619 sa=0 sb=0 sd=0 mult=1 m=1
csn_late_0000_2 sn_late_0000_2 0 {C_SN}
XMWR_late_0000_3 sn_late_0000_3 wl3_late wbl_late_0000 0 sky130_fd_pr__nfet_01v8 L=0.15 W=0.42 nf=1 ad=0.1974 as=0.1974 pd=1.78 ps=1.78 nrd=0.69047619047619  nrs=0.69047619047619 sa=0 sb=0 sd=0 mult=1 m=1
XMRD_late_0000_3 rbl_late_0000 sn_late_0000_3 rwls3_late 0 sky130_fd_pr__nfet_01v8 L=0.15 W=0.42 nf=1 ad=0.1974 as=0.1974 pd=1.78 ps=1.78 nrd=0.69047619047619  nrs=0.69047619047619 sa=0 sb=0 sd=0 mult=1 m=1
csn_late_0000_3 sn_late_0000_3 0 {C_SN}
XMN1_late_0000 rbl_late_0000 ref_late_0000 vn_late_0000 0 sky130_fd_pr__nfet_01v8 L=0.15 W=1 nf=1 ad=0.29 as=0.29 pd=2.58 ps=2.58 nrd=0.29 nrs=0.29 sa=0 sb=0 sd=0 mult=1 m=1
XMN2_late_0000 ref_late_0000 rbl_late_0000 vn_late_0000 0 sky130_fd_pr__nfet_01v8 L=0.15 W=1 nf=1 ad=0.29 as=0.29 pd=2.58 ps=2.58 nrd=0.29 nrs=0.29 sa=0 sb=0 sd=0 mult=1 m=1
XMP1_late_0000 rbl_late_0000 ref_late_0000 vp_late_0000 vdd sky130_fd_pr__pfet_01v8 L=0.15 W=2 nf=1 ad=0.58 as=0.58 pd=4.58 ps=4.58 nrd=0.145 nrs=0.145 sa=0 sb=0 sd=0 mult=1 m=1
XMP2_late_0000 ref_late_0000 rbl_late_0000 vp_late_0000 vdd sky130_fd_pr__pfet_01v8 L=0.15 W=2 nf=1 ad=0.58 as=0.58 pd=4.58 ps=4.58 nrd=0.145 nrs=0.145 sa=0 sb=0 sd=0 mult=1 m=1
XMNF_late_0000 vn_late_0000 en_late 0 0 sky130_fd_pr__nfet_01v8 L=0.15 W=2 nf=1 ad=0.58 as=0.58 pd=4.58 ps=4.58 nrd=0.145 nrs=0.145 sa=0 sb=0 sd=0 mult=1 m=1
XMPH_late_0000 vp_late_0000 enb_late vdd vdd sky130_fd_pr__pfet_01v8 L=0.15 W=4 nf=1 ad=1.16 as=1.16 pd=8.58 ps=8.58 nrd=0.0725 nrs=0.0725 sa=0 sb=0 sd=0 mult=1 m=1
bd_late_0000 d_late_0000 0 v=v(rbl_late_0000)-v(ref_late_0000)

* ---- instance 14: late_1010 (experimental_unapproved) ----
sbi_late_1010 bld1010 wbl_late_1010 bpk_late 0 swwbl
swb_late_1010 ref_late_1010 wbl_late_1010 wbc_late 0 swwbl
cwbl_late_1010 wbl_late_1010 0 {C_WBL}
spa_late_1010 prea rbl_late_1010 ctl_late 0 swpre
spr_late_1010 pref ref_late_1010 ctl_late 0 swpre
crbl_late_1010 rbl_late_1010 0 {C_RBL}
cref_late_1010 ref_late_1010 0 {C_RBL}   $ ASSUMPTION: ideal matched dummy load
XMWR_late_1010_0 sn_late_1010_0 wl0_late wbl_late_1010 0 sky130_fd_pr__nfet_01v8 L=0.15 W=0.42 nf=1 ad=0.1974 as=0.1974 pd=1.78 ps=1.78 nrd=0.69047619047619  nrs=0.69047619047619 sa=0 sb=0 sd=0 mult=1 m=1
XMRD_late_1010_0 rbl_late_1010 sn_late_1010_0 rwls0_late 0 sky130_fd_pr__nfet_01v8 L=0.15 W=0.42 nf=1 ad=0.1974 as=0.1974 pd=1.78 ps=1.78 nrd=0.69047619047619  nrs=0.69047619047619 sa=0 sb=0 sd=0 mult=1 m=1
csn_late_1010_0 sn_late_1010_0 0 {C_SN}
XMWR_late_1010_1 sn_late_1010_1 wl1_late wbl_late_1010 0 sky130_fd_pr__nfet_01v8 L=0.15 W=0.42 nf=1 ad=0.1974 as=0.1974 pd=1.78 ps=1.78 nrd=0.69047619047619  nrs=0.69047619047619 sa=0 sb=0 sd=0 mult=1 m=1
XMRD_late_1010_1 rbl_late_1010 sn_late_1010_1 rwls1_late 0 sky130_fd_pr__nfet_01v8 L=0.15 W=0.42 nf=1 ad=0.1974 as=0.1974 pd=1.78 ps=1.78 nrd=0.69047619047619  nrs=0.69047619047619 sa=0 sb=0 sd=0 mult=1 m=1
csn_late_1010_1 sn_late_1010_1 0 {C_SN}
XMWR_late_1010_2 sn_late_1010_2 wl2_late wbl_late_1010 0 sky130_fd_pr__nfet_01v8 L=0.15 W=0.42 nf=1 ad=0.1974 as=0.1974 pd=1.78 ps=1.78 nrd=0.69047619047619  nrs=0.69047619047619 sa=0 sb=0 sd=0 mult=1 m=1
XMRD_late_1010_2 rbl_late_1010 sn_late_1010_2 rwls2_late 0 sky130_fd_pr__nfet_01v8 L=0.15 W=0.42 nf=1 ad=0.1974 as=0.1974 pd=1.78 ps=1.78 nrd=0.69047619047619  nrs=0.69047619047619 sa=0 sb=0 sd=0 mult=1 m=1
csn_late_1010_2 sn_late_1010_2 0 {C_SN}
XMWR_late_1010_3 sn_late_1010_3 wl3_late wbl_late_1010 0 sky130_fd_pr__nfet_01v8 L=0.15 W=0.42 nf=1 ad=0.1974 as=0.1974 pd=1.78 ps=1.78 nrd=0.69047619047619  nrs=0.69047619047619 sa=0 sb=0 sd=0 mult=1 m=1
XMRD_late_1010_3 rbl_late_1010 sn_late_1010_3 rwls3_late 0 sky130_fd_pr__nfet_01v8 L=0.15 W=0.42 nf=1 ad=0.1974 as=0.1974 pd=1.78 ps=1.78 nrd=0.69047619047619  nrs=0.69047619047619 sa=0 sb=0 sd=0 mult=1 m=1
csn_late_1010_3 sn_late_1010_3 0 {C_SN}
XMN1_late_1010 rbl_late_1010 ref_late_1010 vn_late_1010 0 sky130_fd_pr__nfet_01v8 L=0.15 W=1 nf=1 ad=0.29 as=0.29 pd=2.58 ps=2.58 nrd=0.29 nrs=0.29 sa=0 sb=0 sd=0 mult=1 m=1
XMN2_late_1010 ref_late_1010 rbl_late_1010 vn_late_1010 0 sky130_fd_pr__nfet_01v8 L=0.15 W=1 nf=1 ad=0.29 as=0.29 pd=2.58 ps=2.58 nrd=0.29 nrs=0.29 sa=0 sb=0 sd=0 mult=1 m=1
XMP1_late_1010 rbl_late_1010 ref_late_1010 vp_late_1010 vdd sky130_fd_pr__pfet_01v8 L=0.15 W=2 nf=1 ad=0.58 as=0.58 pd=4.58 ps=4.58 nrd=0.145 nrs=0.145 sa=0 sb=0 sd=0 mult=1 m=1
XMP2_late_1010 ref_late_1010 rbl_late_1010 vp_late_1010 vdd sky130_fd_pr__pfet_01v8 L=0.15 W=2 nf=1 ad=0.58 as=0.58 pd=4.58 ps=4.58 nrd=0.145 nrs=0.145 sa=0 sb=0 sd=0 mult=1 m=1
XMNF_late_1010 vn_late_1010 en_late 0 0 sky130_fd_pr__nfet_01v8 L=0.15 W=2 nf=1 ad=0.58 as=0.58 pd=4.58 ps=4.58 nrd=0.145 nrs=0.145 sa=0 sb=0 sd=0 mult=1 m=1
XMPH_late_1010 vp_late_1010 enb_late vdd vdd sky130_fd_pr__pfet_01v8 L=0.15 W=4 nf=1 ad=1.16 as=1.16 pd=8.58 ps=8.58 nrd=0.0725 nrs=0.0725 sa=0 sb=0 sd=0 mult=1 m=1
bd_late_1010 d_late_1010 0 v=v(rbl_late_1010)-v(ref_late_1010)

* ---- instance 15: late_0101 (experimental_unapproved) ----
sbi_late_0101 bld0101 wbl_late_0101 bpk_late 0 swwbl
swb_late_0101 ref_late_0101 wbl_late_0101 wbc_late 0 swwbl
cwbl_late_0101 wbl_late_0101 0 {C_WBL}
spa_late_0101 prea rbl_late_0101 ctl_late 0 swpre
spr_late_0101 pref ref_late_0101 ctl_late 0 swpre
crbl_late_0101 rbl_late_0101 0 {C_RBL}
cref_late_0101 ref_late_0101 0 {C_RBL}   $ ASSUMPTION: ideal matched dummy load
XMWR_late_0101_0 sn_late_0101_0 wl0_late wbl_late_0101 0 sky130_fd_pr__nfet_01v8 L=0.15 W=0.42 nf=1 ad=0.1974 as=0.1974 pd=1.78 ps=1.78 nrd=0.69047619047619  nrs=0.69047619047619 sa=0 sb=0 sd=0 mult=1 m=1
XMRD_late_0101_0 rbl_late_0101 sn_late_0101_0 rwls0_late 0 sky130_fd_pr__nfet_01v8 L=0.15 W=0.42 nf=1 ad=0.1974 as=0.1974 pd=1.78 ps=1.78 nrd=0.69047619047619  nrs=0.69047619047619 sa=0 sb=0 sd=0 mult=1 m=1
csn_late_0101_0 sn_late_0101_0 0 {C_SN}
XMWR_late_0101_1 sn_late_0101_1 wl1_late wbl_late_0101 0 sky130_fd_pr__nfet_01v8 L=0.15 W=0.42 nf=1 ad=0.1974 as=0.1974 pd=1.78 ps=1.78 nrd=0.69047619047619  nrs=0.69047619047619 sa=0 sb=0 sd=0 mult=1 m=1
XMRD_late_0101_1 rbl_late_0101 sn_late_0101_1 rwls1_late 0 sky130_fd_pr__nfet_01v8 L=0.15 W=0.42 nf=1 ad=0.1974 as=0.1974 pd=1.78 ps=1.78 nrd=0.69047619047619  nrs=0.69047619047619 sa=0 sb=0 sd=0 mult=1 m=1
csn_late_0101_1 sn_late_0101_1 0 {C_SN}
XMWR_late_0101_2 sn_late_0101_2 wl2_late wbl_late_0101 0 sky130_fd_pr__nfet_01v8 L=0.15 W=0.42 nf=1 ad=0.1974 as=0.1974 pd=1.78 ps=1.78 nrd=0.69047619047619  nrs=0.69047619047619 sa=0 sb=0 sd=0 mult=1 m=1
XMRD_late_0101_2 rbl_late_0101 sn_late_0101_2 rwls2_late 0 sky130_fd_pr__nfet_01v8 L=0.15 W=0.42 nf=1 ad=0.1974 as=0.1974 pd=1.78 ps=1.78 nrd=0.69047619047619  nrs=0.69047619047619 sa=0 sb=0 sd=0 mult=1 m=1
csn_late_0101_2 sn_late_0101_2 0 {C_SN}
XMWR_late_0101_3 sn_late_0101_3 wl3_late wbl_late_0101 0 sky130_fd_pr__nfet_01v8 L=0.15 W=0.42 nf=1 ad=0.1974 as=0.1974 pd=1.78 ps=1.78 nrd=0.69047619047619  nrs=0.69047619047619 sa=0 sb=0 sd=0 mult=1 m=1
XMRD_late_0101_3 rbl_late_0101 sn_late_0101_3 rwls3_late 0 sky130_fd_pr__nfet_01v8 L=0.15 W=0.42 nf=1 ad=0.1974 as=0.1974 pd=1.78 ps=1.78 nrd=0.69047619047619  nrs=0.69047619047619 sa=0 sb=0 sd=0 mult=1 m=1
csn_late_0101_3 sn_late_0101_3 0 {C_SN}
XMN1_late_0101 rbl_late_0101 ref_late_0101 vn_late_0101 0 sky130_fd_pr__nfet_01v8 L=0.15 W=1 nf=1 ad=0.29 as=0.29 pd=2.58 ps=2.58 nrd=0.29 nrs=0.29 sa=0 sb=0 sd=0 mult=1 m=1
XMN2_late_0101 ref_late_0101 rbl_late_0101 vn_late_0101 0 sky130_fd_pr__nfet_01v8 L=0.15 W=1 nf=1 ad=0.29 as=0.29 pd=2.58 ps=2.58 nrd=0.29 nrs=0.29 sa=0 sb=0 sd=0 mult=1 m=1
XMP1_late_0101 rbl_late_0101 ref_late_0101 vp_late_0101 vdd sky130_fd_pr__pfet_01v8 L=0.15 W=2 nf=1 ad=0.58 as=0.58 pd=4.58 ps=4.58 nrd=0.145 nrs=0.145 sa=0 sb=0 sd=0 mult=1 m=1
XMP2_late_0101 ref_late_0101 rbl_late_0101 vp_late_0101 vdd sky130_fd_pr__pfet_01v8 L=0.15 W=2 nf=1 ad=0.58 as=0.58 pd=4.58 ps=4.58 nrd=0.145 nrs=0.145 sa=0 sb=0 sd=0 mult=1 m=1
XMNF_late_0101 vn_late_0101 en_late 0 0 sky130_fd_pr__nfet_01v8 L=0.15 W=2 nf=1 ad=0.58 as=0.58 pd=4.58 ps=4.58 nrd=0.145 nrs=0.145 sa=0 sb=0 sd=0 mult=1 m=1
XMPH_late_0101 vp_late_0101 enb_late vdd vdd sky130_fd_pr__pfet_01v8 L=0.15 W=4 nf=1 ad=1.16 as=1.16 pd=8.58 ps=8.58 nrd=0.0725 nrs=0.0725 sa=0 sb=0 sd=0 mult=1 m=1
bd_late_0101 d_late_0101 0 v=v(rbl_late_0101)-v(ref_late_0101)

* ---- instance 16: nowb_1111 (control_missing_writeback) ----
sbi_nowb_1111 bld1111 wbl_nowb_1111 bpk_nowb 0 swwbl
swb_nowb_1111 ref_nowb_1111 wbl_nowb_1111 wbc_nowb 0 swwbl
cwbl_nowb_1111 wbl_nowb_1111 0 {C_WBL}
spa_nowb_1111 prea rbl_nowb_1111 ctl_nowb 0 swpre
spr_nowb_1111 pref ref_nowb_1111 ctl_nowb 0 swpre
crbl_nowb_1111 rbl_nowb_1111 0 {C_RBL}
cref_nowb_1111 ref_nowb_1111 0 {C_RBL}   $ ASSUMPTION: ideal matched dummy load
XMWR_nowb_1111_0 sn_nowb_1111_0 wl0_nowb wbl_nowb_1111 0 sky130_fd_pr__nfet_01v8 L=0.15 W=0.42 nf=1 ad=0.1974 as=0.1974 pd=1.78 ps=1.78 nrd=0.69047619047619  nrs=0.69047619047619 sa=0 sb=0 sd=0 mult=1 m=1
XMRD_nowb_1111_0 rbl_nowb_1111 sn_nowb_1111_0 rwls0_nowb 0 sky130_fd_pr__nfet_01v8 L=0.15 W=0.42 nf=1 ad=0.1974 as=0.1974 pd=1.78 ps=1.78 nrd=0.69047619047619  nrs=0.69047619047619 sa=0 sb=0 sd=0 mult=1 m=1
csn_nowb_1111_0 sn_nowb_1111_0 0 {C_SN}
XMWR_nowb_1111_1 sn_nowb_1111_1 wl1_nowb wbl_nowb_1111 0 sky130_fd_pr__nfet_01v8 L=0.15 W=0.42 nf=1 ad=0.1974 as=0.1974 pd=1.78 ps=1.78 nrd=0.69047619047619  nrs=0.69047619047619 sa=0 sb=0 sd=0 mult=1 m=1
XMRD_nowb_1111_1 rbl_nowb_1111 sn_nowb_1111_1 rwls1_nowb 0 sky130_fd_pr__nfet_01v8 L=0.15 W=0.42 nf=1 ad=0.1974 as=0.1974 pd=1.78 ps=1.78 nrd=0.69047619047619  nrs=0.69047619047619 sa=0 sb=0 sd=0 mult=1 m=1
csn_nowb_1111_1 sn_nowb_1111_1 0 {C_SN}
XMWR_nowb_1111_2 sn_nowb_1111_2 wl2_nowb wbl_nowb_1111 0 sky130_fd_pr__nfet_01v8 L=0.15 W=0.42 nf=1 ad=0.1974 as=0.1974 pd=1.78 ps=1.78 nrd=0.69047619047619  nrs=0.69047619047619 sa=0 sb=0 sd=0 mult=1 m=1
XMRD_nowb_1111_2 rbl_nowb_1111 sn_nowb_1111_2 rwls2_nowb 0 sky130_fd_pr__nfet_01v8 L=0.15 W=0.42 nf=1 ad=0.1974 as=0.1974 pd=1.78 ps=1.78 nrd=0.69047619047619  nrs=0.69047619047619 sa=0 sb=0 sd=0 mult=1 m=1
csn_nowb_1111_2 sn_nowb_1111_2 0 {C_SN}
XMWR_nowb_1111_3 sn_nowb_1111_3 wl3_nowb wbl_nowb_1111 0 sky130_fd_pr__nfet_01v8 L=0.15 W=0.42 nf=1 ad=0.1974 as=0.1974 pd=1.78 ps=1.78 nrd=0.69047619047619  nrs=0.69047619047619 sa=0 sb=0 sd=0 mult=1 m=1
XMRD_nowb_1111_3 rbl_nowb_1111 sn_nowb_1111_3 rwls3_nowb 0 sky130_fd_pr__nfet_01v8 L=0.15 W=0.42 nf=1 ad=0.1974 as=0.1974 pd=1.78 ps=1.78 nrd=0.69047619047619  nrs=0.69047619047619 sa=0 sb=0 sd=0 mult=1 m=1
csn_nowb_1111_3 sn_nowb_1111_3 0 {C_SN}
XMN1_nowb_1111 rbl_nowb_1111 ref_nowb_1111 vn_nowb_1111 0 sky130_fd_pr__nfet_01v8 L=0.15 W=1 nf=1 ad=0.29 as=0.29 pd=2.58 ps=2.58 nrd=0.29 nrs=0.29 sa=0 sb=0 sd=0 mult=1 m=1
XMN2_nowb_1111 ref_nowb_1111 rbl_nowb_1111 vn_nowb_1111 0 sky130_fd_pr__nfet_01v8 L=0.15 W=1 nf=1 ad=0.29 as=0.29 pd=2.58 ps=2.58 nrd=0.29 nrs=0.29 sa=0 sb=0 sd=0 mult=1 m=1
XMP1_nowb_1111 rbl_nowb_1111 ref_nowb_1111 vp_nowb_1111 vdd sky130_fd_pr__pfet_01v8 L=0.15 W=2 nf=1 ad=0.58 as=0.58 pd=4.58 ps=4.58 nrd=0.145 nrs=0.145 sa=0 sb=0 sd=0 mult=1 m=1
XMP2_nowb_1111 ref_nowb_1111 rbl_nowb_1111 vp_nowb_1111 vdd sky130_fd_pr__pfet_01v8 L=0.15 W=2 nf=1 ad=0.58 as=0.58 pd=4.58 ps=4.58 nrd=0.145 nrs=0.145 sa=0 sb=0 sd=0 mult=1 m=1
XMNF_nowb_1111 vn_nowb_1111 en_nowb 0 0 sky130_fd_pr__nfet_01v8 L=0.15 W=2 nf=1 ad=0.58 as=0.58 pd=4.58 ps=4.58 nrd=0.145 nrs=0.145 sa=0 sb=0 sd=0 mult=1 m=1
XMPH_nowb_1111 vp_nowb_1111 enb_nowb vdd vdd sky130_fd_pr__pfet_01v8 L=0.15 W=4 nf=1 ad=1.16 as=1.16 pd=8.58 ps=8.58 nrd=0.0725 nrs=0.0725 sa=0 sb=0 sd=0 mult=1 m=1
bd_nowb_1111 d_nowb_1111 0 v=v(rbl_nowb_1111)-v(ref_nowb_1111)

* ---- instance 17: nowb_1010 (control_missing_writeback) ----
sbi_nowb_1010 bld1010 wbl_nowb_1010 bpk_nowb 0 swwbl
swb_nowb_1010 ref_nowb_1010 wbl_nowb_1010 wbc_nowb 0 swwbl
cwbl_nowb_1010 wbl_nowb_1010 0 {C_WBL}
spa_nowb_1010 prea rbl_nowb_1010 ctl_nowb 0 swpre
spr_nowb_1010 pref ref_nowb_1010 ctl_nowb 0 swpre
crbl_nowb_1010 rbl_nowb_1010 0 {C_RBL}
cref_nowb_1010 ref_nowb_1010 0 {C_RBL}   $ ASSUMPTION: ideal matched dummy load
XMWR_nowb_1010_0 sn_nowb_1010_0 wl0_nowb wbl_nowb_1010 0 sky130_fd_pr__nfet_01v8 L=0.15 W=0.42 nf=1 ad=0.1974 as=0.1974 pd=1.78 ps=1.78 nrd=0.69047619047619  nrs=0.69047619047619 sa=0 sb=0 sd=0 mult=1 m=1
XMRD_nowb_1010_0 rbl_nowb_1010 sn_nowb_1010_0 rwls0_nowb 0 sky130_fd_pr__nfet_01v8 L=0.15 W=0.42 nf=1 ad=0.1974 as=0.1974 pd=1.78 ps=1.78 nrd=0.69047619047619  nrs=0.69047619047619 sa=0 sb=0 sd=0 mult=1 m=1
csn_nowb_1010_0 sn_nowb_1010_0 0 {C_SN}
XMWR_nowb_1010_1 sn_nowb_1010_1 wl1_nowb wbl_nowb_1010 0 sky130_fd_pr__nfet_01v8 L=0.15 W=0.42 nf=1 ad=0.1974 as=0.1974 pd=1.78 ps=1.78 nrd=0.69047619047619  nrs=0.69047619047619 sa=0 sb=0 sd=0 mult=1 m=1
XMRD_nowb_1010_1 rbl_nowb_1010 sn_nowb_1010_1 rwls1_nowb 0 sky130_fd_pr__nfet_01v8 L=0.15 W=0.42 nf=1 ad=0.1974 as=0.1974 pd=1.78 ps=1.78 nrd=0.69047619047619  nrs=0.69047619047619 sa=0 sb=0 sd=0 mult=1 m=1
csn_nowb_1010_1 sn_nowb_1010_1 0 {C_SN}
XMWR_nowb_1010_2 sn_nowb_1010_2 wl2_nowb wbl_nowb_1010 0 sky130_fd_pr__nfet_01v8 L=0.15 W=0.42 nf=1 ad=0.1974 as=0.1974 pd=1.78 ps=1.78 nrd=0.69047619047619  nrs=0.69047619047619 sa=0 sb=0 sd=0 mult=1 m=1
XMRD_nowb_1010_2 rbl_nowb_1010 sn_nowb_1010_2 rwls2_nowb 0 sky130_fd_pr__nfet_01v8 L=0.15 W=0.42 nf=1 ad=0.1974 as=0.1974 pd=1.78 ps=1.78 nrd=0.69047619047619  nrs=0.69047619047619 sa=0 sb=0 sd=0 mult=1 m=1
csn_nowb_1010_2 sn_nowb_1010_2 0 {C_SN}
XMWR_nowb_1010_3 sn_nowb_1010_3 wl3_nowb wbl_nowb_1010 0 sky130_fd_pr__nfet_01v8 L=0.15 W=0.42 nf=1 ad=0.1974 as=0.1974 pd=1.78 ps=1.78 nrd=0.69047619047619  nrs=0.69047619047619 sa=0 sb=0 sd=0 mult=1 m=1
XMRD_nowb_1010_3 rbl_nowb_1010 sn_nowb_1010_3 rwls3_nowb 0 sky130_fd_pr__nfet_01v8 L=0.15 W=0.42 nf=1 ad=0.1974 as=0.1974 pd=1.78 ps=1.78 nrd=0.69047619047619  nrs=0.69047619047619 sa=0 sb=0 sd=0 mult=1 m=1
csn_nowb_1010_3 sn_nowb_1010_3 0 {C_SN}
XMN1_nowb_1010 rbl_nowb_1010 ref_nowb_1010 vn_nowb_1010 0 sky130_fd_pr__nfet_01v8 L=0.15 W=1 nf=1 ad=0.29 as=0.29 pd=2.58 ps=2.58 nrd=0.29 nrs=0.29 sa=0 sb=0 sd=0 mult=1 m=1
XMN2_nowb_1010 ref_nowb_1010 rbl_nowb_1010 vn_nowb_1010 0 sky130_fd_pr__nfet_01v8 L=0.15 W=1 nf=1 ad=0.29 as=0.29 pd=2.58 ps=2.58 nrd=0.29 nrs=0.29 sa=0 sb=0 sd=0 mult=1 m=1
XMP1_nowb_1010 rbl_nowb_1010 ref_nowb_1010 vp_nowb_1010 vdd sky130_fd_pr__pfet_01v8 L=0.15 W=2 nf=1 ad=0.58 as=0.58 pd=4.58 ps=4.58 nrd=0.145 nrs=0.145 sa=0 sb=0 sd=0 mult=1 m=1
XMP2_nowb_1010 ref_nowb_1010 rbl_nowb_1010 vp_nowb_1010 vdd sky130_fd_pr__pfet_01v8 L=0.15 W=2 nf=1 ad=0.58 as=0.58 pd=4.58 ps=4.58 nrd=0.145 nrs=0.145 sa=0 sb=0 sd=0 mult=1 m=1
XMNF_nowb_1010 vn_nowb_1010 en_nowb 0 0 sky130_fd_pr__nfet_01v8 L=0.15 W=2 nf=1 ad=0.58 as=0.58 pd=4.58 ps=4.58 nrd=0.145 nrs=0.145 sa=0 sb=0 sd=0 mult=1 m=1
XMPH_nowb_1010 vp_nowb_1010 enb_nowb vdd vdd sky130_fd_pr__pfet_01v8 L=0.15 W=4 nf=1 ad=1.16 as=1.16 pd=8.58 ps=8.58 nrd=0.0725 nrs=0.0725 sa=0 sb=0 sd=0 mult=1 m=1
bd_nowb_1010 d_nowb_1010 0 v=v(rbl_nowb_1010)-v(ref_nowb_1010)

* initial conditions (tran uic): precharged rails, cells at the opposite of their data, latch tail nodes.
* They apply ONLY at t = 0 (before the initial write); nothing is reset between refresh cycles.
.ic v(wbl_ana_1111)=0 v(rbl_ana_1111)=0.9 v(ref_ana_1111)=0.8 v(sn_ana_1111_0)=0 v(sn_ana_1111_1)=0 v(sn_ana_1111_2)=0
.ic v(sn_ana_1111_3)=0 v(vn_ana_1111)=0.45 v(vp_ana_1111)=1.35 v(wbl_ana_0000)=0 v(rbl_ana_0000)=0.9 v(ref_ana_0000)=0.8
.ic v(sn_ana_0000_0)=1.8 v(sn_ana_0000_1)=1.8 v(sn_ana_0000_2)=1.8 v(sn_ana_0000_3)=1.8 v(vn_ana_0000)=0.45 v(vp_ana_0000)=1.35
.ic v(wbl_ana_1000)=0 v(rbl_ana_1000)=0.9 v(ref_ana_1000)=0.8 v(sn_ana_1000_0)=0 v(sn_ana_1000_1)=1.8 v(sn_ana_1000_2)=1.8
.ic v(sn_ana_1000_3)=1.8 v(vn_ana_1000)=0.45 v(vp_ana_1000)=1.35 v(wbl_ana_0111)=0 v(rbl_ana_0111)=0.9 v(ref_ana_0111)=0.8
.ic v(sn_ana_0111_0)=1.8 v(sn_ana_0111_1)=0 v(sn_ana_0111_2)=0 v(sn_ana_0111_3)=0 v(vn_ana_0111)=0.45 v(vp_ana_0111)=1.35
.ic v(wbl_ana_1010)=0 v(rbl_ana_1010)=0.9 v(ref_ana_1010)=0.8 v(sn_ana_1010_0)=0 v(sn_ana_1010_1)=1.8 v(sn_ana_1010_2)=0
.ic v(sn_ana_1010_3)=1.8 v(vn_ana_1010)=0.45 v(vp_ana_1010)=1.35 v(wbl_ana_0101)=0 v(rbl_ana_0101)=0.9 v(ref_ana_0101)=0.8
.ic v(sn_ana_0101_0)=1.8 v(sn_ana_0101_1)=0 v(sn_ana_0101_2)=1.8 v(sn_ana_0101_3)=0 v(vn_ana_0101)=0.45 v(vp_ana_0101)=1.35
.ic v(wbl_ana_1101)=0 v(rbl_ana_1101)=0.9 v(ref_ana_1101)=0.8 v(sn_ana_1101_0)=0 v(sn_ana_1101_1)=0 v(sn_ana_1101_2)=1.8
.ic v(sn_ana_1101_3)=0 v(vn_ana_1101)=0.45 v(vp_ana_1101)=1.35 v(wbl_ana_0010)=0 v(rbl_ana_0010)=0.9 v(ref_ana_0010)=0.8
.ic v(sn_ana_0010_0)=1.8 v(sn_ana_0010_1)=1.8 v(sn_ana_0010_2)=0 v(sn_ana_0010_3)=1.8 v(vn_ana_0010)=0.45 v(vp_ana_0010)=1.35
.ic v(wbl_rtl_1111)=0 v(rbl_rtl_1111)=0.9 v(ref_rtl_1111)=0.8 v(sn_rtl_1111_0)=0 v(sn_rtl_1111_1)=0 v(sn_rtl_1111_2)=0
.ic v(sn_rtl_1111_3)=0 v(vn_rtl_1111)=0.45 v(vp_rtl_1111)=1.35 v(wbl_rtl_0000)=0 v(rbl_rtl_0000)=0.9 v(ref_rtl_0000)=0.8
.ic v(sn_rtl_0000_0)=1.8 v(sn_rtl_0000_1)=1.8 v(sn_rtl_0000_2)=1.8 v(sn_rtl_0000_3)=1.8 v(vn_rtl_0000)=0.45 v(vp_rtl_0000)=1.35
.ic v(wbl_rtl_1010)=0 v(rbl_rtl_1010)=0.9 v(ref_rtl_1010)=0.8 v(sn_rtl_1010_0)=0 v(sn_rtl_1010_1)=1.8 v(sn_rtl_1010_2)=0
.ic v(sn_rtl_1010_3)=1.8 v(vn_rtl_1010)=0.45 v(vp_rtl_1010)=1.35 v(wbl_rtl_0101)=0 v(rbl_rtl_0101)=0.9 v(ref_rtl_0101)=0.8
.ic v(sn_rtl_0101_0)=1.8 v(sn_rtl_0101_1)=0 v(sn_rtl_0101_2)=1.8 v(sn_rtl_0101_3)=0 v(vn_rtl_0101)=0.45 v(vp_rtl_0101)=1.35
.ic v(wbl_late_1111)=0 v(rbl_late_1111)=0.9 v(ref_late_1111)=0.8 v(sn_late_1111_0)=0 v(sn_late_1111_1)=0 v(sn_late_1111_2)=0
.ic v(sn_late_1111_3)=0 v(vn_late_1111)=0.45 v(vp_late_1111)=1.35 v(wbl_late_0000)=0 v(rbl_late_0000)=0.9 v(ref_late_0000)=0.8
.ic v(sn_late_0000_0)=1.8 v(sn_late_0000_1)=1.8 v(sn_late_0000_2)=1.8 v(sn_late_0000_3)=1.8 v(vn_late_0000)=0.45 v(vp_late_0000)=1.35
.ic v(wbl_late_1010)=0 v(rbl_late_1010)=0.9 v(ref_late_1010)=0.8 v(sn_late_1010_0)=0 v(sn_late_1010_1)=1.8 v(sn_late_1010_2)=0
.ic v(sn_late_1010_3)=1.8 v(vn_late_1010)=0.45 v(vp_late_1010)=1.35 v(wbl_late_0101)=0 v(rbl_late_0101)=0.9 v(ref_late_0101)=0.8
.ic v(sn_late_0101_0)=1.8 v(sn_late_0101_1)=0 v(sn_late_0101_2)=1.8 v(sn_late_0101_3)=0 v(vn_late_0101)=0.45 v(vp_late_0101)=1.35
.ic v(wbl_nowb_1111)=0 v(rbl_nowb_1111)=0.9 v(ref_nowb_1111)=0.8 v(sn_nowb_1111_0)=0 v(sn_nowb_1111_1)=0 v(sn_nowb_1111_2)=0
.ic v(sn_nowb_1111_3)=0 v(vn_nowb_1111)=0.45 v(vp_nowb_1111)=1.35 v(wbl_nowb_1010)=0 v(rbl_nowb_1010)=0.9 v(ref_nowb_1010)=0.8
.ic v(sn_nowb_1010_0)=0 v(sn_nowb_1010_1)=1.8 v(sn_nowb_1010_2)=0 v(sn_nowb_1010_3)=1.8 v(vn_nowb_1010)=0.45 v(vp_nowb_1010)=1.35
