* closed_loop_d60000.spice -- repeated closed-loop refresh, dwell 60000 ns x 2 cycles (EXCESSIVE-DWELL control (12x the ratified bound)), issue #147
* GENERATED by gen_closed_loop.py; do not edit by hand.
*
* PROPOSED/UNRATIFIED SCOPE: 27 C and 125 C, tt/ss/ff/sf/fs, VDD 1.8 V (spec/operating-range-decision-PROPOSED.md).
* One continuous transient per instance: 4 rows written ONCE through M_WR (each cell starting at the opposite of its
* data), then closed-loop refresh of every row each dwell: precharge -> select -> latch enable -> latch COMPLEMENT
* node drives WBL -> WWL pulse. No .ic reset and no ideal expected-data source after the initial write; the actual
* latch decision is written back and carried into the next cycle. Instance name <waveform>_<row0..row3 data>.
* Waveforms: ana = sim/refresh-op analog baseline; rtl = UNCHANGED phase-sequencer strobes + latch-hold adapter;
* late = EXPERIMENTAL UNAPPROVED rtl with RWL released after WWL fall; nowb = ana with write-back WWL pulses deleted.
*
* ASSUMPTIONS (labelled, none is a spec value): ideal drivers and 100 ohm switches, C_WBL = 10 fF (not extracted),
* ideal matched dummy reference load, VREF = VRBL - 100 mV, 4-row column, C_RBL = extracted 4-row worst net,
* C_SN = extracted array MINIMUM wiring C, global corners only, NO mismatch, no device-level column/row driver.

.options method=trap gmin=1e-15 abstol=1e-15 chgtol=1e-18
.param VDD   = 1.8
.param VRBL  = 0.9
.param C_RBL = 9.55559e-16   $ extracted_4row_worst_total_ff, layout/gain_cell_2t_array.parasitics.summary.json
.param C_WBL = 1e-14   $ ASSUMPTION (not extracted)
.param C_SN  = 5.38402e-16   $ comparison.c_sn.array_min_total_ff (wiring only; array-context, issue #89)
vdd   vdd 0 dc {VDD}
vprea prea 0 dc {VRBL}
vpref pref 0 dc 0.8
vrwld rwl_des 0 dc {VDD}
.model swpre sw(vt=0.9 vh=0.1 ron=100 roff=1e12)
.model swwbl sw(vt=0.9 vh=0.1 ron=100 roff=1e12)

* ---- shared control sources, waveform ana (source variant baseline_analog, write-back True) ----
vctl_ana ctl_ana 0 pwl(0 {VDD} 6.00191e-05 {VDD} 6.00192e-05 0 6.00551e-05 0 6.00552e-05 {VDD} 6.00591e-05 {VDD} 6.00592e-05 0 6.00951e-05 0 6.00952e-05 {VDD} 6.00991e-05 {VDD} 6.00992e-05 0 6.01351e-05 0 6.01352e-05 {VDD} 6.01391e-05 {VDD} 6.01392e-05 0 6.01751e-05 0 6.01752e-05 {VDD} 0.0001200191 {VDD} 0.0001200192 0 0.0001200551 0 0.0001200552 {VDD} 0.0001200591 {VDD} 0.0001200592 0 0.0001200951 0 0.0001200952 {VDD} 0.0001200991 {VDD} 0.0001200992 0 0.0001201351 0 0.0001201352 {VDD} 0.0001201391 {VDD} 0.0001201392 0 0.0001201751 0 0.0001201752 {VDD})
ven_ana en_ana 0 pwl(0 0 6.00311e-05 0 6.00312e-05 {VDD} 6.00541e-05 {VDD} 6.00542e-05 0 6.00711e-05 0 6.00712e-05 {VDD} 6.00941e-05 {VDD} 6.00942e-05 0 6.01111e-05 0 6.01112e-05 {VDD} 6.01341e-05 {VDD} 6.01342e-05 0 6.01511e-05 0 6.01512e-05 {VDD} 6.01741e-05 {VDD} 6.01742e-05 0 0.0001200311 0 0.0001200312 {VDD} 0.0001200541 {VDD} 0.0001200542 0 0.0001200711 0 0.0001200712 {VDD} 0.0001200941 {VDD} 0.0001200942 0 0.0001201111 0 0.0001201112 {VDD} 0.0001201341 {VDD} 0.0001201342 0 0.0001201511 0 0.0001201512 {VDD} 0.0001201741 {VDD} 0.0001201742 0)
venb_ana enb_ana 0 pwl(0 {VDD} 6.00311e-05 {VDD} 6.00312e-05 0 6.00541e-05 0 6.00542e-05 {VDD} 6.00711e-05 {VDD} 6.00712e-05 0 6.00941e-05 0 6.00942e-05 {VDD} 6.01111e-05 {VDD} 6.01112e-05 0 6.01341e-05 0 6.01342e-05 {VDD} 6.01511e-05 {VDD} 6.01512e-05 0 6.01741e-05 0 6.01742e-05 {VDD} 0.0001200311 {VDD} 0.0001200312 0 0.0001200541 0 0.0001200542 {VDD} 0.0001200711 {VDD} 0.0001200712 0 0.0001200941 0 0.0001200942 {VDD} 0.0001201111 {VDD} 0.0001201112 0 0.0001201341 0 0.0001201342 {VDD} 0.0001201511 {VDD} 0.0001201512 0 0.0001201741 0 0.0001201742 {VDD})
vwbc_ana wbc_ana 0 pwl(0 0 6.00321e-05 0 6.00322e-05 {VDD} 6.00541e-05 {VDD} 6.00542e-05 0 6.00721e-05 0 6.00722e-05 {VDD} 6.00941e-05 {VDD} 6.00942e-05 0 6.01121e-05 0 6.01122e-05 {VDD} 6.01341e-05 {VDD} 6.01342e-05 0 6.01521e-05 0 6.01522e-05 {VDD} 6.01741e-05 {VDD} 6.01742e-05 0 0.0001200321 0 0.0001200322 {VDD} 0.0001200541 {VDD} 0.0001200542 0 0.0001200721 0 0.0001200722 {VDD} 0.0001200941 {VDD} 0.0001200942 0 0.0001201121 0 0.0001201122 {VDD} 0.0001201341 {VDD} 0.0001201342 0 0.0001201521 0 0.0001201522 {VDD} 0.0001201741 {VDD} 0.0001201742 0)
vbpk_ana bpk_ana 0 pwl(0 {VDD} 6.00321e-05 {VDD} 6.00322e-05 0 6.00541e-05 0 6.00542e-05 {VDD} 6.00721e-05 {VDD} 6.00722e-05 0 6.00941e-05 0 6.00942e-05 {VDD} 6.01121e-05 {VDD} 6.01122e-05 0 6.01341e-05 0 6.01342e-05 {VDD} 6.01521e-05 {VDD} 6.01522e-05 0 6.01741e-05 0 6.01742e-05 {VDD} 0.0001200321 {VDD} 0.0001200322 0 0.0001200541 0 0.0001200542 {VDD} 0.0001200721 {VDD} 0.0001200722 0 0.0001200941 0 0.0001200942 {VDD} 0.0001201121 {VDD} 0.0001201122 0 0.0001201341 0 0.0001201342 {VDD} 0.0001201521 {VDD} 0.0001201522 0 0.0001201741 0 0.0001201742 {VDD})   $ ideal initial-write/park driver connected except during write-back
vrws0_ana rwls0_ana 0 pwl(0 {VDD} 6.00211e-05 {VDD} 6.00212e-05 0 6.00541e-05 0 6.00542e-05 {VDD} 0.0001200211 {VDD} 0.0001200212 0 0.0001200541 0 0.0001200542 {VDD})
vwl0_ana wl0_ana 0 pwl(0 0 1e-09 0 1.1e-09 {VDD} 2.1e-08 {VDD} 2.11e-08 0 6.00321e-05 0 6.00322e-05 {VDD} 6.00521e-05 {VDD} 6.00522e-05 0 0.0001200321 0 0.0001200322 {VDD} 0.0001200521 {VDD} 0.0001200522 0)
vrws1_ana rwls1_ana 0 pwl(0 {VDD} 6.00611e-05 {VDD} 6.00612e-05 0 6.00941e-05 0 6.00942e-05 {VDD} 0.0001200611 {VDD} 0.0001200612 0 0.0001200941 0 0.0001200942 {VDD})
vwl1_ana wl1_ana 0 pwl(0 0 4.1e-08 0 4.11e-08 {VDD} 6.1e-08 {VDD} 6.11e-08 0 6.00721e-05 0 6.00722e-05 {VDD} 6.00921e-05 {VDD} 6.00922e-05 0 0.0001200721 0 0.0001200722 {VDD} 0.0001200921 {VDD} 0.0001200922 0)
vrws2_ana rwls2_ana 0 pwl(0 {VDD} 6.01011e-05 {VDD} 6.01012e-05 0 6.01341e-05 0 6.01342e-05 {VDD} 0.0001201011 {VDD} 0.0001201012 0 0.0001201341 0 0.0001201342 {VDD})
vwl2_ana wl2_ana 0 pwl(0 0 8.1e-08 0 8.11e-08 {VDD} 1.01e-07 {VDD} 1.011e-07 0 6.01121e-05 0 6.01122e-05 {VDD} 6.01321e-05 {VDD} 6.01322e-05 0 0.0001201121 0 0.0001201122 {VDD} 0.0001201321 {VDD} 0.0001201322 0)
vrws3_ana rwls3_ana 0 pwl(0 {VDD} 6.01411e-05 {VDD} 6.01412e-05 0 6.01741e-05 0 6.01742e-05 {VDD} 0.0001201411 {VDD} 0.0001201412 0 0.0001201741 0 0.0001201742 {VDD})
vwl3_ana wl3_ana 0 pwl(0 0 1.21e-07 0 1.211e-07 {VDD} 1.41e-07 {VDD} 1.411e-07 0 6.01521e-05 0 6.01522e-05 {VDD} 6.01721e-05 {VDD} 6.01722e-05 0 0.0001201521 0 0.0001201522 {VDD} 0.0001201721 {VDD} 0.0001201722 0)
vbld0000 bld0000 0 pwl(0 0)
vbld1010 bld1010 0 pwl(0 0 5e-10 0 6e-10 {VDD} 2.31e-08 {VDD} 2.32e-08 0 8.05e-08 0 8.06e-08 {VDD} 1.031e-07 {VDD} 1.032e-07 0)
vbld1111 bld1111 0 pwl(0 0 5e-10 0 6e-10 {VDD} 2.31e-08 {VDD} 2.32e-08 0 4.05e-08 0 4.06e-08 {VDD} 6.31e-08 {VDD} 6.32e-08 0 8.05e-08 0 8.06e-08 {VDD} 1.031e-07 {VDD} 1.032e-07 0 1.205e-07 0 1.206e-07 {VDD} 1.431e-07 {VDD} 1.432e-07 0)

* ---- instance 0: ana_1111 (control_excessive_dwell) ----
sbi_ana_1111 bld1111 wbl_ana_1111 bpk_ana 0 swwbl
swb_ana_1111 ref_ana_1111 wbl_ana_1111 wbc_ana 0 swwbl
cwbl_ana_1111 wbl_ana_1111 0 {C_WBL}
spa_ana_1111 prea rbl_ana_1111 ctl_ana 0 swpre
spr_ana_1111 pref ref_ana_1111 ctl_ana 0 swpre
crbl_ana_1111 rbl_ana_1111 0 {C_RBL}
cref_ana_1111 ref_ana_1111 0 {C_RBL}   $ ASSUMPTION: ideal matched dummy load
XMWR_ana_1111_0 sn_ana_1111_0 wl0_ana wbl_ana_1111 0 sky130_fd_pr__nfet_01v8 L=0.15 W=0.42 nf=1 ad=0.1974 as=0.1974 pd=1.78 ps=1.78 nrd=0.69047619047619  nrs=0.69047619047619 sa=0 sb=0 sd=0 mult=1 m=1
XMRD_ana_1111_0 rbl_ana_1111 sn_ana_1111_0 rwls0_ana 0 sky130_fd_pr__nfet_01v8 L=0.15 W=0.42 nf=1 ad=0.1974 as=0.1974 pd=1.78 ps=1.78 nrd=0.69047619047619  nrs=0.69047619047619 sa=0 sb=0 sd=0 mult=1 m=1
csn_ana_1111_0 sn_ana_1111_0 0 {C_SN}
XMWR_ana_1111_1 sn_ana_1111_1 wl1_ana wbl_ana_1111 0 sky130_fd_pr__nfet_01v8 L=0.15 W=0.42 nf=1 ad=0.1974 as=0.1974 pd=1.78 ps=1.78 nrd=0.69047619047619  nrs=0.69047619047619 sa=0 sb=0 sd=0 mult=1 m=1
XMRD_ana_1111_1 rbl_ana_1111 sn_ana_1111_1 rwls1_ana 0 sky130_fd_pr__nfet_01v8 L=0.15 W=0.42 nf=1 ad=0.1974 as=0.1974 pd=1.78 ps=1.78 nrd=0.69047619047619  nrs=0.69047619047619 sa=0 sb=0 sd=0 mult=1 m=1
csn_ana_1111_1 sn_ana_1111_1 0 {C_SN}
XMWR_ana_1111_2 sn_ana_1111_2 wl2_ana wbl_ana_1111 0 sky130_fd_pr__nfet_01v8 L=0.15 W=0.42 nf=1 ad=0.1974 as=0.1974 pd=1.78 ps=1.78 nrd=0.69047619047619  nrs=0.69047619047619 sa=0 sb=0 sd=0 mult=1 m=1
XMRD_ana_1111_2 rbl_ana_1111 sn_ana_1111_2 rwls2_ana 0 sky130_fd_pr__nfet_01v8 L=0.15 W=0.42 nf=1 ad=0.1974 as=0.1974 pd=1.78 ps=1.78 nrd=0.69047619047619  nrs=0.69047619047619 sa=0 sb=0 sd=0 mult=1 m=1
csn_ana_1111_2 sn_ana_1111_2 0 {C_SN}
XMWR_ana_1111_3 sn_ana_1111_3 wl3_ana wbl_ana_1111 0 sky130_fd_pr__nfet_01v8 L=0.15 W=0.42 nf=1 ad=0.1974 as=0.1974 pd=1.78 ps=1.78 nrd=0.69047619047619  nrs=0.69047619047619 sa=0 sb=0 sd=0 mult=1 m=1
XMRD_ana_1111_3 rbl_ana_1111 sn_ana_1111_3 rwls3_ana 0 sky130_fd_pr__nfet_01v8 L=0.15 W=0.42 nf=1 ad=0.1974 as=0.1974 pd=1.78 ps=1.78 nrd=0.69047619047619  nrs=0.69047619047619 sa=0 sb=0 sd=0 mult=1 m=1
csn_ana_1111_3 sn_ana_1111_3 0 {C_SN}
XMN1_ana_1111 rbl_ana_1111 ref_ana_1111 vn_ana_1111 0 sky130_fd_pr__nfet_01v8 L=0.15 W=1 nf=1 ad=0.29 as=0.29 pd=2.58 ps=2.58 nrd=0.29 nrs=0.29 sa=0 sb=0 sd=0 mult=1 m=1
XMN2_ana_1111 ref_ana_1111 rbl_ana_1111 vn_ana_1111 0 sky130_fd_pr__nfet_01v8 L=0.15 W=1 nf=1 ad=0.29 as=0.29 pd=2.58 ps=2.58 nrd=0.29 nrs=0.29 sa=0 sb=0 sd=0 mult=1 m=1
XMP1_ana_1111 rbl_ana_1111 ref_ana_1111 vp_ana_1111 vdd sky130_fd_pr__pfet_01v8 L=0.15 W=2 nf=1 ad=0.58 as=0.58 pd=4.58 ps=4.58 nrd=0.145 nrs=0.145 sa=0 sb=0 sd=0 mult=1 m=1
XMP2_ana_1111 ref_ana_1111 rbl_ana_1111 vp_ana_1111 vdd sky130_fd_pr__pfet_01v8 L=0.15 W=2 nf=1 ad=0.58 as=0.58 pd=4.58 ps=4.58 nrd=0.145 nrs=0.145 sa=0 sb=0 sd=0 mult=1 m=1
XMNF_ana_1111 vn_ana_1111 en_ana 0 0 sky130_fd_pr__nfet_01v8 L=0.15 W=2 nf=1 ad=0.58 as=0.58 pd=4.58 ps=4.58 nrd=0.145 nrs=0.145 sa=0 sb=0 sd=0 mult=1 m=1
XMPH_ana_1111 vp_ana_1111 enb_ana vdd vdd sky130_fd_pr__pfet_01v8 L=0.15 W=4 nf=1 ad=1.16 as=1.16 pd=8.58 ps=8.58 nrd=0.0725 nrs=0.0725 sa=0 sb=0 sd=0 mult=1 m=1
bd_ana_1111 d_ana_1111 0 v=v(rbl_ana_1111)-v(ref_ana_1111)

* ---- instance 1: ana_1010 (control_excessive_dwell) ----
sbi_ana_1010 bld1010 wbl_ana_1010 bpk_ana 0 swwbl
swb_ana_1010 ref_ana_1010 wbl_ana_1010 wbc_ana 0 swwbl
cwbl_ana_1010 wbl_ana_1010 0 {C_WBL}
spa_ana_1010 prea rbl_ana_1010 ctl_ana 0 swpre
spr_ana_1010 pref ref_ana_1010 ctl_ana 0 swpre
crbl_ana_1010 rbl_ana_1010 0 {C_RBL}
cref_ana_1010 ref_ana_1010 0 {C_RBL}   $ ASSUMPTION: ideal matched dummy load
XMWR_ana_1010_0 sn_ana_1010_0 wl0_ana wbl_ana_1010 0 sky130_fd_pr__nfet_01v8 L=0.15 W=0.42 nf=1 ad=0.1974 as=0.1974 pd=1.78 ps=1.78 nrd=0.69047619047619  nrs=0.69047619047619 sa=0 sb=0 sd=0 mult=1 m=1
XMRD_ana_1010_0 rbl_ana_1010 sn_ana_1010_0 rwls0_ana 0 sky130_fd_pr__nfet_01v8 L=0.15 W=0.42 nf=1 ad=0.1974 as=0.1974 pd=1.78 ps=1.78 nrd=0.69047619047619  nrs=0.69047619047619 sa=0 sb=0 sd=0 mult=1 m=1
csn_ana_1010_0 sn_ana_1010_0 0 {C_SN}
XMWR_ana_1010_1 sn_ana_1010_1 wl1_ana wbl_ana_1010 0 sky130_fd_pr__nfet_01v8 L=0.15 W=0.42 nf=1 ad=0.1974 as=0.1974 pd=1.78 ps=1.78 nrd=0.69047619047619  nrs=0.69047619047619 sa=0 sb=0 sd=0 mult=1 m=1
XMRD_ana_1010_1 rbl_ana_1010 sn_ana_1010_1 rwls1_ana 0 sky130_fd_pr__nfet_01v8 L=0.15 W=0.42 nf=1 ad=0.1974 as=0.1974 pd=1.78 ps=1.78 nrd=0.69047619047619  nrs=0.69047619047619 sa=0 sb=0 sd=0 mult=1 m=1
csn_ana_1010_1 sn_ana_1010_1 0 {C_SN}
XMWR_ana_1010_2 sn_ana_1010_2 wl2_ana wbl_ana_1010 0 sky130_fd_pr__nfet_01v8 L=0.15 W=0.42 nf=1 ad=0.1974 as=0.1974 pd=1.78 ps=1.78 nrd=0.69047619047619  nrs=0.69047619047619 sa=0 sb=0 sd=0 mult=1 m=1
XMRD_ana_1010_2 rbl_ana_1010 sn_ana_1010_2 rwls2_ana 0 sky130_fd_pr__nfet_01v8 L=0.15 W=0.42 nf=1 ad=0.1974 as=0.1974 pd=1.78 ps=1.78 nrd=0.69047619047619  nrs=0.69047619047619 sa=0 sb=0 sd=0 mult=1 m=1
csn_ana_1010_2 sn_ana_1010_2 0 {C_SN}
XMWR_ana_1010_3 sn_ana_1010_3 wl3_ana wbl_ana_1010 0 sky130_fd_pr__nfet_01v8 L=0.15 W=0.42 nf=1 ad=0.1974 as=0.1974 pd=1.78 ps=1.78 nrd=0.69047619047619  nrs=0.69047619047619 sa=0 sb=0 sd=0 mult=1 m=1
XMRD_ana_1010_3 rbl_ana_1010 sn_ana_1010_3 rwls3_ana 0 sky130_fd_pr__nfet_01v8 L=0.15 W=0.42 nf=1 ad=0.1974 as=0.1974 pd=1.78 ps=1.78 nrd=0.69047619047619  nrs=0.69047619047619 sa=0 sb=0 sd=0 mult=1 m=1
csn_ana_1010_3 sn_ana_1010_3 0 {C_SN}
XMN1_ana_1010 rbl_ana_1010 ref_ana_1010 vn_ana_1010 0 sky130_fd_pr__nfet_01v8 L=0.15 W=1 nf=1 ad=0.29 as=0.29 pd=2.58 ps=2.58 nrd=0.29 nrs=0.29 sa=0 sb=0 sd=0 mult=1 m=1
XMN2_ana_1010 ref_ana_1010 rbl_ana_1010 vn_ana_1010 0 sky130_fd_pr__nfet_01v8 L=0.15 W=1 nf=1 ad=0.29 as=0.29 pd=2.58 ps=2.58 nrd=0.29 nrs=0.29 sa=0 sb=0 sd=0 mult=1 m=1
XMP1_ana_1010 rbl_ana_1010 ref_ana_1010 vp_ana_1010 vdd sky130_fd_pr__pfet_01v8 L=0.15 W=2 nf=1 ad=0.58 as=0.58 pd=4.58 ps=4.58 nrd=0.145 nrs=0.145 sa=0 sb=0 sd=0 mult=1 m=1
XMP2_ana_1010 ref_ana_1010 rbl_ana_1010 vp_ana_1010 vdd sky130_fd_pr__pfet_01v8 L=0.15 W=2 nf=1 ad=0.58 as=0.58 pd=4.58 ps=4.58 nrd=0.145 nrs=0.145 sa=0 sb=0 sd=0 mult=1 m=1
XMNF_ana_1010 vn_ana_1010 en_ana 0 0 sky130_fd_pr__nfet_01v8 L=0.15 W=2 nf=1 ad=0.58 as=0.58 pd=4.58 ps=4.58 nrd=0.145 nrs=0.145 sa=0 sb=0 sd=0 mult=1 m=1
XMPH_ana_1010 vp_ana_1010 enb_ana vdd vdd sky130_fd_pr__pfet_01v8 L=0.15 W=4 nf=1 ad=1.16 as=1.16 pd=8.58 ps=8.58 nrd=0.0725 nrs=0.0725 sa=0 sb=0 sd=0 mult=1 m=1
bd_ana_1010 d_ana_1010 0 v=v(rbl_ana_1010)-v(ref_ana_1010)

* ---- instance 2: ana_0000 (control_excessive_dwell) ----
sbi_ana_0000 bld0000 wbl_ana_0000 bpk_ana 0 swwbl
swb_ana_0000 ref_ana_0000 wbl_ana_0000 wbc_ana 0 swwbl
cwbl_ana_0000 wbl_ana_0000 0 {C_WBL}
spa_ana_0000 prea rbl_ana_0000 ctl_ana 0 swpre
spr_ana_0000 pref ref_ana_0000 ctl_ana 0 swpre
crbl_ana_0000 rbl_ana_0000 0 {C_RBL}
cref_ana_0000 ref_ana_0000 0 {C_RBL}   $ ASSUMPTION: ideal matched dummy load
XMWR_ana_0000_0 sn_ana_0000_0 wl0_ana wbl_ana_0000 0 sky130_fd_pr__nfet_01v8 L=0.15 W=0.42 nf=1 ad=0.1974 as=0.1974 pd=1.78 ps=1.78 nrd=0.69047619047619  nrs=0.69047619047619 sa=0 sb=0 sd=0 mult=1 m=1
XMRD_ana_0000_0 rbl_ana_0000 sn_ana_0000_0 rwls0_ana 0 sky130_fd_pr__nfet_01v8 L=0.15 W=0.42 nf=1 ad=0.1974 as=0.1974 pd=1.78 ps=1.78 nrd=0.69047619047619  nrs=0.69047619047619 sa=0 sb=0 sd=0 mult=1 m=1
csn_ana_0000_0 sn_ana_0000_0 0 {C_SN}
XMWR_ana_0000_1 sn_ana_0000_1 wl1_ana wbl_ana_0000 0 sky130_fd_pr__nfet_01v8 L=0.15 W=0.42 nf=1 ad=0.1974 as=0.1974 pd=1.78 ps=1.78 nrd=0.69047619047619  nrs=0.69047619047619 sa=0 sb=0 sd=0 mult=1 m=1
XMRD_ana_0000_1 rbl_ana_0000 sn_ana_0000_1 rwls1_ana 0 sky130_fd_pr__nfet_01v8 L=0.15 W=0.42 nf=1 ad=0.1974 as=0.1974 pd=1.78 ps=1.78 nrd=0.69047619047619  nrs=0.69047619047619 sa=0 sb=0 sd=0 mult=1 m=1
csn_ana_0000_1 sn_ana_0000_1 0 {C_SN}
XMWR_ana_0000_2 sn_ana_0000_2 wl2_ana wbl_ana_0000 0 sky130_fd_pr__nfet_01v8 L=0.15 W=0.42 nf=1 ad=0.1974 as=0.1974 pd=1.78 ps=1.78 nrd=0.69047619047619  nrs=0.69047619047619 sa=0 sb=0 sd=0 mult=1 m=1
XMRD_ana_0000_2 rbl_ana_0000 sn_ana_0000_2 rwls2_ana 0 sky130_fd_pr__nfet_01v8 L=0.15 W=0.42 nf=1 ad=0.1974 as=0.1974 pd=1.78 ps=1.78 nrd=0.69047619047619  nrs=0.69047619047619 sa=0 sb=0 sd=0 mult=1 m=1
csn_ana_0000_2 sn_ana_0000_2 0 {C_SN}
XMWR_ana_0000_3 sn_ana_0000_3 wl3_ana wbl_ana_0000 0 sky130_fd_pr__nfet_01v8 L=0.15 W=0.42 nf=1 ad=0.1974 as=0.1974 pd=1.78 ps=1.78 nrd=0.69047619047619  nrs=0.69047619047619 sa=0 sb=0 sd=0 mult=1 m=1
XMRD_ana_0000_3 rbl_ana_0000 sn_ana_0000_3 rwls3_ana 0 sky130_fd_pr__nfet_01v8 L=0.15 W=0.42 nf=1 ad=0.1974 as=0.1974 pd=1.78 ps=1.78 nrd=0.69047619047619  nrs=0.69047619047619 sa=0 sb=0 sd=0 mult=1 m=1
csn_ana_0000_3 sn_ana_0000_3 0 {C_SN}
XMN1_ana_0000 rbl_ana_0000 ref_ana_0000 vn_ana_0000 0 sky130_fd_pr__nfet_01v8 L=0.15 W=1 nf=1 ad=0.29 as=0.29 pd=2.58 ps=2.58 nrd=0.29 nrs=0.29 sa=0 sb=0 sd=0 mult=1 m=1
XMN2_ana_0000 ref_ana_0000 rbl_ana_0000 vn_ana_0000 0 sky130_fd_pr__nfet_01v8 L=0.15 W=1 nf=1 ad=0.29 as=0.29 pd=2.58 ps=2.58 nrd=0.29 nrs=0.29 sa=0 sb=0 sd=0 mult=1 m=1
XMP1_ana_0000 rbl_ana_0000 ref_ana_0000 vp_ana_0000 vdd sky130_fd_pr__pfet_01v8 L=0.15 W=2 nf=1 ad=0.58 as=0.58 pd=4.58 ps=4.58 nrd=0.145 nrs=0.145 sa=0 sb=0 sd=0 mult=1 m=1
XMP2_ana_0000 ref_ana_0000 rbl_ana_0000 vp_ana_0000 vdd sky130_fd_pr__pfet_01v8 L=0.15 W=2 nf=1 ad=0.58 as=0.58 pd=4.58 ps=4.58 nrd=0.145 nrs=0.145 sa=0 sb=0 sd=0 mult=1 m=1
XMNF_ana_0000 vn_ana_0000 en_ana 0 0 sky130_fd_pr__nfet_01v8 L=0.15 W=2 nf=1 ad=0.58 as=0.58 pd=4.58 ps=4.58 nrd=0.145 nrs=0.145 sa=0 sb=0 sd=0 mult=1 m=1
XMPH_ana_0000 vp_ana_0000 enb_ana vdd vdd sky130_fd_pr__pfet_01v8 L=0.15 W=4 nf=1 ad=1.16 as=1.16 pd=8.58 ps=8.58 nrd=0.0725 nrs=0.0725 sa=0 sb=0 sd=0 mult=1 m=1
bd_ana_0000 d_ana_0000 0 v=v(rbl_ana_0000)-v(ref_ana_0000)

* initial conditions (tran uic): precharged rails, cells at the opposite of their data, latch tail nodes.
* They apply ONLY at t = 0 (before the initial write); nothing is reset between refresh cycles.
.ic v(wbl_ana_1111)=0 v(rbl_ana_1111)=0.9 v(ref_ana_1111)=0.8 v(sn_ana_1111_0)=0 v(sn_ana_1111_1)=0 v(sn_ana_1111_2)=0
.ic v(sn_ana_1111_3)=0 v(vn_ana_1111)=0.45 v(vp_ana_1111)=1.35 v(wbl_ana_1010)=0 v(rbl_ana_1010)=0.9 v(ref_ana_1010)=0.8
.ic v(sn_ana_1010_0)=0 v(sn_ana_1010_1)=1.8 v(sn_ana_1010_2)=0 v(sn_ana_1010_3)=1.8 v(vn_ana_1010)=0.45 v(vp_ana_1010)=1.35
.ic v(wbl_ana_0000)=0 v(rbl_ana_0000)=0.9 v(ref_ana_0000)=0.8 v(sn_ana_0000_0)=1.8 v(sn_ana_0000_1)=1.8 v(sn_ana_0000_2)=1.8
.ic v(sn_ana_0000_3)=1.8 v(vn_ana_0000)=0.45 v(vp_ana_0000)=1.35
