* closed_loop_d5030nbr.spice -- repeated closed-loop refresh, dwell 5030 ns x 1 cycles (issue #373 paired neighbour-SN-level diagnostic at the ratified dwell (sf/125 C only)), issue #147
* GENERATED by gen_closed_loop.py; do not edit by hand.
*
* PROPOSED/UNRATIFIED SCOPE: 27 C and 125 C, tt/ss/ff/sf/fs, VDD 1.8 V (spec/operating-range-decision-PROPOSED.md).
* One continuous transient per instance: 4 rows written ONCE through M_WR (each cell starting at the opposite of its
* data), then closed-loop refresh of every row each dwell: precharge -> select -> latch enable -> latch COMPLEMENT
* node drives WBL -> WWL pulse. No .ic reset and no ideal expected-data source after the initial write; the actual
* latch decision is written back and carried into the next cycle. Instance name <waveform>_<row0..row3 data>.
* Waveforms: ana = sim/refresh-op analog baseline; rtl = UNCHANGED phase-sequencer strobes + latch-hold adapter;
* late = EXPERIMENTAL UNAPPROVED rtl with RWL released after WWL fall; nowb = ana with write-back WWL pulses deleted.
*
* DIAGNOSTIC, PAIRED ARMS (issue #373): cycle-1 row-2 read of pattern 1111 at the ratified dwell, sf/125 C only.
* ana_1111 = instrumented baseline; anb_1111 = IDENTICAL circuit plus the ideal neighbour-SN clamp emitted below.
* RWL/latch/write-back waveform, schedule, write/refresh history, loading and reference are shared and identical.
*
* ASSUMPTIONS (labelled, none is a spec value): ideal drivers and 100 ohm switches, C_WBL = 10 fF (not extracted),
* ideal matched dummy reference load, VREF = VRBL - 100 mV, 4-row column, C_RBL = extracted 4-row worst net,
* C_SN = extracted array MINIMUM wiring C, global corners only, NO mismatch, no device-level column/row driver.

.options method=trap gmin=1e-15 abstol=1e-15 chgtol=1e-18
.param VDD   = 1.8
.param VRBL  = 0.9
.param C_RBL = 9.55559e-16   $ extracted_4row_worst_total_ff, layout/gain_cell_2t_array.parasitics.summary.json
.param C_WBL = 1e-14   $ ASSUMPTION (not extracted)
.param C_SN  = 5.38402e-16   $ comparison.c_sn.array_min_total_ff (wiring only; array-context, issue #89)
vdd   vdd 0 dc {VDD}
vprea prea 0 dc {VRBL}
vpref pref 0 dc 0.8
vrwld rwl_des 0 dc {VDD}
.model swpre sw(vt=0.9 vh=0.1 ron=100 roff=1e12)
.model swwbl sw(vt=0.9 vh=0.1 ron=100 roff=1e12)

* ---- shared control sources, waveform ana (source variant baseline_analog, write-back True) ----
vctl_ana ctl_ana 0 pwl(0 {VDD} 5.0491e-06 {VDD} 5.0492e-06 0 5.0851e-06 0 5.0852e-06 {VDD} 5.0891e-06 {VDD} 5.0892e-06 0 5.1251e-06 0 5.1252e-06 {VDD} 5.1291e-06 {VDD} 5.1292e-06 0 5.1651e-06 0 5.1652e-06 {VDD} 5.1691e-06 {VDD} 5.1692e-06 0 5.2051e-06 0 5.2052e-06 {VDD})
ven_ana en_ana 0 pwl(0 0 5.0611e-06 0 5.0612e-06 {VDD} 5.0841e-06 {VDD} 5.0842e-06 0 5.1011e-06 0 5.1012e-06 {VDD} 5.1241e-06 {VDD} 5.1242e-06 0 5.1411e-06 0 5.1412e-06 {VDD} 5.1641e-06 {VDD} 5.1642e-06 0 5.1811e-06 0 5.1812e-06 {VDD} 5.2041e-06 {VDD} 5.2042e-06 0)
venb_ana enb_ana 0 pwl(0 {VDD} 5.0611e-06 {VDD} 5.0612e-06 0 5.0841e-06 0 5.0842e-06 {VDD} 5.1011e-06 {VDD} 5.1012e-06 0 5.1241e-06 0 5.1242e-06 {VDD} 5.1411e-06 {VDD} 5.1412e-06 0 5.1641e-06 0 5.1642e-06 {VDD} 5.1811e-06 {VDD} 5.1812e-06 0 5.2041e-06 0 5.2042e-06 {VDD})
vwbc_ana wbc_ana 0 pwl(0 0 5.0621e-06 0 5.0622e-06 {VDD} 5.0841e-06 {VDD} 5.0842e-06 0 5.1021e-06 0 5.1022e-06 {VDD} 5.1241e-06 {VDD} 5.1242e-06 0 5.1421e-06 0 5.1422e-06 {VDD} 5.1641e-06 {VDD} 5.1642e-06 0 5.1821e-06 0 5.1822e-06 {VDD} 5.2041e-06 {VDD} 5.2042e-06 0)
vbpk_ana bpk_ana 0 pwl(0 {VDD} 5.0621e-06 {VDD} 5.0622e-06 0 5.0841e-06 0 5.0842e-06 {VDD} 5.1021e-06 {VDD} 5.1022e-06 0 5.1241e-06 0 5.1242e-06 {VDD} 5.1421e-06 {VDD} 5.1422e-06 0 5.1641e-06 0 5.1642e-06 {VDD} 5.1821e-06 {VDD} 5.1822e-06 0 5.2041e-06 0 5.2042e-06 {VDD})   $ ideal initial-write/park driver connected except during write-back
vrws0_ana rwlsrc0_ana 0 pwl(0 {VDD} 5.0511e-06 {VDD} 5.0512e-06 0 5.0841e-06 0 5.0842e-06 {VDD})
vmeas0_ana rwlsrc0_ana rwls0_ana dc 0   $ 0 V ammeter; positive i = this row's RWL rail -> its read device (onto the shared RBL)
vwl0_ana wl0_ana 0 pwl(0 0 1e-09 0 1.1e-09 {VDD} 2.1e-08 {VDD} 2.11e-08 0 5.0621e-06 0 5.0622e-06 {VDD} 5.0821e-06 {VDD} 5.0822e-06 0)
vrws1_ana rwlsrc1_ana 0 pwl(0 {VDD} 5.0911e-06 {VDD} 5.0912e-06 0 5.1241e-06 0 5.1242e-06 {VDD})
vmeas1_ana rwlsrc1_ana rwls1_ana dc 0   $ 0 V ammeter; positive i = this row's RWL rail -> its read device (onto the shared RBL)
vwl1_ana wl1_ana 0 pwl(0 0 4.1e-08 0 4.11e-08 {VDD} 6.1e-08 {VDD} 6.11e-08 0 5.1021e-06 0 5.1022e-06 {VDD} 5.1221e-06 {VDD} 5.1222e-06 0)
vrws2_ana rwlsrc2_ana 0 pwl(0 {VDD} 5.1311e-06 {VDD} 5.1312e-06 0 5.1641e-06 0 5.1642e-06 {VDD})
vmeas2_ana rwlsrc2_ana rwls2_ana dc 0   $ 0 V ammeter; positive i = this row's RWL rail -> its read device (onto the shared RBL)
vwl2_ana wl2_ana 0 pwl(0 0 8.1e-08 0 8.11e-08 {VDD} 1.01e-07 {VDD} 1.011e-07 0 5.1421e-06 0 5.1422e-06 {VDD} 5.1621e-06 {VDD} 5.1622e-06 0)
vrws3_ana rwlsrc3_ana 0 pwl(0 {VDD} 5.1711e-06 {VDD} 5.1712e-06 0 5.2041e-06 0 5.2042e-06 {VDD})
vmeas3_ana rwlsrc3_ana rwls3_ana dc 0   $ 0 V ammeter; positive i = this row's RWL rail -> its read device (onto the shared RBL)
vwl3_ana wl3_ana 0 pwl(0 0 1.21e-07 0 1.211e-07 {VDD} 1.41e-07 {VDD} 1.411e-07 0 5.1821e-06 0 5.1822e-06 {VDD} 5.2021e-06 {VDD} 5.2022e-06 0)
* ---- shared control sources, waveform anb (source variant baseline_analog, write-back True) ----
vctl_anb ctl_anb 0 pwl(0 {VDD} 5.0491e-06 {VDD} 5.0492e-06 0 5.0851e-06 0 5.0852e-06 {VDD} 5.0891e-06 {VDD} 5.0892e-06 0 5.1251e-06 0 5.1252e-06 {VDD} 5.1291e-06 {VDD} 5.1292e-06 0 5.1651e-06 0 5.1652e-06 {VDD} 5.1691e-06 {VDD} 5.1692e-06 0 5.2051e-06 0 5.2052e-06 {VDD})
ven_anb en_anb 0 pwl(0 0 5.0611e-06 0 5.0612e-06 {VDD} 5.0841e-06 {VDD} 5.0842e-06 0 5.1011e-06 0 5.1012e-06 {VDD} 5.1241e-06 {VDD} 5.1242e-06 0 5.1411e-06 0 5.1412e-06 {VDD} 5.1641e-06 {VDD} 5.1642e-06 0 5.1811e-06 0 5.1812e-06 {VDD} 5.2041e-06 {VDD} 5.2042e-06 0)
venb_anb enb_anb 0 pwl(0 {VDD} 5.0611e-06 {VDD} 5.0612e-06 0 5.0841e-06 0 5.0842e-06 {VDD} 5.1011e-06 {VDD} 5.1012e-06 0 5.1241e-06 0 5.1242e-06 {VDD} 5.1411e-06 {VDD} 5.1412e-06 0 5.1641e-06 0 5.1642e-06 {VDD} 5.1811e-06 {VDD} 5.1812e-06 0 5.2041e-06 0 5.2042e-06 {VDD})
vwbc_anb wbc_anb 0 pwl(0 0 5.0621e-06 0 5.0622e-06 {VDD} 5.0841e-06 {VDD} 5.0842e-06 0 5.1021e-06 0 5.1022e-06 {VDD} 5.1241e-06 {VDD} 5.1242e-06 0 5.1421e-06 0 5.1422e-06 {VDD} 5.1641e-06 {VDD} 5.1642e-06 0 5.1821e-06 0 5.1822e-06 {VDD} 5.2041e-06 {VDD} 5.2042e-06 0)
vbpk_anb bpk_anb 0 pwl(0 {VDD} 5.0621e-06 {VDD} 5.0622e-06 0 5.0841e-06 0 5.0842e-06 {VDD} 5.1021e-06 {VDD} 5.1022e-06 0 5.1241e-06 0 5.1242e-06 {VDD} 5.1421e-06 {VDD} 5.1422e-06 0 5.1641e-06 0 5.1642e-06 {VDD} 5.1821e-06 {VDD} 5.1822e-06 0 5.2041e-06 0 5.2042e-06 {VDD})   $ ideal initial-write/park driver connected except during write-back
vrws0_anb rwlsrc0_anb 0 pwl(0 {VDD} 5.0511e-06 {VDD} 5.0512e-06 0 5.0841e-06 0 5.0842e-06 {VDD})
vmeas0_anb rwlsrc0_anb rwls0_anb dc 0   $ 0 V ammeter; positive i = this row's RWL rail -> its read device (onto the shared RBL)
vwl0_anb wl0_anb 0 pwl(0 0 1e-09 0 1.1e-09 {VDD} 2.1e-08 {VDD} 2.11e-08 0 5.0621e-06 0 5.0622e-06 {VDD} 5.0821e-06 {VDD} 5.0822e-06 0)
vrws1_anb rwlsrc1_anb 0 pwl(0 {VDD} 5.0911e-06 {VDD} 5.0912e-06 0 5.1241e-06 0 5.1242e-06 {VDD})
vmeas1_anb rwlsrc1_anb rwls1_anb dc 0   $ 0 V ammeter; positive i = this row's RWL rail -> its read device (onto the shared RBL)
vwl1_anb wl1_anb 0 pwl(0 0 4.1e-08 0 4.11e-08 {VDD} 6.1e-08 {VDD} 6.11e-08 0 5.1021e-06 0 5.1022e-06 {VDD} 5.1221e-06 {VDD} 5.1222e-06 0)
vrws2_anb rwlsrc2_anb 0 pwl(0 {VDD} 5.1311e-06 {VDD} 5.1312e-06 0 5.1641e-06 0 5.1642e-06 {VDD})
vmeas2_anb rwlsrc2_anb rwls2_anb dc 0   $ 0 V ammeter; positive i = this row's RWL rail -> its read device (onto the shared RBL)
vwl2_anb wl2_anb 0 pwl(0 0 8.1e-08 0 8.11e-08 {VDD} 1.01e-07 {VDD} 1.011e-07 0 5.1421e-06 0 5.1422e-06 {VDD} 5.1621e-06 {VDD} 5.1622e-06 0)
vrws3_anb rwlsrc3_anb 0 pwl(0 {VDD} 5.1711e-06 {VDD} 5.1712e-06 0 5.2041e-06 0 5.2042e-06 {VDD})
vmeas3_anb rwlsrc3_anb rwls3_anb dc 0   $ 0 V ammeter; positive i = this row's RWL rail -> its read device (onto the shared RBL)
vwl3_anb wl3_anb 0 pwl(0 0 1.21e-07 0 1.211e-07 {VDD} 1.41e-07 {VDD} 1.411e-07 0 5.1821e-06 0 5.1822e-06 {VDD} 5.2021e-06 {VDD} 5.2022e-06 0)
vbld1111 bld1111 0 pwl(0 0 5e-10 0 6e-10 {VDD} 2.31e-08 {VDD} 2.32e-08 0 4.05e-08 0 4.06e-08 {VDD} 6.31e-08 {VDD} 6.32e-08 0 8.05e-08 0 8.06e-08 {VDD} 1.031e-07 {VDD} 1.032e-07 0 1.205e-07 0 1.206e-07 {VDD} 1.431e-07 {VDD} 1.432e-07 0)

* ---- instance 0: ana_1111 (main) ----
sbi_ana_1111 bld1111 wbl_ana_1111 bpk_ana 0 swwbl
swb_ana_1111 ref_ana_1111 wbl_ana_1111 wbc_ana 0 swwbl
cwbl_ana_1111 wbl_ana_1111 0 {C_WBL}
spa_ana_1111 prea rbl_ana_1111 ctl_ana 0 swpre
spr_ana_1111 pref ref_ana_1111 ctl_ana 0 swpre
crbl_ana_1111 rbl_ana_1111 0 {C_RBL}
cref_ana_1111 ref_ana_1111 0 {C_RBL}   $ ASSUMPTION: ideal matched dummy load
XMWR_ana_1111_0 sn_ana_1111_0 wl0_ana wbl_ana_1111 0 sky130_fd_pr__nfet_01v8 L=0.15 W=0.42 nf=1 ad=0.1974 as=0.1974 pd=1.78 ps=1.78 nrd=0.69047619047619  nrs=0.69047619047619 sa=0 sb=0 sd=0 mult=1 m=1
XMRD_ana_1111_0 rbl_ana_1111 sn_ana_1111_0 rwls0_ana 0 sky130_fd_pr__nfet_01v8 L=0.15 W=0.42 nf=1 ad=0.1974 as=0.1974 pd=1.78 ps=1.78 nrd=0.69047619047619  nrs=0.69047619047619 sa=0 sb=0 sd=0 mult=1 m=1
csn_ana_1111_0 sn_ana_1111_0 0 {C_SN}
XMWR_ana_1111_1 sn_ana_1111_1 wl1_ana wbl_ana_1111 0 sky130_fd_pr__nfet_01v8 L=0.15 W=0.42 nf=1 ad=0.1974 as=0.1974 pd=1.78 ps=1.78 nrd=0.69047619047619  nrs=0.69047619047619 sa=0 sb=0 sd=0 mult=1 m=1
XMRD_ana_1111_1 rbl_ana_1111 sn_ana_1111_1 rwls1_ana 0 sky130_fd_pr__nfet_01v8 L=0.15 W=0.42 nf=1 ad=0.1974 as=0.1974 pd=1.78 ps=1.78 nrd=0.69047619047619  nrs=0.69047619047619 sa=0 sb=0 sd=0 mult=1 m=1
csn_ana_1111_1 sn_ana_1111_1 0 {C_SN}
XMWR_ana_1111_2 sn_ana_1111_2 wl2_ana wbl_ana_1111 0 sky130_fd_pr__nfet_01v8 L=0.15 W=0.42 nf=1 ad=0.1974 as=0.1974 pd=1.78 ps=1.78 nrd=0.69047619047619  nrs=0.69047619047619 sa=0 sb=0 sd=0 mult=1 m=1
XMRD_ana_1111_2 rbl_ana_1111 sn_ana_1111_2 rwls2_ana 0 sky130_fd_pr__nfet_01v8 L=0.15 W=0.42 nf=1 ad=0.1974 as=0.1974 pd=1.78 ps=1.78 nrd=0.69047619047619  nrs=0.69047619047619 sa=0 sb=0 sd=0 mult=1 m=1
csn_ana_1111_2 sn_ana_1111_2 0 {C_SN}
XMWR_ana_1111_3 sn_ana_1111_3 wl3_ana wbl_ana_1111 0 sky130_fd_pr__nfet_01v8 L=0.15 W=0.42 nf=1 ad=0.1974 as=0.1974 pd=1.78 ps=1.78 nrd=0.69047619047619  nrs=0.69047619047619 sa=0 sb=0 sd=0 mult=1 m=1
XMRD_ana_1111_3 rbl_ana_1111 sn_ana_1111_3 rwls3_ana 0 sky130_fd_pr__nfet_01v8 L=0.15 W=0.42 nf=1 ad=0.1974 as=0.1974 pd=1.78 ps=1.78 nrd=0.69047619047619  nrs=0.69047619047619 sa=0 sb=0 sd=0 mult=1 m=1
csn_ana_1111_3 sn_ana_1111_3 0 {C_SN}
XMN1_ana_1111 rbl_ana_1111 ref_ana_1111 vn_ana_1111 0 sky130_fd_pr__nfet_01v8 L=0.15 W=1 nf=1 ad=0.29 as=0.29 pd=2.58 ps=2.58 nrd=0.29 nrs=0.29 sa=0 sb=0 sd=0 mult=1 m=1
XMN2_ana_1111 ref_ana_1111 rbl_ana_1111 vn_ana_1111 0 sky130_fd_pr__nfet_01v8 L=0.15 W=1 nf=1 ad=0.29 as=0.29 pd=2.58 ps=2.58 nrd=0.29 nrs=0.29 sa=0 sb=0 sd=0 mult=1 m=1
XMP1_ana_1111 rbl_ana_1111 ref_ana_1111 vp_ana_1111 vdd sky130_fd_pr__pfet_01v8 L=0.15 W=2 nf=1 ad=0.58 as=0.58 pd=4.58 ps=4.58 nrd=0.145 nrs=0.145 sa=0 sb=0 sd=0 mult=1 m=1
XMP2_ana_1111 ref_ana_1111 rbl_ana_1111 vp_ana_1111 vdd sky130_fd_pr__pfet_01v8 L=0.15 W=2 nf=1 ad=0.58 as=0.58 pd=4.58 ps=4.58 nrd=0.145 nrs=0.145 sa=0 sb=0 sd=0 mult=1 m=1
XMNF_ana_1111 vn_ana_1111 en_ana 0 0 sky130_fd_pr__nfet_01v8 L=0.15 W=2 nf=1 ad=0.58 as=0.58 pd=4.58 ps=4.58 nrd=0.145 nrs=0.145 sa=0 sb=0 sd=0 mult=1 m=1
XMPH_ana_1111 vp_ana_1111 enb_ana vdd vdd sky130_fd_pr__pfet_01v8 L=0.15 W=4 nf=1 ad=1.16 as=1.16 pd=8.58 ps=8.58 nrd=0.0725 nrs=0.0725 sa=0 sb=0 sd=0 mult=1 m=1
bd_ana_1111 d_ana_1111 0 v=v(rbl_ana_1111)-v(ref_ana_1111)

* ---- instance 1: anb_1111 (diagnostic_neighbour_sn_clamp) ----
sbi_anb_1111 bld1111 wbl_anb_1111 bpk_anb 0 swwbl
swb_anb_1111 ref_anb_1111 wbl_anb_1111 wbc_anb 0 swwbl
cwbl_anb_1111 wbl_anb_1111 0 {C_WBL}
spa_anb_1111 prea rbl_anb_1111 ctl_anb 0 swpre
spr_anb_1111 pref ref_anb_1111 ctl_anb 0 swpre
crbl_anb_1111 rbl_anb_1111 0 {C_RBL}
cref_anb_1111 ref_anb_1111 0 {C_RBL}   $ ASSUMPTION: ideal matched dummy load
XMWR_anb_1111_0 sn_anb_1111_0 wl0_anb wbl_anb_1111 0 sky130_fd_pr__nfet_01v8 L=0.15 W=0.42 nf=1 ad=0.1974 as=0.1974 pd=1.78 ps=1.78 nrd=0.69047619047619  nrs=0.69047619047619 sa=0 sb=0 sd=0 mult=1 m=1
XMRD_anb_1111_0 rbl_anb_1111 sn_anb_1111_0 rwls0_anb 0 sky130_fd_pr__nfet_01v8 L=0.15 W=0.42 nf=1 ad=0.1974 as=0.1974 pd=1.78 ps=1.78 nrd=0.69047619047619  nrs=0.69047619047619 sa=0 sb=0 sd=0 mult=1 m=1
csn_anb_1111_0 sn_anb_1111_0 0 {C_SN}
XMWR_anb_1111_1 sn_anb_1111_1 wl1_anb wbl_anb_1111 0 sky130_fd_pr__nfet_01v8 L=0.15 W=0.42 nf=1 ad=0.1974 as=0.1974 pd=1.78 ps=1.78 nrd=0.69047619047619  nrs=0.69047619047619 sa=0 sb=0 sd=0 mult=1 m=1
XMRD_anb_1111_1 rbl_anb_1111 sn_anb_1111_1 rwls1_anb 0 sky130_fd_pr__nfet_01v8 L=0.15 W=0.42 nf=1 ad=0.1974 as=0.1974 pd=1.78 ps=1.78 nrd=0.69047619047619  nrs=0.69047619047619 sa=0 sb=0 sd=0 mult=1 m=1
csn_anb_1111_1 sn_anb_1111_1 0 {C_SN}
XMWR_anb_1111_2 sn_anb_1111_2 wl2_anb wbl_anb_1111 0 sky130_fd_pr__nfet_01v8 L=0.15 W=0.42 nf=1 ad=0.1974 as=0.1974 pd=1.78 ps=1.78 nrd=0.69047619047619  nrs=0.69047619047619 sa=0 sb=0 sd=0 mult=1 m=1
XMRD_anb_1111_2 rbl_anb_1111 sn_anb_1111_2 rwls2_anb 0 sky130_fd_pr__nfet_01v8 L=0.15 W=0.42 nf=1 ad=0.1974 as=0.1974 pd=1.78 ps=1.78 nrd=0.69047619047619  nrs=0.69047619047619 sa=0 sb=0 sd=0 mult=1 m=1
csn_anb_1111_2 sn_anb_1111_2 0 {C_SN}
XMWR_anb_1111_3 sn_anb_1111_3 wl3_anb wbl_anb_1111 0 sky130_fd_pr__nfet_01v8 L=0.15 W=0.42 nf=1 ad=0.1974 as=0.1974 pd=1.78 ps=1.78 nrd=0.69047619047619  nrs=0.69047619047619 sa=0 sb=0 sd=0 mult=1 m=1
XMRD_anb_1111_3 rbl_anb_1111 sn_anb_1111_3 rwls3_anb 0 sky130_fd_pr__nfet_01v8 L=0.15 W=0.42 nf=1 ad=0.1974 as=0.1974 pd=1.78 ps=1.78 nrd=0.69047619047619  nrs=0.69047619047619 sa=0 sb=0 sd=0 mult=1 m=1
csn_anb_1111_3 sn_anb_1111_3 0 {C_SN}
XMN1_anb_1111 rbl_anb_1111 ref_anb_1111 vn_anb_1111 0 sky130_fd_pr__nfet_01v8 L=0.15 W=1 nf=1 ad=0.29 as=0.29 pd=2.58 ps=2.58 nrd=0.29 nrs=0.29 sa=0 sb=0 sd=0 mult=1 m=1
XMN2_anb_1111 ref_anb_1111 rbl_anb_1111 vn_anb_1111 0 sky130_fd_pr__nfet_01v8 L=0.15 W=1 nf=1 ad=0.29 as=0.29 pd=2.58 ps=2.58 nrd=0.29 nrs=0.29 sa=0 sb=0 sd=0 mult=1 m=1
XMP1_anb_1111 rbl_anb_1111 ref_anb_1111 vp_anb_1111 vdd sky130_fd_pr__pfet_01v8 L=0.15 W=2 nf=1 ad=0.58 as=0.58 pd=4.58 ps=4.58 nrd=0.145 nrs=0.145 sa=0 sb=0 sd=0 mult=1 m=1
XMP2_anb_1111 ref_anb_1111 rbl_anb_1111 vp_anb_1111 vdd sky130_fd_pr__pfet_01v8 L=0.15 W=2 nf=1 ad=0.58 as=0.58 pd=4.58 ps=4.58 nrd=0.145 nrs=0.145 sa=0 sb=0 sd=0 mult=1 m=1
XMNF_anb_1111 vn_anb_1111 en_anb 0 0 sky130_fd_pr__nfet_01v8 L=0.15 W=2 nf=1 ad=0.58 as=0.58 pd=4.58 ps=4.58 nrd=0.145 nrs=0.145 sa=0 sb=0 sd=0 mult=1 m=1
XMPH_anb_1111 vp_anb_1111 enb_anb vdd vdd sky130_fd_pr__pfet_01v8 L=0.15 W=4 nf=1 ad=1.16 as=1.16 pd=8.58 ps=8.58 nrd=0.0725 nrs=0.0725 sa=0 sb=0 sd=0 mult=1 m=1
bd_anb_1111 d_anb_1111 0 v=v(rbl_anb_1111)-v(ref_anb_1111)

* initial conditions (tran uic): precharged rails, cells at the opposite of their data, latch tail nodes.
* They apply ONLY at t = 0 (before the initial write); nothing is reset between refresh cycles.
.ic v(wbl_ana_1111)=0 v(rbl_ana_1111)=0.9 v(ref_ana_1111)=0.8 v(sn_ana_1111_0)=0 v(sn_ana_1111_1)=0 v(sn_ana_1111_2)=0
.ic v(sn_ana_1111_3)=0 v(vn_ana_1111)=0.45 v(vp_ana_1111)=1.35 v(wbl_anb_1111)=0 v(rbl_anb_1111)=0.9 v(ref_anb_1111)=0.8
.ic v(sn_anb_1111_0)=0 v(sn_anb_1111_1)=0 v(sn_anb_1111_2)=0 v(sn_anb_1111_3)=0 v(vn_anb_1111)=0.45 v(vp_anb_1111)=1.35

* ---- DIAGNOSTIC ONLY (issue #373): ideal neighbour storage-node clamp, paired arm anb_1111 ----
* Not a circuit feature: an ideal source holds the two restored neighbours' SN stiffly at the
* RTL-control restore level (1.36 V; sf/125 C control_rtl_unchanged range 1.35869..1.39556 V, run 20261118T220449Z)
* through the victim row-2 read window. The baseline arm has no clamp; the read select
* itself is never touched (RWL is active low: driving a neighbour RWL low would select it).
.model swclamp sw(vt=0.5 vh=0.1 ron=1 roff=1e12)
vclmp_anb clmp_anb 0 dc 1.36
vclp_anb clp_anb 0 pwl(0 0 5.1271e-06 0 5.1281e-06 {VDD} 5.1641e-06 {VDD} 5.1651e-06 0)
swc_anb_r0 sn_anb_1111_0 clmp_anb clp_anb 0 swclamp
swc_anb_r1 sn_anb_1111_1 clmp_anb clp_anb 0 swclamp
