* column_periphery.spice -- ideal-source vs designed column periphery on the 2T gain-cell
* column (issue #114). GENERATED by gen_column_periphery.py; do not edit by hand.
*
* PROPOSED/UNRATIFIED SCOPE: corners/temperatures come from
* spec/operating-range-decision-PROPOSED.md (27 C and 125 C only). Inputs follow
* sim/loaded-column/cold-corner/SENSE_INPUT_CONTRACT.md (baseline column).
* CIRCUIT BODY for `klt sim`: no .control/.end; PDK .lib/.temp cards are appended per corner.
*
* Instance kinds: ideal_w<d> = existing ideal sources (100 ohm switch, ideal write source, latch
* on rbl); real_w<d> = designed slice (design/column_periphery.spice); sw_<W*100> = precharge
* width sweep (W in um x100). d = data written to row 0 ('1' or '0').
*
* ASSUMPTIONS (labelled; none is a spec value): C_RBL, C_WBL, VRBL, vpre rail an ideal 0.9 V
* source, 4-row column, all four SN at one level before the write except the written row,
* sense instant, reference level, ideal reference-side precharge and matched dummy load, ideal
* digital control edges (100 ps), global corners only.

.param VDD     = 1.8
.param VRBL    = 0.9   $ ASSUMPTION (contract)
.param VREF    = 0.8   $ ASSUMPTION: VRBL - 0.1 V (as sense-stage)
.param TEDGE   = 1e-10
.param C_RBL   = 1e-14   $ ASSUMPTION (contract; not extracted)
.param C_WBL   = 1e-14   $ ASSUMPTION (not extracted)
.param C_SN    = 6.05354e-16   $ extracted-from-netlist (layout/gain_cell_2t.extract.parasitics.json)

* ---- shared control (ideal digital edges) ----
vdd   vdd 0 dc {VDD}
vpca  pca 0 pwl(0 0 1e-09 0 1.1e-09 {VDD} 5.8e-08 {VDD} 5.81e-08 0)   $ active-high precharge
vpcb  pcb 0 pwl(0 {VDD} 1e-09 {VDD} 1.1e-09 0 5.8e-08 0 5.81e-08 {VDD})   $ active-low precharge
vwen  wen 0 pwl(0 0 1e-08 0 1.01e-08 {VDD} 3.4e-08 {VDD} 3.41e-08 0)
vwenb wenb 0 pwl(0 {VDD} 1e-08 {VDD} 1.01e-08 0 3.4e-08 0 3.41e-08 {VDD})
vdinb1 dinb1 0 dc 0          $ data '1': wbl = NOT dinb = VDD
vdinb0 dinb0 0 dc {VDD}      $ data '0'
vwl   wl 0 pwl(0 0 1.2e-08 0 1.21e-08 {VDD} 3.2e-08 {VDD} 3.21e-08 0)
vrwls rwl_sel 0 pwl(0 {VDD} 6e-08 {VDD} 6.01e-08 0)
vrwld rwl_des 0 dc {VDD}
vsel  sel  0 pwl(0 {VDD} 6.95e-08 {VDD} 6.96e-08 0)
vselb selb 0 pwl(0 0 6.95e-08 0 6.96e-08 {VDD})
ven   en  0 pwl(0 0 7e-08 0 7.01e-08 {VDD})
venb  enb 0 pwl(0 {VDD} 7e-08 {VDD} 7.01e-08 0)
vprea prea 0 dc {VRBL}       $ ASSUMPTION: ideal 0.9 V precharge rail
vpref pref 0 dc {VREF}
.model swpre sw(vt=0.9 vh=0.1 ron=100 roff=1e12)

* ---- instance 0: ideal_w1 ----
XMWR_ideal_w1_0 sn_ideal_w1_0 wl wbl_ideal_w1 0 sky130_fd_pr__nfet_01v8 L=0.15 W=0.42 nf=1 ad=0.1218 as=0.1218 pd=1.42 ps=1.42 nrd=0.69047619047619 nrs=0.69047619047619 sa=0 sb=0 sd=0 mult=1 m=1
XMRD_ideal_w1_0 rbl_ideal_w1 sn_ideal_w1_0 rwl_sel 0 sky130_fd_pr__nfet_01v8 L=0.15 W=0.42 nf=1 ad=0.1218 as=0.1218 pd=1.42 ps=1.42 nrd=0.69047619047619 nrs=0.69047619047619 sa=0 sb=0 sd=0 mult=1 m=1
csn_ideal_w1_0 sn_ideal_w1_0 0 {C_SN}
XMWR_ideal_w1_1 sn_ideal_w1_1 0 wbl_ideal_w1 0 sky130_fd_pr__nfet_01v8 L=0.15 W=0.42 nf=1 ad=0.1218 as=0.1218 pd=1.42 ps=1.42 nrd=0.69047619047619 nrs=0.69047619047619 sa=0 sb=0 sd=0 mult=1 m=1
XMRD_ideal_w1_1 rbl_ideal_w1 sn_ideal_w1_1 rwl_des 0 sky130_fd_pr__nfet_01v8 L=0.15 W=0.42 nf=1 ad=0.1218 as=0.1218 pd=1.42 ps=1.42 nrd=0.69047619047619 nrs=0.69047619047619 sa=0 sb=0 sd=0 mult=1 m=1
csn_ideal_w1_1 sn_ideal_w1_1 0 {C_SN}
XMWR_ideal_w1_2 sn_ideal_w1_2 0 wbl_ideal_w1 0 sky130_fd_pr__nfet_01v8 L=0.15 W=0.42 nf=1 ad=0.1218 as=0.1218 pd=1.42 ps=1.42 nrd=0.69047619047619 nrs=0.69047619047619 sa=0 sb=0 sd=0 mult=1 m=1
XMRD_ideal_w1_2 rbl_ideal_w1 sn_ideal_w1_2 rwl_des 0 sky130_fd_pr__nfet_01v8 L=0.15 W=0.42 nf=1 ad=0.1218 as=0.1218 pd=1.42 ps=1.42 nrd=0.69047619047619 nrs=0.69047619047619 sa=0 sb=0 sd=0 mult=1 m=1
csn_ideal_w1_2 sn_ideal_w1_2 0 {C_SN}
XMWR_ideal_w1_3 sn_ideal_w1_3 0 wbl_ideal_w1 0 sky130_fd_pr__nfet_01v8 L=0.15 W=0.42 nf=1 ad=0.1218 as=0.1218 pd=1.42 ps=1.42 nrd=0.69047619047619 nrs=0.69047619047619 sa=0 sb=0 sd=0 mult=1 m=1
XMRD_ideal_w1_3 rbl_ideal_w1 sn_ideal_w1_3 rwl_des 0 sky130_fd_pr__nfet_01v8 L=0.15 W=0.42 nf=1 ad=0.1218 as=0.1218 pd=1.42 ps=1.42 nrd=0.69047619047619 nrs=0.69047619047619 sa=0 sb=0 sd=0 mult=1 m=1
csn_ideal_w1_3 sn_ideal_w1_3 0 {C_SN}
crbl_ideal_w1 rbl_ideal_w1 0 {C_RBL}
cwbl_ideal_w1 wbl_ideal_w1 0 {C_WBL}
cref_ideal_w1 ref_ideal_w1 0 {C_RBL}   $ ASSUMPTION: ideal matched dummy load
spr_ideal_w1 pref ref_ideal_w1 pca 0 swpre   $ reference-side precharge stays an ideal switch
spa_ideal_w1 prea rbl_ideal_w1 pca 0 swpre   $ existing ideal precharge switch
vwbl_ideal_w1 wbl_ideal_w1 0 pwl(0 0 1e-08 0 1.01e-08 {VDD} 3.4e-08 {VDD} 3.41e-08 0)   $ ideal write source
XMN1_ideal_w1 rbl_ideal_w1 ref_ideal_w1 vn_ideal_w1 0 sky130_fd_pr__nfet_01v8 L=0.15 W=1 nf=1 ad=0.29 as=0.29 pd=2.58 ps=2.58 nrd=0.29 nrs=0.29 sa=0 sb=0 sd=0 mult=1 m=1
XMN2_ideal_w1 ref_ideal_w1 rbl_ideal_w1 vn_ideal_w1 0 sky130_fd_pr__nfet_01v8 L=0.15 W=1 nf=1 ad=0.29 as=0.29 pd=2.58 ps=2.58 nrd=0.29 nrs=0.29 sa=0 sb=0 sd=0 mult=1 m=1
XMP1_ideal_w1 rbl_ideal_w1 ref_ideal_w1 vp_ideal_w1 vdd sky130_fd_pr__pfet_01v8 L=0.15 W=2 nf=1 ad=0.58 as=0.58 pd=4.58 ps=4.58 nrd=0.145 nrs=0.145 sa=0 sb=0 sd=0 mult=1 m=1
XMP2_ideal_w1 ref_ideal_w1 rbl_ideal_w1 vp_ideal_w1 vdd sky130_fd_pr__pfet_01v8 L=0.15 W=2 nf=1 ad=0.58 as=0.58 pd=4.58 ps=4.58 nrd=0.145 nrs=0.145 sa=0 sb=0 sd=0 mult=1 m=1
XMNF_ideal_w1 vn_ideal_w1 en 0 0 sky130_fd_pr__nfet_01v8 L=0.15 W=2 nf=1 ad=0.58 as=0.58 pd=4.58 ps=4.58 nrd=0.145 nrs=0.145 sa=0 sb=0 sd=0 mult=1 m=1
XMPH_ideal_w1 vp_ideal_w1 enb vdd vdd sky130_fd_pr__pfet_01v8 L=0.15 W=4 nf=1 ad=1.16 as=1.16 pd=8.58 ps=8.58 nrd=0.0725 nrs=0.0725 sa=0 sb=0 sd=0 mult=1 m=1
bd_ideal_w1 d_ideal_w1 0 v=v(rbl_ideal_w1)-v(ref_ideal_w1)
bdabs_ideal_w1 dabs_ideal_w1 0 v=abs(v(rbl_ideal_w1)-v(ref_ideal_w1))

* ---- instance 1: ideal_w0 ----
XMWR_ideal_w0_0 sn_ideal_w0_0 wl wbl_ideal_w0 0 sky130_fd_pr__nfet_01v8 L=0.15 W=0.42 nf=1 ad=0.1218 as=0.1218 pd=1.42 ps=1.42 nrd=0.69047619047619 nrs=0.69047619047619 sa=0 sb=0 sd=0 mult=1 m=1
XMRD_ideal_w0_0 rbl_ideal_w0 sn_ideal_w0_0 rwl_sel 0 sky130_fd_pr__nfet_01v8 L=0.15 W=0.42 nf=1 ad=0.1218 as=0.1218 pd=1.42 ps=1.42 nrd=0.69047619047619 nrs=0.69047619047619 sa=0 sb=0 sd=0 mult=1 m=1
csn_ideal_w0_0 sn_ideal_w0_0 0 {C_SN}
XMWR_ideal_w0_1 sn_ideal_w0_1 0 wbl_ideal_w0 0 sky130_fd_pr__nfet_01v8 L=0.15 W=0.42 nf=1 ad=0.1218 as=0.1218 pd=1.42 ps=1.42 nrd=0.69047619047619 nrs=0.69047619047619 sa=0 sb=0 sd=0 mult=1 m=1
XMRD_ideal_w0_1 rbl_ideal_w0 sn_ideal_w0_1 rwl_des 0 sky130_fd_pr__nfet_01v8 L=0.15 W=0.42 nf=1 ad=0.1218 as=0.1218 pd=1.42 ps=1.42 nrd=0.69047619047619 nrs=0.69047619047619 sa=0 sb=0 sd=0 mult=1 m=1
csn_ideal_w0_1 sn_ideal_w0_1 0 {C_SN}
XMWR_ideal_w0_2 sn_ideal_w0_2 0 wbl_ideal_w0 0 sky130_fd_pr__nfet_01v8 L=0.15 W=0.42 nf=1 ad=0.1218 as=0.1218 pd=1.42 ps=1.42 nrd=0.69047619047619 nrs=0.69047619047619 sa=0 sb=0 sd=0 mult=1 m=1
XMRD_ideal_w0_2 rbl_ideal_w0 sn_ideal_w0_2 rwl_des 0 sky130_fd_pr__nfet_01v8 L=0.15 W=0.42 nf=1 ad=0.1218 as=0.1218 pd=1.42 ps=1.42 nrd=0.69047619047619 nrs=0.69047619047619 sa=0 sb=0 sd=0 mult=1 m=1
csn_ideal_w0_2 sn_ideal_w0_2 0 {C_SN}
XMWR_ideal_w0_3 sn_ideal_w0_3 0 wbl_ideal_w0 0 sky130_fd_pr__nfet_01v8 L=0.15 W=0.42 nf=1 ad=0.1218 as=0.1218 pd=1.42 ps=1.42 nrd=0.69047619047619 nrs=0.69047619047619 sa=0 sb=0 sd=0 mult=1 m=1
XMRD_ideal_w0_3 rbl_ideal_w0 sn_ideal_w0_3 rwl_des 0 sky130_fd_pr__nfet_01v8 L=0.15 W=0.42 nf=1 ad=0.1218 as=0.1218 pd=1.42 ps=1.42 nrd=0.69047619047619 nrs=0.69047619047619 sa=0 sb=0 sd=0 mult=1 m=1
csn_ideal_w0_3 sn_ideal_w0_3 0 {C_SN}
crbl_ideal_w0 rbl_ideal_w0 0 {C_RBL}
cwbl_ideal_w0 wbl_ideal_w0 0 {C_WBL}
cref_ideal_w0 ref_ideal_w0 0 {C_RBL}   $ ASSUMPTION: ideal matched dummy load
spr_ideal_w0 pref ref_ideal_w0 pca 0 swpre   $ reference-side precharge stays an ideal switch
spa_ideal_w0 prea rbl_ideal_w0 pca 0 swpre   $ existing ideal precharge switch
vwbl_ideal_w0 wbl_ideal_w0 0 pwl(0 0 1e-08 0 1.01e-08 0 3.4e-08 0 3.41e-08 0)   $ ideal write source
XMN1_ideal_w0 rbl_ideal_w0 ref_ideal_w0 vn_ideal_w0 0 sky130_fd_pr__nfet_01v8 L=0.15 W=1 nf=1 ad=0.29 as=0.29 pd=2.58 ps=2.58 nrd=0.29 nrs=0.29 sa=0 sb=0 sd=0 mult=1 m=1
XMN2_ideal_w0 ref_ideal_w0 rbl_ideal_w0 vn_ideal_w0 0 sky130_fd_pr__nfet_01v8 L=0.15 W=1 nf=1 ad=0.29 as=0.29 pd=2.58 ps=2.58 nrd=0.29 nrs=0.29 sa=0 sb=0 sd=0 mult=1 m=1
XMP1_ideal_w0 rbl_ideal_w0 ref_ideal_w0 vp_ideal_w0 vdd sky130_fd_pr__pfet_01v8 L=0.15 W=2 nf=1 ad=0.58 as=0.58 pd=4.58 ps=4.58 nrd=0.145 nrs=0.145 sa=0 sb=0 sd=0 mult=1 m=1
XMP2_ideal_w0 ref_ideal_w0 rbl_ideal_w0 vp_ideal_w0 vdd sky130_fd_pr__pfet_01v8 L=0.15 W=2 nf=1 ad=0.58 as=0.58 pd=4.58 ps=4.58 nrd=0.145 nrs=0.145 sa=0 sb=0 sd=0 mult=1 m=1
XMNF_ideal_w0 vn_ideal_w0 en 0 0 sky130_fd_pr__nfet_01v8 L=0.15 W=2 nf=1 ad=0.58 as=0.58 pd=4.58 ps=4.58 nrd=0.145 nrs=0.145 sa=0 sb=0 sd=0 mult=1 m=1
XMPH_ideal_w0 vp_ideal_w0 enb vdd vdd sky130_fd_pr__pfet_01v8 L=0.15 W=4 nf=1 ad=1.16 as=1.16 pd=8.58 ps=8.58 nrd=0.0725 nrs=0.0725 sa=0 sb=0 sd=0 mult=1 m=1
bd_ideal_w0 d_ideal_w0 0 v=v(rbl_ideal_w0)-v(ref_ideal_w0)
bdabs_ideal_w0 dabs_ideal_w0 0 v=abs(v(rbl_ideal_w0)-v(ref_ideal_w0))

* ---- instance 2: real_w1 ----
XMWR_real_w1_0 sn_real_w1_0 wl wbl_real_w1 0 sky130_fd_pr__nfet_01v8 L=0.15 W=0.42 nf=1 ad=0.1218 as=0.1218 pd=1.42 ps=1.42 nrd=0.69047619047619 nrs=0.69047619047619 sa=0 sb=0 sd=0 mult=1 m=1
XMRD_real_w1_0 rbl_real_w1 sn_real_w1_0 rwl_sel 0 sky130_fd_pr__nfet_01v8 L=0.15 W=0.42 nf=1 ad=0.1218 as=0.1218 pd=1.42 ps=1.42 nrd=0.69047619047619 nrs=0.69047619047619 sa=0 sb=0 sd=0 mult=1 m=1
csn_real_w1_0 sn_real_w1_0 0 {C_SN}
XMWR_real_w1_1 sn_real_w1_1 0 wbl_real_w1 0 sky130_fd_pr__nfet_01v8 L=0.15 W=0.42 nf=1 ad=0.1218 as=0.1218 pd=1.42 ps=1.42 nrd=0.69047619047619 nrs=0.69047619047619 sa=0 sb=0 sd=0 mult=1 m=1
XMRD_real_w1_1 rbl_real_w1 sn_real_w1_1 rwl_des 0 sky130_fd_pr__nfet_01v8 L=0.15 W=0.42 nf=1 ad=0.1218 as=0.1218 pd=1.42 ps=1.42 nrd=0.69047619047619 nrs=0.69047619047619 sa=0 sb=0 sd=0 mult=1 m=1
csn_real_w1_1 sn_real_w1_1 0 {C_SN}
XMWR_real_w1_2 sn_real_w1_2 0 wbl_real_w1 0 sky130_fd_pr__nfet_01v8 L=0.15 W=0.42 nf=1 ad=0.1218 as=0.1218 pd=1.42 ps=1.42 nrd=0.69047619047619 nrs=0.69047619047619 sa=0 sb=0 sd=0 mult=1 m=1
XMRD_real_w1_2 rbl_real_w1 sn_real_w1_2 rwl_des 0 sky130_fd_pr__nfet_01v8 L=0.15 W=0.42 nf=1 ad=0.1218 as=0.1218 pd=1.42 ps=1.42 nrd=0.69047619047619 nrs=0.69047619047619 sa=0 sb=0 sd=0 mult=1 m=1
csn_real_w1_2 sn_real_w1_2 0 {C_SN}
XMWR_real_w1_3 sn_real_w1_3 0 wbl_real_w1 0 sky130_fd_pr__nfet_01v8 L=0.15 W=0.42 nf=1 ad=0.1218 as=0.1218 pd=1.42 ps=1.42 nrd=0.69047619047619 nrs=0.69047619047619 sa=0 sb=0 sd=0 mult=1 m=1
XMRD_real_w1_3 rbl_real_w1 sn_real_w1_3 rwl_des 0 sky130_fd_pr__nfet_01v8 L=0.15 W=0.42 nf=1 ad=0.1218 as=0.1218 pd=1.42 ps=1.42 nrd=0.69047619047619 nrs=0.69047619047619 sa=0 sb=0 sd=0 mult=1 m=1
csn_real_w1_3 sn_real_w1_3 0 {C_SN}
crbl_real_w1 rbl_real_w1 0 {C_RBL}
cwbl_real_w1 wbl_real_w1 0 {C_WBL}
cref_real_w1 ref_real_w1 0 {C_RBL}   $ ASSUMPTION: ideal matched dummy load
spr_real_w1 pref ref_real_w1 pca 0 swpre   $ reference-side precharge stays an ideal switch
XMPPRE_real_w1 rbl_real_w1 pcb prea prea sky130_fd_pr__pfet_01v8 L=0.15 W=4 nf=1 ad=1.16 as=1.16 pd=8.58 ps=8.58 nrd=0.0725 nrs=0.0725 sa=0 sb=0 sd=0 mult=1 m=1
XMPU1_real_w1 x_real_w1 dinb1 vdd vdd sky130_fd_pr__pfet_01v8 L=0.15 W=1 nf=1 ad=0.29 as=0.29 pd=2.58 ps=2.58 nrd=0.29 nrs=0.29 sa=0 sb=0 sd=0 mult=1 m=1
XMPU2_real_w1 wbl_real_w1 wenb x_real_w1 vdd sky130_fd_pr__pfet_01v8 L=0.15 W=1 nf=1 ad=0.29 as=0.29 pd=2.58 ps=2.58 nrd=0.29 nrs=0.29 sa=0 sb=0 sd=0 mult=1 m=1
XMND2_real_w1 wbl_real_w1 wen y_real_w1 0 sky130_fd_pr__nfet_01v8 L=0.15 W=0.5 nf=1 ad=0.145 as=0.145 pd=1.58 ps=1.58 nrd=0.58 nrs=0.58 sa=0 sb=0 sd=0 mult=1 m=1
XMND1_real_w1 y_real_w1 dinb1 0 0 sky130_fd_pr__nfet_01v8 L=0.15 W=0.5 nf=1 ad=0.145 as=0.145 pd=1.58 ps=1.58 nrd=0.58 nrs=0.58 sa=0 sb=0 sd=0 mult=1 m=1
XMNI_real_w1 wbl_real_w1 wenb 0 0 sky130_fd_pr__nfet_01v8 L=0.15 W=0.42 nf=1 ad=0.1218 as=0.1218 pd=1.42 ps=1.42 nrd=0.69047619047619 nrs=0.69047619047619 sa=0 sb=0 sd=0 mult=1 m=1
XMNS_real_w1 sbl_real_w1 sel rbl_real_w1 0 sky130_fd_pr__nfet_01v8 L=0.15 W=1 nf=1 ad=0.29 as=0.29 pd=2.58 ps=2.58 nrd=0.29 nrs=0.29 sa=0 sb=0 sd=0 mult=1 m=1
XMPS_real_w1 sbl_real_w1 selb rbl_real_w1 vdd sky130_fd_pr__pfet_01v8 L=0.15 W=2 nf=1 ad=0.58 as=0.58 pd=4.58 ps=4.58 nrd=0.145 nrs=0.145 sa=0 sb=0 sd=0 mult=1 m=1
XMNSR_real_w1 sref_real_w1 sel ref_real_w1 0 sky130_fd_pr__nfet_01v8 L=0.15 W=1 nf=1 ad=0.29 as=0.29 pd=2.58 ps=2.58 nrd=0.29 nrs=0.29 sa=0 sb=0 sd=0 mult=1 m=1
XMPSR_real_w1 sref_real_w1 selb ref_real_w1 vdd sky130_fd_pr__pfet_01v8 L=0.15 W=2 nf=1 ad=0.58 as=0.58 pd=4.58 ps=4.58 nrd=0.145 nrs=0.145 sa=0 sb=0 sd=0 mult=1 m=1
XMN1_real_w1 sbl_real_w1 sref_real_w1 vn_real_w1 0 sky130_fd_pr__nfet_01v8 L=0.15 W=1 nf=1 ad=0.29 as=0.29 pd=2.58 ps=2.58 nrd=0.29 nrs=0.29 sa=0 sb=0 sd=0 mult=1 m=1
XMN2_real_w1 sref_real_w1 sbl_real_w1 vn_real_w1 0 sky130_fd_pr__nfet_01v8 L=0.15 W=1 nf=1 ad=0.29 as=0.29 pd=2.58 ps=2.58 nrd=0.29 nrs=0.29 sa=0 sb=0 sd=0 mult=1 m=1
XMP1_real_w1 sbl_real_w1 sref_real_w1 vp_real_w1 vdd sky130_fd_pr__pfet_01v8 L=0.15 W=2 nf=1 ad=0.58 as=0.58 pd=4.58 ps=4.58 nrd=0.145 nrs=0.145 sa=0 sb=0 sd=0 mult=1 m=1
XMP2_real_w1 sref_real_w1 sbl_real_w1 vp_real_w1 vdd sky130_fd_pr__pfet_01v8 L=0.15 W=2 nf=1 ad=0.58 as=0.58 pd=4.58 ps=4.58 nrd=0.145 nrs=0.145 sa=0 sb=0 sd=0 mult=1 m=1
XMNF_real_w1 vn_real_w1 en 0 0 sky130_fd_pr__nfet_01v8 L=0.15 W=2 nf=1 ad=0.58 as=0.58 pd=4.58 ps=4.58 nrd=0.145 nrs=0.145 sa=0 sb=0 sd=0 mult=1 m=1
XMPH_real_w1 vp_real_w1 enb vdd vdd sky130_fd_pr__pfet_01v8 L=0.15 W=4 nf=1 ad=1.16 as=1.16 pd=8.58 ps=8.58 nrd=0.0725 nrs=0.0725 sa=0 sb=0 sd=0 mult=1 m=1
bd_real_w1 d_real_w1 0 v=v(sbl_real_w1)-v(sref_real_w1)
bdabs_real_w1 dabs_real_w1 0 v=abs(v(sbl_real_w1)-v(sref_real_w1))

* ---- instance 3: real_w0 ----
XMWR_real_w0_0 sn_real_w0_0 wl wbl_real_w0 0 sky130_fd_pr__nfet_01v8 L=0.15 W=0.42 nf=1 ad=0.1218 as=0.1218 pd=1.42 ps=1.42 nrd=0.69047619047619 nrs=0.69047619047619 sa=0 sb=0 sd=0 mult=1 m=1
XMRD_real_w0_0 rbl_real_w0 sn_real_w0_0 rwl_sel 0 sky130_fd_pr__nfet_01v8 L=0.15 W=0.42 nf=1 ad=0.1218 as=0.1218 pd=1.42 ps=1.42 nrd=0.69047619047619 nrs=0.69047619047619 sa=0 sb=0 sd=0 mult=1 m=1
csn_real_w0_0 sn_real_w0_0 0 {C_SN}
XMWR_real_w0_1 sn_real_w0_1 0 wbl_real_w0 0 sky130_fd_pr__nfet_01v8 L=0.15 W=0.42 nf=1 ad=0.1218 as=0.1218 pd=1.42 ps=1.42 nrd=0.69047619047619 nrs=0.69047619047619 sa=0 sb=0 sd=0 mult=1 m=1
XMRD_real_w0_1 rbl_real_w0 sn_real_w0_1 rwl_des 0 sky130_fd_pr__nfet_01v8 L=0.15 W=0.42 nf=1 ad=0.1218 as=0.1218 pd=1.42 ps=1.42 nrd=0.69047619047619 nrs=0.69047619047619 sa=0 sb=0 sd=0 mult=1 m=1
csn_real_w0_1 sn_real_w0_1 0 {C_SN}
XMWR_real_w0_2 sn_real_w0_2 0 wbl_real_w0 0 sky130_fd_pr__nfet_01v8 L=0.15 W=0.42 nf=1 ad=0.1218 as=0.1218 pd=1.42 ps=1.42 nrd=0.69047619047619 nrs=0.69047619047619 sa=0 sb=0 sd=0 mult=1 m=1
XMRD_real_w0_2 rbl_real_w0 sn_real_w0_2 rwl_des 0 sky130_fd_pr__nfet_01v8 L=0.15 W=0.42 nf=1 ad=0.1218 as=0.1218 pd=1.42 ps=1.42 nrd=0.69047619047619 nrs=0.69047619047619 sa=0 sb=0 sd=0 mult=1 m=1
csn_real_w0_2 sn_real_w0_2 0 {C_SN}
XMWR_real_w0_3 sn_real_w0_3 0 wbl_real_w0 0 sky130_fd_pr__nfet_01v8 L=0.15 W=0.42 nf=1 ad=0.1218 as=0.1218 pd=1.42 ps=1.42 nrd=0.69047619047619 nrs=0.69047619047619 sa=0 sb=0 sd=0 mult=1 m=1
XMRD_real_w0_3 rbl_real_w0 sn_real_w0_3 rwl_des 0 sky130_fd_pr__nfet_01v8 L=0.15 W=0.42 nf=1 ad=0.1218 as=0.1218 pd=1.42 ps=1.42 nrd=0.69047619047619 nrs=0.69047619047619 sa=0 sb=0 sd=0 mult=1 m=1
csn_real_w0_3 sn_real_w0_3 0 {C_SN}
crbl_real_w0 rbl_real_w0 0 {C_RBL}
cwbl_real_w0 wbl_real_w0 0 {C_WBL}
cref_real_w0 ref_real_w0 0 {C_RBL}   $ ASSUMPTION: ideal matched dummy load
spr_real_w0 pref ref_real_w0 pca 0 swpre   $ reference-side precharge stays an ideal switch
XMPPRE_real_w0 rbl_real_w0 pcb prea prea sky130_fd_pr__pfet_01v8 L=0.15 W=4 nf=1 ad=1.16 as=1.16 pd=8.58 ps=8.58 nrd=0.0725 nrs=0.0725 sa=0 sb=0 sd=0 mult=1 m=1
XMPU1_real_w0 x_real_w0 dinb0 vdd vdd sky130_fd_pr__pfet_01v8 L=0.15 W=1 nf=1 ad=0.29 as=0.29 pd=2.58 ps=2.58 nrd=0.29 nrs=0.29 sa=0 sb=0 sd=0 mult=1 m=1
XMPU2_real_w0 wbl_real_w0 wenb x_real_w0 vdd sky130_fd_pr__pfet_01v8 L=0.15 W=1 nf=1 ad=0.29 as=0.29 pd=2.58 ps=2.58 nrd=0.29 nrs=0.29 sa=0 sb=0 sd=0 mult=1 m=1
XMND2_real_w0 wbl_real_w0 wen y_real_w0 0 sky130_fd_pr__nfet_01v8 L=0.15 W=0.5 nf=1 ad=0.145 as=0.145 pd=1.58 ps=1.58 nrd=0.58 nrs=0.58 sa=0 sb=0 sd=0 mult=1 m=1
XMND1_real_w0 y_real_w0 dinb0 0 0 sky130_fd_pr__nfet_01v8 L=0.15 W=0.5 nf=1 ad=0.145 as=0.145 pd=1.58 ps=1.58 nrd=0.58 nrs=0.58 sa=0 sb=0 sd=0 mult=1 m=1
XMNI_real_w0 wbl_real_w0 wenb 0 0 sky130_fd_pr__nfet_01v8 L=0.15 W=0.42 nf=1 ad=0.1218 as=0.1218 pd=1.42 ps=1.42 nrd=0.69047619047619 nrs=0.69047619047619 sa=0 sb=0 sd=0 mult=1 m=1
XMNS_real_w0 sbl_real_w0 sel rbl_real_w0 0 sky130_fd_pr__nfet_01v8 L=0.15 W=1 nf=1 ad=0.29 as=0.29 pd=2.58 ps=2.58 nrd=0.29 nrs=0.29 sa=0 sb=0 sd=0 mult=1 m=1
XMPS_real_w0 sbl_real_w0 selb rbl_real_w0 vdd sky130_fd_pr__pfet_01v8 L=0.15 W=2 nf=1 ad=0.58 as=0.58 pd=4.58 ps=4.58 nrd=0.145 nrs=0.145 sa=0 sb=0 sd=0 mult=1 m=1
XMNSR_real_w0 sref_real_w0 sel ref_real_w0 0 sky130_fd_pr__nfet_01v8 L=0.15 W=1 nf=1 ad=0.29 as=0.29 pd=2.58 ps=2.58 nrd=0.29 nrs=0.29 sa=0 sb=0 sd=0 mult=1 m=1
XMPSR_real_w0 sref_real_w0 selb ref_real_w0 vdd sky130_fd_pr__pfet_01v8 L=0.15 W=2 nf=1 ad=0.58 as=0.58 pd=4.58 ps=4.58 nrd=0.145 nrs=0.145 sa=0 sb=0 sd=0 mult=1 m=1
XMN1_real_w0 sbl_real_w0 sref_real_w0 vn_real_w0 0 sky130_fd_pr__nfet_01v8 L=0.15 W=1 nf=1 ad=0.29 as=0.29 pd=2.58 ps=2.58 nrd=0.29 nrs=0.29 sa=0 sb=0 sd=0 mult=1 m=1
XMN2_real_w0 sref_real_w0 sbl_real_w0 vn_real_w0 0 sky130_fd_pr__nfet_01v8 L=0.15 W=1 nf=1 ad=0.29 as=0.29 pd=2.58 ps=2.58 nrd=0.29 nrs=0.29 sa=0 sb=0 sd=0 mult=1 m=1
XMP1_real_w0 sbl_real_w0 sref_real_w0 vp_real_w0 vdd sky130_fd_pr__pfet_01v8 L=0.15 W=2 nf=1 ad=0.58 as=0.58 pd=4.58 ps=4.58 nrd=0.145 nrs=0.145 sa=0 sb=0 sd=0 mult=1 m=1
XMP2_real_w0 sref_real_w0 sbl_real_w0 vp_real_w0 vdd sky130_fd_pr__pfet_01v8 L=0.15 W=2 nf=1 ad=0.58 as=0.58 pd=4.58 ps=4.58 nrd=0.145 nrs=0.145 sa=0 sb=0 sd=0 mult=1 m=1
XMNF_real_w0 vn_real_w0 en 0 0 sky130_fd_pr__nfet_01v8 L=0.15 W=2 nf=1 ad=0.58 as=0.58 pd=4.58 ps=4.58 nrd=0.145 nrs=0.145 sa=0 sb=0 sd=0 mult=1 m=1
XMPH_real_w0 vp_real_w0 enb vdd vdd sky130_fd_pr__pfet_01v8 L=0.15 W=4 nf=1 ad=1.16 as=1.16 pd=8.58 ps=8.58 nrd=0.0725 nrs=0.0725 sa=0 sb=0 sd=0 mult=1 m=1
bd_real_w0 d_real_w0 0 v=v(sbl_real_w0)-v(sref_real_w0)
bdabs_real_w0 dabs_real_w0 0 v=abs(v(sbl_real_w0)-v(sref_real_w0))

* ---- instance 4: sw_0100 ----
XMWR_sw_0100_0 sn_sw_0100_0 wl wbl_sw_0100 0 sky130_fd_pr__nfet_01v8 L=0.15 W=0.42 nf=1 ad=0.1218 as=0.1218 pd=1.42 ps=1.42 nrd=0.69047619047619 nrs=0.69047619047619 sa=0 sb=0 sd=0 mult=1 m=1
XMRD_sw_0100_0 rbl_sw_0100 sn_sw_0100_0 rwl_sel 0 sky130_fd_pr__nfet_01v8 L=0.15 W=0.42 nf=1 ad=0.1218 as=0.1218 pd=1.42 ps=1.42 nrd=0.69047619047619 nrs=0.69047619047619 sa=0 sb=0 sd=0 mult=1 m=1
csn_sw_0100_0 sn_sw_0100_0 0 {C_SN}
XMWR_sw_0100_1 sn_sw_0100_1 0 wbl_sw_0100 0 sky130_fd_pr__nfet_01v8 L=0.15 W=0.42 nf=1 ad=0.1218 as=0.1218 pd=1.42 ps=1.42 nrd=0.69047619047619 nrs=0.69047619047619 sa=0 sb=0 sd=0 mult=1 m=1
XMRD_sw_0100_1 rbl_sw_0100 sn_sw_0100_1 rwl_des 0 sky130_fd_pr__nfet_01v8 L=0.15 W=0.42 nf=1 ad=0.1218 as=0.1218 pd=1.42 ps=1.42 nrd=0.69047619047619 nrs=0.69047619047619 sa=0 sb=0 sd=0 mult=1 m=1
csn_sw_0100_1 sn_sw_0100_1 0 {C_SN}
XMWR_sw_0100_2 sn_sw_0100_2 0 wbl_sw_0100 0 sky130_fd_pr__nfet_01v8 L=0.15 W=0.42 nf=1 ad=0.1218 as=0.1218 pd=1.42 ps=1.42 nrd=0.69047619047619 nrs=0.69047619047619 sa=0 sb=0 sd=0 mult=1 m=1
XMRD_sw_0100_2 rbl_sw_0100 sn_sw_0100_2 rwl_des 0 sky130_fd_pr__nfet_01v8 L=0.15 W=0.42 nf=1 ad=0.1218 as=0.1218 pd=1.42 ps=1.42 nrd=0.69047619047619 nrs=0.69047619047619 sa=0 sb=0 sd=0 mult=1 m=1
csn_sw_0100_2 sn_sw_0100_2 0 {C_SN}
XMWR_sw_0100_3 sn_sw_0100_3 0 wbl_sw_0100 0 sky130_fd_pr__nfet_01v8 L=0.15 W=0.42 nf=1 ad=0.1218 as=0.1218 pd=1.42 ps=1.42 nrd=0.69047619047619 nrs=0.69047619047619 sa=0 sb=0 sd=0 mult=1 m=1
XMRD_sw_0100_3 rbl_sw_0100 sn_sw_0100_3 rwl_des 0 sky130_fd_pr__nfet_01v8 L=0.15 W=0.42 nf=1 ad=0.1218 as=0.1218 pd=1.42 ps=1.42 nrd=0.69047619047619 nrs=0.69047619047619 sa=0 sb=0 sd=0 mult=1 m=1
csn_sw_0100_3 sn_sw_0100_3 0 {C_SN}
crbl_sw_0100 rbl_sw_0100 0 {C_RBL}
cwbl_sw_0100 wbl_sw_0100 0 {C_WBL}
cref_sw_0100 ref_sw_0100 0 {C_RBL}   $ ASSUMPTION: ideal matched dummy load
spr_sw_0100 pref ref_sw_0100 pca 0 swpre   $ reference-side precharge stays an ideal switch
XMPPRE_sw_0100 rbl_sw_0100 pcb prea prea sky130_fd_pr__pfet_01v8 L=0.15 W=1 nf=1 ad=0.29 as=0.29 pd=2.58 ps=2.58 nrd=0.29 nrs=0.29 sa=0 sb=0 sd=0 mult=1 m=1
XMPU1_sw_0100 x_sw_0100 dinb1 vdd vdd sky130_fd_pr__pfet_01v8 L=0.15 W=1 nf=1 ad=0.29 as=0.29 pd=2.58 ps=2.58 nrd=0.29 nrs=0.29 sa=0 sb=0 sd=0 mult=1 m=1
XMPU2_sw_0100 wbl_sw_0100 wenb x_sw_0100 vdd sky130_fd_pr__pfet_01v8 L=0.15 W=1 nf=1 ad=0.29 as=0.29 pd=2.58 ps=2.58 nrd=0.29 nrs=0.29 sa=0 sb=0 sd=0 mult=1 m=1
XMND2_sw_0100 wbl_sw_0100 wen y_sw_0100 0 sky130_fd_pr__nfet_01v8 L=0.15 W=0.5 nf=1 ad=0.145 as=0.145 pd=1.58 ps=1.58 nrd=0.58 nrs=0.58 sa=0 sb=0 sd=0 mult=1 m=1
XMND1_sw_0100 y_sw_0100 dinb1 0 0 sky130_fd_pr__nfet_01v8 L=0.15 W=0.5 nf=1 ad=0.145 as=0.145 pd=1.58 ps=1.58 nrd=0.58 nrs=0.58 sa=0 sb=0 sd=0 mult=1 m=1
XMNI_sw_0100 wbl_sw_0100 wenb 0 0 sky130_fd_pr__nfet_01v8 L=0.15 W=0.42 nf=1 ad=0.1218 as=0.1218 pd=1.42 ps=1.42 nrd=0.69047619047619 nrs=0.69047619047619 sa=0 sb=0 sd=0 mult=1 m=1
XMNS_sw_0100 sbl_sw_0100 sel rbl_sw_0100 0 sky130_fd_pr__nfet_01v8 L=0.15 W=1 nf=1 ad=0.29 as=0.29 pd=2.58 ps=2.58 nrd=0.29 nrs=0.29 sa=0 sb=0 sd=0 mult=1 m=1
XMPS_sw_0100 sbl_sw_0100 selb rbl_sw_0100 vdd sky130_fd_pr__pfet_01v8 L=0.15 W=2 nf=1 ad=0.58 as=0.58 pd=4.58 ps=4.58 nrd=0.145 nrs=0.145 sa=0 sb=0 sd=0 mult=1 m=1
XMNSR_sw_0100 sref_sw_0100 sel ref_sw_0100 0 sky130_fd_pr__nfet_01v8 L=0.15 W=1 nf=1 ad=0.29 as=0.29 pd=2.58 ps=2.58 nrd=0.29 nrs=0.29 sa=0 sb=0 sd=0 mult=1 m=1
XMPSR_sw_0100 sref_sw_0100 selb ref_sw_0100 vdd sky130_fd_pr__pfet_01v8 L=0.15 W=2 nf=1 ad=0.58 as=0.58 pd=4.58 ps=4.58 nrd=0.145 nrs=0.145 sa=0 sb=0 sd=0 mult=1 m=1
XMN1_sw_0100 sbl_sw_0100 sref_sw_0100 vn_sw_0100 0 sky130_fd_pr__nfet_01v8 L=0.15 W=1 nf=1 ad=0.29 as=0.29 pd=2.58 ps=2.58 nrd=0.29 nrs=0.29 sa=0 sb=0 sd=0 mult=1 m=1
XMN2_sw_0100 sref_sw_0100 sbl_sw_0100 vn_sw_0100 0 sky130_fd_pr__nfet_01v8 L=0.15 W=1 nf=1 ad=0.29 as=0.29 pd=2.58 ps=2.58 nrd=0.29 nrs=0.29 sa=0 sb=0 sd=0 mult=1 m=1
XMP1_sw_0100 sbl_sw_0100 sref_sw_0100 vp_sw_0100 vdd sky130_fd_pr__pfet_01v8 L=0.15 W=2 nf=1 ad=0.58 as=0.58 pd=4.58 ps=4.58 nrd=0.145 nrs=0.145 sa=0 sb=0 sd=0 mult=1 m=1
XMP2_sw_0100 sref_sw_0100 sbl_sw_0100 vp_sw_0100 vdd sky130_fd_pr__pfet_01v8 L=0.15 W=2 nf=1 ad=0.58 as=0.58 pd=4.58 ps=4.58 nrd=0.145 nrs=0.145 sa=0 sb=0 sd=0 mult=1 m=1
XMNF_sw_0100 vn_sw_0100 en 0 0 sky130_fd_pr__nfet_01v8 L=0.15 W=2 nf=1 ad=0.58 as=0.58 pd=4.58 ps=4.58 nrd=0.145 nrs=0.145 sa=0 sb=0 sd=0 mult=1 m=1
XMPH_sw_0100 vp_sw_0100 enb vdd vdd sky130_fd_pr__pfet_01v8 L=0.15 W=4 nf=1 ad=1.16 as=1.16 pd=8.58 ps=8.58 nrd=0.0725 nrs=0.0725 sa=0 sb=0 sd=0 mult=1 m=1
bd_sw_0100 d_sw_0100 0 v=v(sbl_sw_0100)-v(sref_sw_0100)
bdabs_sw_0100 dabs_sw_0100 0 v=abs(v(sbl_sw_0100)-v(sref_sw_0100))

* ---- instance 5: sw_0200 ----
XMWR_sw_0200_0 sn_sw_0200_0 wl wbl_sw_0200 0 sky130_fd_pr__nfet_01v8 L=0.15 W=0.42 nf=1 ad=0.1218 as=0.1218 pd=1.42 ps=1.42 nrd=0.69047619047619 nrs=0.69047619047619 sa=0 sb=0 sd=0 mult=1 m=1
XMRD_sw_0200_0 rbl_sw_0200 sn_sw_0200_0 rwl_sel 0 sky130_fd_pr__nfet_01v8 L=0.15 W=0.42 nf=1 ad=0.1218 as=0.1218 pd=1.42 ps=1.42 nrd=0.69047619047619 nrs=0.69047619047619 sa=0 sb=0 sd=0 mult=1 m=1
csn_sw_0200_0 sn_sw_0200_0 0 {C_SN}
XMWR_sw_0200_1 sn_sw_0200_1 0 wbl_sw_0200 0 sky130_fd_pr__nfet_01v8 L=0.15 W=0.42 nf=1 ad=0.1218 as=0.1218 pd=1.42 ps=1.42 nrd=0.69047619047619 nrs=0.69047619047619 sa=0 sb=0 sd=0 mult=1 m=1
XMRD_sw_0200_1 rbl_sw_0200 sn_sw_0200_1 rwl_des 0 sky130_fd_pr__nfet_01v8 L=0.15 W=0.42 nf=1 ad=0.1218 as=0.1218 pd=1.42 ps=1.42 nrd=0.69047619047619 nrs=0.69047619047619 sa=0 sb=0 sd=0 mult=1 m=1
csn_sw_0200_1 sn_sw_0200_1 0 {C_SN}
XMWR_sw_0200_2 sn_sw_0200_2 0 wbl_sw_0200 0 sky130_fd_pr__nfet_01v8 L=0.15 W=0.42 nf=1 ad=0.1218 as=0.1218 pd=1.42 ps=1.42 nrd=0.69047619047619 nrs=0.69047619047619 sa=0 sb=0 sd=0 mult=1 m=1
XMRD_sw_0200_2 rbl_sw_0200 sn_sw_0200_2 rwl_des 0 sky130_fd_pr__nfet_01v8 L=0.15 W=0.42 nf=1 ad=0.1218 as=0.1218 pd=1.42 ps=1.42 nrd=0.69047619047619 nrs=0.69047619047619 sa=0 sb=0 sd=0 mult=1 m=1
csn_sw_0200_2 sn_sw_0200_2 0 {C_SN}
XMWR_sw_0200_3 sn_sw_0200_3 0 wbl_sw_0200 0 sky130_fd_pr__nfet_01v8 L=0.15 W=0.42 nf=1 ad=0.1218 as=0.1218 pd=1.42 ps=1.42 nrd=0.69047619047619 nrs=0.69047619047619 sa=0 sb=0 sd=0 mult=1 m=1
XMRD_sw_0200_3 rbl_sw_0200 sn_sw_0200_3 rwl_des 0 sky130_fd_pr__nfet_01v8 L=0.15 W=0.42 nf=1 ad=0.1218 as=0.1218 pd=1.42 ps=1.42 nrd=0.69047619047619 nrs=0.69047619047619 sa=0 sb=0 sd=0 mult=1 m=1
csn_sw_0200_3 sn_sw_0200_3 0 {C_SN}
crbl_sw_0200 rbl_sw_0200 0 {C_RBL}
cwbl_sw_0200 wbl_sw_0200 0 {C_WBL}
cref_sw_0200 ref_sw_0200 0 {C_RBL}   $ ASSUMPTION: ideal matched dummy load
spr_sw_0200 pref ref_sw_0200 pca 0 swpre   $ reference-side precharge stays an ideal switch
XMPPRE_sw_0200 rbl_sw_0200 pcb prea prea sky130_fd_pr__pfet_01v8 L=0.15 W=2 nf=1 ad=0.58 as=0.58 pd=4.58 ps=4.58 nrd=0.145 nrs=0.145 sa=0 sb=0 sd=0 mult=1 m=1
XMPU1_sw_0200 x_sw_0200 dinb1 vdd vdd sky130_fd_pr__pfet_01v8 L=0.15 W=1 nf=1 ad=0.29 as=0.29 pd=2.58 ps=2.58 nrd=0.29 nrs=0.29 sa=0 sb=0 sd=0 mult=1 m=1
XMPU2_sw_0200 wbl_sw_0200 wenb x_sw_0200 vdd sky130_fd_pr__pfet_01v8 L=0.15 W=1 nf=1 ad=0.29 as=0.29 pd=2.58 ps=2.58 nrd=0.29 nrs=0.29 sa=0 sb=0 sd=0 mult=1 m=1
XMND2_sw_0200 wbl_sw_0200 wen y_sw_0200 0 sky130_fd_pr__nfet_01v8 L=0.15 W=0.5 nf=1 ad=0.145 as=0.145 pd=1.58 ps=1.58 nrd=0.58 nrs=0.58 sa=0 sb=0 sd=0 mult=1 m=1
XMND1_sw_0200 y_sw_0200 dinb1 0 0 sky130_fd_pr__nfet_01v8 L=0.15 W=0.5 nf=1 ad=0.145 as=0.145 pd=1.58 ps=1.58 nrd=0.58 nrs=0.58 sa=0 sb=0 sd=0 mult=1 m=1
XMNI_sw_0200 wbl_sw_0200 wenb 0 0 sky130_fd_pr__nfet_01v8 L=0.15 W=0.42 nf=1 ad=0.1218 as=0.1218 pd=1.42 ps=1.42 nrd=0.69047619047619 nrs=0.69047619047619 sa=0 sb=0 sd=0 mult=1 m=1
XMNS_sw_0200 sbl_sw_0200 sel rbl_sw_0200 0 sky130_fd_pr__nfet_01v8 L=0.15 W=1 nf=1 ad=0.29 as=0.29 pd=2.58 ps=2.58 nrd=0.29 nrs=0.29 sa=0 sb=0 sd=0 mult=1 m=1
XMPS_sw_0200 sbl_sw_0200 selb rbl_sw_0200 vdd sky130_fd_pr__pfet_01v8 L=0.15 W=2 nf=1 ad=0.58 as=0.58 pd=4.58 ps=4.58 nrd=0.145 nrs=0.145 sa=0 sb=0 sd=0 mult=1 m=1
XMNSR_sw_0200 sref_sw_0200 sel ref_sw_0200 0 sky130_fd_pr__nfet_01v8 L=0.15 W=1 nf=1 ad=0.29 as=0.29 pd=2.58 ps=2.58 nrd=0.29 nrs=0.29 sa=0 sb=0 sd=0 mult=1 m=1
XMPSR_sw_0200 sref_sw_0200 selb ref_sw_0200 vdd sky130_fd_pr__pfet_01v8 L=0.15 W=2 nf=1 ad=0.58 as=0.58 pd=4.58 ps=4.58 nrd=0.145 nrs=0.145 sa=0 sb=0 sd=0 mult=1 m=1
XMN1_sw_0200 sbl_sw_0200 sref_sw_0200 vn_sw_0200 0 sky130_fd_pr__nfet_01v8 L=0.15 W=1 nf=1 ad=0.29 as=0.29 pd=2.58 ps=2.58 nrd=0.29 nrs=0.29 sa=0 sb=0 sd=0 mult=1 m=1
XMN2_sw_0200 sref_sw_0200 sbl_sw_0200 vn_sw_0200 0 sky130_fd_pr__nfet_01v8 L=0.15 W=1 nf=1 ad=0.29 as=0.29 pd=2.58 ps=2.58 nrd=0.29 nrs=0.29 sa=0 sb=0 sd=0 mult=1 m=1
XMP1_sw_0200 sbl_sw_0200 sref_sw_0200 vp_sw_0200 vdd sky130_fd_pr__pfet_01v8 L=0.15 W=2 nf=1 ad=0.58 as=0.58 pd=4.58 ps=4.58 nrd=0.145 nrs=0.145 sa=0 sb=0 sd=0 mult=1 m=1
XMP2_sw_0200 sref_sw_0200 sbl_sw_0200 vp_sw_0200 vdd sky130_fd_pr__pfet_01v8 L=0.15 W=2 nf=1 ad=0.58 as=0.58 pd=4.58 ps=4.58 nrd=0.145 nrs=0.145 sa=0 sb=0 sd=0 mult=1 m=1
XMNF_sw_0200 vn_sw_0200 en 0 0 sky130_fd_pr__nfet_01v8 L=0.15 W=2 nf=1 ad=0.58 as=0.58 pd=4.58 ps=4.58 nrd=0.145 nrs=0.145 sa=0 sb=0 sd=0 mult=1 m=1
XMPH_sw_0200 vp_sw_0200 enb vdd vdd sky130_fd_pr__pfet_01v8 L=0.15 W=4 nf=1 ad=1.16 as=1.16 pd=8.58 ps=8.58 nrd=0.0725 nrs=0.0725 sa=0 sb=0 sd=0 mult=1 m=1
bd_sw_0200 d_sw_0200 0 v=v(sbl_sw_0200)-v(sref_sw_0200)
bdabs_sw_0200 dabs_sw_0200 0 v=abs(v(sbl_sw_0200)-v(sref_sw_0200))

* ---- instance 6: sw_0400 ----
XMWR_sw_0400_0 sn_sw_0400_0 wl wbl_sw_0400 0 sky130_fd_pr__nfet_01v8 L=0.15 W=0.42 nf=1 ad=0.1218 as=0.1218 pd=1.42 ps=1.42 nrd=0.69047619047619 nrs=0.69047619047619 sa=0 sb=0 sd=0 mult=1 m=1
XMRD_sw_0400_0 rbl_sw_0400 sn_sw_0400_0 rwl_sel 0 sky130_fd_pr__nfet_01v8 L=0.15 W=0.42 nf=1 ad=0.1218 as=0.1218 pd=1.42 ps=1.42 nrd=0.69047619047619 nrs=0.69047619047619 sa=0 sb=0 sd=0 mult=1 m=1
csn_sw_0400_0 sn_sw_0400_0 0 {C_SN}
XMWR_sw_0400_1 sn_sw_0400_1 0 wbl_sw_0400 0 sky130_fd_pr__nfet_01v8 L=0.15 W=0.42 nf=1 ad=0.1218 as=0.1218 pd=1.42 ps=1.42 nrd=0.69047619047619 nrs=0.69047619047619 sa=0 sb=0 sd=0 mult=1 m=1
XMRD_sw_0400_1 rbl_sw_0400 sn_sw_0400_1 rwl_des 0 sky130_fd_pr__nfet_01v8 L=0.15 W=0.42 nf=1 ad=0.1218 as=0.1218 pd=1.42 ps=1.42 nrd=0.69047619047619 nrs=0.69047619047619 sa=0 sb=0 sd=0 mult=1 m=1
csn_sw_0400_1 sn_sw_0400_1 0 {C_SN}
XMWR_sw_0400_2 sn_sw_0400_2 0 wbl_sw_0400 0 sky130_fd_pr__nfet_01v8 L=0.15 W=0.42 nf=1 ad=0.1218 as=0.1218 pd=1.42 ps=1.42 nrd=0.69047619047619 nrs=0.69047619047619 sa=0 sb=0 sd=0 mult=1 m=1
XMRD_sw_0400_2 rbl_sw_0400 sn_sw_0400_2 rwl_des 0 sky130_fd_pr__nfet_01v8 L=0.15 W=0.42 nf=1 ad=0.1218 as=0.1218 pd=1.42 ps=1.42 nrd=0.69047619047619 nrs=0.69047619047619 sa=0 sb=0 sd=0 mult=1 m=1
csn_sw_0400_2 sn_sw_0400_2 0 {C_SN}
XMWR_sw_0400_3 sn_sw_0400_3 0 wbl_sw_0400 0 sky130_fd_pr__nfet_01v8 L=0.15 W=0.42 nf=1 ad=0.1218 as=0.1218 pd=1.42 ps=1.42 nrd=0.69047619047619 nrs=0.69047619047619 sa=0 sb=0 sd=0 mult=1 m=1
XMRD_sw_0400_3 rbl_sw_0400 sn_sw_0400_3 rwl_des 0 sky130_fd_pr__nfet_01v8 L=0.15 W=0.42 nf=1 ad=0.1218 as=0.1218 pd=1.42 ps=1.42 nrd=0.69047619047619 nrs=0.69047619047619 sa=0 sb=0 sd=0 mult=1 m=1
csn_sw_0400_3 sn_sw_0400_3 0 {C_SN}
crbl_sw_0400 rbl_sw_0400 0 {C_RBL}
cwbl_sw_0400 wbl_sw_0400 0 {C_WBL}
cref_sw_0400 ref_sw_0400 0 {C_RBL}   $ ASSUMPTION: ideal matched dummy load
spr_sw_0400 pref ref_sw_0400 pca 0 swpre   $ reference-side precharge stays an ideal switch
XMPPRE_sw_0400 rbl_sw_0400 pcb prea prea sky130_fd_pr__pfet_01v8 L=0.15 W=4 nf=1 ad=1.16 as=1.16 pd=8.58 ps=8.58 nrd=0.0725 nrs=0.0725 sa=0 sb=0 sd=0 mult=1 m=1
XMPU1_sw_0400 x_sw_0400 dinb1 vdd vdd sky130_fd_pr__pfet_01v8 L=0.15 W=1 nf=1 ad=0.29 as=0.29 pd=2.58 ps=2.58 nrd=0.29 nrs=0.29 sa=0 sb=0 sd=0 mult=1 m=1
XMPU2_sw_0400 wbl_sw_0400 wenb x_sw_0400 vdd sky130_fd_pr__pfet_01v8 L=0.15 W=1 nf=1 ad=0.29 as=0.29 pd=2.58 ps=2.58 nrd=0.29 nrs=0.29 sa=0 sb=0 sd=0 mult=1 m=1
XMND2_sw_0400 wbl_sw_0400 wen y_sw_0400 0 sky130_fd_pr__nfet_01v8 L=0.15 W=0.5 nf=1 ad=0.145 as=0.145 pd=1.58 ps=1.58 nrd=0.58 nrs=0.58 sa=0 sb=0 sd=0 mult=1 m=1
XMND1_sw_0400 y_sw_0400 dinb1 0 0 sky130_fd_pr__nfet_01v8 L=0.15 W=0.5 nf=1 ad=0.145 as=0.145 pd=1.58 ps=1.58 nrd=0.58 nrs=0.58 sa=0 sb=0 sd=0 mult=1 m=1
XMNI_sw_0400 wbl_sw_0400 wenb 0 0 sky130_fd_pr__nfet_01v8 L=0.15 W=0.42 nf=1 ad=0.1218 as=0.1218 pd=1.42 ps=1.42 nrd=0.69047619047619 nrs=0.69047619047619 sa=0 sb=0 sd=0 mult=1 m=1
XMNS_sw_0400 sbl_sw_0400 sel rbl_sw_0400 0 sky130_fd_pr__nfet_01v8 L=0.15 W=1 nf=1 ad=0.29 as=0.29 pd=2.58 ps=2.58 nrd=0.29 nrs=0.29 sa=0 sb=0 sd=0 mult=1 m=1
XMPS_sw_0400 sbl_sw_0400 selb rbl_sw_0400 vdd sky130_fd_pr__pfet_01v8 L=0.15 W=2 nf=1 ad=0.58 as=0.58 pd=4.58 ps=4.58 nrd=0.145 nrs=0.145 sa=0 sb=0 sd=0 mult=1 m=1
XMNSR_sw_0400 sref_sw_0400 sel ref_sw_0400 0 sky130_fd_pr__nfet_01v8 L=0.15 W=1 nf=1 ad=0.29 as=0.29 pd=2.58 ps=2.58 nrd=0.29 nrs=0.29 sa=0 sb=0 sd=0 mult=1 m=1
XMPSR_sw_0400 sref_sw_0400 selb ref_sw_0400 vdd sky130_fd_pr__pfet_01v8 L=0.15 W=2 nf=1 ad=0.58 as=0.58 pd=4.58 ps=4.58 nrd=0.145 nrs=0.145 sa=0 sb=0 sd=0 mult=1 m=1
XMN1_sw_0400 sbl_sw_0400 sref_sw_0400 vn_sw_0400 0 sky130_fd_pr__nfet_01v8 L=0.15 W=1 nf=1 ad=0.29 as=0.29 pd=2.58 ps=2.58 nrd=0.29 nrs=0.29 sa=0 sb=0 sd=0 mult=1 m=1
XMN2_sw_0400 sref_sw_0400 sbl_sw_0400 vn_sw_0400 0 sky130_fd_pr__nfet_01v8 L=0.15 W=1 nf=1 ad=0.29 as=0.29 pd=2.58 ps=2.58 nrd=0.29 nrs=0.29 sa=0 sb=0 sd=0 mult=1 m=1
XMP1_sw_0400 sbl_sw_0400 sref_sw_0400 vp_sw_0400 vdd sky130_fd_pr__pfet_01v8 L=0.15 W=2 nf=1 ad=0.58 as=0.58 pd=4.58 ps=4.58 nrd=0.145 nrs=0.145 sa=0 sb=0 sd=0 mult=1 m=1
XMP2_sw_0400 sref_sw_0400 sbl_sw_0400 vp_sw_0400 vdd sky130_fd_pr__pfet_01v8 L=0.15 W=2 nf=1 ad=0.58 as=0.58 pd=4.58 ps=4.58 nrd=0.145 nrs=0.145 sa=0 sb=0 sd=0 mult=1 m=1
XMNF_sw_0400 vn_sw_0400 en 0 0 sky130_fd_pr__nfet_01v8 L=0.15 W=2 nf=1 ad=0.58 as=0.58 pd=4.58 ps=4.58 nrd=0.145 nrs=0.145 sa=0 sb=0 sd=0 mult=1 m=1
XMPH_sw_0400 vp_sw_0400 enb vdd vdd sky130_fd_pr__pfet_01v8 L=0.15 W=4 nf=1 ad=1.16 as=1.16 pd=8.58 ps=8.58 nrd=0.0725 nrs=0.0725 sa=0 sb=0 sd=0 mult=1 m=1
bd_sw_0400 d_sw_0400 0 v=v(sbl_sw_0400)-v(sref_sw_0400)
bdabs_sw_0400 dabs_sw_0400 0 v=abs(v(sbl_sw_0400)-v(sref_sw_0400))

* ---- instance 7: sw_0800 ----
XMWR_sw_0800_0 sn_sw_0800_0 wl wbl_sw_0800 0 sky130_fd_pr__nfet_01v8 L=0.15 W=0.42 nf=1 ad=0.1218 as=0.1218 pd=1.42 ps=1.42 nrd=0.69047619047619 nrs=0.69047619047619 sa=0 sb=0 sd=0 mult=1 m=1
XMRD_sw_0800_0 rbl_sw_0800 sn_sw_0800_0 rwl_sel 0 sky130_fd_pr__nfet_01v8 L=0.15 W=0.42 nf=1 ad=0.1218 as=0.1218 pd=1.42 ps=1.42 nrd=0.69047619047619 nrs=0.69047619047619 sa=0 sb=0 sd=0 mult=1 m=1
csn_sw_0800_0 sn_sw_0800_0 0 {C_SN}
XMWR_sw_0800_1 sn_sw_0800_1 0 wbl_sw_0800 0 sky130_fd_pr__nfet_01v8 L=0.15 W=0.42 nf=1 ad=0.1218 as=0.1218 pd=1.42 ps=1.42 nrd=0.69047619047619 nrs=0.69047619047619 sa=0 sb=0 sd=0 mult=1 m=1
XMRD_sw_0800_1 rbl_sw_0800 sn_sw_0800_1 rwl_des 0 sky130_fd_pr__nfet_01v8 L=0.15 W=0.42 nf=1 ad=0.1218 as=0.1218 pd=1.42 ps=1.42 nrd=0.69047619047619 nrs=0.69047619047619 sa=0 sb=0 sd=0 mult=1 m=1
csn_sw_0800_1 sn_sw_0800_1 0 {C_SN}
XMWR_sw_0800_2 sn_sw_0800_2 0 wbl_sw_0800 0 sky130_fd_pr__nfet_01v8 L=0.15 W=0.42 nf=1 ad=0.1218 as=0.1218 pd=1.42 ps=1.42 nrd=0.69047619047619 nrs=0.69047619047619 sa=0 sb=0 sd=0 mult=1 m=1
XMRD_sw_0800_2 rbl_sw_0800 sn_sw_0800_2 rwl_des 0 sky130_fd_pr__nfet_01v8 L=0.15 W=0.42 nf=1 ad=0.1218 as=0.1218 pd=1.42 ps=1.42 nrd=0.69047619047619 nrs=0.69047619047619 sa=0 sb=0 sd=0 mult=1 m=1
csn_sw_0800_2 sn_sw_0800_2 0 {C_SN}
XMWR_sw_0800_3 sn_sw_0800_3 0 wbl_sw_0800 0 sky130_fd_pr__nfet_01v8 L=0.15 W=0.42 nf=1 ad=0.1218 as=0.1218 pd=1.42 ps=1.42 nrd=0.69047619047619 nrs=0.69047619047619 sa=0 sb=0 sd=0 mult=1 m=1
XMRD_sw_0800_3 rbl_sw_0800 sn_sw_0800_3 rwl_des 0 sky130_fd_pr__nfet_01v8 L=0.15 W=0.42 nf=1 ad=0.1218 as=0.1218 pd=1.42 ps=1.42 nrd=0.69047619047619 nrs=0.69047619047619 sa=0 sb=0 sd=0 mult=1 m=1
csn_sw_0800_3 sn_sw_0800_3 0 {C_SN}
crbl_sw_0800 rbl_sw_0800 0 {C_RBL}
cwbl_sw_0800 wbl_sw_0800 0 {C_WBL}
cref_sw_0800 ref_sw_0800 0 {C_RBL}   $ ASSUMPTION: ideal matched dummy load
spr_sw_0800 pref ref_sw_0800 pca 0 swpre   $ reference-side precharge stays an ideal switch
XMPPRE_sw_0800 rbl_sw_0800 pcb prea prea sky130_fd_pr__pfet_01v8 L=0.15 W=8 nf=1 ad=2.32 as=2.32 pd=16.58 ps=16.58 nrd=0.03625 nrs=0.03625 sa=0 sb=0 sd=0 mult=1 m=1
XMPU1_sw_0800 x_sw_0800 dinb1 vdd vdd sky130_fd_pr__pfet_01v8 L=0.15 W=1 nf=1 ad=0.29 as=0.29 pd=2.58 ps=2.58 nrd=0.29 nrs=0.29 sa=0 sb=0 sd=0 mult=1 m=1
XMPU2_sw_0800 wbl_sw_0800 wenb x_sw_0800 vdd sky130_fd_pr__pfet_01v8 L=0.15 W=1 nf=1 ad=0.29 as=0.29 pd=2.58 ps=2.58 nrd=0.29 nrs=0.29 sa=0 sb=0 sd=0 mult=1 m=1
XMND2_sw_0800 wbl_sw_0800 wen y_sw_0800 0 sky130_fd_pr__nfet_01v8 L=0.15 W=0.5 nf=1 ad=0.145 as=0.145 pd=1.58 ps=1.58 nrd=0.58 nrs=0.58 sa=0 sb=0 sd=0 mult=1 m=1
XMND1_sw_0800 y_sw_0800 dinb1 0 0 sky130_fd_pr__nfet_01v8 L=0.15 W=0.5 nf=1 ad=0.145 as=0.145 pd=1.58 ps=1.58 nrd=0.58 nrs=0.58 sa=0 sb=0 sd=0 mult=1 m=1
XMNI_sw_0800 wbl_sw_0800 wenb 0 0 sky130_fd_pr__nfet_01v8 L=0.15 W=0.42 nf=1 ad=0.1218 as=0.1218 pd=1.42 ps=1.42 nrd=0.69047619047619 nrs=0.69047619047619 sa=0 sb=0 sd=0 mult=1 m=1
XMNS_sw_0800 sbl_sw_0800 sel rbl_sw_0800 0 sky130_fd_pr__nfet_01v8 L=0.15 W=1 nf=1 ad=0.29 as=0.29 pd=2.58 ps=2.58 nrd=0.29 nrs=0.29 sa=0 sb=0 sd=0 mult=1 m=1
XMPS_sw_0800 sbl_sw_0800 selb rbl_sw_0800 vdd sky130_fd_pr__pfet_01v8 L=0.15 W=2 nf=1 ad=0.58 as=0.58 pd=4.58 ps=4.58 nrd=0.145 nrs=0.145 sa=0 sb=0 sd=0 mult=1 m=1
XMNSR_sw_0800 sref_sw_0800 sel ref_sw_0800 0 sky130_fd_pr__nfet_01v8 L=0.15 W=1 nf=1 ad=0.29 as=0.29 pd=2.58 ps=2.58 nrd=0.29 nrs=0.29 sa=0 sb=0 sd=0 mult=1 m=1
XMPSR_sw_0800 sref_sw_0800 selb ref_sw_0800 vdd sky130_fd_pr__pfet_01v8 L=0.15 W=2 nf=1 ad=0.58 as=0.58 pd=4.58 ps=4.58 nrd=0.145 nrs=0.145 sa=0 sb=0 sd=0 mult=1 m=1
XMN1_sw_0800 sbl_sw_0800 sref_sw_0800 vn_sw_0800 0 sky130_fd_pr__nfet_01v8 L=0.15 W=1 nf=1 ad=0.29 as=0.29 pd=2.58 ps=2.58 nrd=0.29 nrs=0.29 sa=0 sb=0 sd=0 mult=1 m=1
XMN2_sw_0800 sref_sw_0800 sbl_sw_0800 vn_sw_0800 0 sky130_fd_pr__nfet_01v8 L=0.15 W=1 nf=1 ad=0.29 as=0.29 pd=2.58 ps=2.58 nrd=0.29 nrs=0.29 sa=0 sb=0 sd=0 mult=1 m=1
XMP1_sw_0800 sbl_sw_0800 sref_sw_0800 vp_sw_0800 vdd sky130_fd_pr__pfet_01v8 L=0.15 W=2 nf=1 ad=0.58 as=0.58 pd=4.58 ps=4.58 nrd=0.145 nrs=0.145 sa=0 sb=0 sd=0 mult=1 m=1
XMP2_sw_0800 sref_sw_0800 sbl_sw_0800 vp_sw_0800 vdd sky130_fd_pr__pfet_01v8 L=0.15 W=2 nf=1 ad=0.58 as=0.58 pd=4.58 ps=4.58 nrd=0.145 nrs=0.145 sa=0 sb=0 sd=0 mult=1 m=1
XMNF_sw_0800 vn_sw_0800 en 0 0 sky130_fd_pr__nfet_01v8 L=0.15 W=2 nf=1 ad=0.58 as=0.58 pd=4.58 ps=4.58 nrd=0.145 nrs=0.145 sa=0 sb=0 sd=0 mult=1 m=1
XMPH_sw_0800 vp_sw_0800 enb vdd vdd sky130_fd_pr__pfet_01v8 L=0.15 W=4 nf=1 ad=1.16 as=1.16 pd=8.58 ps=8.58 nrd=0.0725 nrs=0.0725 sa=0 sb=0 sd=0 mult=1 m=1
bd_sw_0800 d_sw_0800 0 v=v(sbl_sw_0800)-v(sref_sw_0800)
bdabs_sw_0800 dabs_sw_0800 0 v=abs(v(sbl_sw_0800)-v(sref_sw_0800))

* initial conditions (tran uic): rbl fully discharged, stored levels, tail nodes
.ic v(sn_ideal_w1_0)=0 v(sn_ideal_w1_1)=1 v(sn_ideal_w1_2)=1 v(sn_ideal_w1_3)=1 v(rbl_ideal_w1)=0 v(ref_ideal_w1)=0.8
.ic v(wbl_ideal_w1)=0 v(vn_ideal_w1)=0.45 v(vp_ideal_w1)=1.35 v(sn_ideal_w0_0)=1 v(sn_ideal_w0_1)=0 v(sn_ideal_w0_2)=0
.ic v(sn_ideal_w0_3)=0 v(rbl_ideal_w0)=0 v(ref_ideal_w0)=0.8 v(wbl_ideal_w0)=0 v(vn_ideal_w0)=0.45 v(vp_ideal_w0)=1.35
.ic v(sn_real_w1_0)=0 v(sn_real_w1_1)=1 v(sn_real_w1_2)=1 v(sn_real_w1_3)=1 v(rbl_real_w1)=0 v(ref_real_w1)=0.8
.ic v(wbl_real_w1)=0 v(sbl_real_w1)=0 v(sref_real_w1)=0.8 v(vn_real_w1)=0.45 v(vp_real_w1)=1.35 v(sn_real_w0_0)=1
.ic v(sn_real_w0_1)=0 v(sn_real_w0_2)=0 v(sn_real_w0_3)=0 v(rbl_real_w0)=0 v(ref_real_w0)=0.8 v(wbl_real_w0)=0
.ic v(sbl_real_w0)=0 v(sref_real_w0)=0.8 v(vn_real_w0)=0.45 v(vp_real_w0)=1.35 v(sn_sw_0100_0)=0 v(sn_sw_0100_1)=1
.ic v(sn_sw_0100_2)=1 v(sn_sw_0100_3)=1 v(rbl_sw_0100)=0 v(ref_sw_0100)=0.8 v(wbl_sw_0100)=0 v(sbl_sw_0100)=0
.ic v(sref_sw_0100)=0.8 v(vn_sw_0100)=0.45 v(vp_sw_0100)=1.35 v(sn_sw_0200_0)=0 v(sn_sw_0200_1)=1 v(sn_sw_0200_2)=1
.ic v(sn_sw_0200_3)=1 v(rbl_sw_0200)=0 v(ref_sw_0200)=0.8 v(wbl_sw_0200)=0 v(sbl_sw_0200)=0 v(sref_sw_0200)=0.8
.ic v(vn_sw_0200)=0.45 v(vp_sw_0200)=1.35 v(sn_sw_0400_0)=0 v(sn_sw_0400_1)=1 v(sn_sw_0400_2)=1 v(sn_sw_0400_3)=1
.ic v(rbl_sw_0400)=0 v(ref_sw_0400)=0.8 v(wbl_sw_0400)=0 v(sbl_sw_0400)=0 v(sref_sw_0400)=0.8 v(vn_sw_0400)=0.45
.ic v(vp_sw_0400)=1.35 v(sn_sw_0800_0)=0 v(sn_sw_0800_1)=1 v(sn_sw_0800_2)=1 v(sn_sw_0800_3)=1 v(rbl_sw_0800)=0
.ic v(ref_sw_0800)=0.8 v(wbl_sw_0800)=0 v(sbl_sw_0800)=0 v(sref_sw_0800)=0.8 v(vn_sw_0800)=0.45 v(vp_sw_0800)=1.35
