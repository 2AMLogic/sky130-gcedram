* isolation_mc.spice -- Monte Carlo offset of the isolation pair -- GENERATED by gen_isolation_study.py (issue #117); do not edit by hand.
*
* Follow-up to sim/column-periphery (issue #114). PROPOSED/UNRATIFIED SCOPE: corners from
* spec/operating-range-decision-PROPOSED.md (27 C and 125 C only). Inputs follow
* sim/loaded-column/cold-corner/SENSE_INPUT_CONTRACT.md (baseline column).
* CIRCUIT BODY for `klt sim`: no .control/.end; PDK .lib/.temp cards are appended per corner.
*
* Instance kinds: ideal_w<d> = existing ideal sources (the #114 control); <tag>_w<d> = designed
* slice with the per-instance overrides listed in the README; d = data written to row 0.
* Per-instance isolation sources vs_<name>/vsb_<name> close the gates `lead` before the enable.
*
* ASSUMPTIONS (labelled; none is a spec value): C_RBL, C_WBL, VRBL, vpre rail an ideal 0.9 V
* source, 4-row column, all four SN at one level before the write except the written row,
* sense instant, reference level, ideal reference-side precharge and matched dummy load, ideal
* digital control edges (100 ps). sbl/sref carry only device parasitics unless csb is set.

.param VDD     = 1.8
.param VRBL    = 0.9   $ ASSUMPTION (contract)
.param VREF    = 0.8   $ ASSUMPTION: VRBL - 0.1 V (as sense-stage)
.param TEDGE   = 1e-10
.param C_RBL   = 1e-14   $ ASSUMPTION (contract; not extracted)
.param C_WBL   = 1e-14   $ ASSUMPTION (not extracted)
.param C_SN    = 6.72741e-16   $ extracted-from-netlist (layout/gain_cell_2t.extract.parasitics.json)

* ---- shared control (ideal digital edges) ----
vdd   vdd 0 dc {VDD}
vpca  pca 0 pwl(0 0 1e-09 0 1.1e-09 {VDD} 5.8e-08 {VDD} 5.81e-08 0)
vpcb  pcb 0 pwl(0 {VDD} 1e-09 {VDD} 1.1e-09 0 5.8e-08 0 5.81e-08 {VDD})
vwen  wen 0 pwl(0 0 1e-08 0 1.01e-08 {VDD} 3.4e-08 {VDD} 3.41e-08 0)
vwenb wenb 0 pwl(0 {VDD} 1e-08 {VDD} 1.01e-08 0 3.4e-08 0 3.41e-08 {VDD})
vdinb1 dinb1 0 dc 0          $ data '1': wbl = NOT dinb = VDD
vdinb0 dinb0 0 dc {VDD}      $ data '0'
vwl   wl 0 pwl(0 0 1.2e-08 0 1.21e-08 {VDD} 3.2e-08 {VDD} 3.21e-08 0)
vrwls rwl_sel 0 pwl(0 {VDD} 6e-08 {VDD} 6.01e-08 0)
vrwld rwl_des 0 dc {VDD}
ven   en  0 pwl(0 0 7e-08 0 7.01e-08 {VDD})
venb  enb 0 pwl(0 {VDD} 7e-08 {VDD} 7.01e-08 0)
vprea prea 0 dc {VRBL}       $ ASSUMPTION: ideal 0.9 V precharge rail
vpref pref 0 dc {VREF}
.model swpre sw(vt=0.9 vh=0.1 ron=100 roff=1e12)
vpca_100 pca_100 0 pwl(0 0 1e-09 0 1.1e-09 {VDD} 5.8e-08 {VDD} 5.81e-08 0)
vpcb_100 pcb_100 0 pwl(0 {VDD} 1e-09 {VDD} 1.1e-09 0 5.8e-08 0 5.81e-08 {VDD})
vsel_69500  sel_69500  0 pwl(0 {VDD} 6.95e-08 {VDD} 6.96e-08 0)
vselb_69500 selb_69500 0 pwl(0 0 6.95e-08 0 6.96e-08 {VDD})

* ---- instance 0: ideal_w1_r0 ----
XMWR_ideal_w1_r0_0 sn_ideal_w1_r0_0 wl wbl_ideal_w1_r0 0 sky130_fd_pr__nfet_01v8 L=0.15 W=0.42 nf=1 ad=0.1218 as=0.1218 pd=1.42 ps=1.42 nrd=0.69047619047619 nrs=0.69047619047619 sa=0 sb=0 sd=0 mult=1 m=1
XMRD_ideal_w1_r0_0 rbl_ideal_w1_r0 sn_ideal_w1_r0_0 rwl_sel 0 sky130_fd_pr__nfet_01v8 L=0.15 W=0.42 nf=1 ad=0.1218 as=0.1218 pd=1.42 ps=1.42 nrd=0.69047619047619 nrs=0.69047619047619 sa=0 sb=0 sd=0 mult=1 m=1
csn_ideal_w1_r0_0 sn_ideal_w1_r0_0 0 {C_SN}
XMWR_ideal_w1_r0_1 sn_ideal_w1_r0_1 0 wbl_ideal_w1_r0 0 sky130_fd_pr__nfet_01v8 L=0.15 W=0.42 nf=1 ad=0.1218 as=0.1218 pd=1.42 ps=1.42 nrd=0.69047619047619 nrs=0.69047619047619 sa=0 sb=0 sd=0 mult=1 m=1
XMRD_ideal_w1_r0_1 rbl_ideal_w1_r0 sn_ideal_w1_r0_1 rwl_des 0 sky130_fd_pr__nfet_01v8 L=0.15 W=0.42 nf=1 ad=0.1218 as=0.1218 pd=1.42 ps=1.42 nrd=0.69047619047619 nrs=0.69047619047619 sa=0 sb=0 sd=0 mult=1 m=1
csn_ideal_w1_r0_1 sn_ideal_w1_r0_1 0 {C_SN}
XMWR_ideal_w1_r0_2 sn_ideal_w1_r0_2 0 wbl_ideal_w1_r0 0 sky130_fd_pr__nfet_01v8 L=0.15 W=0.42 nf=1 ad=0.1218 as=0.1218 pd=1.42 ps=1.42 nrd=0.69047619047619 nrs=0.69047619047619 sa=0 sb=0 sd=0 mult=1 m=1
XMRD_ideal_w1_r0_2 rbl_ideal_w1_r0 sn_ideal_w1_r0_2 rwl_des 0 sky130_fd_pr__nfet_01v8 L=0.15 W=0.42 nf=1 ad=0.1218 as=0.1218 pd=1.42 ps=1.42 nrd=0.69047619047619 nrs=0.69047619047619 sa=0 sb=0 sd=0 mult=1 m=1
csn_ideal_w1_r0_2 sn_ideal_w1_r0_2 0 {C_SN}
XMWR_ideal_w1_r0_3 sn_ideal_w1_r0_3 0 wbl_ideal_w1_r0 0 sky130_fd_pr__nfet_01v8 L=0.15 W=0.42 nf=1 ad=0.1218 as=0.1218 pd=1.42 ps=1.42 nrd=0.69047619047619 nrs=0.69047619047619 sa=0 sb=0 sd=0 mult=1 m=1
XMRD_ideal_w1_r0_3 rbl_ideal_w1_r0 sn_ideal_w1_r0_3 rwl_des 0 sky130_fd_pr__nfet_01v8 L=0.15 W=0.42 nf=1 ad=0.1218 as=0.1218 pd=1.42 ps=1.42 nrd=0.69047619047619 nrs=0.69047619047619 sa=0 sb=0 sd=0 mult=1 m=1
csn_ideal_w1_r0_3 sn_ideal_w1_r0_3 0 {C_SN}
crbl_ideal_w1_r0 rbl_ideal_w1_r0 0 {C_RBL}
cwbl_ideal_w1_r0 wbl_ideal_w1_r0 0 {C_WBL}
cref_ideal_w1_r0 ref_ideal_w1_r0 0 {C_RBL}   $ ASSUMPTION: ideal matched dummy load
spr_ideal_w1_r0 pref ref_ideal_w1_r0 pca 0 swpre   $ reference-side precharge: ideal switch (#114 convention)
spa_ideal_w1_r0 prea rbl_ideal_w1_r0 pca 0 swpre   $ existing ideal precharge switch
vwbl_ideal_w1_r0 wbl_ideal_w1_r0 0 pwl(0 0 1e-08 0 1.01e-08 {VDD} 3.4e-08 {VDD} 3.41e-08 0)   $ ideal write source
XMN1_ideal_w1_r0 rbl_ideal_w1_r0 ref_ideal_w1_r0 vn_ideal_w1_r0 0 sky130_fd_pr__nfet_01v8 L=0.15 W=1 nf=1 ad=0.29 as=0.29 pd=2.58 ps=2.58 nrd=0.29 nrs=0.29 sa=0 sb=0 sd=0 mult=1 m=1
XMN2_ideal_w1_r0 ref_ideal_w1_r0 rbl_ideal_w1_r0 vn_ideal_w1_r0 0 sky130_fd_pr__nfet_01v8 L=0.15 W=1 nf=1 ad=0.29 as=0.29 pd=2.58 ps=2.58 nrd=0.29 nrs=0.29 sa=0 sb=0 sd=0 mult=1 m=1
XMP1_ideal_w1_r0 rbl_ideal_w1_r0 ref_ideal_w1_r0 vp_ideal_w1_r0 vdd sky130_fd_pr__pfet_01v8 L=0.15 W=2 nf=1 ad=0.58 as=0.58 pd=4.58 ps=4.58 nrd=0.145 nrs=0.145 sa=0 sb=0 sd=0 mult=1 m=1
XMP2_ideal_w1_r0 ref_ideal_w1_r0 rbl_ideal_w1_r0 vp_ideal_w1_r0 vdd sky130_fd_pr__pfet_01v8 L=0.15 W=2 nf=1 ad=0.58 as=0.58 pd=4.58 ps=4.58 nrd=0.145 nrs=0.145 sa=0 sb=0 sd=0 mult=1 m=1
XMNF_ideal_w1_r0 vn_ideal_w1_r0 en 0 0 sky130_fd_pr__nfet_01v8 L=0.15 W=2 nf=1 ad=0.58 as=0.58 pd=4.58 ps=4.58 nrd=0.145 nrs=0.145 sa=0 sb=0 sd=0 mult=1 m=1
XMPH_ideal_w1_r0 vp_ideal_w1_r0 enb vdd vdd sky130_fd_pr__pfet_01v8 L=0.15 W=4 nf=1 ad=1.16 as=1.16 pd=8.58 ps=8.58 nrd=0.0725 nrs=0.0725 sa=0 sb=0 sd=0 mult=1 m=1
bd_ideal_w1_r0 d_ideal_w1_r0 0 v=v(rbl_ideal_w1_r0)-v(ref_ideal_w1_r0)
bdabs_ideal_w1_r0 dabs_ideal_w1_r0 0 v=abs(v(rbl_ideal_w1_r0)-v(ref_ideal_w1_r0))

* ---- instance 1: i00_w1_r0 (baseline: TG nfet 1.0 / pfet 2.0, dummy 1x, lead 0.5 ns) ----
XMWR_i00_w1_r0_0 sn_i00_w1_r0_0 wl wbl_i00_w1_r0 0 sky130_fd_pr__nfet_01v8 L=0.15 W=0.42 nf=1 ad=0.1218 as=0.1218 pd=1.42 ps=1.42 nrd=0.69047619047619 nrs=0.69047619047619 sa=0 sb=0 sd=0 mult=1 m=1
XMRD_i00_w1_r0_0 rbl_i00_w1_r0 sn_i00_w1_r0_0 rwl_sel 0 sky130_fd_pr__nfet_01v8 L=0.15 W=0.42 nf=1 ad=0.1218 as=0.1218 pd=1.42 ps=1.42 nrd=0.69047619047619 nrs=0.69047619047619 sa=0 sb=0 sd=0 mult=1 m=1
csn_i00_w1_r0_0 sn_i00_w1_r0_0 0 {C_SN}
XMWR_i00_w1_r0_1 sn_i00_w1_r0_1 0 wbl_i00_w1_r0 0 sky130_fd_pr__nfet_01v8 L=0.15 W=0.42 nf=1 ad=0.1218 as=0.1218 pd=1.42 ps=1.42 nrd=0.69047619047619 nrs=0.69047619047619 sa=0 sb=0 sd=0 mult=1 m=1
XMRD_i00_w1_r0_1 rbl_i00_w1_r0 sn_i00_w1_r0_1 rwl_des 0 sky130_fd_pr__nfet_01v8 L=0.15 W=0.42 nf=1 ad=0.1218 as=0.1218 pd=1.42 ps=1.42 nrd=0.69047619047619 nrs=0.69047619047619 sa=0 sb=0 sd=0 mult=1 m=1
csn_i00_w1_r0_1 sn_i00_w1_r0_1 0 {C_SN}
XMWR_i00_w1_r0_2 sn_i00_w1_r0_2 0 wbl_i00_w1_r0 0 sky130_fd_pr__nfet_01v8 L=0.15 W=0.42 nf=1 ad=0.1218 as=0.1218 pd=1.42 ps=1.42 nrd=0.69047619047619 nrs=0.69047619047619 sa=0 sb=0 sd=0 mult=1 m=1
XMRD_i00_w1_r0_2 rbl_i00_w1_r0 sn_i00_w1_r0_2 rwl_des 0 sky130_fd_pr__nfet_01v8 L=0.15 W=0.42 nf=1 ad=0.1218 as=0.1218 pd=1.42 ps=1.42 nrd=0.69047619047619 nrs=0.69047619047619 sa=0 sb=0 sd=0 mult=1 m=1
csn_i00_w1_r0_2 sn_i00_w1_r0_2 0 {C_SN}
XMWR_i00_w1_r0_3 sn_i00_w1_r0_3 0 wbl_i00_w1_r0 0 sky130_fd_pr__nfet_01v8 L=0.15 W=0.42 nf=1 ad=0.1218 as=0.1218 pd=1.42 ps=1.42 nrd=0.69047619047619 nrs=0.69047619047619 sa=0 sb=0 sd=0 mult=1 m=1
XMRD_i00_w1_r0_3 rbl_i00_w1_r0 sn_i00_w1_r0_3 rwl_des 0 sky130_fd_pr__nfet_01v8 L=0.15 W=0.42 nf=1 ad=0.1218 as=0.1218 pd=1.42 ps=1.42 nrd=0.69047619047619 nrs=0.69047619047619 sa=0 sb=0 sd=0 mult=1 m=1
csn_i00_w1_r0_3 sn_i00_w1_r0_3 0 {C_SN}
crbl_i00_w1_r0 rbl_i00_w1_r0 0 {C_RBL}
cwbl_i00_w1_r0 wbl_i00_w1_r0 0 {C_WBL}
cref_i00_w1_r0 ref_i00_w1_r0 0 {C_RBL}   $ ASSUMPTION: ideal matched dummy load
spr_i00_w1_r0 pref ref_i00_w1_r0 pca 0 swpre   $ reference-side precharge: ideal switch (#114 convention)
XMPPRE_i00_w1_r0 rbl_i00_w1_r0 pcb_100 prea prea sky130_fd_pr__pfet_01v8 L=0.15 W=4 nf=1 ad=1.16 as=1.16 pd=8.58 ps=8.58 nrd=0.0725 nrs=0.0725 sa=0 sb=0 sd=0 mult=1 m=1
XMPU1_i00_w1_r0 x_i00_w1_r0 dinb1 vdd vdd sky130_fd_pr__pfet_01v8 L=0.15 W=1 nf=1 ad=0.29 as=0.29 pd=2.58 ps=2.58 nrd=0.29 nrs=0.29 sa=0 sb=0 sd=0 mult=1 m=1
XMPU2_i00_w1_r0 wbl_i00_w1_r0 wenb x_i00_w1_r0 vdd sky130_fd_pr__pfet_01v8 L=0.15 W=1 nf=1 ad=0.29 as=0.29 pd=2.58 ps=2.58 nrd=0.29 nrs=0.29 sa=0 sb=0 sd=0 mult=1 m=1
XMND2_i00_w1_r0 wbl_i00_w1_r0 wen y_i00_w1_r0 0 sky130_fd_pr__nfet_01v8 L=0.15 W=0.5 nf=1 ad=0.145 as=0.145 pd=1.58 ps=1.58 nrd=0.58 nrs=0.58 sa=0 sb=0 sd=0 mult=1 m=1
XMND1_i00_w1_r0 y_i00_w1_r0 dinb1 0 0 sky130_fd_pr__nfet_01v8 L=0.15 W=0.5 nf=1 ad=0.145 as=0.145 pd=1.58 ps=1.58 nrd=0.58 nrs=0.58 sa=0 sb=0 sd=0 mult=1 m=1
XMNI_i00_w1_r0 wbl_i00_w1_r0 wenb 0 0 sky130_fd_pr__nfet_01v8 L=0.15 W=0.42 nf=1 ad=0.1218 as=0.1218 pd=1.42 ps=1.42 nrd=0.69047619047619 nrs=0.69047619047619 sa=0 sb=0 sd=0 mult=1 m=1
XMNS_i00_w1_r0 sbl_i00_w1_r0 sel_69500 rbl_i00_w1_r0 0 sky130_fd_pr__nfet_01v8 L=0.15 W=1 nf=1 ad=0.29 as=0.29 pd=2.58 ps=2.58 nrd=0.29 nrs=0.29 sa=0 sb=0 sd=0 mult=1 m=1
XMPS_i00_w1_r0 sbl_i00_w1_r0 selb_69500 rbl_i00_w1_r0 vdd sky130_fd_pr__pfet_01v8 L=0.15 W=2 nf=1 ad=0.58 as=0.58 pd=4.58 ps=4.58 nrd=0.145 nrs=0.145 sa=0 sb=0 sd=0 mult=1 m=1
XMNSR_i00_w1_r0 sref_i00_w1_r0 sel_69500 ref_i00_w1_r0 0 sky130_fd_pr__nfet_01v8 L=0.15 W=1 nf=1 ad=0.29 as=0.29 pd=2.58 ps=2.58 nrd=0.29 nrs=0.29 sa=0 sb=0 sd=0 mult=1 m=1
XMPSR_i00_w1_r0 sref_i00_w1_r0 selb_69500 ref_i00_w1_r0 vdd sky130_fd_pr__pfet_01v8 L=0.15 W=2 nf=1 ad=0.58 as=0.58 pd=4.58 ps=4.58 nrd=0.145 nrs=0.145 sa=0 sb=0 sd=0 mult=1 m=1
XMN1_i00_w1_r0 sbl_i00_w1_r0 sref_i00_w1_r0 vn_i00_w1_r0 0 sky130_fd_pr__nfet_01v8 L=0.15 W=1 nf=1 ad=0.29 as=0.29 pd=2.58 ps=2.58 nrd=0.29 nrs=0.29 sa=0 sb=0 sd=0 mult=1 m=1
XMN2_i00_w1_r0 sref_i00_w1_r0 sbl_i00_w1_r0 vn_i00_w1_r0 0 sky130_fd_pr__nfet_01v8 L=0.15 W=1 nf=1 ad=0.29 as=0.29 pd=2.58 ps=2.58 nrd=0.29 nrs=0.29 sa=0 sb=0 sd=0 mult=1 m=1
XMP1_i00_w1_r0 sbl_i00_w1_r0 sref_i00_w1_r0 vp_i00_w1_r0 vdd sky130_fd_pr__pfet_01v8 L=0.15 W=2 nf=1 ad=0.58 as=0.58 pd=4.58 ps=4.58 nrd=0.145 nrs=0.145 sa=0 sb=0 sd=0 mult=1 m=1
XMP2_i00_w1_r0 sref_i00_w1_r0 sbl_i00_w1_r0 vp_i00_w1_r0 vdd sky130_fd_pr__pfet_01v8 L=0.15 W=2 nf=1 ad=0.58 as=0.58 pd=4.58 ps=4.58 nrd=0.145 nrs=0.145 sa=0 sb=0 sd=0 mult=1 m=1
XMNF_i00_w1_r0 vn_i00_w1_r0 en 0 0 sky130_fd_pr__nfet_01v8 L=0.15 W=2 nf=1 ad=0.58 as=0.58 pd=4.58 ps=4.58 nrd=0.145 nrs=0.145 sa=0 sb=0 sd=0 mult=1 m=1
XMPH_i00_w1_r0 vp_i00_w1_r0 enb vdd vdd sky130_fd_pr__pfet_01v8 L=0.15 W=4 nf=1 ad=1.16 as=1.16 pd=8.58 ps=8.58 nrd=0.0725 nrs=0.0725 sa=0 sb=0 sd=0 mult=1 m=1
bd_i00_w1_r0 d_i00_w1_r0 0 v=v(sbl_i00_w1_r0)-v(sref_i00_w1_r0)
bdabs_i00_w1_r0 dabs_i00_w1_r0 0 v=abs(v(sbl_i00_w1_r0)-v(sref_i00_w1_r0))

* ---- instance 2: f00_w1_r0 (FINAL: nfet-only 0.42 isolation, matched ref precharge 5.0, MND1/MND2 4.0, MNI 2.0) ----
XMWR_f00_w1_r0_0 sn_f00_w1_r0_0 wl wbl_f00_w1_r0 0 sky130_fd_pr__nfet_01v8 L=0.15 W=0.42 nf=1 ad=0.1218 as=0.1218 pd=1.42 ps=1.42 nrd=0.69047619047619 nrs=0.69047619047619 sa=0 sb=0 sd=0 mult=1 m=1
XMRD_f00_w1_r0_0 rbl_f00_w1_r0 sn_f00_w1_r0_0 rwl_sel 0 sky130_fd_pr__nfet_01v8 L=0.15 W=0.42 nf=1 ad=0.1218 as=0.1218 pd=1.42 ps=1.42 nrd=0.69047619047619 nrs=0.69047619047619 sa=0 sb=0 sd=0 mult=1 m=1
csn_f00_w1_r0_0 sn_f00_w1_r0_0 0 {C_SN}
XMWR_f00_w1_r0_1 sn_f00_w1_r0_1 0 wbl_f00_w1_r0 0 sky130_fd_pr__nfet_01v8 L=0.15 W=0.42 nf=1 ad=0.1218 as=0.1218 pd=1.42 ps=1.42 nrd=0.69047619047619 nrs=0.69047619047619 sa=0 sb=0 sd=0 mult=1 m=1
XMRD_f00_w1_r0_1 rbl_f00_w1_r0 sn_f00_w1_r0_1 rwl_des 0 sky130_fd_pr__nfet_01v8 L=0.15 W=0.42 nf=1 ad=0.1218 as=0.1218 pd=1.42 ps=1.42 nrd=0.69047619047619 nrs=0.69047619047619 sa=0 sb=0 sd=0 mult=1 m=1
csn_f00_w1_r0_1 sn_f00_w1_r0_1 0 {C_SN}
XMWR_f00_w1_r0_2 sn_f00_w1_r0_2 0 wbl_f00_w1_r0 0 sky130_fd_pr__nfet_01v8 L=0.15 W=0.42 nf=1 ad=0.1218 as=0.1218 pd=1.42 ps=1.42 nrd=0.69047619047619 nrs=0.69047619047619 sa=0 sb=0 sd=0 mult=1 m=1
XMRD_f00_w1_r0_2 rbl_f00_w1_r0 sn_f00_w1_r0_2 rwl_des 0 sky130_fd_pr__nfet_01v8 L=0.15 W=0.42 nf=1 ad=0.1218 as=0.1218 pd=1.42 ps=1.42 nrd=0.69047619047619 nrs=0.69047619047619 sa=0 sb=0 sd=0 mult=1 m=1
csn_f00_w1_r0_2 sn_f00_w1_r0_2 0 {C_SN}
XMWR_f00_w1_r0_3 sn_f00_w1_r0_3 0 wbl_f00_w1_r0 0 sky130_fd_pr__nfet_01v8 L=0.15 W=0.42 nf=1 ad=0.1218 as=0.1218 pd=1.42 ps=1.42 nrd=0.69047619047619 nrs=0.69047619047619 sa=0 sb=0 sd=0 mult=1 m=1
XMRD_f00_w1_r0_3 rbl_f00_w1_r0 sn_f00_w1_r0_3 rwl_des 0 sky130_fd_pr__nfet_01v8 L=0.15 W=0.42 nf=1 ad=0.1218 as=0.1218 pd=1.42 ps=1.42 nrd=0.69047619047619 nrs=0.69047619047619 sa=0 sb=0 sd=0 mult=1 m=1
csn_f00_w1_r0_3 sn_f00_w1_r0_3 0 {C_SN}
crbl_f00_w1_r0 rbl_f00_w1_r0 0 {C_RBL}
cwbl_f00_w1_r0 wbl_f00_w1_r0 0 {C_WBL}
cref_f00_w1_r0 ref_f00_w1_r0 0 {C_RBL}   $ ASSUMPTION: ideal matched dummy load
XMPPRE_f00_w1_r0 rbl_f00_w1_r0 pcb_100 prea prea sky130_fd_pr__pfet_01v8 L=0.15 W=5 nf=1 ad=1.45 as=1.45 pd=10.58 ps=10.58 nrd=0.058 nrs=0.058 sa=0 sb=0 sd=0 mult=1 m=1
XMPU1_f00_w1_r0 x_f00_w1_r0 dinb1 vdd vdd sky130_fd_pr__pfet_01v8 L=0.15 W=1 nf=1 ad=0.29 as=0.29 pd=2.58 ps=2.58 nrd=0.29 nrs=0.29 sa=0 sb=0 sd=0 mult=1 m=1
XMPU2_f00_w1_r0 wbl_f00_w1_r0 wenb x_f00_w1_r0 vdd sky130_fd_pr__pfet_01v8 L=0.15 W=1 nf=1 ad=0.29 as=0.29 pd=2.58 ps=2.58 nrd=0.29 nrs=0.29 sa=0 sb=0 sd=0 mult=1 m=1
XMND2_f00_w1_r0 wbl_f00_w1_r0 wen y_f00_w1_r0 0 sky130_fd_pr__nfet_01v8 L=0.15 W=4 nf=1 ad=1.16 as=1.16 pd=8.58 ps=8.58 nrd=0.0725 nrs=0.0725 sa=0 sb=0 sd=0 mult=1 m=1
XMND1_f00_w1_r0 y_f00_w1_r0 dinb1 0 0 sky130_fd_pr__nfet_01v8 L=0.15 W=4 nf=1 ad=1.16 as=1.16 pd=8.58 ps=8.58 nrd=0.0725 nrs=0.0725 sa=0 sb=0 sd=0 mult=1 m=1
XMNI_f00_w1_r0 wbl_f00_w1_r0 wenb 0 0 sky130_fd_pr__nfet_01v8 L=0.15 W=2 nf=1 ad=0.58 as=0.58 pd=4.58 ps=4.58 nrd=0.145 nrs=0.145 sa=0 sb=0 sd=0 mult=1 m=1
XMNS_f00_w1_r0 sbl_f00_w1_r0 sel_69500 rbl_f00_w1_r0 0 sky130_fd_pr__nfet_01v8 L=0.15 W=0.42 nf=1 ad=0.1218 as=0.1218 pd=1.42 ps=1.42 nrd=0.69047619047619 nrs=0.69047619047619 sa=0 sb=0 sd=0 mult=1 m=1
XMNSR_f00_w1_r0 sref_f00_w1_r0 sel_69500 ref_f00_w1_r0 0 sky130_fd_pr__nfet_01v8 L=0.15 W=0.42 nf=1 ad=0.1218 as=0.1218 pd=1.42 ps=1.42 nrd=0.69047619047619 nrs=0.69047619047619 sa=0 sb=0 sd=0 mult=1 m=1
XMPPREF_f00_w1_r0 ref_f00_w1_r0 pcb_100 pref pref sky130_fd_pr__pfet_01v8 L=0.15 W=5 nf=1 ad=1.45 as=1.45 pd=10.58 ps=10.58 nrd=0.058 nrs=0.058 sa=0 sb=0 sd=0 mult=1 m=1   $ reference-side precharge: copy of MPPRE
XMN1_f00_w1_r0 sbl_f00_w1_r0 sref_f00_w1_r0 vn_f00_w1_r0 0 sky130_fd_pr__nfet_01v8 L=0.15 W=1 nf=1 ad=0.29 as=0.29 pd=2.58 ps=2.58 nrd=0.29 nrs=0.29 sa=0 sb=0 sd=0 mult=1 m=1
XMN2_f00_w1_r0 sref_f00_w1_r0 sbl_f00_w1_r0 vn_f00_w1_r0 0 sky130_fd_pr__nfet_01v8 L=0.15 W=1 nf=1 ad=0.29 as=0.29 pd=2.58 ps=2.58 nrd=0.29 nrs=0.29 sa=0 sb=0 sd=0 mult=1 m=1
XMP1_f00_w1_r0 sbl_f00_w1_r0 sref_f00_w1_r0 vp_f00_w1_r0 vdd sky130_fd_pr__pfet_01v8 L=0.15 W=2 nf=1 ad=0.58 as=0.58 pd=4.58 ps=4.58 nrd=0.145 nrs=0.145 sa=0 sb=0 sd=0 mult=1 m=1
XMP2_f00_w1_r0 sref_f00_w1_r0 sbl_f00_w1_r0 vp_f00_w1_r0 vdd sky130_fd_pr__pfet_01v8 L=0.15 W=2 nf=1 ad=0.58 as=0.58 pd=4.58 ps=4.58 nrd=0.145 nrs=0.145 sa=0 sb=0 sd=0 mult=1 m=1
XMNF_f00_w1_r0 vn_f00_w1_r0 en 0 0 sky130_fd_pr__nfet_01v8 L=0.15 W=2 nf=1 ad=0.58 as=0.58 pd=4.58 ps=4.58 nrd=0.145 nrs=0.145 sa=0 sb=0 sd=0 mult=1 m=1
XMPH_f00_w1_r0 vp_f00_w1_r0 enb vdd vdd sky130_fd_pr__pfet_01v8 L=0.15 W=4 nf=1 ad=1.16 as=1.16 pd=8.58 ps=8.58 nrd=0.0725 nrs=0.0725 sa=0 sb=0 sd=0 mult=1 m=1
bd_f00_w1_r0 d_f00_w1_r0 0 v=v(sbl_f00_w1_r0)-v(sref_f00_w1_r0)
bdabs_f00_w1_r0 dabs_f00_w1_r0 0 v=abs(v(sbl_f00_w1_r0)-v(sref_f00_w1_r0))

* ---- instance 3: ideal_w1_r1 ----
XMWR_ideal_w1_r1_0 sn_ideal_w1_r1_0 wl wbl_ideal_w1_r1 0 sky130_fd_pr__nfet_01v8 L=0.15 W=0.42 nf=1 ad=0.1218 as=0.1218 pd=1.42 ps=1.42 nrd=0.69047619047619 nrs=0.69047619047619 sa=0 sb=0 sd=0 mult=1 m=1
XMRD_ideal_w1_r1_0 rbl_ideal_w1_r1 sn_ideal_w1_r1_0 rwl_sel 0 sky130_fd_pr__nfet_01v8 L=0.15 W=0.42 nf=1 ad=0.1218 as=0.1218 pd=1.42 ps=1.42 nrd=0.69047619047619 nrs=0.69047619047619 sa=0 sb=0 sd=0 mult=1 m=1
csn_ideal_w1_r1_0 sn_ideal_w1_r1_0 0 {C_SN}
XMWR_ideal_w1_r1_1 sn_ideal_w1_r1_1 0 wbl_ideal_w1_r1 0 sky130_fd_pr__nfet_01v8 L=0.15 W=0.42 nf=1 ad=0.1218 as=0.1218 pd=1.42 ps=1.42 nrd=0.69047619047619 nrs=0.69047619047619 sa=0 sb=0 sd=0 mult=1 m=1
XMRD_ideal_w1_r1_1 rbl_ideal_w1_r1 sn_ideal_w1_r1_1 rwl_des 0 sky130_fd_pr__nfet_01v8 L=0.15 W=0.42 nf=1 ad=0.1218 as=0.1218 pd=1.42 ps=1.42 nrd=0.69047619047619 nrs=0.69047619047619 sa=0 sb=0 sd=0 mult=1 m=1
csn_ideal_w1_r1_1 sn_ideal_w1_r1_1 0 {C_SN}
XMWR_ideal_w1_r1_2 sn_ideal_w1_r1_2 0 wbl_ideal_w1_r1 0 sky130_fd_pr__nfet_01v8 L=0.15 W=0.42 nf=1 ad=0.1218 as=0.1218 pd=1.42 ps=1.42 nrd=0.69047619047619 nrs=0.69047619047619 sa=0 sb=0 sd=0 mult=1 m=1
XMRD_ideal_w1_r1_2 rbl_ideal_w1_r1 sn_ideal_w1_r1_2 rwl_des 0 sky130_fd_pr__nfet_01v8 L=0.15 W=0.42 nf=1 ad=0.1218 as=0.1218 pd=1.42 ps=1.42 nrd=0.69047619047619 nrs=0.69047619047619 sa=0 sb=0 sd=0 mult=1 m=1
csn_ideal_w1_r1_2 sn_ideal_w1_r1_2 0 {C_SN}
XMWR_ideal_w1_r1_3 sn_ideal_w1_r1_3 0 wbl_ideal_w1_r1 0 sky130_fd_pr__nfet_01v8 L=0.15 W=0.42 nf=1 ad=0.1218 as=0.1218 pd=1.42 ps=1.42 nrd=0.69047619047619 nrs=0.69047619047619 sa=0 sb=0 sd=0 mult=1 m=1
XMRD_ideal_w1_r1_3 rbl_ideal_w1_r1 sn_ideal_w1_r1_3 rwl_des 0 sky130_fd_pr__nfet_01v8 L=0.15 W=0.42 nf=1 ad=0.1218 as=0.1218 pd=1.42 ps=1.42 nrd=0.69047619047619 nrs=0.69047619047619 sa=0 sb=0 sd=0 mult=1 m=1
csn_ideal_w1_r1_3 sn_ideal_w1_r1_3 0 {C_SN}
crbl_ideal_w1_r1 rbl_ideal_w1_r1 0 {C_RBL}
cwbl_ideal_w1_r1 wbl_ideal_w1_r1 0 {C_WBL}
cref_ideal_w1_r1 ref_ideal_w1_r1 0 {C_RBL}   $ ASSUMPTION: ideal matched dummy load
spr_ideal_w1_r1 pref ref_ideal_w1_r1 pca 0 swpre   $ reference-side precharge: ideal switch (#114 convention)
spa_ideal_w1_r1 prea rbl_ideal_w1_r1 pca 0 swpre   $ existing ideal precharge switch
vwbl_ideal_w1_r1 wbl_ideal_w1_r1 0 pwl(0 0 1e-08 0 1.01e-08 {VDD} 3.4e-08 {VDD} 3.41e-08 0)   $ ideal write source
XMN1_ideal_w1_r1 rbl_ideal_w1_r1 ref_ideal_w1_r1 vn_ideal_w1_r1 0 sky130_fd_pr__nfet_01v8 L=0.15 W=1 nf=1 ad=0.29 as=0.29 pd=2.58 ps=2.58 nrd=0.29 nrs=0.29 sa=0 sb=0 sd=0 mult=1 m=1
XMN2_ideal_w1_r1 ref_ideal_w1_r1 rbl_ideal_w1_r1 vn_ideal_w1_r1 0 sky130_fd_pr__nfet_01v8 L=0.15 W=1 nf=1 ad=0.29 as=0.29 pd=2.58 ps=2.58 nrd=0.29 nrs=0.29 sa=0 sb=0 sd=0 mult=1 m=1
XMP1_ideal_w1_r1 rbl_ideal_w1_r1 ref_ideal_w1_r1 vp_ideal_w1_r1 vdd sky130_fd_pr__pfet_01v8 L=0.15 W=2 nf=1 ad=0.58 as=0.58 pd=4.58 ps=4.58 nrd=0.145 nrs=0.145 sa=0 sb=0 sd=0 mult=1 m=1
XMP2_ideal_w1_r1 ref_ideal_w1_r1 rbl_ideal_w1_r1 vp_ideal_w1_r1 vdd sky130_fd_pr__pfet_01v8 L=0.15 W=2 nf=1 ad=0.58 as=0.58 pd=4.58 ps=4.58 nrd=0.145 nrs=0.145 sa=0 sb=0 sd=0 mult=1 m=1
XMNF_ideal_w1_r1 vn_ideal_w1_r1 en 0 0 sky130_fd_pr__nfet_01v8 L=0.15 W=2 nf=1 ad=0.58 as=0.58 pd=4.58 ps=4.58 nrd=0.145 nrs=0.145 sa=0 sb=0 sd=0 mult=1 m=1
XMPH_ideal_w1_r1 vp_ideal_w1_r1 enb vdd vdd sky130_fd_pr__pfet_01v8 L=0.15 W=4 nf=1 ad=1.16 as=1.16 pd=8.58 ps=8.58 nrd=0.0725 nrs=0.0725 sa=0 sb=0 sd=0 mult=1 m=1
bd_ideal_w1_r1 d_ideal_w1_r1 0 v=v(rbl_ideal_w1_r1)-v(ref_ideal_w1_r1)
bdabs_ideal_w1_r1 dabs_ideal_w1_r1 0 v=abs(v(rbl_ideal_w1_r1)-v(ref_ideal_w1_r1))

* ---- instance 4: i00_w1_r1 (baseline: TG nfet 1.0 / pfet 2.0, dummy 1x, lead 0.5 ns) ----
XMWR_i00_w1_r1_0 sn_i00_w1_r1_0 wl wbl_i00_w1_r1 0 sky130_fd_pr__nfet_01v8 L=0.15 W=0.42 nf=1 ad=0.1218 as=0.1218 pd=1.42 ps=1.42 nrd=0.69047619047619 nrs=0.69047619047619 sa=0 sb=0 sd=0 mult=1 m=1
XMRD_i00_w1_r1_0 rbl_i00_w1_r1 sn_i00_w1_r1_0 rwl_sel 0 sky130_fd_pr__nfet_01v8 L=0.15 W=0.42 nf=1 ad=0.1218 as=0.1218 pd=1.42 ps=1.42 nrd=0.69047619047619 nrs=0.69047619047619 sa=0 sb=0 sd=0 mult=1 m=1
csn_i00_w1_r1_0 sn_i00_w1_r1_0 0 {C_SN}
XMWR_i00_w1_r1_1 sn_i00_w1_r1_1 0 wbl_i00_w1_r1 0 sky130_fd_pr__nfet_01v8 L=0.15 W=0.42 nf=1 ad=0.1218 as=0.1218 pd=1.42 ps=1.42 nrd=0.69047619047619 nrs=0.69047619047619 sa=0 sb=0 sd=0 mult=1 m=1
XMRD_i00_w1_r1_1 rbl_i00_w1_r1 sn_i00_w1_r1_1 rwl_des 0 sky130_fd_pr__nfet_01v8 L=0.15 W=0.42 nf=1 ad=0.1218 as=0.1218 pd=1.42 ps=1.42 nrd=0.69047619047619 nrs=0.69047619047619 sa=0 sb=0 sd=0 mult=1 m=1
csn_i00_w1_r1_1 sn_i00_w1_r1_1 0 {C_SN}
XMWR_i00_w1_r1_2 sn_i00_w1_r1_2 0 wbl_i00_w1_r1 0 sky130_fd_pr__nfet_01v8 L=0.15 W=0.42 nf=1 ad=0.1218 as=0.1218 pd=1.42 ps=1.42 nrd=0.69047619047619 nrs=0.69047619047619 sa=0 sb=0 sd=0 mult=1 m=1
XMRD_i00_w1_r1_2 rbl_i00_w1_r1 sn_i00_w1_r1_2 rwl_des 0 sky130_fd_pr__nfet_01v8 L=0.15 W=0.42 nf=1 ad=0.1218 as=0.1218 pd=1.42 ps=1.42 nrd=0.69047619047619 nrs=0.69047619047619 sa=0 sb=0 sd=0 mult=1 m=1
csn_i00_w1_r1_2 sn_i00_w1_r1_2 0 {C_SN}
XMWR_i00_w1_r1_3 sn_i00_w1_r1_3 0 wbl_i00_w1_r1 0 sky130_fd_pr__nfet_01v8 L=0.15 W=0.42 nf=1 ad=0.1218 as=0.1218 pd=1.42 ps=1.42 nrd=0.69047619047619 nrs=0.69047619047619 sa=0 sb=0 sd=0 mult=1 m=1
XMRD_i00_w1_r1_3 rbl_i00_w1_r1 sn_i00_w1_r1_3 rwl_des 0 sky130_fd_pr__nfet_01v8 L=0.15 W=0.42 nf=1 ad=0.1218 as=0.1218 pd=1.42 ps=1.42 nrd=0.69047619047619 nrs=0.69047619047619 sa=0 sb=0 sd=0 mult=1 m=1
csn_i00_w1_r1_3 sn_i00_w1_r1_3 0 {C_SN}
crbl_i00_w1_r1 rbl_i00_w1_r1 0 {C_RBL}
cwbl_i00_w1_r1 wbl_i00_w1_r1 0 {C_WBL}
cref_i00_w1_r1 ref_i00_w1_r1 0 {C_RBL}   $ ASSUMPTION: ideal matched dummy load
spr_i00_w1_r1 pref ref_i00_w1_r1 pca 0 swpre   $ reference-side precharge: ideal switch (#114 convention)
XMPPRE_i00_w1_r1 rbl_i00_w1_r1 pcb_100 prea prea sky130_fd_pr__pfet_01v8 L=0.15 W=4 nf=1 ad=1.16 as=1.16 pd=8.58 ps=8.58 nrd=0.0725 nrs=0.0725 sa=0 sb=0 sd=0 mult=1 m=1
XMPU1_i00_w1_r1 x_i00_w1_r1 dinb1 vdd vdd sky130_fd_pr__pfet_01v8 L=0.15 W=1 nf=1 ad=0.29 as=0.29 pd=2.58 ps=2.58 nrd=0.29 nrs=0.29 sa=0 sb=0 sd=0 mult=1 m=1
XMPU2_i00_w1_r1 wbl_i00_w1_r1 wenb x_i00_w1_r1 vdd sky130_fd_pr__pfet_01v8 L=0.15 W=1 nf=1 ad=0.29 as=0.29 pd=2.58 ps=2.58 nrd=0.29 nrs=0.29 sa=0 sb=0 sd=0 mult=1 m=1
XMND2_i00_w1_r1 wbl_i00_w1_r1 wen y_i00_w1_r1 0 sky130_fd_pr__nfet_01v8 L=0.15 W=0.5 nf=1 ad=0.145 as=0.145 pd=1.58 ps=1.58 nrd=0.58 nrs=0.58 sa=0 sb=0 sd=0 mult=1 m=1
XMND1_i00_w1_r1 y_i00_w1_r1 dinb1 0 0 sky130_fd_pr__nfet_01v8 L=0.15 W=0.5 nf=1 ad=0.145 as=0.145 pd=1.58 ps=1.58 nrd=0.58 nrs=0.58 sa=0 sb=0 sd=0 mult=1 m=1
XMNI_i00_w1_r1 wbl_i00_w1_r1 wenb 0 0 sky130_fd_pr__nfet_01v8 L=0.15 W=0.42 nf=1 ad=0.1218 as=0.1218 pd=1.42 ps=1.42 nrd=0.69047619047619 nrs=0.69047619047619 sa=0 sb=0 sd=0 mult=1 m=1
XMNS_i00_w1_r1 sbl_i00_w1_r1 sel_69500 rbl_i00_w1_r1 0 sky130_fd_pr__nfet_01v8 L=0.15 W=1 nf=1 ad=0.29 as=0.29 pd=2.58 ps=2.58 nrd=0.29 nrs=0.29 sa=0 sb=0 sd=0 mult=1 m=1
XMPS_i00_w1_r1 sbl_i00_w1_r1 selb_69500 rbl_i00_w1_r1 vdd sky130_fd_pr__pfet_01v8 L=0.15 W=2 nf=1 ad=0.58 as=0.58 pd=4.58 ps=4.58 nrd=0.145 nrs=0.145 sa=0 sb=0 sd=0 mult=1 m=1
XMNSR_i00_w1_r1 sref_i00_w1_r1 sel_69500 ref_i00_w1_r1 0 sky130_fd_pr__nfet_01v8 L=0.15 W=1 nf=1 ad=0.29 as=0.29 pd=2.58 ps=2.58 nrd=0.29 nrs=0.29 sa=0 sb=0 sd=0 mult=1 m=1
XMPSR_i00_w1_r1 sref_i00_w1_r1 selb_69500 ref_i00_w1_r1 vdd sky130_fd_pr__pfet_01v8 L=0.15 W=2 nf=1 ad=0.58 as=0.58 pd=4.58 ps=4.58 nrd=0.145 nrs=0.145 sa=0 sb=0 sd=0 mult=1 m=1
XMN1_i00_w1_r1 sbl_i00_w1_r1 sref_i00_w1_r1 vn_i00_w1_r1 0 sky130_fd_pr__nfet_01v8 L=0.15 W=1 nf=1 ad=0.29 as=0.29 pd=2.58 ps=2.58 nrd=0.29 nrs=0.29 sa=0 sb=0 sd=0 mult=1 m=1
XMN2_i00_w1_r1 sref_i00_w1_r1 sbl_i00_w1_r1 vn_i00_w1_r1 0 sky130_fd_pr__nfet_01v8 L=0.15 W=1 nf=1 ad=0.29 as=0.29 pd=2.58 ps=2.58 nrd=0.29 nrs=0.29 sa=0 sb=0 sd=0 mult=1 m=1
XMP1_i00_w1_r1 sbl_i00_w1_r1 sref_i00_w1_r1 vp_i00_w1_r1 vdd sky130_fd_pr__pfet_01v8 L=0.15 W=2 nf=1 ad=0.58 as=0.58 pd=4.58 ps=4.58 nrd=0.145 nrs=0.145 sa=0 sb=0 sd=0 mult=1 m=1
XMP2_i00_w1_r1 sref_i00_w1_r1 sbl_i00_w1_r1 vp_i00_w1_r1 vdd sky130_fd_pr__pfet_01v8 L=0.15 W=2 nf=1 ad=0.58 as=0.58 pd=4.58 ps=4.58 nrd=0.145 nrs=0.145 sa=0 sb=0 sd=0 mult=1 m=1
XMNF_i00_w1_r1 vn_i00_w1_r1 en 0 0 sky130_fd_pr__nfet_01v8 L=0.15 W=2 nf=1 ad=0.58 as=0.58 pd=4.58 ps=4.58 nrd=0.145 nrs=0.145 sa=0 sb=0 sd=0 mult=1 m=1
XMPH_i00_w1_r1 vp_i00_w1_r1 enb vdd vdd sky130_fd_pr__pfet_01v8 L=0.15 W=4 nf=1 ad=1.16 as=1.16 pd=8.58 ps=8.58 nrd=0.0725 nrs=0.0725 sa=0 sb=0 sd=0 mult=1 m=1
bd_i00_w1_r1 d_i00_w1_r1 0 v=v(sbl_i00_w1_r1)-v(sref_i00_w1_r1)
bdabs_i00_w1_r1 dabs_i00_w1_r1 0 v=abs(v(sbl_i00_w1_r1)-v(sref_i00_w1_r1))

* ---- instance 5: f00_w1_r1 (FINAL: nfet-only 0.42 isolation, matched ref precharge 5.0, MND1/MND2 4.0, MNI 2.0) ----
XMWR_f00_w1_r1_0 sn_f00_w1_r1_0 wl wbl_f00_w1_r1 0 sky130_fd_pr__nfet_01v8 L=0.15 W=0.42 nf=1 ad=0.1218 as=0.1218 pd=1.42 ps=1.42 nrd=0.69047619047619 nrs=0.69047619047619 sa=0 sb=0 sd=0 mult=1 m=1
XMRD_f00_w1_r1_0 rbl_f00_w1_r1 sn_f00_w1_r1_0 rwl_sel 0 sky130_fd_pr__nfet_01v8 L=0.15 W=0.42 nf=1 ad=0.1218 as=0.1218 pd=1.42 ps=1.42 nrd=0.69047619047619 nrs=0.69047619047619 sa=0 sb=0 sd=0 mult=1 m=1
csn_f00_w1_r1_0 sn_f00_w1_r1_0 0 {C_SN}
XMWR_f00_w1_r1_1 sn_f00_w1_r1_1 0 wbl_f00_w1_r1 0 sky130_fd_pr__nfet_01v8 L=0.15 W=0.42 nf=1 ad=0.1218 as=0.1218 pd=1.42 ps=1.42 nrd=0.69047619047619 nrs=0.69047619047619 sa=0 sb=0 sd=0 mult=1 m=1
XMRD_f00_w1_r1_1 rbl_f00_w1_r1 sn_f00_w1_r1_1 rwl_des 0 sky130_fd_pr__nfet_01v8 L=0.15 W=0.42 nf=1 ad=0.1218 as=0.1218 pd=1.42 ps=1.42 nrd=0.69047619047619 nrs=0.69047619047619 sa=0 sb=0 sd=0 mult=1 m=1
csn_f00_w1_r1_1 sn_f00_w1_r1_1 0 {C_SN}
XMWR_f00_w1_r1_2 sn_f00_w1_r1_2 0 wbl_f00_w1_r1 0 sky130_fd_pr__nfet_01v8 L=0.15 W=0.42 nf=1 ad=0.1218 as=0.1218 pd=1.42 ps=1.42 nrd=0.69047619047619 nrs=0.69047619047619 sa=0 sb=0 sd=0 mult=1 m=1
XMRD_f00_w1_r1_2 rbl_f00_w1_r1 sn_f00_w1_r1_2 rwl_des 0 sky130_fd_pr__nfet_01v8 L=0.15 W=0.42 nf=1 ad=0.1218 as=0.1218 pd=1.42 ps=1.42 nrd=0.69047619047619 nrs=0.69047619047619 sa=0 sb=0 sd=0 mult=1 m=1
csn_f00_w1_r1_2 sn_f00_w1_r1_2 0 {C_SN}
XMWR_f00_w1_r1_3 sn_f00_w1_r1_3 0 wbl_f00_w1_r1 0 sky130_fd_pr__nfet_01v8 L=0.15 W=0.42 nf=1 ad=0.1218 as=0.1218 pd=1.42 ps=1.42 nrd=0.69047619047619 nrs=0.69047619047619 sa=0 sb=0 sd=0 mult=1 m=1
XMRD_f00_w1_r1_3 rbl_f00_w1_r1 sn_f00_w1_r1_3 rwl_des 0 sky130_fd_pr__nfet_01v8 L=0.15 W=0.42 nf=1 ad=0.1218 as=0.1218 pd=1.42 ps=1.42 nrd=0.69047619047619 nrs=0.69047619047619 sa=0 sb=0 sd=0 mult=1 m=1
csn_f00_w1_r1_3 sn_f00_w1_r1_3 0 {C_SN}
crbl_f00_w1_r1 rbl_f00_w1_r1 0 {C_RBL}
cwbl_f00_w1_r1 wbl_f00_w1_r1 0 {C_WBL}
cref_f00_w1_r1 ref_f00_w1_r1 0 {C_RBL}   $ ASSUMPTION: ideal matched dummy load
XMPPRE_f00_w1_r1 rbl_f00_w1_r1 pcb_100 prea prea sky130_fd_pr__pfet_01v8 L=0.15 W=5 nf=1 ad=1.45 as=1.45 pd=10.58 ps=10.58 nrd=0.058 nrs=0.058 sa=0 sb=0 sd=0 mult=1 m=1
XMPU1_f00_w1_r1 x_f00_w1_r1 dinb1 vdd vdd sky130_fd_pr__pfet_01v8 L=0.15 W=1 nf=1 ad=0.29 as=0.29 pd=2.58 ps=2.58 nrd=0.29 nrs=0.29 sa=0 sb=0 sd=0 mult=1 m=1
XMPU2_f00_w1_r1 wbl_f00_w1_r1 wenb x_f00_w1_r1 vdd sky130_fd_pr__pfet_01v8 L=0.15 W=1 nf=1 ad=0.29 as=0.29 pd=2.58 ps=2.58 nrd=0.29 nrs=0.29 sa=0 sb=0 sd=0 mult=1 m=1
XMND2_f00_w1_r1 wbl_f00_w1_r1 wen y_f00_w1_r1 0 sky130_fd_pr__nfet_01v8 L=0.15 W=4 nf=1 ad=1.16 as=1.16 pd=8.58 ps=8.58 nrd=0.0725 nrs=0.0725 sa=0 sb=0 sd=0 mult=1 m=1
XMND1_f00_w1_r1 y_f00_w1_r1 dinb1 0 0 sky130_fd_pr__nfet_01v8 L=0.15 W=4 nf=1 ad=1.16 as=1.16 pd=8.58 ps=8.58 nrd=0.0725 nrs=0.0725 sa=0 sb=0 sd=0 mult=1 m=1
XMNI_f00_w1_r1 wbl_f00_w1_r1 wenb 0 0 sky130_fd_pr__nfet_01v8 L=0.15 W=2 nf=1 ad=0.58 as=0.58 pd=4.58 ps=4.58 nrd=0.145 nrs=0.145 sa=0 sb=0 sd=0 mult=1 m=1
XMNS_f00_w1_r1 sbl_f00_w1_r1 sel_69500 rbl_f00_w1_r1 0 sky130_fd_pr__nfet_01v8 L=0.15 W=0.42 nf=1 ad=0.1218 as=0.1218 pd=1.42 ps=1.42 nrd=0.69047619047619 nrs=0.69047619047619 sa=0 sb=0 sd=0 mult=1 m=1
XMNSR_f00_w1_r1 sref_f00_w1_r1 sel_69500 ref_f00_w1_r1 0 sky130_fd_pr__nfet_01v8 L=0.15 W=0.42 nf=1 ad=0.1218 as=0.1218 pd=1.42 ps=1.42 nrd=0.69047619047619 nrs=0.69047619047619 sa=0 sb=0 sd=0 mult=1 m=1
XMPPREF_f00_w1_r1 ref_f00_w1_r1 pcb_100 pref pref sky130_fd_pr__pfet_01v8 L=0.15 W=5 nf=1 ad=1.45 as=1.45 pd=10.58 ps=10.58 nrd=0.058 nrs=0.058 sa=0 sb=0 sd=0 mult=1 m=1   $ reference-side precharge: copy of MPPRE
XMN1_f00_w1_r1 sbl_f00_w1_r1 sref_f00_w1_r1 vn_f00_w1_r1 0 sky130_fd_pr__nfet_01v8 L=0.15 W=1 nf=1 ad=0.29 as=0.29 pd=2.58 ps=2.58 nrd=0.29 nrs=0.29 sa=0 sb=0 sd=0 mult=1 m=1
XMN2_f00_w1_r1 sref_f00_w1_r1 sbl_f00_w1_r1 vn_f00_w1_r1 0 sky130_fd_pr__nfet_01v8 L=0.15 W=1 nf=1 ad=0.29 as=0.29 pd=2.58 ps=2.58 nrd=0.29 nrs=0.29 sa=0 sb=0 sd=0 mult=1 m=1
XMP1_f00_w1_r1 sbl_f00_w1_r1 sref_f00_w1_r1 vp_f00_w1_r1 vdd sky130_fd_pr__pfet_01v8 L=0.15 W=2 nf=1 ad=0.58 as=0.58 pd=4.58 ps=4.58 nrd=0.145 nrs=0.145 sa=0 sb=0 sd=0 mult=1 m=1
XMP2_f00_w1_r1 sref_f00_w1_r1 sbl_f00_w1_r1 vp_f00_w1_r1 vdd sky130_fd_pr__pfet_01v8 L=0.15 W=2 nf=1 ad=0.58 as=0.58 pd=4.58 ps=4.58 nrd=0.145 nrs=0.145 sa=0 sb=0 sd=0 mult=1 m=1
XMNF_f00_w1_r1 vn_f00_w1_r1 en 0 0 sky130_fd_pr__nfet_01v8 L=0.15 W=2 nf=1 ad=0.58 as=0.58 pd=4.58 ps=4.58 nrd=0.145 nrs=0.145 sa=0 sb=0 sd=0 mult=1 m=1
XMPH_f00_w1_r1 vp_f00_w1_r1 enb vdd vdd sky130_fd_pr__pfet_01v8 L=0.15 W=4 nf=1 ad=1.16 as=1.16 pd=8.58 ps=8.58 nrd=0.0725 nrs=0.0725 sa=0 sb=0 sd=0 mult=1 m=1
bd_f00_w1_r1 d_f00_w1_r1 0 v=v(sbl_f00_w1_r1)-v(sref_f00_w1_r1)
bdabs_f00_w1_r1 dabs_f00_w1_r1 0 v=abs(v(sbl_f00_w1_r1)-v(sref_f00_w1_r1))

* ---- instance 6: ideal_w1_r2 ----
XMWR_ideal_w1_r2_0 sn_ideal_w1_r2_0 wl wbl_ideal_w1_r2 0 sky130_fd_pr__nfet_01v8 L=0.15 W=0.42 nf=1 ad=0.1218 as=0.1218 pd=1.42 ps=1.42 nrd=0.69047619047619 nrs=0.69047619047619 sa=0 sb=0 sd=0 mult=1 m=1
XMRD_ideal_w1_r2_0 rbl_ideal_w1_r2 sn_ideal_w1_r2_0 rwl_sel 0 sky130_fd_pr__nfet_01v8 L=0.15 W=0.42 nf=1 ad=0.1218 as=0.1218 pd=1.42 ps=1.42 nrd=0.69047619047619 nrs=0.69047619047619 sa=0 sb=0 sd=0 mult=1 m=1
csn_ideal_w1_r2_0 sn_ideal_w1_r2_0 0 {C_SN}
XMWR_ideal_w1_r2_1 sn_ideal_w1_r2_1 0 wbl_ideal_w1_r2 0 sky130_fd_pr__nfet_01v8 L=0.15 W=0.42 nf=1 ad=0.1218 as=0.1218 pd=1.42 ps=1.42 nrd=0.69047619047619 nrs=0.69047619047619 sa=0 sb=0 sd=0 mult=1 m=1
XMRD_ideal_w1_r2_1 rbl_ideal_w1_r2 sn_ideal_w1_r2_1 rwl_des 0 sky130_fd_pr__nfet_01v8 L=0.15 W=0.42 nf=1 ad=0.1218 as=0.1218 pd=1.42 ps=1.42 nrd=0.69047619047619 nrs=0.69047619047619 sa=0 sb=0 sd=0 mult=1 m=1
csn_ideal_w1_r2_1 sn_ideal_w1_r2_1 0 {C_SN}
XMWR_ideal_w1_r2_2 sn_ideal_w1_r2_2 0 wbl_ideal_w1_r2 0 sky130_fd_pr__nfet_01v8 L=0.15 W=0.42 nf=1 ad=0.1218 as=0.1218 pd=1.42 ps=1.42 nrd=0.69047619047619 nrs=0.69047619047619 sa=0 sb=0 sd=0 mult=1 m=1
XMRD_ideal_w1_r2_2 rbl_ideal_w1_r2 sn_ideal_w1_r2_2 rwl_des 0 sky130_fd_pr__nfet_01v8 L=0.15 W=0.42 nf=1 ad=0.1218 as=0.1218 pd=1.42 ps=1.42 nrd=0.69047619047619 nrs=0.69047619047619 sa=0 sb=0 sd=0 mult=1 m=1
csn_ideal_w1_r2_2 sn_ideal_w1_r2_2 0 {C_SN}
XMWR_ideal_w1_r2_3 sn_ideal_w1_r2_3 0 wbl_ideal_w1_r2 0 sky130_fd_pr__nfet_01v8 L=0.15 W=0.42 nf=1 ad=0.1218 as=0.1218 pd=1.42 ps=1.42 nrd=0.69047619047619 nrs=0.69047619047619 sa=0 sb=0 sd=0 mult=1 m=1
XMRD_ideal_w1_r2_3 rbl_ideal_w1_r2 sn_ideal_w1_r2_3 rwl_des 0 sky130_fd_pr__nfet_01v8 L=0.15 W=0.42 nf=1 ad=0.1218 as=0.1218 pd=1.42 ps=1.42 nrd=0.69047619047619 nrs=0.69047619047619 sa=0 sb=0 sd=0 mult=1 m=1
csn_ideal_w1_r2_3 sn_ideal_w1_r2_3 0 {C_SN}
crbl_ideal_w1_r2 rbl_ideal_w1_r2 0 {C_RBL}
cwbl_ideal_w1_r2 wbl_ideal_w1_r2 0 {C_WBL}
cref_ideal_w1_r2 ref_ideal_w1_r2 0 {C_RBL}   $ ASSUMPTION: ideal matched dummy load
spr_ideal_w1_r2 pref ref_ideal_w1_r2 pca 0 swpre   $ reference-side precharge: ideal switch (#114 convention)
spa_ideal_w1_r2 prea rbl_ideal_w1_r2 pca 0 swpre   $ existing ideal precharge switch
vwbl_ideal_w1_r2 wbl_ideal_w1_r2 0 pwl(0 0 1e-08 0 1.01e-08 {VDD} 3.4e-08 {VDD} 3.41e-08 0)   $ ideal write source
XMN1_ideal_w1_r2 rbl_ideal_w1_r2 ref_ideal_w1_r2 vn_ideal_w1_r2 0 sky130_fd_pr__nfet_01v8 L=0.15 W=1 nf=1 ad=0.29 as=0.29 pd=2.58 ps=2.58 nrd=0.29 nrs=0.29 sa=0 sb=0 sd=0 mult=1 m=1
XMN2_ideal_w1_r2 ref_ideal_w1_r2 rbl_ideal_w1_r2 vn_ideal_w1_r2 0 sky130_fd_pr__nfet_01v8 L=0.15 W=1 nf=1 ad=0.29 as=0.29 pd=2.58 ps=2.58 nrd=0.29 nrs=0.29 sa=0 sb=0 sd=0 mult=1 m=1
XMP1_ideal_w1_r2 rbl_ideal_w1_r2 ref_ideal_w1_r2 vp_ideal_w1_r2 vdd sky130_fd_pr__pfet_01v8 L=0.15 W=2 nf=1 ad=0.58 as=0.58 pd=4.58 ps=4.58 nrd=0.145 nrs=0.145 sa=0 sb=0 sd=0 mult=1 m=1
XMP2_ideal_w1_r2 ref_ideal_w1_r2 rbl_ideal_w1_r2 vp_ideal_w1_r2 vdd sky130_fd_pr__pfet_01v8 L=0.15 W=2 nf=1 ad=0.58 as=0.58 pd=4.58 ps=4.58 nrd=0.145 nrs=0.145 sa=0 sb=0 sd=0 mult=1 m=1
XMNF_ideal_w1_r2 vn_ideal_w1_r2 en 0 0 sky130_fd_pr__nfet_01v8 L=0.15 W=2 nf=1 ad=0.58 as=0.58 pd=4.58 ps=4.58 nrd=0.145 nrs=0.145 sa=0 sb=0 sd=0 mult=1 m=1
XMPH_ideal_w1_r2 vp_ideal_w1_r2 enb vdd vdd sky130_fd_pr__pfet_01v8 L=0.15 W=4 nf=1 ad=1.16 as=1.16 pd=8.58 ps=8.58 nrd=0.0725 nrs=0.0725 sa=0 sb=0 sd=0 mult=1 m=1
bd_ideal_w1_r2 d_ideal_w1_r2 0 v=v(rbl_ideal_w1_r2)-v(ref_ideal_w1_r2)
bdabs_ideal_w1_r2 dabs_ideal_w1_r2 0 v=abs(v(rbl_ideal_w1_r2)-v(ref_ideal_w1_r2))

* ---- instance 7: i00_w1_r2 (baseline: TG nfet 1.0 / pfet 2.0, dummy 1x, lead 0.5 ns) ----
XMWR_i00_w1_r2_0 sn_i00_w1_r2_0 wl wbl_i00_w1_r2 0 sky130_fd_pr__nfet_01v8 L=0.15 W=0.42 nf=1 ad=0.1218 as=0.1218 pd=1.42 ps=1.42 nrd=0.69047619047619 nrs=0.69047619047619 sa=0 sb=0 sd=0 mult=1 m=1
XMRD_i00_w1_r2_0 rbl_i00_w1_r2 sn_i00_w1_r2_0 rwl_sel 0 sky130_fd_pr__nfet_01v8 L=0.15 W=0.42 nf=1 ad=0.1218 as=0.1218 pd=1.42 ps=1.42 nrd=0.69047619047619 nrs=0.69047619047619 sa=0 sb=0 sd=0 mult=1 m=1
csn_i00_w1_r2_0 sn_i00_w1_r2_0 0 {C_SN}
XMWR_i00_w1_r2_1 sn_i00_w1_r2_1 0 wbl_i00_w1_r2 0 sky130_fd_pr__nfet_01v8 L=0.15 W=0.42 nf=1 ad=0.1218 as=0.1218 pd=1.42 ps=1.42 nrd=0.69047619047619 nrs=0.69047619047619 sa=0 sb=0 sd=0 mult=1 m=1
XMRD_i00_w1_r2_1 rbl_i00_w1_r2 sn_i00_w1_r2_1 rwl_des 0 sky130_fd_pr__nfet_01v8 L=0.15 W=0.42 nf=1 ad=0.1218 as=0.1218 pd=1.42 ps=1.42 nrd=0.69047619047619 nrs=0.69047619047619 sa=0 sb=0 sd=0 mult=1 m=1
csn_i00_w1_r2_1 sn_i00_w1_r2_1 0 {C_SN}
XMWR_i00_w1_r2_2 sn_i00_w1_r2_2 0 wbl_i00_w1_r2 0 sky130_fd_pr__nfet_01v8 L=0.15 W=0.42 nf=1 ad=0.1218 as=0.1218 pd=1.42 ps=1.42 nrd=0.69047619047619 nrs=0.69047619047619 sa=0 sb=0 sd=0 mult=1 m=1
XMRD_i00_w1_r2_2 rbl_i00_w1_r2 sn_i00_w1_r2_2 rwl_des 0 sky130_fd_pr__nfet_01v8 L=0.15 W=0.42 nf=1 ad=0.1218 as=0.1218 pd=1.42 ps=1.42 nrd=0.69047619047619 nrs=0.69047619047619 sa=0 sb=0 sd=0 mult=1 m=1
csn_i00_w1_r2_2 sn_i00_w1_r2_2 0 {C_SN}
XMWR_i00_w1_r2_3 sn_i00_w1_r2_3 0 wbl_i00_w1_r2 0 sky130_fd_pr__nfet_01v8 L=0.15 W=0.42 nf=1 ad=0.1218 as=0.1218 pd=1.42 ps=1.42 nrd=0.69047619047619 nrs=0.69047619047619 sa=0 sb=0 sd=0 mult=1 m=1
XMRD_i00_w1_r2_3 rbl_i00_w1_r2 sn_i00_w1_r2_3 rwl_des 0 sky130_fd_pr__nfet_01v8 L=0.15 W=0.42 nf=1 ad=0.1218 as=0.1218 pd=1.42 ps=1.42 nrd=0.69047619047619 nrs=0.69047619047619 sa=0 sb=0 sd=0 mult=1 m=1
csn_i00_w1_r2_3 sn_i00_w1_r2_3 0 {C_SN}
crbl_i00_w1_r2 rbl_i00_w1_r2 0 {C_RBL}
cwbl_i00_w1_r2 wbl_i00_w1_r2 0 {C_WBL}
cref_i00_w1_r2 ref_i00_w1_r2 0 {C_RBL}   $ ASSUMPTION: ideal matched dummy load
spr_i00_w1_r2 pref ref_i00_w1_r2 pca 0 swpre   $ reference-side precharge: ideal switch (#114 convention)
XMPPRE_i00_w1_r2 rbl_i00_w1_r2 pcb_100 prea prea sky130_fd_pr__pfet_01v8 L=0.15 W=4 nf=1 ad=1.16 as=1.16 pd=8.58 ps=8.58 nrd=0.0725 nrs=0.0725 sa=0 sb=0 sd=0 mult=1 m=1
XMPU1_i00_w1_r2 x_i00_w1_r2 dinb1 vdd vdd sky130_fd_pr__pfet_01v8 L=0.15 W=1 nf=1 ad=0.29 as=0.29 pd=2.58 ps=2.58 nrd=0.29 nrs=0.29 sa=0 sb=0 sd=0 mult=1 m=1
XMPU2_i00_w1_r2 wbl_i00_w1_r2 wenb x_i00_w1_r2 vdd sky130_fd_pr__pfet_01v8 L=0.15 W=1 nf=1 ad=0.29 as=0.29 pd=2.58 ps=2.58 nrd=0.29 nrs=0.29 sa=0 sb=0 sd=0 mult=1 m=1
XMND2_i00_w1_r2 wbl_i00_w1_r2 wen y_i00_w1_r2 0 sky130_fd_pr__nfet_01v8 L=0.15 W=0.5 nf=1 ad=0.145 as=0.145 pd=1.58 ps=1.58 nrd=0.58 nrs=0.58 sa=0 sb=0 sd=0 mult=1 m=1
XMND1_i00_w1_r2 y_i00_w1_r2 dinb1 0 0 sky130_fd_pr__nfet_01v8 L=0.15 W=0.5 nf=1 ad=0.145 as=0.145 pd=1.58 ps=1.58 nrd=0.58 nrs=0.58 sa=0 sb=0 sd=0 mult=1 m=1
XMNI_i00_w1_r2 wbl_i00_w1_r2 wenb 0 0 sky130_fd_pr__nfet_01v8 L=0.15 W=0.42 nf=1 ad=0.1218 as=0.1218 pd=1.42 ps=1.42 nrd=0.69047619047619 nrs=0.69047619047619 sa=0 sb=0 sd=0 mult=1 m=1
XMNS_i00_w1_r2 sbl_i00_w1_r2 sel_69500 rbl_i00_w1_r2 0 sky130_fd_pr__nfet_01v8 L=0.15 W=1 nf=1 ad=0.29 as=0.29 pd=2.58 ps=2.58 nrd=0.29 nrs=0.29 sa=0 sb=0 sd=0 mult=1 m=1
XMPS_i00_w1_r2 sbl_i00_w1_r2 selb_69500 rbl_i00_w1_r2 vdd sky130_fd_pr__pfet_01v8 L=0.15 W=2 nf=1 ad=0.58 as=0.58 pd=4.58 ps=4.58 nrd=0.145 nrs=0.145 sa=0 sb=0 sd=0 mult=1 m=1
XMNSR_i00_w1_r2 sref_i00_w1_r2 sel_69500 ref_i00_w1_r2 0 sky130_fd_pr__nfet_01v8 L=0.15 W=1 nf=1 ad=0.29 as=0.29 pd=2.58 ps=2.58 nrd=0.29 nrs=0.29 sa=0 sb=0 sd=0 mult=1 m=1
XMPSR_i00_w1_r2 sref_i00_w1_r2 selb_69500 ref_i00_w1_r2 vdd sky130_fd_pr__pfet_01v8 L=0.15 W=2 nf=1 ad=0.58 as=0.58 pd=4.58 ps=4.58 nrd=0.145 nrs=0.145 sa=0 sb=0 sd=0 mult=1 m=1
XMN1_i00_w1_r2 sbl_i00_w1_r2 sref_i00_w1_r2 vn_i00_w1_r2 0 sky130_fd_pr__nfet_01v8 L=0.15 W=1 nf=1 ad=0.29 as=0.29 pd=2.58 ps=2.58 nrd=0.29 nrs=0.29 sa=0 sb=0 sd=0 mult=1 m=1
XMN2_i00_w1_r2 sref_i00_w1_r2 sbl_i00_w1_r2 vn_i00_w1_r2 0 sky130_fd_pr__nfet_01v8 L=0.15 W=1 nf=1 ad=0.29 as=0.29 pd=2.58 ps=2.58 nrd=0.29 nrs=0.29 sa=0 sb=0 sd=0 mult=1 m=1
XMP1_i00_w1_r2 sbl_i00_w1_r2 sref_i00_w1_r2 vp_i00_w1_r2 vdd sky130_fd_pr__pfet_01v8 L=0.15 W=2 nf=1 ad=0.58 as=0.58 pd=4.58 ps=4.58 nrd=0.145 nrs=0.145 sa=0 sb=0 sd=0 mult=1 m=1
XMP2_i00_w1_r2 sref_i00_w1_r2 sbl_i00_w1_r2 vp_i00_w1_r2 vdd sky130_fd_pr__pfet_01v8 L=0.15 W=2 nf=1 ad=0.58 as=0.58 pd=4.58 ps=4.58 nrd=0.145 nrs=0.145 sa=0 sb=0 sd=0 mult=1 m=1
XMNF_i00_w1_r2 vn_i00_w1_r2 en 0 0 sky130_fd_pr__nfet_01v8 L=0.15 W=2 nf=1 ad=0.58 as=0.58 pd=4.58 ps=4.58 nrd=0.145 nrs=0.145 sa=0 sb=0 sd=0 mult=1 m=1
XMPH_i00_w1_r2 vp_i00_w1_r2 enb vdd vdd sky130_fd_pr__pfet_01v8 L=0.15 W=4 nf=1 ad=1.16 as=1.16 pd=8.58 ps=8.58 nrd=0.0725 nrs=0.0725 sa=0 sb=0 sd=0 mult=1 m=1
bd_i00_w1_r2 d_i00_w1_r2 0 v=v(sbl_i00_w1_r2)-v(sref_i00_w1_r2)
bdabs_i00_w1_r2 dabs_i00_w1_r2 0 v=abs(v(sbl_i00_w1_r2)-v(sref_i00_w1_r2))

* ---- instance 8: f00_w1_r2 (FINAL: nfet-only 0.42 isolation, matched ref precharge 5.0, MND1/MND2 4.0, MNI 2.0) ----
XMWR_f00_w1_r2_0 sn_f00_w1_r2_0 wl wbl_f00_w1_r2 0 sky130_fd_pr__nfet_01v8 L=0.15 W=0.42 nf=1 ad=0.1218 as=0.1218 pd=1.42 ps=1.42 nrd=0.69047619047619 nrs=0.69047619047619 sa=0 sb=0 sd=0 mult=1 m=1
XMRD_f00_w1_r2_0 rbl_f00_w1_r2 sn_f00_w1_r2_0 rwl_sel 0 sky130_fd_pr__nfet_01v8 L=0.15 W=0.42 nf=1 ad=0.1218 as=0.1218 pd=1.42 ps=1.42 nrd=0.69047619047619 nrs=0.69047619047619 sa=0 sb=0 sd=0 mult=1 m=1
csn_f00_w1_r2_0 sn_f00_w1_r2_0 0 {C_SN}
XMWR_f00_w1_r2_1 sn_f00_w1_r2_1 0 wbl_f00_w1_r2 0 sky130_fd_pr__nfet_01v8 L=0.15 W=0.42 nf=1 ad=0.1218 as=0.1218 pd=1.42 ps=1.42 nrd=0.69047619047619 nrs=0.69047619047619 sa=0 sb=0 sd=0 mult=1 m=1
XMRD_f00_w1_r2_1 rbl_f00_w1_r2 sn_f00_w1_r2_1 rwl_des 0 sky130_fd_pr__nfet_01v8 L=0.15 W=0.42 nf=1 ad=0.1218 as=0.1218 pd=1.42 ps=1.42 nrd=0.69047619047619 nrs=0.69047619047619 sa=0 sb=0 sd=0 mult=1 m=1
csn_f00_w1_r2_1 sn_f00_w1_r2_1 0 {C_SN}
XMWR_f00_w1_r2_2 sn_f00_w1_r2_2 0 wbl_f00_w1_r2 0 sky130_fd_pr__nfet_01v8 L=0.15 W=0.42 nf=1 ad=0.1218 as=0.1218 pd=1.42 ps=1.42 nrd=0.69047619047619 nrs=0.69047619047619 sa=0 sb=0 sd=0 mult=1 m=1
XMRD_f00_w1_r2_2 rbl_f00_w1_r2 sn_f00_w1_r2_2 rwl_des 0 sky130_fd_pr__nfet_01v8 L=0.15 W=0.42 nf=1 ad=0.1218 as=0.1218 pd=1.42 ps=1.42 nrd=0.69047619047619 nrs=0.69047619047619 sa=0 sb=0 sd=0 mult=1 m=1
csn_f00_w1_r2_2 sn_f00_w1_r2_2 0 {C_SN}
XMWR_f00_w1_r2_3 sn_f00_w1_r2_3 0 wbl_f00_w1_r2 0 sky130_fd_pr__nfet_01v8 L=0.15 W=0.42 nf=1 ad=0.1218 as=0.1218 pd=1.42 ps=1.42 nrd=0.69047619047619 nrs=0.69047619047619 sa=0 sb=0 sd=0 mult=1 m=1
XMRD_f00_w1_r2_3 rbl_f00_w1_r2 sn_f00_w1_r2_3 rwl_des 0 sky130_fd_pr__nfet_01v8 L=0.15 W=0.42 nf=1 ad=0.1218 as=0.1218 pd=1.42 ps=1.42 nrd=0.69047619047619 nrs=0.69047619047619 sa=0 sb=0 sd=0 mult=1 m=1
csn_f00_w1_r2_3 sn_f00_w1_r2_3 0 {C_SN}
crbl_f00_w1_r2 rbl_f00_w1_r2 0 {C_RBL}
cwbl_f00_w1_r2 wbl_f00_w1_r2 0 {C_WBL}
cref_f00_w1_r2 ref_f00_w1_r2 0 {C_RBL}   $ ASSUMPTION: ideal matched dummy load
XMPPRE_f00_w1_r2 rbl_f00_w1_r2 pcb_100 prea prea sky130_fd_pr__pfet_01v8 L=0.15 W=5 nf=1 ad=1.45 as=1.45 pd=10.58 ps=10.58 nrd=0.058 nrs=0.058 sa=0 sb=0 sd=0 mult=1 m=1
XMPU1_f00_w1_r2 x_f00_w1_r2 dinb1 vdd vdd sky130_fd_pr__pfet_01v8 L=0.15 W=1 nf=1 ad=0.29 as=0.29 pd=2.58 ps=2.58 nrd=0.29 nrs=0.29 sa=0 sb=0 sd=0 mult=1 m=1
XMPU2_f00_w1_r2 wbl_f00_w1_r2 wenb x_f00_w1_r2 vdd sky130_fd_pr__pfet_01v8 L=0.15 W=1 nf=1 ad=0.29 as=0.29 pd=2.58 ps=2.58 nrd=0.29 nrs=0.29 sa=0 sb=0 sd=0 mult=1 m=1
XMND2_f00_w1_r2 wbl_f00_w1_r2 wen y_f00_w1_r2 0 sky130_fd_pr__nfet_01v8 L=0.15 W=4 nf=1 ad=1.16 as=1.16 pd=8.58 ps=8.58 nrd=0.0725 nrs=0.0725 sa=0 sb=0 sd=0 mult=1 m=1
XMND1_f00_w1_r2 y_f00_w1_r2 dinb1 0 0 sky130_fd_pr__nfet_01v8 L=0.15 W=4 nf=1 ad=1.16 as=1.16 pd=8.58 ps=8.58 nrd=0.0725 nrs=0.0725 sa=0 sb=0 sd=0 mult=1 m=1
XMNI_f00_w1_r2 wbl_f00_w1_r2 wenb 0 0 sky130_fd_pr__nfet_01v8 L=0.15 W=2 nf=1 ad=0.58 as=0.58 pd=4.58 ps=4.58 nrd=0.145 nrs=0.145 sa=0 sb=0 sd=0 mult=1 m=1
XMNS_f00_w1_r2 sbl_f00_w1_r2 sel_69500 rbl_f00_w1_r2 0 sky130_fd_pr__nfet_01v8 L=0.15 W=0.42 nf=1 ad=0.1218 as=0.1218 pd=1.42 ps=1.42 nrd=0.69047619047619 nrs=0.69047619047619 sa=0 sb=0 sd=0 mult=1 m=1
XMNSR_f00_w1_r2 sref_f00_w1_r2 sel_69500 ref_f00_w1_r2 0 sky130_fd_pr__nfet_01v8 L=0.15 W=0.42 nf=1 ad=0.1218 as=0.1218 pd=1.42 ps=1.42 nrd=0.69047619047619 nrs=0.69047619047619 sa=0 sb=0 sd=0 mult=1 m=1
XMPPREF_f00_w1_r2 ref_f00_w1_r2 pcb_100 pref pref sky130_fd_pr__pfet_01v8 L=0.15 W=5 nf=1 ad=1.45 as=1.45 pd=10.58 ps=10.58 nrd=0.058 nrs=0.058 sa=0 sb=0 sd=0 mult=1 m=1   $ reference-side precharge: copy of MPPRE
XMN1_f00_w1_r2 sbl_f00_w1_r2 sref_f00_w1_r2 vn_f00_w1_r2 0 sky130_fd_pr__nfet_01v8 L=0.15 W=1 nf=1 ad=0.29 as=0.29 pd=2.58 ps=2.58 nrd=0.29 nrs=0.29 sa=0 sb=0 sd=0 mult=1 m=1
XMN2_f00_w1_r2 sref_f00_w1_r2 sbl_f00_w1_r2 vn_f00_w1_r2 0 sky130_fd_pr__nfet_01v8 L=0.15 W=1 nf=1 ad=0.29 as=0.29 pd=2.58 ps=2.58 nrd=0.29 nrs=0.29 sa=0 sb=0 sd=0 mult=1 m=1
XMP1_f00_w1_r2 sbl_f00_w1_r2 sref_f00_w1_r2 vp_f00_w1_r2 vdd sky130_fd_pr__pfet_01v8 L=0.15 W=2 nf=1 ad=0.58 as=0.58 pd=4.58 ps=4.58 nrd=0.145 nrs=0.145 sa=0 sb=0 sd=0 mult=1 m=1
XMP2_f00_w1_r2 sref_f00_w1_r2 sbl_f00_w1_r2 vp_f00_w1_r2 vdd sky130_fd_pr__pfet_01v8 L=0.15 W=2 nf=1 ad=0.58 as=0.58 pd=4.58 ps=4.58 nrd=0.145 nrs=0.145 sa=0 sb=0 sd=0 mult=1 m=1
XMNF_f00_w1_r2 vn_f00_w1_r2 en 0 0 sky130_fd_pr__nfet_01v8 L=0.15 W=2 nf=1 ad=0.58 as=0.58 pd=4.58 ps=4.58 nrd=0.145 nrs=0.145 sa=0 sb=0 sd=0 mult=1 m=1
XMPH_f00_w1_r2 vp_f00_w1_r2 enb vdd vdd sky130_fd_pr__pfet_01v8 L=0.15 W=4 nf=1 ad=1.16 as=1.16 pd=8.58 ps=8.58 nrd=0.0725 nrs=0.0725 sa=0 sb=0 sd=0 mult=1 m=1
bd_f00_w1_r2 d_f00_w1_r2 0 v=v(sbl_f00_w1_r2)-v(sref_f00_w1_r2)
bdabs_f00_w1_r2 dabs_f00_w1_r2 0 v=abs(v(sbl_f00_w1_r2)-v(sref_f00_w1_r2))

* ---- instance 9: ideal_w1_r3 ----
XMWR_ideal_w1_r3_0 sn_ideal_w1_r3_0 wl wbl_ideal_w1_r3 0 sky130_fd_pr__nfet_01v8 L=0.15 W=0.42 nf=1 ad=0.1218 as=0.1218 pd=1.42 ps=1.42 nrd=0.69047619047619 nrs=0.69047619047619 sa=0 sb=0 sd=0 mult=1 m=1
XMRD_ideal_w1_r3_0 rbl_ideal_w1_r3 sn_ideal_w1_r3_0 rwl_sel 0 sky130_fd_pr__nfet_01v8 L=0.15 W=0.42 nf=1 ad=0.1218 as=0.1218 pd=1.42 ps=1.42 nrd=0.69047619047619 nrs=0.69047619047619 sa=0 sb=0 sd=0 mult=1 m=1
csn_ideal_w1_r3_0 sn_ideal_w1_r3_0 0 {C_SN}
XMWR_ideal_w1_r3_1 sn_ideal_w1_r3_1 0 wbl_ideal_w1_r3 0 sky130_fd_pr__nfet_01v8 L=0.15 W=0.42 nf=1 ad=0.1218 as=0.1218 pd=1.42 ps=1.42 nrd=0.69047619047619 nrs=0.69047619047619 sa=0 sb=0 sd=0 mult=1 m=1
XMRD_ideal_w1_r3_1 rbl_ideal_w1_r3 sn_ideal_w1_r3_1 rwl_des 0 sky130_fd_pr__nfet_01v8 L=0.15 W=0.42 nf=1 ad=0.1218 as=0.1218 pd=1.42 ps=1.42 nrd=0.69047619047619 nrs=0.69047619047619 sa=0 sb=0 sd=0 mult=1 m=1
csn_ideal_w1_r3_1 sn_ideal_w1_r3_1 0 {C_SN}
XMWR_ideal_w1_r3_2 sn_ideal_w1_r3_2 0 wbl_ideal_w1_r3 0 sky130_fd_pr__nfet_01v8 L=0.15 W=0.42 nf=1 ad=0.1218 as=0.1218 pd=1.42 ps=1.42 nrd=0.69047619047619 nrs=0.69047619047619 sa=0 sb=0 sd=0 mult=1 m=1
XMRD_ideal_w1_r3_2 rbl_ideal_w1_r3 sn_ideal_w1_r3_2 rwl_des 0 sky130_fd_pr__nfet_01v8 L=0.15 W=0.42 nf=1 ad=0.1218 as=0.1218 pd=1.42 ps=1.42 nrd=0.69047619047619 nrs=0.69047619047619 sa=0 sb=0 sd=0 mult=1 m=1
csn_ideal_w1_r3_2 sn_ideal_w1_r3_2 0 {C_SN}
XMWR_ideal_w1_r3_3 sn_ideal_w1_r3_3 0 wbl_ideal_w1_r3 0 sky130_fd_pr__nfet_01v8 L=0.15 W=0.42 nf=1 ad=0.1218 as=0.1218 pd=1.42 ps=1.42 nrd=0.69047619047619 nrs=0.69047619047619 sa=0 sb=0 sd=0 mult=1 m=1
XMRD_ideal_w1_r3_3 rbl_ideal_w1_r3 sn_ideal_w1_r3_3 rwl_des 0 sky130_fd_pr__nfet_01v8 L=0.15 W=0.42 nf=1 ad=0.1218 as=0.1218 pd=1.42 ps=1.42 nrd=0.69047619047619 nrs=0.69047619047619 sa=0 sb=0 sd=0 mult=1 m=1
csn_ideal_w1_r3_3 sn_ideal_w1_r3_3 0 {C_SN}
crbl_ideal_w1_r3 rbl_ideal_w1_r3 0 {C_RBL}
cwbl_ideal_w1_r3 wbl_ideal_w1_r3 0 {C_WBL}
cref_ideal_w1_r3 ref_ideal_w1_r3 0 {C_RBL}   $ ASSUMPTION: ideal matched dummy load
spr_ideal_w1_r3 pref ref_ideal_w1_r3 pca 0 swpre   $ reference-side precharge: ideal switch (#114 convention)
spa_ideal_w1_r3 prea rbl_ideal_w1_r3 pca 0 swpre   $ existing ideal precharge switch
vwbl_ideal_w1_r3 wbl_ideal_w1_r3 0 pwl(0 0 1e-08 0 1.01e-08 {VDD} 3.4e-08 {VDD} 3.41e-08 0)   $ ideal write source
XMN1_ideal_w1_r3 rbl_ideal_w1_r3 ref_ideal_w1_r3 vn_ideal_w1_r3 0 sky130_fd_pr__nfet_01v8 L=0.15 W=1 nf=1 ad=0.29 as=0.29 pd=2.58 ps=2.58 nrd=0.29 nrs=0.29 sa=0 sb=0 sd=0 mult=1 m=1
XMN2_ideal_w1_r3 ref_ideal_w1_r3 rbl_ideal_w1_r3 vn_ideal_w1_r3 0 sky130_fd_pr__nfet_01v8 L=0.15 W=1 nf=1 ad=0.29 as=0.29 pd=2.58 ps=2.58 nrd=0.29 nrs=0.29 sa=0 sb=0 sd=0 mult=1 m=1
XMP1_ideal_w1_r3 rbl_ideal_w1_r3 ref_ideal_w1_r3 vp_ideal_w1_r3 vdd sky130_fd_pr__pfet_01v8 L=0.15 W=2 nf=1 ad=0.58 as=0.58 pd=4.58 ps=4.58 nrd=0.145 nrs=0.145 sa=0 sb=0 sd=0 mult=1 m=1
XMP2_ideal_w1_r3 ref_ideal_w1_r3 rbl_ideal_w1_r3 vp_ideal_w1_r3 vdd sky130_fd_pr__pfet_01v8 L=0.15 W=2 nf=1 ad=0.58 as=0.58 pd=4.58 ps=4.58 nrd=0.145 nrs=0.145 sa=0 sb=0 sd=0 mult=1 m=1
XMNF_ideal_w1_r3 vn_ideal_w1_r3 en 0 0 sky130_fd_pr__nfet_01v8 L=0.15 W=2 nf=1 ad=0.58 as=0.58 pd=4.58 ps=4.58 nrd=0.145 nrs=0.145 sa=0 sb=0 sd=0 mult=1 m=1
XMPH_ideal_w1_r3 vp_ideal_w1_r3 enb vdd vdd sky130_fd_pr__pfet_01v8 L=0.15 W=4 nf=1 ad=1.16 as=1.16 pd=8.58 ps=8.58 nrd=0.0725 nrs=0.0725 sa=0 sb=0 sd=0 mult=1 m=1
bd_ideal_w1_r3 d_ideal_w1_r3 0 v=v(rbl_ideal_w1_r3)-v(ref_ideal_w1_r3)
bdabs_ideal_w1_r3 dabs_ideal_w1_r3 0 v=abs(v(rbl_ideal_w1_r3)-v(ref_ideal_w1_r3))

* ---- instance 10: i00_w1_r3 (baseline: TG nfet 1.0 / pfet 2.0, dummy 1x, lead 0.5 ns) ----
XMWR_i00_w1_r3_0 sn_i00_w1_r3_0 wl wbl_i00_w1_r3 0 sky130_fd_pr__nfet_01v8 L=0.15 W=0.42 nf=1 ad=0.1218 as=0.1218 pd=1.42 ps=1.42 nrd=0.69047619047619 nrs=0.69047619047619 sa=0 sb=0 sd=0 mult=1 m=1
XMRD_i00_w1_r3_0 rbl_i00_w1_r3 sn_i00_w1_r3_0 rwl_sel 0 sky130_fd_pr__nfet_01v8 L=0.15 W=0.42 nf=1 ad=0.1218 as=0.1218 pd=1.42 ps=1.42 nrd=0.69047619047619 nrs=0.69047619047619 sa=0 sb=0 sd=0 mult=1 m=1
csn_i00_w1_r3_0 sn_i00_w1_r3_0 0 {C_SN}
XMWR_i00_w1_r3_1 sn_i00_w1_r3_1 0 wbl_i00_w1_r3 0 sky130_fd_pr__nfet_01v8 L=0.15 W=0.42 nf=1 ad=0.1218 as=0.1218 pd=1.42 ps=1.42 nrd=0.69047619047619 nrs=0.69047619047619 sa=0 sb=0 sd=0 mult=1 m=1
XMRD_i00_w1_r3_1 rbl_i00_w1_r3 sn_i00_w1_r3_1 rwl_des 0 sky130_fd_pr__nfet_01v8 L=0.15 W=0.42 nf=1 ad=0.1218 as=0.1218 pd=1.42 ps=1.42 nrd=0.69047619047619 nrs=0.69047619047619 sa=0 sb=0 sd=0 mult=1 m=1
csn_i00_w1_r3_1 sn_i00_w1_r3_1 0 {C_SN}
XMWR_i00_w1_r3_2 sn_i00_w1_r3_2 0 wbl_i00_w1_r3 0 sky130_fd_pr__nfet_01v8 L=0.15 W=0.42 nf=1 ad=0.1218 as=0.1218 pd=1.42 ps=1.42 nrd=0.69047619047619 nrs=0.69047619047619 sa=0 sb=0 sd=0 mult=1 m=1
XMRD_i00_w1_r3_2 rbl_i00_w1_r3 sn_i00_w1_r3_2 rwl_des 0 sky130_fd_pr__nfet_01v8 L=0.15 W=0.42 nf=1 ad=0.1218 as=0.1218 pd=1.42 ps=1.42 nrd=0.69047619047619 nrs=0.69047619047619 sa=0 sb=0 sd=0 mult=1 m=1
csn_i00_w1_r3_2 sn_i00_w1_r3_2 0 {C_SN}
XMWR_i00_w1_r3_3 sn_i00_w1_r3_3 0 wbl_i00_w1_r3 0 sky130_fd_pr__nfet_01v8 L=0.15 W=0.42 nf=1 ad=0.1218 as=0.1218 pd=1.42 ps=1.42 nrd=0.69047619047619 nrs=0.69047619047619 sa=0 sb=0 sd=0 mult=1 m=1
XMRD_i00_w1_r3_3 rbl_i00_w1_r3 sn_i00_w1_r3_3 rwl_des 0 sky130_fd_pr__nfet_01v8 L=0.15 W=0.42 nf=1 ad=0.1218 as=0.1218 pd=1.42 ps=1.42 nrd=0.69047619047619 nrs=0.69047619047619 sa=0 sb=0 sd=0 mult=1 m=1
csn_i00_w1_r3_3 sn_i00_w1_r3_3 0 {C_SN}
crbl_i00_w1_r3 rbl_i00_w1_r3 0 {C_RBL}
cwbl_i00_w1_r3 wbl_i00_w1_r3 0 {C_WBL}
cref_i00_w1_r3 ref_i00_w1_r3 0 {C_RBL}   $ ASSUMPTION: ideal matched dummy load
spr_i00_w1_r3 pref ref_i00_w1_r3 pca 0 swpre   $ reference-side precharge: ideal switch (#114 convention)
XMPPRE_i00_w1_r3 rbl_i00_w1_r3 pcb_100 prea prea sky130_fd_pr__pfet_01v8 L=0.15 W=4 nf=1 ad=1.16 as=1.16 pd=8.58 ps=8.58 nrd=0.0725 nrs=0.0725 sa=0 sb=0 sd=0 mult=1 m=1
XMPU1_i00_w1_r3 x_i00_w1_r3 dinb1 vdd vdd sky130_fd_pr__pfet_01v8 L=0.15 W=1 nf=1 ad=0.29 as=0.29 pd=2.58 ps=2.58 nrd=0.29 nrs=0.29 sa=0 sb=0 sd=0 mult=1 m=1
XMPU2_i00_w1_r3 wbl_i00_w1_r3 wenb x_i00_w1_r3 vdd sky130_fd_pr__pfet_01v8 L=0.15 W=1 nf=1 ad=0.29 as=0.29 pd=2.58 ps=2.58 nrd=0.29 nrs=0.29 sa=0 sb=0 sd=0 mult=1 m=1
XMND2_i00_w1_r3 wbl_i00_w1_r3 wen y_i00_w1_r3 0 sky130_fd_pr__nfet_01v8 L=0.15 W=0.5 nf=1 ad=0.145 as=0.145 pd=1.58 ps=1.58 nrd=0.58 nrs=0.58 sa=0 sb=0 sd=0 mult=1 m=1
XMND1_i00_w1_r3 y_i00_w1_r3 dinb1 0 0 sky130_fd_pr__nfet_01v8 L=0.15 W=0.5 nf=1 ad=0.145 as=0.145 pd=1.58 ps=1.58 nrd=0.58 nrs=0.58 sa=0 sb=0 sd=0 mult=1 m=1
XMNI_i00_w1_r3 wbl_i00_w1_r3 wenb 0 0 sky130_fd_pr__nfet_01v8 L=0.15 W=0.42 nf=1 ad=0.1218 as=0.1218 pd=1.42 ps=1.42 nrd=0.69047619047619 nrs=0.69047619047619 sa=0 sb=0 sd=0 mult=1 m=1
XMNS_i00_w1_r3 sbl_i00_w1_r3 sel_69500 rbl_i00_w1_r3 0 sky130_fd_pr__nfet_01v8 L=0.15 W=1 nf=1 ad=0.29 as=0.29 pd=2.58 ps=2.58 nrd=0.29 nrs=0.29 sa=0 sb=0 sd=0 mult=1 m=1
XMPS_i00_w1_r3 sbl_i00_w1_r3 selb_69500 rbl_i00_w1_r3 vdd sky130_fd_pr__pfet_01v8 L=0.15 W=2 nf=1 ad=0.58 as=0.58 pd=4.58 ps=4.58 nrd=0.145 nrs=0.145 sa=0 sb=0 sd=0 mult=1 m=1
XMNSR_i00_w1_r3 sref_i00_w1_r3 sel_69500 ref_i00_w1_r3 0 sky130_fd_pr__nfet_01v8 L=0.15 W=1 nf=1 ad=0.29 as=0.29 pd=2.58 ps=2.58 nrd=0.29 nrs=0.29 sa=0 sb=0 sd=0 mult=1 m=1
XMPSR_i00_w1_r3 sref_i00_w1_r3 selb_69500 ref_i00_w1_r3 vdd sky130_fd_pr__pfet_01v8 L=0.15 W=2 nf=1 ad=0.58 as=0.58 pd=4.58 ps=4.58 nrd=0.145 nrs=0.145 sa=0 sb=0 sd=0 mult=1 m=1
XMN1_i00_w1_r3 sbl_i00_w1_r3 sref_i00_w1_r3 vn_i00_w1_r3 0 sky130_fd_pr__nfet_01v8 L=0.15 W=1 nf=1 ad=0.29 as=0.29 pd=2.58 ps=2.58 nrd=0.29 nrs=0.29 sa=0 sb=0 sd=0 mult=1 m=1
XMN2_i00_w1_r3 sref_i00_w1_r3 sbl_i00_w1_r3 vn_i00_w1_r3 0 sky130_fd_pr__nfet_01v8 L=0.15 W=1 nf=1 ad=0.29 as=0.29 pd=2.58 ps=2.58 nrd=0.29 nrs=0.29 sa=0 sb=0 sd=0 mult=1 m=1
XMP1_i00_w1_r3 sbl_i00_w1_r3 sref_i00_w1_r3 vp_i00_w1_r3 vdd sky130_fd_pr__pfet_01v8 L=0.15 W=2 nf=1 ad=0.58 as=0.58 pd=4.58 ps=4.58 nrd=0.145 nrs=0.145 sa=0 sb=0 sd=0 mult=1 m=1
XMP2_i00_w1_r3 sref_i00_w1_r3 sbl_i00_w1_r3 vp_i00_w1_r3 vdd sky130_fd_pr__pfet_01v8 L=0.15 W=2 nf=1 ad=0.58 as=0.58 pd=4.58 ps=4.58 nrd=0.145 nrs=0.145 sa=0 sb=0 sd=0 mult=1 m=1
XMNF_i00_w1_r3 vn_i00_w1_r3 en 0 0 sky130_fd_pr__nfet_01v8 L=0.15 W=2 nf=1 ad=0.58 as=0.58 pd=4.58 ps=4.58 nrd=0.145 nrs=0.145 sa=0 sb=0 sd=0 mult=1 m=1
XMPH_i00_w1_r3 vp_i00_w1_r3 enb vdd vdd sky130_fd_pr__pfet_01v8 L=0.15 W=4 nf=1 ad=1.16 as=1.16 pd=8.58 ps=8.58 nrd=0.0725 nrs=0.0725 sa=0 sb=0 sd=0 mult=1 m=1
bd_i00_w1_r3 d_i00_w1_r3 0 v=v(sbl_i00_w1_r3)-v(sref_i00_w1_r3)
bdabs_i00_w1_r3 dabs_i00_w1_r3 0 v=abs(v(sbl_i00_w1_r3)-v(sref_i00_w1_r3))

* ---- instance 11: f00_w1_r3 (FINAL: nfet-only 0.42 isolation, matched ref precharge 5.0, MND1/MND2 4.0, MNI 2.0) ----
XMWR_f00_w1_r3_0 sn_f00_w1_r3_0 wl wbl_f00_w1_r3 0 sky130_fd_pr__nfet_01v8 L=0.15 W=0.42 nf=1 ad=0.1218 as=0.1218 pd=1.42 ps=1.42 nrd=0.69047619047619 nrs=0.69047619047619 sa=0 sb=0 sd=0 mult=1 m=1
XMRD_f00_w1_r3_0 rbl_f00_w1_r3 sn_f00_w1_r3_0 rwl_sel 0 sky130_fd_pr__nfet_01v8 L=0.15 W=0.42 nf=1 ad=0.1218 as=0.1218 pd=1.42 ps=1.42 nrd=0.69047619047619 nrs=0.69047619047619 sa=0 sb=0 sd=0 mult=1 m=1
csn_f00_w1_r3_0 sn_f00_w1_r3_0 0 {C_SN}
XMWR_f00_w1_r3_1 sn_f00_w1_r3_1 0 wbl_f00_w1_r3 0 sky130_fd_pr__nfet_01v8 L=0.15 W=0.42 nf=1 ad=0.1218 as=0.1218 pd=1.42 ps=1.42 nrd=0.69047619047619 nrs=0.69047619047619 sa=0 sb=0 sd=0 mult=1 m=1
XMRD_f00_w1_r3_1 rbl_f00_w1_r3 sn_f00_w1_r3_1 rwl_des 0 sky130_fd_pr__nfet_01v8 L=0.15 W=0.42 nf=1 ad=0.1218 as=0.1218 pd=1.42 ps=1.42 nrd=0.69047619047619 nrs=0.69047619047619 sa=0 sb=0 sd=0 mult=1 m=1
csn_f00_w1_r3_1 sn_f00_w1_r3_1 0 {C_SN}
XMWR_f00_w1_r3_2 sn_f00_w1_r3_2 0 wbl_f00_w1_r3 0 sky130_fd_pr__nfet_01v8 L=0.15 W=0.42 nf=1 ad=0.1218 as=0.1218 pd=1.42 ps=1.42 nrd=0.69047619047619 nrs=0.69047619047619 sa=0 sb=0 sd=0 mult=1 m=1
XMRD_f00_w1_r3_2 rbl_f00_w1_r3 sn_f00_w1_r3_2 rwl_des 0 sky130_fd_pr__nfet_01v8 L=0.15 W=0.42 nf=1 ad=0.1218 as=0.1218 pd=1.42 ps=1.42 nrd=0.69047619047619 nrs=0.69047619047619 sa=0 sb=0 sd=0 mult=1 m=1
csn_f00_w1_r3_2 sn_f00_w1_r3_2 0 {C_SN}
XMWR_f00_w1_r3_3 sn_f00_w1_r3_3 0 wbl_f00_w1_r3 0 sky130_fd_pr__nfet_01v8 L=0.15 W=0.42 nf=1 ad=0.1218 as=0.1218 pd=1.42 ps=1.42 nrd=0.69047619047619 nrs=0.69047619047619 sa=0 sb=0 sd=0 mult=1 m=1
XMRD_f00_w1_r3_3 rbl_f00_w1_r3 sn_f00_w1_r3_3 rwl_des 0 sky130_fd_pr__nfet_01v8 L=0.15 W=0.42 nf=1 ad=0.1218 as=0.1218 pd=1.42 ps=1.42 nrd=0.69047619047619 nrs=0.69047619047619 sa=0 sb=0 sd=0 mult=1 m=1
csn_f00_w1_r3_3 sn_f00_w1_r3_3 0 {C_SN}
crbl_f00_w1_r3 rbl_f00_w1_r3 0 {C_RBL}
cwbl_f00_w1_r3 wbl_f00_w1_r3 0 {C_WBL}
cref_f00_w1_r3 ref_f00_w1_r3 0 {C_RBL}   $ ASSUMPTION: ideal matched dummy load
XMPPRE_f00_w1_r3 rbl_f00_w1_r3 pcb_100 prea prea sky130_fd_pr__pfet_01v8 L=0.15 W=5 nf=1 ad=1.45 as=1.45 pd=10.58 ps=10.58 nrd=0.058 nrs=0.058 sa=0 sb=0 sd=0 mult=1 m=1
XMPU1_f00_w1_r3 x_f00_w1_r3 dinb1 vdd vdd sky130_fd_pr__pfet_01v8 L=0.15 W=1 nf=1 ad=0.29 as=0.29 pd=2.58 ps=2.58 nrd=0.29 nrs=0.29 sa=0 sb=0 sd=0 mult=1 m=1
XMPU2_f00_w1_r3 wbl_f00_w1_r3 wenb x_f00_w1_r3 vdd sky130_fd_pr__pfet_01v8 L=0.15 W=1 nf=1 ad=0.29 as=0.29 pd=2.58 ps=2.58 nrd=0.29 nrs=0.29 sa=0 sb=0 sd=0 mult=1 m=1
XMND2_f00_w1_r3 wbl_f00_w1_r3 wen y_f00_w1_r3 0 sky130_fd_pr__nfet_01v8 L=0.15 W=4 nf=1 ad=1.16 as=1.16 pd=8.58 ps=8.58 nrd=0.0725 nrs=0.0725 sa=0 sb=0 sd=0 mult=1 m=1
XMND1_f00_w1_r3 y_f00_w1_r3 dinb1 0 0 sky130_fd_pr__nfet_01v8 L=0.15 W=4 nf=1 ad=1.16 as=1.16 pd=8.58 ps=8.58 nrd=0.0725 nrs=0.0725 sa=0 sb=0 sd=0 mult=1 m=1
XMNI_f00_w1_r3 wbl_f00_w1_r3 wenb 0 0 sky130_fd_pr__nfet_01v8 L=0.15 W=2 nf=1 ad=0.58 as=0.58 pd=4.58 ps=4.58 nrd=0.145 nrs=0.145 sa=0 sb=0 sd=0 mult=1 m=1
XMNS_f00_w1_r3 sbl_f00_w1_r3 sel_69500 rbl_f00_w1_r3 0 sky130_fd_pr__nfet_01v8 L=0.15 W=0.42 nf=1 ad=0.1218 as=0.1218 pd=1.42 ps=1.42 nrd=0.69047619047619 nrs=0.69047619047619 sa=0 sb=0 sd=0 mult=1 m=1
XMNSR_f00_w1_r3 sref_f00_w1_r3 sel_69500 ref_f00_w1_r3 0 sky130_fd_pr__nfet_01v8 L=0.15 W=0.42 nf=1 ad=0.1218 as=0.1218 pd=1.42 ps=1.42 nrd=0.69047619047619 nrs=0.69047619047619 sa=0 sb=0 sd=0 mult=1 m=1
XMPPREF_f00_w1_r3 ref_f00_w1_r3 pcb_100 pref pref sky130_fd_pr__pfet_01v8 L=0.15 W=5 nf=1 ad=1.45 as=1.45 pd=10.58 ps=10.58 nrd=0.058 nrs=0.058 sa=0 sb=0 sd=0 mult=1 m=1   $ reference-side precharge: copy of MPPRE
XMN1_f00_w1_r3 sbl_f00_w1_r3 sref_f00_w1_r3 vn_f00_w1_r3 0 sky130_fd_pr__nfet_01v8 L=0.15 W=1 nf=1 ad=0.29 as=0.29 pd=2.58 ps=2.58 nrd=0.29 nrs=0.29 sa=0 sb=0 sd=0 mult=1 m=1
XMN2_f00_w1_r3 sref_f00_w1_r3 sbl_f00_w1_r3 vn_f00_w1_r3 0 sky130_fd_pr__nfet_01v8 L=0.15 W=1 nf=1 ad=0.29 as=0.29 pd=2.58 ps=2.58 nrd=0.29 nrs=0.29 sa=0 sb=0 sd=0 mult=1 m=1
XMP1_f00_w1_r3 sbl_f00_w1_r3 sref_f00_w1_r3 vp_f00_w1_r3 vdd sky130_fd_pr__pfet_01v8 L=0.15 W=2 nf=1 ad=0.58 as=0.58 pd=4.58 ps=4.58 nrd=0.145 nrs=0.145 sa=0 sb=0 sd=0 mult=1 m=1
XMP2_f00_w1_r3 sref_f00_w1_r3 sbl_f00_w1_r3 vp_f00_w1_r3 vdd sky130_fd_pr__pfet_01v8 L=0.15 W=2 nf=1 ad=0.58 as=0.58 pd=4.58 ps=4.58 nrd=0.145 nrs=0.145 sa=0 sb=0 sd=0 mult=1 m=1
XMNF_f00_w1_r3 vn_f00_w1_r3 en 0 0 sky130_fd_pr__nfet_01v8 L=0.15 W=2 nf=1 ad=0.58 as=0.58 pd=4.58 ps=4.58 nrd=0.145 nrs=0.145 sa=0 sb=0 sd=0 mult=1 m=1
XMPH_f00_w1_r3 vp_f00_w1_r3 enb vdd vdd sky130_fd_pr__pfet_01v8 L=0.15 W=4 nf=1 ad=1.16 as=1.16 pd=8.58 ps=8.58 nrd=0.0725 nrs=0.0725 sa=0 sb=0 sd=0 mult=1 m=1
bd_f00_w1_r3 d_f00_w1_r3 0 v=v(sbl_f00_w1_r3)-v(sref_f00_w1_r3)
bdabs_f00_w1_r3 dabs_f00_w1_r3 0 v=abs(v(sbl_f00_w1_r3)-v(sref_f00_w1_r3))

* ---- instance 12: ideal_w0_r0 ----
XMWR_ideal_w0_r0_0 sn_ideal_w0_r0_0 wl wbl_ideal_w0_r0 0 sky130_fd_pr__nfet_01v8 L=0.15 W=0.42 nf=1 ad=0.1218 as=0.1218 pd=1.42 ps=1.42 nrd=0.69047619047619 nrs=0.69047619047619 sa=0 sb=0 sd=0 mult=1 m=1
XMRD_ideal_w0_r0_0 rbl_ideal_w0_r0 sn_ideal_w0_r0_0 rwl_sel 0 sky130_fd_pr__nfet_01v8 L=0.15 W=0.42 nf=1 ad=0.1218 as=0.1218 pd=1.42 ps=1.42 nrd=0.69047619047619 nrs=0.69047619047619 sa=0 sb=0 sd=0 mult=1 m=1
csn_ideal_w0_r0_0 sn_ideal_w0_r0_0 0 {C_SN}
XMWR_ideal_w0_r0_1 sn_ideal_w0_r0_1 0 wbl_ideal_w0_r0 0 sky130_fd_pr__nfet_01v8 L=0.15 W=0.42 nf=1 ad=0.1218 as=0.1218 pd=1.42 ps=1.42 nrd=0.69047619047619 nrs=0.69047619047619 sa=0 sb=0 sd=0 mult=1 m=1
XMRD_ideal_w0_r0_1 rbl_ideal_w0_r0 sn_ideal_w0_r0_1 rwl_des 0 sky130_fd_pr__nfet_01v8 L=0.15 W=0.42 nf=1 ad=0.1218 as=0.1218 pd=1.42 ps=1.42 nrd=0.69047619047619 nrs=0.69047619047619 sa=0 sb=0 sd=0 mult=1 m=1
csn_ideal_w0_r0_1 sn_ideal_w0_r0_1 0 {C_SN}
XMWR_ideal_w0_r0_2 sn_ideal_w0_r0_2 0 wbl_ideal_w0_r0 0 sky130_fd_pr__nfet_01v8 L=0.15 W=0.42 nf=1 ad=0.1218 as=0.1218 pd=1.42 ps=1.42 nrd=0.69047619047619 nrs=0.69047619047619 sa=0 sb=0 sd=0 mult=1 m=1
XMRD_ideal_w0_r0_2 rbl_ideal_w0_r0 sn_ideal_w0_r0_2 rwl_des 0 sky130_fd_pr__nfet_01v8 L=0.15 W=0.42 nf=1 ad=0.1218 as=0.1218 pd=1.42 ps=1.42 nrd=0.69047619047619 nrs=0.69047619047619 sa=0 sb=0 sd=0 mult=1 m=1
csn_ideal_w0_r0_2 sn_ideal_w0_r0_2 0 {C_SN}
XMWR_ideal_w0_r0_3 sn_ideal_w0_r0_3 0 wbl_ideal_w0_r0 0 sky130_fd_pr__nfet_01v8 L=0.15 W=0.42 nf=1 ad=0.1218 as=0.1218 pd=1.42 ps=1.42 nrd=0.69047619047619 nrs=0.69047619047619 sa=0 sb=0 sd=0 mult=1 m=1
XMRD_ideal_w0_r0_3 rbl_ideal_w0_r0 sn_ideal_w0_r0_3 rwl_des 0 sky130_fd_pr__nfet_01v8 L=0.15 W=0.42 nf=1 ad=0.1218 as=0.1218 pd=1.42 ps=1.42 nrd=0.69047619047619 nrs=0.69047619047619 sa=0 sb=0 sd=0 mult=1 m=1
csn_ideal_w0_r0_3 sn_ideal_w0_r0_3 0 {C_SN}
crbl_ideal_w0_r0 rbl_ideal_w0_r0 0 {C_RBL}
cwbl_ideal_w0_r0 wbl_ideal_w0_r0 0 {C_WBL}
cref_ideal_w0_r0 ref_ideal_w0_r0 0 {C_RBL}   $ ASSUMPTION: ideal matched dummy load
spr_ideal_w0_r0 pref ref_ideal_w0_r0 pca 0 swpre   $ reference-side precharge: ideal switch (#114 convention)
spa_ideal_w0_r0 prea rbl_ideal_w0_r0 pca 0 swpre   $ existing ideal precharge switch
vwbl_ideal_w0_r0 wbl_ideal_w0_r0 0 pwl(0 0 1e-08 0 1.01e-08 0 3.4e-08 0 3.41e-08 0)   $ ideal write source
XMN1_ideal_w0_r0 rbl_ideal_w0_r0 ref_ideal_w0_r0 vn_ideal_w0_r0 0 sky130_fd_pr__nfet_01v8 L=0.15 W=1 nf=1 ad=0.29 as=0.29 pd=2.58 ps=2.58 nrd=0.29 nrs=0.29 sa=0 sb=0 sd=0 mult=1 m=1
XMN2_ideal_w0_r0 ref_ideal_w0_r0 rbl_ideal_w0_r0 vn_ideal_w0_r0 0 sky130_fd_pr__nfet_01v8 L=0.15 W=1 nf=1 ad=0.29 as=0.29 pd=2.58 ps=2.58 nrd=0.29 nrs=0.29 sa=0 sb=0 sd=0 mult=1 m=1
XMP1_ideal_w0_r0 rbl_ideal_w0_r0 ref_ideal_w0_r0 vp_ideal_w0_r0 vdd sky130_fd_pr__pfet_01v8 L=0.15 W=2 nf=1 ad=0.58 as=0.58 pd=4.58 ps=4.58 nrd=0.145 nrs=0.145 sa=0 sb=0 sd=0 mult=1 m=1
XMP2_ideal_w0_r0 ref_ideal_w0_r0 rbl_ideal_w0_r0 vp_ideal_w0_r0 vdd sky130_fd_pr__pfet_01v8 L=0.15 W=2 nf=1 ad=0.58 as=0.58 pd=4.58 ps=4.58 nrd=0.145 nrs=0.145 sa=0 sb=0 sd=0 mult=1 m=1
XMNF_ideal_w0_r0 vn_ideal_w0_r0 en 0 0 sky130_fd_pr__nfet_01v8 L=0.15 W=2 nf=1 ad=0.58 as=0.58 pd=4.58 ps=4.58 nrd=0.145 nrs=0.145 sa=0 sb=0 sd=0 mult=1 m=1
XMPH_ideal_w0_r0 vp_ideal_w0_r0 enb vdd vdd sky130_fd_pr__pfet_01v8 L=0.15 W=4 nf=1 ad=1.16 as=1.16 pd=8.58 ps=8.58 nrd=0.0725 nrs=0.0725 sa=0 sb=0 sd=0 mult=1 m=1
bd_ideal_w0_r0 d_ideal_w0_r0 0 v=v(rbl_ideal_w0_r0)-v(ref_ideal_w0_r0)
bdabs_ideal_w0_r0 dabs_ideal_w0_r0 0 v=abs(v(rbl_ideal_w0_r0)-v(ref_ideal_w0_r0))

* ---- instance 13: i00_w0_r0 (baseline: TG nfet 1.0 / pfet 2.0, dummy 1x, lead 0.5 ns) ----
XMWR_i00_w0_r0_0 sn_i00_w0_r0_0 wl wbl_i00_w0_r0 0 sky130_fd_pr__nfet_01v8 L=0.15 W=0.42 nf=1 ad=0.1218 as=0.1218 pd=1.42 ps=1.42 nrd=0.69047619047619 nrs=0.69047619047619 sa=0 sb=0 sd=0 mult=1 m=1
XMRD_i00_w0_r0_0 rbl_i00_w0_r0 sn_i00_w0_r0_0 rwl_sel 0 sky130_fd_pr__nfet_01v8 L=0.15 W=0.42 nf=1 ad=0.1218 as=0.1218 pd=1.42 ps=1.42 nrd=0.69047619047619 nrs=0.69047619047619 sa=0 sb=0 sd=0 mult=1 m=1
csn_i00_w0_r0_0 sn_i00_w0_r0_0 0 {C_SN}
XMWR_i00_w0_r0_1 sn_i00_w0_r0_1 0 wbl_i00_w0_r0 0 sky130_fd_pr__nfet_01v8 L=0.15 W=0.42 nf=1 ad=0.1218 as=0.1218 pd=1.42 ps=1.42 nrd=0.69047619047619 nrs=0.69047619047619 sa=0 sb=0 sd=0 mult=1 m=1
XMRD_i00_w0_r0_1 rbl_i00_w0_r0 sn_i00_w0_r0_1 rwl_des 0 sky130_fd_pr__nfet_01v8 L=0.15 W=0.42 nf=1 ad=0.1218 as=0.1218 pd=1.42 ps=1.42 nrd=0.69047619047619 nrs=0.69047619047619 sa=0 sb=0 sd=0 mult=1 m=1
csn_i00_w0_r0_1 sn_i00_w0_r0_1 0 {C_SN}
XMWR_i00_w0_r0_2 sn_i00_w0_r0_2 0 wbl_i00_w0_r0 0 sky130_fd_pr__nfet_01v8 L=0.15 W=0.42 nf=1 ad=0.1218 as=0.1218 pd=1.42 ps=1.42 nrd=0.69047619047619 nrs=0.69047619047619 sa=0 sb=0 sd=0 mult=1 m=1
XMRD_i00_w0_r0_2 rbl_i00_w0_r0 sn_i00_w0_r0_2 rwl_des 0 sky130_fd_pr__nfet_01v8 L=0.15 W=0.42 nf=1 ad=0.1218 as=0.1218 pd=1.42 ps=1.42 nrd=0.69047619047619 nrs=0.69047619047619 sa=0 sb=0 sd=0 mult=1 m=1
csn_i00_w0_r0_2 sn_i00_w0_r0_2 0 {C_SN}
XMWR_i00_w0_r0_3 sn_i00_w0_r0_3 0 wbl_i00_w0_r0 0 sky130_fd_pr__nfet_01v8 L=0.15 W=0.42 nf=1 ad=0.1218 as=0.1218 pd=1.42 ps=1.42 nrd=0.69047619047619 nrs=0.69047619047619 sa=0 sb=0 sd=0 mult=1 m=1
XMRD_i00_w0_r0_3 rbl_i00_w0_r0 sn_i00_w0_r0_3 rwl_des 0 sky130_fd_pr__nfet_01v8 L=0.15 W=0.42 nf=1 ad=0.1218 as=0.1218 pd=1.42 ps=1.42 nrd=0.69047619047619 nrs=0.69047619047619 sa=0 sb=0 sd=0 mult=1 m=1
csn_i00_w0_r0_3 sn_i00_w0_r0_3 0 {C_SN}
crbl_i00_w0_r0 rbl_i00_w0_r0 0 {C_RBL}
cwbl_i00_w0_r0 wbl_i00_w0_r0 0 {C_WBL}
cref_i00_w0_r0 ref_i00_w0_r0 0 {C_RBL}   $ ASSUMPTION: ideal matched dummy load
spr_i00_w0_r0 pref ref_i00_w0_r0 pca 0 swpre   $ reference-side precharge: ideal switch (#114 convention)
XMPPRE_i00_w0_r0 rbl_i00_w0_r0 pcb_100 prea prea sky130_fd_pr__pfet_01v8 L=0.15 W=4 nf=1 ad=1.16 as=1.16 pd=8.58 ps=8.58 nrd=0.0725 nrs=0.0725 sa=0 sb=0 sd=0 mult=1 m=1
XMPU1_i00_w0_r0 x_i00_w0_r0 dinb0 vdd vdd sky130_fd_pr__pfet_01v8 L=0.15 W=1 nf=1 ad=0.29 as=0.29 pd=2.58 ps=2.58 nrd=0.29 nrs=0.29 sa=0 sb=0 sd=0 mult=1 m=1
XMPU2_i00_w0_r0 wbl_i00_w0_r0 wenb x_i00_w0_r0 vdd sky130_fd_pr__pfet_01v8 L=0.15 W=1 nf=1 ad=0.29 as=0.29 pd=2.58 ps=2.58 nrd=0.29 nrs=0.29 sa=0 sb=0 sd=0 mult=1 m=1
XMND2_i00_w0_r0 wbl_i00_w0_r0 wen y_i00_w0_r0 0 sky130_fd_pr__nfet_01v8 L=0.15 W=0.5 nf=1 ad=0.145 as=0.145 pd=1.58 ps=1.58 nrd=0.58 nrs=0.58 sa=0 sb=0 sd=0 mult=1 m=1
XMND1_i00_w0_r0 y_i00_w0_r0 dinb0 0 0 sky130_fd_pr__nfet_01v8 L=0.15 W=0.5 nf=1 ad=0.145 as=0.145 pd=1.58 ps=1.58 nrd=0.58 nrs=0.58 sa=0 sb=0 sd=0 mult=1 m=1
XMNI_i00_w0_r0 wbl_i00_w0_r0 wenb 0 0 sky130_fd_pr__nfet_01v8 L=0.15 W=0.42 nf=1 ad=0.1218 as=0.1218 pd=1.42 ps=1.42 nrd=0.69047619047619 nrs=0.69047619047619 sa=0 sb=0 sd=0 mult=1 m=1
XMNS_i00_w0_r0 sbl_i00_w0_r0 sel_69500 rbl_i00_w0_r0 0 sky130_fd_pr__nfet_01v8 L=0.15 W=1 nf=1 ad=0.29 as=0.29 pd=2.58 ps=2.58 nrd=0.29 nrs=0.29 sa=0 sb=0 sd=0 mult=1 m=1
XMPS_i00_w0_r0 sbl_i00_w0_r0 selb_69500 rbl_i00_w0_r0 vdd sky130_fd_pr__pfet_01v8 L=0.15 W=2 nf=1 ad=0.58 as=0.58 pd=4.58 ps=4.58 nrd=0.145 nrs=0.145 sa=0 sb=0 sd=0 mult=1 m=1
XMNSR_i00_w0_r0 sref_i00_w0_r0 sel_69500 ref_i00_w0_r0 0 sky130_fd_pr__nfet_01v8 L=0.15 W=1 nf=1 ad=0.29 as=0.29 pd=2.58 ps=2.58 nrd=0.29 nrs=0.29 sa=0 sb=0 sd=0 mult=1 m=1
XMPSR_i00_w0_r0 sref_i00_w0_r0 selb_69500 ref_i00_w0_r0 vdd sky130_fd_pr__pfet_01v8 L=0.15 W=2 nf=1 ad=0.58 as=0.58 pd=4.58 ps=4.58 nrd=0.145 nrs=0.145 sa=0 sb=0 sd=0 mult=1 m=1
XMN1_i00_w0_r0 sbl_i00_w0_r0 sref_i00_w0_r0 vn_i00_w0_r0 0 sky130_fd_pr__nfet_01v8 L=0.15 W=1 nf=1 ad=0.29 as=0.29 pd=2.58 ps=2.58 nrd=0.29 nrs=0.29 sa=0 sb=0 sd=0 mult=1 m=1
XMN2_i00_w0_r0 sref_i00_w0_r0 sbl_i00_w0_r0 vn_i00_w0_r0 0 sky130_fd_pr__nfet_01v8 L=0.15 W=1 nf=1 ad=0.29 as=0.29 pd=2.58 ps=2.58 nrd=0.29 nrs=0.29 sa=0 sb=0 sd=0 mult=1 m=1
XMP1_i00_w0_r0 sbl_i00_w0_r0 sref_i00_w0_r0 vp_i00_w0_r0 vdd sky130_fd_pr__pfet_01v8 L=0.15 W=2 nf=1 ad=0.58 as=0.58 pd=4.58 ps=4.58 nrd=0.145 nrs=0.145 sa=0 sb=0 sd=0 mult=1 m=1
XMP2_i00_w0_r0 sref_i00_w0_r0 sbl_i00_w0_r0 vp_i00_w0_r0 vdd sky130_fd_pr__pfet_01v8 L=0.15 W=2 nf=1 ad=0.58 as=0.58 pd=4.58 ps=4.58 nrd=0.145 nrs=0.145 sa=0 sb=0 sd=0 mult=1 m=1
XMNF_i00_w0_r0 vn_i00_w0_r0 en 0 0 sky130_fd_pr__nfet_01v8 L=0.15 W=2 nf=1 ad=0.58 as=0.58 pd=4.58 ps=4.58 nrd=0.145 nrs=0.145 sa=0 sb=0 sd=0 mult=1 m=1
XMPH_i00_w0_r0 vp_i00_w0_r0 enb vdd vdd sky130_fd_pr__pfet_01v8 L=0.15 W=4 nf=1 ad=1.16 as=1.16 pd=8.58 ps=8.58 nrd=0.0725 nrs=0.0725 sa=0 sb=0 sd=0 mult=1 m=1
bd_i00_w0_r0 d_i00_w0_r0 0 v=v(sbl_i00_w0_r0)-v(sref_i00_w0_r0)
bdabs_i00_w0_r0 dabs_i00_w0_r0 0 v=abs(v(sbl_i00_w0_r0)-v(sref_i00_w0_r0))

* ---- instance 14: f00_w0_r0 (FINAL: nfet-only 0.42 isolation, matched ref precharge 5.0, MND1/MND2 4.0, MNI 2.0) ----
XMWR_f00_w0_r0_0 sn_f00_w0_r0_0 wl wbl_f00_w0_r0 0 sky130_fd_pr__nfet_01v8 L=0.15 W=0.42 nf=1 ad=0.1218 as=0.1218 pd=1.42 ps=1.42 nrd=0.69047619047619 nrs=0.69047619047619 sa=0 sb=0 sd=0 mult=1 m=1
XMRD_f00_w0_r0_0 rbl_f00_w0_r0 sn_f00_w0_r0_0 rwl_sel 0 sky130_fd_pr__nfet_01v8 L=0.15 W=0.42 nf=1 ad=0.1218 as=0.1218 pd=1.42 ps=1.42 nrd=0.69047619047619 nrs=0.69047619047619 sa=0 sb=0 sd=0 mult=1 m=1
csn_f00_w0_r0_0 sn_f00_w0_r0_0 0 {C_SN}
XMWR_f00_w0_r0_1 sn_f00_w0_r0_1 0 wbl_f00_w0_r0 0 sky130_fd_pr__nfet_01v8 L=0.15 W=0.42 nf=1 ad=0.1218 as=0.1218 pd=1.42 ps=1.42 nrd=0.69047619047619 nrs=0.69047619047619 sa=0 sb=0 sd=0 mult=1 m=1
XMRD_f00_w0_r0_1 rbl_f00_w0_r0 sn_f00_w0_r0_1 rwl_des 0 sky130_fd_pr__nfet_01v8 L=0.15 W=0.42 nf=1 ad=0.1218 as=0.1218 pd=1.42 ps=1.42 nrd=0.69047619047619 nrs=0.69047619047619 sa=0 sb=0 sd=0 mult=1 m=1
csn_f00_w0_r0_1 sn_f00_w0_r0_1 0 {C_SN}
XMWR_f00_w0_r0_2 sn_f00_w0_r0_2 0 wbl_f00_w0_r0 0 sky130_fd_pr__nfet_01v8 L=0.15 W=0.42 nf=1 ad=0.1218 as=0.1218 pd=1.42 ps=1.42 nrd=0.69047619047619 nrs=0.69047619047619 sa=0 sb=0 sd=0 mult=1 m=1
XMRD_f00_w0_r0_2 rbl_f00_w0_r0 sn_f00_w0_r0_2 rwl_des 0 sky130_fd_pr__nfet_01v8 L=0.15 W=0.42 nf=1 ad=0.1218 as=0.1218 pd=1.42 ps=1.42 nrd=0.69047619047619 nrs=0.69047619047619 sa=0 sb=0 sd=0 mult=1 m=1
csn_f00_w0_r0_2 sn_f00_w0_r0_2 0 {C_SN}
XMWR_f00_w0_r0_3 sn_f00_w0_r0_3 0 wbl_f00_w0_r0 0 sky130_fd_pr__nfet_01v8 L=0.15 W=0.42 nf=1 ad=0.1218 as=0.1218 pd=1.42 ps=1.42 nrd=0.69047619047619 nrs=0.69047619047619 sa=0 sb=0 sd=0 mult=1 m=1
XMRD_f00_w0_r0_3 rbl_f00_w0_r0 sn_f00_w0_r0_3 rwl_des 0 sky130_fd_pr__nfet_01v8 L=0.15 W=0.42 nf=1 ad=0.1218 as=0.1218 pd=1.42 ps=1.42 nrd=0.69047619047619 nrs=0.69047619047619 sa=0 sb=0 sd=0 mult=1 m=1
csn_f00_w0_r0_3 sn_f00_w0_r0_3 0 {C_SN}
crbl_f00_w0_r0 rbl_f00_w0_r0 0 {C_RBL}
cwbl_f00_w0_r0 wbl_f00_w0_r0 0 {C_WBL}
cref_f00_w0_r0 ref_f00_w0_r0 0 {C_RBL}   $ ASSUMPTION: ideal matched dummy load
XMPPRE_f00_w0_r0 rbl_f00_w0_r0 pcb_100 prea prea sky130_fd_pr__pfet_01v8 L=0.15 W=5 nf=1 ad=1.45 as=1.45 pd=10.58 ps=10.58 nrd=0.058 nrs=0.058 sa=0 sb=0 sd=0 mult=1 m=1
XMPU1_f00_w0_r0 x_f00_w0_r0 dinb0 vdd vdd sky130_fd_pr__pfet_01v8 L=0.15 W=1 nf=1 ad=0.29 as=0.29 pd=2.58 ps=2.58 nrd=0.29 nrs=0.29 sa=0 sb=0 sd=0 mult=1 m=1
XMPU2_f00_w0_r0 wbl_f00_w0_r0 wenb x_f00_w0_r0 vdd sky130_fd_pr__pfet_01v8 L=0.15 W=1 nf=1 ad=0.29 as=0.29 pd=2.58 ps=2.58 nrd=0.29 nrs=0.29 sa=0 sb=0 sd=0 mult=1 m=1
XMND2_f00_w0_r0 wbl_f00_w0_r0 wen y_f00_w0_r0 0 sky130_fd_pr__nfet_01v8 L=0.15 W=4 nf=1 ad=1.16 as=1.16 pd=8.58 ps=8.58 nrd=0.0725 nrs=0.0725 sa=0 sb=0 sd=0 mult=1 m=1
XMND1_f00_w0_r0 y_f00_w0_r0 dinb0 0 0 sky130_fd_pr__nfet_01v8 L=0.15 W=4 nf=1 ad=1.16 as=1.16 pd=8.58 ps=8.58 nrd=0.0725 nrs=0.0725 sa=0 sb=0 sd=0 mult=1 m=1
XMNI_f00_w0_r0 wbl_f00_w0_r0 wenb 0 0 sky130_fd_pr__nfet_01v8 L=0.15 W=2 nf=1 ad=0.58 as=0.58 pd=4.58 ps=4.58 nrd=0.145 nrs=0.145 sa=0 sb=0 sd=0 mult=1 m=1
XMNS_f00_w0_r0 sbl_f00_w0_r0 sel_69500 rbl_f00_w0_r0 0 sky130_fd_pr__nfet_01v8 L=0.15 W=0.42 nf=1 ad=0.1218 as=0.1218 pd=1.42 ps=1.42 nrd=0.69047619047619 nrs=0.69047619047619 sa=0 sb=0 sd=0 mult=1 m=1
XMNSR_f00_w0_r0 sref_f00_w0_r0 sel_69500 ref_f00_w0_r0 0 sky130_fd_pr__nfet_01v8 L=0.15 W=0.42 nf=1 ad=0.1218 as=0.1218 pd=1.42 ps=1.42 nrd=0.69047619047619 nrs=0.69047619047619 sa=0 sb=0 sd=0 mult=1 m=1
XMPPREF_f00_w0_r0 ref_f00_w0_r0 pcb_100 pref pref sky130_fd_pr__pfet_01v8 L=0.15 W=5 nf=1 ad=1.45 as=1.45 pd=10.58 ps=10.58 nrd=0.058 nrs=0.058 sa=0 sb=0 sd=0 mult=1 m=1   $ reference-side precharge: copy of MPPRE
XMN1_f00_w0_r0 sbl_f00_w0_r0 sref_f00_w0_r0 vn_f00_w0_r0 0 sky130_fd_pr__nfet_01v8 L=0.15 W=1 nf=1 ad=0.29 as=0.29 pd=2.58 ps=2.58 nrd=0.29 nrs=0.29 sa=0 sb=0 sd=0 mult=1 m=1
XMN2_f00_w0_r0 sref_f00_w0_r0 sbl_f00_w0_r0 vn_f00_w0_r0 0 sky130_fd_pr__nfet_01v8 L=0.15 W=1 nf=1 ad=0.29 as=0.29 pd=2.58 ps=2.58 nrd=0.29 nrs=0.29 sa=0 sb=0 sd=0 mult=1 m=1
XMP1_f00_w0_r0 sbl_f00_w0_r0 sref_f00_w0_r0 vp_f00_w0_r0 vdd sky130_fd_pr__pfet_01v8 L=0.15 W=2 nf=1 ad=0.58 as=0.58 pd=4.58 ps=4.58 nrd=0.145 nrs=0.145 sa=0 sb=0 sd=0 mult=1 m=1
XMP2_f00_w0_r0 sref_f00_w0_r0 sbl_f00_w0_r0 vp_f00_w0_r0 vdd sky130_fd_pr__pfet_01v8 L=0.15 W=2 nf=1 ad=0.58 as=0.58 pd=4.58 ps=4.58 nrd=0.145 nrs=0.145 sa=0 sb=0 sd=0 mult=1 m=1
XMNF_f00_w0_r0 vn_f00_w0_r0 en 0 0 sky130_fd_pr__nfet_01v8 L=0.15 W=2 nf=1 ad=0.58 as=0.58 pd=4.58 ps=4.58 nrd=0.145 nrs=0.145 sa=0 sb=0 sd=0 mult=1 m=1
XMPH_f00_w0_r0 vp_f00_w0_r0 enb vdd vdd sky130_fd_pr__pfet_01v8 L=0.15 W=4 nf=1 ad=1.16 as=1.16 pd=8.58 ps=8.58 nrd=0.0725 nrs=0.0725 sa=0 sb=0 sd=0 mult=1 m=1
bd_f00_w0_r0 d_f00_w0_r0 0 v=v(sbl_f00_w0_r0)-v(sref_f00_w0_r0)
bdabs_f00_w0_r0 dabs_f00_w0_r0 0 v=abs(v(sbl_f00_w0_r0)-v(sref_f00_w0_r0))

* ---- instance 15: ideal_w0_r1 ----
XMWR_ideal_w0_r1_0 sn_ideal_w0_r1_0 wl wbl_ideal_w0_r1 0 sky130_fd_pr__nfet_01v8 L=0.15 W=0.42 nf=1 ad=0.1218 as=0.1218 pd=1.42 ps=1.42 nrd=0.69047619047619 nrs=0.69047619047619 sa=0 sb=0 sd=0 mult=1 m=1
XMRD_ideal_w0_r1_0 rbl_ideal_w0_r1 sn_ideal_w0_r1_0 rwl_sel 0 sky130_fd_pr__nfet_01v8 L=0.15 W=0.42 nf=1 ad=0.1218 as=0.1218 pd=1.42 ps=1.42 nrd=0.69047619047619 nrs=0.69047619047619 sa=0 sb=0 sd=0 mult=1 m=1
csn_ideal_w0_r1_0 sn_ideal_w0_r1_0 0 {C_SN}
XMWR_ideal_w0_r1_1 sn_ideal_w0_r1_1 0 wbl_ideal_w0_r1 0 sky130_fd_pr__nfet_01v8 L=0.15 W=0.42 nf=1 ad=0.1218 as=0.1218 pd=1.42 ps=1.42 nrd=0.69047619047619 nrs=0.69047619047619 sa=0 sb=0 sd=0 mult=1 m=1
XMRD_ideal_w0_r1_1 rbl_ideal_w0_r1 sn_ideal_w0_r1_1 rwl_des 0 sky130_fd_pr__nfet_01v8 L=0.15 W=0.42 nf=1 ad=0.1218 as=0.1218 pd=1.42 ps=1.42 nrd=0.69047619047619 nrs=0.69047619047619 sa=0 sb=0 sd=0 mult=1 m=1
csn_ideal_w0_r1_1 sn_ideal_w0_r1_1 0 {C_SN}
XMWR_ideal_w0_r1_2 sn_ideal_w0_r1_2 0 wbl_ideal_w0_r1 0 sky130_fd_pr__nfet_01v8 L=0.15 W=0.42 nf=1 ad=0.1218 as=0.1218 pd=1.42 ps=1.42 nrd=0.69047619047619 nrs=0.69047619047619 sa=0 sb=0 sd=0 mult=1 m=1
XMRD_ideal_w0_r1_2 rbl_ideal_w0_r1 sn_ideal_w0_r1_2 rwl_des 0 sky130_fd_pr__nfet_01v8 L=0.15 W=0.42 nf=1 ad=0.1218 as=0.1218 pd=1.42 ps=1.42 nrd=0.69047619047619 nrs=0.69047619047619 sa=0 sb=0 sd=0 mult=1 m=1
csn_ideal_w0_r1_2 sn_ideal_w0_r1_2 0 {C_SN}
XMWR_ideal_w0_r1_3 sn_ideal_w0_r1_3 0 wbl_ideal_w0_r1 0 sky130_fd_pr__nfet_01v8 L=0.15 W=0.42 nf=1 ad=0.1218 as=0.1218 pd=1.42 ps=1.42 nrd=0.69047619047619 nrs=0.69047619047619 sa=0 sb=0 sd=0 mult=1 m=1
XMRD_ideal_w0_r1_3 rbl_ideal_w0_r1 sn_ideal_w0_r1_3 rwl_des 0 sky130_fd_pr__nfet_01v8 L=0.15 W=0.42 nf=1 ad=0.1218 as=0.1218 pd=1.42 ps=1.42 nrd=0.69047619047619 nrs=0.69047619047619 sa=0 sb=0 sd=0 mult=1 m=1
csn_ideal_w0_r1_3 sn_ideal_w0_r1_3 0 {C_SN}
crbl_ideal_w0_r1 rbl_ideal_w0_r1 0 {C_RBL}
cwbl_ideal_w0_r1 wbl_ideal_w0_r1 0 {C_WBL}
cref_ideal_w0_r1 ref_ideal_w0_r1 0 {C_RBL}   $ ASSUMPTION: ideal matched dummy load
spr_ideal_w0_r1 pref ref_ideal_w0_r1 pca 0 swpre   $ reference-side precharge: ideal switch (#114 convention)
spa_ideal_w0_r1 prea rbl_ideal_w0_r1 pca 0 swpre   $ existing ideal precharge switch
vwbl_ideal_w0_r1 wbl_ideal_w0_r1 0 pwl(0 0 1e-08 0 1.01e-08 0 3.4e-08 0 3.41e-08 0)   $ ideal write source
XMN1_ideal_w0_r1 rbl_ideal_w0_r1 ref_ideal_w0_r1 vn_ideal_w0_r1 0 sky130_fd_pr__nfet_01v8 L=0.15 W=1 nf=1 ad=0.29 as=0.29 pd=2.58 ps=2.58 nrd=0.29 nrs=0.29 sa=0 sb=0 sd=0 mult=1 m=1
XMN2_ideal_w0_r1 ref_ideal_w0_r1 rbl_ideal_w0_r1 vn_ideal_w0_r1 0 sky130_fd_pr__nfet_01v8 L=0.15 W=1 nf=1 ad=0.29 as=0.29 pd=2.58 ps=2.58 nrd=0.29 nrs=0.29 sa=0 sb=0 sd=0 mult=1 m=1
XMP1_ideal_w0_r1 rbl_ideal_w0_r1 ref_ideal_w0_r1 vp_ideal_w0_r1 vdd sky130_fd_pr__pfet_01v8 L=0.15 W=2 nf=1 ad=0.58 as=0.58 pd=4.58 ps=4.58 nrd=0.145 nrs=0.145 sa=0 sb=0 sd=0 mult=1 m=1
XMP2_ideal_w0_r1 ref_ideal_w0_r1 rbl_ideal_w0_r1 vp_ideal_w0_r1 vdd sky130_fd_pr__pfet_01v8 L=0.15 W=2 nf=1 ad=0.58 as=0.58 pd=4.58 ps=4.58 nrd=0.145 nrs=0.145 sa=0 sb=0 sd=0 mult=1 m=1
XMNF_ideal_w0_r1 vn_ideal_w0_r1 en 0 0 sky130_fd_pr__nfet_01v8 L=0.15 W=2 nf=1 ad=0.58 as=0.58 pd=4.58 ps=4.58 nrd=0.145 nrs=0.145 sa=0 sb=0 sd=0 mult=1 m=1
XMPH_ideal_w0_r1 vp_ideal_w0_r1 enb vdd vdd sky130_fd_pr__pfet_01v8 L=0.15 W=4 nf=1 ad=1.16 as=1.16 pd=8.58 ps=8.58 nrd=0.0725 nrs=0.0725 sa=0 sb=0 sd=0 mult=1 m=1
bd_ideal_w0_r1 d_ideal_w0_r1 0 v=v(rbl_ideal_w0_r1)-v(ref_ideal_w0_r1)
bdabs_ideal_w0_r1 dabs_ideal_w0_r1 0 v=abs(v(rbl_ideal_w0_r1)-v(ref_ideal_w0_r1))

* ---- instance 16: i00_w0_r1 (baseline: TG nfet 1.0 / pfet 2.0, dummy 1x, lead 0.5 ns) ----
XMWR_i00_w0_r1_0 sn_i00_w0_r1_0 wl wbl_i00_w0_r1 0 sky130_fd_pr__nfet_01v8 L=0.15 W=0.42 nf=1 ad=0.1218 as=0.1218 pd=1.42 ps=1.42 nrd=0.69047619047619 nrs=0.69047619047619 sa=0 sb=0 sd=0 mult=1 m=1
XMRD_i00_w0_r1_0 rbl_i00_w0_r1 sn_i00_w0_r1_0 rwl_sel 0 sky130_fd_pr__nfet_01v8 L=0.15 W=0.42 nf=1 ad=0.1218 as=0.1218 pd=1.42 ps=1.42 nrd=0.69047619047619 nrs=0.69047619047619 sa=0 sb=0 sd=0 mult=1 m=1
csn_i00_w0_r1_0 sn_i00_w0_r1_0 0 {C_SN}
XMWR_i00_w0_r1_1 sn_i00_w0_r1_1 0 wbl_i00_w0_r1 0 sky130_fd_pr__nfet_01v8 L=0.15 W=0.42 nf=1 ad=0.1218 as=0.1218 pd=1.42 ps=1.42 nrd=0.69047619047619 nrs=0.69047619047619 sa=0 sb=0 sd=0 mult=1 m=1
XMRD_i00_w0_r1_1 rbl_i00_w0_r1 sn_i00_w0_r1_1 rwl_des 0 sky130_fd_pr__nfet_01v8 L=0.15 W=0.42 nf=1 ad=0.1218 as=0.1218 pd=1.42 ps=1.42 nrd=0.69047619047619 nrs=0.69047619047619 sa=0 sb=0 sd=0 mult=1 m=1
csn_i00_w0_r1_1 sn_i00_w0_r1_1 0 {C_SN}
XMWR_i00_w0_r1_2 sn_i00_w0_r1_2 0 wbl_i00_w0_r1 0 sky130_fd_pr__nfet_01v8 L=0.15 W=0.42 nf=1 ad=0.1218 as=0.1218 pd=1.42 ps=1.42 nrd=0.69047619047619 nrs=0.69047619047619 sa=0 sb=0 sd=0 mult=1 m=1
XMRD_i00_w0_r1_2 rbl_i00_w0_r1 sn_i00_w0_r1_2 rwl_des 0 sky130_fd_pr__nfet_01v8 L=0.15 W=0.42 nf=1 ad=0.1218 as=0.1218 pd=1.42 ps=1.42 nrd=0.69047619047619 nrs=0.69047619047619 sa=0 sb=0 sd=0 mult=1 m=1
csn_i00_w0_r1_2 sn_i00_w0_r1_2 0 {C_SN}
XMWR_i00_w0_r1_3 sn_i00_w0_r1_3 0 wbl_i00_w0_r1 0 sky130_fd_pr__nfet_01v8 L=0.15 W=0.42 nf=1 ad=0.1218 as=0.1218 pd=1.42 ps=1.42 nrd=0.69047619047619 nrs=0.69047619047619 sa=0 sb=0 sd=0 mult=1 m=1
XMRD_i00_w0_r1_3 rbl_i00_w0_r1 sn_i00_w0_r1_3 rwl_des 0 sky130_fd_pr__nfet_01v8 L=0.15 W=0.42 nf=1 ad=0.1218 as=0.1218 pd=1.42 ps=1.42 nrd=0.69047619047619 nrs=0.69047619047619 sa=0 sb=0 sd=0 mult=1 m=1
csn_i00_w0_r1_3 sn_i00_w0_r1_3 0 {C_SN}
crbl_i00_w0_r1 rbl_i00_w0_r1 0 {C_RBL}
cwbl_i00_w0_r1 wbl_i00_w0_r1 0 {C_WBL}
cref_i00_w0_r1 ref_i00_w0_r1 0 {C_RBL}   $ ASSUMPTION: ideal matched dummy load
spr_i00_w0_r1 pref ref_i00_w0_r1 pca 0 swpre   $ reference-side precharge: ideal switch (#114 convention)
XMPPRE_i00_w0_r1 rbl_i00_w0_r1 pcb_100 prea prea sky130_fd_pr__pfet_01v8 L=0.15 W=4 nf=1 ad=1.16 as=1.16 pd=8.58 ps=8.58 nrd=0.0725 nrs=0.0725 sa=0 sb=0 sd=0 mult=1 m=1
XMPU1_i00_w0_r1 x_i00_w0_r1 dinb0 vdd vdd sky130_fd_pr__pfet_01v8 L=0.15 W=1 nf=1 ad=0.29 as=0.29 pd=2.58 ps=2.58 nrd=0.29 nrs=0.29 sa=0 sb=0 sd=0 mult=1 m=1
XMPU2_i00_w0_r1 wbl_i00_w0_r1 wenb x_i00_w0_r1 vdd sky130_fd_pr__pfet_01v8 L=0.15 W=1 nf=1 ad=0.29 as=0.29 pd=2.58 ps=2.58 nrd=0.29 nrs=0.29 sa=0 sb=0 sd=0 mult=1 m=1
XMND2_i00_w0_r1 wbl_i00_w0_r1 wen y_i00_w0_r1 0 sky130_fd_pr__nfet_01v8 L=0.15 W=0.5 nf=1 ad=0.145 as=0.145 pd=1.58 ps=1.58 nrd=0.58 nrs=0.58 sa=0 sb=0 sd=0 mult=1 m=1
XMND1_i00_w0_r1 y_i00_w0_r1 dinb0 0 0 sky130_fd_pr__nfet_01v8 L=0.15 W=0.5 nf=1 ad=0.145 as=0.145 pd=1.58 ps=1.58 nrd=0.58 nrs=0.58 sa=0 sb=0 sd=0 mult=1 m=1
XMNI_i00_w0_r1 wbl_i00_w0_r1 wenb 0 0 sky130_fd_pr__nfet_01v8 L=0.15 W=0.42 nf=1 ad=0.1218 as=0.1218 pd=1.42 ps=1.42 nrd=0.69047619047619 nrs=0.69047619047619 sa=0 sb=0 sd=0 mult=1 m=1
XMNS_i00_w0_r1 sbl_i00_w0_r1 sel_69500 rbl_i00_w0_r1 0 sky130_fd_pr__nfet_01v8 L=0.15 W=1 nf=1 ad=0.29 as=0.29 pd=2.58 ps=2.58 nrd=0.29 nrs=0.29 sa=0 sb=0 sd=0 mult=1 m=1
XMPS_i00_w0_r1 sbl_i00_w0_r1 selb_69500 rbl_i00_w0_r1 vdd sky130_fd_pr__pfet_01v8 L=0.15 W=2 nf=1 ad=0.58 as=0.58 pd=4.58 ps=4.58 nrd=0.145 nrs=0.145 sa=0 sb=0 sd=0 mult=1 m=1
XMNSR_i00_w0_r1 sref_i00_w0_r1 sel_69500 ref_i00_w0_r1 0 sky130_fd_pr__nfet_01v8 L=0.15 W=1 nf=1 ad=0.29 as=0.29 pd=2.58 ps=2.58 nrd=0.29 nrs=0.29 sa=0 sb=0 sd=0 mult=1 m=1
XMPSR_i00_w0_r1 sref_i00_w0_r1 selb_69500 ref_i00_w0_r1 vdd sky130_fd_pr__pfet_01v8 L=0.15 W=2 nf=1 ad=0.58 as=0.58 pd=4.58 ps=4.58 nrd=0.145 nrs=0.145 sa=0 sb=0 sd=0 mult=1 m=1
XMN1_i00_w0_r1 sbl_i00_w0_r1 sref_i00_w0_r1 vn_i00_w0_r1 0 sky130_fd_pr__nfet_01v8 L=0.15 W=1 nf=1 ad=0.29 as=0.29 pd=2.58 ps=2.58 nrd=0.29 nrs=0.29 sa=0 sb=0 sd=0 mult=1 m=1
XMN2_i00_w0_r1 sref_i00_w0_r1 sbl_i00_w0_r1 vn_i00_w0_r1 0 sky130_fd_pr__nfet_01v8 L=0.15 W=1 nf=1 ad=0.29 as=0.29 pd=2.58 ps=2.58 nrd=0.29 nrs=0.29 sa=0 sb=0 sd=0 mult=1 m=1
XMP1_i00_w0_r1 sbl_i00_w0_r1 sref_i00_w0_r1 vp_i00_w0_r1 vdd sky130_fd_pr__pfet_01v8 L=0.15 W=2 nf=1 ad=0.58 as=0.58 pd=4.58 ps=4.58 nrd=0.145 nrs=0.145 sa=0 sb=0 sd=0 mult=1 m=1
XMP2_i00_w0_r1 sref_i00_w0_r1 sbl_i00_w0_r1 vp_i00_w0_r1 vdd sky130_fd_pr__pfet_01v8 L=0.15 W=2 nf=1 ad=0.58 as=0.58 pd=4.58 ps=4.58 nrd=0.145 nrs=0.145 sa=0 sb=0 sd=0 mult=1 m=1
XMNF_i00_w0_r1 vn_i00_w0_r1 en 0 0 sky130_fd_pr__nfet_01v8 L=0.15 W=2 nf=1 ad=0.58 as=0.58 pd=4.58 ps=4.58 nrd=0.145 nrs=0.145 sa=0 sb=0 sd=0 mult=1 m=1
XMPH_i00_w0_r1 vp_i00_w0_r1 enb vdd vdd sky130_fd_pr__pfet_01v8 L=0.15 W=4 nf=1 ad=1.16 as=1.16 pd=8.58 ps=8.58 nrd=0.0725 nrs=0.0725 sa=0 sb=0 sd=0 mult=1 m=1
bd_i00_w0_r1 d_i00_w0_r1 0 v=v(sbl_i00_w0_r1)-v(sref_i00_w0_r1)
bdabs_i00_w0_r1 dabs_i00_w0_r1 0 v=abs(v(sbl_i00_w0_r1)-v(sref_i00_w0_r1))

* ---- instance 17: f00_w0_r1 (FINAL: nfet-only 0.42 isolation, matched ref precharge 5.0, MND1/MND2 4.0, MNI 2.0) ----
XMWR_f00_w0_r1_0 sn_f00_w0_r1_0 wl wbl_f00_w0_r1 0 sky130_fd_pr__nfet_01v8 L=0.15 W=0.42 nf=1 ad=0.1218 as=0.1218 pd=1.42 ps=1.42 nrd=0.69047619047619 nrs=0.69047619047619 sa=0 sb=0 sd=0 mult=1 m=1
XMRD_f00_w0_r1_0 rbl_f00_w0_r1 sn_f00_w0_r1_0 rwl_sel 0 sky130_fd_pr__nfet_01v8 L=0.15 W=0.42 nf=1 ad=0.1218 as=0.1218 pd=1.42 ps=1.42 nrd=0.69047619047619 nrs=0.69047619047619 sa=0 sb=0 sd=0 mult=1 m=1
csn_f00_w0_r1_0 sn_f00_w0_r1_0 0 {C_SN}
XMWR_f00_w0_r1_1 sn_f00_w0_r1_1 0 wbl_f00_w0_r1 0 sky130_fd_pr__nfet_01v8 L=0.15 W=0.42 nf=1 ad=0.1218 as=0.1218 pd=1.42 ps=1.42 nrd=0.69047619047619 nrs=0.69047619047619 sa=0 sb=0 sd=0 mult=1 m=1
XMRD_f00_w0_r1_1 rbl_f00_w0_r1 sn_f00_w0_r1_1 rwl_des 0 sky130_fd_pr__nfet_01v8 L=0.15 W=0.42 nf=1 ad=0.1218 as=0.1218 pd=1.42 ps=1.42 nrd=0.69047619047619 nrs=0.69047619047619 sa=0 sb=0 sd=0 mult=1 m=1
csn_f00_w0_r1_1 sn_f00_w0_r1_1 0 {C_SN}
XMWR_f00_w0_r1_2 sn_f00_w0_r1_2 0 wbl_f00_w0_r1 0 sky130_fd_pr__nfet_01v8 L=0.15 W=0.42 nf=1 ad=0.1218 as=0.1218 pd=1.42 ps=1.42 nrd=0.69047619047619 nrs=0.69047619047619 sa=0 sb=0 sd=0 mult=1 m=1
XMRD_f00_w0_r1_2 rbl_f00_w0_r1 sn_f00_w0_r1_2 rwl_des 0 sky130_fd_pr__nfet_01v8 L=0.15 W=0.42 nf=1 ad=0.1218 as=0.1218 pd=1.42 ps=1.42 nrd=0.69047619047619 nrs=0.69047619047619 sa=0 sb=0 sd=0 mult=1 m=1
csn_f00_w0_r1_2 sn_f00_w0_r1_2 0 {C_SN}
XMWR_f00_w0_r1_3 sn_f00_w0_r1_3 0 wbl_f00_w0_r1 0 sky130_fd_pr__nfet_01v8 L=0.15 W=0.42 nf=1 ad=0.1218 as=0.1218 pd=1.42 ps=1.42 nrd=0.69047619047619 nrs=0.69047619047619 sa=0 sb=0 sd=0 mult=1 m=1
XMRD_f00_w0_r1_3 rbl_f00_w0_r1 sn_f00_w0_r1_3 rwl_des 0 sky130_fd_pr__nfet_01v8 L=0.15 W=0.42 nf=1 ad=0.1218 as=0.1218 pd=1.42 ps=1.42 nrd=0.69047619047619 nrs=0.69047619047619 sa=0 sb=0 sd=0 mult=1 m=1
csn_f00_w0_r1_3 sn_f00_w0_r1_3 0 {C_SN}
crbl_f00_w0_r1 rbl_f00_w0_r1 0 {C_RBL}
cwbl_f00_w0_r1 wbl_f00_w0_r1 0 {C_WBL}
cref_f00_w0_r1 ref_f00_w0_r1 0 {C_RBL}   $ ASSUMPTION: ideal matched dummy load
XMPPRE_f00_w0_r1 rbl_f00_w0_r1 pcb_100 prea prea sky130_fd_pr__pfet_01v8 L=0.15 W=5 nf=1 ad=1.45 as=1.45 pd=10.58 ps=10.58 nrd=0.058 nrs=0.058 sa=0 sb=0 sd=0 mult=1 m=1
XMPU1_f00_w0_r1 x_f00_w0_r1 dinb0 vdd vdd sky130_fd_pr__pfet_01v8 L=0.15 W=1 nf=1 ad=0.29 as=0.29 pd=2.58 ps=2.58 nrd=0.29 nrs=0.29 sa=0 sb=0 sd=0 mult=1 m=1
XMPU2_f00_w0_r1 wbl_f00_w0_r1 wenb x_f00_w0_r1 vdd sky130_fd_pr__pfet_01v8 L=0.15 W=1 nf=1 ad=0.29 as=0.29 pd=2.58 ps=2.58 nrd=0.29 nrs=0.29 sa=0 sb=0 sd=0 mult=1 m=1
XMND2_f00_w0_r1 wbl_f00_w0_r1 wen y_f00_w0_r1 0 sky130_fd_pr__nfet_01v8 L=0.15 W=4 nf=1 ad=1.16 as=1.16 pd=8.58 ps=8.58 nrd=0.0725 nrs=0.0725 sa=0 sb=0 sd=0 mult=1 m=1
XMND1_f00_w0_r1 y_f00_w0_r1 dinb0 0 0 sky130_fd_pr__nfet_01v8 L=0.15 W=4 nf=1 ad=1.16 as=1.16 pd=8.58 ps=8.58 nrd=0.0725 nrs=0.0725 sa=0 sb=0 sd=0 mult=1 m=1
XMNI_f00_w0_r1 wbl_f00_w0_r1 wenb 0 0 sky130_fd_pr__nfet_01v8 L=0.15 W=2 nf=1 ad=0.58 as=0.58 pd=4.58 ps=4.58 nrd=0.145 nrs=0.145 sa=0 sb=0 sd=0 mult=1 m=1
XMNS_f00_w0_r1 sbl_f00_w0_r1 sel_69500 rbl_f00_w0_r1 0 sky130_fd_pr__nfet_01v8 L=0.15 W=0.42 nf=1 ad=0.1218 as=0.1218 pd=1.42 ps=1.42 nrd=0.69047619047619 nrs=0.69047619047619 sa=0 sb=0 sd=0 mult=1 m=1
XMNSR_f00_w0_r1 sref_f00_w0_r1 sel_69500 ref_f00_w0_r1 0 sky130_fd_pr__nfet_01v8 L=0.15 W=0.42 nf=1 ad=0.1218 as=0.1218 pd=1.42 ps=1.42 nrd=0.69047619047619 nrs=0.69047619047619 sa=0 sb=0 sd=0 mult=1 m=1
XMPPREF_f00_w0_r1 ref_f00_w0_r1 pcb_100 pref pref sky130_fd_pr__pfet_01v8 L=0.15 W=5 nf=1 ad=1.45 as=1.45 pd=10.58 ps=10.58 nrd=0.058 nrs=0.058 sa=0 sb=0 sd=0 mult=1 m=1   $ reference-side precharge: copy of MPPRE
XMN1_f00_w0_r1 sbl_f00_w0_r1 sref_f00_w0_r1 vn_f00_w0_r1 0 sky130_fd_pr__nfet_01v8 L=0.15 W=1 nf=1 ad=0.29 as=0.29 pd=2.58 ps=2.58 nrd=0.29 nrs=0.29 sa=0 sb=0 sd=0 mult=1 m=1
XMN2_f00_w0_r1 sref_f00_w0_r1 sbl_f00_w0_r1 vn_f00_w0_r1 0 sky130_fd_pr__nfet_01v8 L=0.15 W=1 nf=1 ad=0.29 as=0.29 pd=2.58 ps=2.58 nrd=0.29 nrs=0.29 sa=0 sb=0 sd=0 mult=1 m=1
XMP1_f00_w0_r1 sbl_f00_w0_r1 sref_f00_w0_r1 vp_f00_w0_r1 vdd sky130_fd_pr__pfet_01v8 L=0.15 W=2 nf=1 ad=0.58 as=0.58 pd=4.58 ps=4.58 nrd=0.145 nrs=0.145 sa=0 sb=0 sd=0 mult=1 m=1
XMP2_f00_w0_r1 sref_f00_w0_r1 sbl_f00_w0_r1 vp_f00_w0_r1 vdd sky130_fd_pr__pfet_01v8 L=0.15 W=2 nf=1 ad=0.58 as=0.58 pd=4.58 ps=4.58 nrd=0.145 nrs=0.145 sa=0 sb=0 sd=0 mult=1 m=1
XMNF_f00_w0_r1 vn_f00_w0_r1 en 0 0 sky130_fd_pr__nfet_01v8 L=0.15 W=2 nf=1 ad=0.58 as=0.58 pd=4.58 ps=4.58 nrd=0.145 nrs=0.145 sa=0 sb=0 sd=0 mult=1 m=1
XMPH_f00_w0_r1 vp_f00_w0_r1 enb vdd vdd sky130_fd_pr__pfet_01v8 L=0.15 W=4 nf=1 ad=1.16 as=1.16 pd=8.58 ps=8.58 nrd=0.0725 nrs=0.0725 sa=0 sb=0 sd=0 mult=1 m=1
bd_f00_w0_r1 d_f00_w0_r1 0 v=v(sbl_f00_w0_r1)-v(sref_f00_w0_r1)
bdabs_f00_w0_r1 dabs_f00_w0_r1 0 v=abs(v(sbl_f00_w0_r1)-v(sref_f00_w0_r1))

* ---- instance 18: ideal_w0_r2 ----
XMWR_ideal_w0_r2_0 sn_ideal_w0_r2_0 wl wbl_ideal_w0_r2 0 sky130_fd_pr__nfet_01v8 L=0.15 W=0.42 nf=1 ad=0.1218 as=0.1218 pd=1.42 ps=1.42 nrd=0.69047619047619 nrs=0.69047619047619 sa=0 sb=0 sd=0 mult=1 m=1
XMRD_ideal_w0_r2_0 rbl_ideal_w0_r2 sn_ideal_w0_r2_0 rwl_sel 0 sky130_fd_pr__nfet_01v8 L=0.15 W=0.42 nf=1 ad=0.1218 as=0.1218 pd=1.42 ps=1.42 nrd=0.69047619047619 nrs=0.69047619047619 sa=0 sb=0 sd=0 mult=1 m=1
csn_ideal_w0_r2_0 sn_ideal_w0_r2_0 0 {C_SN}
XMWR_ideal_w0_r2_1 sn_ideal_w0_r2_1 0 wbl_ideal_w0_r2 0 sky130_fd_pr__nfet_01v8 L=0.15 W=0.42 nf=1 ad=0.1218 as=0.1218 pd=1.42 ps=1.42 nrd=0.69047619047619 nrs=0.69047619047619 sa=0 sb=0 sd=0 mult=1 m=1
XMRD_ideal_w0_r2_1 rbl_ideal_w0_r2 sn_ideal_w0_r2_1 rwl_des 0 sky130_fd_pr__nfet_01v8 L=0.15 W=0.42 nf=1 ad=0.1218 as=0.1218 pd=1.42 ps=1.42 nrd=0.69047619047619 nrs=0.69047619047619 sa=0 sb=0 sd=0 mult=1 m=1
csn_ideal_w0_r2_1 sn_ideal_w0_r2_1 0 {C_SN}
XMWR_ideal_w0_r2_2 sn_ideal_w0_r2_2 0 wbl_ideal_w0_r2 0 sky130_fd_pr__nfet_01v8 L=0.15 W=0.42 nf=1 ad=0.1218 as=0.1218 pd=1.42 ps=1.42 nrd=0.69047619047619 nrs=0.69047619047619 sa=0 sb=0 sd=0 mult=1 m=1
XMRD_ideal_w0_r2_2 rbl_ideal_w0_r2 sn_ideal_w0_r2_2 rwl_des 0 sky130_fd_pr__nfet_01v8 L=0.15 W=0.42 nf=1 ad=0.1218 as=0.1218 pd=1.42 ps=1.42 nrd=0.69047619047619 nrs=0.69047619047619 sa=0 sb=0 sd=0 mult=1 m=1
csn_ideal_w0_r2_2 sn_ideal_w0_r2_2 0 {C_SN}
XMWR_ideal_w0_r2_3 sn_ideal_w0_r2_3 0 wbl_ideal_w0_r2 0 sky130_fd_pr__nfet_01v8 L=0.15 W=0.42 nf=1 ad=0.1218 as=0.1218 pd=1.42 ps=1.42 nrd=0.69047619047619 nrs=0.69047619047619 sa=0 sb=0 sd=0 mult=1 m=1
XMRD_ideal_w0_r2_3 rbl_ideal_w0_r2 sn_ideal_w0_r2_3 rwl_des 0 sky130_fd_pr__nfet_01v8 L=0.15 W=0.42 nf=1 ad=0.1218 as=0.1218 pd=1.42 ps=1.42 nrd=0.69047619047619 nrs=0.69047619047619 sa=0 sb=0 sd=0 mult=1 m=1
csn_ideal_w0_r2_3 sn_ideal_w0_r2_3 0 {C_SN}
crbl_ideal_w0_r2 rbl_ideal_w0_r2 0 {C_RBL}
cwbl_ideal_w0_r2 wbl_ideal_w0_r2 0 {C_WBL}
cref_ideal_w0_r2 ref_ideal_w0_r2 0 {C_RBL}   $ ASSUMPTION: ideal matched dummy load
spr_ideal_w0_r2 pref ref_ideal_w0_r2 pca 0 swpre   $ reference-side precharge: ideal switch (#114 convention)
spa_ideal_w0_r2 prea rbl_ideal_w0_r2 pca 0 swpre   $ existing ideal precharge switch
vwbl_ideal_w0_r2 wbl_ideal_w0_r2 0 pwl(0 0 1e-08 0 1.01e-08 0 3.4e-08 0 3.41e-08 0)   $ ideal write source
XMN1_ideal_w0_r2 rbl_ideal_w0_r2 ref_ideal_w0_r2 vn_ideal_w0_r2 0 sky130_fd_pr__nfet_01v8 L=0.15 W=1 nf=1 ad=0.29 as=0.29 pd=2.58 ps=2.58 nrd=0.29 nrs=0.29 sa=0 sb=0 sd=0 mult=1 m=1
XMN2_ideal_w0_r2 ref_ideal_w0_r2 rbl_ideal_w0_r2 vn_ideal_w0_r2 0 sky130_fd_pr__nfet_01v8 L=0.15 W=1 nf=1 ad=0.29 as=0.29 pd=2.58 ps=2.58 nrd=0.29 nrs=0.29 sa=0 sb=0 sd=0 mult=1 m=1
XMP1_ideal_w0_r2 rbl_ideal_w0_r2 ref_ideal_w0_r2 vp_ideal_w0_r2 vdd sky130_fd_pr__pfet_01v8 L=0.15 W=2 nf=1 ad=0.58 as=0.58 pd=4.58 ps=4.58 nrd=0.145 nrs=0.145 sa=0 sb=0 sd=0 mult=1 m=1
XMP2_ideal_w0_r2 ref_ideal_w0_r2 rbl_ideal_w0_r2 vp_ideal_w0_r2 vdd sky130_fd_pr__pfet_01v8 L=0.15 W=2 nf=1 ad=0.58 as=0.58 pd=4.58 ps=4.58 nrd=0.145 nrs=0.145 sa=0 sb=0 sd=0 mult=1 m=1
XMNF_ideal_w0_r2 vn_ideal_w0_r2 en 0 0 sky130_fd_pr__nfet_01v8 L=0.15 W=2 nf=1 ad=0.58 as=0.58 pd=4.58 ps=4.58 nrd=0.145 nrs=0.145 sa=0 sb=0 sd=0 mult=1 m=1
XMPH_ideal_w0_r2 vp_ideal_w0_r2 enb vdd vdd sky130_fd_pr__pfet_01v8 L=0.15 W=4 nf=1 ad=1.16 as=1.16 pd=8.58 ps=8.58 nrd=0.0725 nrs=0.0725 sa=0 sb=0 sd=0 mult=1 m=1
bd_ideal_w0_r2 d_ideal_w0_r2 0 v=v(rbl_ideal_w0_r2)-v(ref_ideal_w0_r2)
bdabs_ideal_w0_r2 dabs_ideal_w0_r2 0 v=abs(v(rbl_ideal_w0_r2)-v(ref_ideal_w0_r2))

* ---- instance 19: i00_w0_r2 (baseline: TG nfet 1.0 / pfet 2.0, dummy 1x, lead 0.5 ns) ----
XMWR_i00_w0_r2_0 sn_i00_w0_r2_0 wl wbl_i00_w0_r2 0 sky130_fd_pr__nfet_01v8 L=0.15 W=0.42 nf=1 ad=0.1218 as=0.1218 pd=1.42 ps=1.42 nrd=0.69047619047619 nrs=0.69047619047619 sa=0 sb=0 sd=0 mult=1 m=1
XMRD_i00_w0_r2_0 rbl_i00_w0_r2 sn_i00_w0_r2_0 rwl_sel 0 sky130_fd_pr__nfet_01v8 L=0.15 W=0.42 nf=1 ad=0.1218 as=0.1218 pd=1.42 ps=1.42 nrd=0.69047619047619 nrs=0.69047619047619 sa=0 sb=0 sd=0 mult=1 m=1
csn_i00_w0_r2_0 sn_i00_w0_r2_0 0 {C_SN}
XMWR_i00_w0_r2_1 sn_i00_w0_r2_1 0 wbl_i00_w0_r2 0 sky130_fd_pr__nfet_01v8 L=0.15 W=0.42 nf=1 ad=0.1218 as=0.1218 pd=1.42 ps=1.42 nrd=0.69047619047619 nrs=0.69047619047619 sa=0 sb=0 sd=0 mult=1 m=1
XMRD_i00_w0_r2_1 rbl_i00_w0_r2 sn_i00_w0_r2_1 rwl_des 0 sky130_fd_pr__nfet_01v8 L=0.15 W=0.42 nf=1 ad=0.1218 as=0.1218 pd=1.42 ps=1.42 nrd=0.69047619047619 nrs=0.69047619047619 sa=0 sb=0 sd=0 mult=1 m=1
csn_i00_w0_r2_1 sn_i00_w0_r2_1 0 {C_SN}
XMWR_i00_w0_r2_2 sn_i00_w0_r2_2 0 wbl_i00_w0_r2 0 sky130_fd_pr__nfet_01v8 L=0.15 W=0.42 nf=1 ad=0.1218 as=0.1218 pd=1.42 ps=1.42 nrd=0.69047619047619 nrs=0.69047619047619 sa=0 sb=0 sd=0 mult=1 m=1
XMRD_i00_w0_r2_2 rbl_i00_w0_r2 sn_i00_w0_r2_2 rwl_des 0 sky130_fd_pr__nfet_01v8 L=0.15 W=0.42 nf=1 ad=0.1218 as=0.1218 pd=1.42 ps=1.42 nrd=0.69047619047619 nrs=0.69047619047619 sa=0 sb=0 sd=0 mult=1 m=1
csn_i00_w0_r2_2 sn_i00_w0_r2_2 0 {C_SN}
XMWR_i00_w0_r2_3 sn_i00_w0_r2_3 0 wbl_i00_w0_r2 0 sky130_fd_pr__nfet_01v8 L=0.15 W=0.42 nf=1 ad=0.1218 as=0.1218 pd=1.42 ps=1.42 nrd=0.69047619047619 nrs=0.69047619047619 sa=0 sb=0 sd=0 mult=1 m=1
XMRD_i00_w0_r2_3 rbl_i00_w0_r2 sn_i00_w0_r2_3 rwl_des 0 sky130_fd_pr__nfet_01v8 L=0.15 W=0.42 nf=1 ad=0.1218 as=0.1218 pd=1.42 ps=1.42 nrd=0.69047619047619 nrs=0.69047619047619 sa=0 sb=0 sd=0 mult=1 m=1
csn_i00_w0_r2_3 sn_i00_w0_r2_3 0 {C_SN}
crbl_i00_w0_r2 rbl_i00_w0_r2 0 {C_RBL}
cwbl_i00_w0_r2 wbl_i00_w0_r2 0 {C_WBL}
cref_i00_w0_r2 ref_i00_w0_r2 0 {C_RBL}   $ ASSUMPTION: ideal matched dummy load
spr_i00_w0_r2 pref ref_i00_w0_r2 pca 0 swpre   $ reference-side precharge: ideal switch (#114 convention)
XMPPRE_i00_w0_r2 rbl_i00_w0_r2 pcb_100 prea prea sky130_fd_pr__pfet_01v8 L=0.15 W=4 nf=1 ad=1.16 as=1.16 pd=8.58 ps=8.58 nrd=0.0725 nrs=0.0725 sa=0 sb=0 sd=0 mult=1 m=1
XMPU1_i00_w0_r2 x_i00_w0_r2 dinb0 vdd vdd sky130_fd_pr__pfet_01v8 L=0.15 W=1 nf=1 ad=0.29 as=0.29 pd=2.58 ps=2.58 nrd=0.29 nrs=0.29 sa=0 sb=0 sd=0 mult=1 m=1
XMPU2_i00_w0_r2 wbl_i00_w0_r2 wenb x_i00_w0_r2 vdd sky130_fd_pr__pfet_01v8 L=0.15 W=1 nf=1 ad=0.29 as=0.29 pd=2.58 ps=2.58 nrd=0.29 nrs=0.29 sa=0 sb=0 sd=0 mult=1 m=1
XMND2_i00_w0_r2 wbl_i00_w0_r2 wen y_i00_w0_r2 0 sky130_fd_pr__nfet_01v8 L=0.15 W=0.5 nf=1 ad=0.145 as=0.145 pd=1.58 ps=1.58 nrd=0.58 nrs=0.58 sa=0 sb=0 sd=0 mult=1 m=1
XMND1_i00_w0_r2 y_i00_w0_r2 dinb0 0 0 sky130_fd_pr__nfet_01v8 L=0.15 W=0.5 nf=1 ad=0.145 as=0.145 pd=1.58 ps=1.58 nrd=0.58 nrs=0.58 sa=0 sb=0 sd=0 mult=1 m=1
XMNI_i00_w0_r2 wbl_i00_w0_r2 wenb 0 0 sky130_fd_pr__nfet_01v8 L=0.15 W=0.42 nf=1 ad=0.1218 as=0.1218 pd=1.42 ps=1.42 nrd=0.69047619047619 nrs=0.69047619047619 sa=0 sb=0 sd=0 mult=1 m=1
XMNS_i00_w0_r2 sbl_i00_w0_r2 sel_69500 rbl_i00_w0_r2 0 sky130_fd_pr__nfet_01v8 L=0.15 W=1 nf=1 ad=0.29 as=0.29 pd=2.58 ps=2.58 nrd=0.29 nrs=0.29 sa=0 sb=0 sd=0 mult=1 m=1
XMPS_i00_w0_r2 sbl_i00_w0_r2 selb_69500 rbl_i00_w0_r2 vdd sky130_fd_pr__pfet_01v8 L=0.15 W=2 nf=1 ad=0.58 as=0.58 pd=4.58 ps=4.58 nrd=0.145 nrs=0.145 sa=0 sb=0 sd=0 mult=1 m=1
XMNSR_i00_w0_r2 sref_i00_w0_r2 sel_69500 ref_i00_w0_r2 0 sky130_fd_pr__nfet_01v8 L=0.15 W=1 nf=1 ad=0.29 as=0.29 pd=2.58 ps=2.58 nrd=0.29 nrs=0.29 sa=0 sb=0 sd=0 mult=1 m=1
XMPSR_i00_w0_r2 sref_i00_w0_r2 selb_69500 ref_i00_w0_r2 vdd sky130_fd_pr__pfet_01v8 L=0.15 W=2 nf=1 ad=0.58 as=0.58 pd=4.58 ps=4.58 nrd=0.145 nrs=0.145 sa=0 sb=0 sd=0 mult=1 m=1
XMN1_i00_w0_r2 sbl_i00_w0_r2 sref_i00_w0_r2 vn_i00_w0_r2 0 sky130_fd_pr__nfet_01v8 L=0.15 W=1 nf=1 ad=0.29 as=0.29 pd=2.58 ps=2.58 nrd=0.29 nrs=0.29 sa=0 sb=0 sd=0 mult=1 m=1
XMN2_i00_w0_r2 sref_i00_w0_r2 sbl_i00_w0_r2 vn_i00_w0_r2 0 sky130_fd_pr__nfet_01v8 L=0.15 W=1 nf=1 ad=0.29 as=0.29 pd=2.58 ps=2.58 nrd=0.29 nrs=0.29 sa=0 sb=0 sd=0 mult=1 m=1
XMP1_i00_w0_r2 sbl_i00_w0_r2 sref_i00_w0_r2 vp_i00_w0_r2 vdd sky130_fd_pr__pfet_01v8 L=0.15 W=2 nf=1 ad=0.58 as=0.58 pd=4.58 ps=4.58 nrd=0.145 nrs=0.145 sa=0 sb=0 sd=0 mult=1 m=1
XMP2_i00_w0_r2 sref_i00_w0_r2 sbl_i00_w0_r2 vp_i00_w0_r2 vdd sky130_fd_pr__pfet_01v8 L=0.15 W=2 nf=1 ad=0.58 as=0.58 pd=4.58 ps=4.58 nrd=0.145 nrs=0.145 sa=0 sb=0 sd=0 mult=1 m=1
XMNF_i00_w0_r2 vn_i00_w0_r2 en 0 0 sky130_fd_pr__nfet_01v8 L=0.15 W=2 nf=1 ad=0.58 as=0.58 pd=4.58 ps=4.58 nrd=0.145 nrs=0.145 sa=0 sb=0 sd=0 mult=1 m=1
XMPH_i00_w0_r2 vp_i00_w0_r2 enb vdd vdd sky130_fd_pr__pfet_01v8 L=0.15 W=4 nf=1 ad=1.16 as=1.16 pd=8.58 ps=8.58 nrd=0.0725 nrs=0.0725 sa=0 sb=0 sd=0 mult=1 m=1
bd_i00_w0_r2 d_i00_w0_r2 0 v=v(sbl_i00_w0_r2)-v(sref_i00_w0_r2)
bdabs_i00_w0_r2 dabs_i00_w0_r2 0 v=abs(v(sbl_i00_w0_r2)-v(sref_i00_w0_r2))

* ---- instance 20: f00_w0_r2 (FINAL: nfet-only 0.42 isolation, matched ref precharge 5.0, MND1/MND2 4.0, MNI 2.0) ----
XMWR_f00_w0_r2_0 sn_f00_w0_r2_0 wl wbl_f00_w0_r2 0 sky130_fd_pr__nfet_01v8 L=0.15 W=0.42 nf=1 ad=0.1218 as=0.1218 pd=1.42 ps=1.42 nrd=0.69047619047619 nrs=0.69047619047619 sa=0 sb=0 sd=0 mult=1 m=1
XMRD_f00_w0_r2_0 rbl_f00_w0_r2 sn_f00_w0_r2_0 rwl_sel 0 sky130_fd_pr__nfet_01v8 L=0.15 W=0.42 nf=1 ad=0.1218 as=0.1218 pd=1.42 ps=1.42 nrd=0.69047619047619 nrs=0.69047619047619 sa=0 sb=0 sd=0 mult=1 m=1
csn_f00_w0_r2_0 sn_f00_w0_r2_0 0 {C_SN}
XMWR_f00_w0_r2_1 sn_f00_w0_r2_1 0 wbl_f00_w0_r2 0 sky130_fd_pr__nfet_01v8 L=0.15 W=0.42 nf=1 ad=0.1218 as=0.1218 pd=1.42 ps=1.42 nrd=0.69047619047619 nrs=0.69047619047619 sa=0 sb=0 sd=0 mult=1 m=1
XMRD_f00_w0_r2_1 rbl_f00_w0_r2 sn_f00_w0_r2_1 rwl_des 0 sky130_fd_pr__nfet_01v8 L=0.15 W=0.42 nf=1 ad=0.1218 as=0.1218 pd=1.42 ps=1.42 nrd=0.69047619047619 nrs=0.69047619047619 sa=0 sb=0 sd=0 mult=1 m=1
csn_f00_w0_r2_1 sn_f00_w0_r2_1 0 {C_SN}
XMWR_f00_w0_r2_2 sn_f00_w0_r2_2 0 wbl_f00_w0_r2 0 sky130_fd_pr__nfet_01v8 L=0.15 W=0.42 nf=1 ad=0.1218 as=0.1218 pd=1.42 ps=1.42 nrd=0.69047619047619 nrs=0.69047619047619 sa=0 sb=0 sd=0 mult=1 m=1
XMRD_f00_w0_r2_2 rbl_f00_w0_r2 sn_f00_w0_r2_2 rwl_des 0 sky130_fd_pr__nfet_01v8 L=0.15 W=0.42 nf=1 ad=0.1218 as=0.1218 pd=1.42 ps=1.42 nrd=0.69047619047619 nrs=0.69047619047619 sa=0 sb=0 sd=0 mult=1 m=1
csn_f00_w0_r2_2 sn_f00_w0_r2_2 0 {C_SN}
XMWR_f00_w0_r2_3 sn_f00_w0_r2_3 0 wbl_f00_w0_r2 0 sky130_fd_pr__nfet_01v8 L=0.15 W=0.42 nf=1 ad=0.1218 as=0.1218 pd=1.42 ps=1.42 nrd=0.69047619047619 nrs=0.69047619047619 sa=0 sb=0 sd=0 mult=1 m=1
XMRD_f00_w0_r2_3 rbl_f00_w0_r2 sn_f00_w0_r2_3 rwl_des 0 sky130_fd_pr__nfet_01v8 L=0.15 W=0.42 nf=1 ad=0.1218 as=0.1218 pd=1.42 ps=1.42 nrd=0.69047619047619 nrs=0.69047619047619 sa=0 sb=0 sd=0 mult=1 m=1
csn_f00_w0_r2_3 sn_f00_w0_r2_3 0 {C_SN}
crbl_f00_w0_r2 rbl_f00_w0_r2 0 {C_RBL}
cwbl_f00_w0_r2 wbl_f00_w0_r2 0 {C_WBL}
cref_f00_w0_r2 ref_f00_w0_r2 0 {C_RBL}   $ ASSUMPTION: ideal matched dummy load
XMPPRE_f00_w0_r2 rbl_f00_w0_r2 pcb_100 prea prea sky130_fd_pr__pfet_01v8 L=0.15 W=5 nf=1 ad=1.45 as=1.45 pd=10.58 ps=10.58 nrd=0.058 nrs=0.058 sa=0 sb=0 sd=0 mult=1 m=1
XMPU1_f00_w0_r2 x_f00_w0_r2 dinb0 vdd vdd sky130_fd_pr__pfet_01v8 L=0.15 W=1 nf=1 ad=0.29 as=0.29 pd=2.58 ps=2.58 nrd=0.29 nrs=0.29 sa=0 sb=0 sd=0 mult=1 m=1
XMPU2_f00_w0_r2 wbl_f00_w0_r2 wenb x_f00_w0_r2 vdd sky130_fd_pr__pfet_01v8 L=0.15 W=1 nf=1 ad=0.29 as=0.29 pd=2.58 ps=2.58 nrd=0.29 nrs=0.29 sa=0 sb=0 sd=0 mult=1 m=1
XMND2_f00_w0_r2 wbl_f00_w0_r2 wen y_f00_w0_r2 0 sky130_fd_pr__nfet_01v8 L=0.15 W=4 nf=1 ad=1.16 as=1.16 pd=8.58 ps=8.58 nrd=0.0725 nrs=0.0725 sa=0 sb=0 sd=0 mult=1 m=1
XMND1_f00_w0_r2 y_f00_w0_r2 dinb0 0 0 sky130_fd_pr__nfet_01v8 L=0.15 W=4 nf=1 ad=1.16 as=1.16 pd=8.58 ps=8.58 nrd=0.0725 nrs=0.0725 sa=0 sb=0 sd=0 mult=1 m=1
XMNI_f00_w0_r2 wbl_f00_w0_r2 wenb 0 0 sky130_fd_pr__nfet_01v8 L=0.15 W=2 nf=1 ad=0.58 as=0.58 pd=4.58 ps=4.58 nrd=0.145 nrs=0.145 sa=0 sb=0 sd=0 mult=1 m=1
XMNS_f00_w0_r2 sbl_f00_w0_r2 sel_69500 rbl_f00_w0_r2 0 sky130_fd_pr__nfet_01v8 L=0.15 W=0.42 nf=1 ad=0.1218 as=0.1218 pd=1.42 ps=1.42 nrd=0.69047619047619 nrs=0.69047619047619 sa=0 sb=0 sd=0 mult=1 m=1
XMNSR_f00_w0_r2 sref_f00_w0_r2 sel_69500 ref_f00_w0_r2 0 sky130_fd_pr__nfet_01v8 L=0.15 W=0.42 nf=1 ad=0.1218 as=0.1218 pd=1.42 ps=1.42 nrd=0.69047619047619 nrs=0.69047619047619 sa=0 sb=0 sd=0 mult=1 m=1
XMPPREF_f00_w0_r2 ref_f00_w0_r2 pcb_100 pref pref sky130_fd_pr__pfet_01v8 L=0.15 W=5 nf=1 ad=1.45 as=1.45 pd=10.58 ps=10.58 nrd=0.058 nrs=0.058 sa=0 sb=0 sd=0 mult=1 m=1   $ reference-side precharge: copy of MPPRE
XMN1_f00_w0_r2 sbl_f00_w0_r2 sref_f00_w0_r2 vn_f00_w0_r2 0 sky130_fd_pr__nfet_01v8 L=0.15 W=1 nf=1 ad=0.29 as=0.29 pd=2.58 ps=2.58 nrd=0.29 nrs=0.29 sa=0 sb=0 sd=0 mult=1 m=1
XMN2_f00_w0_r2 sref_f00_w0_r2 sbl_f00_w0_r2 vn_f00_w0_r2 0 sky130_fd_pr__nfet_01v8 L=0.15 W=1 nf=1 ad=0.29 as=0.29 pd=2.58 ps=2.58 nrd=0.29 nrs=0.29 sa=0 sb=0 sd=0 mult=1 m=1
XMP1_f00_w0_r2 sbl_f00_w0_r2 sref_f00_w0_r2 vp_f00_w0_r2 vdd sky130_fd_pr__pfet_01v8 L=0.15 W=2 nf=1 ad=0.58 as=0.58 pd=4.58 ps=4.58 nrd=0.145 nrs=0.145 sa=0 sb=0 sd=0 mult=1 m=1
XMP2_f00_w0_r2 sref_f00_w0_r2 sbl_f00_w0_r2 vp_f00_w0_r2 vdd sky130_fd_pr__pfet_01v8 L=0.15 W=2 nf=1 ad=0.58 as=0.58 pd=4.58 ps=4.58 nrd=0.145 nrs=0.145 sa=0 sb=0 sd=0 mult=1 m=1
XMNF_f00_w0_r2 vn_f00_w0_r2 en 0 0 sky130_fd_pr__nfet_01v8 L=0.15 W=2 nf=1 ad=0.58 as=0.58 pd=4.58 ps=4.58 nrd=0.145 nrs=0.145 sa=0 sb=0 sd=0 mult=1 m=1
XMPH_f00_w0_r2 vp_f00_w0_r2 enb vdd vdd sky130_fd_pr__pfet_01v8 L=0.15 W=4 nf=1 ad=1.16 as=1.16 pd=8.58 ps=8.58 nrd=0.0725 nrs=0.0725 sa=0 sb=0 sd=0 mult=1 m=1
bd_f00_w0_r2 d_f00_w0_r2 0 v=v(sbl_f00_w0_r2)-v(sref_f00_w0_r2)
bdabs_f00_w0_r2 dabs_f00_w0_r2 0 v=abs(v(sbl_f00_w0_r2)-v(sref_f00_w0_r2))

* ---- instance 21: ideal_w0_r3 ----
XMWR_ideal_w0_r3_0 sn_ideal_w0_r3_0 wl wbl_ideal_w0_r3 0 sky130_fd_pr__nfet_01v8 L=0.15 W=0.42 nf=1 ad=0.1218 as=0.1218 pd=1.42 ps=1.42 nrd=0.69047619047619 nrs=0.69047619047619 sa=0 sb=0 sd=0 mult=1 m=1
XMRD_ideal_w0_r3_0 rbl_ideal_w0_r3 sn_ideal_w0_r3_0 rwl_sel 0 sky130_fd_pr__nfet_01v8 L=0.15 W=0.42 nf=1 ad=0.1218 as=0.1218 pd=1.42 ps=1.42 nrd=0.69047619047619 nrs=0.69047619047619 sa=0 sb=0 sd=0 mult=1 m=1
csn_ideal_w0_r3_0 sn_ideal_w0_r3_0 0 {C_SN}
XMWR_ideal_w0_r3_1 sn_ideal_w0_r3_1 0 wbl_ideal_w0_r3 0 sky130_fd_pr__nfet_01v8 L=0.15 W=0.42 nf=1 ad=0.1218 as=0.1218 pd=1.42 ps=1.42 nrd=0.69047619047619 nrs=0.69047619047619 sa=0 sb=0 sd=0 mult=1 m=1
XMRD_ideal_w0_r3_1 rbl_ideal_w0_r3 sn_ideal_w0_r3_1 rwl_des 0 sky130_fd_pr__nfet_01v8 L=0.15 W=0.42 nf=1 ad=0.1218 as=0.1218 pd=1.42 ps=1.42 nrd=0.69047619047619 nrs=0.69047619047619 sa=0 sb=0 sd=0 mult=1 m=1
csn_ideal_w0_r3_1 sn_ideal_w0_r3_1 0 {C_SN}
XMWR_ideal_w0_r3_2 sn_ideal_w0_r3_2 0 wbl_ideal_w0_r3 0 sky130_fd_pr__nfet_01v8 L=0.15 W=0.42 nf=1 ad=0.1218 as=0.1218 pd=1.42 ps=1.42 nrd=0.69047619047619 nrs=0.69047619047619 sa=0 sb=0 sd=0 mult=1 m=1
XMRD_ideal_w0_r3_2 rbl_ideal_w0_r3 sn_ideal_w0_r3_2 rwl_des 0 sky130_fd_pr__nfet_01v8 L=0.15 W=0.42 nf=1 ad=0.1218 as=0.1218 pd=1.42 ps=1.42 nrd=0.69047619047619 nrs=0.69047619047619 sa=0 sb=0 sd=0 mult=1 m=1
csn_ideal_w0_r3_2 sn_ideal_w0_r3_2 0 {C_SN}
XMWR_ideal_w0_r3_3 sn_ideal_w0_r3_3 0 wbl_ideal_w0_r3 0 sky130_fd_pr__nfet_01v8 L=0.15 W=0.42 nf=1 ad=0.1218 as=0.1218 pd=1.42 ps=1.42 nrd=0.69047619047619 nrs=0.69047619047619 sa=0 sb=0 sd=0 mult=1 m=1
XMRD_ideal_w0_r3_3 rbl_ideal_w0_r3 sn_ideal_w0_r3_3 rwl_des 0 sky130_fd_pr__nfet_01v8 L=0.15 W=0.42 nf=1 ad=0.1218 as=0.1218 pd=1.42 ps=1.42 nrd=0.69047619047619 nrs=0.69047619047619 sa=0 sb=0 sd=0 mult=1 m=1
csn_ideal_w0_r3_3 sn_ideal_w0_r3_3 0 {C_SN}
crbl_ideal_w0_r3 rbl_ideal_w0_r3 0 {C_RBL}
cwbl_ideal_w0_r3 wbl_ideal_w0_r3 0 {C_WBL}
cref_ideal_w0_r3 ref_ideal_w0_r3 0 {C_RBL}   $ ASSUMPTION: ideal matched dummy load
spr_ideal_w0_r3 pref ref_ideal_w0_r3 pca 0 swpre   $ reference-side precharge: ideal switch (#114 convention)
spa_ideal_w0_r3 prea rbl_ideal_w0_r3 pca 0 swpre   $ existing ideal precharge switch
vwbl_ideal_w0_r3 wbl_ideal_w0_r3 0 pwl(0 0 1e-08 0 1.01e-08 0 3.4e-08 0 3.41e-08 0)   $ ideal write source
XMN1_ideal_w0_r3 rbl_ideal_w0_r3 ref_ideal_w0_r3 vn_ideal_w0_r3 0 sky130_fd_pr__nfet_01v8 L=0.15 W=1 nf=1 ad=0.29 as=0.29 pd=2.58 ps=2.58 nrd=0.29 nrs=0.29 sa=0 sb=0 sd=0 mult=1 m=1
XMN2_ideal_w0_r3 ref_ideal_w0_r3 rbl_ideal_w0_r3 vn_ideal_w0_r3 0 sky130_fd_pr__nfet_01v8 L=0.15 W=1 nf=1 ad=0.29 as=0.29 pd=2.58 ps=2.58 nrd=0.29 nrs=0.29 sa=0 sb=0 sd=0 mult=1 m=1
XMP1_ideal_w0_r3 rbl_ideal_w0_r3 ref_ideal_w0_r3 vp_ideal_w0_r3 vdd sky130_fd_pr__pfet_01v8 L=0.15 W=2 nf=1 ad=0.58 as=0.58 pd=4.58 ps=4.58 nrd=0.145 nrs=0.145 sa=0 sb=0 sd=0 mult=1 m=1
XMP2_ideal_w0_r3 ref_ideal_w0_r3 rbl_ideal_w0_r3 vp_ideal_w0_r3 vdd sky130_fd_pr__pfet_01v8 L=0.15 W=2 nf=1 ad=0.58 as=0.58 pd=4.58 ps=4.58 nrd=0.145 nrs=0.145 sa=0 sb=0 sd=0 mult=1 m=1
XMNF_ideal_w0_r3 vn_ideal_w0_r3 en 0 0 sky130_fd_pr__nfet_01v8 L=0.15 W=2 nf=1 ad=0.58 as=0.58 pd=4.58 ps=4.58 nrd=0.145 nrs=0.145 sa=0 sb=0 sd=0 mult=1 m=1
XMPH_ideal_w0_r3 vp_ideal_w0_r3 enb vdd vdd sky130_fd_pr__pfet_01v8 L=0.15 W=4 nf=1 ad=1.16 as=1.16 pd=8.58 ps=8.58 nrd=0.0725 nrs=0.0725 sa=0 sb=0 sd=0 mult=1 m=1
bd_ideal_w0_r3 d_ideal_w0_r3 0 v=v(rbl_ideal_w0_r3)-v(ref_ideal_w0_r3)
bdabs_ideal_w0_r3 dabs_ideal_w0_r3 0 v=abs(v(rbl_ideal_w0_r3)-v(ref_ideal_w0_r3))

* ---- instance 22: i00_w0_r3 (baseline: TG nfet 1.0 / pfet 2.0, dummy 1x, lead 0.5 ns) ----
XMWR_i00_w0_r3_0 sn_i00_w0_r3_0 wl wbl_i00_w0_r3 0 sky130_fd_pr__nfet_01v8 L=0.15 W=0.42 nf=1 ad=0.1218 as=0.1218 pd=1.42 ps=1.42 nrd=0.69047619047619 nrs=0.69047619047619 sa=0 sb=0 sd=0 mult=1 m=1
XMRD_i00_w0_r3_0 rbl_i00_w0_r3 sn_i00_w0_r3_0 rwl_sel 0 sky130_fd_pr__nfet_01v8 L=0.15 W=0.42 nf=1 ad=0.1218 as=0.1218 pd=1.42 ps=1.42 nrd=0.69047619047619 nrs=0.69047619047619 sa=0 sb=0 sd=0 mult=1 m=1
csn_i00_w0_r3_0 sn_i00_w0_r3_0 0 {C_SN}
XMWR_i00_w0_r3_1 sn_i00_w0_r3_1 0 wbl_i00_w0_r3 0 sky130_fd_pr__nfet_01v8 L=0.15 W=0.42 nf=1 ad=0.1218 as=0.1218 pd=1.42 ps=1.42 nrd=0.69047619047619 nrs=0.69047619047619 sa=0 sb=0 sd=0 mult=1 m=1
XMRD_i00_w0_r3_1 rbl_i00_w0_r3 sn_i00_w0_r3_1 rwl_des 0 sky130_fd_pr__nfet_01v8 L=0.15 W=0.42 nf=1 ad=0.1218 as=0.1218 pd=1.42 ps=1.42 nrd=0.69047619047619 nrs=0.69047619047619 sa=0 sb=0 sd=0 mult=1 m=1
csn_i00_w0_r3_1 sn_i00_w0_r3_1 0 {C_SN}
XMWR_i00_w0_r3_2 sn_i00_w0_r3_2 0 wbl_i00_w0_r3 0 sky130_fd_pr__nfet_01v8 L=0.15 W=0.42 nf=1 ad=0.1218 as=0.1218 pd=1.42 ps=1.42 nrd=0.69047619047619 nrs=0.69047619047619 sa=0 sb=0 sd=0 mult=1 m=1
XMRD_i00_w0_r3_2 rbl_i00_w0_r3 sn_i00_w0_r3_2 rwl_des 0 sky130_fd_pr__nfet_01v8 L=0.15 W=0.42 nf=1 ad=0.1218 as=0.1218 pd=1.42 ps=1.42 nrd=0.69047619047619 nrs=0.69047619047619 sa=0 sb=0 sd=0 mult=1 m=1
csn_i00_w0_r3_2 sn_i00_w0_r3_2 0 {C_SN}
XMWR_i00_w0_r3_3 sn_i00_w0_r3_3 0 wbl_i00_w0_r3 0 sky130_fd_pr__nfet_01v8 L=0.15 W=0.42 nf=1 ad=0.1218 as=0.1218 pd=1.42 ps=1.42 nrd=0.69047619047619 nrs=0.69047619047619 sa=0 sb=0 sd=0 mult=1 m=1
XMRD_i00_w0_r3_3 rbl_i00_w0_r3 sn_i00_w0_r3_3 rwl_des 0 sky130_fd_pr__nfet_01v8 L=0.15 W=0.42 nf=1 ad=0.1218 as=0.1218 pd=1.42 ps=1.42 nrd=0.69047619047619 nrs=0.69047619047619 sa=0 sb=0 sd=0 mult=1 m=1
csn_i00_w0_r3_3 sn_i00_w0_r3_3 0 {C_SN}
crbl_i00_w0_r3 rbl_i00_w0_r3 0 {C_RBL}
cwbl_i00_w0_r3 wbl_i00_w0_r3 0 {C_WBL}
cref_i00_w0_r3 ref_i00_w0_r3 0 {C_RBL}   $ ASSUMPTION: ideal matched dummy load
spr_i00_w0_r3 pref ref_i00_w0_r3 pca 0 swpre   $ reference-side precharge: ideal switch (#114 convention)
XMPPRE_i00_w0_r3 rbl_i00_w0_r3 pcb_100 prea prea sky130_fd_pr__pfet_01v8 L=0.15 W=4 nf=1 ad=1.16 as=1.16 pd=8.58 ps=8.58 nrd=0.0725 nrs=0.0725 sa=0 sb=0 sd=0 mult=1 m=1
XMPU1_i00_w0_r3 x_i00_w0_r3 dinb0 vdd vdd sky130_fd_pr__pfet_01v8 L=0.15 W=1 nf=1 ad=0.29 as=0.29 pd=2.58 ps=2.58 nrd=0.29 nrs=0.29 sa=0 sb=0 sd=0 mult=1 m=1
XMPU2_i00_w0_r3 wbl_i00_w0_r3 wenb x_i00_w0_r3 vdd sky130_fd_pr__pfet_01v8 L=0.15 W=1 nf=1 ad=0.29 as=0.29 pd=2.58 ps=2.58 nrd=0.29 nrs=0.29 sa=0 sb=0 sd=0 mult=1 m=1
XMND2_i00_w0_r3 wbl_i00_w0_r3 wen y_i00_w0_r3 0 sky130_fd_pr__nfet_01v8 L=0.15 W=0.5 nf=1 ad=0.145 as=0.145 pd=1.58 ps=1.58 nrd=0.58 nrs=0.58 sa=0 sb=0 sd=0 mult=1 m=1
XMND1_i00_w0_r3 y_i00_w0_r3 dinb0 0 0 sky130_fd_pr__nfet_01v8 L=0.15 W=0.5 nf=1 ad=0.145 as=0.145 pd=1.58 ps=1.58 nrd=0.58 nrs=0.58 sa=0 sb=0 sd=0 mult=1 m=1
XMNI_i00_w0_r3 wbl_i00_w0_r3 wenb 0 0 sky130_fd_pr__nfet_01v8 L=0.15 W=0.42 nf=1 ad=0.1218 as=0.1218 pd=1.42 ps=1.42 nrd=0.69047619047619 nrs=0.69047619047619 sa=0 sb=0 sd=0 mult=1 m=1
XMNS_i00_w0_r3 sbl_i00_w0_r3 sel_69500 rbl_i00_w0_r3 0 sky130_fd_pr__nfet_01v8 L=0.15 W=1 nf=1 ad=0.29 as=0.29 pd=2.58 ps=2.58 nrd=0.29 nrs=0.29 sa=0 sb=0 sd=0 mult=1 m=1
XMPS_i00_w0_r3 sbl_i00_w0_r3 selb_69500 rbl_i00_w0_r3 vdd sky130_fd_pr__pfet_01v8 L=0.15 W=2 nf=1 ad=0.58 as=0.58 pd=4.58 ps=4.58 nrd=0.145 nrs=0.145 sa=0 sb=0 sd=0 mult=1 m=1
XMNSR_i00_w0_r3 sref_i00_w0_r3 sel_69500 ref_i00_w0_r3 0 sky130_fd_pr__nfet_01v8 L=0.15 W=1 nf=1 ad=0.29 as=0.29 pd=2.58 ps=2.58 nrd=0.29 nrs=0.29 sa=0 sb=0 sd=0 mult=1 m=1
XMPSR_i00_w0_r3 sref_i00_w0_r3 selb_69500 ref_i00_w0_r3 vdd sky130_fd_pr__pfet_01v8 L=0.15 W=2 nf=1 ad=0.58 as=0.58 pd=4.58 ps=4.58 nrd=0.145 nrs=0.145 sa=0 sb=0 sd=0 mult=1 m=1
XMN1_i00_w0_r3 sbl_i00_w0_r3 sref_i00_w0_r3 vn_i00_w0_r3 0 sky130_fd_pr__nfet_01v8 L=0.15 W=1 nf=1 ad=0.29 as=0.29 pd=2.58 ps=2.58 nrd=0.29 nrs=0.29 sa=0 sb=0 sd=0 mult=1 m=1
XMN2_i00_w0_r3 sref_i00_w0_r3 sbl_i00_w0_r3 vn_i00_w0_r3 0 sky130_fd_pr__nfet_01v8 L=0.15 W=1 nf=1 ad=0.29 as=0.29 pd=2.58 ps=2.58 nrd=0.29 nrs=0.29 sa=0 sb=0 sd=0 mult=1 m=1
XMP1_i00_w0_r3 sbl_i00_w0_r3 sref_i00_w0_r3 vp_i00_w0_r3 vdd sky130_fd_pr__pfet_01v8 L=0.15 W=2 nf=1 ad=0.58 as=0.58 pd=4.58 ps=4.58 nrd=0.145 nrs=0.145 sa=0 sb=0 sd=0 mult=1 m=1
XMP2_i00_w0_r3 sref_i00_w0_r3 sbl_i00_w0_r3 vp_i00_w0_r3 vdd sky130_fd_pr__pfet_01v8 L=0.15 W=2 nf=1 ad=0.58 as=0.58 pd=4.58 ps=4.58 nrd=0.145 nrs=0.145 sa=0 sb=0 sd=0 mult=1 m=1
XMNF_i00_w0_r3 vn_i00_w0_r3 en 0 0 sky130_fd_pr__nfet_01v8 L=0.15 W=2 nf=1 ad=0.58 as=0.58 pd=4.58 ps=4.58 nrd=0.145 nrs=0.145 sa=0 sb=0 sd=0 mult=1 m=1
XMPH_i00_w0_r3 vp_i00_w0_r3 enb vdd vdd sky130_fd_pr__pfet_01v8 L=0.15 W=4 nf=1 ad=1.16 as=1.16 pd=8.58 ps=8.58 nrd=0.0725 nrs=0.0725 sa=0 sb=0 sd=0 mult=1 m=1
bd_i00_w0_r3 d_i00_w0_r3 0 v=v(sbl_i00_w0_r3)-v(sref_i00_w0_r3)
bdabs_i00_w0_r3 dabs_i00_w0_r3 0 v=abs(v(sbl_i00_w0_r3)-v(sref_i00_w0_r3))

* ---- instance 23: f00_w0_r3 (FINAL: nfet-only 0.42 isolation, matched ref precharge 5.0, MND1/MND2 4.0, MNI 2.0) ----
XMWR_f00_w0_r3_0 sn_f00_w0_r3_0 wl wbl_f00_w0_r3 0 sky130_fd_pr__nfet_01v8 L=0.15 W=0.42 nf=1 ad=0.1218 as=0.1218 pd=1.42 ps=1.42 nrd=0.69047619047619 nrs=0.69047619047619 sa=0 sb=0 sd=0 mult=1 m=1
XMRD_f00_w0_r3_0 rbl_f00_w0_r3 sn_f00_w0_r3_0 rwl_sel 0 sky130_fd_pr__nfet_01v8 L=0.15 W=0.42 nf=1 ad=0.1218 as=0.1218 pd=1.42 ps=1.42 nrd=0.69047619047619 nrs=0.69047619047619 sa=0 sb=0 sd=0 mult=1 m=1
csn_f00_w0_r3_0 sn_f00_w0_r3_0 0 {C_SN}
XMWR_f00_w0_r3_1 sn_f00_w0_r3_1 0 wbl_f00_w0_r3 0 sky130_fd_pr__nfet_01v8 L=0.15 W=0.42 nf=1 ad=0.1218 as=0.1218 pd=1.42 ps=1.42 nrd=0.69047619047619 nrs=0.69047619047619 sa=0 sb=0 sd=0 mult=1 m=1
XMRD_f00_w0_r3_1 rbl_f00_w0_r3 sn_f00_w0_r3_1 rwl_des 0 sky130_fd_pr__nfet_01v8 L=0.15 W=0.42 nf=1 ad=0.1218 as=0.1218 pd=1.42 ps=1.42 nrd=0.69047619047619 nrs=0.69047619047619 sa=0 sb=0 sd=0 mult=1 m=1
csn_f00_w0_r3_1 sn_f00_w0_r3_1 0 {C_SN}
XMWR_f00_w0_r3_2 sn_f00_w0_r3_2 0 wbl_f00_w0_r3 0 sky130_fd_pr__nfet_01v8 L=0.15 W=0.42 nf=1 ad=0.1218 as=0.1218 pd=1.42 ps=1.42 nrd=0.69047619047619 nrs=0.69047619047619 sa=0 sb=0 sd=0 mult=1 m=1
XMRD_f00_w0_r3_2 rbl_f00_w0_r3 sn_f00_w0_r3_2 rwl_des 0 sky130_fd_pr__nfet_01v8 L=0.15 W=0.42 nf=1 ad=0.1218 as=0.1218 pd=1.42 ps=1.42 nrd=0.69047619047619 nrs=0.69047619047619 sa=0 sb=0 sd=0 mult=1 m=1
csn_f00_w0_r3_2 sn_f00_w0_r3_2 0 {C_SN}
XMWR_f00_w0_r3_3 sn_f00_w0_r3_3 0 wbl_f00_w0_r3 0 sky130_fd_pr__nfet_01v8 L=0.15 W=0.42 nf=1 ad=0.1218 as=0.1218 pd=1.42 ps=1.42 nrd=0.69047619047619 nrs=0.69047619047619 sa=0 sb=0 sd=0 mult=1 m=1
XMRD_f00_w0_r3_3 rbl_f00_w0_r3 sn_f00_w0_r3_3 rwl_des 0 sky130_fd_pr__nfet_01v8 L=0.15 W=0.42 nf=1 ad=0.1218 as=0.1218 pd=1.42 ps=1.42 nrd=0.69047619047619 nrs=0.69047619047619 sa=0 sb=0 sd=0 mult=1 m=1
csn_f00_w0_r3_3 sn_f00_w0_r3_3 0 {C_SN}
crbl_f00_w0_r3 rbl_f00_w0_r3 0 {C_RBL}
cwbl_f00_w0_r3 wbl_f00_w0_r3 0 {C_WBL}
cref_f00_w0_r3 ref_f00_w0_r3 0 {C_RBL}   $ ASSUMPTION: ideal matched dummy load
XMPPRE_f00_w0_r3 rbl_f00_w0_r3 pcb_100 prea prea sky130_fd_pr__pfet_01v8 L=0.15 W=5 nf=1 ad=1.45 as=1.45 pd=10.58 ps=10.58 nrd=0.058 nrs=0.058 sa=0 sb=0 sd=0 mult=1 m=1
XMPU1_f00_w0_r3 x_f00_w0_r3 dinb0 vdd vdd sky130_fd_pr__pfet_01v8 L=0.15 W=1 nf=1 ad=0.29 as=0.29 pd=2.58 ps=2.58 nrd=0.29 nrs=0.29 sa=0 sb=0 sd=0 mult=1 m=1
XMPU2_f00_w0_r3 wbl_f00_w0_r3 wenb x_f00_w0_r3 vdd sky130_fd_pr__pfet_01v8 L=0.15 W=1 nf=1 ad=0.29 as=0.29 pd=2.58 ps=2.58 nrd=0.29 nrs=0.29 sa=0 sb=0 sd=0 mult=1 m=1
XMND2_f00_w0_r3 wbl_f00_w0_r3 wen y_f00_w0_r3 0 sky130_fd_pr__nfet_01v8 L=0.15 W=4 nf=1 ad=1.16 as=1.16 pd=8.58 ps=8.58 nrd=0.0725 nrs=0.0725 sa=0 sb=0 sd=0 mult=1 m=1
XMND1_f00_w0_r3 y_f00_w0_r3 dinb0 0 0 sky130_fd_pr__nfet_01v8 L=0.15 W=4 nf=1 ad=1.16 as=1.16 pd=8.58 ps=8.58 nrd=0.0725 nrs=0.0725 sa=0 sb=0 sd=0 mult=1 m=1
XMNI_f00_w0_r3 wbl_f00_w0_r3 wenb 0 0 sky130_fd_pr__nfet_01v8 L=0.15 W=2 nf=1 ad=0.58 as=0.58 pd=4.58 ps=4.58 nrd=0.145 nrs=0.145 sa=0 sb=0 sd=0 mult=1 m=1
XMNS_f00_w0_r3 sbl_f00_w0_r3 sel_69500 rbl_f00_w0_r3 0 sky130_fd_pr__nfet_01v8 L=0.15 W=0.42 nf=1 ad=0.1218 as=0.1218 pd=1.42 ps=1.42 nrd=0.69047619047619 nrs=0.69047619047619 sa=0 sb=0 sd=0 mult=1 m=1
XMNSR_f00_w0_r3 sref_f00_w0_r3 sel_69500 ref_f00_w0_r3 0 sky130_fd_pr__nfet_01v8 L=0.15 W=0.42 nf=1 ad=0.1218 as=0.1218 pd=1.42 ps=1.42 nrd=0.69047619047619 nrs=0.69047619047619 sa=0 sb=0 sd=0 mult=1 m=1
XMPPREF_f00_w0_r3 ref_f00_w0_r3 pcb_100 pref pref sky130_fd_pr__pfet_01v8 L=0.15 W=5 nf=1 ad=1.45 as=1.45 pd=10.58 ps=10.58 nrd=0.058 nrs=0.058 sa=0 sb=0 sd=0 mult=1 m=1   $ reference-side precharge: copy of MPPRE
XMN1_f00_w0_r3 sbl_f00_w0_r3 sref_f00_w0_r3 vn_f00_w0_r3 0 sky130_fd_pr__nfet_01v8 L=0.15 W=1 nf=1 ad=0.29 as=0.29 pd=2.58 ps=2.58 nrd=0.29 nrs=0.29 sa=0 sb=0 sd=0 mult=1 m=1
XMN2_f00_w0_r3 sref_f00_w0_r3 sbl_f00_w0_r3 vn_f00_w0_r3 0 sky130_fd_pr__nfet_01v8 L=0.15 W=1 nf=1 ad=0.29 as=0.29 pd=2.58 ps=2.58 nrd=0.29 nrs=0.29 sa=0 sb=0 sd=0 mult=1 m=1
XMP1_f00_w0_r3 sbl_f00_w0_r3 sref_f00_w0_r3 vp_f00_w0_r3 vdd sky130_fd_pr__pfet_01v8 L=0.15 W=2 nf=1 ad=0.58 as=0.58 pd=4.58 ps=4.58 nrd=0.145 nrs=0.145 sa=0 sb=0 sd=0 mult=1 m=1
XMP2_f00_w0_r3 sref_f00_w0_r3 sbl_f00_w0_r3 vp_f00_w0_r3 vdd sky130_fd_pr__pfet_01v8 L=0.15 W=2 nf=1 ad=0.58 as=0.58 pd=4.58 ps=4.58 nrd=0.145 nrs=0.145 sa=0 sb=0 sd=0 mult=1 m=1
XMNF_f00_w0_r3 vn_f00_w0_r3 en 0 0 sky130_fd_pr__nfet_01v8 L=0.15 W=2 nf=1 ad=0.58 as=0.58 pd=4.58 ps=4.58 nrd=0.145 nrs=0.145 sa=0 sb=0 sd=0 mult=1 m=1
XMPH_f00_w0_r3 vp_f00_w0_r3 enb vdd vdd sky130_fd_pr__pfet_01v8 L=0.15 W=4 nf=1 ad=1.16 as=1.16 pd=8.58 ps=8.58 nrd=0.0725 nrs=0.0725 sa=0 sb=0 sd=0 mult=1 m=1
bd_f00_w0_r3 d_f00_w0_r3 0 v=v(sbl_f00_w0_r3)-v(sref_f00_w0_r3)
bdabs_f00_w0_r3 dabs_f00_w0_r3 0 v=abs(v(sbl_f00_w0_r3)-v(sref_f00_w0_r3))

* initial conditions (tran uic): rbl fully discharged, stored levels, tail nodes
.ic v(sn_ideal_w1_r0_0)=0 v(sn_ideal_w1_r0_1)=1 v(sn_ideal_w1_r0_2)=1 v(sn_ideal_w1_r0_3)=1 v(rbl_ideal_w1_r0)=0 v(ref_ideal_w1_r0)=0.8
.ic v(wbl_ideal_w1_r0)=0 v(vn_ideal_w1_r0)=0.45 v(vp_ideal_w1_r0)=1.35 v(sn_i00_w1_r0_0)=0 v(sn_i00_w1_r0_1)=1 v(sn_i00_w1_r0_2)=1
.ic v(sn_i00_w1_r0_3)=1 v(rbl_i00_w1_r0)=0 v(ref_i00_w1_r0)=0.8 v(wbl_i00_w1_r0)=0 v(sbl_i00_w1_r0)=0 v(sref_i00_w1_r0)=0.8
.ic v(vn_i00_w1_r0)=0.45 v(vp_i00_w1_r0)=1.35 v(sn_f00_w1_r0_0)=0 v(sn_f00_w1_r0_1)=1 v(sn_f00_w1_r0_2)=1 v(sn_f00_w1_r0_3)=1
.ic v(rbl_f00_w1_r0)=0 v(ref_f00_w1_r0)=0.8 v(wbl_f00_w1_r0)=0 v(sbl_f00_w1_r0)=0 v(sref_f00_w1_r0)=0.8 v(vn_f00_w1_r0)=0.45
.ic v(vp_f00_w1_r0)=1.35 v(sn_ideal_w1_r1_0)=0 v(sn_ideal_w1_r1_1)=1 v(sn_ideal_w1_r1_2)=1 v(sn_ideal_w1_r1_3)=1 v(rbl_ideal_w1_r1)=0
.ic v(ref_ideal_w1_r1)=0.8 v(wbl_ideal_w1_r1)=0 v(vn_ideal_w1_r1)=0.45 v(vp_ideal_w1_r1)=1.35 v(sn_i00_w1_r1_0)=0 v(sn_i00_w1_r1_1)=1
.ic v(sn_i00_w1_r1_2)=1 v(sn_i00_w1_r1_3)=1 v(rbl_i00_w1_r1)=0 v(ref_i00_w1_r1)=0.8 v(wbl_i00_w1_r1)=0 v(sbl_i00_w1_r1)=0
.ic v(sref_i00_w1_r1)=0.8 v(vn_i00_w1_r1)=0.45 v(vp_i00_w1_r1)=1.35 v(sn_f00_w1_r1_0)=0 v(sn_f00_w1_r1_1)=1 v(sn_f00_w1_r1_2)=1
.ic v(sn_f00_w1_r1_3)=1 v(rbl_f00_w1_r1)=0 v(ref_f00_w1_r1)=0.8 v(wbl_f00_w1_r1)=0 v(sbl_f00_w1_r1)=0 v(sref_f00_w1_r1)=0.8
.ic v(vn_f00_w1_r1)=0.45 v(vp_f00_w1_r1)=1.35 v(sn_ideal_w1_r2_0)=0 v(sn_ideal_w1_r2_1)=1 v(sn_ideal_w1_r2_2)=1 v(sn_ideal_w1_r2_3)=1
.ic v(rbl_ideal_w1_r2)=0 v(ref_ideal_w1_r2)=0.8 v(wbl_ideal_w1_r2)=0 v(vn_ideal_w1_r2)=0.45 v(vp_ideal_w1_r2)=1.35 v(sn_i00_w1_r2_0)=0
.ic v(sn_i00_w1_r2_1)=1 v(sn_i00_w1_r2_2)=1 v(sn_i00_w1_r2_3)=1 v(rbl_i00_w1_r2)=0 v(ref_i00_w1_r2)=0.8 v(wbl_i00_w1_r2)=0
.ic v(sbl_i00_w1_r2)=0 v(sref_i00_w1_r2)=0.8 v(vn_i00_w1_r2)=0.45 v(vp_i00_w1_r2)=1.35 v(sn_f00_w1_r2_0)=0 v(sn_f00_w1_r2_1)=1
.ic v(sn_f00_w1_r2_2)=1 v(sn_f00_w1_r2_3)=1 v(rbl_f00_w1_r2)=0 v(ref_f00_w1_r2)=0.8 v(wbl_f00_w1_r2)=0 v(sbl_f00_w1_r2)=0
.ic v(sref_f00_w1_r2)=0.8 v(vn_f00_w1_r2)=0.45 v(vp_f00_w1_r2)=1.35 v(sn_ideal_w1_r3_0)=0 v(sn_ideal_w1_r3_1)=1 v(sn_ideal_w1_r3_2)=1
.ic v(sn_ideal_w1_r3_3)=1 v(rbl_ideal_w1_r3)=0 v(ref_ideal_w1_r3)=0.8 v(wbl_ideal_w1_r3)=0 v(vn_ideal_w1_r3)=0.45 v(vp_ideal_w1_r3)=1.35
.ic v(sn_i00_w1_r3_0)=0 v(sn_i00_w1_r3_1)=1 v(sn_i00_w1_r3_2)=1 v(sn_i00_w1_r3_3)=1 v(rbl_i00_w1_r3)=0 v(ref_i00_w1_r3)=0.8
.ic v(wbl_i00_w1_r3)=0 v(sbl_i00_w1_r3)=0 v(sref_i00_w1_r3)=0.8 v(vn_i00_w1_r3)=0.45 v(vp_i00_w1_r3)=1.35 v(sn_f00_w1_r3_0)=0
.ic v(sn_f00_w1_r3_1)=1 v(sn_f00_w1_r3_2)=1 v(sn_f00_w1_r3_3)=1 v(rbl_f00_w1_r3)=0 v(ref_f00_w1_r3)=0.8 v(wbl_f00_w1_r3)=0
.ic v(sbl_f00_w1_r3)=0 v(sref_f00_w1_r3)=0.8 v(vn_f00_w1_r3)=0.45 v(vp_f00_w1_r3)=1.35 v(sn_ideal_w0_r0_0)=1 v(sn_ideal_w0_r0_1)=0
.ic v(sn_ideal_w0_r0_2)=0 v(sn_ideal_w0_r0_3)=0 v(rbl_ideal_w0_r0)=0 v(ref_ideal_w0_r0)=0.8 v(wbl_ideal_w0_r0)=0 v(vn_ideal_w0_r0)=0.45
.ic v(vp_ideal_w0_r0)=1.35 v(sn_i00_w0_r0_0)=1 v(sn_i00_w0_r0_1)=0 v(sn_i00_w0_r0_2)=0 v(sn_i00_w0_r0_3)=0 v(rbl_i00_w0_r0)=0
.ic v(ref_i00_w0_r0)=0.8 v(wbl_i00_w0_r0)=0 v(sbl_i00_w0_r0)=0 v(sref_i00_w0_r0)=0.8 v(vn_i00_w0_r0)=0.45 v(vp_i00_w0_r0)=1.35
.ic v(sn_f00_w0_r0_0)=1 v(sn_f00_w0_r0_1)=0 v(sn_f00_w0_r0_2)=0 v(sn_f00_w0_r0_3)=0 v(rbl_f00_w0_r0)=0 v(ref_f00_w0_r0)=0.8
.ic v(wbl_f00_w0_r0)=0 v(sbl_f00_w0_r0)=0 v(sref_f00_w0_r0)=0.8 v(vn_f00_w0_r0)=0.45 v(vp_f00_w0_r0)=1.35 v(sn_ideal_w0_r1_0)=1
.ic v(sn_ideal_w0_r1_1)=0 v(sn_ideal_w0_r1_2)=0 v(sn_ideal_w0_r1_3)=0 v(rbl_ideal_w0_r1)=0 v(ref_ideal_w0_r1)=0.8 v(wbl_ideal_w0_r1)=0
.ic v(vn_ideal_w0_r1)=0.45 v(vp_ideal_w0_r1)=1.35 v(sn_i00_w0_r1_0)=1 v(sn_i00_w0_r1_1)=0 v(sn_i00_w0_r1_2)=0 v(sn_i00_w0_r1_3)=0
.ic v(rbl_i00_w0_r1)=0 v(ref_i00_w0_r1)=0.8 v(wbl_i00_w0_r1)=0 v(sbl_i00_w0_r1)=0 v(sref_i00_w0_r1)=0.8 v(vn_i00_w0_r1)=0.45
.ic v(vp_i00_w0_r1)=1.35 v(sn_f00_w0_r1_0)=1 v(sn_f00_w0_r1_1)=0 v(sn_f00_w0_r1_2)=0 v(sn_f00_w0_r1_3)=0 v(rbl_f00_w0_r1)=0
.ic v(ref_f00_w0_r1)=0.8 v(wbl_f00_w0_r1)=0 v(sbl_f00_w0_r1)=0 v(sref_f00_w0_r1)=0.8 v(vn_f00_w0_r1)=0.45 v(vp_f00_w0_r1)=1.35
.ic v(sn_ideal_w0_r2_0)=1 v(sn_ideal_w0_r2_1)=0 v(sn_ideal_w0_r2_2)=0 v(sn_ideal_w0_r2_3)=0 v(rbl_ideal_w0_r2)=0 v(ref_ideal_w0_r2)=0.8
.ic v(wbl_ideal_w0_r2)=0 v(vn_ideal_w0_r2)=0.45 v(vp_ideal_w0_r2)=1.35 v(sn_i00_w0_r2_0)=1 v(sn_i00_w0_r2_1)=0 v(sn_i00_w0_r2_2)=0
.ic v(sn_i00_w0_r2_3)=0 v(rbl_i00_w0_r2)=0 v(ref_i00_w0_r2)=0.8 v(wbl_i00_w0_r2)=0 v(sbl_i00_w0_r2)=0 v(sref_i00_w0_r2)=0.8
.ic v(vn_i00_w0_r2)=0.45 v(vp_i00_w0_r2)=1.35 v(sn_f00_w0_r2_0)=1 v(sn_f00_w0_r2_1)=0 v(sn_f00_w0_r2_2)=0 v(sn_f00_w0_r2_3)=0
.ic v(rbl_f00_w0_r2)=0 v(ref_f00_w0_r2)=0.8 v(wbl_f00_w0_r2)=0 v(sbl_f00_w0_r2)=0 v(sref_f00_w0_r2)=0.8 v(vn_f00_w0_r2)=0.45
.ic v(vp_f00_w0_r2)=1.35 v(sn_ideal_w0_r3_0)=1 v(sn_ideal_w0_r3_1)=0 v(sn_ideal_w0_r3_2)=0 v(sn_ideal_w0_r3_3)=0 v(rbl_ideal_w0_r3)=0
.ic v(ref_ideal_w0_r3)=0.8 v(wbl_ideal_w0_r3)=0 v(vn_ideal_w0_r3)=0.45 v(vp_ideal_w0_r3)=1.35 v(sn_i00_w0_r3_0)=1 v(sn_i00_w0_r3_1)=0
.ic v(sn_i00_w0_r3_2)=0 v(sn_i00_w0_r3_3)=0 v(rbl_i00_w0_r3)=0 v(ref_i00_w0_r3)=0.8 v(wbl_i00_w0_r3)=0 v(sbl_i00_w0_r3)=0
.ic v(sref_i00_w0_r3)=0.8 v(vn_i00_w0_r3)=0.45 v(vp_i00_w0_r3)=1.35 v(sn_f00_w0_r3_0)=1 v(sn_f00_w0_r3_1)=0 v(sn_f00_w0_r3_2)=0
.ic v(sn_f00_w0_r3_3)=0 v(rbl_f00_w0_r3)=0 v(ref_f00_w0_r3)=0.8 v(wbl_f00_w0_r3)=0 v(sbl_f00_w0_r3)=0 v(sref_f00_w0_r3)=0.8
.ic v(vn_f00_w0_r3)=0.45 v(vp_f00_w0_r3)=1.35
