* isolation_study.spice -- isolation-gate / write-driver sweep -- GENERATED by gen_isolation_study.py (issue #117); do not edit by hand.
*
* Follow-up to sim/column-periphery (issue #114). PROPOSED/UNRATIFIED SCOPE: corners from
* spec/operating-range-decision-PROPOSED.md (27 C and 125 C only). Inputs follow
* sim/loaded-column/cold-corner/SENSE_INPUT_CONTRACT.md (baseline column).
* CIRCUIT BODY for `klt sim`: no .control/.end; PDK .lib/.temp cards are appended per corner.
*
* Instance kinds: ideal_w<d> = existing ideal sources (the #114 control); <tag>_w<d> = designed
* slice with the per-instance overrides listed in the README; d = data written to row 0.
* Per-instance isolation sources vs_<name>/vsb_<name> close the gates `lead` before the enable.
*
* ASSUMPTIONS (labelled; none is a spec value): C_RBL, C_WBL, VRBL, vpre rail an ideal 0.9 V
* source, 4-row column, all four SN at one level before the write except the written row,
* sense instant, reference level, ideal reference-side precharge and matched dummy load, ideal
* digital control edges (100 ps). sbl/sref carry only device parasitics unless csb is set.

.param VDD     = 1.8
.param VRBL    = 0.9   $ ASSUMPTION (contract)
.param VREF    = 0.8   $ ASSUMPTION: VRBL - 0.1 V (as sense-stage)
.param TEDGE   = 1e-10
.param C_RBL   = 1e-14   $ ASSUMPTION (contract; not extracted)
.param C_WBL   = 1e-14   $ ASSUMPTION (not extracted)
.param C_SN    = 6.05354e-16   $ extracted-from-netlist (layout/gain_cell_2t.extract.parasitics.json)

* ---- shared control (ideal digital edges) ----
vdd   vdd 0 dc {VDD}
vpca  pca 0 pwl(0 0 1e-09 0 1.1e-09 {VDD} 5.8e-08 {VDD} 5.81e-08 0)
vpcb  pcb 0 pwl(0 {VDD} 1e-09 {VDD} 1.1e-09 0 5.8e-08 0 5.81e-08 {VDD})
vwen  wen 0 pwl(0 0 1e-08 0 1.01e-08 {VDD} 3.4e-08 {VDD} 3.41e-08 0)
vwenb wenb 0 pwl(0 {VDD} 1e-08 {VDD} 1.01e-08 0 3.4e-08 0 3.41e-08 {VDD})
vdinb1 dinb1 0 dc 0          $ data '1': wbl = NOT dinb = VDD
vdinb0 dinb0 0 dc {VDD}      $ data '0'
vwl   wl 0 pwl(0 0 1.2e-08 0 1.21e-08 {VDD} 3.2e-08 {VDD} 3.21e-08 0)
vrwls rwl_sel 0 pwl(0 {VDD} 6e-08 {VDD} 6.01e-08 0)
vrwld rwl_des 0 dc {VDD}
ven   en  0 pwl(0 0 7e-08 0 7.01e-08 {VDD})
venb  enb 0 pwl(0 {VDD} 7e-08 {VDD} 7.01e-08 0)
vprea prea 0 dc {VRBL}       $ ASSUMPTION: ideal 0.9 V precharge rail
vpref pref 0 dc {VREF}
.model swpre sw(vt=0.9 vh=0.1 ron=100 roff=1e12)
vpca_100 pca_100 0 pwl(0 0 1e-09 0 1.1e-09 {VDD} 5.8e-08 {VDD} 5.81e-08 0)
vpcb_100 pcb_100 0 pwl(0 {VDD} 1e-09 {VDD} 1.1e-09 0 5.8e-08 0 5.81e-08 {VDD})
vpca_500 pca_500 0 pwl(0 0 1e-09 0 1.1e-09 {VDD} 5.8e-08 {VDD} 5.85e-08 0)
vpcb_500 pcb_500 0 pwl(0 {VDD} 1e-09 {VDD} 1.1e-09 0 5.8e-08 0 5.85e-08 {VDD})
vpca_1000 pca_1000 0 pwl(0 0 1e-09 0 1.1e-09 {VDD} 5.8e-08 {VDD} 5.9e-08 0)
vpcb_1000 pcb_1000 0 pwl(0 {VDD} 1e-09 {VDD} 1.1e-09 0 5.8e-08 0 5.9e-08 {VDD})
vsel_68000  sel_68000  0 pwl(0 {VDD} 6.8e-08 {VDD} 6.81e-08 0)
vselb_68000 selb_68000 0 pwl(0 0 6.8e-08 0 6.81e-08 {VDD})
vsel_69000  sel_69000  0 pwl(0 {VDD} 6.9e-08 {VDD} 6.91e-08 0)
vselb_69000 selb_69000 0 pwl(0 0 6.9e-08 0 6.91e-08 {VDD})
vsel_69500  sel_69500  0 pwl(0 {VDD} 6.95e-08 {VDD} 6.96e-08 0)
vselb_69500 selb_69500 0 pwl(0 0 6.95e-08 0 6.96e-08 {VDD})
vsel_69900  sel_69900  0 pwl(0 {VDD} 6.99e-08 {VDD} 7e-08 0)
vselb_69900 selb_69900 0 pwl(0 0 6.99e-08 0 7e-08 {VDD})

* ---- instance 0: ideal_w1 ----
XMWR_ideal_w1_0 sn_ideal_w1_0 wl wbl_ideal_w1 0 sky130_fd_pr__nfet_01v8 L=0.15 W=0.42 nf=1 ad=0.1218 as=0.1218 pd=1.42 ps=1.42 nrd=0.69047619047619 nrs=0.69047619047619 sa=0 sb=0 sd=0 mult=1 m=1
XMRD_ideal_w1_0 rbl_ideal_w1 sn_ideal_w1_0 rwl_sel 0 sky130_fd_pr__nfet_01v8 L=0.15 W=0.42 nf=1 ad=0.1218 as=0.1218 pd=1.42 ps=1.42 nrd=0.69047619047619 nrs=0.69047619047619 sa=0 sb=0 sd=0 mult=1 m=1
csn_ideal_w1_0 sn_ideal_w1_0 0 {C_SN}
XMWR_ideal_w1_1 sn_ideal_w1_1 0 wbl_ideal_w1 0 sky130_fd_pr__nfet_01v8 L=0.15 W=0.42 nf=1 ad=0.1218 as=0.1218 pd=1.42 ps=1.42 nrd=0.69047619047619 nrs=0.69047619047619 sa=0 sb=0 sd=0 mult=1 m=1
XMRD_ideal_w1_1 rbl_ideal_w1 sn_ideal_w1_1 rwl_des 0 sky130_fd_pr__nfet_01v8 L=0.15 W=0.42 nf=1 ad=0.1218 as=0.1218 pd=1.42 ps=1.42 nrd=0.69047619047619 nrs=0.69047619047619 sa=0 sb=0 sd=0 mult=1 m=1
csn_ideal_w1_1 sn_ideal_w1_1 0 {C_SN}
XMWR_ideal_w1_2 sn_ideal_w1_2 0 wbl_ideal_w1 0 sky130_fd_pr__nfet_01v8 L=0.15 W=0.42 nf=1 ad=0.1218 as=0.1218 pd=1.42 ps=1.42 nrd=0.69047619047619 nrs=0.69047619047619 sa=0 sb=0 sd=0 mult=1 m=1
XMRD_ideal_w1_2 rbl_ideal_w1 sn_ideal_w1_2 rwl_des 0 sky130_fd_pr__nfet_01v8 L=0.15 W=0.42 nf=1 ad=0.1218 as=0.1218 pd=1.42 ps=1.42 nrd=0.69047619047619 nrs=0.69047619047619 sa=0 sb=0 sd=0 mult=1 m=1
csn_ideal_w1_2 sn_ideal_w1_2 0 {C_SN}
XMWR_ideal_w1_3 sn_ideal_w1_3 0 wbl_ideal_w1 0 sky130_fd_pr__nfet_01v8 L=0.15 W=0.42 nf=1 ad=0.1218 as=0.1218 pd=1.42 ps=1.42 nrd=0.69047619047619 nrs=0.69047619047619 sa=0 sb=0 sd=0 mult=1 m=1
XMRD_ideal_w1_3 rbl_ideal_w1 sn_ideal_w1_3 rwl_des 0 sky130_fd_pr__nfet_01v8 L=0.15 W=0.42 nf=1 ad=0.1218 as=0.1218 pd=1.42 ps=1.42 nrd=0.69047619047619 nrs=0.69047619047619 sa=0 sb=0 sd=0 mult=1 m=1
csn_ideal_w1_3 sn_ideal_w1_3 0 {C_SN}
crbl_ideal_w1 rbl_ideal_w1 0 {C_RBL}
cwbl_ideal_w1 wbl_ideal_w1 0 {C_WBL}
cref_ideal_w1 ref_ideal_w1 0 {C_RBL}   $ ASSUMPTION: ideal matched dummy load
spr_ideal_w1 pref ref_ideal_w1 pca 0 swpre   $ reference-side precharge: ideal switch (#114 convention)
spa_ideal_w1 prea rbl_ideal_w1 pca 0 swpre   $ existing ideal precharge switch
vwbl_ideal_w1 wbl_ideal_w1 0 pwl(0 0 1e-08 0 1.01e-08 {VDD} 3.4e-08 {VDD} 3.41e-08 0)   $ ideal write source
XMN1_ideal_w1 rbl_ideal_w1 ref_ideal_w1 vn_ideal_w1 0 sky130_fd_pr__nfet_01v8 L=0.15 W=1 nf=1 ad=0.29 as=0.29 pd=2.58 ps=2.58 nrd=0.29 nrs=0.29 sa=0 sb=0 sd=0 mult=1 m=1
XMN2_ideal_w1 ref_ideal_w1 rbl_ideal_w1 vn_ideal_w1 0 sky130_fd_pr__nfet_01v8 L=0.15 W=1 nf=1 ad=0.29 as=0.29 pd=2.58 ps=2.58 nrd=0.29 nrs=0.29 sa=0 sb=0 sd=0 mult=1 m=1
XMP1_ideal_w1 rbl_ideal_w1 ref_ideal_w1 vp_ideal_w1 vdd sky130_fd_pr__pfet_01v8 L=0.15 W=2 nf=1 ad=0.58 as=0.58 pd=4.58 ps=4.58 nrd=0.145 nrs=0.145 sa=0 sb=0 sd=0 mult=1 m=1
XMP2_ideal_w1 ref_ideal_w1 rbl_ideal_w1 vp_ideal_w1 vdd sky130_fd_pr__pfet_01v8 L=0.15 W=2 nf=1 ad=0.58 as=0.58 pd=4.58 ps=4.58 nrd=0.145 nrs=0.145 sa=0 sb=0 sd=0 mult=1 m=1
XMNF_ideal_w1 vn_ideal_w1 en 0 0 sky130_fd_pr__nfet_01v8 L=0.15 W=2 nf=1 ad=0.58 as=0.58 pd=4.58 ps=4.58 nrd=0.145 nrs=0.145 sa=0 sb=0 sd=0 mult=1 m=1
XMPH_ideal_w1 vp_ideal_w1 enb vdd vdd sky130_fd_pr__pfet_01v8 L=0.15 W=4 nf=1 ad=1.16 as=1.16 pd=8.58 ps=8.58 nrd=0.0725 nrs=0.0725 sa=0 sb=0 sd=0 mult=1 m=1
bd_ideal_w1 d_ideal_w1 0 v=v(rbl_ideal_w1)-v(ref_ideal_w1)
bdabs_ideal_w1 dabs_ideal_w1 0 v=abs(v(rbl_ideal_w1)-v(ref_ideal_w1))

* ---- instance 1: ideal_w0 ----
XMWR_ideal_w0_0 sn_ideal_w0_0 wl wbl_ideal_w0 0 sky130_fd_pr__nfet_01v8 L=0.15 W=0.42 nf=1 ad=0.1218 as=0.1218 pd=1.42 ps=1.42 nrd=0.69047619047619 nrs=0.69047619047619 sa=0 sb=0 sd=0 mult=1 m=1
XMRD_ideal_w0_0 rbl_ideal_w0 sn_ideal_w0_0 rwl_sel 0 sky130_fd_pr__nfet_01v8 L=0.15 W=0.42 nf=1 ad=0.1218 as=0.1218 pd=1.42 ps=1.42 nrd=0.69047619047619 nrs=0.69047619047619 sa=0 sb=0 sd=0 mult=1 m=1
csn_ideal_w0_0 sn_ideal_w0_0 0 {C_SN}
XMWR_ideal_w0_1 sn_ideal_w0_1 0 wbl_ideal_w0 0 sky130_fd_pr__nfet_01v8 L=0.15 W=0.42 nf=1 ad=0.1218 as=0.1218 pd=1.42 ps=1.42 nrd=0.69047619047619 nrs=0.69047619047619 sa=0 sb=0 sd=0 mult=1 m=1
XMRD_ideal_w0_1 rbl_ideal_w0 sn_ideal_w0_1 rwl_des 0 sky130_fd_pr__nfet_01v8 L=0.15 W=0.42 nf=1 ad=0.1218 as=0.1218 pd=1.42 ps=1.42 nrd=0.69047619047619 nrs=0.69047619047619 sa=0 sb=0 sd=0 mult=1 m=1
csn_ideal_w0_1 sn_ideal_w0_1 0 {C_SN}
XMWR_ideal_w0_2 sn_ideal_w0_2 0 wbl_ideal_w0 0 sky130_fd_pr__nfet_01v8 L=0.15 W=0.42 nf=1 ad=0.1218 as=0.1218 pd=1.42 ps=1.42 nrd=0.69047619047619 nrs=0.69047619047619 sa=0 sb=0 sd=0 mult=1 m=1
XMRD_ideal_w0_2 rbl_ideal_w0 sn_ideal_w0_2 rwl_des 0 sky130_fd_pr__nfet_01v8 L=0.15 W=0.42 nf=1 ad=0.1218 as=0.1218 pd=1.42 ps=1.42 nrd=0.69047619047619 nrs=0.69047619047619 sa=0 sb=0 sd=0 mult=1 m=1
csn_ideal_w0_2 sn_ideal_w0_2 0 {C_SN}
XMWR_ideal_w0_3 sn_ideal_w0_3 0 wbl_ideal_w0 0 sky130_fd_pr__nfet_01v8 L=0.15 W=0.42 nf=1 ad=0.1218 as=0.1218 pd=1.42 ps=1.42 nrd=0.69047619047619 nrs=0.69047619047619 sa=0 sb=0 sd=0 mult=1 m=1
XMRD_ideal_w0_3 rbl_ideal_w0 sn_ideal_w0_3 rwl_des 0 sky130_fd_pr__nfet_01v8 L=0.15 W=0.42 nf=1 ad=0.1218 as=0.1218 pd=1.42 ps=1.42 nrd=0.69047619047619 nrs=0.69047619047619 sa=0 sb=0 sd=0 mult=1 m=1
csn_ideal_w0_3 sn_ideal_w0_3 0 {C_SN}
crbl_ideal_w0 rbl_ideal_w0 0 {C_RBL}
cwbl_ideal_w0 wbl_ideal_w0 0 {C_WBL}
cref_ideal_w0 ref_ideal_w0 0 {C_RBL}   $ ASSUMPTION: ideal matched dummy load
spr_ideal_w0 pref ref_ideal_w0 pca 0 swpre   $ reference-side precharge: ideal switch (#114 convention)
spa_ideal_w0 prea rbl_ideal_w0 pca 0 swpre   $ existing ideal precharge switch
vwbl_ideal_w0 wbl_ideal_w0 0 pwl(0 0 1e-08 0 1.01e-08 0 3.4e-08 0 3.41e-08 0)   $ ideal write source
XMN1_ideal_w0 rbl_ideal_w0 ref_ideal_w0 vn_ideal_w0 0 sky130_fd_pr__nfet_01v8 L=0.15 W=1 nf=1 ad=0.29 as=0.29 pd=2.58 ps=2.58 nrd=0.29 nrs=0.29 sa=0 sb=0 sd=0 mult=1 m=1
XMN2_ideal_w0 ref_ideal_w0 rbl_ideal_w0 vn_ideal_w0 0 sky130_fd_pr__nfet_01v8 L=0.15 W=1 nf=1 ad=0.29 as=0.29 pd=2.58 ps=2.58 nrd=0.29 nrs=0.29 sa=0 sb=0 sd=0 mult=1 m=1
XMP1_ideal_w0 rbl_ideal_w0 ref_ideal_w0 vp_ideal_w0 vdd sky130_fd_pr__pfet_01v8 L=0.15 W=2 nf=1 ad=0.58 as=0.58 pd=4.58 ps=4.58 nrd=0.145 nrs=0.145 sa=0 sb=0 sd=0 mult=1 m=1
XMP2_ideal_w0 ref_ideal_w0 rbl_ideal_w0 vp_ideal_w0 vdd sky130_fd_pr__pfet_01v8 L=0.15 W=2 nf=1 ad=0.58 as=0.58 pd=4.58 ps=4.58 nrd=0.145 nrs=0.145 sa=0 sb=0 sd=0 mult=1 m=1
XMNF_ideal_w0 vn_ideal_w0 en 0 0 sky130_fd_pr__nfet_01v8 L=0.15 W=2 nf=1 ad=0.58 as=0.58 pd=4.58 ps=4.58 nrd=0.145 nrs=0.145 sa=0 sb=0 sd=0 mult=1 m=1
XMPH_ideal_w0 vp_ideal_w0 enb vdd vdd sky130_fd_pr__pfet_01v8 L=0.15 W=4 nf=1 ad=1.16 as=1.16 pd=8.58 ps=8.58 nrd=0.0725 nrs=0.0725 sa=0 sb=0 sd=0 mult=1 m=1
bd_ideal_w0 d_ideal_w0 0 v=v(rbl_ideal_w0)-v(ref_ideal_w0)
bdabs_ideal_w0 dabs_ideal_w0 0 v=abs(v(rbl_ideal_w0)-v(ref_ideal_w0))

* ---- instance 2: i00_w1 (baseline: TG nfet 1.0 / pfet 2.0, dummy 1x, lead 0.5 ns) ----
XMWR_i00_w1_0 sn_i00_w1_0 wl wbl_i00_w1 0 sky130_fd_pr__nfet_01v8 L=0.15 W=0.42 nf=1 ad=0.1218 as=0.1218 pd=1.42 ps=1.42 nrd=0.69047619047619 nrs=0.69047619047619 sa=0 sb=0 sd=0 mult=1 m=1
XMRD_i00_w1_0 rbl_i00_w1 sn_i00_w1_0 rwl_sel 0 sky130_fd_pr__nfet_01v8 L=0.15 W=0.42 nf=1 ad=0.1218 as=0.1218 pd=1.42 ps=1.42 nrd=0.69047619047619 nrs=0.69047619047619 sa=0 sb=0 sd=0 mult=1 m=1
csn_i00_w1_0 sn_i00_w1_0 0 {C_SN}
XMWR_i00_w1_1 sn_i00_w1_1 0 wbl_i00_w1 0 sky130_fd_pr__nfet_01v8 L=0.15 W=0.42 nf=1 ad=0.1218 as=0.1218 pd=1.42 ps=1.42 nrd=0.69047619047619 nrs=0.69047619047619 sa=0 sb=0 sd=0 mult=1 m=1
XMRD_i00_w1_1 rbl_i00_w1 sn_i00_w1_1 rwl_des 0 sky130_fd_pr__nfet_01v8 L=0.15 W=0.42 nf=1 ad=0.1218 as=0.1218 pd=1.42 ps=1.42 nrd=0.69047619047619 nrs=0.69047619047619 sa=0 sb=0 sd=0 mult=1 m=1
csn_i00_w1_1 sn_i00_w1_1 0 {C_SN}
XMWR_i00_w1_2 sn_i00_w1_2 0 wbl_i00_w1 0 sky130_fd_pr__nfet_01v8 L=0.15 W=0.42 nf=1 ad=0.1218 as=0.1218 pd=1.42 ps=1.42 nrd=0.69047619047619 nrs=0.69047619047619 sa=0 sb=0 sd=0 mult=1 m=1
XMRD_i00_w1_2 rbl_i00_w1 sn_i00_w1_2 rwl_des 0 sky130_fd_pr__nfet_01v8 L=0.15 W=0.42 nf=1 ad=0.1218 as=0.1218 pd=1.42 ps=1.42 nrd=0.69047619047619 nrs=0.69047619047619 sa=0 sb=0 sd=0 mult=1 m=1
csn_i00_w1_2 sn_i00_w1_2 0 {C_SN}
XMWR_i00_w1_3 sn_i00_w1_3 0 wbl_i00_w1 0 sky130_fd_pr__nfet_01v8 L=0.15 W=0.42 nf=1 ad=0.1218 as=0.1218 pd=1.42 ps=1.42 nrd=0.69047619047619 nrs=0.69047619047619 sa=0 sb=0 sd=0 mult=1 m=1
XMRD_i00_w1_3 rbl_i00_w1 sn_i00_w1_3 rwl_des 0 sky130_fd_pr__nfet_01v8 L=0.15 W=0.42 nf=1 ad=0.1218 as=0.1218 pd=1.42 ps=1.42 nrd=0.69047619047619 nrs=0.69047619047619 sa=0 sb=0 sd=0 mult=1 m=1
csn_i00_w1_3 sn_i00_w1_3 0 {C_SN}
crbl_i00_w1 rbl_i00_w1 0 {C_RBL}
cwbl_i00_w1 wbl_i00_w1 0 {C_WBL}
cref_i00_w1 ref_i00_w1 0 {C_RBL}   $ ASSUMPTION: ideal matched dummy load
spr_i00_w1 pref ref_i00_w1 pca 0 swpre   $ reference-side precharge: ideal switch (#114 convention)
XMPPRE_i00_w1 rbl_i00_w1 pcb_100 prea prea sky130_fd_pr__pfet_01v8 L=0.15 W=4 nf=1 ad=1.16 as=1.16 pd=8.58 ps=8.58 nrd=0.0725 nrs=0.0725 sa=0 sb=0 sd=0 mult=1 m=1
XMPU1_i00_w1 x_i00_w1 dinb1 vdd vdd sky130_fd_pr__pfet_01v8 L=0.15 W=1 nf=1 ad=0.29 as=0.29 pd=2.58 ps=2.58 nrd=0.29 nrs=0.29 sa=0 sb=0 sd=0 mult=1 m=1
XMPU2_i00_w1 wbl_i00_w1 wenb x_i00_w1 vdd sky130_fd_pr__pfet_01v8 L=0.15 W=1 nf=1 ad=0.29 as=0.29 pd=2.58 ps=2.58 nrd=0.29 nrs=0.29 sa=0 sb=0 sd=0 mult=1 m=1
XMND2_i00_w1 wbl_i00_w1 wen y_i00_w1 0 sky130_fd_pr__nfet_01v8 L=0.15 W=0.5 nf=1 ad=0.145 as=0.145 pd=1.58 ps=1.58 nrd=0.58 nrs=0.58 sa=0 sb=0 sd=0 mult=1 m=1
XMND1_i00_w1 y_i00_w1 dinb1 0 0 sky130_fd_pr__nfet_01v8 L=0.15 W=0.5 nf=1 ad=0.145 as=0.145 pd=1.58 ps=1.58 nrd=0.58 nrs=0.58 sa=0 sb=0 sd=0 mult=1 m=1
XMNI_i00_w1 wbl_i00_w1 wenb 0 0 sky130_fd_pr__nfet_01v8 L=0.15 W=0.42 nf=1 ad=0.1218 as=0.1218 pd=1.42 ps=1.42 nrd=0.69047619047619 nrs=0.69047619047619 sa=0 sb=0 sd=0 mult=1 m=1
XMNS_i00_w1 sbl_i00_w1 sel_69500 rbl_i00_w1 0 sky130_fd_pr__nfet_01v8 L=0.15 W=1 nf=1 ad=0.29 as=0.29 pd=2.58 ps=2.58 nrd=0.29 nrs=0.29 sa=0 sb=0 sd=0 mult=1 m=1
XMPS_i00_w1 sbl_i00_w1 selb_69500 rbl_i00_w1 vdd sky130_fd_pr__pfet_01v8 L=0.15 W=2 nf=1 ad=0.58 as=0.58 pd=4.58 ps=4.58 nrd=0.145 nrs=0.145 sa=0 sb=0 sd=0 mult=1 m=1
XMNSR_i00_w1 sref_i00_w1 sel_69500 ref_i00_w1 0 sky130_fd_pr__nfet_01v8 L=0.15 W=1 nf=1 ad=0.29 as=0.29 pd=2.58 ps=2.58 nrd=0.29 nrs=0.29 sa=0 sb=0 sd=0 mult=1 m=1
XMPSR_i00_w1 sref_i00_w1 selb_69500 ref_i00_w1 vdd sky130_fd_pr__pfet_01v8 L=0.15 W=2 nf=1 ad=0.58 as=0.58 pd=4.58 ps=4.58 nrd=0.145 nrs=0.145 sa=0 sb=0 sd=0 mult=1 m=1
XMN1_i00_w1 sbl_i00_w1 sref_i00_w1 vn_i00_w1 0 sky130_fd_pr__nfet_01v8 L=0.15 W=1 nf=1 ad=0.29 as=0.29 pd=2.58 ps=2.58 nrd=0.29 nrs=0.29 sa=0 sb=0 sd=0 mult=1 m=1
XMN2_i00_w1 sref_i00_w1 sbl_i00_w1 vn_i00_w1 0 sky130_fd_pr__nfet_01v8 L=0.15 W=1 nf=1 ad=0.29 as=0.29 pd=2.58 ps=2.58 nrd=0.29 nrs=0.29 sa=0 sb=0 sd=0 mult=1 m=1
XMP1_i00_w1 sbl_i00_w1 sref_i00_w1 vp_i00_w1 vdd sky130_fd_pr__pfet_01v8 L=0.15 W=2 nf=1 ad=0.58 as=0.58 pd=4.58 ps=4.58 nrd=0.145 nrs=0.145 sa=0 sb=0 sd=0 mult=1 m=1
XMP2_i00_w1 sref_i00_w1 sbl_i00_w1 vp_i00_w1 vdd sky130_fd_pr__pfet_01v8 L=0.15 W=2 nf=1 ad=0.58 as=0.58 pd=4.58 ps=4.58 nrd=0.145 nrs=0.145 sa=0 sb=0 sd=0 mult=1 m=1
XMNF_i00_w1 vn_i00_w1 en 0 0 sky130_fd_pr__nfet_01v8 L=0.15 W=2 nf=1 ad=0.58 as=0.58 pd=4.58 ps=4.58 nrd=0.145 nrs=0.145 sa=0 sb=0 sd=0 mult=1 m=1
XMPH_i00_w1 vp_i00_w1 enb vdd vdd sky130_fd_pr__pfet_01v8 L=0.15 W=4 nf=1 ad=1.16 as=1.16 pd=8.58 ps=8.58 nrd=0.0725 nrs=0.0725 sa=0 sb=0 sd=0 mult=1 m=1
bd_i00_w1 d_i00_w1 0 v=v(sbl_i00_w1)-v(sref_i00_w1)
bdabs_i00_w1 dabs_i00_w1 0 v=abs(v(sbl_i00_w1)-v(sref_i00_w1))

* ---- instance 3: i00_w0 (baseline: TG nfet 1.0 / pfet 2.0, dummy 1x, lead 0.5 ns) ----
XMWR_i00_w0_0 sn_i00_w0_0 wl wbl_i00_w0 0 sky130_fd_pr__nfet_01v8 L=0.15 W=0.42 nf=1 ad=0.1218 as=0.1218 pd=1.42 ps=1.42 nrd=0.69047619047619 nrs=0.69047619047619 sa=0 sb=0 sd=0 mult=1 m=1
XMRD_i00_w0_0 rbl_i00_w0 sn_i00_w0_0 rwl_sel 0 sky130_fd_pr__nfet_01v8 L=0.15 W=0.42 nf=1 ad=0.1218 as=0.1218 pd=1.42 ps=1.42 nrd=0.69047619047619 nrs=0.69047619047619 sa=0 sb=0 sd=0 mult=1 m=1
csn_i00_w0_0 sn_i00_w0_0 0 {C_SN}
XMWR_i00_w0_1 sn_i00_w0_1 0 wbl_i00_w0 0 sky130_fd_pr__nfet_01v8 L=0.15 W=0.42 nf=1 ad=0.1218 as=0.1218 pd=1.42 ps=1.42 nrd=0.69047619047619 nrs=0.69047619047619 sa=0 sb=0 sd=0 mult=1 m=1
XMRD_i00_w0_1 rbl_i00_w0 sn_i00_w0_1 rwl_des 0 sky130_fd_pr__nfet_01v8 L=0.15 W=0.42 nf=1 ad=0.1218 as=0.1218 pd=1.42 ps=1.42 nrd=0.69047619047619 nrs=0.69047619047619 sa=0 sb=0 sd=0 mult=1 m=1
csn_i00_w0_1 sn_i00_w0_1 0 {C_SN}
XMWR_i00_w0_2 sn_i00_w0_2 0 wbl_i00_w0 0 sky130_fd_pr__nfet_01v8 L=0.15 W=0.42 nf=1 ad=0.1218 as=0.1218 pd=1.42 ps=1.42 nrd=0.69047619047619 nrs=0.69047619047619 sa=0 sb=0 sd=0 mult=1 m=1
XMRD_i00_w0_2 rbl_i00_w0 sn_i00_w0_2 rwl_des 0 sky130_fd_pr__nfet_01v8 L=0.15 W=0.42 nf=1 ad=0.1218 as=0.1218 pd=1.42 ps=1.42 nrd=0.69047619047619 nrs=0.69047619047619 sa=0 sb=0 sd=0 mult=1 m=1
csn_i00_w0_2 sn_i00_w0_2 0 {C_SN}
XMWR_i00_w0_3 sn_i00_w0_3 0 wbl_i00_w0 0 sky130_fd_pr__nfet_01v8 L=0.15 W=0.42 nf=1 ad=0.1218 as=0.1218 pd=1.42 ps=1.42 nrd=0.69047619047619 nrs=0.69047619047619 sa=0 sb=0 sd=0 mult=1 m=1
XMRD_i00_w0_3 rbl_i00_w0 sn_i00_w0_3 rwl_des 0 sky130_fd_pr__nfet_01v8 L=0.15 W=0.42 nf=1 ad=0.1218 as=0.1218 pd=1.42 ps=1.42 nrd=0.69047619047619 nrs=0.69047619047619 sa=0 sb=0 sd=0 mult=1 m=1
csn_i00_w0_3 sn_i00_w0_3 0 {C_SN}
crbl_i00_w0 rbl_i00_w0 0 {C_RBL}
cwbl_i00_w0 wbl_i00_w0 0 {C_WBL}
cref_i00_w0 ref_i00_w0 0 {C_RBL}   $ ASSUMPTION: ideal matched dummy load
spr_i00_w0 pref ref_i00_w0 pca 0 swpre   $ reference-side precharge: ideal switch (#114 convention)
XMPPRE_i00_w0 rbl_i00_w0 pcb_100 prea prea sky130_fd_pr__pfet_01v8 L=0.15 W=4 nf=1 ad=1.16 as=1.16 pd=8.58 ps=8.58 nrd=0.0725 nrs=0.0725 sa=0 sb=0 sd=0 mult=1 m=1
XMPU1_i00_w0 x_i00_w0 dinb0 vdd vdd sky130_fd_pr__pfet_01v8 L=0.15 W=1 nf=1 ad=0.29 as=0.29 pd=2.58 ps=2.58 nrd=0.29 nrs=0.29 sa=0 sb=0 sd=0 mult=1 m=1
XMPU2_i00_w0 wbl_i00_w0 wenb x_i00_w0 vdd sky130_fd_pr__pfet_01v8 L=0.15 W=1 nf=1 ad=0.29 as=0.29 pd=2.58 ps=2.58 nrd=0.29 nrs=0.29 sa=0 sb=0 sd=0 mult=1 m=1
XMND2_i00_w0 wbl_i00_w0 wen y_i00_w0 0 sky130_fd_pr__nfet_01v8 L=0.15 W=0.5 nf=1 ad=0.145 as=0.145 pd=1.58 ps=1.58 nrd=0.58 nrs=0.58 sa=0 sb=0 sd=0 mult=1 m=1
XMND1_i00_w0 y_i00_w0 dinb0 0 0 sky130_fd_pr__nfet_01v8 L=0.15 W=0.5 nf=1 ad=0.145 as=0.145 pd=1.58 ps=1.58 nrd=0.58 nrs=0.58 sa=0 sb=0 sd=0 mult=1 m=1
XMNI_i00_w0 wbl_i00_w0 wenb 0 0 sky130_fd_pr__nfet_01v8 L=0.15 W=0.42 nf=1 ad=0.1218 as=0.1218 pd=1.42 ps=1.42 nrd=0.69047619047619 nrs=0.69047619047619 sa=0 sb=0 sd=0 mult=1 m=1
XMNS_i00_w0 sbl_i00_w0 sel_69500 rbl_i00_w0 0 sky130_fd_pr__nfet_01v8 L=0.15 W=1 nf=1 ad=0.29 as=0.29 pd=2.58 ps=2.58 nrd=0.29 nrs=0.29 sa=0 sb=0 sd=0 mult=1 m=1
XMPS_i00_w0 sbl_i00_w0 selb_69500 rbl_i00_w0 vdd sky130_fd_pr__pfet_01v8 L=0.15 W=2 nf=1 ad=0.58 as=0.58 pd=4.58 ps=4.58 nrd=0.145 nrs=0.145 sa=0 sb=0 sd=0 mult=1 m=1
XMNSR_i00_w0 sref_i00_w0 sel_69500 ref_i00_w0 0 sky130_fd_pr__nfet_01v8 L=0.15 W=1 nf=1 ad=0.29 as=0.29 pd=2.58 ps=2.58 nrd=0.29 nrs=0.29 sa=0 sb=0 sd=0 mult=1 m=1
XMPSR_i00_w0 sref_i00_w0 selb_69500 ref_i00_w0 vdd sky130_fd_pr__pfet_01v8 L=0.15 W=2 nf=1 ad=0.58 as=0.58 pd=4.58 ps=4.58 nrd=0.145 nrs=0.145 sa=0 sb=0 sd=0 mult=1 m=1
XMN1_i00_w0 sbl_i00_w0 sref_i00_w0 vn_i00_w0 0 sky130_fd_pr__nfet_01v8 L=0.15 W=1 nf=1 ad=0.29 as=0.29 pd=2.58 ps=2.58 nrd=0.29 nrs=0.29 sa=0 sb=0 sd=0 mult=1 m=1
XMN2_i00_w0 sref_i00_w0 sbl_i00_w0 vn_i00_w0 0 sky130_fd_pr__nfet_01v8 L=0.15 W=1 nf=1 ad=0.29 as=0.29 pd=2.58 ps=2.58 nrd=0.29 nrs=0.29 sa=0 sb=0 sd=0 mult=1 m=1
XMP1_i00_w0 sbl_i00_w0 sref_i00_w0 vp_i00_w0 vdd sky130_fd_pr__pfet_01v8 L=0.15 W=2 nf=1 ad=0.58 as=0.58 pd=4.58 ps=4.58 nrd=0.145 nrs=0.145 sa=0 sb=0 sd=0 mult=1 m=1
XMP2_i00_w0 sref_i00_w0 sbl_i00_w0 vp_i00_w0 vdd sky130_fd_pr__pfet_01v8 L=0.15 W=2 nf=1 ad=0.58 as=0.58 pd=4.58 ps=4.58 nrd=0.145 nrs=0.145 sa=0 sb=0 sd=0 mult=1 m=1
XMNF_i00_w0 vn_i00_w0 en 0 0 sky130_fd_pr__nfet_01v8 L=0.15 W=2 nf=1 ad=0.58 as=0.58 pd=4.58 ps=4.58 nrd=0.145 nrs=0.145 sa=0 sb=0 sd=0 mult=1 m=1
XMPH_i00_w0 vp_i00_w0 enb vdd vdd sky130_fd_pr__pfet_01v8 L=0.15 W=4 nf=1 ad=1.16 as=1.16 pd=8.58 ps=8.58 nrd=0.0725 nrs=0.0725 sa=0 sb=0 sd=0 mult=1 m=1
bd_i00_w0 d_i00_w0 0 v=v(sbl_i00_w0)-v(sref_i00_w0)
bdabs_i00_w0 dabs_i00_w0 0 v=abs(v(sbl_i00_w0)-v(sref_i00_w0))

* ---- instance 4: i01_w1 (lead 0.1 ns) ----
XMWR_i01_w1_0 sn_i01_w1_0 wl wbl_i01_w1 0 sky130_fd_pr__nfet_01v8 L=0.15 W=0.42 nf=1 ad=0.1218 as=0.1218 pd=1.42 ps=1.42 nrd=0.69047619047619 nrs=0.69047619047619 sa=0 sb=0 sd=0 mult=1 m=1
XMRD_i01_w1_0 rbl_i01_w1 sn_i01_w1_0 rwl_sel 0 sky130_fd_pr__nfet_01v8 L=0.15 W=0.42 nf=1 ad=0.1218 as=0.1218 pd=1.42 ps=1.42 nrd=0.69047619047619 nrs=0.69047619047619 sa=0 sb=0 sd=0 mult=1 m=1
csn_i01_w1_0 sn_i01_w1_0 0 {C_SN}
XMWR_i01_w1_1 sn_i01_w1_1 0 wbl_i01_w1 0 sky130_fd_pr__nfet_01v8 L=0.15 W=0.42 nf=1 ad=0.1218 as=0.1218 pd=1.42 ps=1.42 nrd=0.69047619047619 nrs=0.69047619047619 sa=0 sb=0 sd=0 mult=1 m=1
XMRD_i01_w1_1 rbl_i01_w1 sn_i01_w1_1 rwl_des 0 sky130_fd_pr__nfet_01v8 L=0.15 W=0.42 nf=1 ad=0.1218 as=0.1218 pd=1.42 ps=1.42 nrd=0.69047619047619 nrs=0.69047619047619 sa=0 sb=0 sd=0 mult=1 m=1
csn_i01_w1_1 sn_i01_w1_1 0 {C_SN}
XMWR_i01_w1_2 sn_i01_w1_2 0 wbl_i01_w1 0 sky130_fd_pr__nfet_01v8 L=0.15 W=0.42 nf=1 ad=0.1218 as=0.1218 pd=1.42 ps=1.42 nrd=0.69047619047619 nrs=0.69047619047619 sa=0 sb=0 sd=0 mult=1 m=1
XMRD_i01_w1_2 rbl_i01_w1 sn_i01_w1_2 rwl_des 0 sky130_fd_pr__nfet_01v8 L=0.15 W=0.42 nf=1 ad=0.1218 as=0.1218 pd=1.42 ps=1.42 nrd=0.69047619047619 nrs=0.69047619047619 sa=0 sb=0 sd=0 mult=1 m=1
csn_i01_w1_2 sn_i01_w1_2 0 {C_SN}
XMWR_i01_w1_3 sn_i01_w1_3 0 wbl_i01_w1 0 sky130_fd_pr__nfet_01v8 L=0.15 W=0.42 nf=1 ad=0.1218 as=0.1218 pd=1.42 ps=1.42 nrd=0.69047619047619 nrs=0.69047619047619 sa=0 sb=0 sd=0 mult=1 m=1
XMRD_i01_w1_3 rbl_i01_w1 sn_i01_w1_3 rwl_des 0 sky130_fd_pr__nfet_01v8 L=0.15 W=0.42 nf=1 ad=0.1218 as=0.1218 pd=1.42 ps=1.42 nrd=0.69047619047619 nrs=0.69047619047619 sa=0 sb=0 sd=0 mult=1 m=1
csn_i01_w1_3 sn_i01_w1_3 0 {C_SN}
crbl_i01_w1 rbl_i01_w1 0 {C_RBL}
cwbl_i01_w1 wbl_i01_w1 0 {C_WBL}
cref_i01_w1 ref_i01_w1 0 {C_RBL}   $ ASSUMPTION: ideal matched dummy load
spr_i01_w1 pref ref_i01_w1 pca 0 swpre   $ reference-side precharge: ideal switch (#114 convention)
XMPPRE_i01_w1 rbl_i01_w1 pcb_100 prea prea sky130_fd_pr__pfet_01v8 L=0.15 W=4 nf=1 ad=1.16 as=1.16 pd=8.58 ps=8.58 nrd=0.0725 nrs=0.0725 sa=0 sb=0 sd=0 mult=1 m=1
XMPU1_i01_w1 x_i01_w1 dinb1 vdd vdd sky130_fd_pr__pfet_01v8 L=0.15 W=1 nf=1 ad=0.29 as=0.29 pd=2.58 ps=2.58 nrd=0.29 nrs=0.29 sa=0 sb=0 sd=0 mult=1 m=1
XMPU2_i01_w1 wbl_i01_w1 wenb x_i01_w1 vdd sky130_fd_pr__pfet_01v8 L=0.15 W=1 nf=1 ad=0.29 as=0.29 pd=2.58 ps=2.58 nrd=0.29 nrs=0.29 sa=0 sb=0 sd=0 mult=1 m=1
XMND2_i01_w1 wbl_i01_w1 wen y_i01_w1 0 sky130_fd_pr__nfet_01v8 L=0.15 W=0.5 nf=1 ad=0.145 as=0.145 pd=1.58 ps=1.58 nrd=0.58 nrs=0.58 sa=0 sb=0 sd=0 mult=1 m=1
XMND1_i01_w1 y_i01_w1 dinb1 0 0 sky130_fd_pr__nfet_01v8 L=0.15 W=0.5 nf=1 ad=0.145 as=0.145 pd=1.58 ps=1.58 nrd=0.58 nrs=0.58 sa=0 sb=0 sd=0 mult=1 m=1
XMNI_i01_w1 wbl_i01_w1 wenb 0 0 sky130_fd_pr__nfet_01v8 L=0.15 W=0.42 nf=1 ad=0.1218 as=0.1218 pd=1.42 ps=1.42 nrd=0.69047619047619 nrs=0.69047619047619 sa=0 sb=0 sd=0 mult=1 m=1
XMNS_i01_w1 sbl_i01_w1 sel_69900 rbl_i01_w1 0 sky130_fd_pr__nfet_01v8 L=0.15 W=1 nf=1 ad=0.29 as=0.29 pd=2.58 ps=2.58 nrd=0.29 nrs=0.29 sa=0 sb=0 sd=0 mult=1 m=1
XMPS_i01_w1 sbl_i01_w1 selb_69900 rbl_i01_w1 vdd sky130_fd_pr__pfet_01v8 L=0.15 W=2 nf=1 ad=0.58 as=0.58 pd=4.58 ps=4.58 nrd=0.145 nrs=0.145 sa=0 sb=0 sd=0 mult=1 m=1
XMNSR_i01_w1 sref_i01_w1 sel_69900 ref_i01_w1 0 sky130_fd_pr__nfet_01v8 L=0.15 W=1 nf=1 ad=0.29 as=0.29 pd=2.58 ps=2.58 nrd=0.29 nrs=0.29 sa=0 sb=0 sd=0 mult=1 m=1
XMPSR_i01_w1 sref_i01_w1 selb_69900 ref_i01_w1 vdd sky130_fd_pr__pfet_01v8 L=0.15 W=2 nf=1 ad=0.58 as=0.58 pd=4.58 ps=4.58 nrd=0.145 nrs=0.145 sa=0 sb=0 sd=0 mult=1 m=1
XMN1_i01_w1 sbl_i01_w1 sref_i01_w1 vn_i01_w1 0 sky130_fd_pr__nfet_01v8 L=0.15 W=1 nf=1 ad=0.29 as=0.29 pd=2.58 ps=2.58 nrd=0.29 nrs=0.29 sa=0 sb=0 sd=0 mult=1 m=1
XMN2_i01_w1 sref_i01_w1 sbl_i01_w1 vn_i01_w1 0 sky130_fd_pr__nfet_01v8 L=0.15 W=1 nf=1 ad=0.29 as=0.29 pd=2.58 ps=2.58 nrd=0.29 nrs=0.29 sa=0 sb=0 sd=0 mult=1 m=1
XMP1_i01_w1 sbl_i01_w1 sref_i01_w1 vp_i01_w1 vdd sky130_fd_pr__pfet_01v8 L=0.15 W=2 nf=1 ad=0.58 as=0.58 pd=4.58 ps=4.58 nrd=0.145 nrs=0.145 sa=0 sb=0 sd=0 mult=1 m=1
XMP2_i01_w1 sref_i01_w1 sbl_i01_w1 vp_i01_w1 vdd sky130_fd_pr__pfet_01v8 L=0.15 W=2 nf=1 ad=0.58 as=0.58 pd=4.58 ps=4.58 nrd=0.145 nrs=0.145 sa=0 sb=0 sd=0 mult=1 m=1
XMNF_i01_w1 vn_i01_w1 en 0 0 sky130_fd_pr__nfet_01v8 L=0.15 W=2 nf=1 ad=0.58 as=0.58 pd=4.58 ps=4.58 nrd=0.145 nrs=0.145 sa=0 sb=0 sd=0 mult=1 m=1
XMPH_i01_w1 vp_i01_w1 enb vdd vdd sky130_fd_pr__pfet_01v8 L=0.15 W=4 nf=1 ad=1.16 as=1.16 pd=8.58 ps=8.58 nrd=0.0725 nrs=0.0725 sa=0 sb=0 sd=0 mult=1 m=1
bd_i01_w1 d_i01_w1 0 v=v(sbl_i01_w1)-v(sref_i01_w1)
bdabs_i01_w1 dabs_i01_w1 0 v=abs(v(sbl_i01_w1)-v(sref_i01_w1))

* ---- instance 5: i01_w0 (lead 0.1 ns) ----
XMWR_i01_w0_0 sn_i01_w0_0 wl wbl_i01_w0 0 sky130_fd_pr__nfet_01v8 L=0.15 W=0.42 nf=1 ad=0.1218 as=0.1218 pd=1.42 ps=1.42 nrd=0.69047619047619 nrs=0.69047619047619 sa=0 sb=0 sd=0 mult=1 m=1
XMRD_i01_w0_0 rbl_i01_w0 sn_i01_w0_0 rwl_sel 0 sky130_fd_pr__nfet_01v8 L=0.15 W=0.42 nf=1 ad=0.1218 as=0.1218 pd=1.42 ps=1.42 nrd=0.69047619047619 nrs=0.69047619047619 sa=0 sb=0 sd=0 mult=1 m=1
csn_i01_w0_0 sn_i01_w0_0 0 {C_SN}
XMWR_i01_w0_1 sn_i01_w0_1 0 wbl_i01_w0 0 sky130_fd_pr__nfet_01v8 L=0.15 W=0.42 nf=1 ad=0.1218 as=0.1218 pd=1.42 ps=1.42 nrd=0.69047619047619 nrs=0.69047619047619 sa=0 sb=0 sd=0 mult=1 m=1
XMRD_i01_w0_1 rbl_i01_w0 sn_i01_w0_1 rwl_des 0 sky130_fd_pr__nfet_01v8 L=0.15 W=0.42 nf=1 ad=0.1218 as=0.1218 pd=1.42 ps=1.42 nrd=0.69047619047619 nrs=0.69047619047619 sa=0 sb=0 sd=0 mult=1 m=1
csn_i01_w0_1 sn_i01_w0_1 0 {C_SN}
XMWR_i01_w0_2 sn_i01_w0_2 0 wbl_i01_w0 0 sky130_fd_pr__nfet_01v8 L=0.15 W=0.42 nf=1 ad=0.1218 as=0.1218 pd=1.42 ps=1.42 nrd=0.69047619047619 nrs=0.69047619047619 sa=0 sb=0 sd=0 mult=1 m=1
XMRD_i01_w0_2 rbl_i01_w0 sn_i01_w0_2 rwl_des 0 sky130_fd_pr__nfet_01v8 L=0.15 W=0.42 nf=1 ad=0.1218 as=0.1218 pd=1.42 ps=1.42 nrd=0.69047619047619 nrs=0.69047619047619 sa=0 sb=0 sd=0 mult=1 m=1
csn_i01_w0_2 sn_i01_w0_2 0 {C_SN}
XMWR_i01_w0_3 sn_i01_w0_3 0 wbl_i01_w0 0 sky130_fd_pr__nfet_01v8 L=0.15 W=0.42 nf=1 ad=0.1218 as=0.1218 pd=1.42 ps=1.42 nrd=0.69047619047619 nrs=0.69047619047619 sa=0 sb=0 sd=0 mult=1 m=1
XMRD_i01_w0_3 rbl_i01_w0 sn_i01_w0_3 rwl_des 0 sky130_fd_pr__nfet_01v8 L=0.15 W=0.42 nf=1 ad=0.1218 as=0.1218 pd=1.42 ps=1.42 nrd=0.69047619047619 nrs=0.69047619047619 sa=0 sb=0 sd=0 mult=1 m=1
csn_i01_w0_3 sn_i01_w0_3 0 {C_SN}
crbl_i01_w0 rbl_i01_w0 0 {C_RBL}
cwbl_i01_w0 wbl_i01_w0 0 {C_WBL}
cref_i01_w0 ref_i01_w0 0 {C_RBL}   $ ASSUMPTION: ideal matched dummy load
spr_i01_w0 pref ref_i01_w0 pca 0 swpre   $ reference-side precharge: ideal switch (#114 convention)
XMPPRE_i01_w0 rbl_i01_w0 pcb_100 prea prea sky130_fd_pr__pfet_01v8 L=0.15 W=4 nf=1 ad=1.16 as=1.16 pd=8.58 ps=8.58 nrd=0.0725 nrs=0.0725 sa=0 sb=0 sd=0 mult=1 m=1
XMPU1_i01_w0 x_i01_w0 dinb0 vdd vdd sky130_fd_pr__pfet_01v8 L=0.15 W=1 nf=1 ad=0.29 as=0.29 pd=2.58 ps=2.58 nrd=0.29 nrs=0.29 sa=0 sb=0 sd=0 mult=1 m=1
XMPU2_i01_w0 wbl_i01_w0 wenb x_i01_w0 vdd sky130_fd_pr__pfet_01v8 L=0.15 W=1 nf=1 ad=0.29 as=0.29 pd=2.58 ps=2.58 nrd=0.29 nrs=0.29 sa=0 sb=0 sd=0 mult=1 m=1
XMND2_i01_w0 wbl_i01_w0 wen y_i01_w0 0 sky130_fd_pr__nfet_01v8 L=0.15 W=0.5 nf=1 ad=0.145 as=0.145 pd=1.58 ps=1.58 nrd=0.58 nrs=0.58 sa=0 sb=0 sd=0 mult=1 m=1
XMND1_i01_w0 y_i01_w0 dinb0 0 0 sky130_fd_pr__nfet_01v8 L=0.15 W=0.5 nf=1 ad=0.145 as=0.145 pd=1.58 ps=1.58 nrd=0.58 nrs=0.58 sa=0 sb=0 sd=0 mult=1 m=1
XMNI_i01_w0 wbl_i01_w0 wenb 0 0 sky130_fd_pr__nfet_01v8 L=0.15 W=0.42 nf=1 ad=0.1218 as=0.1218 pd=1.42 ps=1.42 nrd=0.69047619047619 nrs=0.69047619047619 sa=0 sb=0 sd=0 mult=1 m=1
XMNS_i01_w0 sbl_i01_w0 sel_69900 rbl_i01_w0 0 sky130_fd_pr__nfet_01v8 L=0.15 W=1 nf=1 ad=0.29 as=0.29 pd=2.58 ps=2.58 nrd=0.29 nrs=0.29 sa=0 sb=0 sd=0 mult=1 m=1
XMPS_i01_w0 sbl_i01_w0 selb_69900 rbl_i01_w0 vdd sky130_fd_pr__pfet_01v8 L=0.15 W=2 nf=1 ad=0.58 as=0.58 pd=4.58 ps=4.58 nrd=0.145 nrs=0.145 sa=0 sb=0 sd=0 mult=1 m=1
XMNSR_i01_w0 sref_i01_w0 sel_69900 ref_i01_w0 0 sky130_fd_pr__nfet_01v8 L=0.15 W=1 nf=1 ad=0.29 as=0.29 pd=2.58 ps=2.58 nrd=0.29 nrs=0.29 sa=0 sb=0 sd=0 mult=1 m=1
XMPSR_i01_w0 sref_i01_w0 selb_69900 ref_i01_w0 vdd sky130_fd_pr__pfet_01v8 L=0.15 W=2 nf=1 ad=0.58 as=0.58 pd=4.58 ps=4.58 nrd=0.145 nrs=0.145 sa=0 sb=0 sd=0 mult=1 m=1
XMN1_i01_w0 sbl_i01_w0 sref_i01_w0 vn_i01_w0 0 sky130_fd_pr__nfet_01v8 L=0.15 W=1 nf=1 ad=0.29 as=0.29 pd=2.58 ps=2.58 nrd=0.29 nrs=0.29 sa=0 sb=0 sd=0 mult=1 m=1
XMN2_i01_w0 sref_i01_w0 sbl_i01_w0 vn_i01_w0 0 sky130_fd_pr__nfet_01v8 L=0.15 W=1 nf=1 ad=0.29 as=0.29 pd=2.58 ps=2.58 nrd=0.29 nrs=0.29 sa=0 sb=0 sd=0 mult=1 m=1
XMP1_i01_w0 sbl_i01_w0 sref_i01_w0 vp_i01_w0 vdd sky130_fd_pr__pfet_01v8 L=0.15 W=2 nf=1 ad=0.58 as=0.58 pd=4.58 ps=4.58 nrd=0.145 nrs=0.145 sa=0 sb=0 sd=0 mult=1 m=1
XMP2_i01_w0 sref_i01_w0 sbl_i01_w0 vp_i01_w0 vdd sky130_fd_pr__pfet_01v8 L=0.15 W=2 nf=1 ad=0.58 as=0.58 pd=4.58 ps=4.58 nrd=0.145 nrs=0.145 sa=0 sb=0 sd=0 mult=1 m=1
XMNF_i01_w0 vn_i01_w0 en 0 0 sky130_fd_pr__nfet_01v8 L=0.15 W=2 nf=1 ad=0.58 as=0.58 pd=4.58 ps=4.58 nrd=0.145 nrs=0.145 sa=0 sb=0 sd=0 mult=1 m=1
XMPH_i01_w0 vp_i01_w0 enb vdd vdd sky130_fd_pr__pfet_01v8 L=0.15 W=4 nf=1 ad=1.16 as=1.16 pd=8.58 ps=8.58 nrd=0.0725 nrs=0.0725 sa=0 sb=0 sd=0 mult=1 m=1
bd_i01_w0 d_i01_w0 0 v=v(sbl_i01_w0)-v(sref_i01_w0)
bdabs_i01_w0 dabs_i01_w0 0 v=abs(v(sbl_i01_w0)-v(sref_i01_w0))

* ---- instance 6: i02_w1 (lead 1.0 ns) ----
XMWR_i02_w1_0 sn_i02_w1_0 wl wbl_i02_w1 0 sky130_fd_pr__nfet_01v8 L=0.15 W=0.42 nf=1 ad=0.1218 as=0.1218 pd=1.42 ps=1.42 nrd=0.69047619047619 nrs=0.69047619047619 sa=0 sb=0 sd=0 mult=1 m=1
XMRD_i02_w1_0 rbl_i02_w1 sn_i02_w1_0 rwl_sel 0 sky130_fd_pr__nfet_01v8 L=0.15 W=0.42 nf=1 ad=0.1218 as=0.1218 pd=1.42 ps=1.42 nrd=0.69047619047619 nrs=0.69047619047619 sa=0 sb=0 sd=0 mult=1 m=1
csn_i02_w1_0 sn_i02_w1_0 0 {C_SN}
XMWR_i02_w1_1 sn_i02_w1_1 0 wbl_i02_w1 0 sky130_fd_pr__nfet_01v8 L=0.15 W=0.42 nf=1 ad=0.1218 as=0.1218 pd=1.42 ps=1.42 nrd=0.69047619047619 nrs=0.69047619047619 sa=0 sb=0 sd=0 mult=1 m=1
XMRD_i02_w1_1 rbl_i02_w1 sn_i02_w1_1 rwl_des 0 sky130_fd_pr__nfet_01v8 L=0.15 W=0.42 nf=1 ad=0.1218 as=0.1218 pd=1.42 ps=1.42 nrd=0.69047619047619 nrs=0.69047619047619 sa=0 sb=0 sd=0 mult=1 m=1
csn_i02_w1_1 sn_i02_w1_1 0 {C_SN}
XMWR_i02_w1_2 sn_i02_w1_2 0 wbl_i02_w1 0 sky130_fd_pr__nfet_01v8 L=0.15 W=0.42 nf=1 ad=0.1218 as=0.1218 pd=1.42 ps=1.42 nrd=0.69047619047619 nrs=0.69047619047619 sa=0 sb=0 sd=0 mult=1 m=1
XMRD_i02_w1_2 rbl_i02_w1 sn_i02_w1_2 rwl_des 0 sky130_fd_pr__nfet_01v8 L=0.15 W=0.42 nf=1 ad=0.1218 as=0.1218 pd=1.42 ps=1.42 nrd=0.69047619047619 nrs=0.69047619047619 sa=0 sb=0 sd=0 mult=1 m=1
csn_i02_w1_2 sn_i02_w1_2 0 {C_SN}
XMWR_i02_w1_3 sn_i02_w1_3 0 wbl_i02_w1 0 sky130_fd_pr__nfet_01v8 L=0.15 W=0.42 nf=1 ad=0.1218 as=0.1218 pd=1.42 ps=1.42 nrd=0.69047619047619 nrs=0.69047619047619 sa=0 sb=0 sd=0 mult=1 m=1
XMRD_i02_w1_3 rbl_i02_w1 sn_i02_w1_3 rwl_des 0 sky130_fd_pr__nfet_01v8 L=0.15 W=0.42 nf=1 ad=0.1218 as=0.1218 pd=1.42 ps=1.42 nrd=0.69047619047619 nrs=0.69047619047619 sa=0 sb=0 sd=0 mult=1 m=1
csn_i02_w1_3 sn_i02_w1_3 0 {C_SN}
crbl_i02_w1 rbl_i02_w1 0 {C_RBL}
cwbl_i02_w1 wbl_i02_w1 0 {C_WBL}
cref_i02_w1 ref_i02_w1 0 {C_RBL}   $ ASSUMPTION: ideal matched dummy load
spr_i02_w1 pref ref_i02_w1 pca 0 swpre   $ reference-side precharge: ideal switch (#114 convention)
XMPPRE_i02_w1 rbl_i02_w1 pcb_100 prea prea sky130_fd_pr__pfet_01v8 L=0.15 W=4 nf=1 ad=1.16 as=1.16 pd=8.58 ps=8.58 nrd=0.0725 nrs=0.0725 sa=0 sb=0 sd=0 mult=1 m=1
XMPU1_i02_w1 x_i02_w1 dinb1 vdd vdd sky130_fd_pr__pfet_01v8 L=0.15 W=1 nf=1 ad=0.29 as=0.29 pd=2.58 ps=2.58 nrd=0.29 nrs=0.29 sa=0 sb=0 sd=0 mult=1 m=1
XMPU2_i02_w1 wbl_i02_w1 wenb x_i02_w1 vdd sky130_fd_pr__pfet_01v8 L=0.15 W=1 nf=1 ad=0.29 as=0.29 pd=2.58 ps=2.58 nrd=0.29 nrs=0.29 sa=0 sb=0 sd=0 mult=1 m=1
XMND2_i02_w1 wbl_i02_w1 wen y_i02_w1 0 sky130_fd_pr__nfet_01v8 L=0.15 W=0.5 nf=1 ad=0.145 as=0.145 pd=1.58 ps=1.58 nrd=0.58 nrs=0.58 sa=0 sb=0 sd=0 mult=1 m=1
XMND1_i02_w1 y_i02_w1 dinb1 0 0 sky130_fd_pr__nfet_01v8 L=0.15 W=0.5 nf=1 ad=0.145 as=0.145 pd=1.58 ps=1.58 nrd=0.58 nrs=0.58 sa=0 sb=0 sd=0 mult=1 m=1
XMNI_i02_w1 wbl_i02_w1 wenb 0 0 sky130_fd_pr__nfet_01v8 L=0.15 W=0.42 nf=1 ad=0.1218 as=0.1218 pd=1.42 ps=1.42 nrd=0.69047619047619 nrs=0.69047619047619 sa=0 sb=0 sd=0 mult=1 m=1
XMNS_i02_w1 sbl_i02_w1 sel_69000 rbl_i02_w1 0 sky130_fd_pr__nfet_01v8 L=0.15 W=1 nf=1 ad=0.29 as=0.29 pd=2.58 ps=2.58 nrd=0.29 nrs=0.29 sa=0 sb=0 sd=0 mult=1 m=1
XMPS_i02_w1 sbl_i02_w1 selb_69000 rbl_i02_w1 vdd sky130_fd_pr__pfet_01v8 L=0.15 W=2 nf=1 ad=0.58 as=0.58 pd=4.58 ps=4.58 nrd=0.145 nrs=0.145 sa=0 sb=0 sd=0 mult=1 m=1
XMNSR_i02_w1 sref_i02_w1 sel_69000 ref_i02_w1 0 sky130_fd_pr__nfet_01v8 L=0.15 W=1 nf=1 ad=0.29 as=0.29 pd=2.58 ps=2.58 nrd=0.29 nrs=0.29 sa=0 sb=0 sd=0 mult=1 m=1
XMPSR_i02_w1 sref_i02_w1 selb_69000 ref_i02_w1 vdd sky130_fd_pr__pfet_01v8 L=0.15 W=2 nf=1 ad=0.58 as=0.58 pd=4.58 ps=4.58 nrd=0.145 nrs=0.145 sa=0 sb=0 sd=0 mult=1 m=1
XMN1_i02_w1 sbl_i02_w1 sref_i02_w1 vn_i02_w1 0 sky130_fd_pr__nfet_01v8 L=0.15 W=1 nf=1 ad=0.29 as=0.29 pd=2.58 ps=2.58 nrd=0.29 nrs=0.29 sa=0 sb=0 sd=0 mult=1 m=1
XMN2_i02_w1 sref_i02_w1 sbl_i02_w1 vn_i02_w1 0 sky130_fd_pr__nfet_01v8 L=0.15 W=1 nf=1 ad=0.29 as=0.29 pd=2.58 ps=2.58 nrd=0.29 nrs=0.29 sa=0 sb=0 sd=0 mult=1 m=1
XMP1_i02_w1 sbl_i02_w1 sref_i02_w1 vp_i02_w1 vdd sky130_fd_pr__pfet_01v8 L=0.15 W=2 nf=1 ad=0.58 as=0.58 pd=4.58 ps=4.58 nrd=0.145 nrs=0.145 sa=0 sb=0 sd=0 mult=1 m=1
XMP2_i02_w1 sref_i02_w1 sbl_i02_w1 vp_i02_w1 vdd sky130_fd_pr__pfet_01v8 L=0.15 W=2 nf=1 ad=0.58 as=0.58 pd=4.58 ps=4.58 nrd=0.145 nrs=0.145 sa=0 sb=0 sd=0 mult=1 m=1
XMNF_i02_w1 vn_i02_w1 en 0 0 sky130_fd_pr__nfet_01v8 L=0.15 W=2 nf=1 ad=0.58 as=0.58 pd=4.58 ps=4.58 nrd=0.145 nrs=0.145 sa=0 sb=0 sd=0 mult=1 m=1
XMPH_i02_w1 vp_i02_w1 enb vdd vdd sky130_fd_pr__pfet_01v8 L=0.15 W=4 nf=1 ad=1.16 as=1.16 pd=8.58 ps=8.58 nrd=0.0725 nrs=0.0725 sa=0 sb=0 sd=0 mult=1 m=1
bd_i02_w1 d_i02_w1 0 v=v(sbl_i02_w1)-v(sref_i02_w1)
bdabs_i02_w1 dabs_i02_w1 0 v=abs(v(sbl_i02_w1)-v(sref_i02_w1))

* ---- instance 7: i02_w0 (lead 1.0 ns) ----
XMWR_i02_w0_0 sn_i02_w0_0 wl wbl_i02_w0 0 sky130_fd_pr__nfet_01v8 L=0.15 W=0.42 nf=1 ad=0.1218 as=0.1218 pd=1.42 ps=1.42 nrd=0.69047619047619 nrs=0.69047619047619 sa=0 sb=0 sd=0 mult=1 m=1
XMRD_i02_w0_0 rbl_i02_w0 sn_i02_w0_0 rwl_sel 0 sky130_fd_pr__nfet_01v8 L=0.15 W=0.42 nf=1 ad=0.1218 as=0.1218 pd=1.42 ps=1.42 nrd=0.69047619047619 nrs=0.69047619047619 sa=0 sb=0 sd=0 mult=1 m=1
csn_i02_w0_0 sn_i02_w0_0 0 {C_SN}
XMWR_i02_w0_1 sn_i02_w0_1 0 wbl_i02_w0 0 sky130_fd_pr__nfet_01v8 L=0.15 W=0.42 nf=1 ad=0.1218 as=0.1218 pd=1.42 ps=1.42 nrd=0.69047619047619 nrs=0.69047619047619 sa=0 sb=0 sd=0 mult=1 m=1
XMRD_i02_w0_1 rbl_i02_w0 sn_i02_w0_1 rwl_des 0 sky130_fd_pr__nfet_01v8 L=0.15 W=0.42 nf=1 ad=0.1218 as=0.1218 pd=1.42 ps=1.42 nrd=0.69047619047619 nrs=0.69047619047619 sa=0 sb=0 sd=0 mult=1 m=1
csn_i02_w0_1 sn_i02_w0_1 0 {C_SN}
XMWR_i02_w0_2 sn_i02_w0_2 0 wbl_i02_w0 0 sky130_fd_pr__nfet_01v8 L=0.15 W=0.42 nf=1 ad=0.1218 as=0.1218 pd=1.42 ps=1.42 nrd=0.69047619047619 nrs=0.69047619047619 sa=0 sb=0 sd=0 mult=1 m=1
XMRD_i02_w0_2 rbl_i02_w0 sn_i02_w0_2 rwl_des 0 sky130_fd_pr__nfet_01v8 L=0.15 W=0.42 nf=1 ad=0.1218 as=0.1218 pd=1.42 ps=1.42 nrd=0.69047619047619 nrs=0.69047619047619 sa=0 sb=0 sd=0 mult=1 m=1
csn_i02_w0_2 sn_i02_w0_2 0 {C_SN}
XMWR_i02_w0_3 sn_i02_w0_3 0 wbl_i02_w0 0 sky130_fd_pr__nfet_01v8 L=0.15 W=0.42 nf=1 ad=0.1218 as=0.1218 pd=1.42 ps=1.42 nrd=0.69047619047619 nrs=0.69047619047619 sa=0 sb=0 sd=0 mult=1 m=1
XMRD_i02_w0_3 rbl_i02_w0 sn_i02_w0_3 rwl_des 0 sky130_fd_pr__nfet_01v8 L=0.15 W=0.42 nf=1 ad=0.1218 as=0.1218 pd=1.42 ps=1.42 nrd=0.69047619047619 nrs=0.69047619047619 sa=0 sb=0 sd=0 mult=1 m=1
csn_i02_w0_3 sn_i02_w0_3 0 {C_SN}
crbl_i02_w0 rbl_i02_w0 0 {C_RBL}
cwbl_i02_w0 wbl_i02_w0 0 {C_WBL}
cref_i02_w0 ref_i02_w0 0 {C_RBL}   $ ASSUMPTION: ideal matched dummy load
spr_i02_w0 pref ref_i02_w0 pca 0 swpre   $ reference-side precharge: ideal switch (#114 convention)
XMPPRE_i02_w0 rbl_i02_w0 pcb_100 prea prea sky130_fd_pr__pfet_01v8 L=0.15 W=4 nf=1 ad=1.16 as=1.16 pd=8.58 ps=8.58 nrd=0.0725 nrs=0.0725 sa=0 sb=0 sd=0 mult=1 m=1
XMPU1_i02_w0 x_i02_w0 dinb0 vdd vdd sky130_fd_pr__pfet_01v8 L=0.15 W=1 nf=1 ad=0.29 as=0.29 pd=2.58 ps=2.58 nrd=0.29 nrs=0.29 sa=0 sb=0 sd=0 mult=1 m=1
XMPU2_i02_w0 wbl_i02_w0 wenb x_i02_w0 vdd sky130_fd_pr__pfet_01v8 L=0.15 W=1 nf=1 ad=0.29 as=0.29 pd=2.58 ps=2.58 nrd=0.29 nrs=0.29 sa=0 sb=0 sd=0 mult=1 m=1
XMND2_i02_w0 wbl_i02_w0 wen y_i02_w0 0 sky130_fd_pr__nfet_01v8 L=0.15 W=0.5 nf=1 ad=0.145 as=0.145 pd=1.58 ps=1.58 nrd=0.58 nrs=0.58 sa=0 sb=0 sd=0 mult=1 m=1
XMND1_i02_w0 y_i02_w0 dinb0 0 0 sky130_fd_pr__nfet_01v8 L=0.15 W=0.5 nf=1 ad=0.145 as=0.145 pd=1.58 ps=1.58 nrd=0.58 nrs=0.58 sa=0 sb=0 sd=0 mult=1 m=1
XMNI_i02_w0 wbl_i02_w0 wenb 0 0 sky130_fd_pr__nfet_01v8 L=0.15 W=0.42 nf=1 ad=0.1218 as=0.1218 pd=1.42 ps=1.42 nrd=0.69047619047619 nrs=0.69047619047619 sa=0 sb=0 sd=0 mult=1 m=1
XMNS_i02_w0 sbl_i02_w0 sel_69000 rbl_i02_w0 0 sky130_fd_pr__nfet_01v8 L=0.15 W=1 nf=1 ad=0.29 as=0.29 pd=2.58 ps=2.58 nrd=0.29 nrs=0.29 sa=0 sb=0 sd=0 mult=1 m=1
XMPS_i02_w0 sbl_i02_w0 selb_69000 rbl_i02_w0 vdd sky130_fd_pr__pfet_01v8 L=0.15 W=2 nf=1 ad=0.58 as=0.58 pd=4.58 ps=4.58 nrd=0.145 nrs=0.145 sa=0 sb=0 sd=0 mult=1 m=1
XMNSR_i02_w0 sref_i02_w0 sel_69000 ref_i02_w0 0 sky130_fd_pr__nfet_01v8 L=0.15 W=1 nf=1 ad=0.29 as=0.29 pd=2.58 ps=2.58 nrd=0.29 nrs=0.29 sa=0 sb=0 sd=0 mult=1 m=1
XMPSR_i02_w0 sref_i02_w0 selb_69000 ref_i02_w0 vdd sky130_fd_pr__pfet_01v8 L=0.15 W=2 nf=1 ad=0.58 as=0.58 pd=4.58 ps=4.58 nrd=0.145 nrs=0.145 sa=0 sb=0 sd=0 mult=1 m=1
XMN1_i02_w0 sbl_i02_w0 sref_i02_w0 vn_i02_w0 0 sky130_fd_pr__nfet_01v8 L=0.15 W=1 nf=1 ad=0.29 as=0.29 pd=2.58 ps=2.58 nrd=0.29 nrs=0.29 sa=0 sb=0 sd=0 mult=1 m=1
XMN2_i02_w0 sref_i02_w0 sbl_i02_w0 vn_i02_w0 0 sky130_fd_pr__nfet_01v8 L=0.15 W=1 nf=1 ad=0.29 as=0.29 pd=2.58 ps=2.58 nrd=0.29 nrs=0.29 sa=0 sb=0 sd=0 mult=1 m=1
XMP1_i02_w0 sbl_i02_w0 sref_i02_w0 vp_i02_w0 vdd sky130_fd_pr__pfet_01v8 L=0.15 W=2 nf=1 ad=0.58 as=0.58 pd=4.58 ps=4.58 nrd=0.145 nrs=0.145 sa=0 sb=0 sd=0 mult=1 m=1
XMP2_i02_w0 sref_i02_w0 sbl_i02_w0 vp_i02_w0 vdd sky130_fd_pr__pfet_01v8 L=0.15 W=2 nf=1 ad=0.58 as=0.58 pd=4.58 ps=4.58 nrd=0.145 nrs=0.145 sa=0 sb=0 sd=0 mult=1 m=1
XMNF_i02_w0 vn_i02_w0 en 0 0 sky130_fd_pr__nfet_01v8 L=0.15 W=2 nf=1 ad=0.58 as=0.58 pd=4.58 ps=4.58 nrd=0.145 nrs=0.145 sa=0 sb=0 sd=0 mult=1 m=1
XMPH_i02_w0 vp_i02_w0 enb vdd vdd sky130_fd_pr__pfet_01v8 L=0.15 W=4 nf=1 ad=1.16 as=1.16 pd=8.58 ps=8.58 nrd=0.0725 nrs=0.0725 sa=0 sb=0 sd=0 mult=1 m=1
bd_i02_w0 d_i02_w0 0 v=v(sbl_i02_w0)-v(sref_i02_w0)
bdabs_i02_w0 dabs_i02_w0 0 v=abs(v(sbl_i02_w0)-v(sref_i02_w0))

* ---- instance 8: i03_w1 (lead 2.0 ns) ----
XMWR_i03_w1_0 sn_i03_w1_0 wl wbl_i03_w1 0 sky130_fd_pr__nfet_01v8 L=0.15 W=0.42 nf=1 ad=0.1218 as=0.1218 pd=1.42 ps=1.42 nrd=0.69047619047619 nrs=0.69047619047619 sa=0 sb=0 sd=0 mult=1 m=1
XMRD_i03_w1_0 rbl_i03_w1 sn_i03_w1_0 rwl_sel 0 sky130_fd_pr__nfet_01v8 L=0.15 W=0.42 nf=1 ad=0.1218 as=0.1218 pd=1.42 ps=1.42 nrd=0.69047619047619 nrs=0.69047619047619 sa=0 sb=0 sd=0 mult=1 m=1
csn_i03_w1_0 sn_i03_w1_0 0 {C_SN}
XMWR_i03_w1_1 sn_i03_w1_1 0 wbl_i03_w1 0 sky130_fd_pr__nfet_01v8 L=0.15 W=0.42 nf=1 ad=0.1218 as=0.1218 pd=1.42 ps=1.42 nrd=0.69047619047619 nrs=0.69047619047619 sa=0 sb=0 sd=0 mult=1 m=1
XMRD_i03_w1_1 rbl_i03_w1 sn_i03_w1_1 rwl_des 0 sky130_fd_pr__nfet_01v8 L=0.15 W=0.42 nf=1 ad=0.1218 as=0.1218 pd=1.42 ps=1.42 nrd=0.69047619047619 nrs=0.69047619047619 sa=0 sb=0 sd=0 mult=1 m=1
csn_i03_w1_1 sn_i03_w1_1 0 {C_SN}
XMWR_i03_w1_2 sn_i03_w1_2 0 wbl_i03_w1 0 sky130_fd_pr__nfet_01v8 L=0.15 W=0.42 nf=1 ad=0.1218 as=0.1218 pd=1.42 ps=1.42 nrd=0.69047619047619 nrs=0.69047619047619 sa=0 sb=0 sd=0 mult=1 m=1
XMRD_i03_w1_2 rbl_i03_w1 sn_i03_w1_2 rwl_des 0 sky130_fd_pr__nfet_01v8 L=0.15 W=0.42 nf=1 ad=0.1218 as=0.1218 pd=1.42 ps=1.42 nrd=0.69047619047619 nrs=0.69047619047619 sa=0 sb=0 sd=0 mult=1 m=1
csn_i03_w1_2 sn_i03_w1_2 0 {C_SN}
XMWR_i03_w1_3 sn_i03_w1_3 0 wbl_i03_w1 0 sky130_fd_pr__nfet_01v8 L=0.15 W=0.42 nf=1 ad=0.1218 as=0.1218 pd=1.42 ps=1.42 nrd=0.69047619047619 nrs=0.69047619047619 sa=0 sb=0 sd=0 mult=1 m=1
XMRD_i03_w1_3 rbl_i03_w1 sn_i03_w1_3 rwl_des 0 sky130_fd_pr__nfet_01v8 L=0.15 W=0.42 nf=1 ad=0.1218 as=0.1218 pd=1.42 ps=1.42 nrd=0.69047619047619 nrs=0.69047619047619 sa=0 sb=0 sd=0 mult=1 m=1
csn_i03_w1_3 sn_i03_w1_3 0 {C_SN}
crbl_i03_w1 rbl_i03_w1 0 {C_RBL}
cwbl_i03_w1 wbl_i03_w1 0 {C_WBL}
cref_i03_w1 ref_i03_w1 0 {C_RBL}   $ ASSUMPTION: ideal matched dummy load
spr_i03_w1 pref ref_i03_w1 pca 0 swpre   $ reference-side precharge: ideal switch (#114 convention)
XMPPRE_i03_w1 rbl_i03_w1 pcb_100 prea prea sky130_fd_pr__pfet_01v8 L=0.15 W=4 nf=1 ad=1.16 as=1.16 pd=8.58 ps=8.58 nrd=0.0725 nrs=0.0725 sa=0 sb=0 sd=0 mult=1 m=1
XMPU1_i03_w1 x_i03_w1 dinb1 vdd vdd sky130_fd_pr__pfet_01v8 L=0.15 W=1 nf=1 ad=0.29 as=0.29 pd=2.58 ps=2.58 nrd=0.29 nrs=0.29 sa=0 sb=0 sd=0 mult=1 m=1
XMPU2_i03_w1 wbl_i03_w1 wenb x_i03_w1 vdd sky130_fd_pr__pfet_01v8 L=0.15 W=1 nf=1 ad=0.29 as=0.29 pd=2.58 ps=2.58 nrd=0.29 nrs=0.29 sa=0 sb=0 sd=0 mult=1 m=1
XMND2_i03_w1 wbl_i03_w1 wen y_i03_w1 0 sky130_fd_pr__nfet_01v8 L=0.15 W=0.5 nf=1 ad=0.145 as=0.145 pd=1.58 ps=1.58 nrd=0.58 nrs=0.58 sa=0 sb=0 sd=0 mult=1 m=1
XMND1_i03_w1 y_i03_w1 dinb1 0 0 sky130_fd_pr__nfet_01v8 L=0.15 W=0.5 nf=1 ad=0.145 as=0.145 pd=1.58 ps=1.58 nrd=0.58 nrs=0.58 sa=0 sb=0 sd=0 mult=1 m=1
XMNI_i03_w1 wbl_i03_w1 wenb 0 0 sky130_fd_pr__nfet_01v8 L=0.15 W=0.42 nf=1 ad=0.1218 as=0.1218 pd=1.42 ps=1.42 nrd=0.69047619047619 nrs=0.69047619047619 sa=0 sb=0 sd=0 mult=1 m=1
XMNS_i03_w1 sbl_i03_w1 sel_68000 rbl_i03_w1 0 sky130_fd_pr__nfet_01v8 L=0.15 W=1 nf=1 ad=0.29 as=0.29 pd=2.58 ps=2.58 nrd=0.29 nrs=0.29 sa=0 sb=0 sd=0 mult=1 m=1
XMPS_i03_w1 sbl_i03_w1 selb_68000 rbl_i03_w1 vdd sky130_fd_pr__pfet_01v8 L=0.15 W=2 nf=1 ad=0.58 as=0.58 pd=4.58 ps=4.58 nrd=0.145 nrs=0.145 sa=0 sb=0 sd=0 mult=1 m=1
XMNSR_i03_w1 sref_i03_w1 sel_68000 ref_i03_w1 0 sky130_fd_pr__nfet_01v8 L=0.15 W=1 nf=1 ad=0.29 as=0.29 pd=2.58 ps=2.58 nrd=0.29 nrs=0.29 sa=0 sb=0 sd=0 mult=1 m=1
XMPSR_i03_w1 sref_i03_w1 selb_68000 ref_i03_w1 vdd sky130_fd_pr__pfet_01v8 L=0.15 W=2 nf=1 ad=0.58 as=0.58 pd=4.58 ps=4.58 nrd=0.145 nrs=0.145 sa=0 sb=0 sd=0 mult=1 m=1
XMN1_i03_w1 sbl_i03_w1 sref_i03_w1 vn_i03_w1 0 sky130_fd_pr__nfet_01v8 L=0.15 W=1 nf=1 ad=0.29 as=0.29 pd=2.58 ps=2.58 nrd=0.29 nrs=0.29 sa=0 sb=0 sd=0 mult=1 m=1
XMN2_i03_w1 sref_i03_w1 sbl_i03_w1 vn_i03_w1 0 sky130_fd_pr__nfet_01v8 L=0.15 W=1 nf=1 ad=0.29 as=0.29 pd=2.58 ps=2.58 nrd=0.29 nrs=0.29 sa=0 sb=0 sd=0 mult=1 m=1
XMP1_i03_w1 sbl_i03_w1 sref_i03_w1 vp_i03_w1 vdd sky130_fd_pr__pfet_01v8 L=0.15 W=2 nf=1 ad=0.58 as=0.58 pd=4.58 ps=4.58 nrd=0.145 nrs=0.145 sa=0 sb=0 sd=0 mult=1 m=1
XMP2_i03_w1 sref_i03_w1 sbl_i03_w1 vp_i03_w1 vdd sky130_fd_pr__pfet_01v8 L=0.15 W=2 nf=1 ad=0.58 as=0.58 pd=4.58 ps=4.58 nrd=0.145 nrs=0.145 sa=0 sb=0 sd=0 mult=1 m=1
XMNF_i03_w1 vn_i03_w1 en 0 0 sky130_fd_pr__nfet_01v8 L=0.15 W=2 nf=1 ad=0.58 as=0.58 pd=4.58 ps=4.58 nrd=0.145 nrs=0.145 sa=0 sb=0 sd=0 mult=1 m=1
XMPH_i03_w1 vp_i03_w1 enb vdd vdd sky130_fd_pr__pfet_01v8 L=0.15 W=4 nf=1 ad=1.16 as=1.16 pd=8.58 ps=8.58 nrd=0.0725 nrs=0.0725 sa=0 sb=0 sd=0 mult=1 m=1
bd_i03_w1 d_i03_w1 0 v=v(sbl_i03_w1)-v(sref_i03_w1)
bdabs_i03_w1 dabs_i03_w1 0 v=abs(v(sbl_i03_w1)-v(sref_i03_w1))

* ---- instance 9: i03_w0 (lead 2.0 ns) ----
XMWR_i03_w0_0 sn_i03_w0_0 wl wbl_i03_w0 0 sky130_fd_pr__nfet_01v8 L=0.15 W=0.42 nf=1 ad=0.1218 as=0.1218 pd=1.42 ps=1.42 nrd=0.69047619047619 nrs=0.69047619047619 sa=0 sb=0 sd=0 mult=1 m=1
XMRD_i03_w0_0 rbl_i03_w0 sn_i03_w0_0 rwl_sel 0 sky130_fd_pr__nfet_01v8 L=0.15 W=0.42 nf=1 ad=0.1218 as=0.1218 pd=1.42 ps=1.42 nrd=0.69047619047619 nrs=0.69047619047619 sa=0 sb=0 sd=0 mult=1 m=1
csn_i03_w0_0 sn_i03_w0_0 0 {C_SN}
XMWR_i03_w0_1 sn_i03_w0_1 0 wbl_i03_w0 0 sky130_fd_pr__nfet_01v8 L=0.15 W=0.42 nf=1 ad=0.1218 as=0.1218 pd=1.42 ps=1.42 nrd=0.69047619047619 nrs=0.69047619047619 sa=0 sb=0 sd=0 mult=1 m=1
XMRD_i03_w0_1 rbl_i03_w0 sn_i03_w0_1 rwl_des 0 sky130_fd_pr__nfet_01v8 L=0.15 W=0.42 nf=1 ad=0.1218 as=0.1218 pd=1.42 ps=1.42 nrd=0.69047619047619 nrs=0.69047619047619 sa=0 sb=0 sd=0 mult=1 m=1
csn_i03_w0_1 sn_i03_w0_1 0 {C_SN}
XMWR_i03_w0_2 sn_i03_w0_2 0 wbl_i03_w0 0 sky130_fd_pr__nfet_01v8 L=0.15 W=0.42 nf=1 ad=0.1218 as=0.1218 pd=1.42 ps=1.42 nrd=0.69047619047619 nrs=0.69047619047619 sa=0 sb=0 sd=0 mult=1 m=1
XMRD_i03_w0_2 rbl_i03_w0 sn_i03_w0_2 rwl_des 0 sky130_fd_pr__nfet_01v8 L=0.15 W=0.42 nf=1 ad=0.1218 as=0.1218 pd=1.42 ps=1.42 nrd=0.69047619047619 nrs=0.69047619047619 sa=0 sb=0 sd=0 mult=1 m=1
csn_i03_w0_2 sn_i03_w0_2 0 {C_SN}
XMWR_i03_w0_3 sn_i03_w0_3 0 wbl_i03_w0 0 sky130_fd_pr__nfet_01v8 L=0.15 W=0.42 nf=1 ad=0.1218 as=0.1218 pd=1.42 ps=1.42 nrd=0.69047619047619 nrs=0.69047619047619 sa=0 sb=0 sd=0 mult=1 m=1
XMRD_i03_w0_3 rbl_i03_w0 sn_i03_w0_3 rwl_des 0 sky130_fd_pr__nfet_01v8 L=0.15 W=0.42 nf=1 ad=0.1218 as=0.1218 pd=1.42 ps=1.42 nrd=0.69047619047619 nrs=0.69047619047619 sa=0 sb=0 sd=0 mult=1 m=1
csn_i03_w0_3 sn_i03_w0_3 0 {C_SN}
crbl_i03_w0 rbl_i03_w0 0 {C_RBL}
cwbl_i03_w0 wbl_i03_w0 0 {C_WBL}
cref_i03_w0 ref_i03_w0 0 {C_RBL}   $ ASSUMPTION: ideal matched dummy load
spr_i03_w0 pref ref_i03_w0 pca 0 swpre   $ reference-side precharge: ideal switch (#114 convention)
XMPPRE_i03_w0 rbl_i03_w0 pcb_100 prea prea sky130_fd_pr__pfet_01v8 L=0.15 W=4 nf=1 ad=1.16 as=1.16 pd=8.58 ps=8.58 nrd=0.0725 nrs=0.0725 sa=0 sb=0 sd=0 mult=1 m=1
XMPU1_i03_w0 x_i03_w0 dinb0 vdd vdd sky130_fd_pr__pfet_01v8 L=0.15 W=1 nf=1 ad=0.29 as=0.29 pd=2.58 ps=2.58 nrd=0.29 nrs=0.29 sa=0 sb=0 sd=0 mult=1 m=1
XMPU2_i03_w0 wbl_i03_w0 wenb x_i03_w0 vdd sky130_fd_pr__pfet_01v8 L=0.15 W=1 nf=1 ad=0.29 as=0.29 pd=2.58 ps=2.58 nrd=0.29 nrs=0.29 sa=0 sb=0 sd=0 mult=1 m=1
XMND2_i03_w0 wbl_i03_w0 wen y_i03_w0 0 sky130_fd_pr__nfet_01v8 L=0.15 W=0.5 nf=1 ad=0.145 as=0.145 pd=1.58 ps=1.58 nrd=0.58 nrs=0.58 sa=0 sb=0 sd=0 mult=1 m=1
XMND1_i03_w0 y_i03_w0 dinb0 0 0 sky130_fd_pr__nfet_01v8 L=0.15 W=0.5 nf=1 ad=0.145 as=0.145 pd=1.58 ps=1.58 nrd=0.58 nrs=0.58 sa=0 sb=0 sd=0 mult=1 m=1
XMNI_i03_w0 wbl_i03_w0 wenb 0 0 sky130_fd_pr__nfet_01v8 L=0.15 W=0.42 nf=1 ad=0.1218 as=0.1218 pd=1.42 ps=1.42 nrd=0.69047619047619 nrs=0.69047619047619 sa=0 sb=0 sd=0 mult=1 m=1
XMNS_i03_w0 sbl_i03_w0 sel_68000 rbl_i03_w0 0 sky130_fd_pr__nfet_01v8 L=0.15 W=1 nf=1 ad=0.29 as=0.29 pd=2.58 ps=2.58 nrd=0.29 nrs=0.29 sa=0 sb=0 sd=0 mult=1 m=1
XMPS_i03_w0 sbl_i03_w0 selb_68000 rbl_i03_w0 vdd sky130_fd_pr__pfet_01v8 L=0.15 W=2 nf=1 ad=0.58 as=0.58 pd=4.58 ps=4.58 nrd=0.145 nrs=0.145 sa=0 sb=0 sd=0 mult=1 m=1
XMNSR_i03_w0 sref_i03_w0 sel_68000 ref_i03_w0 0 sky130_fd_pr__nfet_01v8 L=0.15 W=1 nf=1 ad=0.29 as=0.29 pd=2.58 ps=2.58 nrd=0.29 nrs=0.29 sa=0 sb=0 sd=0 mult=1 m=1
XMPSR_i03_w0 sref_i03_w0 selb_68000 ref_i03_w0 vdd sky130_fd_pr__pfet_01v8 L=0.15 W=2 nf=1 ad=0.58 as=0.58 pd=4.58 ps=4.58 nrd=0.145 nrs=0.145 sa=0 sb=0 sd=0 mult=1 m=1
XMN1_i03_w0 sbl_i03_w0 sref_i03_w0 vn_i03_w0 0 sky130_fd_pr__nfet_01v8 L=0.15 W=1 nf=1 ad=0.29 as=0.29 pd=2.58 ps=2.58 nrd=0.29 nrs=0.29 sa=0 sb=0 sd=0 mult=1 m=1
XMN2_i03_w0 sref_i03_w0 sbl_i03_w0 vn_i03_w0 0 sky130_fd_pr__nfet_01v8 L=0.15 W=1 nf=1 ad=0.29 as=0.29 pd=2.58 ps=2.58 nrd=0.29 nrs=0.29 sa=0 sb=0 sd=0 mult=1 m=1
XMP1_i03_w0 sbl_i03_w0 sref_i03_w0 vp_i03_w0 vdd sky130_fd_pr__pfet_01v8 L=0.15 W=2 nf=1 ad=0.58 as=0.58 pd=4.58 ps=4.58 nrd=0.145 nrs=0.145 sa=0 sb=0 sd=0 mult=1 m=1
XMP2_i03_w0 sref_i03_w0 sbl_i03_w0 vp_i03_w0 vdd sky130_fd_pr__pfet_01v8 L=0.15 W=2 nf=1 ad=0.58 as=0.58 pd=4.58 ps=4.58 nrd=0.145 nrs=0.145 sa=0 sb=0 sd=0 mult=1 m=1
XMNF_i03_w0 vn_i03_w0 en 0 0 sky130_fd_pr__nfet_01v8 L=0.15 W=2 nf=1 ad=0.58 as=0.58 pd=4.58 ps=4.58 nrd=0.145 nrs=0.145 sa=0 sb=0 sd=0 mult=1 m=1
XMPH_i03_w0 vp_i03_w0 enb vdd vdd sky130_fd_pr__pfet_01v8 L=0.15 W=4 nf=1 ad=1.16 as=1.16 pd=8.58 ps=8.58 nrd=0.0725 nrs=0.0725 sa=0 sb=0 sd=0 mult=1 m=1
bd_i03_w0 d_i03_w0 0 v=v(sbl_i03_w0)-v(sref_i03_w0)
bdabs_i03_w0 dabs_i03_w0 0 v=abs(v(sbl_i03_w0)-v(sref_i03_w0))

* ---- instance 10: i04_w1 (TG 0.5 / 1.0) ----
XMWR_i04_w1_0 sn_i04_w1_0 wl wbl_i04_w1 0 sky130_fd_pr__nfet_01v8 L=0.15 W=0.42 nf=1 ad=0.1218 as=0.1218 pd=1.42 ps=1.42 nrd=0.69047619047619 nrs=0.69047619047619 sa=0 sb=0 sd=0 mult=1 m=1
XMRD_i04_w1_0 rbl_i04_w1 sn_i04_w1_0 rwl_sel 0 sky130_fd_pr__nfet_01v8 L=0.15 W=0.42 nf=1 ad=0.1218 as=0.1218 pd=1.42 ps=1.42 nrd=0.69047619047619 nrs=0.69047619047619 sa=0 sb=0 sd=0 mult=1 m=1
csn_i04_w1_0 sn_i04_w1_0 0 {C_SN}
XMWR_i04_w1_1 sn_i04_w1_1 0 wbl_i04_w1 0 sky130_fd_pr__nfet_01v8 L=0.15 W=0.42 nf=1 ad=0.1218 as=0.1218 pd=1.42 ps=1.42 nrd=0.69047619047619 nrs=0.69047619047619 sa=0 sb=0 sd=0 mult=1 m=1
XMRD_i04_w1_1 rbl_i04_w1 sn_i04_w1_1 rwl_des 0 sky130_fd_pr__nfet_01v8 L=0.15 W=0.42 nf=1 ad=0.1218 as=0.1218 pd=1.42 ps=1.42 nrd=0.69047619047619 nrs=0.69047619047619 sa=0 sb=0 sd=0 mult=1 m=1
csn_i04_w1_1 sn_i04_w1_1 0 {C_SN}
XMWR_i04_w1_2 sn_i04_w1_2 0 wbl_i04_w1 0 sky130_fd_pr__nfet_01v8 L=0.15 W=0.42 nf=1 ad=0.1218 as=0.1218 pd=1.42 ps=1.42 nrd=0.69047619047619 nrs=0.69047619047619 sa=0 sb=0 sd=0 mult=1 m=1
XMRD_i04_w1_2 rbl_i04_w1 sn_i04_w1_2 rwl_des 0 sky130_fd_pr__nfet_01v8 L=0.15 W=0.42 nf=1 ad=0.1218 as=0.1218 pd=1.42 ps=1.42 nrd=0.69047619047619 nrs=0.69047619047619 sa=0 sb=0 sd=0 mult=1 m=1
csn_i04_w1_2 sn_i04_w1_2 0 {C_SN}
XMWR_i04_w1_3 sn_i04_w1_3 0 wbl_i04_w1 0 sky130_fd_pr__nfet_01v8 L=0.15 W=0.42 nf=1 ad=0.1218 as=0.1218 pd=1.42 ps=1.42 nrd=0.69047619047619 nrs=0.69047619047619 sa=0 sb=0 sd=0 mult=1 m=1
XMRD_i04_w1_3 rbl_i04_w1 sn_i04_w1_3 rwl_des 0 sky130_fd_pr__nfet_01v8 L=0.15 W=0.42 nf=1 ad=0.1218 as=0.1218 pd=1.42 ps=1.42 nrd=0.69047619047619 nrs=0.69047619047619 sa=0 sb=0 sd=0 mult=1 m=1
csn_i04_w1_3 sn_i04_w1_3 0 {C_SN}
crbl_i04_w1 rbl_i04_w1 0 {C_RBL}
cwbl_i04_w1 wbl_i04_w1 0 {C_WBL}
cref_i04_w1 ref_i04_w1 0 {C_RBL}   $ ASSUMPTION: ideal matched dummy load
spr_i04_w1 pref ref_i04_w1 pca 0 swpre   $ reference-side precharge: ideal switch (#114 convention)
XMPPRE_i04_w1 rbl_i04_w1 pcb_100 prea prea sky130_fd_pr__pfet_01v8 L=0.15 W=4 nf=1 ad=1.16 as=1.16 pd=8.58 ps=8.58 nrd=0.0725 nrs=0.0725 sa=0 sb=0 sd=0 mult=1 m=1
XMPU1_i04_w1 x_i04_w1 dinb1 vdd vdd sky130_fd_pr__pfet_01v8 L=0.15 W=1 nf=1 ad=0.29 as=0.29 pd=2.58 ps=2.58 nrd=0.29 nrs=0.29 sa=0 sb=0 sd=0 mult=1 m=1
XMPU2_i04_w1 wbl_i04_w1 wenb x_i04_w1 vdd sky130_fd_pr__pfet_01v8 L=0.15 W=1 nf=1 ad=0.29 as=0.29 pd=2.58 ps=2.58 nrd=0.29 nrs=0.29 sa=0 sb=0 sd=0 mult=1 m=1
XMND2_i04_w1 wbl_i04_w1 wen y_i04_w1 0 sky130_fd_pr__nfet_01v8 L=0.15 W=0.5 nf=1 ad=0.145 as=0.145 pd=1.58 ps=1.58 nrd=0.58 nrs=0.58 sa=0 sb=0 sd=0 mult=1 m=1
XMND1_i04_w1 y_i04_w1 dinb1 0 0 sky130_fd_pr__nfet_01v8 L=0.15 W=0.5 nf=1 ad=0.145 as=0.145 pd=1.58 ps=1.58 nrd=0.58 nrs=0.58 sa=0 sb=0 sd=0 mult=1 m=1
XMNI_i04_w1 wbl_i04_w1 wenb 0 0 sky130_fd_pr__nfet_01v8 L=0.15 W=0.42 nf=1 ad=0.1218 as=0.1218 pd=1.42 ps=1.42 nrd=0.69047619047619 nrs=0.69047619047619 sa=0 sb=0 sd=0 mult=1 m=1
XMNS_i04_w1 sbl_i04_w1 sel_69500 rbl_i04_w1 0 sky130_fd_pr__nfet_01v8 L=0.15 W=0.5 nf=1 ad=0.145 as=0.145 pd=1.58 ps=1.58 nrd=0.58 nrs=0.58 sa=0 sb=0 sd=0 mult=1 m=1
XMPS_i04_w1 sbl_i04_w1 selb_69500 rbl_i04_w1 vdd sky130_fd_pr__pfet_01v8 L=0.15 W=1 nf=1 ad=0.29 as=0.29 pd=2.58 ps=2.58 nrd=0.29 nrs=0.29 sa=0 sb=0 sd=0 mult=1 m=1
XMNSR_i04_w1 sref_i04_w1 sel_69500 ref_i04_w1 0 sky130_fd_pr__nfet_01v8 L=0.15 W=0.5 nf=1 ad=0.145 as=0.145 pd=1.58 ps=1.58 nrd=0.58 nrs=0.58 sa=0 sb=0 sd=0 mult=1 m=1
XMPSR_i04_w1 sref_i04_w1 selb_69500 ref_i04_w1 vdd sky130_fd_pr__pfet_01v8 L=0.15 W=1 nf=1 ad=0.29 as=0.29 pd=2.58 ps=2.58 nrd=0.29 nrs=0.29 sa=0 sb=0 sd=0 mult=1 m=1
XMN1_i04_w1 sbl_i04_w1 sref_i04_w1 vn_i04_w1 0 sky130_fd_pr__nfet_01v8 L=0.15 W=1 nf=1 ad=0.29 as=0.29 pd=2.58 ps=2.58 nrd=0.29 nrs=0.29 sa=0 sb=0 sd=0 mult=1 m=1
XMN2_i04_w1 sref_i04_w1 sbl_i04_w1 vn_i04_w1 0 sky130_fd_pr__nfet_01v8 L=0.15 W=1 nf=1 ad=0.29 as=0.29 pd=2.58 ps=2.58 nrd=0.29 nrs=0.29 sa=0 sb=0 sd=0 mult=1 m=1
XMP1_i04_w1 sbl_i04_w1 sref_i04_w1 vp_i04_w1 vdd sky130_fd_pr__pfet_01v8 L=0.15 W=2 nf=1 ad=0.58 as=0.58 pd=4.58 ps=4.58 nrd=0.145 nrs=0.145 sa=0 sb=0 sd=0 mult=1 m=1
XMP2_i04_w1 sref_i04_w1 sbl_i04_w1 vp_i04_w1 vdd sky130_fd_pr__pfet_01v8 L=0.15 W=2 nf=1 ad=0.58 as=0.58 pd=4.58 ps=4.58 nrd=0.145 nrs=0.145 sa=0 sb=0 sd=0 mult=1 m=1
XMNF_i04_w1 vn_i04_w1 en 0 0 sky130_fd_pr__nfet_01v8 L=0.15 W=2 nf=1 ad=0.58 as=0.58 pd=4.58 ps=4.58 nrd=0.145 nrs=0.145 sa=0 sb=0 sd=0 mult=1 m=1
XMPH_i04_w1 vp_i04_w1 enb vdd vdd sky130_fd_pr__pfet_01v8 L=0.15 W=4 nf=1 ad=1.16 as=1.16 pd=8.58 ps=8.58 nrd=0.0725 nrs=0.0725 sa=0 sb=0 sd=0 mult=1 m=1
bd_i04_w1 d_i04_w1 0 v=v(sbl_i04_w1)-v(sref_i04_w1)
bdabs_i04_w1 dabs_i04_w1 0 v=abs(v(sbl_i04_w1)-v(sref_i04_w1))

* ---- instance 11: i04_w0 (TG 0.5 / 1.0) ----
XMWR_i04_w0_0 sn_i04_w0_0 wl wbl_i04_w0 0 sky130_fd_pr__nfet_01v8 L=0.15 W=0.42 nf=1 ad=0.1218 as=0.1218 pd=1.42 ps=1.42 nrd=0.69047619047619 nrs=0.69047619047619 sa=0 sb=0 sd=0 mult=1 m=1
XMRD_i04_w0_0 rbl_i04_w0 sn_i04_w0_0 rwl_sel 0 sky130_fd_pr__nfet_01v8 L=0.15 W=0.42 nf=1 ad=0.1218 as=0.1218 pd=1.42 ps=1.42 nrd=0.69047619047619 nrs=0.69047619047619 sa=0 sb=0 sd=0 mult=1 m=1
csn_i04_w0_0 sn_i04_w0_0 0 {C_SN}
XMWR_i04_w0_1 sn_i04_w0_1 0 wbl_i04_w0 0 sky130_fd_pr__nfet_01v8 L=0.15 W=0.42 nf=1 ad=0.1218 as=0.1218 pd=1.42 ps=1.42 nrd=0.69047619047619 nrs=0.69047619047619 sa=0 sb=0 sd=0 mult=1 m=1
XMRD_i04_w0_1 rbl_i04_w0 sn_i04_w0_1 rwl_des 0 sky130_fd_pr__nfet_01v8 L=0.15 W=0.42 nf=1 ad=0.1218 as=0.1218 pd=1.42 ps=1.42 nrd=0.69047619047619 nrs=0.69047619047619 sa=0 sb=0 sd=0 mult=1 m=1
csn_i04_w0_1 sn_i04_w0_1 0 {C_SN}
XMWR_i04_w0_2 sn_i04_w0_2 0 wbl_i04_w0 0 sky130_fd_pr__nfet_01v8 L=0.15 W=0.42 nf=1 ad=0.1218 as=0.1218 pd=1.42 ps=1.42 nrd=0.69047619047619 nrs=0.69047619047619 sa=0 sb=0 sd=0 mult=1 m=1
XMRD_i04_w0_2 rbl_i04_w0 sn_i04_w0_2 rwl_des 0 sky130_fd_pr__nfet_01v8 L=0.15 W=0.42 nf=1 ad=0.1218 as=0.1218 pd=1.42 ps=1.42 nrd=0.69047619047619 nrs=0.69047619047619 sa=0 sb=0 sd=0 mult=1 m=1
csn_i04_w0_2 sn_i04_w0_2 0 {C_SN}
XMWR_i04_w0_3 sn_i04_w0_3 0 wbl_i04_w0 0 sky130_fd_pr__nfet_01v8 L=0.15 W=0.42 nf=1 ad=0.1218 as=0.1218 pd=1.42 ps=1.42 nrd=0.69047619047619 nrs=0.69047619047619 sa=0 sb=0 sd=0 mult=1 m=1
XMRD_i04_w0_3 rbl_i04_w0 sn_i04_w0_3 rwl_des 0 sky130_fd_pr__nfet_01v8 L=0.15 W=0.42 nf=1 ad=0.1218 as=0.1218 pd=1.42 ps=1.42 nrd=0.69047619047619 nrs=0.69047619047619 sa=0 sb=0 sd=0 mult=1 m=1
csn_i04_w0_3 sn_i04_w0_3 0 {C_SN}
crbl_i04_w0 rbl_i04_w0 0 {C_RBL}
cwbl_i04_w0 wbl_i04_w0 0 {C_WBL}
cref_i04_w0 ref_i04_w0 0 {C_RBL}   $ ASSUMPTION: ideal matched dummy load
spr_i04_w0 pref ref_i04_w0 pca 0 swpre   $ reference-side precharge: ideal switch (#114 convention)
XMPPRE_i04_w0 rbl_i04_w0 pcb_100 prea prea sky130_fd_pr__pfet_01v8 L=0.15 W=4 nf=1 ad=1.16 as=1.16 pd=8.58 ps=8.58 nrd=0.0725 nrs=0.0725 sa=0 sb=0 sd=0 mult=1 m=1
XMPU1_i04_w0 x_i04_w0 dinb0 vdd vdd sky130_fd_pr__pfet_01v8 L=0.15 W=1 nf=1 ad=0.29 as=0.29 pd=2.58 ps=2.58 nrd=0.29 nrs=0.29 sa=0 sb=0 sd=0 mult=1 m=1
XMPU2_i04_w0 wbl_i04_w0 wenb x_i04_w0 vdd sky130_fd_pr__pfet_01v8 L=0.15 W=1 nf=1 ad=0.29 as=0.29 pd=2.58 ps=2.58 nrd=0.29 nrs=0.29 sa=0 sb=0 sd=0 mult=1 m=1
XMND2_i04_w0 wbl_i04_w0 wen y_i04_w0 0 sky130_fd_pr__nfet_01v8 L=0.15 W=0.5 nf=1 ad=0.145 as=0.145 pd=1.58 ps=1.58 nrd=0.58 nrs=0.58 sa=0 sb=0 sd=0 mult=1 m=1
XMND1_i04_w0 y_i04_w0 dinb0 0 0 sky130_fd_pr__nfet_01v8 L=0.15 W=0.5 nf=1 ad=0.145 as=0.145 pd=1.58 ps=1.58 nrd=0.58 nrs=0.58 sa=0 sb=0 sd=0 mult=1 m=1
XMNI_i04_w0 wbl_i04_w0 wenb 0 0 sky130_fd_pr__nfet_01v8 L=0.15 W=0.42 nf=1 ad=0.1218 as=0.1218 pd=1.42 ps=1.42 nrd=0.69047619047619 nrs=0.69047619047619 sa=0 sb=0 sd=0 mult=1 m=1
XMNS_i04_w0 sbl_i04_w0 sel_69500 rbl_i04_w0 0 sky130_fd_pr__nfet_01v8 L=0.15 W=0.5 nf=1 ad=0.145 as=0.145 pd=1.58 ps=1.58 nrd=0.58 nrs=0.58 sa=0 sb=0 sd=0 mult=1 m=1
XMPS_i04_w0 sbl_i04_w0 selb_69500 rbl_i04_w0 vdd sky130_fd_pr__pfet_01v8 L=0.15 W=1 nf=1 ad=0.29 as=0.29 pd=2.58 ps=2.58 nrd=0.29 nrs=0.29 sa=0 sb=0 sd=0 mult=1 m=1
XMNSR_i04_w0 sref_i04_w0 sel_69500 ref_i04_w0 0 sky130_fd_pr__nfet_01v8 L=0.15 W=0.5 nf=1 ad=0.145 as=0.145 pd=1.58 ps=1.58 nrd=0.58 nrs=0.58 sa=0 sb=0 sd=0 mult=1 m=1
XMPSR_i04_w0 sref_i04_w0 selb_69500 ref_i04_w0 vdd sky130_fd_pr__pfet_01v8 L=0.15 W=1 nf=1 ad=0.29 as=0.29 pd=2.58 ps=2.58 nrd=0.29 nrs=0.29 sa=0 sb=0 sd=0 mult=1 m=1
XMN1_i04_w0 sbl_i04_w0 sref_i04_w0 vn_i04_w0 0 sky130_fd_pr__nfet_01v8 L=0.15 W=1 nf=1 ad=0.29 as=0.29 pd=2.58 ps=2.58 nrd=0.29 nrs=0.29 sa=0 sb=0 sd=0 mult=1 m=1
XMN2_i04_w0 sref_i04_w0 sbl_i04_w0 vn_i04_w0 0 sky130_fd_pr__nfet_01v8 L=0.15 W=1 nf=1 ad=0.29 as=0.29 pd=2.58 ps=2.58 nrd=0.29 nrs=0.29 sa=0 sb=0 sd=0 mult=1 m=1
XMP1_i04_w0 sbl_i04_w0 sref_i04_w0 vp_i04_w0 vdd sky130_fd_pr__pfet_01v8 L=0.15 W=2 nf=1 ad=0.58 as=0.58 pd=4.58 ps=4.58 nrd=0.145 nrs=0.145 sa=0 sb=0 sd=0 mult=1 m=1
XMP2_i04_w0 sref_i04_w0 sbl_i04_w0 vp_i04_w0 vdd sky130_fd_pr__pfet_01v8 L=0.15 W=2 nf=1 ad=0.58 as=0.58 pd=4.58 ps=4.58 nrd=0.145 nrs=0.145 sa=0 sb=0 sd=0 mult=1 m=1
XMNF_i04_w0 vn_i04_w0 en 0 0 sky130_fd_pr__nfet_01v8 L=0.15 W=2 nf=1 ad=0.58 as=0.58 pd=4.58 ps=4.58 nrd=0.145 nrs=0.145 sa=0 sb=0 sd=0 mult=1 m=1
XMPH_i04_w0 vp_i04_w0 enb vdd vdd sky130_fd_pr__pfet_01v8 L=0.15 W=4 nf=1 ad=1.16 as=1.16 pd=8.58 ps=8.58 nrd=0.0725 nrs=0.0725 sa=0 sb=0 sd=0 mult=1 m=1
bd_i04_w0 d_i04_w0 0 v=v(sbl_i04_w0)-v(sref_i04_w0)
bdabs_i04_w0 dabs_i04_w0 0 v=abs(v(sbl_i04_w0)-v(sref_i04_w0))

* ---- instance 12: i05_w1 (TG 0.42 / 0.42) ----
XMWR_i05_w1_0 sn_i05_w1_0 wl wbl_i05_w1 0 sky130_fd_pr__nfet_01v8 L=0.15 W=0.42 nf=1 ad=0.1218 as=0.1218 pd=1.42 ps=1.42 nrd=0.69047619047619 nrs=0.69047619047619 sa=0 sb=0 sd=0 mult=1 m=1
XMRD_i05_w1_0 rbl_i05_w1 sn_i05_w1_0 rwl_sel 0 sky130_fd_pr__nfet_01v8 L=0.15 W=0.42 nf=1 ad=0.1218 as=0.1218 pd=1.42 ps=1.42 nrd=0.69047619047619 nrs=0.69047619047619 sa=0 sb=0 sd=0 mult=1 m=1
csn_i05_w1_0 sn_i05_w1_0 0 {C_SN}
XMWR_i05_w1_1 sn_i05_w1_1 0 wbl_i05_w1 0 sky130_fd_pr__nfet_01v8 L=0.15 W=0.42 nf=1 ad=0.1218 as=0.1218 pd=1.42 ps=1.42 nrd=0.69047619047619 nrs=0.69047619047619 sa=0 sb=0 sd=0 mult=1 m=1
XMRD_i05_w1_1 rbl_i05_w1 sn_i05_w1_1 rwl_des 0 sky130_fd_pr__nfet_01v8 L=0.15 W=0.42 nf=1 ad=0.1218 as=0.1218 pd=1.42 ps=1.42 nrd=0.69047619047619 nrs=0.69047619047619 sa=0 sb=0 sd=0 mult=1 m=1
csn_i05_w1_1 sn_i05_w1_1 0 {C_SN}
XMWR_i05_w1_2 sn_i05_w1_2 0 wbl_i05_w1 0 sky130_fd_pr__nfet_01v8 L=0.15 W=0.42 nf=1 ad=0.1218 as=0.1218 pd=1.42 ps=1.42 nrd=0.69047619047619 nrs=0.69047619047619 sa=0 sb=0 sd=0 mult=1 m=1
XMRD_i05_w1_2 rbl_i05_w1 sn_i05_w1_2 rwl_des 0 sky130_fd_pr__nfet_01v8 L=0.15 W=0.42 nf=1 ad=0.1218 as=0.1218 pd=1.42 ps=1.42 nrd=0.69047619047619 nrs=0.69047619047619 sa=0 sb=0 sd=0 mult=1 m=1
csn_i05_w1_2 sn_i05_w1_2 0 {C_SN}
XMWR_i05_w1_3 sn_i05_w1_3 0 wbl_i05_w1 0 sky130_fd_pr__nfet_01v8 L=0.15 W=0.42 nf=1 ad=0.1218 as=0.1218 pd=1.42 ps=1.42 nrd=0.69047619047619 nrs=0.69047619047619 sa=0 sb=0 sd=0 mult=1 m=1
XMRD_i05_w1_3 rbl_i05_w1 sn_i05_w1_3 rwl_des 0 sky130_fd_pr__nfet_01v8 L=0.15 W=0.42 nf=1 ad=0.1218 as=0.1218 pd=1.42 ps=1.42 nrd=0.69047619047619 nrs=0.69047619047619 sa=0 sb=0 sd=0 mult=1 m=1
csn_i05_w1_3 sn_i05_w1_3 0 {C_SN}
crbl_i05_w1 rbl_i05_w1 0 {C_RBL}
cwbl_i05_w1 wbl_i05_w1 0 {C_WBL}
cref_i05_w1 ref_i05_w1 0 {C_RBL}   $ ASSUMPTION: ideal matched dummy load
spr_i05_w1 pref ref_i05_w1 pca 0 swpre   $ reference-side precharge: ideal switch (#114 convention)
XMPPRE_i05_w1 rbl_i05_w1 pcb_100 prea prea sky130_fd_pr__pfet_01v8 L=0.15 W=4 nf=1 ad=1.16 as=1.16 pd=8.58 ps=8.58 nrd=0.0725 nrs=0.0725 sa=0 sb=0 sd=0 mult=1 m=1
XMPU1_i05_w1 x_i05_w1 dinb1 vdd vdd sky130_fd_pr__pfet_01v8 L=0.15 W=1 nf=1 ad=0.29 as=0.29 pd=2.58 ps=2.58 nrd=0.29 nrs=0.29 sa=0 sb=0 sd=0 mult=1 m=1
XMPU2_i05_w1 wbl_i05_w1 wenb x_i05_w1 vdd sky130_fd_pr__pfet_01v8 L=0.15 W=1 nf=1 ad=0.29 as=0.29 pd=2.58 ps=2.58 nrd=0.29 nrs=0.29 sa=0 sb=0 sd=0 mult=1 m=1
XMND2_i05_w1 wbl_i05_w1 wen y_i05_w1 0 sky130_fd_pr__nfet_01v8 L=0.15 W=0.5 nf=1 ad=0.145 as=0.145 pd=1.58 ps=1.58 nrd=0.58 nrs=0.58 sa=0 sb=0 sd=0 mult=1 m=1
XMND1_i05_w1 y_i05_w1 dinb1 0 0 sky130_fd_pr__nfet_01v8 L=0.15 W=0.5 nf=1 ad=0.145 as=0.145 pd=1.58 ps=1.58 nrd=0.58 nrs=0.58 sa=0 sb=0 sd=0 mult=1 m=1
XMNI_i05_w1 wbl_i05_w1 wenb 0 0 sky130_fd_pr__nfet_01v8 L=0.15 W=0.42 nf=1 ad=0.1218 as=0.1218 pd=1.42 ps=1.42 nrd=0.69047619047619 nrs=0.69047619047619 sa=0 sb=0 sd=0 mult=1 m=1
XMNS_i05_w1 sbl_i05_w1 sel_69500 rbl_i05_w1 0 sky130_fd_pr__nfet_01v8 L=0.15 W=0.42 nf=1 ad=0.1218 as=0.1218 pd=1.42 ps=1.42 nrd=0.69047619047619 nrs=0.69047619047619 sa=0 sb=0 sd=0 mult=1 m=1
XMPS_i05_w1 sbl_i05_w1 selb_69500 rbl_i05_w1 vdd sky130_fd_pr__pfet_01v8 L=0.15 W=0.42 nf=1 ad=0.1218 as=0.1218 pd=1.42 ps=1.42 nrd=0.69047619047619 nrs=0.69047619047619 sa=0 sb=0 sd=0 mult=1 m=1
XMNSR_i05_w1 sref_i05_w1 sel_69500 ref_i05_w1 0 sky130_fd_pr__nfet_01v8 L=0.15 W=0.42 nf=1 ad=0.1218 as=0.1218 pd=1.42 ps=1.42 nrd=0.69047619047619 nrs=0.69047619047619 sa=0 sb=0 sd=0 mult=1 m=1
XMPSR_i05_w1 sref_i05_w1 selb_69500 ref_i05_w1 vdd sky130_fd_pr__pfet_01v8 L=0.15 W=0.42 nf=1 ad=0.1218 as=0.1218 pd=1.42 ps=1.42 nrd=0.69047619047619 nrs=0.69047619047619 sa=0 sb=0 sd=0 mult=1 m=1
XMN1_i05_w1 sbl_i05_w1 sref_i05_w1 vn_i05_w1 0 sky130_fd_pr__nfet_01v8 L=0.15 W=1 nf=1 ad=0.29 as=0.29 pd=2.58 ps=2.58 nrd=0.29 nrs=0.29 sa=0 sb=0 sd=0 mult=1 m=1
XMN2_i05_w1 sref_i05_w1 sbl_i05_w1 vn_i05_w1 0 sky130_fd_pr__nfet_01v8 L=0.15 W=1 nf=1 ad=0.29 as=0.29 pd=2.58 ps=2.58 nrd=0.29 nrs=0.29 sa=0 sb=0 sd=0 mult=1 m=1
XMP1_i05_w1 sbl_i05_w1 sref_i05_w1 vp_i05_w1 vdd sky130_fd_pr__pfet_01v8 L=0.15 W=2 nf=1 ad=0.58 as=0.58 pd=4.58 ps=4.58 nrd=0.145 nrs=0.145 sa=0 sb=0 sd=0 mult=1 m=1
XMP2_i05_w1 sref_i05_w1 sbl_i05_w1 vp_i05_w1 vdd sky130_fd_pr__pfet_01v8 L=0.15 W=2 nf=1 ad=0.58 as=0.58 pd=4.58 ps=4.58 nrd=0.145 nrs=0.145 sa=0 sb=0 sd=0 mult=1 m=1
XMNF_i05_w1 vn_i05_w1 en 0 0 sky130_fd_pr__nfet_01v8 L=0.15 W=2 nf=1 ad=0.58 as=0.58 pd=4.58 ps=4.58 nrd=0.145 nrs=0.145 sa=0 sb=0 sd=0 mult=1 m=1
XMPH_i05_w1 vp_i05_w1 enb vdd vdd sky130_fd_pr__pfet_01v8 L=0.15 W=4 nf=1 ad=1.16 as=1.16 pd=8.58 ps=8.58 nrd=0.0725 nrs=0.0725 sa=0 sb=0 sd=0 mult=1 m=1
bd_i05_w1 d_i05_w1 0 v=v(sbl_i05_w1)-v(sref_i05_w1)
bdabs_i05_w1 dabs_i05_w1 0 v=abs(v(sbl_i05_w1)-v(sref_i05_w1))

* ---- instance 13: i05_w0 (TG 0.42 / 0.42) ----
XMWR_i05_w0_0 sn_i05_w0_0 wl wbl_i05_w0 0 sky130_fd_pr__nfet_01v8 L=0.15 W=0.42 nf=1 ad=0.1218 as=0.1218 pd=1.42 ps=1.42 nrd=0.69047619047619 nrs=0.69047619047619 sa=0 sb=0 sd=0 mult=1 m=1
XMRD_i05_w0_0 rbl_i05_w0 sn_i05_w0_0 rwl_sel 0 sky130_fd_pr__nfet_01v8 L=0.15 W=0.42 nf=1 ad=0.1218 as=0.1218 pd=1.42 ps=1.42 nrd=0.69047619047619 nrs=0.69047619047619 sa=0 sb=0 sd=0 mult=1 m=1
csn_i05_w0_0 sn_i05_w0_0 0 {C_SN}
XMWR_i05_w0_1 sn_i05_w0_1 0 wbl_i05_w0 0 sky130_fd_pr__nfet_01v8 L=0.15 W=0.42 nf=1 ad=0.1218 as=0.1218 pd=1.42 ps=1.42 nrd=0.69047619047619 nrs=0.69047619047619 sa=0 sb=0 sd=0 mult=1 m=1
XMRD_i05_w0_1 rbl_i05_w0 sn_i05_w0_1 rwl_des 0 sky130_fd_pr__nfet_01v8 L=0.15 W=0.42 nf=1 ad=0.1218 as=0.1218 pd=1.42 ps=1.42 nrd=0.69047619047619 nrs=0.69047619047619 sa=0 sb=0 sd=0 mult=1 m=1
csn_i05_w0_1 sn_i05_w0_1 0 {C_SN}
XMWR_i05_w0_2 sn_i05_w0_2 0 wbl_i05_w0 0 sky130_fd_pr__nfet_01v8 L=0.15 W=0.42 nf=1 ad=0.1218 as=0.1218 pd=1.42 ps=1.42 nrd=0.69047619047619 nrs=0.69047619047619 sa=0 sb=0 sd=0 mult=1 m=1
XMRD_i05_w0_2 rbl_i05_w0 sn_i05_w0_2 rwl_des 0 sky130_fd_pr__nfet_01v8 L=0.15 W=0.42 nf=1 ad=0.1218 as=0.1218 pd=1.42 ps=1.42 nrd=0.69047619047619 nrs=0.69047619047619 sa=0 sb=0 sd=0 mult=1 m=1
csn_i05_w0_2 sn_i05_w0_2 0 {C_SN}
XMWR_i05_w0_3 sn_i05_w0_3 0 wbl_i05_w0 0 sky130_fd_pr__nfet_01v8 L=0.15 W=0.42 nf=1 ad=0.1218 as=0.1218 pd=1.42 ps=1.42 nrd=0.69047619047619 nrs=0.69047619047619 sa=0 sb=0 sd=0 mult=1 m=1
XMRD_i05_w0_3 rbl_i05_w0 sn_i05_w0_3 rwl_des 0 sky130_fd_pr__nfet_01v8 L=0.15 W=0.42 nf=1 ad=0.1218 as=0.1218 pd=1.42 ps=1.42 nrd=0.69047619047619 nrs=0.69047619047619 sa=0 sb=0 sd=0 mult=1 m=1
csn_i05_w0_3 sn_i05_w0_3 0 {C_SN}
crbl_i05_w0 rbl_i05_w0 0 {C_RBL}
cwbl_i05_w0 wbl_i05_w0 0 {C_WBL}
cref_i05_w0 ref_i05_w0 0 {C_RBL}   $ ASSUMPTION: ideal matched dummy load
spr_i05_w0 pref ref_i05_w0 pca 0 swpre   $ reference-side precharge: ideal switch (#114 convention)
XMPPRE_i05_w0 rbl_i05_w0 pcb_100 prea prea sky130_fd_pr__pfet_01v8 L=0.15 W=4 nf=1 ad=1.16 as=1.16 pd=8.58 ps=8.58 nrd=0.0725 nrs=0.0725 sa=0 sb=0 sd=0 mult=1 m=1
XMPU1_i05_w0 x_i05_w0 dinb0 vdd vdd sky130_fd_pr__pfet_01v8 L=0.15 W=1 nf=1 ad=0.29 as=0.29 pd=2.58 ps=2.58 nrd=0.29 nrs=0.29 sa=0 sb=0 sd=0 mult=1 m=1
XMPU2_i05_w0 wbl_i05_w0 wenb x_i05_w0 vdd sky130_fd_pr__pfet_01v8 L=0.15 W=1 nf=1 ad=0.29 as=0.29 pd=2.58 ps=2.58 nrd=0.29 nrs=0.29 sa=0 sb=0 sd=0 mult=1 m=1
XMND2_i05_w0 wbl_i05_w0 wen y_i05_w0 0 sky130_fd_pr__nfet_01v8 L=0.15 W=0.5 nf=1 ad=0.145 as=0.145 pd=1.58 ps=1.58 nrd=0.58 nrs=0.58 sa=0 sb=0 sd=0 mult=1 m=1
XMND1_i05_w0 y_i05_w0 dinb0 0 0 sky130_fd_pr__nfet_01v8 L=0.15 W=0.5 nf=1 ad=0.145 as=0.145 pd=1.58 ps=1.58 nrd=0.58 nrs=0.58 sa=0 sb=0 sd=0 mult=1 m=1
XMNI_i05_w0 wbl_i05_w0 wenb 0 0 sky130_fd_pr__nfet_01v8 L=0.15 W=0.42 nf=1 ad=0.1218 as=0.1218 pd=1.42 ps=1.42 nrd=0.69047619047619 nrs=0.69047619047619 sa=0 sb=0 sd=0 mult=1 m=1
XMNS_i05_w0 sbl_i05_w0 sel_69500 rbl_i05_w0 0 sky130_fd_pr__nfet_01v8 L=0.15 W=0.42 nf=1 ad=0.1218 as=0.1218 pd=1.42 ps=1.42 nrd=0.69047619047619 nrs=0.69047619047619 sa=0 sb=0 sd=0 mult=1 m=1
XMPS_i05_w0 sbl_i05_w0 selb_69500 rbl_i05_w0 vdd sky130_fd_pr__pfet_01v8 L=0.15 W=0.42 nf=1 ad=0.1218 as=0.1218 pd=1.42 ps=1.42 nrd=0.69047619047619 nrs=0.69047619047619 sa=0 sb=0 sd=0 mult=1 m=1
XMNSR_i05_w0 sref_i05_w0 sel_69500 ref_i05_w0 0 sky130_fd_pr__nfet_01v8 L=0.15 W=0.42 nf=1 ad=0.1218 as=0.1218 pd=1.42 ps=1.42 nrd=0.69047619047619 nrs=0.69047619047619 sa=0 sb=0 sd=0 mult=1 m=1
XMPSR_i05_w0 sref_i05_w0 selb_69500 ref_i05_w0 vdd sky130_fd_pr__pfet_01v8 L=0.15 W=0.42 nf=1 ad=0.1218 as=0.1218 pd=1.42 ps=1.42 nrd=0.69047619047619 nrs=0.69047619047619 sa=0 sb=0 sd=0 mult=1 m=1
XMN1_i05_w0 sbl_i05_w0 sref_i05_w0 vn_i05_w0 0 sky130_fd_pr__nfet_01v8 L=0.15 W=1 nf=1 ad=0.29 as=0.29 pd=2.58 ps=2.58 nrd=0.29 nrs=0.29 sa=0 sb=0 sd=0 mult=1 m=1
XMN2_i05_w0 sref_i05_w0 sbl_i05_w0 vn_i05_w0 0 sky130_fd_pr__nfet_01v8 L=0.15 W=1 nf=1 ad=0.29 as=0.29 pd=2.58 ps=2.58 nrd=0.29 nrs=0.29 sa=0 sb=0 sd=0 mult=1 m=1
XMP1_i05_w0 sbl_i05_w0 sref_i05_w0 vp_i05_w0 vdd sky130_fd_pr__pfet_01v8 L=0.15 W=2 nf=1 ad=0.58 as=0.58 pd=4.58 ps=4.58 nrd=0.145 nrs=0.145 sa=0 sb=0 sd=0 mult=1 m=1
XMP2_i05_w0 sref_i05_w0 sbl_i05_w0 vp_i05_w0 vdd sky130_fd_pr__pfet_01v8 L=0.15 W=2 nf=1 ad=0.58 as=0.58 pd=4.58 ps=4.58 nrd=0.145 nrs=0.145 sa=0 sb=0 sd=0 mult=1 m=1
XMNF_i05_w0 vn_i05_w0 en 0 0 sky130_fd_pr__nfet_01v8 L=0.15 W=2 nf=1 ad=0.58 as=0.58 pd=4.58 ps=4.58 nrd=0.145 nrs=0.145 sa=0 sb=0 sd=0 mult=1 m=1
XMPH_i05_w0 vp_i05_w0 enb vdd vdd sky130_fd_pr__pfet_01v8 L=0.15 W=4 nf=1 ad=1.16 as=1.16 pd=8.58 ps=8.58 nrd=0.0725 nrs=0.0725 sa=0 sb=0 sd=0 mult=1 m=1
bd_i05_w0 d_i05_w0 0 v=v(sbl_i05_w0)-v(sref_i05_w0)
bdabs_i05_w0 dabs_i05_w0 0 v=abs(v(sbl_i05_w0)-v(sref_i05_w0))

* ---- instance 14: i06_w1 (TG 0.42 / 0.84) ----
XMWR_i06_w1_0 sn_i06_w1_0 wl wbl_i06_w1 0 sky130_fd_pr__nfet_01v8 L=0.15 W=0.42 nf=1 ad=0.1218 as=0.1218 pd=1.42 ps=1.42 nrd=0.69047619047619 nrs=0.69047619047619 sa=0 sb=0 sd=0 mult=1 m=1
XMRD_i06_w1_0 rbl_i06_w1 sn_i06_w1_0 rwl_sel 0 sky130_fd_pr__nfet_01v8 L=0.15 W=0.42 nf=1 ad=0.1218 as=0.1218 pd=1.42 ps=1.42 nrd=0.69047619047619 nrs=0.69047619047619 sa=0 sb=0 sd=0 mult=1 m=1
csn_i06_w1_0 sn_i06_w1_0 0 {C_SN}
XMWR_i06_w1_1 sn_i06_w1_1 0 wbl_i06_w1 0 sky130_fd_pr__nfet_01v8 L=0.15 W=0.42 nf=1 ad=0.1218 as=0.1218 pd=1.42 ps=1.42 nrd=0.69047619047619 nrs=0.69047619047619 sa=0 sb=0 sd=0 mult=1 m=1
XMRD_i06_w1_1 rbl_i06_w1 sn_i06_w1_1 rwl_des 0 sky130_fd_pr__nfet_01v8 L=0.15 W=0.42 nf=1 ad=0.1218 as=0.1218 pd=1.42 ps=1.42 nrd=0.69047619047619 nrs=0.69047619047619 sa=0 sb=0 sd=0 mult=1 m=1
csn_i06_w1_1 sn_i06_w1_1 0 {C_SN}
XMWR_i06_w1_2 sn_i06_w1_2 0 wbl_i06_w1 0 sky130_fd_pr__nfet_01v8 L=0.15 W=0.42 nf=1 ad=0.1218 as=0.1218 pd=1.42 ps=1.42 nrd=0.69047619047619 nrs=0.69047619047619 sa=0 sb=0 sd=0 mult=1 m=1
XMRD_i06_w1_2 rbl_i06_w1 sn_i06_w1_2 rwl_des 0 sky130_fd_pr__nfet_01v8 L=0.15 W=0.42 nf=1 ad=0.1218 as=0.1218 pd=1.42 ps=1.42 nrd=0.69047619047619 nrs=0.69047619047619 sa=0 sb=0 sd=0 mult=1 m=1
csn_i06_w1_2 sn_i06_w1_2 0 {C_SN}
XMWR_i06_w1_3 sn_i06_w1_3 0 wbl_i06_w1 0 sky130_fd_pr__nfet_01v8 L=0.15 W=0.42 nf=1 ad=0.1218 as=0.1218 pd=1.42 ps=1.42 nrd=0.69047619047619 nrs=0.69047619047619 sa=0 sb=0 sd=0 mult=1 m=1
XMRD_i06_w1_3 rbl_i06_w1 sn_i06_w1_3 rwl_des 0 sky130_fd_pr__nfet_01v8 L=0.15 W=0.42 nf=1 ad=0.1218 as=0.1218 pd=1.42 ps=1.42 nrd=0.69047619047619 nrs=0.69047619047619 sa=0 sb=0 sd=0 mult=1 m=1
csn_i06_w1_3 sn_i06_w1_3 0 {C_SN}
crbl_i06_w1 rbl_i06_w1 0 {C_RBL}
cwbl_i06_w1 wbl_i06_w1 0 {C_WBL}
cref_i06_w1 ref_i06_w1 0 {C_RBL}   $ ASSUMPTION: ideal matched dummy load
spr_i06_w1 pref ref_i06_w1 pca 0 swpre   $ reference-side precharge: ideal switch (#114 convention)
XMPPRE_i06_w1 rbl_i06_w1 pcb_100 prea prea sky130_fd_pr__pfet_01v8 L=0.15 W=4 nf=1 ad=1.16 as=1.16 pd=8.58 ps=8.58 nrd=0.0725 nrs=0.0725 sa=0 sb=0 sd=0 mult=1 m=1
XMPU1_i06_w1 x_i06_w1 dinb1 vdd vdd sky130_fd_pr__pfet_01v8 L=0.15 W=1 nf=1 ad=0.29 as=0.29 pd=2.58 ps=2.58 nrd=0.29 nrs=0.29 sa=0 sb=0 sd=0 mult=1 m=1
XMPU2_i06_w1 wbl_i06_w1 wenb x_i06_w1 vdd sky130_fd_pr__pfet_01v8 L=0.15 W=1 nf=1 ad=0.29 as=0.29 pd=2.58 ps=2.58 nrd=0.29 nrs=0.29 sa=0 sb=0 sd=0 mult=1 m=1
XMND2_i06_w1 wbl_i06_w1 wen y_i06_w1 0 sky130_fd_pr__nfet_01v8 L=0.15 W=0.5 nf=1 ad=0.145 as=0.145 pd=1.58 ps=1.58 nrd=0.58 nrs=0.58 sa=0 sb=0 sd=0 mult=1 m=1
XMND1_i06_w1 y_i06_w1 dinb1 0 0 sky130_fd_pr__nfet_01v8 L=0.15 W=0.5 nf=1 ad=0.145 as=0.145 pd=1.58 ps=1.58 nrd=0.58 nrs=0.58 sa=0 sb=0 sd=0 mult=1 m=1
XMNI_i06_w1 wbl_i06_w1 wenb 0 0 sky130_fd_pr__nfet_01v8 L=0.15 W=0.42 nf=1 ad=0.1218 as=0.1218 pd=1.42 ps=1.42 nrd=0.69047619047619 nrs=0.69047619047619 sa=0 sb=0 sd=0 mult=1 m=1
XMNS_i06_w1 sbl_i06_w1 sel_69500 rbl_i06_w1 0 sky130_fd_pr__nfet_01v8 L=0.15 W=0.42 nf=1 ad=0.1218 as=0.1218 pd=1.42 ps=1.42 nrd=0.69047619047619 nrs=0.69047619047619 sa=0 sb=0 sd=0 mult=1 m=1
XMPS_i06_w1 sbl_i06_w1 selb_69500 rbl_i06_w1 vdd sky130_fd_pr__pfet_01v8 L=0.15 W=0.84 nf=1 ad=0.2436 as=0.2436 pd=2.26 ps=2.26 nrd=0.3452380952381 nrs=0.3452380952381 sa=0 sb=0 sd=0 mult=1 m=1
XMNSR_i06_w1 sref_i06_w1 sel_69500 ref_i06_w1 0 sky130_fd_pr__nfet_01v8 L=0.15 W=0.42 nf=1 ad=0.1218 as=0.1218 pd=1.42 ps=1.42 nrd=0.69047619047619 nrs=0.69047619047619 sa=0 sb=0 sd=0 mult=1 m=1
XMPSR_i06_w1 sref_i06_w1 selb_69500 ref_i06_w1 vdd sky130_fd_pr__pfet_01v8 L=0.15 W=0.84 nf=1 ad=0.2436 as=0.2436 pd=2.26 ps=2.26 nrd=0.3452380952381 nrs=0.3452380952381 sa=0 sb=0 sd=0 mult=1 m=1
XMN1_i06_w1 sbl_i06_w1 sref_i06_w1 vn_i06_w1 0 sky130_fd_pr__nfet_01v8 L=0.15 W=1 nf=1 ad=0.29 as=0.29 pd=2.58 ps=2.58 nrd=0.29 nrs=0.29 sa=0 sb=0 sd=0 mult=1 m=1
XMN2_i06_w1 sref_i06_w1 sbl_i06_w1 vn_i06_w1 0 sky130_fd_pr__nfet_01v8 L=0.15 W=1 nf=1 ad=0.29 as=0.29 pd=2.58 ps=2.58 nrd=0.29 nrs=0.29 sa=0 sb=0 sd=0 mult=1 m=1
XMP1_i06_w1 sbl_i06_w1 sref_i06_w1 vp_i06_w1 vdd sky130_fd_pr__pfet_01v8 L=0.15 W=2 nf=1 ad=0.58 as=0.58 pd=4.58 ps=4.58 nrd=0.145 nrs=0.145 sa=0 sb=0 sd=0 mult=1 m=1
XMP2_i06_w1 sref_i06_w1 sbl_i06_w1 vp_i06_w1 vdd sky130_fd_pr__pfet_01v8 L=0.15 W=2 nf=1 ad=0.58 as=0.58 pd=4.58 ps=4.58 nrd=0.145 nrs=0.145 sa=0 sb=0 sd=0 mult=1 m=1
XMNF_i06_w1 vn_i06_w1 en 0 0 sky130_fd_pr__nfet_01v8 L=0.15 W=2 nf=1 ad=0.58 as=0.58 pd=4.58 ps=4.58 nrd=0.145 nrs=0.145 sa=0 sb=0 sd=0 mult=1 m=1
XMPH_i06_w1 vp_i06_w1 enb vdd vdd sky130_fd_pr__pfet_01v8 L=0.15 W=4 nf=1 ad=1.16 as=1.16 pd=8.58 ps=8.58 nrd=0.0725 nrs=0.0725 sa=0 sb=0 sd=0 mult=1 m=1
bd_i06_w1 d_i06_w1 0 v=v(sbl_i06_w1)-v(sref_i06_w1)
bdabs_i06_w1 dabs_i06_w1 0 v=abs(v(sbl_i06_w1)-v(sref_i06_w1))

* ---- instance 15: i06_w0 (TG 0.42 / 0.84) ----
XMWR_i06_w0_0 sn_i06_w0_0 wl wbl_i06_w0 0 sky130_fd_pr__nfet_01v8 L=0.15 W=0.42 nf=1 ad=0.1218 as=0.1218 pd=1.42 ps=1.42 nrd=0.69047619047619 nrs=0.69047619047619 sa=0 sb=0 sd=0 mult=1 m=1
XMRD_i06_w0_0 rbl_i06_w0 sn_i06_w0_0 rwl_sel 0 sky130_fd_pr__nfet_01v8 L=0.15 W=0.42 nf=1 ad=0.1218 as=0.1218 pd=1.42 ps=1.42 nrd=0.69047619047619 nrs=0.69047619047619 sa=0 sb=0 sd=0 mult=1 m=1
csn_i06_w0_0 sn_i06_w0_0 0 {C_SN}
XMWR_i06_w0_1 sn_i06_w0_1 0 wbl_i06_w0 0 sky130_fd_pr__nfet_01v8 L=0.15 W=0.42 nf=1 ad=0.1218 as=0.1218 pd=1.42 ps=1.42 nrd=0.69047619047619 nrs=0.69047619047619 sa=0 sb=0 sd=0 mult=1 m=1
XMRD_i06_w0_1 rbl_i06_w0 sn_i06_w0_1 rwl_des 0 sky130_fd_pr__nfet_01v8 L=0.15 W=0.42 nf=1 ad=0.1218 as=0.1218 pd=1.42 ps=1.42 nrd=0.69047619047619 nrs=0.69047619047619 sa=0 sb=0 sd=0 mult=1 m=1
csn_i06_w0_1 sn_i06_w0_1 0 {C_SN}
XMWR_i06_w0_2 sn_i06_w0_2 0 wbl_i06_w0 0 sky130_fd_pr__nfet_01v8 L=0.15 W=0.42 nf=1 ad=0.1218 as=0.1218 pd=1.42 ps=1.42 nrd=0.69047619047619 nrs=0.69047619047619 sa=0 sb=0 sd=0 mult=1 m=1
XMRD_i06_w0_2 rbl_i06_w0 sn_i06_w0_2 rwl_des 0 sky130_fd_pr__nfet_01v8 L=0.15 W=0.42 nf=1 ad=0.1218 as=0.1218 pd=1.42 ps=1.42 nrd=0.69047619047619 nrs=0.69047619047619 sa=0 sb=0 sd=0 mult=1 m=1
csn_i06_w0_2 sn_i06_w0_2 0 {C_SN}
XMWR_i06_w0_3 sn_i06_w0_3 0 wbl_i06_w0 0 sky130_fd_pr__nfet_01v8 L=0.15 W=0.42 nf=1 ad=0.1218 as=0.1218 pd=1.42 ps=1.42 nrd=0.69047619047619 nrs=0.69047619047619 sa=0 sb=0 sd=0 mult=1 m=1
XMRD_i06_w0_3 rbl_i06_w0 sn_i06_w0_3 rwl_des 0 sky130_fd_pr__nfet_01v8 L=0.15 W=0.42 nf=1 ad=0.1218 as=0.1218 pd=1.42 ps=1.42 nrd=0.69047619047619 nrs=0.69047619047619 sa=0 sb=0 sd=0 mult=1 m=1
csn_i06_w0_3 sn_i06_w0_3 0 {C_SN}
crbl_i06_w0 rbl_i06_w0 0 {C_RBL}
cwbl_i06_w0 wbl_i06_w0 0 {C_WBL}
cref_i06_w0 ref_i06_w0 0 {C_RBL}   $ ASSUMPTION: ideal matched dummy load
spr_i06_w0 pref ref_i06_w0 pca 0 swpre   $ reference-side precharge: ideal switch (#114 convention)
XMPPRE_i06_w0 rbl_i06_w0 pcb_100 prea prea sky130_fd_pr__pfet_01v8 L=0.15 W=4 nf=1 ad=1.16 as=1.16 pd=8.58 ps=8.58 nrd=0.0725 nrs=0.0725 sa=0 sb=0 sd=0 mult=1 m=1
XMPU1_i06_w0 x_i06_w0 dinb0 vdd vdd sky130_fd_pr__pfet_01v8 L=0.15 W=1 nf=1 ad=0.29 as=0.29 pd=2.58 ps=2.58 nrd=0.29 nrs=0.29 sa=0 sb=0 sd=0 mult=1 m=1
XMPU2_i06_w0 wbl_i06_w0 wenb x_i06_w0 vdd sky130_fd_pr__pfet_01v8 L=0.15 W=1 nf=1 ad=0.29 as=0.29 pd=2.58 ps=2.58 nrd=0.29 nrs=0.29 sa=0 sb=0 sd=0 mult=1 m=1
XMND2_i06_w0 wbl_i06_w0 wen y_i06_w0 0 sky130_fd_pr__nfet_01v8 L=0.15 W=0.5 nf=1 ad=0.145 as=0.145 pd=1.58 ps=1.58 nrd=0.58 nrs=0.58 sa=0 sb=0 sd=0 mult=1 m=1
XMND1_i06_w0 y_i06_w0 dinb0 0 0 sky130_fd_pr__nfet_01v8 L=0.15 W=0.5 nf=1 ad=0.145 as=0.145 pd=1.58 ps=1.58 nrd=0.58 nrs=0.58 sa=0 sb=0 sd=0 mult=1 m=1
XMNI_i06_w0 wbl_i06_w0 wenb 0 0 sky130_fd_pr__nfet_01v8 L=0.15 W=0.42 nf=1 ad=0.1218 as=0.1218 pd=1.42 ps=1.42 nrd=0.69047619047619 nrs=0.69047619047619 sa=0 sb=0 sd=0 mult=1 m=1
XMNS_i06_w0 sbl_i06_w0 sel_69500 rbl_i06_w0 0 sky130_fd_pr__nfet_01v8 L=0.15 W=0.42 nf=1 ad=0.1218 as=0.1218 pd=1.42 ps=1.42 nrd=0.69047619047619 nrs=0.69047619047619 sa=0 sb=0 sd=0 mult=1 m=1
XMPS_i06_w0 sbl_i06_w0 selb_69500 rbl_i06_w0 vdd sky130_fd_pr__pfet_01v8 L=0.15 W=0.84 nf=1 ad=0.2436 as=0.2436 pd=2.26 ps=2.26 nrd=0.3452380952381 nrs=0.3452380952381 sa=0 sb=0 sd=0 mult=1 m=1
XMNSR_i06_w0 sref_i06_w0 sel_69500 ref_i06_w0 0 sky130_fd_pr__nfet_01v8 L=0.15 W=0.42 nf=1 ad=0.1218 as=0.1218 pd=1.42 ps=1.42 nrd=0.69047619047619 nrs=0.69047619047619 sa=0 sb=0 sd=0 mult=1 m=1
XMPSR_i06_w0 sref_i06_w0 selb_69500 ref_i06_w0 vdd sky130_fd_pr__pfet_01v8 L=0.15 W=0.84 nf=1 ad=0.2436 as=0.2436 pd=2.26 ps=2.26 nrd=0.3452380952381 nrs=0.3452380952381 sa=0 sb=0 sd=0 mult=1 m=1
XMN1_i06_w0 sbl_i06_w0 sref_i06_w0 vn_i06_w0 0 sky130_fd_pr__nfet_01v8 L=0.15 W=1 nf=1 ad=0.29 as=0.29 pd=2.58 ps=2.58 nrd=0.29 nrs=0.29 sa=0 sb=0 sd=0 mult=1 m=1
XMN2_i06_w0 sref_i06_w0 sbl_i06_w0 vn_i06_w0 0 sky130_fd_pr__nfet_01v8 L=0.15 W=1 nf=1 ad=0.29 as=0.29 pd=2.58 ps=2.58 nrd=0.29 nrs=0.29 sa=0 sb=0 sd=0 mult=1 m=1
XMP1_i06_w0 sbl_i06_w0 sref_i06_w0 vp_i06_w0 vdd sky130_fd_pr__pfet_01v8 L=0.15 W=2 nf=1 ad=0.58 as=0.58 pd=4.58 ps=4.58 nrd=0.145 nrs=0.145 sa=0 sb=0 sd=0 mult=1 m=1
XMP2_i06_w0 sref_i06_w0 sbl_i06_w0 vp_i06_w0 vdd sky130_fd_pr__pfet_01v8 L=0.15 W=2 nf=1 ad=0.58 as=0.58 pd=4.58 ps=4.58 nrd=0.145 nrs=0.145 sa=0 sb=0 sd=0 mult=1 m=1
XMNF_i06_w0 vn_i06_w0 en 0 0 sky130_fd_pr__nfet_01v8 L=0.15 W=2 nf=1 ad=0.58 as=0.58 pd=4.58 ps=4.58 nrd=0.145 nrs=0.145 sa=0 sb=0 sd=0 mult=1 m=1
XMPH_i06_w0 vp_i06_w0 enb vdd vdd sky130_fd_pr__pfet_01v8 L=0.15 W=4 nf=1 ad=1.16 as=1.16 pd=8.58 ps=8.58 nrd=0.0725 nrs=0.0725 sa=0 sb=0 sd=0 mult=1 m=1
bd_i06_w0 d_i06_w0 0 v=v(sbl_i06_w0)-v(sref_i06_w0)
bdabs_i06_w0 dabs_i06_w0 0 v=abs(v(sbl_i06_w0)-v(sref_i06_w0))

* ---- instance 16: i07_w1 (TG 2.0 / 4.0 (direction check)) ----
XMWR_i07_w1_0 sn_i07_w1_0 wl wbl_i07_w1 0 sky130_fd_pr__nfet_01v8 L=0.15 W=0.42 nf=1 ad=0.1218 as=0.1218 pd=1.42 ps=1.42 nrd=0.69047619047619 nrs=0.69047619047619 sa=0 sb=0 sd=0 mult=1 m=1
XMRD_i07_w1_0 rbl_i07_w1 sn_i07_w1_0 rwl_sel 0 sky130_fd_pr__nfet_01v8 L=0.15 W=0.42 nf=1 ad=0.1218 as=0.1218 pd=1.42 ps=1.42 nrd=0.69047619047619 nrs=0.69047619047619 sa=0 sb=0 sd=0 mult=1 m=1
csn_i07_w1_0 sn_i07_w1_0 0 {C_SN}
XMWR_i07_w1_1 sn_i07_w1_1 0 wbl_i07_w1 0 sky130_fd_pr__nfet_01v8 L=0.15 W=0.42 nf=1 ad=0.1218 as=0.1218 pd=1.42 ps=1.42 nrd=0.69047619047619 nrs=0.69047619047619 sa=0 sb=0 sd=0 mult=1 m=1
XMRD_i07_w1_1 rbl_i07_w1 sn_i07_w1_1 rwl_des 0 sky130_fd_pr__nfet_01v8 L=0.15 W=0.42 nf=1 ad=0.1218 as=0.1218 pd=1.42 ps=1.42 nrd=0.69047619047619 nrs=0.69047619047619 sa=0 sb=0 sd=0 mult=1 m=1
csn_i07_w1_1 sn_i07_w1_1 0 {C_SN}
XMWR_i07_w1_2 sn_i07_w1_2 0 wbl_i07_w1 0 sky130_fd_pr__nfet_01v8 L=0.15 W=0.42 nf=1 ad=0.1218 as=0.1218 pd=1.42 ps=1.42 nrd=0.69047619047619 nrs=0.69047619047619 sa=0 sb=0 sd=0 mult=1 m=1
XMRD_i07_w1_2 rbl_i07_w1 sn_i07_w1_2 rwl_des 0 sky130_fd_pr__nfet_01v8 L=0.15 W=0.42 nf=1 ad=0.1218 as=0.1218 pd=1.42 ps=1.42 nrd=0.69047619047619 nrs=0.69047619047619 sa=0 sb=0 sd=0 mult=1 m=1
csn_i07_w1_2 sn_i07_w1_2 0 {C_SN}
XMWR_i07_w1_3 sn_i07_w1_3 0 wbl_i07_w1 0 sky130_fd_pr__nfet_01v8 L=0.15 W=0.42 nf=1 ad=0.1218 as=0.1218 pd=1.42 ps=1.42 nrd=0.69047619047619 nrs=0.69047619047619 sa=0 sb=0 sd=0 mult=1 m=1
XMRD_i07_w1_3 rbl_i07_w1 sn_i07_w1_3 rwl_des 0 sky130_fd_pr__nfet_01v8 L=0.15 W=0.42 nf=1 ad=0.1218 as=0.1218 pd=1.42 ps=1.42 nrd=0.69047619047619 nrs=0.69047619047619 sa=0 sb=0 sd=0 mult=1 m=1
csn_i07_w1_3 sn_i07_w1_3 0 {C_SN}
crbl_i07_w1 rbl_i07_w1 0 {C_RBL}
cwbl_i07_w1 wbl_i07_w1 0 {C_WBL}
cref_i07_w1 ref_i07_w1 0 {C_RBL}   $ ASSUMPTION: ideal matched dummy load
spr_i07_w1 pref ref_i07_w1 pca 0 swpre   $ reference-side precharge: ideal switch (#114 convention)
XMPPRE_i07_w1 rbl_i07_w1 pcb_100 prea prea sky130_fd_pr__pfet_01v8 L=0.15 W=4 nf=1 ad=1.16 as=1.16 pd=8.58 ps=8.58 nrd=0.0725 nrs=0.0725 sa=0 sb=0 sd=0 mult=1 m=1
XMPU1_i07_w1 x_i07_w1 dinb1 vdd vdd sky130_fd_pr__pfet_01v8 L=0.15 W=1 nf=1 ad=0.29 as=0.29 pd=2.58 ps=2.58 nrd=0.29 nrs=0.29 sa=0 sb=0 sd=0 mult=1 m=1
XMPU2_i07_w1 wbl_i07_w1 wenb x_i07_w1 vdd sky130_fd_pr__pfet_01v8 L=0.15 W=1 nf=1 ad=0.29 as=0.29 pd=2.58 ps=2.58 nrd=0.29 nrs=0.29 sa=0 sb=0 sd=0 mult=1 m=1
XMND2_i07_w1 wbl_i07_w1 wen y_i07_w1 0 sky130_fd_pr__nfet_01v8 L=0.15 W=0.5 nf=1 ad=0.145 as=0.145 pd=1.58 ps=1.58 nrd=0.58 nrs=0.58 sa=0 sb=0 sd=0 mult=1 m=1
XMND1_i07_w1 y_i07_w1 dinb1 0 0 sky130_fd_pr__nfet_01v8 L=0.15 W=0.5 nf=1 ad=0.145 as=0.145 pd=1.58 ps=1.58 nrd=0.58 nrs=0.58 sa=0 sb=0 sd=0 mult=1 m=1
XMNI_i07_w1 wbl_i07_w1 wenb 0 0 sky130_fd_pr__nfet_01v8 L=0.15 W=0.42 nf=1 ad=0.1218 as=0.1218 pd=1.42 ps=1.42 nrd=0.69047619047619 nrs=0.69047619047619 sa=0 sb=0 sd=0 mult=1 m=1
XMNS_i07_w1 sbl_i07_w1 sel_69500 rbl_i07_w1 0 sky130_fd_pr__nfet_01v8 L=0.15 W=2 nf=1 ad=0.58 as=0.58 pd=4.58 ps=4.58 nrd=0.145 nrs=0.145 sa=0 sb=0 sd=0 mult=1 m=1
XMPS_i07_w1 sbl_i07_w1 selb_69500 rbl_i07_w1 vdd sky130_fd_pr__pfet_01v8 L=0.15 W=4 nf=1 ad=1.16 as=1.16 pd=8.58 ps=8.58 nrd=0.0725 nrs=0.0725 sa=0 sb=0 sd=0 mult=1 m=1
XMNSR_i07_w1 sref_i07_w1 sel_69500 ref_i07_w1 0 sky130_fd_pr__nfet_01v8 L=0.15 W=2 nf=1 ad=0.58 as=0.58 pd=4.58 ps=4.58 nrd=0.145 nrs=0.145 sa=0 sb=0 sd=0 mult=1 m=1
XMPSR_i07_w1 sref_i07_w1 selb_69500 ref_i07_w1 vdd sky130_fd_pr__pfet_01v8 L=0.15 W=4 nf=1 ad=1.16 as=1.16 pd=8.58 ps=8.58 nrd=0.0725 nrs=0.0725 sa=0 sb=0 sd=0 mult=1 m=1
XMN1_i07_w1 sbl_i07_w1 sref_i07_w1 vn_i07_w1 0 sky130_fd_pr__nfet_01v8 L=0.15 W=1 nf=1 ad=0.29 as=0.29 pd=2.58 ps=2.58 nrd=0.29 nrs=0.29 sa=0 sb=0 sd=0 mult=1 m=1
XMN2_i07_w1 sref_i07_w1 sbl_i07_w1 vn_i07_w1 0 sky130_fd_pr__nfet_01v8 L=0.15 W=1 nf=1 ad=0.29 as=0.29 pd=2.58 ps=2.58 nrd=0.29 nrs=0.29 sa=0 sb=0 sd=0 mult=1 m=1
XMP1_i07_w1 sbl_i07_w1 sref_i07_w1 vp_i07_w1 vdd sky130_fd_pr__pfet_01v8 L=0.15 W=2 nf=1 ad=0.58 as=0.58 pd=4.58 ps=4.58 nrd=0.145 nrs=0.145 sa=0 sb=0 sd=0 mult=1 m=1
XMP2_i07_w1 sref_i07_w1 sbl_i07_w1 vp_i07_w1 vdd sky130_fd_pr__pfet_01v8 L=0.15 W=2 nf=1 ad=0.58 as=0.58 pd=4.58 ps=4.58 nrd=0.145 nrs=0.145 sa=0 sb=0 sd=0 mult=1 m=1
XMNF_i07_w1 vn_i07_w1 en 0 0 sky130_fd_pr__nfet_01v8 L=0.15 W=2 nf=1 ad=0.58 as=0.58 pd=4.58 ps=4.58 nrd=0.145 nrs=0.145 sa=0 sb=0 sd=0 mult=1 m=1
XMPH_i07_w1 vp_i07_w1 enb vdd vdd sky130_fd_pr__pfet_01v8 L=0.15 W=4 nf=1 ad=1.16 as=1.16 pd=8.58 ps=8.58 nrd=0.0725 nrs=0.0725 sa=0 sb=0 sd=0 mult=1 m=1
bd_i07_w1 d_i07_w1 0 v=v(sbl_i07_w1)-v(sref_i07_w1)
bdabs_i07_w1 dabs_i07_w1 0 v=abs(v(sbl_i07_w1)-v(sref_i07_w1))

* ---- instance 17: i07_w0 (TG 2.0 / 4.0 (direction check)) ----
XMWR_i07_w0_0 sn_i07_w0_0 wl wbl_i07_w0 0 sky130_fd_pr__nfet_01v8 L=0.15 W=0.42 nf=1 ad=0.1218 as=0.1218 pd=1.42 ps=1.42 nrd=0.69047619047619 nrs=0.69047619047619 sa=0 sb=0 sd=0 mult=1 m=1
XMRD_i07_w0_0 rbl_i07_w0 sn_i07_w0_0 rwl_sel 0 sky130_fd_pr__nfet_01v8 L=0.15 W=0.42 nf=1 ad=0.1218 as=0.1218 pd=1.42 ps=1.42 nrd=0.69047619047619 nrs=0.69047619047619 sa=0 sb=0 sd=0 mult=1 m=1
csn_i07_w0_0 sn_i07_w0_0 0 {C_SN}
XMWR_i07_w0_1 sn_i07_w0_1 0 wbl_i07_w0 0 sky130_fd_pr__nfet_01v8 L=0.15 W=0.42 nf=1 ad=0.1218 as=0.1218 pd=1.42 ps=1.42 nrd=0.69047619047619 nrs=0.69047619047619 sa=0 sb=0 sd=0 mult=1 m=1
XMRD_i07_w0_1 rbl_i07_w0 sn_i07_w0_1 rwl_des 0 sky130_fd_pr__nfet_01v8 L=0.15 W=0.42 nf=1 ad=0.1218 as=0.1218 pd=1.42 ps=1.42 nrd=0.69047619047619 nrs=0.69047619047619 sa=0 sb=0 sd=0 mult=1 m=1
csn_i07_w0_1 sn_i07_w0_1 0 {C_SN}
XMWR_i07_w0_2 sn_i07_w0_2 0 wbl_i07_w0 0 sky130_fd_pr__nfet_01v8 L=0.15 W=0.42 nf=1 ad=0.1218 as=0.1218 pd=1.42 ps=1.42 nrd=0.69047619047619 nrs=0.69047619047619 sa=0 sb=0 sd=0 mult=1 m=1
XMRD_i07_w0_2 rbl_i07_w0 sn_i07_w0_2 rwl_des 0 sky130_fd_pr__nfet_01v8 L=0.15 W=0.42 nf=1 ad=0.1218 as=0.1218 pd=1.42 ps=1.42 nrd=0.69047619047619 nrs=0.69047619047619 sa=0 sb=0 sd=0 mult=1 m=1
csn_i07_w0_2 sn_i07_w0_2 0 {C_SN}
XMWR_i07_w0_3 sn_i07_w0_3 0 wbl_i07_w0 0 sky130_fd_pr__nfet_01v8 L=0.15 W=0.42 nf=1 ad=0.1218 as=0.1218 pd=1.42 ps=1.42 nrd=0.69047619047619 nrs=0.69047619047619 sa=0 sb=0 sd=0 mult=1 m=1
XMRD_i07_w0_3 rbl_i07_w0 sn_i07_w0_3 rwl_des 0 sky130_fd_pr__nfet_01v8 L=0.15 W=0.42 nf=1 ad=0.1218 as=0.1218 pd=1.42 ps=1.42 nrd=0.69047619047619 nrs=0.69047619047619 sa=0 sb=0 sd=0 mult=1 m=1
csn_i07_w0_3 sn_i07_w0_3 0 {C_SN}
crbl_i07_w0 rbl_i07_w0 0 {C_RBL}
cwbl_i07_w0 wbl_i07_w0 0 {C_WBL}
cref_i07_w0 ref_i07_w0 0 {C_RBL}   $ ASSUMPTION: ideal matched dummy load
spr_i07_w0 pref ref_i07_w0 pca 0 swpre   $ reference-side precharge: ideal switch (#114 convention)
XMPPRE_i07_w0 rbl_i07_w0 pcb_100 prea prea sky130_fd_pr__pfet_01v8 L=0.15 W=4 nf=1 ad=1.16 as=1.16 pd=8.58 ps=8.58 nrd=0.0725 nrs=0.0725 sa=0 sb=0 sd=0 mult=1 m=1
XMPU1_i07_w0 x_i07_w0 dinb0 vdd vdd sky130_fd_pr__pfet_01v8 L=0.15 W=1 nf=1 ad=0.29 as=0.29 pd=2.58 ps=2.58 nrd=0.29 nrs=0.29 sa=0 sb=0 sd=0 mult=1 m=1
XMPU2_i07_w0 wbl_i07_w0 wenb x_i07_w0 vdd sky130_fd_pr__pfet_01v8 L=0.15 W=1 nf=1 ad=0.29 as=0.29 pd=2.58 ps=2.58 nrd=0.29 nrs=0.29 sa=0 sb=0 sd=0 mult=1 m=1
XMND2_i07_w0 wbl_i07_w0 wen y_i07_w0 0 sky130_fd_pr__nfet_01v8 L=0.15 W=0.5 nf=1 ad=0.145 as=0.145 pd=1.58 ps=1.58 nrd=0.58 nrs=0.58 sa=0 sb=0 sd=0 mult=1 m=1
XMND1_i07_w0 y_i07_w0 dinb0 0 0 sky130_fd_pr__nfet_01v8 L=0.15 W=0.5 nf=1 ad=0.145 as=0.145 pd=1.58 ps=1.58 nrd=0.58 nrs=0.58 sa=0 sb=0 sd=0 mult=1 m=1
XMNI_i07_w0 wbl_i07_w0 wenb 0 0 sky130_fd_pr__nfet_01v8 L=0.15 W=0.42 nf=1 ad=0.1218 as=0.1218 pd=1.42 ps=1.42 nrd=0.69047619047619 nrs=0.69047619047619 sa=0 sb=0 sd=0 mult=1 m=1
XMNS_i07_w0 sbl_i07_w0 sel_69500 rbl_i07_w0 0 sky130_fd_pr__nfet_01v8 L=0.15 W=2 nf=1 ad=0.58 as=0.58 pd=4.58 ps=4.58 nrd=0.145 nrs=0.145 sa=0 sb=0 sd=0 mult=1 m=1
XMPS_i07_w0 sbl_i07_w0 selb_69500 rbl_i07_w0 vdd sky130_fd_pr__pfet_01v8 L=0.15 W=4 nf=1 ad=1.16 as=1.16 pd=8.58 ps=8.58 nrd=0.0725 nrs=0.0725 sa=0 sb=0 sd=0 mult=1 m=1
XMNSR_i07_w0 sref_i07_w0 sel_69500 ref_i07_w0 0 sky130_fd_pr__nfet_01v8 L=0.15 W=2 nf=1 ad=0.58 as=0.58 pd=4.58 ps=4.58 nrd=0.145 nrs=0.145 sa=0 sb=0 sd=0 mult=1 m=1
XMPSR_i07_w0 sref_i07_w0 selb_69500 ref_i07_w0 vdd sky130_fd_pr__pfet_01v8 L=0.15 W=4 nf=1 ad=1.16 as=1.16 pd=8.58 ps=8.58 nrd=0.0725 nrs=0.0725 sa=0 sb=0 sd=0 mult=1 m=1
XMN1_i07_w0 sbl_i07_w0 sref_i07_w0 vn_i07_w0 0 sky130_fd_pr__nfet_01v8 L=0.15 W=1 nf=1 ad=0.29 as=0.29 pd=2.58 ps=2.58 nrd=0.29 nrs=0.29 sa=0 sb=0 sd=0 mult=1 m=1
XMN2_i07_w0 sref_i07_w0 sbl_i07_w0 vn_i07_w0 0 sky130_fd_pr__nfet_01v8 L=0.15 W=1 nf=1 ad=0.29 as=0.29 pd=2.58 ps=2.58 nrd=0.29 nrs=0.29 sa=0 sb=0 sd=0 mult=1 m=1
XMP1_i07_w0 sbl_i07_w0 sref_i07_w0 vp_i07_w0 vdd sky130_fd_pr__pfet_01v8 L=0.15 W=2 nf=1 ad=0.58 as=0.58 pd=4.58 ps=4.58 nrd=0.145 nrs=0.145 sa=0 sb=0 sd=0 mult=1 m=1
XMP2_i07_w0 sref_i07_w0 sbl_i07_w0 vp_i07_w0 vdd sky130_fd_pr__pfet_01v8 L=0.15 W=2 nf=1 ad=0.58 as=0.58 pd=4.58 ps=4.58 nrd=0.145 nrs=0.145 sa=0 sb=0 sd=0 mult=1 m=1
XMNF_i07_w0 vn_i07_w0 en 0 0 sky130_fd_pr__nfet_01v8 L=0.15 W=2 nf=1 ad=0.58 as=0.58 pd=4.58 ps=4.58 nrd=0.145 nrs=0.145 sa=0 sb=0 sd=0 mult=1 m=1
XMPH_i07_w0 vp_i07_w0 enb vdd vdd sky130_fd_pr__pfet_01v8 L=0.15 W=4 nf=1 ad=1.16 as=1.16 pd=8.58 ps=8.58 nrd=0.0725 nrs=0.0725 sa=0 sb=0 sd=0 mult=1 m=1
bd_i07_w0 d_i07_w0 0 v=v(sbl_i07_w0)-v(sref_i07_w0)
bdabs_i07_w0 dabs_i07_w0 0 v=abs(v(sbl_i07_w0)-v(sref_i07_w0))

* ---- instance 18: i08_w1 (nfet only 1.0) ----
XMWR_i08_w1_0 sn_i08_w1_0 wl wbl_i08_w1 0 sky130_fd_pr__nfet_01v8 L=0.15 W=0.42 nf=1 ad=0.1218 as=0.1218 pd=1.42 ps=1.42 nrd=0.69047619047619 nrs=0.69047619047619 sa=0 sb=0 sd=0 mult=1 m=1
XMRD_i08_w1_0 rbl_i08_w1 sn_i08_w1_0 rwl_sel 0 sky130_fd_pr__nfet_01v8 L=0.15 W=0.42 nf=1 ad=0.1218 as=0.1218 pd=1.42 ps=1.42 nrd=0.69047619047619 nrs=0.69047619047619 sa=0 sb=0 sd=0 mult=1 m=1
csn_i08_w1_0 sn_i08_w1_0 0 {C_SN}
XMWR_i08_w1_1 sn_i08_w1_1 0 wbl_i08_w1 0 sky130_fd_pr__nfet_01v8 L=0.15 W=0.42 nf=1 ad=0.1218 as=0.1218 pd=1.42 ps=1.42 nrd=0.69047619047619 nrs=0.69047619047619 sa=0 sb=0 sd=0 mult=1 m=1
XMRD_i08_w1_1 rbl_i08_w1 sn_i08_w1_1 rwl_des 0 sky130_fd_pr__nfet_01v8 L=0.15 W=0.42 nf=1 ad=0.1218 as=0.1218 pd=1.42 ps=1.42 nrd=0.69047619047619 nrs=0.69047619047619 sa=0 sb=0 sd=0 mult=1 m=1
csn_i08_w1_1 sn_i08_w1_1 0 {C_SN}
XMWR_i08_w1_2 sn_i08_w1_2 0 wbl_i08_w1 0 sky130_fd_pr__nfet_01v8 L=0.15 W=0.42 nf=1 ad=0.1218 as=0.1218 pd=1.42 ps=1.42 nrd=0.69047619047619 nrs=0.69047619047619 sa=0 sb=0 sd=0 mult=1 m=1
XMRD_i08_w1_2 rbl_i08_w1 sn_i08_w1_2 rwl_des 0 sky130_fd_pr__nfet_01v8 L=0.15 W=0.42 nf=1 ad=0.1218 as=0.1218 pd=1.42 ps=1.42 nrd=0.69047619047619 nrs=0.69047619047619 sa=0 sb=0 sd=0 mult=1 m=1
csn_i08_w1_2 sn_i08_w1_2 0 {C_SN}
XMWR_i08_w1_3 sn_i08_w1_3 0 wbl_i08_w1 0 sky130_fd_pr__nfet_01v8 L=0.15 W=0.42 nf=1 ad=0.1218 as=0.1218 pd=1.42 ps=1.42 nrd=0.69047619047619 nrs=0.69047619047619 sa=0 sb=0 sd=0 mult=1 m=1
XMRD_i08_w1_3 rbl_i08_w1 sn_i08_w1_3 rwl_des 0 sky130_fd_pr__nfet_01v8 L=0.15 W=0.42 nf=1 ad=0.1218 as=0.1218 pd=1.42 ps=1.42 nrd=0.69047619047619 nrs=0.69047619047619 sa=0 sb=0 sd=0 mult=1 m=1
csn_i08_w1_3 sn_i08_w1_3 0 {C_SN}
crbl_i08_w1 rbl_i08_w1 0 {C_RBL}
cwbl_i08_w1 wbl_i08_w1 0 {C_WBL}
cref_i08_w1 ref_i08_w1 0 {C_RBL}   $ ASSUMPTION: ideal matched dummy load
spr_i08_w1 pref ref_i08_w1 pca 0 swpre   $ reference-side precharge: ideal switch (#114 convention)
XMPPRE_i08_w1 rbl_i08_w1 pcb_100 prea prea sky130_fd_pr__pfet_01v8 L=0.15 W=4 nf=1 ad=1.16 as=1.16 pd=8.58 ps=8.58 nrd=0.0725 nrs=0.0725 sa=0 sb=0 sd=0 mult=1 m=1
XMPU1_i08_w1 x_i08_w1 dinb1 vdd vdd sky130_fd_pr__pfet_01v8 L=0.15 W=1 nf=1 ad=0.29 as=0.29 pd=2.58 ps=2.58 nrd=0.29 nrs=0.29 sa=0 sb=0 sd=0 mult=1 m=1
XMPU2_i08_w1 wbl_i08_w1 wenb x_i08_w1 vdd sky130_fd_pr__pfet_01v8 L=0.15 W=1 nf=1 ad=0.29 as=0.29 pd=2.58 ps=2.58 nrd=0.29 nrs=0.29 sa=0 sb=0 sd=0 mult=1 m=1
XMND2_i08_w1 wbl_i08_w1 wen y_i08_w1 0 sky130_fd_pr__nfet_01v8 L=0.15 W=0.5 nf=1 ad=0.145 as=0.145 pd=1.58 ps=1.58 nrd=0.58 nrs=0.58 sa=0 sb=0 sd=0 mult=1 m=1
XMND1_i08_w1 y_i08_w1 dinb1 0 0 sky130_fd_pr__nfet_01v8 L=0.15 W=0.5 nf=1 ad=0.145 as=0.145 pd=1.58 ps=1.58 nrd=0.58 nrs=0.58 sa=0 sb=0 sd=0 mult=1 m=1
XMNI_i08_w1 wbl_i08_w1 wenb 0 0 sky130_fd_pr__nfet_01v8 L=0.15 W=0.42 nf=1 ad=0.1218 as=0.1218 pd=1.42 ps=1.42 nrd=0.69047619047619 nrs=0.69047619047619 sa=0 sb=0 sd=0 mult=1 m=1
XMNS_i08_w1 sbl_i08_w1 sel_69500 rbl_i08_w1 0 sky130_fd_pr__nfet_01v8 L=0.15 W=1 nf=1 ad=0.29 as=0.29 pd=2.58 ps=2.58 nrd=0.29 nrs=0.29 sa=0 sb=0 sd=0 mult=1 m=1
XMNSR_i08_w1 sref_i08_w1 sel_69500 ref_i08_w1 0 sky130_fd_pr__nfet_01v8 L=0.15 W=1 nf=1 ad=0.29 as=0.29 pd=2.58 ps=2.58 nrd=0.29 nrs=0.29 sa=0 sb=0 sd=0 mult=1 m=1
XMN1_i08_w1 sbl_i08_w1 sref_i08_w1 vn_i08_w1 0 sky130_fd_pr__nfet_01v8 L=0.15 W=1 nf=1 ad=0.29 as=0.29 pd=2.58 ps=2.58 nrd=0.29 nrs=0.29 sa=0 sb=0 sd=0 mult=1 m=1
XMN2_i08_w1 sref_i08_w1 sbl_i08_w1 vn_i08_w1 0 sky130_fd_pr__nfet_01v8 L=0.15 W=1 nf=1 ad=0.29 as=0.29 pd=2.58 ps=2.58 nrd=0.29 nrs=0.29 sa=0 sb=0 sd=0 mult=1 m=1
XMP1_i08_w1 sbl_i08_w1 sref_i08_w1 vp_i08_w1 vdd sky130_fd_pr__pfet_01v8 L=0.15 W=2 nf=1 ad=0.58 as=0.58 pd=4.58 ps=4.58 nrd=0.145 nrs=0.145 sa=0 sb=0 sd=0 mult=1 m=1
XMP2_i08_w1 sref_i08_w1 sbl_i08_w1 vp_i08_w1 vdd sky130_fd_pr__pfet_01v8 L=0.15 W=2 nf=1 ad=0.58 as=0.58 pd=4.58 ps=4.58 nrd=0.145 nrs=0.145 sa=0 sb=0 sd=0 mult=1 m=1
XMNF_i08_w1 vn_i08_w1 en 0 0 sky130_fd_pr__nfet_01v8 L=0.15 W=2 nf=1 ad=0.58 as=0.58 pd=4.58 ps=4.58 nrd=0.145 nrs=0.145 sa=0 sb=0 sd=0 mult=1 m=1
XMPH_i08_w1 vp_i08_w1 enb vdd vdd sky130_fd_pr__pfet_01v8 L=0.15 W=4 nf=1 ad=1.16 as=1.16 pd=8.58 ps=8.58 nrd=0.0725 nrs=0.0725 sa=0 sb=0 sd=0 mult=1 m=1
bd_i08_w1 d_i08_w1 0 v=v(sbl_i08_w1)-v(sref_i08_w1)
bdabs_i08_w1 dabs_i08_w1 0 v=abs(v(sbl_i08_w1)-v(sref_i08_w1))

* ---- instance 19: i08_w0 (nfet only 1.0) ----
XMWR_i08_w0_0 sn_i08_w0_0 wl wbl_i08_w0 0 sky130_fd_pr__nfet_01v8 L=0.15 W=0.42 nf=1 ad=0.1218 as=0.1218 pd=1.42 ps=1.42 nrd=0.69047619047619 nrs=0.69047619047619 sa=0 sb=0 sd=0 mult=1 m=1
XMRD_i08_w0_0 rbl_i08_w0 sn_i08_w0_0 rwl_sel 0 sky130_fd_pr__nfet_01v8 L=0.15 W=0.42 nf=1 ad=0.1218 as=0.1218 pd=1.42 ps=1.42 nrd=0.69047619047619 nrs=0.69047619047619 sa=0 sb=0 sd=0 mult=1 m=1
csn_i08_w0_0 sn_i08_w0_0 0 {C_SN}
XMWR_i08_w0_1 sn_i08_w0_1 0 wbl_i08_w0 0 sky130_fd_pr__nfet_01v8 L=0.15 W=0.42 nf=1 ad=0.1218 as=0.1218 pd=1.42 ps=1.42 nrd=0.69047619047619 nrs=0.69047619047619 sa=0 sb=0 sd=0 mult=1 m=1
XMRD_i08_w0_1 rbl_i08_w0 sn_i08_w0_1 rwl_des 0 sky130_fd_pr__nfet_01v8 L=0.15 W=0.42 nf=1 ad=0.1218 as=0.1218 pd=1.42 ps=1.42 nrd=0.69047619047619 nrs=0.69047619047619 sa=0 sb=0 sd=0 mult=1 m=1
csn_i08_w0_1 sn_i08_w0_1 0 {C_SN}
XMWR_i08_w0_2 sn_i08_w0_2 0 wbl_i08_w0 0 sky130_fd_pr__nfet_01v8 L=0.15 W=0.42 nf=1 ad=0.1218 as=0.1218 pd=1.42 ps=1.42 nrd=0.69047619047619 nrs=0.69047619047619 sa=0 sb=0 sd=0 mult=1 m=1
XMRD_i08_w0_2 rbl_i08_w0 sn_i08_w0_2 rwl_des 0 sky130_fd_pr__nfet_01v8 L=0.15 W=0.42 nf=1 ad=0.1218 as=0.1218 pd=1.42 ps=1.42 nrd=0.69047619047619 nrs=0.69047619047619 sa=0 sb=0 sd=0 mult=1 m=1
csn_i08_w0_2 sn_i08_w0_2 0 {C_SN}
XMWR_i08_w0_3 sn_i08_w0_3 0 wbl_i08_w0 0 sky130_fd_pr__nfet_01v8 L=0.15 W=0.42 nf=1 ad=0.1218 as=0.1218 pd=1.42 ps=1.42 nrd=0.69047619047619 nrs=0.69047619047619 sa=0 sb=0 sd=0 mult=1 m=1
XMRD_i08_w0_3 rbl_i08_w0 sn_i08_w0_3 rwl_des 0 sky130_fd_pr__nfet_01v8 L=0.15 W=0.42 nf=1 ad=0.1218 as=0.1218 pd=1.42 ps=1.42 nrd=0.69047619047619 nrs=0.69047619047619 sa=0 sb=0 sd=0 mult=1 m=1
csn_i08_w0_3 sn_i08_w0_3 0 {C_SN}
crbl_i08_w0 rbl_i08_w0 0 {C_RBL}
cwbl_i08_w0 wbl_i08_w0 0 {C_WBL}
cref_i08_w0 ref_i08_w0 0 {C_RBL}   $ ASSUMPTION: ideal matched dummy load
spr_i08_w0 pref ref_i08_w0 pca 0 swpre   $ reference-side precharge: ideal switch (#114 convention)
XMPPRE_i08_w0 rbl_i08_w0 pcb_100 prea prea sky130_fd_pr__pfet_01v8 L=0.15 W=4 nf=1 ad=1.16 as=1.16 pd=8.58 ps=8.58 nrd=0.0725 nrs=0.0725 sa=0 sb=0 sd=0 mult=1 m=1
XMPU1_i08_w0 x_i08_w0 dinb0 vdd vdd sky130_fd_pr__pfet_01v8 L=0.15 W=1 nf=1 ad=0.29 as=0.29 pd=2.58 ps=2.58 nrd=0.29 nrs=0.29 sa=0 sb=0 sd=0 mult=1 m=1
XMPU2_i08_w0 wbl_i08_w0 wenb x_i08_w0 vdd sky130_fd_pr__pfet_01v8 L=0.15 W=1 nf=1 ad=0.29 as=0.29 pd=2.58 ps=2.58 nrd=0.29 nrs=0.29 sa=0 sb=0 sd=0 mult=1 m=1
XMND2_i08_w0 wbl_i08_w0 wen y_i08_w0 0 sky130_fd_pr__nfet_01v8 L=0.15 W=0.5 nf=1 ad=0.145 as=0.145 pd=1.58 ps=1.58 nrd=0.58 nrs=0.58 sa=0 sb=0 sd=0 mult=1 m=1
XMND1_i08_w0 y_i08_w0 dinb0 0 0 sky130_fd_pr__nfet_01v8 L=0.15 W=0.5 nf=1 ad=0.145 as=0.145 pd=1.58 ps=1.58 nrd=0.58 nrs=0.58 sa=0 sb=0 sd=0 mult=1 m=1
XMNI_i08_w0 wbl_i08_w0 wenb 0 0 sky130_fd_pr__nfet_01v8 L=0.15 W=0.42 nf=1 ad=0.1218 as=0.1218 pd=1.42 ps=1.42 nrd=0.69047619047619 nrs=0.69047619047619 sa=0 sb=0 sd=0 mult=1 m=1
XMNS_i08_w0 sbl_i08_w0 sel_69500 rbl_i08_w0 0 sky130_fd_pr__nfet_01v8 L=0.15 W=1 nf=1 ad=0.29 as=0.29 pd=2.58 ps=2.58 nrd=0.29 nrs=0.29 sa=0 sb=0 sd=0 mult=1 m=1
XMNSR_i08_w0 sref_i08_w0 sel_69500 ref_i08_w0 0 sky130_fd_pr__nfet_01v8 L=0.15 W=1 nf=1 ad=0.29 as=0.29 pd=2.58 ps=2.58 nrd=0.29 nrs=0.29 sa=0 sb=0 sd=0 mult=1 m=1
XMN1_i08_w0 sbl_i08_w0 sref_i08_w0 vn_i08_w0 0 sky130_fd_pr__nfet_01v8 L=0.15 W=1 nf=1 ad=0.29 as=0.29 pd=2.58 ps=2.58 nrd=0.29 nrs=0.29 sa=0 sb=0 sd=0 mult=1 m=1
XMN2_i08_w0 sref_i08_w0 sbl_i08_w0 vn_i08_w0 0 sky130_fd_pr__nfet_01v8 L=0.15 W=1 nf=1 ad=0.29 as=0.29 pd=2.58 ps=2.58 nrd=0.29 nrs=0.29 sa=0 sb=0 sd=0 mult=1 m=1
XMP1_i08_w0 sbl_i08_w0 sref_i08_w0 vp_i08_w0 vdd sky130_fd_pr__pfet_01v8 L=0.15 W=2 nf=1 ad=0.58 as=0.58 pd=4.58 ps=4.58 nrd=0.145 nrs=0.145 sa=0 sb=0 sd=0 mult=1 m=1
XMP2_i08_w0 sref_i08_w0 sbl_i08_w0 vp_i08_w0 vdd sky130_fd_pr__pfet_01v8 L=0.15 W=2 nf=1 ad=0.58 as=0.58 pd=4.58 ps=4.58 nrd=0.145 nrs=0.145 sa=0 sb=0 sd=0 mult=1 m=1
XMNF_i08_w0 vn_i08_w0 en 0 0 sky130_fd_pr__nfet_01v8 L=0.15 W=2 nf=1 ad=0.58 as=0.58 pd=4.58 ps=4.58 nrd=0.145 nrs=0.145 sa=0 sb=0 sd=0 mult=1 m=1
XMPH_i08_w0 vp_i08_w0 enb vdd vdd sky130_fd_pr__pfet_01v8 L=0.15 W=4 nf=1 ad=1.16 as=1.16 pd=8.58 ps=8.58 nrd=0.0725 nrs=0.0725 sa=0 sb=0 sd=0 mult=1 m=1
bd_i08_w0 d_i08_w0 0 v=v(sbl_i08_w0)-v(sref_i08_w0)
bdabs_i08_w0 dabs_i08_w0 0 v=abs(v(sbl_i08_w0)-v(sref_i08_w0))

* ---- instance 20: i09_w1 (nfet only 0.42) ----
XMWR_i09_w1_0 sn_i09_w1_0 wl wbl_i09_w1 0 sky130_fd_pr__nfet_01v8 L=0.15 W=0.42 nf=1 ad=0.1218 as=0.1218 pd=1.42 ps=1.42 nrd=0.69047619047619 nrs=0.69047619047619 sa=0 sb=0 sd=0 mult=1 m=1
XMRD_i09_w1_0 rbl_i09_w1 sn_i09_w1_0 rwl_sel 0 sky130_fd_pr__nfet_01v8 L=0.15 W=0.42 nf=1 ad=0.1218 as=0.1218 pd=1.42 ps=1.42 nrd=0.69047619047619 nrs=0.69047619047619 sa=0 sb=0 sd=0 mult=1 m=1
csn_i09_w1_0 sn_i09_w1_0 0 {C_SN}
XMWR_i09_w1_1 sn_i09_w1_1 0 wbl_i09_w1 0 sky130_fd_pr__nfet_01v8 L=0.15 W=0.42 nf=1 ad=0.1218 as=0.1218 pd=1.42 ps=1.42 nrd=0.69047619047619 nrs=0.69047619047619 sa=0 sb=0 sd=0 mult=1 m=1
XMRD_i09_w1_1 rbl_i09_w1 sn_i09_w1_1 rwl_des 0 sky130_fd_pr__nfet_01v8 L=0.15 W=0.42 nf=1 ad=0.1218 as=0.1218 pd=1.42 ps=1.42 nrd=0.69047619047619 nrs=0.69047619047619 sa=0 sb=0 sd=0 mult=1 m=1
csn_i09_w1_1 sn_i09_w1_1 0 {C_SN}
XMWR_i09_w1_2 sn_i09_w1_2 0 wbl_i09_w1 0 sky130_fd_pr__nfet_01v8 L=0.15 W=0.42 nf=1 ad=0.1218 as=0.1218 pd=1.42 ps=1.42 nrd=0.69047619047619 nrs=0.69047619047619 sa=0 sb=0 sd=0 mult=1 m=1
XMRD_i09_w1_2 rbl_i09_w1 sn_i09_w1_2 rwl_des 0 sky130_fd_pr__nfet_01v8 L=0.15 W=0.42 nf=1 ad=0.1218 as=0.1218 pd=1.42 ps=1.42 nrd=0.69047619047619 nrs=0.69047619047619 sa=0 sb=0 sd=0 mult=1 m=1
csn_i09_w1_2 sn_i09_w1_2 0 {C_SN}
XMWR_i09_w1_3 sn_i09_w1_3 0 wbl_i09_w1 0 sky130_fd_pr__nfet_01v8 L=0.15 W=0.42 nf=1 ad=0.1218 as=0.1218 pd=1.42 ps=1.42 nrd=0.69047619047619 nrs=0.69047619047619 sa=0 sb=0 sd=0 mult=1 m=1
XMRD_i09_w1_3 rbl_i09_w1 sn_i09_w1_3 rwl_des 0 sky130_fd_pr__nfet_01v8 L=0.15 W=0.42 nf=1 ad=0.1218 as=0.1218 pd=1.42 ps=1.42 nrd=0.69047619047619 nrs=0.69047619047619 sa=0 sb=0 sd=0 mult=1 m=1
csn_i09_w1_3 sn_i09_w1_3 0 {C_SN}
crbl_i09_w1 rbl_i09_w1 0 {C_RBL}
cwbl_i09_w1 wbl_i09_w1 0 {C_WBL}
cref_i09_w1 ref_i09_w1 0 {C_RBL}   $ ASSUMPTION: ideal matched dummy load
spr_i09_w1 pref ref_i09_w1 pca 0 swpre   $ reference-side precharge: ideal switch (#114 convention)
XMPPRE_i09_w1 rbl_i09_w1 pcb_100 prea prea sky130_fd_pr__pfet_01v8 L=0.15 W=4 nf=1 ad=1.16 as=1.16 pd=8.58 ps=8.58 nrd=0.0725 nrs=0.0725 sa=0 sb=0 sd=0 mult=1 m=1
XMPU1_i09_w1 x_i09_w1 dinb1 vdd vdd sky130_fd_pr__pfet_01v8 L=0.15 W=1 nf=1 ad=0.29 as=0.29 pd=2.58 ps=2.58 nrd=0.29 nrs=0.29 sa=0 sb=0 sd=0 mult=1 m=1
XMPU2_i09_w1 wbl_i09_w1 wenb x_i09_w1 vdd sky130_fd_pr__pfet_01v8 L=0.15 W=1 nf=1 ad=0.29 as=0.29 pd=2.58 ps=2.58 nrd=0.29 nrs=0.29 sa=0 sb=0 sd=0 mult=1 m=1
XMND2_i09_w1 wbl_i09_w1 wen y_i09_w1 0 sky130_fd_pr__nfet_01v8 L=0.15 W=0.5 nf=1 ad=0.145 as=0.145 pd=1.58 ps=1.58 nrd=0.58 nrs=0.58 sa=0 sb=0 sd=0 mult=1 m=1
XMND1_i09_w1 y_i09_w1 dinb1 0 0 sky130_fd_pr__nfet_01v8 L=0.15 W=0.5 nf=1 ad=0.145 as=0.145 pd=1.58 ps=1.58 nrd=0.58 nrs=0.58 sa=0 sb=0 sd=0 mult=1 m=1
XMNI_i09_w1 wbl_i09_w1 wenb 0 0 sky130_fd_pr__nfet_01v8 L=0.15 W=0.42 nf=1 ad=0.1218 as=0.1218 pd=1.42 ps=1.42 nrd=0.69047619047619 nrs=0.69047619047619 sa=0 sb=0 sd=0 mult=1 m=1
XMNS_i09_w1 sbl_i09_w1 sel_69500 rbl_i09_w1 0 sky130_fd_pr__nfet_01v8 L=0.15 W=0.42 nf=1 ad=0.1218 as=0.1218 pd=1.42 ps=1.42 nrd=0.69047619047619 nrs=0.69047619047619 sa=0 sb=0 sd=0 mult=1 m=1
XMNSR_i09_w1 sref_i09_w1 sel_69500 ref_i09_w1 0 sky130_fd_pr__nfet_01v8 L=0.15 W=0.42 nf=1 ad=0.1218 as=0.1218 pd=1.42 ps=1.42 nrd=0.69047619047619 nrs=0.69047619047619 sa=0 sb=0 sd=0 mult=1 m=1
XMN1_i09_w1 sbl_i09_w1 sref_i09_w1 vn_i09_w1 0 sky130_fd_pr__nfet_01v8 L=0.15 W=1 nf=1 ad=0.29 as=0.29 pd=2.58 ps=2.58 nrd=0.29 nrs=0.29 sa=0 sb=0 sd=0 mult=1 m=1
XMN2_i09_w1 sref_i09_w1 sbl_i09_w1 vn_i09_w1 0 sky130_fd_pr__nfet_01v8 L=0.15 W=1 nf=1 ad=0.29 as=0.29 pd=2.58 ps=2.58 nrd=0.29 nrs=0.29 sa=0 sb=0 sd=0 mult=1 m=1
XMP1_i09_w1 sbl_i09_w1 sref_i09_w1 vp_i09_w1 vdd sky130_fd_pr__pfet_01v8 L=0.15 W=2 nf=1 ad=0.58 as=0.58 pd=4.58 ps=4.58 nrd=0.145 nrs=0.145 sa=0 sb=0 sd=0 mult=1 m=1
XMP2_i09_w1 sref_i09_w1 sbl_i09_w1 vp_i09_w1 vdd sky130_fd_pr__pfet_01v8 L=0.15 W=2 nf=1 ad=0.58 as=0.58 pd=4.58 ps=4.58 nrd=0.145 nrs=0.145 sa=0 sb=0 sd=0 mult=1 m=1
XMNF_i09_w1 vn_i09_w1 en 0 0 sky130_fd_pr__nfet_01v8 L=0.15 W=2 nf=1 ad=0.58 as=0.58 pd=4.58 ps=4.58 nrd=0.145 nrs=0.145 sa=0 sb=0 sd=0 mult=1 m=1
XMPH_i09_w1 vp_i09_w1 enb vdd vdd sky130_fd_pr__pfet_01v8 L=0.15 W=4 nf=1 ad=1.16 as=1.16 pd=8.58 ps=8.58 nrd=0.0725 nrs=0.0725 sa=0 sb=0 sd=0 mult=1 m=1
bd_i09_w1 d_i09_w1 0 v=v(sbl_i09_w1)-v(sref_i09_w1)
bdabs_i09_w1 dabs_i09_w1 0 v=abs(v(sbl_i09_w1)-v(sref_i09_w1))

* ---- instance 21: i09_w0 (nfet only 0.42) ----
XMWR_i09_w0_0 sn_i09_w0_0 wl wbl_i09_w0 0 sky130_fd_pr__nfet_01v8 L=0.15 W=0.42 nf=1 ad=0.1218 as=0.1218 pd=1.42 ps=1.42 nrd=0.69047619047619 nrs=0.69047619047619 sa=0 sb=0 sd=0 mult=1 m=1
XMRD_i09_w0_0 rbl_i09_w0 sn_i09_w0_0 rwl_sel 0 sky130_fd_pr__nfet_01v8 L=0.15 W=0.42 nf=1 ad=0.1218 as=0.1218 pd=1.42 ps=1.42 nrd=0.69047619047619 nrs=0.69047619047619 sa=0 sb=0 sd=0 mult=1 m=1
csn_i09_w0_0 sn_i09_w0_0 0 {C_SN}
XMWR_i09_w0_1 sn_i09_w0_1 0 wbl_i09_w0 0 sky130_fd_pr__nfet_01v8 L=0.15 W=0.42 nf=1 ad=0.1218 as=0.1218 pd=1.42 ps=1.42 nrd=0.69047619047619 nrs=0.69047619047619 sa=0 sb=0 sd=0 mult=1 m=1
XMRD_i09_w0_1 rbl_i09_w0 sn_i09_w0_1 rwl_des 0 sky130_fd_pr__nfet_01v8 L=0.15 W=0.42 nf=1 ad=0.1218 as=0.1218 pd=1.42 ps=1.42 nrd=0.69047619047619 nrs=0.69047619047619 sa=0 sb=0 sd=0 mult=1 m=1
csn_i09_w0_1 sn_i09_w0_1 0 {C_SN}
XMWR_i09_w0_2 sn_i09_w0_2 0 wbl_i09_w0 0 sky130_fd_pr__nfet_01v8 L=0.15 W=0.42 nf=1 ad=0.1218 as=0.1218 pd=1.42 ps=1.42 nrd=0.69047619047619 nrs=0.69047619047619 sa=0 sb=0 sd=0 mult=1 m=1
XMRD_i09_w0_2 rbl_i09_w0 sn_i09_w0_2 rwl_des 0 sky130_fd_pr__nfet_01v8 L=0.15 W=0.42 nf=1 ad=0.1218 as=0.1218 pd=1.42 ps=1.42 nrd=0.69047619047619 nrs=0.69047619047619 sa=0 sb=0 sd=0 mult=1 m=1
csn_i09_w0_2 sn_i09_w0_2 0 {C_SN}
XMWR_i09_w0_3 sn_i09_w0_3 0 wbl_i09_w0 0 sky130_fd_pr__nfet_01v8 L=0.15 W=0.42 nf=1 ad=0.1218 as=0.1218 pd=1.42 ps=1.42 nrd=0.69047619047619 nrs=0.69047619047619 sa=0 sb=0 sd=0 mult=1 m=1
XMRD_i09_w0_3 rbl_i09_w0 sn_i09_w0_3 rwl_des 0 sky130_fd_pr__nfet_01v8 L=0.15 W=0.42 nf=1 ad=0.1218 as=0.1218 pd=1.42 ps=1.42 nrd=0.69047619047619 nrs=0.69047619047619 sa=0 sb=0 sd=0 mult=1 m=1
csn_i09_w0_3 sn_i09_w0_3 0 {C_SN}
crbl_i09_w0 rbl_i09_w0 0 {C_RBL}
cwbl_i09_w0 wbl_i09_w0 0 {C_WBL}
cref_i09_w0 ref_i09_w0 0 {C_RBL}   $ ASSUMPTION: ideal matched dummy load
spr_i09_w0 pref ref_i09_w0 pca 0 swpre   $ reference-side precharge: ideal switch (#114 convention)
XMPPRE_i09_w0 rbl_i09_w0 pcb_100 prea prea sky130_fd_pr__pfet_01v8 L=0.15 W=4 nf=1 ad=1.16 as=1.16 pd=8.58 ps=8.58 nrd=0.0725 nrs=0.0725 sa=0 sb=0 sd=0 mult=1 m=1
XMPU1_i09_w0 x_i09_w0 dinb0 vdd vdd sky130_fd_pr__pfet_01v8 L=0.15 W=1 nf=1 ad=0.29 as=0.29 pd=2.58 ps=2.58 nrd=0.29 nrs=0.29 sa=0 sb=0 sd=0 mult=1 m=1
XMPU2_i09_w0 wbl_i09_w0 wenb x_i09_w0 vdd sky130_fd_pr__pfet_01v8 L=0.15 W=1 nf=1 ad=0.29 as=0.29 pd=2.58 ps=2.58 nrd=0.29 nrs=0.29 sa=0 sb=0 sd=0 mult=1 m=1
XMND2_i09_w0 wbl_i09_w0 wen y_i09_w0 0 sky130_fd_pr__nfet_01v8 L=0.15 W=0.5 nf=1 ad=0.145 as=0.145 pd=1.58 ps=1.58 nrd=0.58 nrs=0.58 sa=0 sb=0 sd=0 mult=1 m=1
XMND1_i09_w0 y_i09_w0 dinb0 0 0 sky130_fd_pr__nfet_01v8 L=0.15 W=0.5 nf=1 ad=0.145 as=0.145 pd=1.58 ps=1.58 nrd=0.58 nrs=0.58 sa=0 sb=0 sd=0 mult=1 m=1
XMNI_i09_w0 wbl_i09_w0 wenb 0 0 sky130_fd_pr__nfet_01v8 L=0.15 W=0.42 nf=1 ad=0.1218 as=0.1218 pd=1.42 ps=1.42 nrd=0.69047619047619 nrs=0.69047619047619 sa=0 sb=0 sd=0 mult=1 m=1
XMNS_i09_w0 sbl_i09_w0 sel_69500 rbl_i09_w0 0 sky130_fd_pr__nfet_01v8 L=0.15 W=0.42 nf=1 ad=0.1218 as=0.1218 pd=1.42 ps=1.42 nrd=0.69047619047619 nrs=0.69047619047619 sa=0 sb=0 sd=0 mult=1 m=1
XMNSR_i09_w0 sref_i09_w0 sel_69500 ref_i09_w0 0 sky130_fd_pr__nfet_01v8 L=0.15 W=0.42 nf=1 ad=0.1218 as=0.1218 pd=1.42 ps=1.42 nrd=0.69047619047619 nrs=0.69047619047619 sa=0 sb=0 sd=0 mult=1 m=1
XMN1_i09_w0 sbl_i09_w0 sref_i09_w0 vn_i09_w0 0 sky130_fd_pr__nfet_01v8 L=0.15 W=1 nf=1 ad=0.29 as=0.29 pd=2.58 ps=2.58 nrd=0.29 nrs=0.29 sa=0 sb=0 sd=0 mult=1 m=1
XMN2_i09_w0 sref_i09_w0 sbl_i09_w0 vn_i09_w0 0 sky130_fd_pr__nfet_01v8 L=0.15 W=1 nf=1 ad=0.29 as=0.29 pd=2.58 ps=2.58 nrd=0.29 nrs=0.29 sa=0 sb=0 sd=0 mult=1 m=1
XMP1_i09_w0 sbl_i09_w0 sref_i09_w0 vp_i09_w0 vdd sky130_fd_pr__pfet_01v8 L=0.15 W=2 nf=1 ad=0.58 as=0.58 pd=4.58 ps=4.58 nrd=0.145 nrs=0.145 sa=0 sb=0 sd=0 mult=1 m=1
XMP2_i09_w0 sref_i09_w0 sbl_i09_w0 vp_i09_w0 vdd sky130_fd_pr__pfet_01v8 L=0.15 W=2 nf=1 ad=0.58 as=0.58 pd=4.58 ps=4.58 nrd=0.145 nrs=0.145 sa=0 sb=0 sd=0 mult=1 m=1
XMNF_i09_w0 vn_i09_w0 en 0 0 sky130_fd_pr__nfet_01v8 L=0.15 W=2 nf=1 ad=0.58 as=0.58 pd=4.58 ps=4.58 nrd=0.145 nrs=0.145 sa=0 sb=0 sd=0 mult=1 m=1
XMPH_i09_w0 vp_i09_w0 enb vdd vdd sky130_fd_pr__pfet_01v8 L=0.15 W=4 nf=1 ad=1.16 as=1.16 pd=8.58 ps=8.58 nrd=0.0725 nrs=0.0725 sa=0 sb=0 sd=0 mult=1 m=1
bd_i09_w0 d_i09_w0 0 v=v(sbl_i09_w0)-v(sref_i09_w0)
bdabs_i09_w0 dabs_i09_w0 0 v=abs(v(sbl_i09_w0)-v(sref_i09_w0))

* ---- instance 22: i10_w1 (pfet only 1.0) ----
XMWR_i10_w1_0 sn_i10_w1_0 wl wbl_i10_w1 0 sky130_fd_pr__nfet_01v8 L=0.15 W=0.42 nf=1 ad=0.1218 as=0.1218 pd=1.42 ps=1.42 nrd=0.69047619047619 nrs=0.69047619047619 sa=0 sb=0 sd=0 mult=1 m=1
XMRD_i10_w1_0 rbl_i10_w1 sn_i10_w1_0 rwl_sel 0 sky130_fd_pr__nfet_01v8 L=0.15 W=0.42 nf=1 ad=0.1218 as=0.1218 pd=1.42 ps=1.42 nrd=0.69047619047619 nrs=0.69047619047619 sa=0 sb=0 sd=0 mult=1 m=1
csn_i10_w1_0 sn_i10_w1_0 0 {C_SN}
XMWR_i10_w1_1 sn_i10_w1_1 0 wbl_i10_w1 0 sky130_fd_pr__nfet_01v8 L=0.15 W=0.42 nf=1 ad=0.1218 as=0.1218 pd=1.42 ps=1.42 nrd=0.69047619047619 nrs=0.69047619047619 sa=0 sb=0 sd=0 mult=1 m=1
XMRD_i10_w1_1 rbl_i10_w1 sn_i10_w1_1 rwl_des 0 sky130_fd_pr__nfet_01v8 L=0.15 W=0.42 nf=1 ad=0.1218 as=0.1218 pd=1.42 ps=1.42 nrd=0.69047619047619 nrs=0.69047619047619 sa=0 sb=0 sd=0 mult=1 m=1
csn_i10_w1_1 sn_i10_w1_1 0 {C_SN}
XMWR_i10_w1_2 sn_i10_w1_2 0 wbl_i10_w1 0 sky130_fd_pr__nfet_01v8 L=0.15 W=0.42 nf=1 ad=0.1218 as=0.1218 pd=1.42 ps=1.42 nrd=0.69047619047619 nrs=0.69047619047619 sa=0 sb=0 sd=0 mult=1 m=1
XMRD_i10_w1_2 rbl_i10_w1 sn_i10_w1_2 rwl_des 0 sky130_fd_pr__nfet_01v8 L=0.15 W=0.42 nf=1 ad=0.1218 as=0.1218 pd=1.42 ps=1.42 nrd=0.69047619047619 nrs=0.69047619047619 sa=0 sb=0 sd=0 mult=1 m=1
csn_i10_w1_2 sn_i10_w1_2 0 {C_SN}
XMWR_i10_w1_3 sn_i10_w1_3 0 wbl_i10_w1 0 sky130_fd_pr__nfet_01v8 L=0.15 W=0.42 nf=1 ad=0.1218 as=0.1218 pd=1.42 ps=1.42 nrd=0.69047619047619 nrs=0.69047619047619 sa=0 sb=0 sd=0 mult=1 m=1
XMRD_i10_w1_3 rbl_i10_w1 sn_i10_w1_3 rwl_des 0 sky130_fd_pr__nfet_01v8 L=0.15 W=0.42 nf=1 ad=0.1218 as=0.1218 pd=1.42 ps=1.42 nrd=0.69047619047619 nrs=0.69047619047619 sa=0 sb=0 sd=0 mult=1 m=1
csn_i10_w1_3 sn_i10_w1_3 0 {C_SN}
crbl_i10_w1 rbl_i10_w1 0 {C_RBL}
cwbl_i10_w1 wbl_i10_w1 0 {C_WBL}
cref_i10_w1 ref_i10_w1 0 {C_RBL}   $ ASSUMPTION: ideal matched dummy load
spr_i10_w1 pref ref_i10_w1 pca 0 swpre   $ reference-side precharge: ideal switch (#114 convention)
XMPPRE_i10_w1 rbl_i10_w1 pcb_100 prea prea sky130_fd_pr__pfet_01v8 L=0.15 W=4 nf=1 ad=1.16 as=1.16 pd=8.58 ps=8.58 nrd=0.0725 nrs=0.0725 sa=0 sb=0 sd=0 mult=1 m=1
XMPU1_i10_w1 x_i10_w1 dinb1 vdd vdd sky130_fd_pr__pfet_01v8 L=0.15 W=1 nf=1 ad=0.29 as=0.29 pd=2.58 ps=2.58 nrd=0.29 nrs=0.29 sa=0 sb=0 sd=0 mult=1 m=1
XMPU2_i10_w1 wbl_i10_w1 wenb x_i10_w1 vdd sky130_fd_pr__pfet_01v8 L=0.15 W=1 nf=1 ad=0.29 as=0.29 pd=2.58 ps=2.58 nrd=0.29 nrs=0.29 sa=0 sb=0 sd=0 mult=1 m=1
XMND2_i10_w1 wbl_i10_w1 wen y_i10_w1 0 sky130_fd_pr__nfet_01v8 L=0.15 W=0.5 nf=1 ad=0.145 as=0.145 pd=1.58 ps=1.58 nrd=0.58 nrs=0.58 sa=0 sb=0 sd=0 mult=1 m=1
XMND1_i10_w1 y_i10_w1 dinb1 0 0 sky130_fd_pr__nfet_01v8 L=0.15 W=0.5 nf=1 ad=0.145 as=0.145 pd=1.58 ps=1.58 nrd=0.58 nrs=0.58 sa=0 sb=0 sd=0 mult=1 m=1
XMNI_i10_w1 wbl_i10_w1 wenb 0 0 sky130_fd_pr__nfet_01v8 L=0.15 W=0.42 nf=1 ad=0.1218 as=0.1218 pd=1.42 ps=1.42 nrd=0.69047619047619 nrs=0.69047619047619 sa=0 sb=0 sd=0 mult=1 m=1
XMPS_i10_w1 sbl_i10_w1 selb_69500 rbl_i10_w1 vdd sky130_fd_pr__pfet_01v8 L=0.15 W=1 nf=1 ad=0.29 as=0.29 pd=2.58 ps=2.58 nrd=0.29 nrs=0.29 sa=0 sb=0 sd=0 mult=1 m=1
XMPSR_i10_w1 sref_i10_w1 selb_69500 ref_i10_w1 vdd sky130_fd_pr__pfet_01v8 L=0.15 W=1 nf=1 ad=0.29 as=0.29 pd=2.58 ps=2.58 nrd=0.29 nrs=0.29 sa=0 sb=0 sd=0 mult=1 m=1
XMN1_i10_w1 sbl_i10_w1 sref_i10_w1 vn_i10_w1 0 sky130_fd_pr__nfet_01v8 L=0.15 W=1 nf=1 ad=0.29 as=0.29 pd=2.58 ps=2.58 nrd=0.29 nrs=0.29 sa=0 sb=0 sd=0 mult=1 m=1
XMN2_i10_w1 sref_i10_w1 sbl_i10_w1 vn_i10_w1 0 sky130_fd_pr__nfet_01v8 L=0.15 W=1 nf=1 ad=0.29 as=0.29 pd=2.58 ps=2.58 nrd=0.29 nrs=0.29 sa=0 sb=0 sd=0 mult=1 m=1
XMP1_i10_w1 sbl_i10_w1 sref_i10_w1 vp_i10_w1 vdd sky130_fd_pr__pfet_01v8 L=0.15 W=2 nf=1 ad=0.58 as=0.58 pd=4.58 ps=4.58 nrd=0.145 nrs=0.145 sa=0 sb=0 sd=0 mult=1 m=1
XMP2_i10_w1 sref_i10_w1 sbl_i10_w1 vp_i10_w1 vdd sky130_fd_pr__pfet_01v8 L=0.15 W=2 nf=1 ad=0.58 as=0.58 pd=4.58 ps=4.58 nrd=0.145 nrs=0.145 sa=0 sb=0 sd=0 mult=1 m=1
XMNF_i10_w1 vn_i10_w1 en 0 0 sky130_fd_pr__nfet_01v8 L=0.15 W=2 nf=1 ad=0.58 as=0.58 pd=4.58 ps=4.58 nrd=0.145 nrs=0.145 sa=0 sb=0 sd=0 mult=1 m=1
XMPH_i10_w1 vp_i10_w1 enb vdd vdd sky130_fd_pr__pfet_01v8 L=0.15 W=4 nf=1 ad=1.16 as=1.16 pd=8.58 ps=8.58 nrd=0.0725 nrs=0.0725 sa=0 sb=0 sd=0 mult=1 m=1
bd_i10_w1 d_i10_w1 0 v=v(sbl_i10_w1)-v(sref_i10_w1)
bdabs_i10_w1 dabs_i10_w1 0 v=abs(v(sbl_i10_w1)-v(sref_i10_w1))

* ---- instance 23: i10_w0 (pfet only 1.0) ----
XMWR_i10_w0_0 sn_i10_w0_0 wl wbl_i10_w0 0 sky130_fd_pr__nfet_01v8 L=0.15 W=0.42 nf=1 ad=0.1218 as=0.1218 pd=1.42 ps=1.42 nrd=0.69047619047619 nrs=0.69047619047619 sa=0 sb=0 sd=0 mult=1 m=1
XMRD_i10_w0_0 rbl_i10_w0 sn_i10_w0_0 rwl_sel 0 sky130_fd_pr__nfet_01v8 L=0.15 W=0.42 nf=1 ad=0.1218 as=0.1218 pd=1.42 ps=1.42 nrd=0.69047619047619 nrs=0.69047619047619 sa=0 sb=0 sd=0 mult=1 m=1
csn_i10_w0_0 sn_i10_w0_0 0 {C_SN}
XMWR_i10_w0_1 sn_i10_w0_1 0 wbl_i10_w0 0 sky130_fd_pr__nfet_01v8 L=0.15 W=0.42 nf=1 ad=0.1218 as=0.1218 pd=1.42 ps=1.42 nrd=0.69047619047619 nrs=0.69047619047619 sa=0 sb=0 sd=0 mult=1 m=1
XMRD_i10_w0_1 rbl_i10_w0 sn_i10_w0_1 rwl_des 0 sky130_fd_pr__nfet_01v8 L=0.15 W=0.42 nf=1 ad=0.1218 as=0.1218 pd=1.42 ps=1.42 nrd=0.69047619047619 nrs=0.69047619047619 sa=0 sb=0 sd=0 mult=1 m=1
csn_i10_w0_1 sn_i10_w0_1 0 {C_SN}
XMWR_i10_w0_2 sn_i10_w0_2 0 wbl_i10_w0 0 sky130_fd_pr__nfet_01v8 L=0.15 W=0.42 nf=1 ad=0.1218 as=0.1218 pd=1.42 ps=1.42 nrd=0.69047619047619 nrs=0.69047619047619 sa=0 sb=0 sd=0 mult=1 m=1
XMRD_i10_w0_2 rbl_i10_w0 sn_i10_w0_2 rwl_des 0 sky130_fd_pr__nfet_01v8 L=0.15 W=0.42 nf=1 ad=0.1218 as=0.1218 pd=1.42 ps=1.42 nrd=0.69047619047619 nrs=0.69047619047619 sa=0 sb=0 sd=0 mult=1 m=1
csn_i10_w0_2 sn_i10_w0_2 0 {C_SN}
XMWR_i10_w0_3 sn_i10_w0_3 0 wbl_i10_w0 0 sky130_fd_pr__nfet_01v8 L=0.15 W=0.42 nf=1 ad=0.1218 as=0.1218 pd=1.42 ps=1.42 nrd=0.69047619047619 nrs=0.69047619047619 sa=0 sb=0 sd=0 mult=1 m=1
XMRD_i10_w0_3 rbl_i10_w0 sn_i10_w0_3 rwl_des 0 sky130_fd_pr__nfet_01v8 L=0.15 W=0.42 nf=1 ad=0.1218 as=0.1218 pd=1.42 ps=1.42 nrd=0.69047619047619 nrs=0.69047619047619 sa=0 sb=0 sd=0 mult=1 m=1
csn_i10_w0_3 sn_i10_w0_3 0 {C_SN}
crbl_i10_w0 rbl_i10_w0 0 {C_RBL}
cwbl_i10_w0 wbl_i10_w0 0 {C_WBL}
cref_i10_w0 ref_i10_w0 0 {C_RBL}   $ ASSUMPTION: ideal matched dummy load
spr_i10_w0 pref ref_i10_w0 pca 0 swpre   $ reference-side precharge: ideal switch (#114 convention)
XMPPRE_i10_w0 rbl_i10_w0 pcb_100 prea prea sky130_fd_pr__pfet_01v8 L=0.15 W=4 nf=1 ad=1.16 as=1.16 pd=8.58 ps=8.58 nrd=0.0725 nrs=0.0725 sa=0 sb=0 sd=0 mult=1 m=1
XMPU1_i10_w0 x_i10_w0 dinb0 vdd vdd sky130_fd_pr__pfet_01v8 L=0.15 W=1 nf=1 ad=0.29 as=0.29 pd=2.58 ps=2.58 nrd=0.29 nrs=0.29 sa=0 sb=0 sd=0 mult=1 m=1
XMPU2_i10_w0 wbl_i10_w0 wenb x_i10_w0 vdd sky130_fd_pr__pfet_01v8 L=0.15 W=1 nf=1 ad=0.29 as=0.29 pd=2.58 ps=2.58 nrd=0.29 nrs=0.29 sa=0 sb=0 sd=0 mult=1 m=1
XMND2_i10_w0 wbl_i10_w0 wen y_i10_w0 0 sky130_fd_pr__nfet_01v8 L=0.15 W=0.5 nf=1 ad=0.145 as=0.145 pd=1.58 ps=1.58 nrd=0.58 nrs=0.58 sa=0 sb=0 sd=0 mult=1 m=1
XMND1_i10_w0 y_i10_w0 dinb0 0 0 sky130_fd_pr__nfet_01v8 L=0.15 W=0.5 nf=1 ad=0.145 as=0.145 pd=1.58 ps=1.58 nrd=0.58 nrs=0.58 sa=0 sb=0 sd=0 mult=1 m=1
XMNI_i10_w0 wbl_i10_w0 wenb 0 0 sky130_fd_pr__nfet_01v8 L=0.15 W=0.42 nf=1 ad=0.1218 as=0.1218 pd=1.42 ps=1.42 nrd=0.69047619047619 nrs=0.69047619047619 sa=0 sb=0 sd=0 mult=1 m=1
XMPS_i10_w0 sbl_i10_w0 selb_69500 rbl_i10_w0 vdd sky130_fd_pr__pfet_01v8 L=0.15 W=1 nf=1 ad=0.29 as=0.29 pd=2.58 ps=2.58 nrd=0.29 nrs=0.29 sa=0 sb=0 sd=0 mult=1 m=1
XMPSR_i10_w0 sref_i10_w0 selb_69500 ref_i10_w0 vdd sky130_fd_pr__pfet_01v8 L=0.15 W=1 nf=1 ad=0.29 as=0.29 pd=2.58 ps=2.58 nrd=0.29 nrs=0.29 sa=0 sb=0 sd=0 mult=1 m=1
XMN1_i10_w0 sbl_i10_w0 sref_i10_w0 vn_i10_w0 0 sky130_fd_pr__nfet_01v8 L=0.15 W=1 nf=1 ad=0.29 as=0.29 pd=2.58 ps=2.58 nrd=0.29 nrs=0.29 sa=0 sb=0 sd=0 mult=1 m=1
XMN2_i10_w0 sref_i10_w0 sbl_i10_w0 vn_i10_w0 0 sky130_fd_pr__nfet_01v8 L=0.15 W=1 nf=1 ad=0.29 as=0.29 pd=2.58 ps=2.58 nrd=0.29 nrs=0.29 sa=0 sb=0 sd=0 mult=1 m=1
XMP1_i10_w0 sbl_i10_w0 sref_i10_w0 vp_i10_w0 vdd sky130_fd_pr__pfet_01v8 L=0.15 W=2 nf=1 ad=0.58 as=0.58 pd=4.58 ps=4.58 nrd=0.145 nrs=0.145 sa=0 sb=0 sd=0 mult=1 m=1
XMP2_i10_w0 sref_i10_w0 sbl_i10_w0 vp_i10_w0 vdd sky130_fd_pr__pfet_01v8 L=0.15 W=2 nf=1 ad=0.58 as=0.58 pd=4.58 ps=4.58 nrd=0.145 nrs=0.145 sa=0 sb=0 sd=0 mult=1 m=1
XMNF_i10_w0 vn_i10_w0 en 0 0 sky130_fd_pr__nfet_01v8 L=0.15 W=2 nf=1 ad=0.58 as=0.58 pd=4.58 ps=4.58 nrd=0.145 nrs=0.145 sa=0 sb=0 sd=0 mult=1 m=1
XMPH_i10_w0 vp_i10_w0 enb vdd vdd sky130_fd_pr__pfet_01v8 L=0.15 W=4 nf=1 ad=1.16 as=1.16 pd=8.58 ps=8.58 nrd=0.0725 nrs=0.0725 sa=0 sb=0 sd=0 mult=1 m=1
bd_i10_w0 d_i10_w0 0 v=v(sbl_i10_w0)-v(sref_i10_w0)
bdabs_i10_w0 dabs_i10_w0 0 v=abs(v(sbl_i10_w0)-v(sref_i10_w0))

* ---- instance 24: i11_w1 (pfet only 0.5) ----
XMWR_i11_w1_0 sn_i11_w1_0 wl wbl_i11_w1 0 sky130_fd_pr__nfet_01v8 L=0.15 W=0.42 nf=1 ad=0.1218 as=0.1218 pd=1.42 ps=1.42 nrd=0.69047619047619 nrs=0.69047619047619 sa=0 sb=0 sd=0 mult=1 m=1
XMRD_i11_w1_0 rbl_i11_w1 sn_i11_w1_0 rwl_sel 0 sky130_fd_pr__nfet_01v8 L=0.15 W=0.42 nf=1 ad=0.1218 as=0.1218 pd=1.42 ps=1.42 nrd=0.69047619047619 nrs=0.69047619047619 sa=0 sb=0 sd=0 mult=1 m=1
csn_i11_w1_0 sn_i11_w1_0 0 {C_SN}
XMWR_i11_w1_1 sn_i11_w1_1 0 wbl_i11_w1 0 sky130_fd_pr__nfet_01v8 L=0.15 W=0.42 nf=1 ad=0.1218 as=0.1218 pd=1.42 ps=1.42 nrd=0.69047619047619 nrs=0.69047619047619 sa=0 sb=0 sd=0 mult=1 m=1
XMRD_i11_w1_1 rbl_i11_w1 sn_i11_w1_1 rwl_des 0 sky130_fd_pr__nfet_01v8 L=0.15 W=0.42 nf=1 ad=0.1218 as=0.1218 pd=1.42 ps=1.42 nrd=0.69047619047619 nrs=0.69047619047619 sa=0 sb=0 sd=0 mult=1 m=1
csn_i11_w1_1 sn_i11_w1_1 0 {C_SN}
XMWR_i11_w1_2 sn_i11_w1_2 0 wbl_i11_w1 0 sky130_fd_pr__nfet_01v8 L=0.15 W=0.42 nf=1 ad=0.1218 as=0.1218 pd=1.42 ps=1.42 nrd=0.69047619047619 nrs=0.69047619047619 sa=0 sb=0 sd=0 mult=1 m=1
XMRD_i11_w1_2 rbl_i11_w1 sn_i11_w1_2 rwl_des 0 sky130_fd_pr__nfet_01v8 L=0.15 W=0.42 nf=1 ad=0.1218 as=0.1218 pd=1.42 ps=1.42 nrd=0.69047619047619 nrs=0.69047619047619 sa=0 sb=0 sd=0 mult=1 m=1
csn_i11_w1_2 sn_i11_w1_2 0 {C_SN}
XMWR_i11_w1_3 sn_i11_w1_3 0 wbl_i11_w1 0 sky130_fd_pr__nfet_01v8 L=0.15 W=0.42 nf=1 ad=0.1218 as=0.1218 pd=1.42 ps=1.42 nrd=0.69047619047619 nrs=0.69047619047619 sa=0 sb=0 sd=0 mult=1 m=1
XMRD_i11_w1_3 rbl_i11_w1 sn_i11_w1_3 rwl_des 0 sky130_fd_pr__nfet_01v8 L=0.15 W=0.42 nf=1 ad=0.1218 as=0.1218 pd=1.42 ps=1.42 nrd=0.69047619047619 nrs=0.69047619047619 sa=0 sb=0 sd=0 mult=1 m=1
csn_i11_w1_3 sn_i11_w1_3 0 {C_SN}
crbl_i11_w1 rbl_i11_w1 0 {C_RBL}
cwbl_i11_w1 wbl_i11_w1 0 {C_WBL}
cref_i11_w1 ref_i11_w1 0 {C_RBL}   $ ASSUMPTION: ideal matched dummy load
spr_i11_w1 pref ref_i11_w1 pca 0 swpre   $ reference-side precharge: ideal switch (#114 convention)
XMPPRE_i11_w1 rbl_i11_w1 pcb_100 prea prea sky130_fd_pr__pfet_01v8 L=0.15 W=4 nf=1 ad=1.16 as=1.16 pd=8.58 ps=8.58 nrd=0.0725 nrs=0.0725 sa=0 sb=0 sd=0 mult=1 m=1
XMPU1_i11_w1 x_i11_w1 dinb1 vdd vdd sky130_fd_pr__pfet_01v8 L=0.15 W=1 nf=1 ad=0.29 as=0.29 pd=2.58 ps=2.58 nrd=0.29 nrs=0.29 sa=0 sb=0 sd=0 mult=1 m=1
XMPU2_i11_w1 wbl_i11_w1 wenb x_i11_w1 vdd sky130_fd_pr__pfet_01v8 L=0.15 W=1 nf=1 ad=0.29 as=0.29 pd=2.58 ps=2.58 nrd=0.29 nrs=0.29 sa=0 sb=0 sd=0 mult=1 m=1
XMND2_i11_w1 wbl_i11_w1 wen y_i11_w1 0 sky130_fd_pr__nfet_01v8 L=0.15 W=0.5 nf=1 ad=0.145 as=0.145 pd=1.58 ps=1.58 nrd=0.58 nrs=0.58 sa=0 sb=0 sd=0 mult=1 m=1
XMND1_i11_w1 y_i11_w1 dinb1 0 0 sky130_fd_pr__nfet_01v8 L=0.15 W=0.5 nf=1 ad=0.145 as=0.145 pd=1.58 ps=1.58 nrd=0.58 nrs=0.58 sa=0 sb=0 sd=0 mult=1 m=1
XMNI_i11_w1 wbl_i11_w1 wenb 0 0 sky130_fd_pr__nfet_01v8 L=0.15 W=0.42 nf=1 ad=0.1218 as=0.1218 pd=1.42 ps=1.42 nrd=0.69047619047619 nrs=0.69047619047619 sa=0 sb=0 sd=0 mult=1 m=1
XMPS_i11_w1 sbl_i11_w1 selb_69500 rbl_i11_w1 vdd sky130_fd_pr__pfet_01v8 L=0.15 W=0.5 nf=1 ad=0.145 as=0.145 pd=1.58 ps=1.58 nrd=0.58 nrs=0.58 sa=0 sb=0 sd=0 mult=1 m=1
XMPSR_i11_w1 sref_i11_w1 selb_69500 ref_i11_w1 vdd sky130_fd_pr__pfet_01v8 L=0.15 W=0.5 nf=1 ad=0.145 as=0.145 pd=1.58 ps=1.58 nrd=0.58 nrs=0.58 sa=0 sb=0 sd=0 mult=1 m=1
XMN1_i11_w1 sbl_i11_w1 sref_i11_w1 vn_i11_w1 0 sky130_fd_pr__nfet_01v8 L=0.15 W=1 nf=1 ad=0.29 as=0.29 pd=2.58 ps=2.58 nrd=0.29 nrs=0.29 sa=0 sb=0 sd=0 mult=1 m=1
XMN2_i11_w1 sref_i11_w1 sbl_i11_w1 vn_i11_w1 0 sky130_fd_pr__nfet_01v8 L=0.15 W=1 nf=1 ad=0.29 as=0.29 pd=2.58 ps=2.58 nrd=0.29 nrs=0.29 sa=0 sb=0 sd=0 mult=1 m=1
XMP1_i11_w1 sbl_i11_w1 sref_i11_w1 vp_i11_w1 vdd sky130_fd_pr__pfet_01v8 L=0.15 W=2 nf=1 ad=0.58 as=0.58 pd=4.58 ps=4.58 nrd=0.145 nrs=0.145 sa=0 sb=0 sd=0 mult=1 m=1
XMP2_i11_w1 sref_i11_w1 sbl_i11_w1 vp_i11_w1 vdd sky130_fd_pr__pfet_01v8 L=0.15 W=2 nf=1 ad=0.58 as=0.58 pd=4.58 ps=4.58 nrd=0.145 nrs=0.145 sa=0 sb=0 sd=0 mult=1 m=1
XMNF_i11_w1 vn_i11_w1 en 0 0 sky130_fd_pr__nfet_01v8 L=0.15 W=2 nf=1 ad=0.58 as=0.58 pd=4.58 ps=4.58 nrd=0.145 nrs=0.145 sa=0 sb=0 sd=0 mult=1 m=1
XMPH_i11_w1 vp_i11_w1 enb vdd vdd sky130_fd_pr__pfet_01v8 L=0.15 W=4 nf=1 ad=1.16 as=1.16 pd=8.58 ps=8.58 nrd=0.0725 nrs=0.0725 sa=0 sb=0 sd=0 mult=1 m=1
bd_i11_w1 d_i11_w1 0 v=v(sbl_i11_w1)-v(sref_i11_w1)
bdabs_i11_w1 dabs_i11_w1 0 v=abs(v(sbl_i11_w1)-v(sref_i11_w1))

* ---- instance 25: i11_w0 (pfet only 0.5) ----
XMWR_i11_w0_0 sn_i11_w0_0 wl wbl_i11_w0 0 sky130_fd_pr__nfet_01v8 L=0.15 W=0.42 nf=1 ad=0.1218 as=0.1218 pd=1.42 ps=1.42 nrd=0.69047619047619 nrs=0.69047619047619 sa=0 sb=0 sd=0 mult=1 m=1
XMRD_i11_w0_0 rbl_i11_w0 sn_i11_w0_0 rwl_sel 0 sky130_fd_pr__nfet_01v8 L=0.15 W=0.42 nf=1 ad=0.1218 as=0.1218 pd=1.42 ps=1.42 nrd=0.69047619047619 nrs=0.69047619047619 sa=0 sb=0 sd=0 mult=1 m=1
csn_i11_w0_0 sn_i11_w0_0 0 {C_SN}
XMWR_i11_w0_1 sn_i11_w0_1 0 wbl_i11_w0 0 sky130_fd_pr__nfet_01v8 L=0.15 W=0.42 nf=1 ad=0.1218 as=0.1218 pd=1.42 ps=1.42 nrd=0.69047619047619 nrs=0.69047619047619 sa=0 sb=0 sd=0 mult=1 m=1
XMRD_i11_w0_1 rbl_i11_w0 sn_i11_w0_1 rwl_des 0 sky130_fd_pr__nfet_01v8 L=0.15 W=0.42 nf=1 ad=0.1218 as=0.1218 pd=1.42 ps=1.42 nrd=0.69047619047619 nrs=0.69047619047619 sa=0 sb=0 sd=0 mult=1 m=1
csn_i11_w0_1 sn_i11_w0_1 0 {C_SN}
XMWR_i11_w0_2 sn_i11_w0_2 0 wbl_i11_w0 0 sky130_fd_pr__nfet_01v8 L=0.15 W=0.42 nf=1 ad=0.1218 as=0.1218 pd=1.42 ps=1.42 nrd=0.69047619047619 nrs=0.69047619047619 sa=0 sb=0 sd=0 mult=1 m=1
XMRD_i11_w0_2 rbl_i11_w0 sn_i11_w0_2 rwl_des 0 sky130_fd_pr__nfet_01v8 L=0.15 W=0.42 nf=1 ad=0.1218 as=0.1218 pd=1.42 ps=1.42 nrd=0.69047619047619 nrs=0.69047619047619 sa=0 sb=0 sd=0 mult=1 m=1
csn_i11_w0_2 sn_i11_w0_2 0 {C_SN}
XMWR_i11_w0_3 sn_i11_w0_3 0 wbl_i11_w0 0 sky130_fd_pr__nfet_01v8 L=0.15 W=0.42 nf=1 ad=0.1218 as=0.1218 pd=1.42 ps=1.42 nrd=0.69047619047619 nrs=0.69047619047619 sa=0 sb=0 sd=0 mult=1 m=1
XMRD_i11_w0_3 rbl_i11_w0 sn_i11_w0_3 rwl_des 0 sky130_fd_pr__nfet_01v8 L=0.15 W=0.42 nf=1 ad=0.1218 as=0.1218 pd=1.42 ps=1.42 nrd=0.69047619047619 nrs=0.69047619047619 sa=0 sb=0 sd=0 mult=1 m=1
csn_i11_w0_3 sn_i11_w0_3 0 {C_SN}
crbl_i11_w0 rbl_i11_w0 0 {C_RBL}
cwbl_i11_w0 wbl_i11_w0 0 {C_WBL}
cref_i11_w0 ref_i11_w0 0 {C_RBL}   $ ASSUMPTION: ideal matched dummy load
spr_i11_w0 pref ref_i11_w0 pca 0 swpre   $ reference-side precharge: ideal switch (#114 convention)
XMPPRE_i11_w0 rbl_i11_w0 pcb_100 prea prea sky130_fd_pr__pfet_01v8 L=0.15 W=4 nf=1 ad=1.16 as=1.16 pd=8.58 ps=8.58 nrd=0.0725 nrs=0.0725 sa=0 sb=0 sd=0 mult=1 m=1
XMPU1_i11_w0 x_i11_w0 dinb0 vdd vdd sky130_fd_pr__pfet_01v8 L=0.15 W=1 nf=1 ad=0.29 as=0.29 pd=2.58 ps=2.58 nrd=0.29 nrs=0.29 sa=0 sb=0 sd=0 mult=1 m=1
XMPU2_i11_w0 wbl_i11_w0 wenb x_i11_w0 vdd sky130_fd_pr__pfet_01v8 L=0.15 W=1 nf=1 ad=0.29 as=0.29 pd=2.58 ps=2.58 nrd=0.29 nrs=0.29 sa=0 sb=0 sd=0 mult=1 m=1
XMND2_i11_w0 wbl_i11_w0 wen y_i11_w0 0 sky130_fd_pr__nfet_01v8 L=0.15 W=0.5 nf=1 ad=0.145 as=0.145 pd=1.58 ps=1.58 nrd=0.58 nrs=0.58 sa=0 sb=0 sd=0 mult=1 m=1
XMND1_i11_w0 y_i11_w0 dinb0 0 0 sky130_fd_pr__nfet_01v8 L=0.15 W=0.5 nf=1 ad=0.145 as=0.145 pd=1.58 ps=1.58 nrd=0.58 nrs=0.58 sa=0 sb=0 sd=0 mult=1 m=1
XMNI_i11_w0 wbl_i11_w0 wenb 0 0 sky130_fd_pr__nfet_01v8 L=0.15 W=0.42 nf=1 ad=0.1218 as=0.1218 pd=1.42 ps=1.42 nrd=0.69047619047619 nrs=0.69047619047619 sa=0 sb=0 sd=0 mult=1 m=1
XMPS_i11_w0 sbl_i11_w0 selb_69500 rbl_i11_w0 vdd sky130_fd_pr__pfet_01v8 L=0.15 W=0.5 nf=1 ad=0.145 as=0.145 pd=1.58 ps=1.58 nrd=0.58 nrs=0.58 sa=0 sb=0 sd=0 mult=1 m=1
XMPSR_i11_w0 sref_i11_w0 selb_69500 ref_i11_w0 vdd sky130_fd_pr__pfet_01v8 L=0.15 W=0.5 nf=1 ad=0.145 as=0.145 pd=1.58 ps=1.58 nrd=0.58 nrs=0.58 sa=0 sb=0 sd=0 mult=1 m=1
XMN1_i11_w0 sbl_i11_w0 sref_i11_w0 vn_i11_w0 0 sky130_fd_pr__nfet_01v8 L=0.15 W=1 nf=1 ad=0.29 as=0.29 pd=2.58 ps=2.58 nrd=0.29 nrs=0.29 sa=0 sb=0 sd=0 mult=1 m=1
XMN2_i11_w0 sref_i11_w0 sbl_i11_w0 vn_i11_w0 0 sky130_fd_pr__nfet_01v8 L=0.15 W=1 nf=1 ad=0.29 as=0.29 pd=2.58 ps=2.58 nrd=0.29 nrs=0.29 sa=0 sb=0 sd=0 mult=1 m=1
XMP1_i11_w0 sbl_i11_w0 sref_i11_w0 vp_i11_w0 vdd sky130_fd_pr__pfet_01v8 L=0.15 W=2 nf=1 ad=0.58 as=0.58 pd=4.58 ps=4.58 nrd=0.145 nrs=0.145 sa=0 sb=0 sd=0 mult=1 m=1
XMP2_i11_w0 sref_i11_w0 sbl_i11_w0 vp_i11_w0 vdd sky130_fd_pr__pfet_01v8 L=0.15 W=2 nf=1 ad=0.58 as=0.58 pd=4.58 ps=4.58 nrd=0.145 nrs=0.145 sa=0 sb=0 sd=0 mult=1 m=1
XMNF_i11_w0 vn_i11_w0 en 0 0 sky130_fd_pr__nfet_01v8 L=0.15 W=2 nf=1 ad=0.58 as=0.58 pd=4.58 ps=4.58 nrd=0.145 nrs=0.145 sa=0 sb=0 sd=0 mult=1 m=1
XMPH_i11_w0 vp_i11_w0 enb vdd vdd sky130_fd_pr__pfet_01v8 L=0.15 W=4 nf=1 ad=1.16 as=1.16 pd=8.58 ps=8.58 nrd=0.0725 nrs=0.0725 sa=0 sb=0 sd=0 mult=1 m=1
bd_i11_w0 d_i11_w0 0 v=v(sbl_i11_w0)-v(sref_i11_w0)
bdabs_i11_w0 dabs_i11_w0 0 v=abs(v(sbl_i11_w0)-v(sref_i11_w0))

* ---- instance 26: i12_w1 (baseline TG, dummy 0.5x) ----
XMWR_i12_w1_0 sn_i12_w1_0 wl wbl_i12_w1 0 sky130_fd_pr__nfet_01v8 L=0.15 W=0.42 nf=1 ad=0.1218 as=0.1218 pd=1.42 ps=1.42 nrd=0.69047619047619 nrs=0.69047619047619 sa=0 sb=0 sd=0 mult=1 m=1
XMRD_i12_w1_0 rbl_i12_w1 sn_i12_w1_0 rwl_sel 0 sky130_fd_pr__nfet_01v8 L=0.15 W=0.42 nf=1 ad=0.1218 as=0.1218 pd=1.42 ps=1.42 nrd=0.69047619047619 nrs=0.69047619047619 sa=0 sb=0 sd=0 mult=1 m=1
csn_i12_w1_0 sn_i12_w1_0 0 {C_SN}
XMWR_i12_w1_1 sn_i12_w1_1 0 wbl_i12_w1 0 sky130_fd_pr__nfet_01v8 L=0.15 W=0.42 nf=1 ad=0.1218 as=0.1218 pd=1.42 ps=1.42 nrd=0.69047619047619 nrs=0.69047619047619 sa=0 sb=0 sd=0 mult=1 m=1
XMRD_i12_w1_1 rbl_i12_w1 sn_i12_w1_1 rwl_des 0 sky130_fd_pr__nfet_01v8 L=0.15 W=0.42 nf=1 ad=0.1218 as=0.1218 pd=1.42 ps=1.42 nrd=0.69047619047619 nrs=0.69047619047619 sa=0 sb=0 sd=0 mult=1 m=1
csn_i12_w1_1 sn_i12_w1_1 0 {C_SN}
XMWR_i12_w1_2 sn_i12_w1_2 0 wbl_i12_w1 0 sky130_fd_pr__nfet_01v8 L=0.15 W=0.42 nf=1 ad=0.1218 as=0.1218 pd=1.42 ps=1.42 nrd=0.69047619047619 nrs=0.69047619047619 sa=0 sb=0 sd=0 mult=1 m=1
XMRD_i12_w1_2 rbl_i12_w1 sn_i12_w1_2 rwl_des 0 sky130_fd_pr__nfet_01v8 L=0.15 W=0.42 nf=1 ad=0.1218 as=0.1218 pd=1.42 ps=1.42 nrd=0.69047619047619 nrs=0.69047619047619 sa=0 sb=0 sd=0 mult=1 m=1
csn_i12_w1_2 sn_i12_w1_2 0 {C_SN}
XMWR_i12_w1_3 sn_i12_w1_3 0 wbl_i12_w1 0 sky130_fd_pr__nfet_01v8 L=0.15 W=0.42 nf=1 ad=0.1218 as=0.1218 pd=1.42 ps=1.42 nrd=0.69047619047619 nrs=0.69047619047619 sa=0 sb=0 sd=0 mult=1 m=1
XMRD_i12_w1_3 rbl_i12_w1 sn_i12_w1_3 rwl_des 0 sky130_fd_pr__nfet_01v8 L=0.15 W=0.42 nf=1 ad=0.1218 as=0.1218 pd=1.42 ps=1.42 nrd=0.69047619047619 nrs=0.69047619047619 sa=0 sb=0 sd=0 mult=1 m=1
csn_i12_w1_3 sn_i12_w1_3 0 {C_SN}
crbl_i12_w1 rbl_i12_w1 0 {C_RBL}
cwbl_i12_w1 wbl_i12_w1 0 {C_WBL}
cref_i12_w1 ref_i12_w1 0 {C_RBL}   $ ASSUMPTION: ideal matched dummy load
spr_i12_w1 pref ref_i12_w1 pca 0 swpre   $ reference-side precharge: ideal switch (#114 convention)
XMPPRE_i12_w1 rbl_i12_w1 pcb_100 prea prea sky130_fd_pr__pfet_01v8 L=0.15 W=4 nf=1 ad=1.16 as=1.16 pd=8.58 ps=8.58 nrd=0.0725 nrs=0.0725 sa=0 sb=0 sd=0 mult=1 m=1
XMPU1_i12_w1 x_i12_w1 dinb1 vdd vdd sky130_fd_pr__pfet_01v8 L=0.15 W=1 nf=1 ad=0.29 as=0.29 pd=2.58 ps=2.58 nrd=0.29 nrs=0.29 sa=0 sb=0 sd=0 mult=1 m=1
XMPU2_i12_w1 wbl_i12_w1 wenb x_i12_w1 vdd sky130_fd_pr__pfet_01v8 L=0.15 W=1 nf=1 ad=0.29 as=0.29 pd=2.58 ps=2.58 nrd=0.29 nrs=0.29 sa=0 sb=0 sd=0 mult=1 m=1
XMND2_i12_w1 wbl_i12_w1 wen y_i12_w1 0 sky130_fd_pr__nfet_01v8 L=0.15 W=0.5 nf=1 ad=0.145 as=0.145 pd=1.58 ps=1.58 nrd=0.58 nrs=0.58 sa=0 sb=0 sd=0 mult=1 m=1
XMND1_i12_w1 y_i12_w1 dinb1 0 0 sky130_fd_pr__nfet_01v8 L=0.15 W=0.5 nf=1 ad=0.145 as=0.145 pd=1.58 ps=1.58 nrd=0.58 nrs=0.58 sa=0 sb=0 sd=0 mult=1 m=1
XMNI_i12_w1 wbl_i12_w1 wenb 0 0 sky130_fd_pr__nfet_01v8 L=0.15 W=0.42 nf=1 ad=0.1218 as=0.1218 pd=1.42 ps=1.42 nrd=0.69047619047619 nrs=0.69047619047619 sa=0 sb=0 sd=0 mult=1 m=1
XMNS_i12_w1 sbl_i12_w1 sel_69500 rbl_i12_w1 0 sky130_fd_pr__nfet_01v8 L=0.15 W=1 nf=1 ad=0.29 as=0.29 pd=2.58 ps=2.58 nrd=0.29 nrs=0.29 sa=0 sb=0 sd=0 mult=1 m=1
XMPS_i12_w1 sbl_i12_w1 selb_69500 rbl_i12_w1 vdd sky130_fd_pr__pfet_01v8 L=0.15 W=2 nf=1 ad=0.58 as=0.58 pd=4.58 ps=4.58 nrd=0.145 nrs=0.145 sa=0 sb=0 sd=0 mult=1 m=1
XMNSR_i12_w1 sref_i12_w1 sel_69500 ref_i12_w1 0 sky130_fd_pr__nfet_01v8 L=0.15 W=0.5 nf=1 ad=0.145 as=0.145 pd=1.58 ps=1.58 nrd=0.58 nrs=0.58 sa=0 sb=0 sd=0 mult=1 m=1
XMPSR_i12_w1 sref_i12_w1 selb_69500 ref_i12_w1 vdd sky130_fd_pr__pfet_01v8 L=0.15 W=1 nf=1 ad=0.29 as=0.29 pd=2.58 ps=2.58 nrd=0.29 nrs=0.29 sa=0 sb=0 sd=0 mult=1 m=1
XMN1_i12_w1 sbl_i12_w1 sref_i12_w1 vn_i12_w1 0 sky130_fd_pr__nfet_01v8 L=0.15 W=1 nf=1 ad=0.29 as=0.29 pd=2.58 ps=2.58 nrd=0.29 nrs=0.29 sa=0 sb=0 sd=0 mult=1 m=1
XMN2_i12_w1 sref_i12_w1 sbl_i12_w1 vn_i12_w1 0 sky130_fd_pr__nfet_01v8 L=0.15 W=1 nf=1 ad=0.29 as=0.29 pd=2.58 ps=2.58 nrd=0.29 nrs=0.29 sa=0 sb=0 sd=0 mult=1 m=1
XMP1_i12_w1 sbl_i12_w1 sref_i12_w1 vp_i12_w1 vdd sky130_fd_pr__pfet_01v8 L=0.15 W=2 nf=1 ad=0.58 as=0.58 pd=4.58 ps=4.58 nrd=0.145 nrs=0.145 sa=0 sb=0 sd=0 mult=1 m=1
XMP2_i12_w1 sref_i12_w1 sbl_i12_w1 vp_i12_w1 vdd sky130_fd_pr__pfet_01v8 L=0.15 W=2 nf=1 ad=0.58 as=0.58 pd=4.58 ps=4.58 nrd=0.145 nrs=0.145 sa=0 sb=0 sd=0 mult=1 m=1
XMNF_i12_w1 vn_i12_w1 en 0 0 sky130_fd_pr__nfet_01v8 L=0.15 W=2 nf=1 ad=0.58 as=0.58 pd=4.58 ps=4.58 nrd=0.145 nrs=0.145 sa=0 sb=0 sd=0 mult=1 m=1
XMPH_i12_w1 vp_i12_w1 enb vdd vdd sky130_fd_pr__pfet_01v8 L=0.15 W=4 nf=1 ad=1.16 as=1.16 pd=8.58 ps=8.58 nrd=0.0725 nrs=0.0725 sa=0 sb=0 sd=0 mult=1 m=1
bd_i12_w1 d_i12_w1 0 v=v(sbl_i12_w1)-v(sref_i12_w1)
bdabs_i12_w1 dabs_i12_w1 0 v=abs(v(sbl_i12_w1)-v(sref_i12_w1))

* ---- instance 27: i12_w0 (baseline TG, dummy 0.5x) ----
XMWR_i12_w0_0 sn_i12_w0_0 wl wbl_i12_w0 0 sky130_fd_pr__nfet_01v8 L=0.15 W=0.42 nf=1 ad=0.1218 as=0.1218 pd=1.42 ps=1.42 nrd=0.69047619047619 nrs=0.69047619047619 sa=0 sb=0 sd=0 mult=1 m=1
XMRD_i12_w0_0 rbl_i12_w0 sn_i12_w0_0 rwl_sel 0 sky130_fd_pr__nfet_01v8 L=0.15 W=0.42 nf=1 ad=0.1218 as=0.1218 pd=1.42 ps=1.42 nrd=0.69047619047619 nrs=0.69047619047619 sa=0 sb=0 sd=0 mult=1 m=1
csn_i12_w0_0 sn_i12_w0_0 0 {C_SN}
XMWR_i12_w0_1 sn_i12_w0_1 0 wbl_i12_w0 0 sky130_fd_pr__nfet_01v8 L=0.15 W=0.42 nf=1 ad=0.1218 as=0.1218 pd=1.42 ps=1.42 nrd=0.69047619047619 nrs=0.69047619047619 sa=0 sb=0 sd=0 mult=1 m=1
XMRD_i12_w0_1 rbl_i12_w0 sn_i12_w0_1 rwl_des 0 sky130_fd_pr__nfet_01v8 L=0.15 W=0.42 nf=1 ad=0.1218 as=0.1218 pd=1.42 ps=1.42 nrd=0.69047619047619 nrs=0.69047619047619 sa=0 sb=0 sd=0 mult=1 m=1
csn_i12_w0_1 sn_i12_w0_1 0 {C_SN}
XMWR_i12_w0_2 sn_i12_w0_2 0 wbl_i12_w0 0 sky130_fd_pr__nfet_01v8 L=0.15 W=0.42 nf=1 ad=0.1218 as=0.1218 pd=1.42 ps=1.42 nrd=0.69047619047619 nrs=0.69047619047619 sa=0 sb=0 sd=0 mult=1 m=1
XMRD_i12_w0_2 rbl_i12_w0 sn_i12_w0_2 rwl_des 0 sky130_fd_pr__nfet_01v8 L=0.15 W=0.42 nf=1 ad=0.1218 as=0.1218 pd=1.42 ps=1.42 nrd=0.69047619047619 nrs=0.69047619047619 sa=0 sb=0 sd=0 mult=1 m=1
csn_i12_w0_2 sn_i12_w0_2 0 {C_SN}
XMWR_i12_w0_3 sn_i12_w0_3 0 wbl_i12_w0 0 sky130_fd_pr__nfet_01v8 L=0.15 W=0.42 nf=1 ad=0.1218 as=0.1218 pd=1.42 ps=1.42 nrd=0.69047619047619 nrs=0.69047619047619 sa=0 sb=0 sd=0 mult=1 m=1
XMRD_i12_w0_3 rbl_i12_w0 sn_i12_w0_3 rwl_des 0 sky130_fd_pr__nfet_01v8 L=0.15 W=0.42 nf=1 ad=0.1218 as=0.1218 pd=1.42 ps=1.42 nrd=0.69047619047619 nrs=0.69047619047619 sa=0 sb=0 sd=0 mult=1 m=1
csn_i12_w0_3 sn_i12_w0_3 0 {C_SN}
crbl_i12_w0 rbl_i12_w0 0 {C_RBL}
cwbl_i12_w0 wbl_i12_w0 0 {C_WBL}
cref_i12_w0 ref_i12_w0 0 {C_RBL}   $ ASSUMPTION: ideal matched dummy load
spr_i12_w0 pref ref_i12_w0 pca 0 swpre   $ reference-side precharge: ideal switch (#114 convention)
XMPPRE_i12_w0 rbl_i12_w0 pcb_100 prea prea sky130_fd_pr__pfet_01v8 L=0.15 W=4 nf=1 ad=1.16 as=1.16 pd=8.58 ps=8.58 nrd=0.0725 nrs=0.0725 sa=0 sb=0 sd=0 mult=1 m=1
XMPU1_i12_w0 x_i12_w0 dinb0 vdd vdd sky130_fd_pr__pfet_01v8 L=0.15 W=1 nf=1 ad=0.29 as=0.29 pd=2.58 ps=2.58 nrd=0.29 nrs=0.29 sa=0 sb=0 sd=0 mult=1 m=1
XMPU2_i12_w0 wbl_i12_w0 wenb x_i12_w0 vdd sky130_fd_pr__pfet_01v8 L=0.15 W=1 nf=1 ad=0.29 as=0.29 pd=2.58 ps=2.58 nrd=0.29 nrs=0.29 sa=0 sb=0 sd=0 mult=1 m=1
XMND2_i12_w0 wbl_i12_w0 wen y_i12_w0 0 sky130_fd_pr__nfet_01v8 L=0.15 W=0.5 nf=1 ad=0.145 as=0.145 pd=1.58 ps=1.58 nrd=0.58 nrs=0.58 sa=0 sb=0 sd=0 mult=1 m=1
XMND1_i12_w0 y_i12_w0 dinb0 0 0 sky130_fd_pr__nfet_01v8 L=0.15 W=0.5 nf=1 ad=0.145 as=0.145 pd=1.58 ps=1.58 nrd=0.58 nrs=0.58 sa=0 sb=0 sd=0 mult=1 m=1
XMNI_i12_w0 wbl_i12_w0 wenb 0 0 sky130_fd_pr__nfet_01v8 L=0.15 W=0.42 nf=1 ad=0.1218 as=0.1218 pd=1.42 ps=1.42 nrd=0.69047619047619 nrs=0.69047619047619 sa=0 sb=0 sd=0 mult=1 m=1
XMNS_i12_w0 sbl_i12_w0 sel_69500 rbl_i12_w0 0 sky130_fd_pr__nfet_01v8 L=0.15 W=1 nf=1 ad=0.29 as=0.29 pd=2.58 ps=2.58 nrd=0.29 nrs=0.29 sa=0 sb=0 sd=0 mult=1 m=1
XMPS_i12_w0 sbl_i12_w0 selb_69500 rbl_i12_w0 vdd sky130_fd_pr__pfet_01v8 L=0.15 W=2 nf=1 ad=0.58 as=0.58 pd=4.58 ps=4.58 nrd=0.145 nrs=0.145 sa=0 sb=0 sd=0 mult=1 m=1
XMNSR_i12_w0 sref_i12_w0 sel_69500 ref_i12_w0 0 sky130_fd_pr__nfet_01v8 L=0.15 W=0.5 nf=1 ad=0.145 as=0.145 pd=1.58 ps=1.58 nrd=0.58 nrs=0.58 sa=0 sb=0 sd=0 mult=1 m=1
XMPSR_i12_w0 sref_i12_w0 selb_69500 ref_i12_w0 vdd sky130_fd_pr__pfet_01v8 L=0.15 W=1 nf=1 ad=0.29 as=0.29 pd=2.58 ps=2.58 nrd=0.29 nrs=0.29 sa=0 sb=0 sd=0 mult=1 m=1
XMN1_i12_w0 sbl_i12_w0 sref_i12_w0 vn_i12_w0 0 sky130_fd_pr__nfet_01v8 L=0.15 W=1 nf=1 ad=0.29 as=0.29 pd=2.58 ps=2.58 nrd=0.29 nrs=0.29 sa=0 sb=0 sd=0 mult=1 m=1
XMN2_i12_w0 sref_i12_w0 sbl_i12_w0 vn_i12_w0 0 sky130_fd_pr__nfet_01v8 L=0.15 W=1 nf=1 ad=0.29 as=0.29 pd=2.58 ps=2.58 nrd=0.29 nrs=0.29 sa=0 sb=0 sd=0 mult=1 m=1
XMP1_i12_w0 sbl_i12_w0 sref_i12_w0 vp_i12_w0 vdd sky130_fd_pr__pfet_01v8 L=0.15 W=2 nf=1 ad=0.58 as=0.58 pd=4.58 ps=4.58 nrd=0.145 nrs=0.145 sa=0 sb=0 sd=0 mult=1 m=1
XMP2_i12_w0 sref_i12_w0 sbl_i12_w0 vp_i12_w0 vdd sky130_fd_pr__pfet_01v8 L=0.15 W=2 nf=1 ad=0.58 as=0.58 pd=4.58 ps=4.58 nrd=0.145 nrs=0.145 sa=0 sb=0 sd=0 mult=1 m=1
XMNF_i12_w0 vn_i12_w0 en 0 0 sky130_fd_pr__nfet_01v8 L=0.15 W=2 nf=1 ad=0.58 as=0.58 pd=4.58 ps=4.58 nrd=0.145 nrs=0.145 sa=0 sb=0 sd=0 mult=1 m=1
XMPH_i12_w0 vp_i12_w0 enb vdd vdd sky130_fd_pr__pfet_01v8 L=0.15 W=4 nf=1 ad=1.16 as=1.16 pd=8.58 ps=8.58 nrd=0.0725 nrs=0.0725 sa=0 sb=0 sd=0 mult=1 m=1
bd_i12_w0 d_i12_w0 0 v=v(sbl_i12_w0)-v(sref_i12_w0)
bdabs_i12_w0 dabs_i12_w0 0 v=abs(v(sbl_i12_w0)-v(sref_i12_w0))

* ---- instance 28: i13_w1 (baseline TG, dummy 0.75x) ----
XMWR_i13_w1_0 sn_i13_w1_0 wl wbl_i13_w1 0 sky130_fd_pr__nfet_01v8 L=0.15 W=0.42 nf=1 ad=0.1218 as=0.1218 pd=1.42 ps=1.42 nrd=0.69047619047619 nrs=0.69047619047619 sa=0 sb=0 sd=0 mult=1 m=1
XMRD_i13_w1_0 rbl_i13_w1 sn_i13_w1_0 rwl_sel 0 sky130_fd_pr__nfet_01v8 L=0.15 W=0.42 nf=1 ad=0.1218 as=0.1218 pd=1.42 ps=1.42 nrd=0.69047619047619 nrs=0.69047619047619 sa=0 sb=0 sd=0 mult=1 m=1
csn_i13_w1_0 sn_i13_w1_0 0 {C_SN}
XMWR_i13_w1_1 sn_i13_w1_1 0 wbl_i13_w1 0 sky130_fd_pr__nfet_01v8 L=0.15 W=0.42 nf=1 ad=0.1218 as=0.1218 pd=1.42 ps=1.42 nrd=0.69047619047619 nrs=0.69047619047619 sa=0 sb=0 sd=0 mult=1 m=1
XMRD_i13_w1_1 rbl_i13_w1 sn_i13_w1_1 rwl_des 0 sky130_fd_pr__nfet_01v8 L=0.15 W=0.42 nf=1 ad=0.1218 as=0.1218 pd=1.42 ps=1.42 nrd=0.69047619047619 nrs=0.69047619047619 sa=0 sb=0 sd=0 mult=1 m=1
csn_i13_w1_1 sn_i13_w1_1 0 {C_SN}
XMWR_i13_w1_2 sn_i13_w1_2 0 wbl_i13_w1 0 sky130_fd_pr__nfet_01v8 L=0.15 W=0.42 nf=1 ad=0.1218 as=0.1218 pd=1.42 ps=1.42 nrd=0.69047619047619 nrs=0.69047619047619 sa=0 sb=0 sd=0 mult=1 m=1
XMRD_i13_w1_2 rbl_i13_w1 sn_i13_w1_2 rwl_des 0 sky130_fd_pr__nfet_01v8 L=0.15 W=0.42 nf=1 ad=0.1218 as=0.1218 pd=1.42 ps=1.42 nrd=0.69047619047619 nrs=0.69047619047619 sa=0 sb=0 sd=0 mult=1 m=1
csn_i13_w1_2 sn_i13_w1_2 0 {C_SN}
XMWR_i13_w1_3 sn_i13_w1_3 0 wbl_i13_w1 0 sky130_fd_pr__nfet_01v8 L=0.15 W=0.42 nf=1 ad=0.1218 as=0.1218 pd=1.42 ps=1.42 nrd=0.69047619047619 nrs=0.69047619047619 sa=0 sb=0 sd=0 mult=1 m=1
XMRD_i13_w1_3 rbl_i13_w1 sn_i13_w1_3 rwl_des 0 sky130_fd_pr__nfet_01v8 L=0.15 W=0.42 nf=1 ad=0.1218 as=0.1218 pd=1.42 ps=1.42 nrd=0.69047619047619 nrs=0.69047619047619 sa=0 sb=0 sd=0 mult=1 m=1
csn_i13_w1_3 sn_i13_w1_3 0 {C_SN}
crbl_i13_w1 rbl_i13_w1 0 {C_RBL}
cwbl_i13_w1 wbl_i13_w1 0 {C_WBL}
cref_i13_w1 ref_i13_w1 0 {C_RBL}   $ ASSUMPTION: ideal matched dummy load
spr_i13_w1 pref ref_i13_w1 pca 0 swpre   $ reference-side precharge: ideal switch (#114 convention)
XMPPRE_i13_w1 rbl_i13_w1 pcb_100 prea prea sky130_fd_pr__pfet_01v8 L=0.15 W=4 nf=1 ad=1.16 as=1.16 pd=8.58 ps=8.58 nrd=0.0725 nrs=0.0725 sa=0 sb=0 sd=0 mult=1 m=1
XMPU1_i13_w1 x_i13_w1 dinb1 vdd vdd sky130_fd_pr__pfet_01v8 L=0.15 W=1 nf=1 ad=0.29 as=0.29 pd=2.58 ps=2.58 nrd=0.29 nrs=0.29 sa=0 sb=0 sd=0 mult=1 m=1
XMPU2_i13_w1 wbl_i13_w1 wenb x_i13_w1 vdd sky130_fd_pr__pfet_01v8 L=0.15 W=1 nf=1 ad=0.29 as=0.29 pd=2.58 ps=2.58 nrd=0.29 nrs=0.29 sa=0 sb=0 sd=0 mult=1 m=1
XMND2_i13_w1 wbl_i13_w1 wen y_i13_w1 0 sky130_fd_pr__nfet_01v8 L=0.15 W=0.5 nf=1 ad=0.145 as=0.145 pd=1.58 ps=1.58 nrd=0.58 nrs=0.58 sa=0 sb=0 sd=0 mult=1 m=1
XMND1_i13_w1 y_i13_w1 dinb1 0 0 sky130_fd_pr__nfet_01v8 L=0.15 W=0.5 nf=1 ad=0.145 as=0.145 pd=1.58 ps=1.58 nrd=0.58 nrs=0.58 sa=0 sb=0 sd=0 mult=1 m=1
XMNI_i13_w1 wbl_i13_w1 wenb 0 0 sky130_fd_pr__nfet_01v8 L=0.15 W=0.42 nf=1 ad=0.1218 as=0.1218 pd=1.42 ps=1.42 nrd=0.69047619047619 nrs=0.69047619047619 sa=0 sb=0 sd=0 mult=1 m=1
XMNS_i13_w1 sbl_i13_w1 sel_69500 rbl_i13_w1 0 sky130_fd_pr__nfet_01v8 L=0.15 W=1 nf=1 ad=0.29 as=0.29 pd=2.58 ps=2.58 nrd=0.29 nrs=0.29 sa=0 sb=0 sd=0 mult=1 m=1
XMPS_i13_w1 sbl_i13_w1 selb_69500 rbl_i13_w1 vdd sky130_fd_pr__pfet_01v8 L=0.15 W=2 nf=1 ad=0.58 as=0.58 pd=4.58 ps=4.58 nrd=0.145 nrs=0.145 sa=0 sb=0 sd=0 mult=1 m=1
XMNSR_i13_w1 sref_i13_w1 sel_69500 ref_i13_w1 0 sky130_fd_pr__nfet_01v8 L=0.15 W=0.75 nf=1 ad=0.2175 as=0.2175 pd=2.08 ps=2.08 nrd=0.38666666666667 nrs=0.38666666666667 sa=0 sb=0 sd=0 mult=1 m=1
XMPSR_i13_w1 sref_i13_w1 selb_69500 ref_i13_w1 vdd sky130_fd_pr__pfet_01v8 L=0.15 W=1.5 nf=1 ad=0.435 as=0.435 pd=3.58 ps=3.58 nrd=0.19333333333333 nrs=0.19333333333333 sa=0 sb=0 sd=0 mult=1 m=1
XMN1_i13_w1 sbl_i13_w1 sref_i13_w1 vn_i13_w1 0 sky130_fd_pr__nfet_01v8 L=0.15 W=1 nf=1 ad=0.29 as=0.29 pd=2.58 ps=2.58 nrd=0.29 nrs=0.29 sa=0 sb=0 sd=0 mult=1 m=1
XMN2_i13_w1 sref_i13_w1 sbl_i13_w1 vn_i13_w1 0 sky130_fd_pr__nfet_01v8 L=0.15 W=1 nf=1 ad=0.29 as=0.29 pd=2.58 ps=2.58 nrd=0.29 nrs=0.29 sa=0 sb=0 sd=0 mult=1 m=1
XMP1_i13_w1 sbl_i13_w1 sref_i13_w1 vp_i13_w1 vdd sky130_fd_pr__pfet_01v8 L=0.15 W=2 nf=1 ad=0.58 as=0.58 pd=4.58 ps=4.58 nrd=0.145 nrs=0.145 sa=0 sb=0 sd=0 mult=1 m=1
XMP2_i13_w1 sref_i13_w1 sbl_i13_w1 vp_i13_w1 vdd sky130_fd_pr__pfet_01v8 L=0.15 W=2 nf=1 ad=0.58 as=0.58 pd=4.58 ps=4.58 nrd=0.145 nrs=0.145 sa=0 sb=0 sd=0 mult=1 m=1
XMNF_i13_w1 vn_i13_w1 en 0 0 sky130_fd_pr__nfet_01v8 L=0.15 W=2 nf=1 ad=0.58 as=0.58 pd=4.58 ps=4.58 nrd=0.145 nrs=0.145 sa=0 sb=0 sd=0 mult=1 m=1
XMPH_i13_w1 vp_i13_w1 enb vdd vdd sky130_fd_pr__pfet_01v8 L=0.15 W=4 nf=1 ad=1.16 as=1.16 pd=8.58 ps=8.58 nrd=0.0725 nrs=0.0725 sa=0 sb=0 sd=0 mult=1 m=1
bd_i13_w1 d_i13_w1 0 v=v(sbl_i13_w1)-v(sref_i13_w1)
bdabs_i13_w1 dabs_i13_w1 0 v=abs(v(sbl_i13_w1)-v(sref_i13_w1))

* ---- instance 29: i13_w0 (baseline TG, dummy 0.75x) ----
XMWR_i13_w0_0 sn_i13_w0_0 wl wbl_i13_w0 0 sky130_fd_pr__nfet_01v8 L=0.15 W=0.42 nf=1 ad=0.1218 as=0.1218 pd=1.42 ps=1.42 nrd=0.69047619047619 nrs=0.69047619047619 sa=0 sb=0 sd=0 mult=1 m=1
XMRD_i13_w0_0 rbl_i13_w0 sn_i13_w0_0 rwl_sel 0 sky130_fd_pr__nfet_01v8 L=0.15 W=0.42 nf=1 ad=0.1218 as=0.1218 pd=1.42 ps=1.42 nrd=0.69047619047619 nrs=0.69047619047619 sa=0 sb=0 sd=0 mult=1 m=1
csn_i13_w0_0 sn_i13_w0_0 0 {C_SN}
XMWR_i13_w0_1 sn_i13_w0_1 0 wbl_i13_w0 0 sky130_fd_pr__nfet_01v8 L=0.15 W=0.42 nf=1 ad=0.1218 as=0.1218 pd=1.42 ps=1.42 nrd=0.69047619047619 nrs=0.69047619047619 sa=0 sb=0 sd=0 mult=1 m=1
XMRD_i13_w0_1 rbl_i13_w0 sn_i13_w0_1 rwl_des 0 sky130_fd_pr__nfet_01v8 L=0.15 W=0.42 nf=1 ad=0.1218 as=0.1218 pd=1.42 ps=1.42 nrd=0.69047619047619 nrs=0.69047619047619 sa=0 sb=0 sd=0 mult=1 m=1
csn_i13_w0_1 sn_i13_w0_1 0 {C_SN}
XMWR_i13_w0_2 sn_i13_w0_2 0 wbl_i13_w0 0 sky130_fd_pr__nfet_01v8 L=0.15 W=0.42 nf=1 ad=0.1218 as=0.1218 pd=1.42 ps=1.42 nrd=0.69047619047619 nrs=0.69047619047619 sa=0 sb=0 sd=0 mult=1 m=1
XMRD_i13_w0_2 rbl_i13_w0 sn_i13_w0_2 rwl_des 0 sky130_fd_pr__nfet_01v8 L=0.15 W=0.42 nf=1 ad=0.1218 as=0.1218 pd=1.42 ps=1.42 nrd=0.69047619047619 nrs=0.69047619047619 sa=0 sb=0 sd=0 mult=1 m=1
csn_i13_w0_2 sn_i13_w0_2 0 {C_SN}
XMWR_i13_w0_3 sn_i13_w0_3 0 wbl_i13_w0 0 sky130_fd_pr__nfet_01v8 L=0.15 W=0.42 nf=1 ad=0.1218 as=0.1218 pd=1.42 ps=1.42 nrd=0.69047619047619 nrs=0.69047619047619 sa=0 sb=0 sd=0 mult=1 m=1
XMRD_i13_w0_3 rbl_i13_w0 sn_i13_w0_3 rwl_des 0 sky130_fd_pr__nfet_01v8 L=0.15 W=0.42 nf=1 ad=0.1218 as=0.1218 pd=1.42 ps=1.42 nrd=0.69047619047619 nrs=0.69047619047619 sa=0 sb=0 sd=0 mult=1 m=1
csn_i13_w0_3 sn_i13_w0_3 0 {C_SN}
crbl_i13_w0 rbl_i13_w0 0 {C_RBL}
cwbl_i13_w0 wbl_i13_w0 0 {C_WBL}
cref_i13_w0 ref_i13_w0 0 {C_RBL}   $ ASSUMPTION: ideal matched dummy load
spr_i13_w0 pref ref_i13_w0 pca 0 swpre   $ reference-side precharge: ideal switch (#114 convention)
XMPPRE_i13_w0 rbl_i13_w0 pcb_100 prea prea sky130_fd_pr__pfet_01v8 L=0.15 W=4 nf=1 ad=1.16 as=1.16 pd=8.58 ps=8.58 nrd=0.0725 nrs=0.0725 sa=0 sb=0 sd=0 mult=1 m=1
XMPU1_i13_w0 x_i13_w0 dinb0 vdd vdd sky130_fd_pr__pfet_01v8 L=0.15 W=1 nf=1 ad=0.29 as=0.29 pd=2.58 ps=2.58 nrd=0.29 nrs=0.29 sa=0 sb=0 sd=0 mult=1 m=1
XMPU2_i13_w0 wbl_i13_w0 wenb x_i13_w0 vdd sky130_fd_pr__pfet_01v8 L=0.15 W=1 nf=1 ad=0.29 as=0.29 pd=2.58 ps=2.58 nrd=0.29 nrs=0.29 sa=0 sb=0 sd=0 mult=1 m=1
XMND2_i13_w0 wbl_i13_w0 wen y_i13_w0 0 sky130_fd_pr__nfet_01v8 L=0.15 W=0.5 nf=1 ad=0.145 as=0.145 pd=1.58 ps=1.58 nrd=0.58 nrs=0.58 sa=0 sb=0 sd=0 mult=1 m=1
XMND1_i13_w0 y_i13_w0 dinb0 0 0 sky130_fd_pr__nfet_01v8 L=0.15 W=0.5 nf=1 ad=0.145 as=0.145 pd=1.58 ps=1.58 nrd=0.58 nrs=0.58 sa=0 sb=0 sd=0 mult=1 m=1
XMNI_i13_w0 wbl_i13_w0 wenb 0 0 sky130_fd_pr__nfet_01v8 L=0.15 W=0.42 nf=1 ad=0.1218 as=0.1218 pd=1.42 ps=1.42 nrd=0.69047619047619 nrs=0.69047619047619 sa=0 sb=0 sd=0 mult=1 m=1
XMNS_i13_w0 sbl_i13_w0 sel_69500 rbl_i13_w0 0 sky130_fd_pr__nfet_01v8 L=0.15 W=1 nf=1 ad=0.29 as=0.29 pd=2.58 ps=2.58 nrd=0.29 nrs=0.29 sa=0 sb=0 sd=0 mult=1 m=1
XMPS_i13_w0 sbl_i13_w0 selb_69500 rbl_i13_w0 vdd sky130_fd_pr__pfet_01v8 L=0.15 W=2 nf=1 ad=0.58 as=0.58 pd=4.58 ps=4.58 nrd=0.145 nrs=0.145 sa=0 sb=0 sd=0 mult=1 m=1
XMNSR_i13_w0 sref_i13_w0 sel_69500 ref_i13_w0 0 sky130_fd_pr__nfet_01v8 L=0.15 W=0.75 nf=1 ad=0.2175 as=0.2175 pd=2.08 ps=2.08 nrd=0.38666666666667 nrs=0.38666666666667 sa=0 sb=0 sd=0 mult=1 m=1
XMPSR_i13_w0 sref_i13_w0 selb_69500 ref_i13_w0 vdd sky130_fd_pr__pfet_01v8 L=0.15 W=1.5 nf=1 ad=0.435 as=0.435 pd=3.58 ps=3.58 nrd=0.19333333333333 nrs=0.19333333333333 sa=0 sb=0 sd=0 mult=1 m=1
XMN1_i13_w0 sbl_i13_w0 sref_i13_w0 vn_i13_w0 0 sky130_fd_pr__nfet_01v8 L=0.15 W=1 nf=1 ad=0.29 as=0.29 pd=2.58 ps=2.58 nrd=0.29 nrs=0.29 sa=0 sb=0 sd=0 mult=1 m=1
XMN2_i13_w0 sref_i13_w0 sbl_i13_w0 vn_i13_w0 0 sky130_fd_pr__nfet_01v8 L=0.15 W=1 nf=1 ad=0.29 as=0.29 pd=2.58 ps=2.58 nrd=0.29 nrs=0.29 sa=0 sb=0 sd=0 mult=1 m=1
XMP1_i13_w0 sbl_i13_w0 sref_i13_w0 vp_i13_w0 vdd sky130_fd_pr__pfet_01v8 L=0.15 W=2 nf=1 ad=0.58 as=0.58 pd=4.58 ps=4.58 nrd=0.145 nrs=0.145 sa=0 sb=0 sd=0 mult=1 m=1
XMP2_i13_w0 sref_i13_w0 sbl_i13_w0 vp_i13_w0 vdd sky130_fd_pr__pfet_01v8 L=0.15 W=2 nf=1 ad=0.58 as=0.58 pd=4.58 ps=4.58 nrd=0.145 nrs=0.145 sa=0 sb=0 sd=0 mult=1 m=1
XMNF_i13_w0 vn_i13_w0 en 0 0 sky130_fd_pr__nfet_01v8 L=0.15 W=2 nf=1 ad=0.58 as=0.58 pd=4.58 ps=4.58 nrd=0.145 nrs=0.145 sa=0 sb=0 sd=0 mult=1 m=1
XMPH_i13_w0 vp_i13_w0 enb vdd vdd sky130_fd_pr__pfet_01v8 L=0.15 W=4 nf=1 ad=1.16 as=1.16 pd=8.58 ps=8.58 nrd=0.0725 nrs=0.0725 sa=0 sb=0 sd=0 mult=1 m=1
bd_i13_w0 d_i13_w0 0 v=v(sbl_i13_w0)-v(sref_i13_w0)
bdabs_i13_w0 dabs_i13_w0 0 v=abs(v(sbl_i13_w0)-v(sref_i13_w0))

* ---- instance 30: i14_w1 (baseline TG, dummy 1.5x) ----
XMWR_i14_w1_0 sn_i14_w1_0 wl wbl_i14_w1 0 sky130_fd_pr__nfet_01v8 L=0.15 W=0.42 nf=1 ad=0.1218 as=0.1218 pd=1.42 ps=1.42 nrd=0.69047619047619 nrs=0.69047619047619 sa=0 sb=0 sd=0 mult=1 m=1
XMRD_i14_w1_0 rbl_i14_w1 sn_i14_w1_0 rwl_sel 0 sky130_fd_pr__nfet_01v8 L=0.15 W=0.42 nf=1 ad=0.1218 as=0.1218 pd=1.42 ps=1.42 nrd=0.69047619047619 nrs=0.69047619047619 sa=0 sb=0 sd=0 mult=1 m=1
csn_i14_w1_0 sn_i14_w1_0 0 {C_SN}
XMWR_i14_w1_1 sn_i14_w1_1 0 wbl_i14_w1 0 sky130_fd_pr__nfet_01v8 L=0.15 W=0.42 nf=1 ad=0.1218 as=0.1218 pd=1.42 ps=1.42 nrd=0.69047619047619 nrs=0.69047619047619 sa=0 sb=0 sd=0 mult=1 m=1
XMRD_i14_w1_1 rbl_i14_w1 sn_i14_w1_1 rwl_des 0 sky130_fd_pr__nfet_01v8 L=0.15 W=0.42 nf=1 ad=0.1218 as=0.1218 pd=1.42 ps=1.42 nrd=0.69047619047619 nrs=0.69047619047619 sa=0 sb=0 sd=0 mult=1 m=1
csn_i14_w1_1 sn_i14_w1_1 0 {C_SN}
XMWR_i14_w1_2 sn_i14_w1_2 0 wbl_i14_w1 0 sky130_fd_pr__nfet_01v8 L=0.15 W=0.42 nf=1 ad=0.1218 as=0.1218 pd=1.42 ps=1.42 nrd=0.69047619047619 nrs=0.69047619047619 sa=0 sb=0 sd=0 mult=1 m=1
XMRD_i14_w1_2 rbl_i14_w1 sn_i14_w1_2 rwl_des 0 sky130_fd_pr__nfet_01v8 L=0.15 W=0.42 nf=1 ad=0.1218 as=0.1218 pd=1.42 ps=1.42 nrd=0.69047619047619 nrs=0.69047619047619 sa=0 sb=0 sd=0 mult=1 m=1
csn_i14_w1_2 sn_i14_w1_2 0 {C_SN}
XMWR_i14_w1_3 sn_i14_w1_3 0 wbl_i14_w1 0 sky130_fd_pr__nfet_01v8 L=0.15 W=0.42 nf=1 ad=0.1218 as=0.1218 pd=1.42 ps=1.42 nrd=0.69047619047619 nrs=0.69047619047619 sa=0 sb=0 sd=0 mult=1 m=1
XMRD_i14_w1_3 rbl_i14_w1 sn_i14_w1_3 rwl_des 0 sky130_fd_pr__nfet_01v8 L=0.15 W=0.42 nf=1 ad=0.1218 as=0.1218 pd=1.42 ps=1.42 nrd=0.69047619047619 nrs=0.69047619047619 sa=0 sb=0 sd=0 mult=1 m=1
csn_i14_w1_3 sn_i14_w1_3 0 {C_SN}
crbl_i14_w1 rbl_i14_w1 0 {C_RBL}
cwbl_i14_w1 wbl_i14_w1 0 {C_WBL}
cref_i14_w1 ref_i14_w1 0 {C_RBL}   $ ASSUMPTION: ideal matched dummy load
spr_i14_w1 pref ref_i14_w1 pca 0 swpre   $ reference-side precharge: ideal switch (#114 convention)
XMPPRE_i14_w1 rbl_i14_w1 pcb_100 prea prea sky130_fd_pr__pfet_01v8 L=0.15 W=4 nf=1 ad=1.16 as=1.16 pd=8.58 ps=8.58 nrd=0.0725 nrs=0.0725 sa=0 sb=0 sd=0 mult=1 m=1
XMPU1_i14_w1 x_i14_w1 dinb1 vdd vdd sky130_fd_pr__pfet_01v8 L=0.15 W=1 nf=1 ad=0.29 as=0.29 pd=2.58 ps=2.58 nrd=0.29 nrs=0.29 sa=0 sb=0 sd=0 mult=1 m=1
XMPU2_i14_w1 wbl_i14_w1 wenb x_i14_w1 vdd sky130_fd_pr__pfet_01v8 L=0.15 W=1 nf=1 ad=0.29 as=0.29 pd=2.58 ps=2.58 nrd=0.29 nrs=0.29 sa=0 sb=0 sd=0 mult=1 m=1
XMND2_i14_w1 wbl_i14_w1 wen y_i14_w1 0 sky130_fd_pr__nfet_01v8 L=0.15 W=0.5 nf=1 ad=0.145 as=0.145 pd=1.58 ps=1.58 nrd=0.58 nrs=0.58 sa=0 sb=0 sd=0 mult=1 m=1
XMND1_i14_w1 y_i14_w1 dinb1 0 0 sky130_fd_pr__nfet_01v8 L=0.15 W=0.5 nf=1 ad=0.145 as=0.145 pd=1.58 ps=1.58 nrd=0.58 nrs=0.58 sa=0 sb=0 sd=0 mult=1 m=1
XMNI_i14_w1 wbl_i14_w1 wenb 0 0 sky130_fd_pr__nfet_01v8 L=0.15 W=0.42 nf=1 ad=0.1218 as=0.1218 pd=1.42 ps=1.42 nrd=0.69047619047619 nrs=0.69047619047619 sa=0 sb=0 sd=0 mult=1 m=1
XMNS_i14_w1 sbl_i14_w1 sel_69500 rbl_i14_w1 0 sky130_fd_pr__nfet_01v8 L=0.15 W=1 nf=1 ad=0.29 as=0.29 pd=2.58 ps=2.58 nrd=0.29 nrs=0.29 sa=0 sb=0 sd=0 mult=1 m=1
XMPS_i14_w1 sbl_i14_w1 selb_69500 rbl_i14_w1 vdd sky130_fd_pr__pfet_01v8 L=0.15 W=2 nf=1 ad=0.58 as=0.58 pd=4.58 ps=4.58 nrd=0.145 nrs=0.145 sa=0 sb=0 sd=0 mult=1 m=1
XMNSR_i14_w1 sref_i14_w1 sel_69500 ref_i14_w1 0 sky130_fd_pr__nfet_01v8 L=0.15 W=1.5 nf=1 ad=0.435 as=0.435 pd=3.58 ps=3.58 nrd=0.19333333333333 nrs=0.19333333333333 sa=0 sb=0 sd=0 mult=1 m=1
XMPSR_i14_w1 sref_i14_w1 selb_69500 ref_i14_w1 vdd sky130_fd_pr__pfet_01v8 L=0.15 W=3 nf=1 ad=0.87 as=0.87 pd=6.58 ps=6.58 nrd=0.096666666666667 nrs=0.096666666666667 sa=0 sb=0 sd=0 mult=1 m=1
XMN1_i14_w1 sbl_i14_w1 sref_i14_w1 vn_i14_w1 0 sky130_fd_pr__nfet_01v8 L=0.15 W=1 nf=1 ad=0.29 as=0.29 pd=2.58 ps=2.58 nrd=0.29 nrs=0.29 sa=0 sb=0 sd=0 mult=1 m=1
XMN2_i14_w1 sref_i14_w1 sbl_i14_w1 vn_i14_w1 0 sky130_fd_pr__nfet_01v8 L=0.15 W=1 nf=1 ad=0.29 as=0.29 pd=2.58 ps=2.58 nrd=0.29 nrs=0.29 sa=0 sb=0 sd=0 mult=1 m=1
XMP1_i14_w1 sbl_i14_w1 sref_i14_w1 vp_i14_w1 vdd sky130_fd_pr__pfet_01v8 L=0.15 W=2 nf=1 ad=0.58 as=0.58 pd=4.58 ps=4.58 nrd=0.145 nrs=0.145 sa=0 sb=0 sd=0 mult=1 m=1
XMP2_i14_w1 sref_i14_w1 sbl_i14_w1 vp_i14_w1 vdd sky130_fd_pr__pfet_01v8 L=0.15 W=2 nf=1 ad=0.58 as=0.58 pd=4.58 ps=4.58 nrd=0.145 nrs=0.145 sa=0 sb=0 sd=0 mult=1 m=1
XMNF_i14_w1 vn_i14_w1 en 0 0 sky130_fd_pr__nfet_01v8 L=0.15 W=2 nf=1 ad=0.58 as=0.58 pd=4.58 ps=4.58 nrd=0.145 nrs=0.145 sa=0 sb=0 sd=0 mult=1 m=1
XMPH_i14_w1 vp_i14_w1 enb vdd vdd sky130_fd_pr__pfet_01v8 L=0.15 W=4 nf=1 ad=1.16 as=1.16 pd=8.58 ps=8.58 nrd=0.0725 nrs=0.0725 sa=0 sb=0 sd=0 mult=1 m=1
bd_i14_w1 d_i14_w1 0 v=v(sbl_i14_w1)-v(sref_i14_w1)
bdabs_i14_w1 dabs_i14_w1 0 v=abs(v(sbl_i14_w1)-v(sref_i14_w1))

* ---- instance 31: i14_w0 (baseline TG, dummy 1.5x) ----
XMWR_i14_w0_0 sn_i14_w0_0 wl wbl_i14_w0 0 sky130_fd_pr__nfet_01v8 L=0.15 W=0.42 nf=1 ad=0.1218 as=0.1218 pd=1.42 ps=1.42 nrd=0.69047619047619 nrs=0.69047619047619 sa=0 sb=0 sd=0 mult=1 m=1
XMRD_i14_w0_0 rbl_i14_w0 sn_i14_w0_0 rwl_sel 0 sky130_fd_pr__nfet_01v8 L=0.15 W=0.42 nf=1 ad=0.1218 as=0.1218 pd=1.42 ps=1.42 nrd=0.69047619047619 nrs=0.69047619047619 sa=0 sb=0 sd=0 mult=1 m=1
csn_i14_w0_0 sn_i14_w0_0 0 {C_SN}
XMWR_i14_w0_1 sn_i14_w0_1 0 wbl_i14_w0 0 sky130_fd_pr__nfet_01v8 L=0.15 W=0.42 nf=1 ad=0.1218 as=0.1218 pd=1.42 ps=1.42 nrd=0.69047619047619 nrs=0.69047619047619 sa=0 sb=0 sd=0 mult=1 m=1
XMRD_i14_w0_1 rbl_i14_w0 sn_i14_w0_1 rwl_des 0 sky130_fd_pr__nfet_01v8 L=0.15 W=0.42 nf=1 ad=0.1218 as=0.1218 pd=1.42 ps=1.42 nrd=0.69047619047619 nrs=0.69047619047619 sa=0 sb=0 sd=0 mult=1 m=1
csn_i14_w0_1 sn_i14_w0_1 0 {C_SN}
XMWR_i14_w0_2 sn_i14_w0_2 0 wbl_i14_w0 0 sky130_fd_pr__nfet_01v8 L=0.15 W=0.42 nf=1 ad=0.1218 as=0.1218 pd=1.42 ps=1.42 nrd=0.69047619047619 nrs=0.69047619047619 sa=0 sb=0 sd=0 mult=1 m=1
XMRD_i14_w0_2 rbl_i14_w0 sn_i14_w0_2 rwl_des 0 sky130_fd_pr__nfet_01v8 L=0.15 W=0.42 nf=1 ad=0.1218 as=0.1218 pd=1.42 ps=1.42 nrd=0.69047619047619 nrs=0.69047619047619 sa=0 sb=0 sd=0 mult=1 m=1
csn_i14_w0_2 sn_i14_w0_2 0 {C_SN}
XMWR_i14_w0_3 sn_i14_w0_3 0 wbl_i14_w0 0 sky130_fd_pr__nfet_01v8 L=0.15 W=0.42 nf=1 ad=0.1218 as=0.1218 pd=1.42 ps=1.42 nrd=0.69047619047619 nrs=0.69047619047619 sa=0 sb=0 sd=0 mult=1 m=1
XMRD_i14_w0_3 rbl_i14_w0 sn_i14_w0_3 rwl_des 0 sky130_fd_pr__nfet_01v8 L=0.15 W=0.42 nf=1 ad=0.1218 as=0.1218 pd=1.42 ps=1.42 nrd=0.69047619047619 nrs=0.69047619047619 sa=0 sb=0 sd=0 mult=1 m=1
csn_i14_w0_3 sn_i14_w0_3 0 {C_SN}
crbl_i14_w0 rbl_i14_w0 0 {C_RBL}
cwbl_i14_w0 wbl_i14_w0 0 {C_WBL}
cref_i14_w0 ref_i14_w0 0 {C_RBL}   $ ASSUMPTION: ideal matched dummy load
spr_i14_w0 pref ref_i14_w0 pca 0 swpre   $ reference-side precharge: ideal switch (#114 convention)
XMPPRE_i14_w0 rbl_i14_w0 pcb_100 prea prea sky130_fd_pr__pfet_01v8 L=0.15 W=4 nf=1 ad=1.16 as=1.16 pd=8.58 ps=8.58 nrd=0.0725 nrs=0.0725 sa=0 sb=0 sd=0 mult=1 m=1
XMPU1_i14_w0 x_i14_w0 dinb0 vdd vdd sky130_fd_pr__pfet_01v8 L=0.15 W=1 nf=1 ad=0.29 as=0.29 pd=2.58 ps=2.58 nrd=0.29 nrs=0.29 sa=0 sb=0 sd=0 mult=1 m=1
XMPU2_i14_w0 wbl_i14_w0 wenb x_i14_w0 vdd sky130_fd_pr__pfet_01v8 L=0.15 W=1 nf=1 ad=0.29 as=0.29 pd=2.58 ps=2.58 nrd=0.29 nrs=0.29 sa=0 sb=0 sd=0 mult=1 m=1
XMND2_i14_w0 wbl_i14_w0 wen y_i14_w0 0 sky130_fd_pr__nfet_01v8 L=0.15 W=0.5 nf=1 ad=0.145 as=0.145 pd=1.58 ps=1.58 nrd=0.58 nrs=0.58 sa=0 sb=0 sd=0 mult=1 m=1
XMND1_i14_w0 y_i14_w0 dinb0 0 0 sky130_fd_pr__nfet_01v8 L=0.15 W=0.5 nf=1 ad=0.145 as=0.145 pd=1.58 ps=1.58 nrd=0.58 nrs=0.58 sa=0 sb=0 sd=0 mult=1 m=1
XMNI_i14_w0 wbl_i14_w0 wenb 0 0 sky130_fd_pr__nfet_01v8 L=0.15 W=0.42 nf=1 ad=0.1218 as=0.1218 pd=1.42 ps=1.42 nrd=0.69047619047619 nrs=0.69047619047619 sa=0 sb=0 sd=0 mult=1 m=1
XMNS_i14_w0 sbl_i14_w0 sel_69500 rbl_i14_w0 0 sky130_fd_pr__nfet_01v8 L=0.15 W=1 nf=1 ad=0.29 as=0.29 pd=2.58 ps=2.58 nrd=0.29 nrs=0.29 sa=0 sb=0 sd=0 mult=1 m=1
XMPS_i14_w0 sbl_i14_w0 selb_69500 rbl_i14_w0 vdd sky130_fd_pr__pfet_01v8 L=0.15 W=2 nf=1 ad=0.58 as=0.58 pd=4.58 ps=4.58 nrd=0.145 nrs=0.145 sa=0 sb=0 sd=0 mult=1 m=1
XMNSR_i14_w0 sref_i14_w0 sel_69500 ref_i14_w0 0 sky130_fd_pr__nfet_01v8 L=0.15 W=1.5 nf=1 ad=0.435 as=0.435 pd=3.58 ps=3.58 nrd=0.19333333333333 nrs=0.19333333333333 sa=0 sb=0 sd=0 mult=1 m=1
XMPSR_i14_w0 sref_i14_w0 selb_69500 ref_i14_w0 vdd sky130_fd_pr__pfet_01v8 L=0.15 W=3 nf=1 ad=0.87 as=0.87 pd=6.58 ps=6.58 nrd=0.096666666666667 nrs=0.096666666666667 sa=0 sb=0 sd=0 mult=1 m=1
XMN1_i14_w0 sbl_i14_w0 sref_i14_w0 vn_i14_w0 0 sky130_fd_pr__nfet_01v8 L=0.15 W=1 nf=1 ad=0.29 as=0.29 pd=2.58 ps=2.58 nrd=0.29 nrs=0.29 sa=0 sb=0 sd=0 mult=1 m=1
XMN2_i14_w0 sref_i14_w0 sbl_i14_w0 vn_i14_w0 0 sky130_fd_pr__nfet_01v8 L=0.15 W=1 nf=1 ad=0.29 as=0.29 pd=2.58 ps=2.58 nrd=0.29 nrs=0.29 sa=0 sb=0 sd=0 mult=1 m=1
XMP1_i14_w0 sbl_i14_w0 sref_i14_w0 vp_i14_w0 vdd sky130_fd_pr__pfet_01v8 L=0.15 W=2 nf=1 ad=0.58 as=0.58 pd=4.58 ps=4.58 nrd=0.145 nrs=0.145 sa=0 sb=0 sd=0 mult=1 m=1
XMP2_i14_w0 sref_i14_w0 sbl_i14_w0 vp_i14_w0 vdd sky130_fd_pr__pfet_01v8 L=0.15 W=2 nf=1 ad=0.58 as=0.58 pd=4.58 ps=4.58 nrd=0.145 nrs=0.145 sa=0 sb=0 sd=0 mult=1 m=1
XMNF_i14_w0 vn_i14_w0 en 0 0 sky130_fd_pr__nfet_01v8 L=0.15 W=2 nf=1 ad=0.58 as=0.58 pd=4.58 ps=4.58 nrd=0.145 nrs=0.145 sa=0 sb=0 sd=0 mult=1 m=1
XMPH_i14_w0 vp_i14_w0 enb vdd vdd sky130_fd_pr__pfet_01v8 L=0.15 W=4 nf=1 ad=1.16 as=1.16 pd=8.58 ps=8.58 nrd=0.0725 nrs=0.0725 sa=0 sb=0 sd=0 mult=1 m=1
bd_i14_w0 d_i14_w0 0 v=v(sbl_i14_w0)-v(sref_i14_w0)
bdabs_i14_w0 dabs_i14_w0 0 v=abs(v(sbl_i14_w0)-v(sref_i14_w0))

* ---- instance 32: i15_w1 (TG 0.42 / 0.84, +5 fF on sbl and sref) ----
XMWR_i15_w1_0 sn_i15_w1_0 wl wbl_i15_w1 0 sky130_fd_pr__nfet_01v8 L=0.15 W=0.42 nf=1 ad=0.1218 as=0.1218 pd=1.42 ps=1.42 nrd=0.69047619047619 nrs=0.69047619047619 sa=0 sb=0 sd=0 mult=1 m=1
XMRD_i15_w1_0 rbl_i15_w1 sn_i15_w1_0 rwl_sel 0 sky130_fd_pr__nfet_01v8 L=0.15 W=0.42 nf=1 ad=0.1218 as=0.1218 pd=1.42 ps=1.42 nrd=0.69047619047619 nrs=0.69047619047619 sa=0 sb=0 sd=0 mult=1 m=1
csn_i15_w1_0 sn_i15_w1_0 0 {C_SN}
XMWR_i15_w1_1 sn_i15_w1_1 0 wbl_i15_w1 0 sky130_fd_pr__nfet_01v8 L=0.15 W=0.42 nf=1 ad=0.1218 as=0.1218 pd=1.42 ps=1.42 nrd=0.69047619047619 nrs=0.69047619047619 sa=0 sb=0 sd=0 mult=1 m=1
XMRD_i15_w1_1 rbl_i15_w1 sn_i15_w1_1 rwl_des 0 sky130_fd_pr__nfet_01v8 L=0.15 W=0.42 nf=1 ad=0.1218 as=0.1218 pd=1.42 ps=1.42 nrd=0.69047619047619 nrs=0.69047619047619 sa=0 sb=0 sd=0 mult=1 m=1
csn_i15_w1_1 sn_i15_w1_1 0 {C_SN}
XMWR_i15_w1_2 sn_i15_w1_2 0 wbl_i15_w1 0 sky130_fd_pr__nfet_01v8 L=0.15 W=0.42 nf=1 ad=0.1218 as=0.1218 pd=1.42 ps=1.42 nrd=0.69047619047619 nrs=0.69047619047619 sa=0 sb=0 sd=0 mult=1 m=1
XMRD_i15_w1_2 rbl_i15_w1 sn_i15_w1_2 rwl_des 0 sky130_fd_pr__nfet_01v8 L=0.15 W=0.42 nf=1 ad=0.1218 as=0.1218 pd=1.42 ps=1.42 nrd=0.69047619047619 nrs=0.69047619047619 sa=0 sb=0 sd=0 mult=1 m=1
csn_i15_w1_2 sn_i15_w1_2 0 {C_SN}
XMWR_i15_w1_3 sn_i15_w1_3 0 wbl_i15_w1 0 sky130_fd_pr__nfet_01v8 L=0.15 W=0.42 nf=1 ad=0.1218 as=0.1218 pd=1.42 ps=1.42 nrd=0.69047619047619 nrs=0.69047619047619 sa=0 sb=0 sd=0 mult=1 m=1
XMRD_i15_w1_3 rbl_i15_w1 sn_i15_w1_3 rwl_des 0 sky130_fd_pr__nfet_01v8 L=0.15 W=0.42 nf=1 ad=0.1218 as=0.1218 pd=1.42 ps=1.42 nrd=0.69047619047619 nrs=0.69047619047619 sa=0 sb=0 sd=0 mult=1 m=1
csn_i15_w1_3 sn_i15_w1_3 0 {C_SN}
crbl_i15_w1 rbl_i15_w1 0 {C_RBL}
cwbl_i15_w1 wbl_i15_w1 0 {C_WBL}
cref_i15_w1 ref_i15_w1 0 {C_RBL}   $ ASSUMPTION: ideal matched dummy load
spr_i15_w1 pref ref_i15_w1 pca 0 swpre   $ reference-side precharge: ideal switch (#114 convention)
XMPPRE_i15_w1 rbl_i15_w1 pcb_100 prea prea sky130_fd_pr__pfet_01v8 L=0.15 W=4 nf=1 ad=1.16 as=1.16 pd=8.58 ps=8.58 nrd=0.0725 nrs=0.0725 sa=0 sb=0 sd=0 mult=1 m=1
XMPU1_i15_w1 x_i15_w1 dinb1 vdd vdd sky130_fd_pr__pfet_01v8 L=0.15 W=1 nf=1 ad=0.29 as=0.29 pd=2.58 ps=2.58 nrd=0.29 nrs=0.29 sa=0 sb=0 sd=0 mult=1 m=1
XMPU2_i15_w1 wbl_i15_w1 wenb x_i15_w1 vdd sky130_fd_pr__pfet_01v8 L=0.15 W=1 nf=1 ad=0.29 as=0.29 pd=2.58 ps=2.58 nrd=0.29 nrs=0.29 sa=0 sb=0 sd=0 mult=1 m=1
XMND2_i15_w1 wbl_i15_w1 wen y_i15_w1 0 sky130_fd_pr__nfet_01v8 L=0.15 W=0.5 nf=1 ad=0.145 as=0.145 pd=1.58 ps=1.58 nrd=0.58 nrs=0.58 sa=0 sb=0 sd=0 mult=1 m=1
XMND1_i15_w1 y_i15_w1 dinb1 0 0 sky130_fd_pr__nfet_01v8 L=0.15 W=0.5 nf=1 ad=0.145 as=0.145 pd=1.58 ps=1.58 nrd=0.58 nrs=0.58 sa=0 sb=0 sd=0 mult=1 m=1
XMNI_i15_w1 wbl_i15_w1 wenb 0 0 sky130_fd_pr__nfet_01v8 L=0.15 W=0.42 nf=1 ad=0.1218 as=0.1218 pd=1.42 ps=1.42 nrd=0.69047619047619 nrs=0.69047619047619 sa=0 sb=0 sd=0 mult=1 m=1
XMNS_i15_w1 sbl_i15_w1 sel_69500 rbl_i15_w1 0 sky130_fd_pr__nfet_01v8 L=0.15 W=0.42 nf=1 ad=0.1218 as=0.1218 pd=1.42 ps=1.42 nrd=0.69047619047619 nrs=0.69047619047619 sa=0 sb=0 sd=0 mult=1 m=1
XMPS_i15_w1 sbl_i15_w1 selb_69500 rbl_i15_w1 vdd sky130_fd_pr__pfet_01v8 L=0.15 W=0.84 nf=1 ad=0.2436 as=0.2436 pd=2.26 ps=2.26 nrd=0.3452380952381 nrs=0.3452380952381 sa=0 sb=0 sd=0 mult=1 m=1
XMNSR_i15_w1 sref_i15_w1 sel_69500 ref_i15_w1 0 sky130_fd_pr__nfet_01v8 L=0.15 W=0.42 nf=1 ad=0.1218 as=0.1218 pd=1.42 ps=1.42 nrd=0.69047619047619 nrs=0.69047619047619 sa=0 sb=0 sd=0 mult=1 m=1
XMPSR_i15_w1 sref_i15_w1 selb_69500 ref_i15_w1 vdd sky130_fd_pr__pfet_01v8 L=0.15 W=0.84 nf=1 ad=0.2436 as=0.2436 pd=2.26 ps=2.26 nrd=0.3452380952381 nrs=0.3452380952381 sa=0 sb=0 sd=0 mult=1 m=1
csb_i15_w1 sbl_i15_w1 0 5e-15   $ STUDY option: extra latch-input hold capacitance
csr_i15_w1 sref_i15_w1 0 5e-15
XMN1_i15_w1 sbl_i15_w1 sref_i15_w1 vn_i15_w1 0 sky130_fd_pr__nfet_01v8 L=0.15 W=1 nf=1 ad=0.29 as=0.29 pd=2.58 ps=2.58 nrd=0.29 nrs=0.29 sa=0 sb=0 sd=0 mult=1 m=1
XMN2_i15_w1 sref_i15_w1 sbl_i15_w1 vn_i15_w1 0 sky130_fd_pr__nfet_01v8 L=0.15 W=1 nf=1 ad=0.29 as=0.29 pd=2.58 ps=2.58 nrd=0.29 nrs=0.29 sa=0 sb=0 sd=0 mult=1 m=1
XMP1_i15_w1 sbl_i15_w1 sref_i15_w1 vp_i15_w1 vdd sky130_fd_pr__pfet_01v8 L=0.15 W=2 nf=1 ad=0.58 as=0.58 pd=4.58 ps=4.58 nrd=0.145 nrs=0.145 sa=0 sb=0 sd=0 mult=1 m=1
XMP2_i15_w1 sref_i15_w1 sbl_i15_w1 vp_i15_w1 vdd sky130_fd_pr__pfet_01v8 L=0.15 W=2 nf=1 ad=0.58 as=0.58 pd=4.58 ps=4.58 nrd=0.145 nrs=0.145 sa=0 sb=0 sd=0 mult=1 m=1
XMNF_i15_w1 vn_i15_w1 en 0 0 sky130_fd_pr__nfet_01v8 L=0.15 W=2 nf=1 ad=0.58 as=0.58 pd=4.58 ps=4.58 nrd=0.145 nrs=0.145 sa=0 sb=0 sd=0 mult=1 m=1
XMPH_i15_w1 vp_i15_w1 enb vdd vdd sky130_fd_pr__pfet_01v8 L=0.15 W=4 nf=1 ad=1.16 as=1.16 pd=8.58 ps=8.58 nrd=0.0725 nrs=0.0725 sa=0 sb=0 sd=0 mult=1 m=1
bd_i15_w1 d_i15_w1 0 v=v(sbl_i15_w1)-v(sref_i15_w1)
bdabs_i15_w1 dabs_i15_w1 0 v=abs(v(sbl_i15_w1)-v(sref_i15_w1))

* ---- instance 33: i15_w0 (TG 0.42 / 0.84, +5 fF on sbl and sref) ----
XMWR_i15_w0_0 sn_i15_w0_0 wl wbl_i15_w0 0 sky130_fd_pr__nfet_01v8 L=0.15 W=0.42 nf=1 ad=0.1218 as=0.1218 pd=1.42 ps=1.42 nrd=0.69047619047619 nrs=0.69047619047619 sa=0 sb=0 sd=0 mult=1 m=1
XMRD_i15_w0_0 rbl_i15_w0 sn_i15_w0_0 rwl_sel 0 sky130_fd_pr__nfet_01v8 L=0.15 W=0.42 nf=1 ad=0.1218 as=0.1218 pd=1.42 ps=1.42 nrd=0.69047619047619 nrs=0.69047619047619 sa=0 sb=0 sd=0 mult=1 m=1
csn_i15_w0_0 sn_i15_w0_0 0 {C_SN}
XMWR_i15_w0_1 sn_i15_w0_1 0 wbl_i15_w0 0 sky130_fd_pr__nfet_01v8 L=0.15 W=0.42 nf=1 ad=0.1218 as=0.1218 pd=1.42 ps=1.42 nrd=0.69047619047619 nrs=0.69047619047619 sa=0 sb=0 sd=0 mult=1 m=1
XMRD_i15_w0_1 rbl_i15_w0 sn_i15_w0_1 rwl_des 0 sky130_fd_pr__nfet_01v8 L=0.15 W=0.42 nf=1 ad=0.1218 as=0.1218 pd=1.42 ps=1.42 nrd=0.69047619047619 nrs=0.69047619047619 sa=0 sb=0 sd=0 mult=1 m=1
csn_i15_w0_1 sn_i15_w0_1 0 {C_SN}
XMWR_i15_w0_2 sn_i15_w0_2 0 wbl_i15_w0 0 sky130_fd_pr__nfet_01v8 L=0.15 W=0.42 nf=1 ad=0.1218 as=0.1218 pd=1.42 ps=1.42 nrd=0.69047619047619 nrs=0.69047619047619 sa=0 sb=0 sd=0 mult=1 m=1
XMRD_i15_w0_2 rbl_i15_w0 sn_i15_w0_2 rwl_des 0 sky130_fd_pr__nfet_01v8 L=0.15 W=0.42 nf=1 ad=0.1218 as=0.1218 pd=1.42 ps=1.42 nrd=0.69047619047619 nrs=0.69047619047619 sa=0 sb=0 sd=0 mult=1 m=1
csn_i15_w0_2 sn_i15_w0_2 0 {C_SN}
XMWR_i15_w0_3 sn_i15_w0_3 0 wbl_i15_w0 0 sky130_fd_pr__nfet_01v8 L=0.15 W=0.42 nf=1 ad=0.1218 as=0.1218 pd=1.42 ps=1.42 nrd=0.69047619047619 nrs=0.69047619047619 sa=0 sb=0 sd=0 mult=1 m=1
XMRD_i15_w0_3 rbl_i15_w0 sn_i15_w0_3 rwl_des 0 sky130_fd_pr__nfet_01v8 L=0.15 W=0.42 nf=1 ad=0.1218 as=0.1218 pd=1.42 ps=1.42 nrd=0.69047619047619 nrs=0.69047619047619 sa=0 sb=0 sd=0 mult=1 m=1
csn_i15_w0_3 sn_i15_w0_3 0 {C_SN}
crbl_i15_w0 rbl_i15_w0 0 {C_RBL}
cwbl_i15_w0 wbl_i15_w0 0 {C_WBL}
cref_i15_w0 ref_i15_w0 0 {C_RBL}   $ ASSUMPTION: ideal matched dummy load
spr_i15_w0 pref ref_i15_w0 pca 0 swpre   $ reference-side precharge: ideal switch (#114 convention)
XMPPRE_i15_w0 rbl_i15_w0 pcb_100 prea prea sky130_fd_pr__pfet_01v8 L=0.15 W=4 nf=1 ad=1.16 as=1.16 pd=8.58 ps=8.58 nrd=0.0725 nrs=0.0725 sa=0 sb=0 sd=0 mult=1 m=1
XMPU1_i15_w0 x_i15_w0 dinb0 vdd vdd sky130_fd_pr__pfet_01v8 L=0.15 W=1 nf=1 ad=0.29 as=0.29 pd=2.58 ps=2.58 nrd=0.29 nrs=0.29 sa=0 sb=0 sd=0 mult=1 m=1
XMPU2_i15_w0 wbl_i15_w0 wenb x_i15_w0 vdd sky130_fd_pr__pfet_01v8 L=0.15 W=1 nf=1 ad=0.29 as=0.29 pd=2.58 ps=2.58 nrd=0.29 nrs=0.29 sa=0 sb=0 sd=0 mult=1 m=1
XMND2_i15_w0 wbl_i15_w0 wen y_i15_w0 0 sky130_fd_pr__nfet_01v8 L=0.15 W=0.5 nf=1 ad=0.145 as=0.145 pd=1.58 ps=1.58 nrd=0.58 nrs=0.58 sa=0 sb=0 sd=0 mult=1 m=1
XMND1_i15_w0 y_i15_w0 dinb0 0 0 sky130_fd_pr__nfet_01v8 L=0.15 W=0.5 nf=1 ad=0.145 as=0.145 pd=1.58 ps=1.58 nrd=0.58 nrs=0.58 sa=0 sb=0 sd=0 mult=1 m=1
XMNI_i15_w0 wbl_i15_w0 wenb 0 0 sky130_fd_pr__nfet_01v8 L=0.15 W=0.42 nf=1 ad=0.1218 as=0.1218 pd=1.42 ps=1.42 nrd=0.69047619047619 nrs=0.69047619047619 sa=0 sb=0 sd=0 mult=1 m=1
XMNS_i15_w0 sbl_i15_w0 sel_69500 rbl_i15_w0 0 sky130_fd_pr__nfet_01v8 L=0.15 W=0.42 nf=1 ad=0.1218 as=0.1218 pd=1.42 ps=1.42 nrd=0.69047619047619 nrs=0.69047619047619 sa=0 sb=0 sd=0 mult=1 m=1
XMPS_i15_w0 sbl_i15_w0 selb_69500 rbl_i15_w0 vdd sky130_fd_pr__pfet_01v8 L=0.15 W=0.84 nf=1 ad=0.2436 as=0.2436 pd=2.26 ps=2.26 nrd=0.3452380952381 nrs=0.3452380952381 sa=0 sb=0 sd=0 mult=1 m=1
XMNSR_i15_w0 sref_i15_w0 sel_69500 ref_i15_w0 0 sky130_fd_pr__nfet_01v8 L=0.15 W=0.42 nf=1 ad=0.1218 as=0.1218 pd=1.42 ps=1.42 nrd=0.69047619047619 nrs=0.69047619047619 sa=0 sb=0 sd=0 mult=1 m=1
XMPSR_i15_w0 sref_i15_w0 selb_69500 ref_i15_w0 vdd sky130_fd_pr__pfet_01v8 L=0.15 W=0.84 nf=1 ad=0.2436 as=0.2436 pd=2.26 ps=2.26 nrd=0.3452380952381 nrs=0.3452380952381 sa=0 sb=0 sd=0 mult=1 m=1
csb_i15_w0 sbl_i15_w0 0 5e-15   $ STUDY option: extra latch-input hold capacitance
csr_i15_w0 sref_i15_w0 0 5e-15
XMN1_i15_w0 sbl_i15_w0 sref_i15_w0 vn_i15_w0 0 sky130_fd_pr__nfet_01v8 L=0.15 W=1 nf=1 ad=0.29 as=0.29 pd=2.58 ps=2.58 nrd=0.29 nrs=0.29 sa=0 sb=0 sd=0 mult=1 m=1
XMN2_i15_w0 sref_i15_w0 sbl_i15_w0 vn_i15_w0 0 sky130_fd_pr__nfet_01v8 L=0.15 W=1 nf=1 ad=0.29 as=0.29 pd=2.58 ps=2.58 nrd=0.29 nrs=0.29 sa=0 sb=0 sd=0 mult=1 m=1
XMP1_i15_w0 sbl_i15_w0 sref_i15_w0 vp_i15_w0 vdd sky130_fd_pr__pfet_01v8 L=0.15 W=2 nf=1 ad=0.58 as=0.58 pd=4.58 ps=4.58 nrd=0.145 nrs=0.145 sa=0 sb=0 sd=0 mult=1 m=1
XMP2_i15_w0 sref_i15_w0 sbl_i15_w0 vp_i15_w0 vdd sky130_fd_pr__pfet_01v8 L=0.15 W=2 nf=1 ad=0.58 as=0.58 pd=4.58 ps=4.58 nrd=0.145 nrs=0.145 sa=0 sb=0 sd=0 mult=1 m=1
XMNF_i15_w0 vn_i15_w0 en 0 0 sky130_fd_pr__nfet_01v8 L=0.15 W=2 nf=1 ad=0.58 as=0.58 pd=4.58 ps=4.58 nrd=0.145 nrs=0.145 sa=0 sb=0 sd=0 mult=1 m=1
XMPH_i15_w0 vp_i15_w0 enb vdd vdd sky130_fd_pr__pfet_01v8 L=0.15 W=4 nf=1 ad=1.16 as=1.16 pd=8.58 ps=8.58 nrd=0.0725 nrs=0.0725 sa=0 sb=0 sd=0 mult=1 m=1
bd_i15_w0 d_i15_w0 0 v=v(sbl_i15_w0)-v(sref_i15_w0)
bdabs_i15_w0 dabs_i15_w0 0 v=abs(v(sbl_i15_w0)-v(sref_i15_w0))

* ---- instance 34: m00_w1 (baseline: TG nfet 1.0 / pfet 2.0, dummy 1x, lead 0.5 ns [matched ref precharge]) ----
XMWR_m00_w1_0 sn_m00_w1_0 wl wbl_m00_w1 0 sky130_fd_pr__nfet_01v8 L=0.15 W=0.42 nf=1 ad=0.1218 as=0.1218 pd=1.42 ps=1.42 nrd=0.69047619047619 nrs=0.69047619047619 sa=0 sb=0 sd=0 mult=1 m=1
XMRD_m00_w1_0 rbl_m00_w1 sn_m00_w1_0 rwl_sel 0 sky130_fd_pr__nfet_01v8 L=0.15 W=0.42 nf=1 ad=0.1218 as=0.1218 pd=1.42 ps=1.42 nrd=0.69047619047619 nrs=0.69047619047619 sa=0 sb=0 sd=0 mult=1 m=1
csn_m00_w1_0 sn_m00_w1_0 0 {C_SN}
XMWR_m00_w1_1 sn_m00_w1_1 0 wbl_m00_w1 0 sky130_fd_pr__nfet_01v8 L=0.15 W=0.42 nf=1 ad=0.1218 as=0.1218 pd=1.42 ps=1.42 nrd=0.69047619047619 nrs=0.69047619047619 sa=0 sb=0 sd=0 mult=1 m=1
XMRD_m00_w1_1 rbl_m00_w1 sn_m00_w1_1 rwl_des 0 sky130_fd_pr__nfet_01v8 L=0.15 W=0.42 nf=1 ad=0.1218 as=0.1218 pd=1.42 ps=1.42 nrd=0.69047619047619 nrs=0.69047619047619 sa=0 sb=0 sd=0 mult=1 m=1
csn_m00_w1_1 sn_m00_w1_1 0 {C_SN}
XMWR_m00_w1_2 sn_m00_w1_2 0 wbl_m00_w1 0 sky130_fd_pr__nfet_01v8 L=0.15 W=0.42 nf=1 ad=0.1218 as=0.1218 pd=1.42 ps=1.42 nrd=0.69047619047619 nrs=0.69047619047619 sa=0 sb=0 sd=0 mult=1 m=1
XMRD_m00_w1_2 rbl_m00_w1 sn_m00_w1_2 rwl_des 0 sky130_fd_pr__nfet_01v8 L=0.15 W=0.42 nf=1 ad=0.1218 as=0.1218 pd=1.42 ps=1.42 nrd=0.69047619047619 nrs=0.69047619047619 sa=0 sb=0 sd=0 mult=1 m=1
csn_m00_w1_2 sn_m00_w1_2 0 {C_SN}
XMWR_m00_w1_3 sn_m00_w1_3 0 wbl_m00_w1 0 sky130_fd_pr__nfet_01v8 L=0.15 W=0.42 nf=1 ad=0.1218 as=0.1218 pd=1.42 ps=1.42 nrd=0.69047619047619 nrs=0.69047619047619 sa=0 sb=0 sd=0 mult=1 m=1
XMRD_m00_w1_3 rbl_m00_w1 sn_m00_w1_3 rwl_des 0 sky130_fd_pr__nfet_01v8 L=0.15 W=0.42 nf=1 ad=0.1218 as=0.1218 pd=1.42 ps=1.42 nrd=0.69047619047619 nrs=0.69047619047619 sa=0 sb=0 sd=0 mult=1 m=1
csn_m00_w1_3 sn_m00_w1_3 0 {C_SN}
crbl_m00_w1 rbl_m00_w1 0 {C_RBL}
cwbl_m00_w1 wbl_m00_w1 0 {C_WBL}
cref_m00_w1 ref_m00_w1 0 {C_RBL}   $ ASSUMPTION: ideal matched dummy load
XMPPRE_m00_w1 rbl_m00_w1 pcb_100 prea prea sky130_fd_pr__pfet_01v8 L=0.15 W=4 nf=1 ad=1.16 as=1.16 pd=8.58 ps=8.58 nrd=0.0725 nrs=0.0725 sa=0 sb=0 sd=0 mult=1 m=1
XMPU1_m00_w1 x_m00_w1 dinb1 vdd vdd sky130_fd_pr__pfet_01v8 L=0.15 W=1 nf=1 ad=0.29 as=0.29 pd=2.58 ps=2.58 nrd=0.29 nrs=0.29 sa=0 sb=0 sd=0 mult=1 m=1
XMPU2_m00_w1 wbl_m00_w1 wenb x_m00_w1 vdd sky130_fd_pr__pfet_01v8 L=0.15 W=1 nf=1 ad=0.29 as=0.29 pd=2.58 ps=2.58 nrd=0.29 nrs=0.29 sa=0 sb=0 sd=0 mult=1 m=1
XMND2_m00_w1 wbl_m00_w1 wen y_m00_w1 0 sky130_fd_pr__nfet_01v8 L=0.15 W=0.5 nf=1 ad=0.145 as=0.145 pd=1.58 ps=1.58 nrd=0.58 nrs=0.58 sa=0 sb=0 sd=0 mult=1 m=1
XMND1_m00_w1 y_m00_w1 dinb1 0 0 sky130_fd_pr__nfet_01v8 L=0.15 W=0.5 nf=1 ad=0.145 as=0.145 pd=1.58 ps=1.58 nrd=0.58 nrs=0.58 sa=0 sb=0 sd=0 mult=1 m=1
XMNI_m00_w1 wbl_m00_w1 wenb 0 0 sky130_fd_pr__nfet_01v8 L=0.15 W=0.42 nf=1 ad=0.1218 as=0.1218 pd=1.42 ps=1.42 nrd=0.69047619047619 nrs=0.69047619047619 sa=0 sb=0 sd=0 mult=1 m=1
XMNS_m00_w1 sbl_m00_w1 sel_69500 rbl_m00_w1 0 sky130_fd_pr__nfet_01v8 L=0.15 W=1 nf=1 ad=0.29 as=0.29 pd=2.58 ps=2.58 nrd=0.29 nrs=0.29 sa=0 sb=0 sd=0 mult=1 m=1
XMPS_m00_w1 sbl_m00_w1 selb_69500 rbl_m00_w1 vdd sky130_fd_pr__pfet_01v8 L=0.15 W=2 nf=1 ad=0.58 as=0.58 pd=4.58 ps=4.58 nrd=0.145 nrs=0.145 sa=0 sb=0 sd=0 mult=1 m=1
XMNSR_m00_w1 sref_m00_w1 sel_69500 ref_m00_w1 0 sky130_fd_pr__nfet_01v8 L=0.15 W=1 nf=1 ad=0.29 as=0.29 pd=2.58 ps=2.58 nrd=0.29 nrs=0.29 sa=0 sb=0 sd=0 mult=1 m=1
XMPSR_m00_w1 sref_m00_w1 selb_69500 ref_m00_w1 vdd sky130_fd_pr__pfet_01v8 L=0.15 W=2 nf=1 ad=0.58 as=0.58 pd=4.58 ps=4.58 nrd=0.145 nrs=0.145 sa=0 sb=0 sd=0 mult=1 m=1
XMPPREF_m00_w1 ref_m00_w1 pcb_100 pref pref sky130_fd_pr__pfet_01v8 L=0.15 W=4 nf=1 ad=1.16 as=1.16 pd=8.58 ps=8.58 nrd=0.0725 nrs=0.0725 sa=0 sb=0 sd=0 mult=1 m=1   $ reference-side precharge: copy of MPPRE
XMN1_m00_w1 sbl_m00_w1 sref_m00_w1 vn_m00_w1 0 sky130_fd_pr__nfet_01v8 L=0.15 W=1 nf=1 ad=0.29 as=0.29 pd=2.58 ps=2.58 nrd=0.29 nrs=0.29 sa=0 sb=0 sd=0 mult=1 m=1
XMN2_m00_w1 sref_m00_w1 sbl_m00_w1 vn_m00_w1 0 sky130_fd_pr__nfet_01v8 L=0.15 W=1 nf=1 ad=0.29 as=0.29 pd=2.58 ps=2.58 nrd=0.29 nrs=0.29 sa=0 sb=0 sd=0 mult=1 m=1
XMP1_m00_w1 sbl_m00_w1 sref_m00_w1 vp_m00_w1 vdd sky130_fd_pr__pfet_01v8 L=0.15 W=2 nf=1 ad=0.58 as=0.58 pd=4.58 ps=4.58 nrd=0.145 nrs=0.145 sa=0 sb=0 sd=0 mult=1 m=1
XMP2_m00_w1 sref_m00_w1 sbl_m00_w1 vp_m00_w1 vdd sky130_fd_pr__pfet_01v8 L=0.15 W=2 nf=1 ad=0.58 as=0.58 pd=4.58 ps=4.58 nrd=0.145 nrs=0.145 sa=0 sb=0 sd=0 mult=1 m=1
XMNF_m00_w1 vn_m00_w1 en 0 0 sky130_fd_pr__nfet_01v8 L=0.15 W=2 nf=1 ad=0.58 as=0.58 pd=4.58 ps=4.58 nrd=0.145 nrs=0.145 sa=0 sb=0 sd=0 mult=1 m=1
XMPH_m00_w1 vp_m00_w1 enb vdd vdd sky130_fd_pr__pfet_01v8 L=0.15 W=4 nf=1 ad=1.16 as=1.16 pd=8.58 ps=8.58 nrd=0.0725 nrs=0.0725 sa=0 sb=0 sd=0 mult=1 m=1
bd_m00_w1 d_m00_w1 0 v=v(sbl_m00_w1)-v(sref_m00_w1)
bdabs_m00_w1 dabs_m00_w1 0 v=abs(v(sbl_m00_w1)-v(sref_m00_w1))

* ---- instance 35: m00_w0 (baseline: TG nfet 1.0 / pfet 2.0, dummy 1x, lead 0.5 ns [matched ref precharge]) ----
XMWR_m00_w0_0 sn_m00_w0_0 wl wbl_m00_w0 0 sky130_fd_pr__nfet_01v8 L=0.15 W=0.42 nf=1 ad=0.1218 as=0.1218 pd=1.42 ps=1.42 nrd=0.69047619047619 nrs=0.69047619047619 sa=0 sb=0 sd=0 mult=1 m=1
XMRD_m00_w0_0 rbl_m00_w0 sn_m00_w0_0 rwl_sel 0 sky130_fd_pr__nfet_01v8 L=0.15 W=0.42 nf=1 ad=0.1218 as=0.1218 pd=1.42 ps=1.42 nrd=0.69047619047619 nrs=0.69047619047619 sa=0 sb=0 sd=0 mult=1 m=1
csn_m00_w0_0 sn_m00_w0_0 0 {C_SN}
XMWR_m00_w0_1 sn_m00_w0_1 0 wbl_m00_w0 0 sky130_fd_pr__nfet_01v8 L=0.15 W=0.42 nf=1 ad=0.1218 as=0.1218 pd=1.42 ps=1.42 nrd=0.69047619047619 nrs=0.69047619047619 sa=0 sb=0 sd=0 mult=1 m=1
XMRD_m00_w0_1 rbl_m00_w0 sn_m00_w0_1 rwl_des 0 sky130_fd_pr__nfet_01v8 L=0.15 W=0.42 nf=1 ad=0.1218 as=0.1218 pd=1.42 ps=1.42 nrd=0.69047619047619 nrs=0.69047619047619 sa=0 sb=0 sd=0 mult=1 m=1
csn_m00_w0_1 sn_m00_w0_1 0 {C_SN}
XMWR_m00_w0_2 sn_m00_w0_2 0 wbl_m00_w0 0 sky130_fd_pr__nfet_01v8 L=0.15 W=0.42 nf=1 ad=0.1218 as=0.1218 pd=1.42 ps=1.42 nrd=0.69047619047619 nrs=0.69047619047619 sa=0 sb=0 sd=0 mult=1 m=1
XMRD_m00_w0_2 rbl_m00_w0 sn_m00_w0_2 rwl_des 0 sky130_fd_pr__nfet_01v8 L=0.15 W=0.42 nf=1 ad=0.1218 as=0.1218 pd=1.42 ps=1.42 nrd=0.69047619047619 nrs=0.69047619047619 sa=0 sb=0 sd=0 mult=1 m=1
csn_m00_w0_2 sn_m00_w0_2 0 {C_SN}
XMWR_m00_w0_3 sn_m00_w0_3 0 wbl_m00_w0 0 sky130_fd_pr__nfet_01v8 L=0.15 W=0.42 nf=1 ad=0.1218 as=0.1218 pd=1.42 ps=1.42 nrd=0.69047619047619 nrs=0.69047619047619 sa=0 sb=0 sd=0 mult=1 m=1
XMRD_m00_w0_3 rbl_m00_w0 sn_m00_w0_3 rwl_des 0 sky130_fd_pr__nfet_01v8 L=0.15 W=0.42 nf=1 ad=0.1218 as=0.1218 pd=1.42 ps=1.42 nrd=0.69047619047619 nrs=0.69047619047619 sa=0 sb=0 sd=0 mult=1 m=1
csn_m00_w0_3 sn_m00_w0_3 0 {C_SN}
crbl_m00_w0 rbl_m00_w0 0 {C_RBL}
cwbl_m00_w0 wbl_m00_w0 0 {C_WBL}
cref_m00_w0 ref_m00_w0 0 {C_RBL}   $ ASSUMPTION: ideal matched dummy load
XMPPRE_m00_w0 rbl_m00_w0 pcb_100 prea prea sky130_fd_pr__pfet_01v8 L=0.15 W=4 nf=1 ad=1.16 as=1.16 pd=8.58 ps=8.58 nrd=0.0725 nrs=0.0725 sa=0 sb=0 sd=0 mult=1 m=1
XMPU1_m00_w0 x_m00_w0 dinb0 vdd vdd sky130_fd_pr__pfet_01v8 L=0.15 W=1 nf=1 ad=0.29 as=0.29 pd=2.58 ps=2.58 nrd=0.29 nrs=0.29 sa=0 sb=0 sd=0 mult=1 m=1
XMPU2_m00_w0 wbl_m00_w0 wenb x_m00_w0 vdd sky130_fd_pr__pfet_01v8 L=0.15 W=1 nf=1 ad=0.29 as=0.29 pd=2.58 ps=2.58 nrd=0.29 nrs=0.29 sa=0 sb=0 sd=0 mult=1 m=1
XMND2_m00_w0 wbl_m00_w0 wen y_m00_w0 0 sky130_fd_pr__nfet_01v8 L=0.15 W=0.5 nf=1 ad=0.145 as=0.145 pd=1.58 ps=1.58 nrd=0.58 nrs=0.58 sa=0 sb=0 sd=0 mult=1 m=1
XMND1_m00_w0 y_m00_w0 dinb0 0 0 sky130_fd_pr__nfet_01v8 L=0.15 W=0.5 nf=1 ad=0.145 as=0.145 pd=1.58 ps=1.58 nrd=0.58 nrs=0.58 sa=0 sb=0 sd=0 mult=1 m=1
XMNI_m00_w0 wbl_m00_w0 wenb 0 0 sky130_fd_pr__nfet_01v8 L=0.15 W=0.42 nf=1 ad=0.1218 as=0.1218 pd=1.42 ps=1.42 nrd=0.69047619047619 nrs=0.69047619047619 sa=0 sb=0 sd=0 mult=1 m=1
XMNS_m00_w0 sbl_m00_w0 sel_69500 rbl_m00_w0 0 sky130_fd_pr__nfet_01v8 L=0.15 W=1 nf=1 ad=0.29 as=0.29 pd=2.58 ps=2.58 nrd=0.29 nrs=0.29 sa=0 sb=0 sd=0 mult=1 m=1
XMPS_m00_w0 sbl_m00_w0 selb_69500 rbl_m00_w0 vdd sky130_fd_pr__pfet_01v8 L=0.15 W=2 nf=1 ad=0.58 as=0.58 pd=4.58 ps=4.58 nrd=0.145 nrs=0.145 sa=0 sb=0 sd=0 mult=1 m=1
XMNSR_m00_w0 sref_m00_w0 sel_69500 ref_m00_w0 0 sky130_fd_pr__nfet_01v8 L=0.15 W=1 nf=1 ad=0.29 as=0.29 pd=2.58 ps=2.58 nrd=0.29 nrs=0.29 sa=0 sb=0 sd=0 mult=1 m=1
XMPSR_m00_w0 sref_m00_w0 selb_69500 ref_m00_w0 vdd sky130_fd_pr__pfet_01v8 L=0.15 W=2 nf=1 ad=0.58 as=0.58 pd=4.58 ps=4.58 nrd=0.145 nrs=0.145 sa=0 sb=0 sd=0 mult=1 m=1
XMPPREF_m00_w0 ref_m00_w0 pcb_100 pref pref sky130_fd_pr__pfet_01v8 L=0.15 W=4 nf=1 ad=1.16 as=1.16 pd=8.58 ps=8.58 nrd=0.0725 nrs=0.0725 sa=0 sb=0 sd=0 mult=1 m=1   $ reference-side precharge: copy of MPPRE
XMN1_m00_w0 sbl_m00_w0 sref_m00_w0 vn_m00_w0 0 sky130_fd_pr__nfet_01v8 L=0.15 W=1 nf=1 ad=0.29 as=0.29 pd=2.58 ps=2.58 nrd=0.29 nrs=0.29 sa=0 sb=0 sd=0 mult=1 m=1
XMN2_m00_w0 sref_m00_w0 sbl_m00_w0 vn_m00_w0 0 sky130_fd_pr__nfet_01v8 L=0.15 W=1 nf=1 ad=0.29 as=0.29 pd=2.58 ps=2.58 nrd=0.29 nrs=0.29 sa=0 sb=0 sd=0 mult=1 m=1
XMP1_m00_w0 sbl_m00_w0 sref_m00_w0 vp_m00_w0 vdd sky130_fd_pr__pfet_01v8 L=0.15 W=2 nf=1 ad=0.58 as=0.58 pd=4.58 ps=4.58 nrd=0.145 nrs=0.145 sa=0 sb=0 sd=0 mult=1 m=1
XMP2_m00_w0 sref_m00_w0 sbl_m00_w0 vp_m00_w0 vdd sky130_fd_pr__pfet_01v8 L=0.15 W=2 nf=1 ad=0.58 as=0.58 pd=4.58 ps=4.58 nrd=0.145 nrs=0.145 sa=0 sb=0 sd=0 mult=1 m=1
XMNF_m00_w0 vn_m00_w0 en 0 0 sky130_fd_pr__nfet_01v8 L=0.15 W=2 nf=1 ad=0.58 as=0.58 pd=4.58 ps=4.58 nrd=0.145 nrs=0.145 sa=0 sb=0 sd=0 mult=1 m=1
XMPH_m00_w0 vp_m00_w0 enb vdd vdd sky130_fd_pr__pfet_01v8 L=0.15 W=4 nf=1 ad=1.16 as=1.16 pd=8.58 ps=8.58 nrd=0.0725 nrs=0.0725 sa=0 sb=0 sd=0 mult=1 m=1
bd_m00_w0 d_m00_w0 0 v=v(sbl_m00_w0)-v(sref_m00_w0)
bdabs_m00_w0 dabs_m00_w0 0 v=abs(v(sbl_m00_w0)-v(sref_m00_w0))

* ---- instance 36: m01_w1 (lead 0.1 ns [matched ref precharge]) ----
XMWR_m01_w1_0 sn_m01_w1_0 wl wbl_m01_w1 0 sky130_fd_pr__nfet_01v8 L=0.15 W=0.42 nf=1 ad=0.1218 as=0.1218 pd=1.42 ps=1.42 nrd=0.69047619047619 nrs=0.69047619047619 sa=0 sb=0 sd=0 mult=1 m=1
XMRD_m01_w1_0 rbl_m01_w1 sn_m01_w1_0 rwl_sel 0 sky130_fd_pr__nfet_01v8 L=0.15 W=0.42 nf=1 ad=0.1218 as=0.1218 pd=1.42 ps=1.42 nrd=0.69047619047619 nrs=0.69047619047619 sa=0 sb=0 sd=0 mult=1 m=1
csn_m01_w1_0 sn_m01_w1_0 0 {C_SN}
XMWR_m01_w1_1 sn_m01_w1_1 0 wbl_m01_w1 0 sky130_fd_pr__nfet_01v8 L=0.15 W=0.42 nf=1 ad=0.1218 as=0.1218 pd=1.42 ps=1.42 nrd=0.69047619047619 nrs=0.69047619047619 sa=0 sb=0 sd=0 mult=1 m=1
XMRD_m01_w1_1 rbl_m01_w1 sn_m01_w1_1 rwl_des 0 sky130_fd_pr__nfet_01v8 L=0.15 W=0.42 nf=1 ad=0.1218 as=0.1218 pd=1.42 ps=1.42 nrd=0.69047619047619 nrs=0.69047619047619 sa=0 sb=0 sd=0 mult=1 m=1
csn_m01_w1_1 sn_m01_w1_1 0 {C_SN}
XMWR_m01_w1_2 sn_m01_w1_2 0 wbl_m01_w1 0 sky130_fd_pr__nfet_01v8 L=0.15 W=0.42 nf=1 ad=0.1218 as=0.1218 pd=1.42 ps=1.42 nrd=0.69047619047619 nrs=0.69047619047619 sa=0 sb=0 sd=0 mult=1 m=1
XMRD_m01_w1_2 rbl_m01_w1 sn_m01_w1_2 rwl_des 0 sky130_fd_pr__nfet_01v8 L=0.15 W=0.42 nf=1 ad=0.1218 as=0.1218 pd=1.42 ps=1.42 nrd=0.69047619047619 nrs=0.69047619047619 sa=0 sb=0 sd=0 mult=1 m=1
csn_m01_w1_2 sn_m01_w1_2 0 {C_SN}
XMWR_m01_w1_3 sn_m01_w1_3 0 wbl_m01_w1 0 sky130_fd_pr__nfet_01v8 L=0.15 W=0.42 nf=1 ad=0.1218 as=0.1218 pd=1.42 ps=1.42 nrd=0.69047619047619 nrs=0.69047619047619 sa=0 sb=0 sd=0 mult=1 m=1
XMRD_m01_w1_3 rbl_m01_w1 sn_m01_w1_3 rwl_des 0 sky130_fd_pr__nfet_01v8 L=0.15 W=0.42 nf=1 ad=0.1218 as=0.1218 pd=1.42 ps=1.42 nrd=0.69047619047619 nrs=0.69047619047619 sa=0 sb=0 sd=0 mult=1 m=1
csn_m01_w1_3 sn_m01_w1_3 0 {C_SN}
crbl_m01_w1 rbl_m01_w1 0 {C_RBL}
cwbl_m01_w1 wbl_m01_w1 0 {C_WBL}
cref_m01_w1 ref_m01_w1 0 {C_RBL}   $ ASSUMPTION: ideal matched dummy load
XMPPRE_m01_w1 rbl_m01_w1 pcb_100 prea prea sky130_fd_pr__pfet_01v8 L=0.15 W=4 nf=1 ad=1.16 as=1.16 pd=8.58 ps=8.58 nrd=0.0725 nrs=0.0725 sa=0 sb=0 sd=0 mult=1 m=1
XMPU1_m01_w1 x_m01_w1 dinb1 vdd vdd sky130_fd_pr__pfet_01v8 L=0.15 W=1 nf=1 ad=0.29 as=0.29 pd=2.58 ps=2.58 nrd=0.29 nrs=0.29 sa=0 sb=0 sd=0 mult=1 m=1
XMPU2_m01_w1 wbl_m01_w1 wenb x_m01_w1 vdd sky130_fd_pr__pfet_01v8 L=0.15 W=1 nf=1 ad=0.29 as=0.29 pd=2.58 ps=2.58 nrd=0.29 nrs=0.29 sa=0 sb=0 sd=0 mult=1 m=1
XMND2_m01_w1 wbl_m01_w1 wen y_m01_w1 0 sky130_fd_pr__nfet_01v8 L=0.15 W=0.5 nf=1 ad=0.145 as=0.145 pd=1.58 ps=1.58 nrd=0.58 nrs=0.58 sa=0 sb=0 sd=0 mult=1 m=1
XMND1_m01_w1 y_m01_w1 dinb1 0 0 sky130_fd_pr__nfet_01v8 L=0.15 W=0.5 nf=1 ad=0.145 as=0.145 pd=1.58 ps=1.58 nrd=0.58 nrs=0.58 sa=0 sb=0 sd=0 mult=1 m=1
XMNI_m01_w1 wbl_m01_w1 wenb 0 0 sky130_fd_pr__nfet_01v8 L=0.15 W=0.42 nf=1 ad=0.1218 as=0.1218 pd=1.42 ps=1.42 nrd=0.69047619047619 nrs=0.69047619047619 sa=0 sb=0 sd=0 mult=1 m=1
XMNS_m01_w1 sbl_m01_w1 sel_69900 rbl_m01_w1 0 sky130_fd_pr__nfet_01v8 L=0.15 W=1 nf=1 ad=0.29 as=0.29 pd=2.58 ps=2.58 nrd=0.29 nrs=0.29 sa=0 sb=0 sd=0 mult=1 m=1
XMPS_m01_w1 sbl_m01_w1 selb_69900 rbl_m01_w1 vdd sky130_fd_pr__pfet_01v8 L=0.15 W=2 nf=1 ad=0.58 as=0.58 pd=4.58 ps=4.58 nrd=0.145 nrs=0.145 sa=0 sb=0 sd=0 mult=1 m=1
XMNSR_m01_w1 sref_m01_w1 sel_69900 ref_m01_w1 0 sky130_fd_pr__nfet_01v8 L=0.15 W=1 nf=1 ad=0.29 as=0.29 pd=2.58 ps=2.58 nrd=0.29 nrs=0.29 sa=0 sb=0 sd=0 mult=1 m=1
XMPSR_m01_w1 sref_m01_w1 selb_69900 ref_m01_w1 vdd sky130_fd_pr__pfet_01v8 L=0.15 W=2 nf=1 ad=0.58 as=0.58 pd=4.58 ps=4.58 nrd=0.145 nrs=0.145 sa=0 sb=0 sd=0 mult=1 m=1
XMPPREF_m01_w1 ref_m01_w1 pcb_100 pref pref sky130_fd_pr__pfet_01v8 L=0.15 W=4 nf=1 ad=1.16 as=1.16 pd=8.58 ps=8.58 nrd=0.0725 nrs=0.0725 sa=0 sb=0 sd=0 mult=1 m=1   $ reference-side precharge: copy of MPPRE
XMN1_m01_w1 sbl_m01_w1 sref_m01_w1 vn_m01_w1 0 sky130_fd_pr__nfet_01v8 L=0.15 W=1 nf=1 ad=0.29 as=0.29 pd=2.58 ps=2.58 nrd=0.29 nrs=0.29 sa=0 sb=0 sd=0 mult=1 m=1
XMN2_m01_w1 sref_m01_w1 sbl_m01_w1 vn_m01_w1 0 sky130_fd_pr__nfet_01v8 L=0.15 W=1 nf=1 ad=0.29 as=0.29 pd=2.58 ps=2.58 nrd=0.29 nrs=0.29 sa=0 sb=0 sd=0 mult=1 m=1
XMP1_m01_w1 sbl_m01_w1 sref_m01_w1 vp_m01_w1 vdd sky130_fd_pr__pfet_01v8 L=0.15 W=2 nf=1 ad=0.58 as=0.58 pd=4.58 ps=4.58 nrd=0.145 nrs=0.145 sa=0 sb=0 sd=0 mult=1 m=1
XMP2_m01_w1 sref_m01_w1 sbl_m01_w1 vp_m01_w1 vdd sky130_fd_pr__pfet_01v8 L=0.15 W=2 nf=1 ad=0.58 as=0.58 pd=4.58 ps=4.58 nrd=0.145 nrs=0.145 sa=0 sb=0 sd=0 mult=1 m=1
XMNF_m01_w1 vn_m01_w1 en 0 0 sky130_fd_pr__nfet_01v8 L=0.15 W=2 nf=1 ad=0.58 as=0.58 pd=4.58 ps=4.58 nrd=0.145 nrs=0.145 sa=0 sb=0 sd=0 mult=1 m=1
XMPH_m01_w1 vp_m01_w1 enb vdd vdd sky130_fd_pr__pfet_01v8 L=0.15 W=4 nf=1 ad=1.16 as=1.16 pd=8.58 ps=8.58 nrd=0.0725 nrs=0.0725 sa=0 sb=0 sd=0 mult=1 m=1
bd_m01_w1 d_m01_w1 0 v=v(sbl_m01_w1)-v(sref_m01_w1)
bdabs_m01_w1 dabs_m01_w1 0 v=abs(v(sbl_m01_w1)-v(sref_m01_w1))

* ---- instance 37: m01_w0 (lead 0.1 ns [matched ref precharge]) ----
XMWR_m01_w0_0 sn_m01_w0_0 wl wbl_m01_w0 0 sky130_fd_pr__nfet_01v8 L=0.15 W=0.42 nf=1 ad=0.1218 as=0.1218 pd=1.42 ps=1.42 nrd=0.69047619047619 nrs=0.69047619047619 sa=0 sb=0 sd=0 mult=1 m=1
XMRD_m01_w0_0 rbl_m01_w0 sn_m01_w0_0 rwl_sel 0 sky130_fd_pr__nfet_01v8 L=0.15 W=0.42 nf=1 ad=0.1218 as=0.1218 pd=1.42 ps=1.42 nrd=0.69047619047619 nrs=0.69047619047619 sa=0 sb=0 sd=0 mult=1 m=1
csn_m01_w0_0 sn_m01_w0_0 0 {C_SN}
XMWR_m01_w0_1 sn_m01_w0_1 0 wbl_m01_w0 0 sky130_fd_pr__nfet_01v8 L=0.15 W=0.42 nf=1 ad=0.1218 as=0.1218 pd=1.42 ps=1.42 nrd=0.69047619047619 nrs=0.69047619047619 sa=0 sb=0 sd=0 mult=1 m=1
XMRD_m01_w0_1 rbl_m01_w0 sn_m01_w0_1 rwl_des 0 sky130_fd_pr__nfet_01v8 L=0.15 W=0.42 nf=1 ad=0.1218 as=0.1218 pd=1.42 ps=1.42 nrd=0.69047619047619 nrs=0.69047619047619 sa=0 sb=0 sd=0 mult=1 m=1
csn_m01_w0_1 sn_m01_w0_1 0 {C_SN}
XMWR_m01_w0_2 sn_m01_w0_2 0 wbl_m01_w0 0 sky130_fd_pr__nfet_01v8 L=0.15 W=0.42 nf=1 ad=0.1218 as=0.1218 pd=1.42 ps=1.42 nrd=0.69047619047619 nrs=0.69047619047619 sa=0 sb=0 sd=0 mult=1 m=1
XMRD_m01_w0_2 rbl_m01_w0 sn_m01_w0_2 rwl_des 0 sky130_fd_pr__nfet_01v8 L=0.15 W=0.42 nf=1 ad=0.1218 as=0.1218 pd=1.42 ps=1.42 nrd=0.69047619047619 nrs=0.69047619047619 sa=0 sb=0 sd=0 mult=1 m=1
csn_m01_w0_2 sn_m01_w0_2 0 {C_SN}
XMWR_m01_w0_3 sn_m01_w0_3 0 wbl_m01_w0 0 sky130_fd_pr__nfet_01v8 L=0.15 W=0.42 nf=1 ad=0.1218 as=0.1218 pd=1.42 ps=1.42 nrd=0.69047619047619 nrs=0.69047619047619 sa=0 sb=0 sd=0 mult=1 m=1
XMRD_m01_w0_3 rbl_m01_w0 sn_m01_w0_3 rwl_des 0 sky130_fd_pr__nfet_01v8 L=0.15 W=0.42 nf=1 ad=0.1218 as=0.1218 pd=1.42 ps=1.42 nrd=0.69047619047619 nrs=0.69047619047619 sa=0 sb=0 sd=0 mult=1 m=1
csn_m01_w0_3 sn_m01_w0_3 0 {C_SN}
crbl_m01_w0 rbl_m01_w0 0 {C_RBL}
cwbl_m01_w0 wbl_m01_w0 0 {C_WBL}
cref_m01_w0 ref_m01_w0 0 {C_RBL}   $ ASSUMPTION: ideal matched dummy load
XMPPRE_m01_w0 rbl_m01_w0 pcb_100 prea prea sky130_fd_pr__pfet_01v8 L=0.15 W=4 nf=1 ad=1.16 as=1.16 pd=8.58 ps=8.58 nrd=0.0725 nrs=0.0725 sa=0 sb=0 sd=0 mult=1 m=1
XMPU1_m01_w0 x_m01_w0 dinb0 vdd vdd sky130_fd_pr__pfet_01v8 L=0.15 W=1 nf=1 ad=0.29 as=0.29 pd=2.58 ps=2.58 nrd=0.29 nrs=0.29 sa=0 sb=0 sd=0 mult=1 m=1
XMPU2_m01_w0 wbl_m01_w0 wenb x_m01_w0 vdd sky130_fd_pr__pfet_01v8 L=0.15 W=1 nf=1 ad=0.29 as=0.29 pd=2.58 ps=2.58 nrd=0.29 nrs=0.29 sa=0 sb=0 sd=0 mult=1 m=1
XMND2_m01_w0 wbl_m01_w0 wen y_m01_w0 0 sky130_fd_pr__nfet_01v8 L=0.15 W=0.5 nf=1 ad=0.145 as=0.145 pd=1.58 ps=1.58 nrd=0.58 nrs=0.58 sa=0 sb=0 sd=0 mult=1 m=1
XMND1_m01_w0 y_m01_w0 dinb0 0 0 sky130_fd_pr__nfet_01v8 L=0.15 W=0.5 nf=1 ad=0.145 as=0.145 pd=1.58 ps=1.58 nrd=0.58 nrs=0.58 sa=0 sb=0 sd=0 mult=1 m=1
XMNI_m01_w0 wbl_m01_w0 wenb 0 0 sky130_fd_pr__nfet_01v8 L=0.15 W=0.42 nf=1 ad=0.1218 as=0.1218 pd=1.42 ps=1.42 nrd=0.69047619047619 nrs=0.69047619047619 sa=0 sb=0 sd=0 mult=1 m=1
XMNS_m01_w0 sbl_m01_w0 sel_69900 rbl_m01_w0 0 sky130_fd_pr__nfet_01v8 L=0.15 W=1 nf=1 ad=0.29 as=0.29 pd=2.58 ps=2.58 nrd=0.29 nrs=0.29 sa=0 sb=0 sd=0 mult=1 m=1
XMPS_m01_w0 sbl_m01_w0 selb_69900 rbl_m01_w0 vdd sky130_fd_pr__pfet_01v8 L=0.15 W=2 nf=1 ad=0.58 as=0.58 pd=4.58 ps=4.58 nrd=0.145 nrs=0.145 sa=0 sb=0 sd=0 mult=1 m=1
XMNSR_m01_w0 sref_m01_w0 sel_69900 ref_m01_w0 0 sky130_fd_pr__nfet_01v8 L=0.15 W=1 nf=1 ad=0.29 as=0.29 pd=2.58 ps=2.58 nrd=0.29 nrs=0.29 sa=0 sb=0 sd=0 mult=1 m=1
XMPSR_m01_w0 sref_m01_w0 selb_69900 ref_m01_w0 vdd sky130_fd_pr__pfet_01v8 L=0.15 W=2 nf=1 ad=0.58 as=0.58 pd=4.58 ps=4.58 nrd=0.145 nrs=0.145 sa=0 sb=0 sd=0 mult=1 m=1
XMPPREF_m01_w0 ref_m01_w0 pcb_100 pref pref sky130_fd_pr__pfet_01v8 L=0.15 W=4 nf=1 ad=1.16 as=1.16 pd=8.58 ps=8.58 nrd=0.0725 nrs=0.0725 sa=0 sb=0 sd=0 mult=1 m=1   $ reference-side precharge: copy of MPPRE
XMN1_m01_w0 sbl_m01_w0 sref_m01_w0 vn_m01_w0 0 sky130_fd_pr__nfet_01v8 L=0.15 W=1 nf=1 ad=0.29 as=0.29 pd=2.58 ps=2.58 nrd=0.29 nrs=0.29 sa=0 sb=0 sd=0 mult=1 m=1
XMN2_m01_w0 sref_m01_w0 sbl_m01_w0 vn_m01_w0 0 sky130_fd_pr__nfet_01v8 L=0.15 W=1 nf=1 ad=0.29 as=0.29 pd=2.58 ps=2.58 nrd=0.29 nrs=0.29 sa=0 sb=0 sd=0 mult=1 m=1
XMP1_m01_w0 sbl_m01_w0 sref_m01_w0 vp_m01_w0 vdd sky130_fd_pr__pfet_01v8 L=0.15 W=2 nf=1 ad=0.58 as=0.58 pd=4.58 ps=4.58 nrd=0.145 nrs=0.145 sa=0 sb=0 sd=0 mult=1 m=1
XMP2_m01_w0 sref_m01_w0 sbl_m01_w0 vp_m01_w0 vdd sky130_fd_pr__pfet_01v8 L=0.15 W=2 nf=1 ad=0.58 as=0.58 pd=4.58 ps=4.58 nrd=0.145 nrs=0.145 sa=0 sb=0 sd=0 mult=1 m=1
XMNF_m01_w0 vn_m01_w0 en 0 0 sky130_fd_pr__nfet_01v8 L=0.15 W=2 nf=1 ad=0.58 as=0.58 pd=4.58 ps=4.58 nrd=0.145 nrs=0.145 sa=0 sb=0 sd=0 mult=1 m=1
XMPH_m01_w0 vp_m01_w0 enb vdd vdd sky130_fd_pr__pfet_01v8 L=0.15 W=4 nf=1 ad=1.16 as=1.16 pd=8.58 ps=8.58 nrd=0.0725 nrs=0.0725 sa=0 sb=0 sd=0 mult=1 m=1
bd_m01_w0 d_m01_w0 0 v=v(sbl_m01_w0)-v(sref_m01_w0)
bdabs_m01_w0 dabs_m01_w0 0 v=abs(v(sbl_m01_w0)-v(sref_m01_w0))

* ---- instance 38: m02_w1 (lead 1.0 ns [matched ref precharge]) ----
XMWR_m02_w1_0 sn_m02_w1_0 wl wbl_m02_w1 0 sky130_fd_pr__nfet_01v8 L=0.15 W=0.42 nf=1 ad=0.1218 as=0.1218 pd=1.42 ps=1.42 nrd=0.69047619047619 nrs=0.69047619047619 sa=0 sb=0 sd=0 mult=1 m=1
XMRD_m02_w1_0 rbl_m02_w1 sn_m02_w1_0 rwl_sel 0 sky130_fd_pr__nfet_01v8 L=0.15 W=0.42 nf=1 ad=0.1218 as=0.1218 pd=1.42 ps=1.42 nrd=0.69047619047619 nrs=0.69047619047619 sa=0 sb=0 sd=0 mult=1 m=1
csn_m02_w1_0 sn_m02_w1_0 0 {C_SN}
XMWR_m02_w1_1 sn_m02_w1_1 0 wbl_m02_w1 0 sky130_fd_pr__nfet_01v8 L=0.15 W=0.42 nf=1 ad=0.1218 as=0.1218 pd=1.42 ps=1.42 nrd=0.69047619047619 nrs=0.69047619047619 sa=0 sb=0 sd=0 mult=1 m=1
XMRD_m02_w1_1 rbl_m02_w1 sn_m02_w1_1 rwl_des 0 sky130_fd_pr__nfet_01v8 L=0.15 W=0.42 nf=1 ad=0.1218 as=0.1218 pd=1.42 ps=1.42 nrd=0.69047619047619 nrs=0.69047619047619 sa=0 sb=0 sd=0 mult=1 m=1
csn_m02_w1_1 sn_m02_w1_1 0 {C_SN}
XMWR_m02_w1_2 sn_m02_w1_2 0 wbl_m02_w1 0 sky130_fd_pr__nfet_01v8 L=0.15 W=0.42 nf=1 ad=0.1218 as=0.1218 pd=1.42 ps=1.42 nrd=0.69047619047619 nrs=0.69047619047619 sa=0 sb=0 sd=0 mult=1 m=1
XMRD_m02_w1_2 rbl_m02_w1 sn_m02_w1_2 rwl_des 0 sky130_fd_pr__nfet_01v8 L=0.15 W=0.42 nf=1 ad=0.1218 as=0.1218 pd=1.42 ps=1.42 nrd=0.69047619047619 nrs=0.69047619047619 sa=0 sb=0 sd=0 mult=1 m=1
csn_m02_w1_2 sn_m02_w1_2 0 {C_SN}
XMWR_m02_w1_3 sn_m02_w1_3 0 wbl_m02_w1 0 sky130_fd_pr__nfet_01v8 L=0.15 W=0.42 nf=1 ad=0.1218 as=0.1218 pd=1.42 ps=1.42 nrd=0.69047619047619 nrs=0.69047619047619 sa=0 sb=0 sd=0 mult=1 m=1
XMRD_m02_w1_3 rbl_m02_w1 sn_m02_w1_3 rwl_des 0 sky130_fd_pr__nfet_01v8 L=0.15 W=0.42 nf=1 ad=0.1218 as=0.1218 pd=1.42 ps=1.42 nrd=0.69047619047619 nrs=0.69047619047619 sa=0 sb=0 sd=0 mult=1 m=1
csn_m02_w1_3 sn_m02_w1_3 0 {C_SN}
crbl_m02_w1 rbl_m02_w1 0 {C_RBL}
cwbl_m02_w1 wbl_m02_w1 0 {C_WBL}
cref_m02_w1 ref_m02_w1 0 {C_RBL}   $ ASSUMPTION: ideal matched dummy load
XMPPRE_m02_w1 rbl_m02_w1 pcb_100 prea prea sky130_fd_pr__pfet_01v8 L=0.15 W=4 nf=1 ad=1.16 as=1.16 pd=8.58 ps=8.58 nrd=0.0725 nrs=0.0725 sa=0 sb=0 sd=0 mult=1 m=1
XMPU1_m02_w1 x_m02_w1 dinb1 vdd vdd sky130_fd_pr__pfet_01v8 L=0.15 W=1 nf=1 ad=0.29 as=0.29 pd=2.58 ps=2.58 nrd=0.29 nrs=0.29 sa=0 sb=0 sd=0 mult=1 m=1
XMPU2_m02_w1 wbl_m02_w1 wenb x_m02_w1 vdd sky130_fd_pr__pfet_01v8 L=0.15 W=1 nf=1 ad=0.29 as=0.29 pd=2.58 ps=2.58 nrd=0.29 nrs=0.29 sa=0 sb=0 sd=0 mult=1 m=1
XMND2_m02_w1 wbl_m02_w1 wen y_m02_w1 0 sky130_fd_pr__nfet_01v8 L=0.15 W=0.5 nf=1 ad=0.145 as=0.145 pd=1.58 ps=1.58 nrd=0.58 nrs=0.58 sa=0 sb=0 sd=0 mult=1 m=1
XMND1_m02_w1 y_m02_w1 dinb1 0 0 sky130_fd_pr__nfet_01v8 L=0.15 W=0.5 nf=1 ad=0.145 as=0.145 pd=1.58 ps=1.58 nrd=0.58 nrs=0.58 sa=0 sb=0 sd=0 mult=1 m=1
XMNI_m02_w1 wbl_m02_w1 wenb 0 0 sky130_fd_pr__nfet_01v8 L=0.15 W=0.42 nf=1 ad=0.1218 as=0.1218 pd=1.42 ps=1.42 nrd=0.69047619047619 nrs=0.69047619047619 sa=0 sb=0 sd=0 mult=1 m=1
XMNS_m02_w1 sbl_m02_w1 sel_69000 rbl_m02_w1 0 sky130_fd_pr__nfet_01v8 L=0.15 W=1 nf=1 ad=0.29 as=0.29 pd=2.58 ps=2.58 nrd=0.29 nrs=0.29 sa=0 sb=0 sd=0 mult=1 m=1
XMPS_m02_w1 sbl_m02_w1 selb_69000 rbl_m02_w1 vdd sky130_fd_pr__pfet_01v8 L=0.15 W=2 nf=1 ad=0.58 as=0.58 pd=4.58 ps=4.58 nrd=0.145 nrs=0.145 sa=0 sb=0 sd=0 mult=1 m=1
XMNSR_m02_w1 sref_m02_w1 sel_69000 ref_m02_w1 0 sky130_fd_pr__nfet_01v8 L=0.15 W=1 nf=1 ad=0.29 as=0.29 pd=2.58 ps=2.58 nrd=0.29 nrs=0.29 sa=0 sb=0 sd=0 mult=1 m=1
XMPSR_m02_w1 sref_m02_w1 selb_69000 ref_m02_w1 vdd sky130_fd_pr__pfet_01v8 L=0.15 W=2 nf=1 ad=0.58 as=0.58 pd=4.58 ps=4.58 nrd=0.145 nrs=0.145 sa=0 sb=0 sd=0 mult=1 m=1
XMPPREF_m02_w1 ref_m02_w1 pcb_100 pref pref sky130_fd_pr__pfet_01v8 L=0.15 W=4 nf=1 ad=1.16 as=1.16 pd=8.58 ps=8.58 nrd=0.0725 nrs=0.0725 sa=0 sb=0 sd=0 mult=1 m=1   $ reference-side precharge: copy of MPPRE
XMN1_m02_w1 sbl_m02_w1 sref_m02_w1 vn_m02_w1 0 sky130_fd_pr__nfet_01v8 L=0.15 W=1 nf=1 ad=0.29 as=0.29 pd=2.58 ps=2.58 nrd=0.29 nrs=0.29 sa=0 sb=0 sd=0 mult=1 m=1
XMN2_m02_w1 sref_m02_w1 sbl_m02_w1 vn_m02_w1 0 sky130_fd_pr__nfet_01v8 L=0.15 W=1 nf=1 ad=0.29 as=0.29 pd=2.58 ps=2.58 nrd=0.29 nrs=0.29 sa=0 sb=0 sd=0 mult=1 m=1
XMP1_m02_w1 sbl_m02_w1 sref_m02_w1 vp_m02_w1 vdd sky130_fd_pr__pfet_01v8 L=0.15 W=2 nf=1 ad=0.58 as=0.58 pd=4.58 ps=4.58 nrd=0.145 nrs=0.145 sa=0 sb=0 sd=0 mult=1 m=1
XMP2_m02_w1 sref_m02_w1 sbl_m02_w1 vp_m02_w1 vdd sky130_fd_pr__pfet_01v8 L=0.15 W=2 nf=1 ad=0.58 as=0.58 pd=4.58 ps=4.58 nrd=0.145 nrs=0.145 sa=0 sb=0 sd=0 mult=1 m=1
XMNF_m02_w1 vn_m02_w1 en 0 0 sky130_fd_pr__nfet_01v8 L=0.15 W=2 nf=1 ad=0.58 as=0.58 pd=4.58 ps=4.58 nrd=0.145 nrs=0.145 sa=0 sb=0 sd=0 mult=1 m=1
XMPH_m02_w1 vp_m02_w1 enb vdd vdd sky130_fd_pr__pfet_01v8 L=0.15 W=4 nf=1 ad=1.16 as=1.16 pd=8.58 ps=8.58 nrd=0.0725 nrs=0.0725 sa=0 sb=0 sd=0 mult=1 m=1
bd_m02_w1 d_m02_w1 0 v=v(sbl_m02_w1)-v(sref_m02_w1)
bdabs_m02_w1 dabs_m02_w1 0 v=abs(v(sbl_m02_w1)-v(sref_m02_w1))

* ---- instance 39: m02_w0 (lead 1.0 ns [matched ref precharge]) ----
XMWR_m02_w0_0 sn_m02_w0_0 wl wbl_m02_w0 0 sky130_fd_pr__nfet_01v8 L=0.15 W=0.42 nf=1 ad=0.1218 as=0.1218 pd=1.42 ps=1.42 nrd=0.69047619047619 nrs=0.69047619047619 sa=0 sb=0 sd=0 mult=1 m=1
XMRD_m02_w0_0 rbl_m02_w0 sn_m02_w0_0 rwl_sel 0 sky130_fd_pr__nfet_01v8 L=0.15 W=0.42 nf=1 ad=0.1218 as=0.1218 pd=1.42 ps=1.42 nrd=0.69047619047619 nrs=0.69047619047619 sa=0 sb=0 sd=0 mult=1 m=1
csn_m02_w0_0 sn_m02_w0_0 0 {C_SN}
XMWR_m02_w0_1 sn_m02_w0_1 0 wbl_m02_w0 0 sky130_fd_pr__nfet_01v8 L=0.15 W=0.42 nf=1 ad=0.1218 as=0.1218 pd=1.42 ps=1.42 nrd=0.69047619047619 nrs=0.69047619047619 sa=0 sb=0 sd=0 mult=1 m=1
XMRD_m02_w0_1 rbl_m02_w0 sn_m02_w0_1 rwl_des 0 sky130_fd_pr__nfet_01v8 L=0.15 W=0.42 nf=1 ad=0.1218 as=0.1218 pd=1.42 ps=1.42 nrd=0.69047619047619 nrs=0.69047619047619 sa=0 sb=0 sd=0 mult=1 m=1
csn_m02_w0_1 sn_m02_w0_1 0 {C_SN}
XMWR_m02_w0_2 sn_m02_w0_2 0 wbl_m02_w0 0 sky130_fd_pr__nfet_01v8 L=0.15 W=0.42 nf=1 ad=0.1218 as=0.1218 pd=1.42 ps=1.42 nrd=0.69047619047619 nrs=0.69047619047619 sa=0 sb=0 sd=0 mult=1 m=1
XMRD_m02_w0_2 rbl_m02_w0 sn_m02_w0_2 rwl_des 0 sky130_fd_pr__nfet_01v8 L=0.15 W=0.42 nf=1 ad=0.1218 as=0.1218 pd=1.42 ps=1.42 nrd=0.69047619047619 nrs=0.69047619047619 sa=0 sb=0 sd=0 mult=1 m=1
csn_m02_w0_2 sn_m02_w0_2 0 {C_SN}
XMWR_m02_w0_3 sn_m02_w0_3 0 wbl_m02_w0 0 sky130_fd_pr__nfet_01v8 L=0.15 W=0.42 nf=1 ad=0.1218 as=0.1218 pd=1.42 ps=1.42 nrd=0.69047619047619 nrs=0.69047619047619 sa=0 sb=0 sd=0 mult=1 m=1
XMRD_m02_w0_3 rbl_m02_w0 sn_m02_w0_3 rwl_des 0 sky130_fd_pr__nfet_01v8 L=0.15 W=0.42 nf=1 ad=0.1218 as=0.1218 pd=1.42 ps=1.42 nrd=0.69047619047619 nrs=0.69047619047619 sa=0 sb=0 sd=0 mult=1 m=1
csn_m02_w0_3 sn_m02_w0_3 0 {C_SN}
crbl_m02_w0 rbl_m02_w0 0 {C_RBL}
cwbl_m02_w0 wbl_m02_w0 0 {C_WBL}
cref_m02_w0 ref_m02_w0 0 {C_RBL}   $ ASSUMPTION: ideal matched dummy load
XMPPRE_m02_w0 rbl_m02_w0 pcb_100 prea prea sky130_fd_pr__pfet_01v8 L=0.15 W=4 nf=1 ad=1.16 as=1.16 pd=8.58 ps=8.58 nrd=0.0725 nrs=0.0725 sa=0 sb=0 sd=0 mult=1 m=1
XMPU1_m02_w0 x_m02_w0 dinb0 vdd vdd sky130_fd_pr__pfet_01v8 L=0.15 W=1 nf=1 ad=0.29 as=0.29 pd=2.58 ps=2.58 nrd=0.29 nrs=0.29 sa=0 sb=0 sd=0 mult=1 m=1
XMPU2_m02_w0 wbl_m02_w0 wenb x_m02_w0 vdd sky130_fd_pr__pfet_01v8 L=0.15 W=1 nf=1 ad=0.29 as=0.29 pd=2.58 ps=2.58 nrd=0.29 nrs=0.29 sa=0 sb=0 sd=0 mult=1 m=1
XMND2_m02_w0 wbl_m02_w0 wen y_m02_w0 0 sky130_fd_pr__nfet_01v8 L=0.15 W=0.5 nf=1 ad=0.145 as=0.145 pd=1.58 ps=1.58 nrd=0.58 nrs=0.58 sa=0 sb=0 sd=0 mult=1 m=1
XMND1_m02_w0 y_m02_w0 dinb0 0 0 sky130_fd_pr__nfet_01v8 L=0.15 W=0.5 nf=1 ad=0.145 as=0.145 pd=1.58 ps=1.58 nrd=0.58 nrs=0.58 sa=0 sb=0 sd=0 mult=1 m=1
XMNI_m02_w0 wbl_m02_w0 wenb 0 0 sky130_fd_pr__nfet_01v8 L=0.15 W=0.42 nf=1 ad=0.1218 as=0.1218 pd=1.42 ps=1.42 nrd=0.69047619047619 nrs=0.69047619047619 sa=0 sb=0 sd=0 mult=1 m=1
XMNS_m02_w0 sbl_m02_w0 sel_69000 rbl_m02_w0 0 sky130_fd_pr__nfet_01v8 L=0.15 W=1 nf=1 ad=0.29 as=0.29 pd=2.58 ps=2.58 nrd=0.29 nrs=0.29 sa=0 sb=0 sd=0 mult=1 m=1
XMPS_m02_w0 sbl_m02_w0 selb_69000 rbl_m02_w0 vdd sky130_fd_pr__pfet_01v8 L=0.15 W=2 nf=1 ad=0.58 as=0.58 pd=4.58 ps=4.58 nrd=0.145 nrs=0.145 sa=0 sb=0 sd=0 mult=1 m=1
XMNSR_m02_w0 sref_m02_w0 sel_69000 ref_m02_w0 0 sky130_fd_pr__nfet_01v8 L=0.15 W=1 nf=1 ad=0.29 as=0.29 pd=2.58 ps=2.58 nrd=0.29 nrs=0.29 sa=0 sb=0 sd=0 mult=1 m=1
XMPSR_m02_w0 sref_m02_w0 selb_69000 ref_m02_w0 vdd sky130_fd_pr__pfet_01v8 L=0.15 W=2 nf=1 ad=0.58 as=0.58 pd=4.58 ps=4.58 nrd=0.145 nrs=0.145 sa=0 sb=0 sd=0 mult=1 m=1
XMPPREF_m02_w0 ref_m02_w0 pcb_100 pref pref sky130_fd_pr__pfet_01v8 L=0.15 W=4 nf=1 ad=1.16 as=1.16 pd=8.58 ps=8.58 nrd=0.0725 nrs=0.0725 sa=0 sb=0 sd=0 mult=1 m=1   $ reference-side precharge: copy of MPPRE
XMN1_m02_w0 sbl_m02_w0 sref_m02_w0 vn_m02_w0 0 sky130_fd_pr__nfet_01v8 L=0.15 W=1 nf=1 ad=0.29 as=0.29 pd=2.58 ps=2.58 nrd=0.29 nrs=0.29 sa=0 sb=0 sd=0 mult=1 m=1
XMN2_m02_w0 sref_m02_w0 sbl_m02_w0 vn_m02_w0 0 sky130_fd_pr__nfet_01v8 L=0.15 W=1 nf=1 ad=0.29 as=0.29 pd=2.58 ps=2.58 nrd=0.29 nrs=0.29 sa=0 sb=0 sd=0 mult=1 m=1
XMP1_m02_w0 sbl_m02_w0 sref_m02_w0 vp_m02_w0 vdd sky130_fd_pr__pfet_01v8 L=0.15 W=2 nf=1 ad=0.58 as=0.58 pd=4.58 ps=4.58 nrd=0.145 nrs=0.145 sa=0 sb=0 sd=0 mult=1 m=1
XMP2_m02_w0 sref_m02_w0 sbl_m02_w0 vp_m02_w0 vdd sky130_fd_pr__pfet_01v8 L=0.15 W=2 nf=1 ad=0.58 as=0.58 pd=4.58 ps=4.58 nrd=0.145 nrs=0.145 sa=0 sb=0 sd=0 mult=1 m=1
XMNF_m02_w0 vn_m02_w0 en 0 0 sky130_fd_pr__nfet_01v8 L=0.15 W=2 nf=1 ad=0.58 as=0.58 pd=4.58 ps=4.58 nrd=0.145 nrs=0.145 sa=0 sb=0 sd=0 mult=1 m=1
XMPH_m02_w0 vp_m02_w0 enb vdd vdd sky130_fd_pr__pfet_01v8 L=0.15 W=4 nf=1 ad=1.16 as=1.16 pd=8.58 ps=8.58 nrd=0.0725 nrs=0.0725 sa=0 sb=0 sd=0 mult=1 m=1
bd_m02_w0 d_m02_w0 0 v=v(sbl_m02_w0)-v(sref_m02_w0)
bdabs_m02_w0 dabs_m02_w0 0 v=abs(v(sbl_m02_w0)-v(sref_m02_w0))

* ---- instance 40: m03_w1 (lead 2.0 ns [matched ref precharge]) ----
XMWR_m03_w1_0 sn_m03_w1_0 wl wbl_m03_w1 0 sky130_fd_pr__nfet_01v8 L=0.15 W=0.42 nf=1 ad=0.1218 as=0.1218 pd=1.42 ps=1.42 nrd=0.69047619047619 nrs=0.69047619047619 sa=0 sb=0 sd=0 mult=1 m=1
XMRD_m03_w1_0 rbl_m03_w1 sn_m03_w1_0 rwl_sel 0 sky130_fd_pr__nfet_01v8 L=0.15 W=0.42 nf=1 ad=0.1218 as=0.1218 pd=1.42 ps=1.42 nrd=0.69047619047619 nrs=0.69047619047619 sa=0 sb=0 sd=0 mult=1 m=1
csn_m03_w1_0 sn_m03_w1_0 0 {C_SN}
XMWR_m03_w1_1 sn_m03_w1_1 0 wbl_m03_w1 0 sky130_fd_pr__nfet_01v8 L=0.15 W=0.42 nf=1 ad=0.1218 as=0.1218 pd=1.42 ps=1.42 nrd=0.69047619047619 nrs=0.69047619047619 sa=0 sb=0 sd=0 mult=1 m=1
XMRD_m03_w1_1 rbl_m03_w1 sn_m03_w1_1 rwl_des 0 sky130_fd_pr__nfet_01v8 L=0.15 W=0.42 nf=1 ad=0.1218 as=0.1218 pd=1.42 ps=1.42 nrd=0.69047619047619 nrs=0.69047619047619 sa=0 sb=0 sd=0 mult=1 m=1
csn_m03_w1_1 sn_m03_w1_1 0 {C_SN}
XMWR_m03_w1_2 sn_m03_w1_2 0 wbl_m03_w1 0 sky130_fd_pr__nfet_01v8 L=0.15 W=0.42 nf=1 ad=0.1218 as=0.1218 pd=1.42 ps=1.42 nrd=0.69047619047619 nrs=0.69047619047619 sa=0 sb=0 sd=0 mult=1 m=1
XMRD_m03_w1_2 rbl_m03_w1 sn_m03_w1_2 rwl_des 0 sky130_fd_pr__nfet_01v8 L=0.15 W=0.42 nf=1 ad=0.1218 as=0.1218 pd=1.42 ps=1.42 nrd=0.69047619047619 nrs=0.69047619047619 sa=0 sb=0 sd=0 mult=1 m=1
csn_m03_w1_2 sn_m03_w1_2 0 {C_SN}
XMWR_m03_w1_3 sn_m03_w1_3 0 wbl_m03_w1 0 sky130_fd_pr__nfet_01v8 L=0.15 W=0.42 nf=1 ad=0.1218 as=0.1218 pd=1.42 ps=1.42 nrd=0.69047619047619 nrs=0.69047619047619 sa=0 sb=0 sd=0 mult=1 m=1
XMRD_m03_w1_3 rbl_m03_w1 sn_m03_w1_3 rwl_des 0 sky130_fd_pr__nfet_01v8 L=0.15 W=0.42 nf=1 ad=0.1218 as=0.1218 pd=1.42 ps=1.42 nrd=0.69047619047619 nrs=0.69047619047619 sa=0 sb=0 sd=0 mult=1 m=1
csn_m03_w1_3 sn_m03_w1_3 0 {C_SN}
crbl_m03_w1 rbl_m03_w1 0 {C_RBL}
cwbl_m03_w1 wbl_m03_w1 0 {C_WBL}
cref_m03_w1 ref_m03_w1 0 {C_RBL}   $ ASSUMPTION: ideal matched dummy load
XMPPRE_m03_w1 rbl_m03_w1 pcb_100 prea prea sky130_fd_pr__pfet_01v8 L=0.15 W=4 nf=1 ad=1.16 as=1.16 pd=8.58 ps=8.58 nrd=0.0725 nrs=0.0725 sa=0 sb=0 sd=0 mult=1 m=1
XMPU1_m03_w1 x_m03_w1 dinb1 vdd vdd sky130_fd_pr__pfet_01v8 L=0.15 W=1 nf=1 ad=0.29 as=0.29 pd=2.58 ps=2.58 nrd=0.29 nrs=0.29 sa=0 sb=0 sd=0 mult=1 m=1
XMPU2_m03_w1 wbl_m03_w1 wenb x_m03_w1 vdd sky130_fd_pr__pfet_01v8 L=0.15 W=1 nf=1 ad=0.29 as=0.29 pd=2.58 ps=2.58 nrd=0.29 nrs=0.29 sa=0 sb=0 sd=0 mult=1 m=1
XMND2_m03_w1 wbl_m03_w1 wen y_m03_w1 0 sky130_fd_pr__nfet_01v8 L=0.15 W=0.5 nf=1 ad=0.145 as=0.145 pd=1.58 ps=1.58 nrd=0.58 nrs=0.58 sa=0 sb=0 sd=0 mult=1 m=1
XMND1_m03_w1 y_m03_w1 dinb1 0 0 sky130_fd_pr__nfet_01v8 L=0.15 W=0.5 nf=1 ad=0.145 as=0.145 pd=1.58 ps=1.58 nrd=0.58 nrs=0.58 sa=0 sb=0 sd=0 mult=1 m=1
XMNI_m03_w1 wbl_m03_w1 wenb 0 0 sky130_fd_pr__nfet_01v8 L=0.15 W=0.42 nf=1 ad=0.1218 as=0.1218 pd=1.42 ps=1.42 nrd=0.69047619047619 nrs=0.69047619047619 sa=0 sb=0 sd=0 mult=1 m=1
XMNS_m03_w1 sbl_m03_w1 sel_68000 rbl_m03_w1 0 sky130_fd_pr__nfet_01v8 L=0.15 W=1 nf=1 ad=0.29 as=0.29 pd=2.58 ps=2.58 nrd=0.29 nrs=0.29 sa=0 sb=0 sd=0 mult=1 m=1
XMPS_m03_w1 sbl_m03_w1 selb_68000 rbl_m03_w1 vdd sky130_fd_pr__pfet_01v8 L=0.15 W=2 nf=1 ad=0.58 as=0.58 pd=4.58 ps=4.58 nrd=0.145 nrs=0.145 sa=0 sb=0 sd=0 mult=1 m=1
XMNSR_m03_w1 sref_m03_w1 sel_68000 ref_m03_w1 0 sky130_fd_pr__nfet_01v8 L=0.15 W=1 nf=1 ad=0.29 as=0.29 pd=2.58 ps=2.58 nrd=0.29 nrs=0.29 sa=0 sb=0 sd=0 mult=1 m=1
XMPSR_m03_w1 sref_m03_w1 selb_68000 ref_m03_w1 vdd sky130_fd_pr__pfet_01v8 L=0.15 W=2 nf=1 ad=0.58 as=0.58 pd=4.58 ps=4.58 nrd=0.145 nrs=0.145 sa=0 sb=0 sd=0 mult=1 m=1
XMPPREF_m03_w1 ref_m03_w1 pcb_100 pref pref sky130_fd_pr__pfet_01v8 L=0.15 W=4 nf=1 ad=1.16 as=1.16 pd=8.58 ps=8.58 nrd=0.0725 nrs=0.0725 sa=0 sb=0 sd=0 mult=1 m=1   $ reference-side precharge: copy of MPPRE
XMN1_m03_w1 sbl_m03_w1 sref_m03_w1 vn_m03_w1 0 sky130_fd_pr__nfet_01v8 L=0.15 W=1 nf=1 ad=0.29 as=0.29 pd=2.58 ps=2.58 nrd=0.29 nrs=0.29 sa=0 sb=0 sd=0 mult=1 m=1
XMN2_m03_w1 sref_m03_w1 sbl_m03_w1 vn_m03_w1 0 sky130_fd_pr__nfet_01v8 L=0.15 W=1 nf=1 ad=0.29 as=0.29 pd=2.58 ps=2.58 nrd=0.29 nrs=0.29 sa=0 sb=0 sd=0 mult=1 m=1
XMP1_m03_w1 sbl_m03_w1 sref_m03_w1 vp_m03_w1 vdd sky130_fd_pr__pfet_01v8 L=0.15 W=2 nf=1 ad=0.58 as=0.58 pd=4.58 ps=4.58 nrd=0.145 nrs=0.145 sa=0 sb=0 sd=0 mult=1 m=1
XMP2_m03_w1 sref_m03_w1 sbl_m03_w1 vp_m03_w1 vdd sky130_fd_pr__pfet_01v8 L=0.15 W=2 nf=1 ad=0.58 as=0.58 pd=4.58 ps=4.58 nrd=0.145 nrs=0.145 sa=0 sb=0 sd=0 mult=1 m=1
XMNF_m03_w1 vn_m03_w1 en 0 0 sky130_fd_pr__nfet_01v8 L=0.15 W=2 nf=1 ad=0.58 as=0.58 pd=4.58 ps=4.58 nrd=0.145 nrs=0.145 sa=0 sb=0 sd=0 mult=1 m=1
XMPH_m03_w1 vp_m03_w1 enb vdd vdd sky130_fd_pr__pfet_01v8 L=0.15 W=4 nf=1 ad=1.16 as=1.16 pd=8.58 ps=8.58 nrd=0.0725 nrs=0.0725 sa=0 sb=0 sd=0 mult=1 m=1
bd_m03_w1 d_m03_w1 0 v=v(sbl_m03_w1)-v(sref_m03_w1)
bdabs_m03_w1 dabs_m03_w1 0 v=abs(v(sbl_m03_w1)-v(sref_m03_w1))

* ---- instance 41: m03_w0 (lead 2.0 ns [matched ref precharge]) ----
XMWR_m03_w0_0 sn_m03_w0_0 wl wbl_m03_w0 0 sky130_fd_pr__nfet_01v8 L=0.15 W=0.42 nf=1 ad=0.1218 as=0.1218 pd=1.42 ps=1.42 nrd=0.69047619047619 nrs=0.69047619047619 sa=0 sb=0 sd=0 mult=1 m=1
XMRD_m03_w0_0 rbl_m03_w0 sn_m03_w0_0 rwl_sel 0 sky130_fd_pr__nfet_01v8 L=0.15 W=0.42 nf=1 ad=0.1218 as=0.1218 pd=1.42 ps=1.42 nrd=0.69047619047619 nrs=0.69047619047619 sa=0 sb=0 sd=0 mult=1 m=1
csn_m03_w0_0 sn_m03_w0_0 0 {C_SN}
XMWR_m03_w0_1 sn_m03_w0_1 0 wbl_m03_w0 0 sky130_fd_pr__nfet_01v8 L=0.15 W=0.42 nf=1 ad=0.1218 as=0.1218 pd=1.42 ps=1.42 nrd=0.69047619047619 nrs=0.69047619047619 sa=0 sb=0 sd=0 mult=1 m=1
XMRD_m03_w0_1 rbl_m03_w0 sn_m03_w0_1 rwl_des 0 sky130_fd_pr__nfet_01v8 L=0.15 W=0.42 nf=1 ad=0.1218 as=0.1218 pd=1.42 ps=1.42 nrd=0.69047619047619 nrs=0.69047619047619 sa=0 sb=0 sd=0 mult=1 m=1
csn_m03_w0_1 sn_m03_w0_1 0 {C_SN}
XMWR_m03_w0_2 sn_m03_w0_2 0 wbl_m03_w0 0 sky130_fd_pr__nfet_01v8 L=0.15 W=0.42 nf=1 ad=0.1218 as=0.1218 pd=1.42 ps=1.42 nrd=0.69047619047619 nrs=0.69047619047619 sa=0 sb=0 sd=0 mult=1 m=1
XMRD_m03_w0_2 rbl_m03_w0 sn_m03_w0_2 rwl_des 0 sky130_fd_pr__nfet_01v8 L=0.15 W=0.42 nf=1 ad=0.1218 as=0.1218 pd=1.42 ps=1.42 nrd=0.69047619047619 nrs=0.69047619047619 sa=0 sb=0 sd=0 mult=1 m=1
csn_m03_w0_2 sn_m03_w0_2 0 {C_SN}
XMWR_m03_w0_3 sn_m03_w0_3 0 wbl_m03_w0 0 sky130_fd_pr__nfet_01v8 L=0.15 W=0.42 nf=1 ad=0.1218 as=0.1218 pd=1.42 ps=1.42 nrd=0.69047619047619 nrs=0.69047619047619 sa=0 sb=0 sd=0 mult=1 m=1
XMRD_m03_w0_3 rbl_m03_w0 sn_m03_w0_3 rwl_des 0 sky130_fd_pr__nfet_01v8 L=0.15 W=0.42 nf=1 ad=0.1218 as=0.1218 pd=1.42 ps=1.42 nrd=0.69047619047619 nrs=0.69047619047619 sa=0 sb=0 sd=0 mult=1 m=1
csn_m03_w0_3 sn_m03_w0_3 0 {C_SN}
crbl_m03_w0 rbl_m03_w0 0 {C_RBL}
cwbl_m03_w0 wbl_m03_w0 0 {C_WBL}
cref_m03_w0 ref_m03_w0 0 {C_RBL}   $ ASSUMPTION: ideal matched dummy load
XMPPRE_m03_w0 rbl_m03_w0 pcb_100 prea prea sky130_fd_pr__pfet_01v8 L=0.15 W=4 nf=1 ad=1.16 as=1.16 pd=8.58 ps=8.58 nrd=0.0725 nrs=0.0725 sa=0 sb=0 sd=0 mult=1 m=1
XMPU1_m03_w0 x_m03_w0 dinb0 vdd vdd sky130_fd_pr__pfet_01v8 L=0.15 W=1 nf=1 ad=0.29 as=0.29 pd=2.58 ps=2.58 nrd=0.29 nrs=0.29 sa=0 sb=0 sd=0 mult=1 m=1
XMPU2_m03_w0 wbl_m03_w0 wenb x_m03_w0 vdd sky130_fd_pr__pfet_01v8 L=0.15 W=1 nf=1 ad=0.29 as=0.29 pd=2.58 ps=2.58 nrd=0.29 nrs=0.29 sa=0 sb=0 sd=0 mult=1 m=1
XMND2_m03_w0 wbl_m03_w0 wen y_m03_w0 0 sky130_fd_pr__nfet_01v8 L=0.15 W=0.5 nf=1 ad=0.145 as=0.145 pd=1.58 ps=1.58 nrd=0.58 nrs=0.58 sa=0 sb=0 sd=0 mult=1 m=1
XMND1_m03_w0 y_m03_w0 dinb0 0 0 sky130_fd_pr__nfet_01v8 L=0.15 W=0.5 nf=1 ad=0.145 as=0.145 pd=1.58 ps=1.58 nrd=0.58 nrs=0.58 sa=0 sb=0 sd=0 mult=1 m=1
XMNI_m03_w0 wbl_m03_w0 wenb 0 0 sky130_fd_pr__nfet_01v8 L=0.15 W=0.42 nf=1 ad=0.1218 as=0.1218 pd=1.42 ps=1.42 nrd=0.69047619047619 nrs=0.69047619047619 sa=0 sb=0 sd=0 mult=1 m=1
XMNS_m03_w0 sbl_m03_w0 sel_68000 rbl_m03_w0 0 sky130_fd_pr__nfet_01v8 L=0.15 W=1 nf=1 ad=0.29 as=0.29 pd=2.58 ps=2.58 nrd=0.29 nrs=0.29 sa=0 sb=0 sd=0 mult=1 m=1
XMPS_m03_w0 sbl_m03_w0 selb_68000 rbl_m03_w0 vdd sky130_fd_pr__pfet_01v8 L=0.15 W=2 nf=1 ad=0.58 as=0.58 pd=4.58 ps=4.58 nrd=0.145 nrs=0.145 sa=0 sb=0 sd=0 mult=1 m=1
XMNSR_m03_w0 sref_m03_w0 sel_68000 ref_m03_w0 0 sky130_fd_pr__nfet_01v8 L=0.15 W=1 nf=1 ad=0.29 as=0.29 pd=2.58 ps=2.58 nrd=0.29 nrs=0.29 sa=0 sb=0 sd=0 mult=1 m=1
XMPSR_m03_w0 sref_m03_w0 selb_68000 ref_m03_w0 vdd sky130_fd_pr__pfet_01v8 L=0.15 W=2 nf=1 ad=0.58 as=0.58 pd=4.58 ps=4.58 nrd=0.145 nrs=0.145 sa=0 sb=0 sd=0 mult=1 m=1
XMPPREF_m03_w0 ref_m03_w0 pcb_100 pref pref sky130_fd_pr__pfet_01v8 L=0.15 W=4 nf=1 ad=1.16 as=1.16 pd=8.58 ps=8.58 nrd=0.0725 nrs=0.0725 sa=0 sb=0 sd=0 mult=1 m=1   $ reference-side precharge: copy of MPPRE
XMN1_m03_w0 sbl_m03_w0 sref_m03_w0 vn_m03_w0 0 sky130_fd_pr__nfet_01v8 L=0.15 W=1 nf=1 ad=0.29 as=0.29 pd=2.58 ps=2.58 nrd=0.29 nrs=0.29 sa=0 sb=0 sd=0 mult=1 m=1
XMN2_m03_w0 sref_m03_w0 sbl_m03_w0 vn_m03_w0 0 sky130_fd_pr__nfet_01v8 L=0.15 W=1 nf=1 ad=0.29 as=0.29 pd=2.58 ps=2.58 nrd=0.29 nrs=0.29 sa=0 sb=0 sd=0 mult=1 m=1
XMP1_m03_w0 sbl_m03_w0 sref_m03_w0 vp_m03_w0 vdd sky130_fd_pr__pfet_01v8 L=0.15 W=2 nf=1 ad=0.58 as=0.58 pd=4.58 ps=4.58 nrd=0.145 nrs=0.145 sa=0 sb=0 sd=0 mult=1 m=1
XMP2_m03_w0 sref_m03_w0 sbl_m03_w0 vp_m03_w0 vdd sky130_fd_pr__pfet_01v8 L=0.15 W=2 nf=1 ad=0.58 as=0.58 pd=4.58 ps=4.58 nrd=0.145 nrs=0.145 sa=0 sb=0 sd=0 mult=1 m=1
XMNF_m03_w0 vn_m03_w0 en 0 0 sky130_fd_pr__nfet_01v8 L=0.15 W=2 nf=1 ad=0.58 as=0.58 pd=4.58 ps=4.58 nrd=0.145 nrs=0.145 sa=0 sb=0 sd=0 mult=1 m=1
XMPH_m03_w0 vp_m03_w0 enb vdd vdd sky130_fd_pr__pfet_01v8 L=0.15 W=4 nf=1 ad=1.16 as=1.16 pd=8.58 ps=8.58 nrd=0.0725 nrs=0.0725 sa=0 sb=0 sd=0 mult=1 m=1
bd_m03_w0 d_m03_w0 0 v=v(sbl_m03_w0)-v(sref_m03_w0)
bdabs_m03_w0 dabs_m03_w0 0 v=abs(v(sbl_m03_w0)-v(sref_m03_w0))

* ---- instance 42: m04_w1 (TG 0.5 / 1.0 [matched ref precharge]) ----
XMWR_m04_w1_0 sn_m04_w1_0 wl wbl_m04_w1 0 sky130_fd_pr__nfet_01v8 L=0.15 W=0.42 nf=1 ad=0.1218 as=0.1218 pd=1.42 ps=1.42 nrd=0.69047619047619 nrs=0.69047619047619 sa=0 sb=0 sd=0 mult=1 m=1
XMRD_m04_w1_0 rbl_m04_w1 sn_m04_w1_0 rwl_sel 0 sky130_fd_pr__nfet_01v8 L=0.15 W=0.42 nf=1 ad=0.1218 as=0.1218 pd=1.42 ps=1.42 nrd=0.69047619047619 nrs=0.69047619047619 sa=0 sb=0 sd=0 mult=1 m=1
csn_m04_w1_0 sn_m04_w1_0 0 {C_SN}
XMWR_m04_w1_1 sn_m04_w1_1 0 wbl_m04_w1 0 sky130_fd_pr__nfet_01v8 L=0.15 W=0.42 nf=1 ad=0.1218 as=0.1218 pd=1.42 ps=1.42 nrd=0.69047619047619 nrs=0.69047619047619 sa=0 sb=0 sd=0 mult=1 m=1
XMRD_m04_w1_1 rbl_m04_w1 sn_m04_w1_1 rwl_des 0 sky130_fd_pr__nfet_01v8 L=0.15 W=0.42 nf=1 ad=0.1218 as=0.1218 pd=1.42 ps=1.42 nrd=0.69047619047619 nrs=0.69047619047619 sa=0 sb=0 sd=0 mult=1 m=1
csn_m04_w1_1 sn_m04_w1_1 0 {C_SN}
XMWR_m04_w1_2 sn_m04_w1_2 0 wbl_m04_w1 0 sky130_fd_pr__nfet_01v8 L=0.15 W=0.42 nf=1 ad=0.1218 as=0.1218 pd=1.42 ps=1.42 nrd=0.69047619047619 nrs=0.69047619047619 sa=0 sb=0 sd=0 mult=1 m=1
XMRD_m04_w1_2 rbl_m04_w1 sn_m04_w1_2 rwl_des 0 sky130_fd_pr__nfet_01v8 L=0.15 W=0.42 nf=1 ad=0.1218 as=0.1218 pd=1.42 ps=1.42 nrd=0.69047619047619 nrs=0.69047619047619 sa=0 sb=0 sd=0 mult=1 m=1
csn_m04_w1_2 sn_m04_w1_2 0 {C_SN}
XMWR_m04_w1_3 sn_m04_w1_3 0 wbl_m04_w1 0 sky130_fd_pr__nfet_01v8 L=0.15 W=0.42 nf=1 ad=0.1218 as=0.1218 pd=1.42 ps=1.42 nrd=0.69047619047619 nrs=0.69047619047619 sa=0 sb=0 sd=0 mult=1 m=1
XMRD_m04_w1_3 rbl_m04_w1 sn_m04_w1_3 rwl_des 0 sky130_fd_pr__nfet_01v8 L=0.15 W=0.42 nf=1 ad=0.1218 as=0.1218 pd=1.42 ps=1.42 nrd=0.69047619047619 nrs=0.69047619047619 sa=0 sb=0 sd=0 mult=1 m=1
csn_m04_w1_3 sn_m04_w1_3 0 {C_SN}
crbl_m04_w1 rbl_m04_w1 0 {C_RBL}
cwbl_m04_w1 wbl_m04_w1 0 {C_WBL}
cref_m04_w1 ref_m04_w1 0 {C_RBL}   $ ASSUMPTION: ideal matched dummy load
XMPPRE_m04_w1 rbl_m04_w1 pcb_100 prea prea sky130_fd_pr__pfet_01v8 L=0.15 W=4 nf=1 ad=1.16 as=1.16 pd=8.58 ps=8.58 nrd=0.0725 nrs=0.0725 sa=0 sb=0 sd=0 mult=1 m=1
XMPU1_m04_w1 x_m04_w1 dinb1 vdd vdd sky130_fd_pr__pfet_01v8 L=0.15 W=1 nf=1 ad=0.29 as=0.29 pd=2.58 ps=2.58 nrd=0.29 nrs=0.29 sa=0 sb=0 sd=0 mult=1 m=1
XMPU2_m04_w1 wbl_m04_w1 wenb x_m04_w1 vdd sky130_fd_pr__pfet_01v8 L=0.15 W=1 nf=1 ad=0.29 as=0.29 pd=2.58 ps=2.58 nrd=0.29 nrs=0.29 sa=0 sb=0 sd=0 mult=1 m=1
XMND2_m04_w1 wbl_m04_w1 wen y_m04_w1 0 sky130_fd_pr__nfet_01v8 L=0.15 W=0.5 nf=1 ad=0.145 as=0.145 pd=1.58 ps=1.58 nrd=0.58 nrs=0.58 sa=0 sb=0 sd=0 mult=1 m=1
XMND1_m04_w1 y_m04_w1 dinb1 0 0 sky130_fd_pr__nfet_01v8 L=0.15 W=0.5 nf=1 ad=0.145 as=0.145 pd=1.58 ps=1.58 nrd=0.58 nrs=0.58 sa=0 sb=0 sd=0 mult=1 m=1
XMNI_m04_w1 wbl_m04_w1 wenb 0 0 sky130_fd_pr__nfet_01v8 L=0.15 W=0.42 nf=1 ad=0.1218 as=0.1218 pd=1.42 ps=1.42 nrd=0.69047619047619 nrs=0.69047619047619 sa=0 sb=0 sd=0 mult=1 m=1
XMNS_m04_w1 sbl_m04_w1 sel_69500 rbl_m04_w1 0 sky130_fd_pr__nfet_01v8 L=0.15 W=0.5 nf=1 ad=0.145 as=0.145 pd=1.58 ps=1.58 nrd=0.58 nrs=0.58 sa=0 sb=0 sd=0 mult=1 m=1
XMPS_m04_w1 sbl_m04_w1 selb_69500 rbl_m04_w1 vdd sky130_fd_pr__pfet_01v8 L=0.15 W=1 nf=1 ad=0.29 as=0.29 pd=2.58 ps=2.58 nrd=0.29 nrs=0.29 sa=0 sb=0 sd=0 mult=1 m=1
XMNSR_m04_w1 sref_m04_w1 sel_69500 ref_m04_w1 0 sky130_fd_pr__nfet_01v8 L=0.15 W=0.5 nf=1 ad=0.145 as=0.145 pd=1.58 ps=1.58 nrd=0.58 nrs=0.58 sa=0 sb=0 sd=0 mult=1 m=1
XMPSR_m04_w1 sref_m04_w1 selb_69500 ref_m04_w1 vdd sky130_fd_pr__pfet_01v8 L=0.15 W=1 nf=1 ad=0.29 as=0.29 pd=2.58 ps=2.58 nrd=0.29 nrs=0.29 sa=0 sb=0 sd=0 mult=1 m=1
XMPPREF_m04_w1 ref_m04_w1 pcb_100 pref pref sky130_fd_pr__pfet_01v8 L=0.15 W=4 nf=1 ad=1.16 as=1.16 pd=8.58 ps=8.58 nrd=0.0725 nrs=0.0725 sa=0 sb=0 sd=0 mult=1 m=1   $ reference-side precharge: copy of MPPRE
XMN1_m04_w1 sbl_m04_w1 sref_m04_w1 vn_m04_w1 0 sky130_fd_pr__nfet_01v8 L=0.15 W=1 nf=1 ad=0.29 as=0.29 pd=2.58 ps=2.58 nrd=0.29 nrs=0.29 sa=0 sb=0 sd=0 mult=1 m=1
XMN2_m04_w1 sref_m04_w1 sbl_m04_w1 vn_m04_w1 0 sky130_fd_pr__nfet_01v8 L=0.15 W=1 nf=1 ad=0.29 as=0.29 pd=2.58 ps=2.58 nrd=0.29 nrs=0.29 sa=0 sb=0 sd=0 mult=1 m=1
XMP1_m04_w1 sbl_m04_w1 sref_m04_w1 vp_m04_w1 vdd sky130_fd_pr__pfet_01v8 L=0.15 W=2 nf=1 ad=0.58 as=0.58 pd=4.58 ps=4.58 nrd=0.145 nrs=0.145 sa=0 sb=0 sd=0 mult=1 m=1
XMP2_m04_w1 sref_m04_w1 sbl_m04_w1 vp_m04_w1 vdd sky130_fd_pr__pfet_01v8 L=0.15 W=2 nf=1 ad=0.58 as=0.58 pd=4.58 ps=4.58 nrd=0.145 nrs=0.145 sa=0 sb=0 sd=0 mult=1 m=1
XMNF_m04_w1 vn_m04_w1 en 0 0 sky130_fd_pr__nfet_01v8 L=0.15 W=2 nf=1 ad=0.58 as=0.58 pd=4.58 ps=4.58 nrd=0.145 nrs=0.145 sa=0 sb=0 sd=0 mult=1 m=1
XMPH_m04_w1 vp_m04_w1 enb vdd vdd sky130_fd_pr__pfet_01v8 L=0.15 W=4 nf=1 ad=1.16 as=1.16 pd=8.58 ps=8.58 nrd=0.0725 nrs=0.0725 sa=0 sb=0 sd=0 mult=1 m=1
bd_m04_w1 d_m04_w1 0 v=v(sbl_m04_w1)-v(sref_m04_w1)
bdabs_m04_w1 dabs_m04_w1 0 v=abs(v(sbl_m04_w1)-v(sref_m04_w1))

* ---- instance 43: m04_w0 (TG 0.5 / 1.0 [matched ref precharge]) ----
XMWR_m04_w0_0 sn_m04_w0_0 wl wbl_m04_w0 0 sky130_fd_pr__nfet_01v8 L=0.15 W=0.42 nf=1 ad=0.1218 as=0.1218 pd=1.42 ps=1.42 nrd=0.69047619047619 nrs=0.69047619047619 sa=0 sb=0 sd=0 mult=1 m=1
XMRD_m04_w0_0 rbl_m04_w0 sn_m04_w0_0 rwl_sel 0 sky130_fd_pr__nfet_01v8 L=0.15 W=0.42 nf=1 ad=0.1218 as=0.1218 pd=1.42 ps=1.42 nrd=0.69047619047619 nrs=0.69047619047619 sa=0 sb=0 sd=0 mult=1 m=1
csn_m04_w0_0 sn_m04_w0_0 0 {C_SN}
XMWR_m04_w0_1 sn_m04_w0_1 0 wbl_m04_w0 0 sky130_fd_pr__nfet_01v8 L=0.15 W=0.42 nf=1 ad=0.1218 as=0.1218 pd=1.42 ps=1.42 nrd=0.69047619047619 nrs=0.69047619047619 sa=0 sb=0 sd=0 mult=1 m=1
XMRD_m04_w0_1 rbl_m04_w0 sn_m04_w0_1 rwl_des 0 sky130_fd_pr__nfet_01v8 L=0.15 W=0.42 nf=1 ad=0.1218 as=0.1218 pd=1.42 ps=1.42 nrd=0.69047619047619 nrs=0.69047619047619 sa=0 sb=0 sd=0 mult=1 m=1
csn_m04_w0_1 sn_m04_w0_1 0 {C_SN}
XMWR_m04_w0_2 sn_m04_w0_2 0 wbl_m04_w0 0 sky130_fd_pr__nfet_01v8 L=0.15 W=0.42 nf=1 ad=0.1218 as=0.1218 pd=1.42 ps=1.42 nrd=0.69047619047619 nrs=0.69047619047619 sa=0 sb=0 sd=0 mult=1 m=1
XMRD_m04_w0_2 rbl_m04_w0 sn_m04_w0_2 rwl_des 0 sky130_fd_pr__nfet_01v8 L=0.15 W=0.42 nf=1 ad=0.1218 as=0.1218 pd=1.42 ps=1.42 nrd=0.69047619047619 nrs=0.69047619047619 sa=0 sb=0 sd=0 mult=1 m=1
csn_m04_w0_2 sn_m04_w0_2 0 {C_SN}
XMWR_m04_w0_3 sn_m04_w0_3 0 wbl_m04_w0 0 sky130_fd_pr__nfet_01v8 L=0.15 W=0.42 nf=1 ad=0.1218 as=0.1218 pd=1.42 ps=1.42 nrd=0.69047619047619 nrs=0.69047619047619 sa=0 sb=0 sd=0 mult=1 m=1
XMRD_m04_w0_3 rbl_m04_w0 sn_m04_w0_3 rwl_des 0 sky130_fd_pr__nfet_01v8 L=0.15 W=0.42 nf=1 ad=0.1218 as=0.1218 pd=1.42 ps=1.42 nrd=0.69047619047619 nrs=0.69047619047619 sa=0 sb=0 sd=0 mult=1 m=1
csn_m04_w0_3 sn_m04_w0_3 0 {C_SN}
crbl_m04_w0 rbl_m04_w0 0 {C_RBL}
cwbl_m04_w0 wbl_m04_w0 0 {C_WBL}
cref_m04_w0 ref_m04_w0 0 {C_RBL}   $ ASSUMPTION: ideal matched dummy load
XMPPRE_m04_w0 rbl_m04_w0 pcb_100 prea prea sky130_fd_pr__pfet_01v8 L=0.15 W=4 nf=1 ad=1.16 as=1.16 pd=8.58 ps=8.58 nrd=0.0725 nrs=0.0725 sa=0 sb=0 sd=0 mult=1 m=1
XMPU1_m04_w0 x_m04_w0 dinb0 vdd vdd sky130_fd_pr__pfet_01v8 L=0.15 W=1 nf=1 ad=0.29 as=0.29 pd=2.58 ps=2.58 nrd=0.29 nrs=0.29 sa=0 sb=0 sd=0 mult=1 m=1
XMPU2_m04_w0 wbl_m04_w0 wenb x_m04_w0 vdd sky130_fd_pr__pfet_01v8 L=0.15 W=1 nf=1 ad=0.29 as=0.29 pd=2.58 ps=2.58 nrd=0.29 nrs=0.29 sa=0 sb=0 sd=0 mult=1 m=1
XMND2_m04_w0 wbl_m04_w0 wen y_m04_w0 0 sky130_fd_pr__nfet_01v8 L=0.15 W=0.5 nf=1 ad=0.145 as=0.145 pd=1.58 ps=1.58 nrd=0.58 nrs=0.58 sa=0 sb=0 sd=0 mult=1 m=1
XMND1_m04_w0 y_m04_w0 dinb0 0 0 sky130_fd_pr__nfet_01v8 L=0.15 W=0.5 nf=1 ad=0.145 as=0.145 pd=1.58 ps=1.58 nrd=0.58 nrs=0.58 sa=0 sb=0 sd=0 mult=1 m=1
XMNI_m04_w0 wbl_m04_w0 wenb 0 0 sky130_fd_pr__nfet_01v8 L=0.15 W=0.42 nf=1 ad=0.1218 as=0.1218 pd=1.42 ps=1.42 nrd=0.69047619047619 nrs=0.69047619047619 sa=0 sb=0 sd=0 mult=1 m=1
XMNS_m04_w0 sbl_m04_w0 sel_69500 rbl_m04_w0 0 sky130_fd_pr__nfet_01v8 L=0.15 W=0.5 nf=1 ad=0.145 as=0.145 pd=1.58 ps=1.58 nrd=0.58 nrs=0.58 sa=0 sb=0 sd=0 mult=1 m=1
XMPS_m04_w0 sbl_m04_w0 selb_69500 rbl_m04_w0 vdd sky130_fd_pr__pfet_01v8 L=0.15 W=1 nf=1 ad=0.29 as=0.29 pd=2.58 ps=2.58 nrd=0.29 nrs=0.29 sa=0 sb=0 sd=0 mult=1 m=1
XMNSR_m04_w0 sref_m04_w0 sel_69500 ref_m04_w0 0 sky130_fd_pr__nfet_01v8 L=0.15 W=0.5 nf=1 ad=0.145 as=0.145 pd=1.58 ps=1.58 nrd=0.58 nrs=0.58 sa=0 sb=0 sd=0 mult=1 m=1
XMPSR_m04_w0 sref_m04_w0 selb_69500 ref_m04_w0 vdd sky130_fd_pr__pfet_01v8 L=0.15 W=1 nf=1 ad=0.29 as=0.29 pd=2.58 ps=2.58 nrd=0.29 nrs=0.29 sa=0 sb=0 sd=0 mult=1 m=1
XMPPREF_m04_w0 ref_m04_w0 pcb_100 pref pref sky130_fd_pr__pfet_01v8 L=0.15 W=4 nf=1 ad=1.16 as=1.16 pd=8.58 ps=8.58 nrd=0.0725 nrs=0.0725 sa=0 sb=0 sd=0 mult=1 m=1   $ reference-side precharge: copy of MPPRE
XMN1_m04_w0 sbl_m04_w0 sref_m04_w0 vn_m04_w0 0 sky130_fd_pr__nfet_01v8 L=0.15 W=1 nf=1 ad=0.29 as=0.29 pd=2.58 ps=2.58 nrd=0.29 nrs=0.29 sa=0 sb=0 sd=0 mult=1 m=1
XMN2_m04_w0 sref_m04_w0 sbl_m04_w0 vn_m04_w0 0 sky130_fd_pr__nfet_01v8 L=0.15 W=1 nf=1 ad=0.29 as=0.29 pd=2.58 ps=2.58 nrd=0.29 nrs=0.29 sa=0 sb=0 sd=0 mult=1 m=1
XMP1_m04_w0 sbl_m04_w0 sref_m04_w0 vp_m04_w0 vdd sky130_fd_pr__pfet_01v8 L=0.15 W=2 nf=1 ad=0.58 as=0.58 pd=4.58 ps=4.58 nrd=0.145 nrs=0.145 sa=0 sb=0 sd=0 mult=1 m=1
XMP2_m04_w0 sref_m04_w0 sbl_m04_w0 vp_m04_w0 vdd sky130_fd_pr__pfet_01v8 L=0.15 W=2 nf=1 ad=0.58 as=0.58 pd=4.58 ps=4.58 nrd=0.145 nrs=0.145 sa=0 sb=0 sd=0 mult=1 m=1
XMNF_m04_w0 vn_m04_w0 en 0 0 sky130_fd_pr__nfet_01v8 L=0.15 W=2 nf=1 ad=0.58 as=0.58 pd=4.58 ps=4.58 nrd=0.145 nrs=0.145 sa=0 sb=0 sd=0 mult=1 m=1
XMPH_m04_w0 vp_m04_w0 enb vdd vdd sky130_fd_pr__pfet_01v8 L=0.15 W=4 nf=1 ad=1.16 as=1.16 pd=8.58 ps=8.58 nrd=0.0725 nrs=0.0725 sa=0 sb=0 sd=0 mult=1 m=1
bd_m04_w0 d_m04_w0 0 v=v(sbl_m04_w0)-v(sref_m04_w0)
bdabs_m04_w0 dabs_m04_w0 0 v=abs(v(sbl_m04_w0)-v(sref_m04_w0))

* ---- instance 44: m05_w1 (TG 0.42 / 0.42 [matched ref precharge]) ----
XMWR_m05_w1_0 sn_m05_w1_0 wl wbl_m05_w1 0 sky130_fd_pr__nfet_01v8 L=0.15 W=0.42 nf=1 ad=0.1218 as=0.1218 pd=1.42 ps=1.42 nrd=0.69047619047619 nrs=0.69047619047619 sa=0 sb=0 sd=0 mult=1 m=1
XMRD_m05_w1_0 rbl_m05_w1 sn_m05_w1_0 rwl_sel 0 sky130_fd_pr__nfet_01v8 L=0.15 W=0.42 nf=1 ad=0.1218 as=0.1218 pd=1.42 ps=1.42 nrd=0.69047619047619 nrs=0.69047619047619 sa=0 sb=0 sd=0 mult=1 m=1
csn_m05_w1_0 sn_m05_w1_0 0 {C_SN}
XMWR_m05_w1_1 sn_m05_w1_1 0 wbl_m05_w1 0 sky130_fd_pr__nfet_01v8 L=0.15 W=0.42 nf=1 ad=0.1218 as=0.1218 pd=1.42 ps=1.42 nrd=0.69047619047619 nrs=0.69047619047619 sa=0 sb=0 sd=0 mult=1 m=1
XMRD_m05_w1_1 rbl_m05_w1 sn_m05_w1_1 rwl_des 0 sky130_fd_pr__nfet_01v8 L=0.15 W=0.42 nf=1 ad=0.1218 as=0.1218 pd=1.42 ps=1.42 nrd=0.69047619047619 nrs=0.69047619047619 sa=0 sb=0 sd=0 mult=1 m=1
csn_m05_w1_1 sn_m05_w1_1 0 {C_SN}
XMWR_m05_w1_2 sn_m05_w1_2 0 wbl_m05_w1 0 sky130_fd_pr__nfet_01v8 L=0.15 W=0.42 nf=1 ad=0.1218 as=0.1218 pd=1.42 ps=1.42 nrd=0.69047619047619 nrs=0.69047619047619 sa=0 sb=0 sd=0 mult=1 m=1
XMRD_m05_w1_2 rbl_m05_w1 sn_m05_w1_2 rwl_des 0 sky130_fd_pr__nfet_01v8 L=0.15 W=0.42 nf=1 ad=0.1218 as=0.1218 pd=1.42 ps=1.42 nrd=0.69047619047619 nrs=0.69047619047619 sa=0 sb=0 sd=0 mult=1 m=1
csn_m05_w1_2 sn_m05_w1_2 0 {C_SN}
XMWR_m05_w1_3 sn_m05_w1_3 0 wbl_m05_w1 0 sky130_fd_pr__nfet_01v8 L=0.15 W=0.42 nf=1 ad=0.1218 as=0.1218 pd=1.42 ps=1.42 nrd=0.69047619047619 nrs=0.69047619047619 sa=0 sb=0 sd=0 mult=1 m=1
XMRD_m05_w1_3 rbl_m05_w1 sn_m05_w1_3 rwl_des 0 sky130_fd_pr__nfet_01v8 L=0.15 W=0.42 nf=1 ad=0.1218 as=0.1218 pd=1.42 ps=1.42 nrd=0.69047619047619 nrs=0.69047619047619 sa=0 sb=0 sd=0 mult=1 m=1
csn_m05_w1_3 sn_m05_w1_3 0 {C_SN}
crbl_m05_w1 rbl_m05_w1 0 {C_RBL}
cwbl_m05_w1 wbl_m05_w1 0 {C_WBL}
cref_m05_w1 ref_m05_w1 0 {C_RBL}   $ ASSUMPTION: ideal matched dummy load
XMPPRE_m05_w1 rbl_m05_w1 pcb_100 prea prea sky130_fd_pr__pfet_01v8 L=0.15 W=4 nf=1 ad=1.16 as=1.16 pd=8.58 ps=8.58 nrd=0.0725 nrs=0.0725 sa=0 sb=0 sd=0 mult=1 m=1
XMPU1_m05_w1 x_m05_w1 dinb1 vdd vdd sky130_fd_pr__pfet_01v8 L=0.15 W=1 nf=1 ad=0.29 as=0.29 pd=2.58 ps=2.58 nrd=0.29 nrs=0.29 sa=0 sb=0 sd=0 mult=1 m=1
XMPU2_m05_w1 wbl_m05_w1 wenb x_m05_w1 vdd sky130_fd_pr__pfet_01v8 L=0.15 W=1 nf=1 ad=0.29 as=0.29 pd=2.58 ps=2.58 nrd=0.29 nrs=0.29 sa=0 sb=0 sd=0 mult=1 m=1
XMND2_m05_w1 wbl_m05_w1 wen y_m05_w1 0 sky130_fd_pr__nfet_01v8 L=0.15 W=0.5 nf=1 ad=0.145 as=0.145 pd=1.58 ps=1.58 nrd=0.58 nrs=0.58 sa=0 sb=0 sd=0 mult=1 m=1
XMND1_m05_w1 y_m05_w1 dinb1 0 0 sky130_fd_pr__nfet_01v8 L=0.15 W=0.5 nf=1 ad=0.145 as=0.145 pd=1.58 ps=1.58 nrd=0.58 nrs=0.58 sa=0 sb=0 sd=0 mult=1 m=1
XMNI_m05_w1 wbl_m05_w1 wenb 0 0 sky130_fd_pr__nfet_01v8 L=0.15 W=0.42 nf=1 ad=0.1218 as=0.1218 pd=1.42 ps=1.42 nrd=0.69047619047619 nrs=0.69047619047619 sa=0 sb=0 sd=0 mult=1 m=1
XMNS_m05_w1 sbl_m05_w1 sel_69500 rbl_m05_w1 0 sky130_fd_pr__nfet_01v8 L=0.15 W=0.42 nf=1 ad=0.1218 as=0.1218 pd=1.42 ps=1.42 nrd=0.69047619047619 nrs=0.69047619047619 sa=0 sb=0 sd=0 mult=1 m=1
XMPS_m05_w1 sbl_m05_w1 selb_69500 rbl_m05_w1 vdd sky130_fd_pr__pfet_01v8 L=0.15 W=0.42 nf=1 ad=0.1218 as=0.1218 pd=1.42 ps=1.42 nrd=0.69047619047619 nrs=0.69047619047619 sa=0 sb=0 sd=0 mult=1 m=1
XMNSR_m05_w1 sref_m05_w1 sel_69500 ref_m05_w1 0 sky130_fd_pr__nfet_01v8 L=0.15 W=0.42 nf=1 ad=0.1218 as=0.1218 pd=1.42 ps=1.42 nrd=0.69047619047619 nrs=0.69047619047619 sa=0 sb=0 sd=0 mult=1 m=1
XMPSR_m05_w1 sref_m05_w1 selb_69500 ref_m05_w1 vdd sky130_fd_pr__pfet_01v8 L=0.15 W=0.42 nf=1 ad=0.1218 as=0.1218 pd=1.42 ps=1.42 nrd=0.69047619047619 nrs=0.69047619047619 sa=0 sb=0 sd=0 mult=1 m=1
XMPPREF_m05_w1 ref_m05_w1 pcb_100 pref pref sky130_fd_pr__pfet_01v8 L=0.15 W=4 nf=1 ad=1.16 as=1.16 pd=8.58 ps=8.58 nrd=0.0725 nrs=0.0725 sa=0 sb=0 sd=0 mult=1 m=1   $ reference-side precharge: copy of MPPRE
XMN1_m05_w1 sbl_m05_w1 sref_m05_w1 vn_m05_w1 0 sky130_fd_pr__nfet_01v8 L=0.15 W=1 nf=1 ad=0.29 as=0.29 pd=2.58 ps=2.58 nrd=0.29 nrs=0.29 sa=0 sb=0 sd=0 mult=1 m=1
XMN2_m05_w1 sref_m05_w1 sbl_m05_w1 vn_m05_w1 0 sky130_fd_pr__nfet_01v8 L=0.15 W=1 nf=1 ad=0.29 as=0.29 pd=2.58 ps=2.58 nrd=0.29 nrs=0.29 sa=0 sb=0 sd=0 mult=1 m=1
XMP1_m05_w1 sbl_m05_w1 sref_m05_w1 vp_m05_w1 vdd sky130_fd_pr__pfet_01v8 L=0.15 W=2 nf=1 ad=0.58 as=0.58 pd=4.58 ps=4.58 nrd=0.145 nrs=0.145 sa=0 sb=0 sd=0 mult=1 m=1
XMP2_m05_w1 sref_m05_w1 sbl_m05_w1 vp_m05_w1 vdd sky130_fd_pr__pfet_01v8 L=0.15 W=2 nf=1 ad=0.58 as=0.58 pd=4.58 ps=4.58 nrd=0.145 nrs=0.145 sa=0 sb=0 sd=0 mult=1 m=1
XMNF_m05_w1 vn_m05_w1 en 0 0 sky130_fd_pr__nfet_01v8 L=0.15 W=2 nf=1 ad=0.58 as=0.58 pd=4.58 ps=4.58 nrd=0.145 nrs=0.145 sa=0 sb=0 sd=0 mult=1 m=1
XMPH_m05_w1 vp_m05_w1 enb vdd vdd sky130_fd_pr__pfet_01v8 L=0.15 W=4 nf=1 ad=1.16 as=1.16 pd=8.58 ps=8.58 nrd=0.0725 nrs=0.0725 sa=0 sb=0 sd=0 mult=1 m=1
bd_m05_w1 d_m05_w1 0 v=v(sbl_m05_w1)-v(sref_m05_w1)
bdabs_m05_w1 dabs_m05_w1 0 v=abs(v(sbl_m05_w1)-v(sref_m05_w1))

* ---- instance 45: m05_w0 (TG 0.42 / 0.42 [matched ref precharge]) ----
XMWR_m05_w0_0 sn_m05_w0_0 wl wbl_m05_w0 0 sky130_fd_pr__nfet_01v8 L=0.15 W=0.42 nf=1 ad=0.1218 as=0.1218 pd=1.42 ps=1.42 nrd=0.69047619047619 nrs=0.69047619047619 sa=0 sb=0 sd=0 mult=1 m=1
XMRD_m05_w0_0 rbl_m05_w0 sn_m05_w0_0 rwl_sel 0 sky130_fd_pr__nfet_01v8 L=0.15 W=0.42 nf=1 ad=0.1218 as=0.1218 pd=1.42 ps=1.42 nrd=0.69047619047619 nrs=0.69047619047619 sa=0 sb=0 sd=0 mult=1 m=1
csn_m05_w0_0 sn_m05_w0_0 0 {C_SN}
XMWR_m05_w0_1 sn_m05_w0_1 0 wbl_m05_w0 0 sky130_fd_pr__nfet_01v8 L=0.15 W=0.42 nf=1 ad=0.1218 as=0.1218 pd=1.42 ps=1.42 nrd=0.69047619047619 nrs=0.69047619047619 sa=0 sb=0 sd=0 mult=1 m=1
XMRD_m05_w0_1 rbl_m05_w0 sn_m05_w0_1 rwl_des 0 sky130_fd_pr__nfet_01v8 L=0.15 W=0.42 nf=1 ad=0.1218 as=0.1218 pd=1.42 ps=1.42 nrd=0.69047619047619 nrs=0.69047619047619 sa=0 sb=0 sd=0 mult=1 m=1
csn_m05_w0_1 sn_m05_w0_1 0 {C_SN}
XMWR_m05_w0_2 sn_m05_w0_2 0 wbl_m05_w0 0 sky130_fd_pr__nfet_01v8 L=0.15 W=0.42 nf=1 ad=0.1218 as=0.1218 pd=1.42 ps=1.42 nrd=0.69047619047619 nrs=0.69047619047619 sa=0 sb=0 sd=0 mult=1 m=1
XMRD_m05_w0_2 rbl_m05_w0 sn_m05_w0_2 rwl_des 0 sky130_fd_pr__nfet_01v8 L=0.15 W=0.42 nf=1 ad=0.1218 as=0.1218 pd=1.42 ps=1.42 nrd=0.69047619047619 nrs=0.69047619047619 sa=0 sb=0 sd=0 mult=1 m=1
csn_m05_w0_2 sn_m05_w0_2 0 {C_SN}
XMWR_m05_w0_3 sn_m05_w0_3 0 wbl_m05_w0 0 sky130_fd_pr__nfet_01v8 L=0.15 W=0.42 nf=1 ad=0.1218 as=0.1218 pd=1.42 ps=1.42 nrd=0.69047619047619 nrs=0.69047619047619 sa=0 sb=0 sd=0 mult=1 m=1
XMRD_m05_w0_3 rbl_m05_w0 sn_m05_w0_3 rwl_des 0 sky130_fd_pr__nfet_01v8 L=0.15 W=0.42 nf=1 ad=0.1218 as=0.1218 pd=1.42 ps=1.42 nrd=0.69047619047619 nrs=0.69047619047619 sa=0 sb=0 sd=0 mult=1 m=1
csn_m05_w0_3 sn_m05_w0_3 0 {C_SN}
crbl_m05_w0 rbl_m05_w0 0 {C_RBL}
cwbl_m05_w0 wbl_m05_w0 0 {C_WBL}
cref_m05_w0 ref_m05_w0 0 {C_RBL}   $ ASSUMPTION: ideal matched dummy load
XMPPRE_m05_w0 rbl_m05_w0 pcb_100 prea prea sky130_fd_pr__pfet_01v8 L=0.15 W=4 nf=1 ad=1.16 as=1.16 pd=8.58 ps=8.58 nrd=0.0725 nrs=0.0725 sa=0 sb=0 sd=0 mult=1 m=1
XMPU1_m05_w0 x_m05_w0 dinb0 vdd vdd sky130_fd_pr__pfet_01v8 L=0.15 W=1 nf=1 ad=0.29 as=0.29 pd=2.58 ps=2.58 nrd=0.29 nrs=0.29 sa=0 sb=0 sd=0 mult=1 m=1
XMPU2_m05_w0 wbl_m05_w0 wenb x_m05_w0 vdd sky130_fd_pr__pfet_01v8 L=0.15 W=1 nf=1 ad=0.29 as=0.29 pd=2.58 ps=2.58 nrd=0.29 nrs=0.29 sa=0 sb=0 sd=0 mult=1 m=1
XMND2_m05_w0 wbl_m05_w0 wen y_m05_w0 0 sky130_fd_pr__nfet_01v8 L=0.15 W=0.5 nf=1 ad=0.145 as=0.145 pd=1.58 ps=1.58 nrd=0.58 nrs=0.58 sa=0 sb=0 sd=0 mult=1 m=1
XMND1_m05_w0 y_m05_w0 dinb0 0 0 sky130_fd_pr__nfet_01v8 L=0.15 W=0.5 nf=1 ad=0.145 as=0.145 pd=1.58 ps=1.58 nrd=0.58 nrs=0.58 sa=0 sb=0 sd=0 mult=1 m=1
XMNI_m05_w0 wbl_m05_w0 wenb 0 0 sky130_fd_pr__nfet_01v8 L=0.15 W=0.42 nf=1 ad=0.1218 as=0.1218 pd=1.42 ps=1.42 nrd=0.69047619047619 nrs=0.69047619047619 sa=0 sb=0 sd=0 mult=1 m=1
XMNS_m05_w0 sbl_m05_w0 sel_69500 rbl_m05_w0 0 sky130_fd_pr__nfet_01v8 L=0.15 W=0.42 nf=1 ad=0.1218 as=0.1218 pd=1.42 ps=1.42 nrd=0.69047619047619 nrs=0.69047619047619 sa=0 sb=0 sd=0 mult=1 m=1
XMPS_m05_w0 sbl_m05_w0 selb_69500 rbl_m05_w0 vdd sky130_fd_pr__pfet_01v8 L=0.15 W=0.42 nf=1 ad=0.1218 as=0.1218 pd=1.42 ps=1.42 nrd=0.69047619047619 nrs=0.69047619047619 sa=0 sb=0 sd=0 mult=1 m=1
XMNSR_m05_w0 sref_m05_w0 sel_69500 ref_m05_w0 0 sky130_fd_pr__nfet_01v8 L=0.15 W=0.42 nf=1 ad=0.1218 as=0.1218 pd=1.42 ps=1.42 nrd=0.69047619047619 nrs=0.69047619047619 sa=0 sb=0 sd=0 mult=1 m=1
XMPSR_m05_w0 sref_m05_w0 selb_69500 ref_m05_w0 vdd sky130_fd_pr__pfet_01v8 L=0.15 W=0.42 nf=1 ad=0.1218 as=0.1218 pd=1.42 ps=1.42 nrd=0.69047619047619 nrs=0.69047619047619 sa=0 sb=0 sd=0 mult=1 m=1
XMPPREF_m05_w0 ref_m05_w0 pcb_100 pref pref sky130_fd_pr__pfet_01v8 L=0.15 W=4 nf=1 ad=1.16 as=1.16 pd=8.58 ps=8.58 nrd=0.0725 nrs=0.0725 sa=0 sb=0 sd=0 mult=1 m=1   $ reference-side precharge: copy of MPPRE
XMN1_m05_w0 sbl_m05_w0 sref_m05_w0 vn_m05_w0 0 sky130_fd_pr__nfet_01v8 L=0.15 W=1 nf=1 ad=0.29 as=0.29 pd=2.58 ps=2.58 nrd=0.29 nrs=0.29 sa=0 sb=0 sd=0 mult=1 m=1
XMN2_m05_w0 sref_m05_w0 sbl_m05_w0 vn_m05_w0 0 sky130_fd_pr__nfet_01v8 L=0.15 W=1 nf=1 ad=0.29 as=0.29 pd=2.58 ps=2.58 nrd=0.29 nrs=0.29 sa=0 sb=0 sd=0 mult=1 m=1
XMP1_m05_w0 sbl_m05_w0 sref_m05_w0 vp_m05_w0 vdd sky130_fd_pr__pfet_01v8 L=0.15 W=2 nf=1 ad=0.58 as=0.58 pd=4.58 ps=4.58 nrd=0.145 nrs=0.145 sa=0 sb=0 sd=0 mult=1 m=1
XMP2_m05_w0 sref_m05_w0 sbl_m05_w0 vp_m05_w0 vdd sky130_fd_pr__pfet_01v8 L=0.15 W=2 nf=1 ad=0.58 as=0.58 pd=4.58 ps=4.58 nrd=0.145 nrs=0.145 sa=0 sb=0 sd=0 mult=1 m=1
XMNF_m05_w0 vn_m05_w0 en 0 0 sky130_fd_pr__nfet_01v8 L=0.15 W=2 nf=1 ad=0.58 as=0.58 pd=4.58 ps=4.58 nrd=0.145 nrs=0.145 sa=0 sb=0 sd=0 mult=1 m=1
XMPH_m05_w0 vp_m05_w0 enb vdd vdd sky130_fd_pr__pfet_01v8 L=0.15 W=4 nf=1 ad=1.16 as=1.16 pd=8.58 ps=8.58 nrd=0.0725 nrs=0.0725 sa=0 sb=0 sd=0 mult=1 m=1
bd_m05_w0 d_m05_w0 0 v=v(sbl_m05_w0)-v(sref_m05_w0)
bdabs_m05_w0 dabs_m05_w0 0 v=abs(v(sbl_m05_w0)-v(sref_m05_w0))

* ---- instance 46: m06_w1 (TG 0.42 / 0.84 [matched ref precharge]) ----
XMWR_m06_w1_0 sn_m06_w1_0 wl wbl_m06_w1 0 sky130_fd_pr__nfet_01v8 L=0.15 W=0.42 nf=1 ad=0.1218 as=0.1218 pd=1.42 ps=1.42 nrd=0.69047619047619 nrs=0.69047619047619 sa=0 sb=0 sd=0 mult=1 m=1
XMRD_m06_w1_0 rbl_m06_w1 sn_m06_w1_0 rwl_sel 0 sky130_fd_pr__nfet_01v8 L=0.15 W=0.42 nf=1 ad=0.1218 as=0.1218 pd=1.42 ps=1.42 nrd=0.69047619047619 nrs=0.69047619047619 sa=0 sb=0 sd=0 mult=1 m=1
csn_m06_w1_0 sn_m06_w1_0 0 {C_SN}
XMWR_m06_w1_1 sn_m06_w1_1 0 wbl_m06_w1 0 sky130_fd_pr__nfet_01v8 L=0.15 W=0.42 nf=1 ad=0.1218 as=0.1218 pd=1.42 ps=1.42 nrd=0.69047619047619 nrs=0.69047619047619 sa=0 sb=0 sd=0 mult=1 m=1
XMRD_m06_w1_1 rbl_m06_w1 sn_m06_w1_1 rwl_des 0 sky130_fd_pr__nfet_01v8 L=0.15 W=0.42 nf=1 ad=0.1218 as=0.1218 pd=1.42 ps=1.42 nrd=0.69047619047619 nrs=0.69047619047619 sa=0 sb=0 sd=0 mult=1 m=1
csn_m06_w1_1 sn_m06_w1_1 0 {C_SN}
XMWR_m06_w1_2 sn_m06_w1_2 0 wbl_m06_w1 0 sky130_fd_pr__nfet_01v8 L=0.15 W=0.42 nf=1 ad=0.1218 as=0.1218 pd=1.42 ps=1.42 nrd=0.69047619047619 nrs=0.69047619047619 sa=0 sb=0 sd=0 mult=1 m=1
XMRD_m06_w1_2 rbl_m06_w1 sn_m06_w1_2 rwl_des 0 sky130_fd_pr__nfet_01v8 L=0.15 W=0.42 nf=1 ad=0.1218 as=0.1218 pd=1.42 ps=1.42 nrd=0.69047619047619 nrs=0.69047619047619 sa=0 sb=0 sd=0 mult=1 m=1
csn_m06_w1_2 sn_m06_w1_2 0 {C_SN}
XMWR_m06_w1_3 sn_m06_w1_3 0 wbl_m06_w1 0 sky130_fd_pr__nfet_01v8 L=0.15 W=0.42 nf=1 ad=0.1218 as=0.1218 pd=1.42 ps=1.42 nrd=0.69047619047619 nrs=0.69047619047619 sa=0 sb=0 sd=0 mult=1 m=1
XMRD_m06_w1_3 rbl_m06_w1 sn_m06_w1_3 rwl_des 0 sky130_fd_pr__nfet_01v8 L=0.15 W=0.42 nf=1 ad=0.1218 as=0.1218 pd=1.42 ps=1.42 nrd=0.69047619047619 nrs=0.69047619047619 sa=0 sb=0 sd=0 mult=1 m=1
csn_m06_w1_3 sn_m06_w1_3 0 {C_SN}
crbl_m06_w1 rbl_m06_w1 0 {C_RBL}
cwbl_m06_w1 wbl_m06_w1 0 {C_WBL}
cref_m06_w1 ref_m06_w1 0 {C_RBL}   $ ASSUMPTION: ideal matched dummy load
XMPPRE_m06_w1 rbl_m06_w1 pcb_100 prea prea sky130_fd_pr__pfet_01v8 L=0.15 W=4 nf=1 ad=1.16 as=1.16 pd=8.58 ps=8.58 nrd=0.0725 nrs=0.0725 sa=0 sb=0 sd=0 mult=1 m=1
XMPU1_m06_w1 x_m06_w1 dinb1 vdd vdd sky130_fd_pr__pfet_01v8 L=0.15 W=1 nf=1 ad=0.29 as=0.29 pd=2.58 ps=2.58 nrd=0.29 nrs=0.29 sa=0 sb=0 sd=0 mult=1 m=1
XMPU2_m06_w1 wbl_m06_w1 wenb x_m06_w1 vdd sky130_fd_pr__pfet_01v8 L=0.15 W=1 nf=1 ad=0.29 as=0.29 pd=2.58 ps=2.58 nrd=0.29 nrs=0.29 sa=0 sb=0 sd=0 mult=1 m=1
XMND2_m06_w1 wbl_m06_w1 wen y_m06_w1 0 sky130_fd_pr__nfet_01v8 L=0.15 W=0.5 nf=1 ad=0.145 as=0.145 pd=1.58 ps=1.58 nrd=0.58 nrs=0.58 sa=0 sb=0 sd=0 mult=1 m=1
XMND1_m06_w1 y_m06_w1 dinb1 0 0 sky130_fd_pr__nfet_01v8 L=0.15 W=0.5 nf=1 ad=0.145 as=0.145 pd=1.58 ps=1.58 nrd=0.58 nrs=0.58 sa=0 sb=0 sd=0 mult=1 m=1
XMNI_m06_w1 wbl_m06_w1 wenb 0 0 sky130_fd_pr__nfet_01v8 L=0.15 W=0.42 nf=1 ad=0.1218 as=0.1218 pd=1.42 ps=1.42 nrd=0.69047619047619 nrs=0.69047619047619 sa=0 sb=0 sd=0 mult=1 m=1
XMNS_m06_w1 sbl_m06_w1 sel_69500 rbl_m06_w1 0 sky130_fd_pr__nfet_01v8 L=0.15 W=0.42 nf=1 ad=0.1218 as=0.1218 pd=1.42 ps=1.42 nrd=0.69047619047619 nrs=0.69047619047619 sa=0 sb=0 sd=0 mult=1 m=1
XMPS_m06_w1 sbl_m06_w1 selb_69500 rbl_m06_w1 vdd sky130_fd_pr__pfet_01v8 L=0.15 W=0.84 nf=1 ad=0.2436 as=0.2436 pd=2.26 ps=2.26 nrd=0.3452380952381 nrs=0.3452380952381 sa=0 sb=0 sd=0 mult=1 m=1
XMNSR_m06_w1 sref_m06_w1 sel_69500 ref_m06_w1 0 sky130_fd_pr__nfet_01v8 L=0.15 W=0.42 nf=1 ad=0.1218 as=0.1218 pd=1.42 ps=1.42 nrd=0.69047619047619 nrs=0.69047619047619 sa=0 sb=0 sd=0 mult=1 m=1
XMPSR_m06_w1 sref_m06_w1 selb_69500 ref_m06_w1 vdd sky130_fd_pr__pfet_01v8 L=0.15 W=0.84 nf=1 ad=0.2436 as=0.2436 pd=2.26 ps=2.26 nrd=0.3452380952381 nrs=0.3452380952381 sa=0 sb=0 sd=0 mult=1 m=1
XMPPREF_m06_w1 ref_m06_w1 pcb_100 pref pref sky130_fd_pr__pfet_01v8 L=0.15 W=4 nf=1 ad=1.16 as=1.16 pd=8.58 ps=8.58 nrd=0.0725 nrs=0.0725 sa=0 sb=0 sd=0 mult=1 m=1   $ reference-side precharge: copy of MPPRE
XMN1_m06_w1 sbl_m06_w1 sref_m06_w1 vn_m06_w1 0 sky130_fd_pr__nfet_01v8 L=0.15 W=1 nf=1 ad=0.29 as=0.29 pd=2.58 ps=2.58 nrd=0.29 nrs=0.29 sa=0 sb=0 sd=0 mult=1 m=1
XMN2_m06_w1 sref_m06_w1 sbl_m06_w1 vn_m06_w1 0 sky130_fd_pr__nfet_01v8 L=0.15 W=1 nf=1 ad=0.29 as=0.29 pd=2.58 ps=2.58 nrd=0.29 nrs=0.29 sa=0 sb=0 sd=0 mult=1 m=1
XMP1_m06_w1 sbl_m06_w1 sref_m06_w1 vp_m06_w1 vdd sky130_fd_pr__pfet_01v8 L=0.15 W=2 nf=1 ad=0.58 as=0.58 pd=4.58 ps=4.58 nrd=0.145 nrs=0.145 sa=0 sb=0 sd=0 mult=1 m=1
XMP2_m06_w1 sref_m06_w1 sbl_m06_w1 vp_m06_w1 vdd sky130_fd_pr__pfet_01v8 L=0.15 W=2 nf=1 ad=0.58 as=0.58 pd=4.58 ps=4.58 nrd=0.145 nrs=0.145 sa=0 sb=0 sd=0 mult=1 m=1
XMNF_m06_w1 vn_m06_w1 en 0 0 sky130_fd_pr__nfet_01v8 L=0.15 W=2 nf=1 ad=0.58 as=0.58 pd=4.58 ps=4.58 nrd=0.145 nrs=0.145 sa=0 sb=0 sd=0 mult=1 m=1
XMPH_m06_w1 vp_m06_w1 enb vdd vdd sky130_fd_pr__pfet_01v8 L=0.15 W=4 nf=1 ad=1.16 as=1.16 pd=8.58 ps=8.58 nrd=0.0725 nrs=0.0725 sa=0 sb=0 sd=0 mult=1 m=1
bd_m06_w1 d_m06_w1 0 v=v(sbl_m06_w1)-v(sref_m06_w1)
bdabs_m06_w1 dabs_m06_w1 0 v=abs(v(sbl_m06_w1)-v(sref_m06_w1))

* ---- instance 47: m06_w0 (TG 0.42 / 0.84 [matched ref precharge]) ----
XMWR_m06_w0_0 sn_m06_w0_0 wl wbl_m06_w0 0 sky130_fd_pr__nfet_01v8 L=0.15 W=0.42 nf=1 ad=0.1218 as=0.1218 pd=1.42 ps=1.42 nrd=0.69047619047619 nrs=0.69047619047619 sa=0 sb=0 sd=0 mult=1 m=1
XMRD_m06_w0_0 rbl_m06_w0 sn_m06_w0_0 rwl_sel 0 sky130_fd_pr__nfet_01v8 L=0.15 W=0.42 nf=1 ad=0.1218 as=0.1218 pd=1.42 ps=1.42 nrd=0.69047619047619 nrs=0.69047619047619 sa=0 sb=0 sd=0 mult=1 m=1
csn_m06_w0_0 sn_m06_w0_0 0 {C_SN}
XMWR_m06_w0_1 sn_m06_w0_1 0 wbl_m06_w0 0 sky130_fd_pr__nfet_01v8 L=0.15 W=0.42 nf=1 ad=0.1218 as=0.1218 pd=1.42 ps=1.42 nrd=0.69047619047619 nrs=0.69047619047619 sa=0 sb=0 sd=0 mult=1 m=1
XMRD_m06_w0_1 rbl_m06_w0 sn_m06_w0_1 rwl_des 0 sky130_fd_pr__nfet_01v8 L=0.15 W=0.42 nf=1 ad=0.1218 as=0.1218 pd=1.42 ps=1.42 nrd=0.69047619047619 nrs=0.69047619047619 sa=0 sb=0 sd=0 mult=1 m=1
csn_m06_w0_1 sn_m06_w0_1 0 {C_SN}
XMWR_m06_w0_2 sn_m06_w0_2 0 wbl_m06_w0 0 sky130_fd_pr__nfet_01v8 L=0.15 W=0.42 nf=1 ad=0.1218 as=0.1218 pd=1.42 ps=1.42 nrd=0.69047619047619 nrs=0.69047619047619 sa=0 sb=0 sd=0 mult=1 m=1
XMRD_m06_w0_2 rbl_m06_w0 sn_m06_w0_2 rwl_des 0 sky130_fd_pr__nfet_01v8 L=0.15 W=0.42 nf=1 ad=0.1218 as=0.1218 pd=1.42 ps=1.42 nrd=0.69047619047619 nrs=0.69047619047619 sa=0 sb=0 sd=0 mult=1 m=1
csn_m06_w0_2 sn_m06_w0_2 0 {C_SN}
XMWR_m06_w0_3 sn_m06_w0_3 0 wbl_m06_w0 0 sky130_fd_pr__nfet_01v8 L=0.15 W=0.42 nf=1 ad=0.1218 as=0.1218 pd=1.42 ps=1.42 nrd=0.69047619047619 nrs=0.69047619047619 sa=0 sb=0 sd=0 mult=1 m=1
XMRD_m06_w0_3 rbl_m06_w0 sn_m06_w0_3 rwl_des 0 sky130_fd_pr__nfet_01v8 L=0.15 W=0.42 nf=1 ad=0.1218 as=0.1218 pd=1.42 ps=1.42 nrd=0.69047619047619 nrs=0.69047619047619 sa=0 sb=0 sd=0 mult=1 m=1
csn_m06_w0_3 sn_m06_w0_3 0 {C_SN}
crbl_m06_w0 rbl_m06_w0 0 {C_RBL}
cwbl_m06_w0 wbl_m06_w0 0 {C_WBL}
cref_m06_w0 ref_m06_w0 0 {C_RBL}   $ ASSUMPTION: ideal matched dummy load
XMPPRE_m06_w0 rbl_m06_w0 pcb_100 prea prea sky130_fd_pr__pfet_01v8 L=0.15 W=4 nf=1 ad=1.16 as=1.16 pd=8.58 ps=8.58 nrd=0.0725 nrs=0.0725 sa=0 sb=0 sd=0 mult=1 m=1
XMPU1_m06_w0 x_m06_w0 dinb0 vdd vdd sky130_fd_pr__pfet_01v8 L=0.15 W=1 nf=1 ad=0.29 as=0.29 pd=2.58 ps=2.58 nrd=0.29 nrs=0.29 sa=0 sb=0 sd=0 mult=1 m=1
XMPU2_m06_w0 wbl_m06_w0 wenb x_m06_w0 vdd sky130_fd_pr__pfet_01v8 L=0.15 W=1 nf=1 ad=0.29 as=0.29 pd=2.58 ps=2.58 nrd=0.29 nrs=0.29 sa=0 sb=0 sd=0 mult=1 m=1
XMND2_m06_w0 wbl_m06_w0 wen y_m06_w0 0 sky130_fd_pr__nfet_01v8 L=0.15 W=0.5 nf=1 ad=0.145 as=0.145 pd=1.58 ps=1.58 nrd=0.58 nrs=0.58 sa=0 sb=0 sd=0 mult=1 m=1
XMND1_m06_w0 y_m06_w0 dinb0 0 0 sky130_fd_pr__nfet_01v8 L=0.15 W=0.5 nf=1 ad=0.145 as=0.145 pd=1.58 ps=1.58 nrd=0.58 nrs=0.58 sa=0 sb=0 sd=0 mult=1 m=1
XMNI_m06_w0 wbl_m06_w0 wenb 0 0 sky130_fd_pr__nfet_01v8 L=0.15 W=0.42 nf=1 ad=0.1218 as=0.1218 pd=1.42 ps=1.42 nrd=0.69047619047619 nrs=0.69047619047619 sa=0 sb=0 sd=0 mult=1 m=1
XMNS_m06_w0 sbl_m06_w0 sel_69500 rbl_m06_w0 0 sky130_fd_pr__nfet_01v8 L=0.15 W=0.42 nf=1 ad=0.1218 as=0.1218 pd=1.42 ps=1.42 nrd=0.69047619047619 nrs=0.69047619047619 sa=0 sb=0 sd=0 mult=1 m=1
XMPS_m06_w0 sbl_m06_w0 selb_69500 rbl_m06_w0 vdd sky130_fd_pr__pfet_01v8 L=0.15 W=0.84 nf=1 ad=0.2436 as=0.2436 pd=2.26 ps=2.26 nrd=0.3452380952381 nrs=0.3452380952381 sa=0 sb=0 sd=0 mult=1 m=1
XMNSR_m06_w0 sref_m06_w0 sel_69500 ref_m06_w0 0 sky130_fd_pr__nfet_01v8 L=0.15 W=0.42 nf=1 ad=0.1218 as=0.1218 pd=1.42 ps=1.42 nrd=0.69047619047619 nrs=0.69047619047619 sa=0 sb=0 sd=0 mult=1 m=1
XMPSR_m06_w0 sref_m06_w0 selb_69500 ref_m06_w0 vdd sky130_fd_pr__pfet_01v8 L=0.15 W=0.84 nf=1 ad=0.2436 as=0.2436 pd=2.26 ps=2.26 nrd=0.3452380952381 nrs=0.3452380952381 sa=0 sb=0 sd=0 mult=1 m=1
XMPPREF_m06_w0 ref_m06_w0 pcb_100 pref pref sky130_fd_pr__pfet_01v8 L=0.15 W=4 nf=1 ad=1.16 as=1.16 pd=8.58 ps=8.58 nrd=0.0725 nrs=0.0725 sa=0 sb=0 sd=0 mult=1 m=1   $ reference-side precharge: copy of MPPRE
XMN1_m06_w0 sbl_m06_w0 sref_m06_w0 vn_m06_w0 0 sky130_fd_pr__nfet_01v8 L=0.15 W=1 nf=1 ad=0.29 as=0.29 pd=2.58 ps=2.58 nrd=0.29 nrs=0.29 sa=0 sb=0 sd=0 mult=1 m=1
XMN2_m06_w0 sref_m06_w0 sbl_m06_w0 vn_m06_w0 0 sky130_fd_pr__nfet_01v8 L=0.15 W=1 nf=1 ad=0.29 as=0.29 pd=2.58 ps=2.58 nrd=0.29 nrs=0.29 sa=0 sb=0 sd=0 mult=1 m=1
XMP1_m06_w0 sbl_m06_w0 sref_m06_w0 vp_m06_w0 vdd sky130_fd_pr__pfet_01v8 L=0.15 W=2 nf=1 ad=0.58 as=0.58 pd=4.58 ps=4.58 nrd=0.145 nrs=0.145 sa=0 sb=0 sd=0 mult=1 m=1
XMP2_m06_w0 sref_m06_w0 sbl_m06_w0 vp_m06_w0 vdd sky130_fd_pr__pfet_01v8 L=0.15 W=2 nf=1 ad=0.58 as=0.58 pd=4.58 ps=4.58 nrd=0.145 nrs=0.145 sa=0 sb=0 sd=0 mult=1 m=1
XMNF_m06_w0 vn_m06_w0 en 0 0 sky130_fd_pr__nfet_01v8 L=0.15 W=2 nf=1 ad=0.58 as=0.58 pd=4.58 ps=4.58 nrd=0.145 nrs=0.145 sa=0 sb=0 sd=0 mult=1 m=1
XMPH_m06_w0 vp_m06_w0 enb vdd vdd sky130_fd_pr__pfet_01v8 L=0.15 W=4 nf=1 ad=1.16 as=1.16 pd=8.58 ps=8.58 nrd=0.0725 nrs=0.0725 sa=0 sb=0 sd=0 mult=1 m=1
bd_m06_w0 d_m06_w0 0 v=v(sbl_m06_w0)-v(sref_m06_w0)
bdabs_m06_w0 dabs_m06_w0 0 v=abs(v(sbl_m06_w0)-v(sref_m06_w0))

* ---- instance 48: m07_w1 (TG 2.0 / 4.0 (direction check) [matched ref precharge]) ----
XMWR_m07_w1_0 sn_m07_w1_0 wl wbl_m07_w1 0 sky130_fd_pr__nfet_01v8 L=0.15 W=0.42 nf=1 ad=0.1218 as=0.1218 pd=1.42 ps=1.42 nrd=0.69047619047619 nrs=0.69047619047619 sa=0 sb=0 sd=0 mult=1 m=1
XMRD_m07_w1_0 rbl_m07_w1 sn_m07_w1_0 rwl_sel 0 sky130_fd_pr__nfet_01v8 L=0.15 W=0.42 nf=1 ad=0.1218 as=0.1218 pd=1.42 ps=1.42 nrd=0.69047619047619 nrs=0.69047619047619 sa=0 sb=0 sd=0 mult=1 m=1
csn_m07_w1_0 sn_m07_w1_0 0 {C_SN}
XMWR_m07_w1_1 sn_m07_w1_1 0 wbl_m07_w1 0 sky130_fd_pr__nfet_01v8 L=0.15 W=0.42 nf=1 ad=0.1218 as=0.1218 pd=1.42 ps=1.42 nrd=0.69047619047619 nrs=0.69047619047619 sa=0 sb=0 sd=0 mult=1 m=1
XMRD_m07_w1_1 rbl_m07_w1 sn_m07_w1_1 rwl_des 0 sky130_fd_pr__nfet_01v8 L=0.15 W=0.42 nf=1 ad=0.1218 as=0.1218 pd=1.42 ps=1.42 nrd=0.69047619047619 nrs=0.69047619047619 sa=0 sb=0 sd=0 mult=1 m=1
csn_m07_w1_1 sn_m07_w1_1 0 {C_SN}
XMWR_m07_w1_2 sn_m07_w1_2 0 wbl_m07_w1 0 sky130_fd_pr__nfet_01v8 L=0.15 W=0.42 nf=1 ad=0.1218 as=0.1218 pd=1.42 ps=1.42 nrd=0.69047619047619 nrs=0.69047619047619 sa=0 sb=0 sd=0 mult=1 m=1
XMRD_m07_w1_2 rbl_m07_w1 sn_m07_w1_2 rwl_des 0 sky130_fd_pr__nfet_01v8 L=0.15 W=0.42 nf=1 ad=0.1218 as=0.1218 pd=1.42 ps=1.42 nrd=0.69047619047619 nrs=0.69047619047619 sa=0 sb=0 sd=0 mult=1 m=1
csn_m07_w1_2 sn_m07_w1_2 0 {C_SN}
XMWR_m07_w1_3 sn_m07_w1_3 0 wbl_m07_w1 0 sky130_fd_pr__nfet_01v8 L=0.15 W=0.42 nf=1 ad=0.1218 as=0.1218 pd=1.42 ps=1.42 nrd=0.69047619047619 nrs=0.69047619047619 sa=0 sb=0 sd=0 mult=1 m=1
XMRD_m07_w1_3 rbl_m07_w1 sn_m07_w1_3 rwl_des 0 sky130_fd_pr__nfet_01v8 L=0.15 W=0.42 nf=1 ad=0.1218 as=0.1218 pd=1.42 ps=1.42 nrd=0.69047619047619 nrs=0.69047619047619 sa=0 sb=0 sd=0 mult=1 m=1
csn_m07_w1_3 sn_m07_w1_3 0 {C_SN}
crbl_m07_w1 rbl_m07_w1 0 {C_RBL}
cwbl_m07_w1 wbl_m07_w1 0 {C_WBL}
cref_m07_w1 ref_m07_w1 0 {C_RBL}   $ ASSUMPTION: ideal matched dummy load
XMPPRE_m07_w1 rbl_m07_w1 pcb_100 prea prea sky130_fd_pr__pfet_01v8 L=0.15 W=4 nf=1 ad=1.16 as=1.16 pd=8.58 ps=8.58 nrd=0.0725 nrs=0.0725 sa=0 sb=0 sd=0 mult=1 m=1
XMPU1_m07_w1 x_m07_w1 dinb1 vdd vdd sky130_fd_pr__pfet_01v8 L=0.15 W=1 nf=1 ad=0.29 as=0.29 pd=2.58 ps=2.58 nrd=0.29 nrs=0.29 sa=0 sb=0 sd=0 mult=1 m=1
XMPU2_m07_w1 wbl_m07_w1 wenb x_m07_w1 vdd sky130_fd_pr__pfet_01v8 L=0.15 W=1 nf=1 ad=0.29 as=0.29 pd=2.58 ps=2.58 nrd=0.29 nrs=0.29 sa=0 sb=0 sd=0 mult=1 m=1
XMND2_m07_w1 wbl_m07_w1 wen y_m07_w1 0 sky130_fd_pr__nfet_01v8 L=0.15 W=0.5 nf=1 ad=0.145 as=0.145 pd=1.58 ps=1.58 nrd=0.58 nrs=0.58 sa=0 sb=0 sd=0 mult=1 m=1
XMND1_m07_w1 y_m07_w1 dinb1 0 0 sky130_fd_pr__nfet_01v8 L=0.15 W=0.5 nf=1 ad=0.145 as=0.145 pd=1.58 ps=1.58 nrd=0.58 nrs=0.58 sa=0 sb=0 sd=0 mult=1 m=1
XMNI_m07_w1 wbl_m07_w1 wenb 0 0 sky130_fd_pr__nfet_01v8 L=0.15 W=0.42 nf=1 ad=0.1218 as=0.1218 pd=1.42 ps=1.42 nrd=0.69047619047619 nrs=0.69047619047619 sa=0 sb=0 sd=0 mult=1 m=1
XMNS_m07_w1 sbl_m07_w1 sel_69500 rbl_m07_w1 0 sky130_fd_pr__nfet_01v8 L=0.15 W=2 nf=1 ad=0.58 as=0.58 pd=4.58 ps=4.58 nrd=0.145 nrs=0.145 sa=0 sb=0 sd=0 mult=1 m=1
XMPS_m07_w1 sbl_m07_w1 selb_69500 rbl_m07_w1 vdd sky130_fd_pr__pfet_01v8 L=0.15 W=4 nf=1 ad=1.16 as=1.16 pd=8.58 ps=8.58 nrd=0.0725 nrs=0.0725 sa=0 sb=0 sd=0 mult=1 m=1
XMNSR_m07_w1 sref_m07_w1 sel_69500 ref_m07_w1 0 sky130_fd_pr__nfet_01v8 L=0.15 W=2 nf=1 ad=0.58 as=0.58 pd=4.58 ps=4.58 nrd=0.145 nrs=0.145 sa=0 sb=0 sd=0 mult=1 m=1
XMPSR_m07_w1 sref_m07_w1 selb_69500 ref_m07_w1 vdd sky130_fd_pr__pfet_01v8 L=0.15 W=4 nf=1 ad=1.16 as=1.16 pd=8.58 ps=8.58 nrd=0.0725 nrs=0.0725 sa=0 sb=0 sd=0 mult=1 m=1
XMPPREF_m07_w1 ref_m07_w1 pcb_100 pref pref sky130_fd_pr__pfet_01v8 L=0.15 W=4 nf=1 ad=1.16 as=1.16 pd=8.58 ps=8.58 nrd=0.0725 nrs=0.0725 sa=0 sb=0 sd=0 mult=1 m=1   $ reference-side precharge: copy of MPPRE
XMN1_m07_w1 sbl_m07_w1 sref_m07_w1 vn_m07_w1 0 sky130_fd_pr__nfet_01v8 L=0.15 W=1 nf=1 ad=0.29 as=0.29 pd=2.58 ps=2.58 nrd=0.29 nrs=0.29 sa=0 sb=0 sd=0 mult=1 m=1
XMN2_m07_w1 sref_m07_w1 sbl_m07_w1 vn_m07_w1 0 sky130_fd_pr__nfet_01v8 L=0.15 W=1 nf=1 ad=0.29 as=0.29 pd=2.58 ps=2.58 nrd=0.29 nrs=0.29 sa=0 sb=0 sd=0 mult=1 m=1
XMP1_m07_w1 sbl_m07_w1 sref_m07_w1 vp_m07_w1 vdd sky130_fd_pr__pfet_01v8 L=0.15 W=2 nf=1 ad=0.58 as=0.58 pd=4.58 ps=4.58 nrd=0.145 nrs=0.145 sa=0 sb=0 sd=0 mult=1 m=1
XMP2_m07_w1 sref_m07_w1 sbl_m07_w1 vp_m07_w1 vdd sky130_fd_pr__pfet_01v8 L=0.15 W=2 nf=1 ad=0.58 as=0.58 pd=4.58 ps=4.58 nrd=0.145 nrs=0.145 sa=0 sb=0 sd=0 mult=1 m=1
XMNF_m07_w1 vn_m07_w1 en 0 0 sky130_fd_pr__nfet_01v8 L=0.15 W=2 nf=1 ad=0.58 as=0.58 pd=4.58 ps=4.58 nrd=0.145 nrs=0.145 sa=0 sb=0 sd=0 mult=1 m=1
XMPH_m07_w1 vp_m07_w1 enb vdd vdd sky130_fd_pr__pfet_01v8 L=0.15 W=4 nf=1 ad=1.16 as=1.16 pd=8.58 ps=8.58 nrd=0.0725 nrs=0.0725 sa=0 sb=0 sd=0 mult=1 m=1
bd_m07_w1 d_m07_w1 0 v=v(sbl_m07_w1)-v(sref_m07_w1)
bdabs_m07_w1 dabs_m07_w1 0 v=abs(v(sbl_m07_w1)-v(sref_m07_w1))

* ---- instance 49: m07_w0 (TG 2.0 / 4.0 (direction check) [matched ref precharge]) ----
XMWR_m07_w0_0 sn_m07_w0_0 wl wbl_m07_w0 0 sky130_fd_pr__nfet_01v8 L=0.15 W=0.42 nf=1 ad=0.1218 as=0.1218 pd=1.42 ps=1.42 nrd=0.69047619047619 nrs=0.69047619047619 sa=0 sb=0 sd=0 mult=1 m=1
XMRD_m07_w0_0 rbl_m07_w0 sn_m07_w0_0 rwl_sel 0 sky130_fd_pr__nfet_01v8 L=0.15 W=0.42 nf=1 ad=0.1218 as=0.1218 pd=1.42 ps=1.42 nrd=0.69047619047619 nrs=0.69047619047619 sa=0 sb=0 sd=0 mult=1 m=1
csn_m07_w0_0 sn_m07_w0_0 0 {C_SN}
XMWR_m07_w0_1 sn_m07_w0_1 0 wbl_m07_w0 0 sky130_fd_pr__nfet_01v8 L=0.15 W=0.42 nf=1 ad=0.1218 as=0.1218 pd=1.42 ps=1.42 nrd=0.69047619047619 nrs=0.69047619047619 sa=0 sb=0 sd=0 mult=1 m=1
XMRD_m07_w0_1 rbl_m07_w0 sn_m07_w0_1 rwl_des 0 sky130_fd_pr__nfet_01v8 L=0.15 W=0.42 nf=1 ad=0.1218 as=0.1218 pd=1.42 ps=1.42 nrd=0.69047619047619 nrs=0.69047619047619 sa=0 sb=0 sd=0 mult=1 m=1
csn_m07_w0_1 sn_m07_w0_1 0 {C_SN}
XMWR_m07_w0_2 sn_m07_w0_2 0 wbl_m07_w0 0 sky130_fd_pr__nfet_01v8 L=0.15 W=0.42 nf=1 ad=0.1218 as=0.1218 pd=1.42 ps=1.42 nrd=0.69047619047619 nrs=0.69047619047619 sa=0 sb=0 sd=0 mult=1 m=1
XMRD_m07_w0_2 rbl_m07_w0 sn_m07_w0_2 rwl_des 0 sky130_fd_pr__nfet_01v8 L=0.15 W=0.42 nf=1 ad=0.1218 as=0.1218 pd=1.42 ps=1.42 nrd=0.69047619047619 nrs=0.69047619047619 sa=0 sb=0 sd=0 mult=1 m=1
csn_m07_w0_2 sn_m07_w0_2 0 {C_SN}
XMWR_m07_w0_3 sn_m07_w0_3 0 wbl_m07_w0 0 sky130_fd_pr__nfet_01v8 L=0.15 W=0.42 nf=1 ad=0.1218 as=0.1218 pd=1.42 ps=1.42 nrd=0.69047619047619 nrs=0.69047619047619 sa=0 sb=0 sd=0 mult=1 m=1
XMRD_m07_w0_3 rbl_m07_w0 sn_m07_w0_3 rwl_des 0 sky130_fd_pr__nfet_01v8 L=0.15 W=0.42 nf=1 ad=0.1218 as=0.1218 pd=1.42 ps=1.42 nrd=0.69047619047619 nrs=0.69047619047619 sa=0 sb=0 sd=0 mult=1 m=1
csn_m07_w0_3 sn_m07_w0_3 0 {C_SN}
crbl_m07_w0 rbl_m07_w0 0 {C_RBL}
cwbl_m07_w0 wbl_m07_w0 0 {C_WBL}
cref_m07_w0 ref_m07_w0 0 {C_RBL}   $ ASSUMPTION: ideal matched dummy load
XMPPRE_m07_w0 rbl_m07_w0 pcb_100 prea prea sky130_fd_pr__pfet_01v8 L=0.15 W=4 nf=1 ad=1.16 as=1.16 pd=8.58 ps=8.58 nrd=0.0725 nrs=0.0725 sa=0 sb=0 sd=0 mult=1 m=1
XMPU1_m07_w0 x_m07_w0 dinb0 vdd vdd sky130_fd_pr__pfet_01v8 L=0.15 W=1 nf=1 ad=0.29 as=0.29 pd=2.58 ps=2.58 nrd=0.29 nrs=0.29 sa=0 sb=0 sd=0 mult=1 m=1
XMPU2_m07_w0 wbl_m07_w0 wenb x_m07_w0 vdd sky130_fd_pr__pfet_01v8 L=0.15 W=1 nf=1 ad=0.29 as=0.29 pd=2.58 ps=2.58 nrd=0.29 nrs=0.29 sa=0 sb=0 sd=0 mult=1 m=1
XMND2_m07_w0 wbl_m07_w0 wen y_m07_w0 0 sky130_fd_pr__nfet_01v8 L=0.15 W=0.5 nf=1 ad=0.145 as=0.145 pd=1.58 ps=1.58 nrd=0.58 nrs=0.58 sa=0 sb=0 sd=0 mult=1 m=1
XMND1_m07_w0 y_m07_w0 dinb0 0 0 sky130_fd_pr__nfet_01v8 L=0.15 W=0.5 nf=1 ad=0.145 as=0.145 pd=1.58 ps=1.58 nrd=0.58 nrs=0.58 sa=0 sb=0 sd=0 mult=1 m=1
XMNI_m07_w0 wbl_m07_w0 wenb 0 0 sky130_fd_pr__nfet_01v8 L=0.15 W=0.42 nf=1 ad=0.1218 as=0.1218 pd=1.42 ps=1.42 nrd=0.69047619047619 nrs=0.69047619047619 sa=0 sb=0 sd=0 mult=1 m=1
XMNS_m07_w0 sbl_m07_w0 sel_69500 rbl_m07_w0 0 sky130_fd_pr__nfet_01v8 L=0.15 W=2 nf=1 ad=0.58 as=0.58 pd=4.58 ps=4.58 nrd=0.145 nrs=0.145 sa=0 sb=0 sd=0 mult=1 m=1
XMPS_m07_w0 sbl_m07_w0 selb_69500 rbl_m07_w0 vdd sky130_fd_pr__pfet_01v8 L=0.15 W=4 nf=1 ad=1.16 as=1.16 pd=8.58 ps=8.58 nrd=0.0725 nrs=0.0725 sa=0 sb=0 sd=0 mult=1 m=1
XMNSR_m07_w0 sref_m07_w0 sel_69500 ref_m07_w0 0 sky130_fd_pr__nfet_01v8 L=0.15 W=2 nf=1 ad=0.58 as=0.58 pd=4.58 ps=4.58 nrd=0.145 nrs=0.145 sa=0 sb=0 sd=0 mult=1 m=1
XMPSR_m07_w0 sref_m07_w0 selb_69500 ref_m07_w0 vdd sky130_fd_pr__pfet_01v8 L=0.15 W=4 nf=1 ad=1.16 as=1.16 pd=8.58 ps=8.58 nrd=0.0725 nrs=0.0725 sa=0 sb=0 sd=0 mult=1 m=1
XMPPREF_m07_w0 ref_m07_w0 pcb_100 pref pref sky130_fd_pr__pfet_01v8 L=0.15 W=4 nf=1 ad=1.16 as=1.16 pd=8.58 ps=8.58 nrd=0.0725 nrs=0.0725 sa=0 sb=0 sd=0 mult=1 m=1   $ reference-side precharge: copy of MPPRE
XMN1_m07_w0 sbl_m07_w0 sref_m07_w0 vn_m07_w0 0 sky130_fd_pr__nfet_01v8 L=0.15 W=1 nf=1 ad=0.29 as=0.29 pd=2.58 ps=2.58 nrd=0.29 nrs=0.29 sa=0 sb=0 sd=0 mult=1 m=1
XMN2_m07_w0 sref_m07_w0 sbl_m07_w0 vn_m07_w0 0 sky130_fd_pr__nfet_01v8 L=0.15 W=1 nf=1 ad=0.29 as=0.29 pd=2.58 ps=2.58 nrd=0.29 nrs=0.29 sa=0 sb=0 sd=0 mult=1 m=1
XMP1_m07_w0 sbl_m07_w0 sref_m07_w0 vp_m07_w0 vdd sky130_fd_pr__pfet_01v8 L=0.15 W=2 nf=1 ad=0.58 as=0.58 pd=4.58 ps=4.58 nrd=0.145 nrs=0.145 sa=0 sb=0 sd=0 mult=1 m=1
XMP2_m07_w0 sref_m07_w0 sbl_m07_w0 vp_m07_w0 vdd sky130_fd_pr__pfet_01v8 L=0.15 W=2 nf=1 ad=0.58 as=0.58 pd=4.58 ps=4.58 nrd=0.145 nrs=0.145 sa=0 sb=0 sd=0 mult=1 m=1
XMNF_m07_w0 vn_m07_w0 en 0 0 sky130_fd_pr__nfet_01v8 L=0.15 W=2 nf=1 ad=0.58 as=0.58 pd=4.58 ps=4.58 nrd=0.145 nrs=0.145 sa=0 sb=0 sd=0 mult=1 m=1
XMPH_m07_w0 vp_m07_w0 enb vdd vdd sky130_fd_pr__pfet_01v8 L=0.15 W=4 nf=1 ad=1.16 as=1.16 pd=8.58 ps=8.58 nrd=0.0725 nrs=0.0725 sa=0 sb=0 sd=0 mult=1 m=1
bd_m07_w0 d_m07_w0 0 v=v(sbl_m07_w0)-v(sref_m07_w0)
bdabs_m07_w0 dabs_m07_w0 0 v=abs(v(sbl_m07_w0)-v(sref_m07_w0))

* ---- instance 50: m08_w1 (nfet only 1.0 [matched ref precharge]) ----
XMWR_m08_w1_0 sn_m08_w1_0 wl wbl_m08_w1 0 sky130_fd_pr__nfet_01v8 L=0.15 W=0.42 nf=1 ad=0.1218 as=0.1218 pd=1.42 ps=1.42 nrd=0.69047619047619 nrs=0.69047619047619 sa=0 sb=0 sd=0 mult=1 m=1
XMRD_m08_w1_0 rbl_m08_w1 sn_m08_w1_0 rwl_sel 0 sky130_fd_pr__nfet_01v8 L=0.15 W=0.42 nf=1 ad=0.1218 as=0.1218 pd=1.42 ps=1.42 nrd=0.69047619047619 nrs=0.69047619047619 sa=0 sb=0 sd=0 mult=1 m=1
csn_m08_w1_0 sn_m08_w1_0 0 {C_SN}
XMWR_m08_w1_1 sn_m08_w1_1 0 wbl_m08_w1 0 sky130_fd_pr__nfet_01v8 L=0.15 W=0.42 nf=1 ad=0.1218 as=0.1218 pd=1.42 ps=1.42 nrd=0.69047619047619 nrs=0.69047619047619 sa=0 sb=0 sd=0 mult=1 m=1
XMRD_m08_w1_1 rbl_m08_w1 sn_m08_w1_1 rwl_des 0 sky130_fd_pr__nfet_01v8 L=0.15 W=0.42 nf=1 ad=0.1218 as=0.1218 pd=1.42 ps=1.42 nrd=0.69047619047619 nrs=0.69047619047619 sa=0 sb=0 sd=0 mult=1 m=1
csn_m08_w1_1 sn_m08_w1_1 0 {C_SN}
XMWR_m08_w1_2 sn_m08_w1_2 0 wbl_m08_w1 0 sky130_fd_pr__nfet_01v8 L=0.15 W=0.42 nf=1 ad=0.1218 as=0.1218 pd=1.42 ps=1.42 nrd=0.69047619047619 nrs=0.69047619047619 sa=0 sb=0 sd=0 mult=1 m=1
XMRD_m08_w1_2 rbl_m08_w1 sn_m08_w1_2 rwl_des 0 sky130_fd_pr__nfet_01v8 L=0.15 W=0.42 nf=1 ad=0.1218 as=0.1218 pd=1.42 ps=1.42 nrd=0.69047619047619 nrs=0.69047619047619 sa=0 sb=0 sd=0 mult=1 m=1
csn_m08_w1_2 sn_m08_w1_2 0 {C_SN}
XMWR_m08_w1_3 sn_m08_w1_3 0 wbl_m08_w1 0 sky130_fd_pr__nfet_01v8 L=0.15 W=0.42 nf=1 ad=0.1218 as=0.1218 pd=1.42 ps=1.42 nrd=0.69047619047619 nrs=0.69047619047619 sa=0 sb=0 sd=0 mult=1 m=1
XMRD_m08_w1_3 rbl_m08_w1 sn_m08_w1_3 rwl_des 0 sky130_fd_pr__nfet_01v8 L=0.15 W=0.42 nf=1 ad=0.1218 as=0.1218 pd=1.42 ps=1.42 nrd=0.69047619047619 nrs=0.69047619047619 sa=0 sb=0 sd=0 mult=1 m=1
csn_m08_w1_3 sn_m08_w1_3 0 {C_SN}
crbl_m08_w1 rbl_m08_w1 0 {C_RBL}
cwbl_m08_w1 wbl_m08_w1 0 {C_WBL}
cref_m08_w1 ref_m08_w1 0 {C_RBL}   $ ASSUMPTION: ideal matched dummy load
XMPPRE_m08_w1 rbl_m08_w1 pcb_100 prea prea sky130_fd_pr__pfet_01v8 L=0.15 W=4 nf=1 ad=1.16 as=1.16 pd=8.58 ps=8.58 nrd=0.0725 nrs=0.0725 sa=0 sb=0 sd=0 mult=1 m=1
XMPU1_m08_w1 x_m08_w1 dinb1 vdd vdd sky130_fd_pr__pfet_01v8 L=0.15 W=1 nf=1 ad=0.29 as=0.29 pd=2.58 ps=2.58 nrd=0.29 nrs=0.29 sa=0 sb=0 sd=0 mult=1 m=1
XMPU2_m08_w1 wbl_m08_w1 wenb x_m08_w1 vdd sky130_fd_pr__pfet_01v8 L=0.15 W=1 nf=1 ad=0.29 as=0.29 pd=2.58 ps=2.58 nrd=0.29 nrs=0.29 sa=0 sb=0 sd=0 mult=1 m=1
XMND2_m08_w1 wbl_m08_w1 wen y_m08_w1 0 sky130_fd_pr__nfet_01v8 L=0.15 W=0.5 nf=1 ad=0.145 as=0.145 pd=1.58 ps=1.58 nrd=0.58 nrs=0.58 sa=0 sb=0 sd=0 mult=1 m=1
XMND1_m08_w1 y_m08_w1 dinb1 0 0 sky130_fd_pr__nfet_01v8 L=0.15 W=0.5 nf=1 ad=0.145 as=0.145 pd=1.58 ps=1.58 nrd=0.58 nrs=0.58 sa=0 sb=0 sd=0 mult=1 m=1
XMNI_m08_w1 wbl_m08_w1 wenb 0 0 sky130_fd_pr__nfet_01v8 L=0.15 W=0.42 nf=1 ad=0.1218 as=0.1218 pd=1.42 ps=1.42 nrd=0.69047619047619 nrs=0.69047619047619 sa=0 sb=0 sd=0 mult=1 m=1
XMNS_m08_w1 sbl_m08_w1 sel_69500 rbl_m08_w1 0 sky130_fd_pr__nfet_01v8 L=0.15 W=1 nf=1 ad=0.29 as=0.29 pd=2.58 ps=2.58 nrd=0.29 nrs=0.29 sa=0 sb=0 sd=0 mult=1 m=1
XMNSR_m08_w1 sref_m08_w1 sel_69500 ref_m08_w1 0 sky130_fd_pr__nfet_01v8 L=0.15 W=1 nf=1 ad=0.29 as=0.29 pd=2.58 ps=2.58 nrd=0.29 nrs=0.29 sa=0 sb=0 sd=0 mult=1 m=1
XMPPREF_m08_w1 ref_m08_w1 pcb_100 pref pref sky130_fd_pr__pfet_01v8 L=0.15 W=4 nf=1 ad=1.16 as=1.16 pd=8.58 ps=8.58 nrd=0.0725 nrs=0.0725 sa=0 sb=0 sd=0 mult=1 m=1   $ reference-side precharge: copy of MPPRE
XMN1_m08_w1 sbl_m08_w1 sref_m08_w1 vn_m08_w1 0 sky130_fd_pr__nfet_01v8 L=0.15 W=1 nf=1 ad=0.29 as=0.29 pd=2.58 ps=2.58 nrd=0.29 nrs=0.29 sa=0 sb=0 sd=0 mult=1 m=1
XMN2_m08_w1 sref_m08_w1 sbl_m08_w1 vn_m08_w1 0 sky130_fd_pr__nfet_01v8 L=0.15 W=1 nf=1 ad=0.29 as=0.29 pd=2.58 ps=2.58 nrd=0.29 nrs=0.29 sa=0 sb=0 sd=0 mult=1 m=1
XMP1_m08_w1 sbl_m08_w1 sref_m08_w1 vp_m08_w1 vdd sky130_fd_pr__pfet_01v8 L=0.15 W=2 nf=1 ad=0.58 as=0.58 pd=4.58 ps=4.58 nrd=0.145 nrs=0.145 sa=0 sb=0 sd=0 mult=1 m=1
XMP2_m08_w1 sref_m08_w1 sbl_m08_w1 vp_m08_w1 vdd sky130_fd_pr__pfet_01v8 L=0.15 W=2 nf=1 ad=0.58 as=0.58 pd=4.58 ps=4.58 nrd=0.145 nrs=0.145 sa=0 sb=0 sd=0 mult=1 m=1
XMNF_m08_w1 vn_m08_w1 en 0 0 sky130_fd_pr__nfet_01v8 L=0.15 W=2 nf=1 ad=0.58 as=0.58 pd=4.58 ps=4.58 nrd=0.145 nrs=0.145 sa=0 sb=0 sd=0 mult=1 m=1
XMPH_m08_w1 vp_m08_w1 enb vdd vdd sky130_fd_pr__pfet_01v8 L=0.15 W=4 nf=1 ad=1.16 as=1.16 pd=8.58 ps=8.58 nrd=0.0725 nrs=0.0725 sa=0 sb=0 sd=0 mult=1 m=1
bd_m08_w1 d_m08_w1 0 v=v(sbl_m08_w1)-v(sref_m08_w1)
bdabs_m08_w1 dabs_m08_w1 0 v=abs(v(sbl_m08_w1)-v(sref_m08_w1))

* ---- instance 51: m08_w0 (nfet only 1.0 [matched ref precharge]) ----
XMWR_m08_w0_0 sn_m08_w0_0 wl wbl_m08_w0 0 sky130_fd_pr__nfet_01v8 L=0.15 W=0.42 nf=1 ad=0.1218 as=0.1218 pd=1.42 ps=1.42 nrd=0.69047619047619 nrs=0.69047619047619 sa=0 sb=0 sd=0 mult=1 m=1
XMRD_m08_w0_0 rbl_m08_w0 sn_m08_w0_0 rwl_sel 0 sky130_fd_pr__nfet_01v8 L=0.15 W=0.42 nf=1 ad=0.1218 as=0.1218 pd=1.42 ps=1.42 nrd=0.69047619047619 nrs=0.69047619047619 sa=0 sb=0 sd=0 mult=1 m=1
csn_m08_w0_0 sn_m08_w0_0 0 {C_SN}
XMWR_m08_w0_1 sn_m08_w0_1 0 wbl_m08_w0 0 sky130_fd_pr__nfet_01v8 L=0.15 W=0.42 nf=1 ad=0.1218 as=0.1218 pd=1.42 ps=1.42 nrd=0.69047619047619 nrs=0.69047619047619 sa=0 sb=0 sd=0 mult=1 m=1
XMRD_m08_w0_1 rbl_m08_w0 sn_m08_w0_1 rwl_des 0 sky130_fd_pr__nfet_01v8 L=0.15 W=0.42 nf=1 ad=0.1218 as=0.1218 pd=1.42 ps=1.42 nrd=0.69047619047619 nrs=0.69047619047619 sa=0 sb=0 sd=0 mult=1 m=1
csn_m08_w0_1 sn_m08_w0_1 0 {C_SN}
XMWR_m08_w0_2 sn_m08_w0_2 0 wbl_m08_w0 0 sky130_fd_pr__nfet_01v8 L=0.15 W=0.42 nf=1 ad=0.1218 as=0.1218 pd=1.42 ps=1.42 nrd=0.69047619047619 nrs=0.69047619047619 sa=0 sb=0 sd=0 mult=1 m=1
XMRD_m08_w0_2 rbl_m08_w0 sn_m08_w0_2 rwl_des 0 sky130_fd_pr__nfet_01v8 L=0.15 W=0.42 nf=1 ad=0.1218 as=0.1218 pd=1.42 ps=1.42 nrd=0.69047619047619 nrs=0.69047619047619 sa=0 sb=0 sd=0 mult=1 m=1
csn_m08_w0_2 sn_m08_w0_2 0 {C_SN}
XMWR_m08_w0_3 sn_m08_w0_3 0 wbl_m08_w0 0 sky130_fd_pr__nfet_01v8 L=0.15 W=0.42 nf=1 ad=0.1218 as=0.1218 pd=1.42 ps=1.42 nrd=0.69047619047619 nrs=0.69047619047619 sa=0 sb=0 sd=0 mult=1 m=1
XMRD_m08_w0_3 rbl_m08_w0 sn_m08_w0_3 rwl_des 0 sky130_fd_pr__nfet_01v8 L=0.15 W=0.42 nf=1 ad=0.1218 as=0.1218 pd=1.42 ps=1.42 nrd=0.69047619047619 nrs=0.69047619047619 sa=0 sb=0 sd=0 mult=1 m=1
csn_m08_w0_3 sn_m08_w0_3 0 {C_SN}
crbl_m08_w0 rbl_m08_w0 0 {C_RBL}
cwbl_m08_w0 wbl_m08_w0 0 {C_WBL}
cref_m08_w0 ref_m08_w0 0 {C_RBL}   $ ASSUMPTION: ideal matched dummy load
XMPPRE_m08_w0 rbl_m08_w0 pcb_100 prea prea sky130_fd_pr__pfet_01v8 L=0.15 W=4 nf=1 ad=1.16 as=1.16 pd=8.58 ps=8.58 nrd=0.0725 nrs=0.0725 sa=0 sb=0 sd=0 mult=1 m=1
XMPU1_m08_w0 x_m08_w0 dinb0 vdd vdd sky130_fd_pr__pfet_01v8 L=0.15 W=1 nf=1 ad=0.29 as=0.29 pd=2.58 ps=2.58 nrd=0.29 nrs=0.29 sa=0 sb=0 sd=0 mult=1 m=1
XMPU2_m08_w0 wbl_m08_w0 wenb x_m08_w0 vdd sky130_fd_pr__pfet_01v8 L=0.15 W=1 nf=1 ad=0.29 as=0.29 pd=2.58 ps=2.58 nrd=0.29 nrs=0.29 sa=0 sb=0 sd=0 mult=1 m=1
XMND2_m08_w0 wbl_m08_w0 wen y_m08_w0 0 sky130_fd_pr__nfet_01v8 L=0.15 W=0.5 nf=1 ad=0.145 as=0.145 pd=1.58 ps=1.58 nrd=0.58 nrs=0.58 sa=0 sb=0 sd=0 mult=1 m=1
XMND1_m08_w0 y_m08_w0 dinb0 0 0 sky130_fd_pr__nfet_01v8 L=0.15 W=0.5 nf=1 ad=0.145 as=0.145 pd=1.58 ps=1.58 nrd=0.58 nrs=0.58 sa=0 sb=0 sd=0 mult=1 m=1
XMNI_m08_w0 wbl_m08_w0 wenb 0 0 sky130_fd_pr__nfet_01v8 L=0.15 W=0.42 nf=1 ad=0.1218 as=0.1218 pd=1.42 ps=1.42 nrd=0.69047619047619 nrs=0.69047619047619 sa=0 sb=0 sd=0 mult=1 m=1
XMNS_m08_w0 sbl_m08_w0 sel_69500 rbl_m08_w0 0 sky130_fd_pr__nfet_01v8 L=0.15 W=1 nf=1 ad=0.29 as=0.29 pd=2.58 ps=2.58 nrd=0.29 nrs=0.29 sa=0 sb=0 sd=0 mult=1 m=1
XMNSR_m08_w0 sref_m08_w0 sel_69500 ref_m08_w0 0 sky130_fd_pr__nfet_01v8 L=0.15 W=1 nf=1 ad=0.29 as=0.29 pd=2.58 ps=2.58 nrd=0.29 nrs=0.29 sa=0 sb=0 sd=0 mult=1 m=1
XMPPREF_m08_w0 ref_m08_w0 pcb_100 pref pref sky130_fd_pr__pfet_01v8 L=0.15 W=4 nf=1 ad=1.16 as=1.16 pd=8.58 ps=8.58 nrd=0.0725 nrs=0.0725 sa=0 sb=0 sd=0 mult=1 m=1   $ reference-side precharge: copy of MPPRE
XMN1_m08_w0 sbl_m08_w0 sref_m08_w0 vn_m08_w0 0 sky130_fd_pr__nfet_01v8 L=0.15 W=1 nf=1 ad=0.29 as=0.29 pd=2.58 ps=2.58 nrd=0.29 nrs=0.29 sa=0 sb=0 sd=0 mult=1 m=1
XMN2_m08_w0 sref_m08_w0 sbl_m08_w0 vn_m08_w0 0 sky130_fd_pr__nfet_01v8 L=0.15 W=1 nf=1 ad=0.29 as=0.29 pd=2.58 ps=2.58 nrd=0.29 nrs=0.29 sa=0 sb=0 sd=0 mult=1 m=1
XMP1_m08_w0 sbl_m08_w0 sref_m08_w0 vp_m08_w0 vdd sky130_fd_pr__pfet_01v8 L=0.15 W=2 nf=1 ad=0.58 as=0.58 pd=4.58 ps=4.58 nrd=0.145 nrs=0.145 sa=0 sb=0 sd=0 mult=1 m=1
XMP2_m08_w0 sref_m08_w0 sbl_m08_w0 vp_m08_w0 vdd sky130_fd_pr__pfet_01v8 L=0.15 W=2 nf=1 ad=0.58 as=0.58 pd=4.58 ps=4.58 nrd=0.145 nrs=0.145 sa=0 sb=0 sd=0 mult=1 m=1
XMNF_m08_w0 vn_m08_w0 en 0 0 sky130_fd_pr__nfet_01v8 L=0.15 W=2 nf=1 ad=0.58 as=0.58 pd=4.58 ps=4.58 nrd=0.145 nrs=0.145 sa=0 sb=0 sd=0 mult=1 m=1
XMPH_m08_w0 vp_m08_w0 enb vdd vdd sky130_fd_pr__pfet_01v8 L=0.15 W=4 nf=1 ad=1.16 as=1.16 pd=8.58 ps=8.58 nrd=0.0725 nrs=0.0725 sa=0 sb=0 sd=0 mult=1 m=1
bd_m08_w0 d_m08_w0 0 v=v(sbl_m08_w0)-v(sref_m08_w0)
bdabs_m08_w0 dabs_m08_w0 0 v=abs(v(sbl_m08_w0)-v(sref_m08_w0))

* ---- instance 52: m09_w1 (nfet only 0.42 [matched ref precharge]) ----
XMWR_m09_w1_0 sn_m09_w1_0 wl wbl_m09_w1 0 sky130_fd_pr__nfet_01v8 L=0.15 W=0.42 nf=1 ad=0.1218 as=0.1218 pd=1.42 ps=1.42 nrd=0.69047619047619 nrs=0.69047619047619 sa=0 sb=0 sd=0 mult=1 m=1
XMRD_m09_w1_0 rbl_m09_w1 sn_m09_w1_0 rwl_sel 0 sky130_fd_pr__nfet_01v8 L=0.15 W=0.42 nf=1 ad=0.1218 as=0.1218 pd=1.42 ps=1.42 nrd=0.69047619047619 nrs=0.69047619047619 sa=0 sb=0 sd=0 mult=1 m=1
csn_m09_w1_0 sn_m09_w1_0 0 {C_SN}
XMWR_m09_w1_1 sn_m09_w1_1 0 wbl_m09_w1 0 sky130_fd_pr__nfet_01v8 L=0.15 W=0.42 nf=1 ad=0.1218 as=0.1218 pd=1.42 ps=1.42 nrd=0.69047619047619 nrs=0.69047619047619 sa=0 sb=0 sd=0 mult=1 m=1
XMRD_m09_w1_1 rbl_m09_w1 sn_m09_w1_1 rwl_des 0 sky130_fd_pr__nfet_01v8 L=0.15 W=0.42 nf=1 ad=0.1218 as=0.1218 pd=1.42 ps=1.42 nrd=0.69047619047619 nrs=0.69047619047619 sa=0 sb=0 sd=0 mult=1 m=1
csn_m09_w1_1 sn_m09_w1_1 0 {C_SN}
XMWR_m09_w1_2 sn_m09_w1_2 0 wbl_m09_w1 0 sky130_fd_pr__nfet_01v8 L=0.15 W=0.42 nf=1 ad=0.1218 as=0.1218 pd=1.42 ps=1.42 nrd=0.69047619047619 nrs=0.69047619047619 sa=0 sb=0 sd=0 mult=1 m=1
XMRD_m09_w1_2 rbl_m09_w1 sn_m09_w1_2 rwl_des 0 sky130_fd_pr__nfet_01v8 L=0.15 W=0.42 nf=1 ad=0.1218 as=0.1218 pd=1.42 ps=1.42 nrd=0.69047619047619 nrs=0.69047619047619 sa=0 sb=0 sd=0 mult=1 m=1
csn_m09_w1_2 sn_m09_w1_2 0 {C_SN}
XMWR_m09_w1_3 sn_m09_w1_3 0 wbl_m09_w1 0 sky130_fd_pr__nfet_01v8 L=0.15 W=0.42 nf=1 ad=0.1218 as=0.1218 pd=1.42 ps=1.42 nrd=0.69047619047619 nrs=0.69047619047619 sa=0 sb=0 sd=0 mult=1 m=1
XMRD_m09_w1_3 rbl_m09_w1 sn_m09_w1_3 rwl_des 0 sky130_fd_pr__nfet_01v8 L=0.15 W=0.42 nf=1 ad=0.1218 as=0.1218 pd=1.42 ps=1.42 nrd=0.69047619047619 nrs=0.69047619047619 sa=0 sb=0 sd=0 mult=1 m=1
csn_m09_w1_3 sn_m09_w1_3 0 {C_SN}
crbl_m09_w1 rbl_m09_w1 0 {C_RBL}
cwbl_m09_w1 wbl_m09_w1 0 {C_WBL}
cref_m09_w1 ref_m09_w1 0 {C_RBL}   $ ASSUMPTION: ideal matched dummy load
XMPPRE_m09_w1 rbl_m09_w1 pcb_100 prea prea sky130_fd_pr__pfet_01v8 L=0.15 W=4 nf=1 ad=1.16 as=1.16 pd=8.58 ps=8.58 nrd=0.0725 nrs=0.0725 sa=0 sb=0 sd=0 mult=1 m=1
XMPU1_m09_w1 x_m09_w1 dinb1 vdd vdd sky130_fd_pr__pfet_01v8 L=0.15 W=1 nf=1 ad=0.29 as=0.29 pd=2.58 ps=2.58 nrd=0.29 nrs=0.29 sa=0 sb=0 sd=0 mult=1 m=1
XMPU2_m09_w1 wbl_m09_w1 wenb x_m09_w1 vdd sky130_fd_pr__pfet_01v8 L=0.15 W=1 nf=1 ad=0.29 as=0.29 pd=2.58 ps=2.58 nrd=0.29 nrs=0.29 sa=0 sb=0 sd=0 mult=1 m=1
XMND2_m09_w1 wbl_m09_w1 wen y_m09_w1 0 sky130_fd_pr__nfet_01v8 L=0.15 W=0.5 nf=1 ad=0.145 as=0.145 pd=1.58 ps=1.58 nrd=0.58 nrs=0.58 sa=0 sb=0 sd=0 mult=1 m=1
XMND1_m09_w1 y_m09_w1 dinb1 0 0 sky130_fd_pr__nfet_01v8 L=0.15 W=0.5 nf=1 ad=0.145 as=0.145 pd=1.58 ps=1.58 nrd=0.58 nrs=0.58 sa=0 sb=0 sd=0 mult=1 m=1
XMNI_m09_w1 wbl_m09_w1 wenb 0 0 sky130_fd_pr__nfet_01v8 L=0.15 W=0.42 nf=1 ad=0.1218 as=0.1218 pd=1.42 ps=1.42 nrd=0.69047619047619 nrs=0.69047619047619 sa=0 sb=0 sd=0 mult=1 m=1
XMNS_m09_w1 sbl_m09_w1 sel_69500 rbl_m09_w1 0 sky130_fd_pr__nfet_01v8 L=0.15 W=0.42 nf=1 ad=0.1218 as=0.1218 pd=1.42 ps=1.42 nrd=0.69047619047619 nrs=0.69047619047619 sa=0 sb=0 sd=0 mult=1 m=1
XMNSR_m09_w1 sref_m09_w1 sel_69500 ref_m09_w1 0 sky130_fd_pr__nfet_01v8 L=0.15 W=0.42 nf=1 ad=0.1218 as=0.1218 pd=1.42 ps=1.42 nrd=0.69047619047619 nrs=0.69047619047619 sa=0 sb=0 sd=0 mult=1 m=1
XMPPREF_m09_w1 ref_m09_w1 pcb_100 pref pref sky130_fd_pr__pfet_01v8 L=0.15 W=4 nf=1 ad=1.16 as=1.16 pd=8.58 ps=8.58 nrd=0.0725 nrs=0.0725 sa=0 sb=0 sd=0 mult=1 m=1   $ reference-side precharge: copy of MPPRE
XMN1_m09_w1 sbl_m09_w1 sref_m09_w1 vn_m09_w1 0 sky130_fd_pr__nfet_01v8 L=0.15 W=1 nf=1 ad=0.29 as=0.29 pd=2.58 ps=2.58 nrd=0.29 nrs=0.29 sa=0 sb=0 sd=0 mult=1 m=1
XMN2_m09_w1 sref_m09_w1 sbl_m09_w1 vn_m09_w1 0 sky130_fd_pr__nfet_01v8 L=0.15 W=1 nf=1 ad=0.29 as=0.29 pd=2.58 ps=2.58 nrd=0.29 nrs=0.29 sa=0 sb=0 sd=0 mult=1 m=1
XMP1_m09_w1 sbl_m09_w1 sref_m09_w1 vp_m09_w1 vdd sky130_fd_pr__pfet_01v8 L=0.15 W=2 nf=1 ad=0.58 as=0.58 pd=4.58 ps=4.58 nrd=0.145 nrs=0.145 sa=0 sb=0 sd=0 mult=1 m=1
XMP2_m09_w1 sref_m09_w1 sbl_m09_w1 vp_m09_w1 vdd sky130_fd_pr__pfet_01v8 L=0.15 W=2 nf=1 ad=0.58 as=0.58 pd=4.58 ps=4.58 nrd=0.145 nrs=0.145 sa=0 sb=0 sd=0 mult=1 m=1
XMNF_m09_w1 vn_m09_w1 en 0 0 sky130_fd_pr__nfet_01v8 L=0.15 W=2 nf=1 ad=0.58 as=0.58 pd=4.58 ps=4.58 nrd=0.145 nrs=0.145 sa=0 sb=0 sd=0 mult=1 m=1
XMPH_m09_w1 vp_m09_w1 enb vdd vdd sky130_fd_pr__pfet_01v8 L=0.15 W=4 nf=1 ad=1.16 as=1.16 pd=8.58 ps=8.58 nrd=0.0725 nrs=0.0725 sa=0 sb=0 sd=0 mult=1 m=1
bd_m09_w1 d_m09_w1 0 v=v(sbl_m09_w1)-v(sref_m09_w1)
bdabs_m09_w1 dabs_m09_w1 0 v=abs(v(sbl_m09_w1)-v(sref_m09_w1))

* ---- instance 53: m09_w0 (nfet only 0.42 [matched ref precharge]) ----
XMWR_m09_w0_0 sn_m09_w0_0 wl wbl_m09_w0 0 sky130_fd_pr__nfet_01v8 L=0.15 W=0.42 nf=1 ad=0.1218 as=0.1218 pd=1.42 ps=1.42 nrd=0.69047619047619 nrs=0.69047619047619 sa=0 sb=0 sd=0 mult=1 m=1
XMRD_m09_w0_0 rbl_m09_w0 sn_m09_w0_0 rwl_sel 0 sky130_fd_pr__nfet_01v8 L=0.15 W=0.42 nf=1 ad=0.1218 as=0.1218 pd=1.42 ps=1.42 nrd=0.69047619047619 nrs=0.69047619047619 sa=0 sb=0 sd=0 mult=1 m=1
csn_m09_w0_0 sn_m09_w0_0 0 {C_SN}
XMWR_m09_w0_1 sn_m09_w0_1 0 wbl_m09_w0 0 sky130_fd_pr__nfet_01v8 L=0.15 W=0.42 nf=1 ad=0.1218 as=0.1218 pd=1.42 ps=1.42 nrd=0.69047619047619 nrs=0.69047619047619 sa=0 sb=0 sd=0 mult=1 m=1
XMRD_m09_w0_1 rbl_m09_w0 sn_m09_w0_1 rwl_des 0 sky130_fd_pr__nfet_01v8 L=0.15 W=0.42 nf=1 ad=0.1218 as=0.1218 pd=1.42 ps=1.42 nrd=0.69047619047619 nrs=0.69047619047619 sa=0 sb=0 sd=0 mult=1 m=1
csn_m09_w0_1 sn_m09_w0_1 0 {C_SN}
XMWR_m09_w0_2 sn_m09_w0_2 0 wbl_m09_w0 0 sky130_fd_pr__nfet_01v8 L=0.15 W=0.42 nf=1 ad=0.1218 as=0.1218 pd=1.42 ps=1.42 nrd=0.69047619047619 nrs=0.69047619047619 sa=0 sb=0 sd=0 mult=1 m=1
XMRD_m09_w0_2 rbl_m09_w0 sn_m09_w0_2 rwl_des 0 sky130_fd_pr__nfet_01v8 L=0.15 W=0.42 nf=1 ad=0.1218 as=0.1218 pd=1.42 ps=1.42 nrd=0.69047619047619 nrs=0.69047619047619 sa=0 sb=0 sd=0 mult=1 m=1
csn_m09_w0_2 sn_m09_w0_2 0 {C_SN}
XMWR_m09_w0_3 sn_m09_w0_3 0 wbl_m09_w0 0 sky130_fd_pr__nfet_01v8 L=0.15 W=0.42 nf=1 ad=0.1218 as=0.1218 pd=1.42 ps=1.42 nrd=0.69047619047619 nrs=0.69047619047619 sa=0 sb=0 sd=0 mult=1 m=1
XMRD_m09_w0_3 rbl_m09_w0 sn_m09_w0_3 rwl_des 0 sky130_fd_pr__nfet_01v8 L=0.15 W=0.42 nf=1 ad=0.1218 as=0.1218 pd=1.42 ps=1.42 nrd=0.69047619047619 nrs=0.69047619047619 sa=0 sb=0 sd=0 mult=1 m=1
csn_m09_w0_3 sn_m09_w0_3 0 {C_SN}
crbl_m09_w0 rbl_m09_w0 0 {C_RBL}
cwbl_m09_w0 wbl_m09_w0 0 {C_WBL}
cref_m09_w0 ref_m09_w0 0 {C_RBL}   $ ASSUMPTION: ideal matched dummy load
XMPPRE_m09_w0 rbl_m09_w0 pcb_100 prea prea sky130_fd_pr__pfet_01v8 L=0.15 W=4 nf=1 ad=1.16 as=1.16 pd=8.58 ps=8.58 nrd=0.0725 nrs=0.0725 sa=0 sb=0 sd=0 mult=1 m=1
XMPU1_m09_w0 x_m09_w0 dinb0 vdd vdd sky130_fd_pr__pfet_01v8 L=0.15 W=1 nf=1 ad=0.29 as=0.29 pd=2.58 ps=2.58 nrd=0.29 nrs=0.29 sa=0 sb=0 sd=0 mult=1 m=1
XMPU2_m09_w0 wbl_m09_w0 wenb x_m09_w0 vdd sky130_fd_pr__pfet_01v8 L=0.15 W=1 nf=1 ad=0.29 as=0.29 pd=2.58 ps=2.58 nrd=0.29 nrs=0.29 sa=0 sb=0 sd=0 mult=1 m=1
XMND2_m09_w0 wbl_m09_w0 wen y_m09_w0 0 sky130_fd_pr__nfet_01v8 L=0.15 W=0.5 nf=1 ad=0.145 as=0.145 pd=1.58 ps=1.58 nrd=0.58 nrs=0.58 sa=0 sb=0 sd=0 mult=1 m=1
XMND1_m09_w0 y_m09_w0 dinb0 0 0 sky130_fd_pr__nfet_01v8 L=0.15 W=0.5 nf=1 ad=0.145 as=0.145 pd=1.58 ps=1.58 nrd=0.58 nrs=0.58 sa=0 sb=0 sd=0 mult=1 m=1
XMNI_m09_w0 wbl_m09_w0 wenb 0 0 sky130_fd_pr__nfet_01v8 L=0.15 W=0.42 nf=1 ad=0.1218 as=0.1218 pd=1.42 ps=1.42 nrd=0.69047619047619 nrs=0.69047619047619 sa=0 sb=0 sd=0 mult=1 m=1
XMNS_m09_w0 sbl_m09_w0 sel_69500 rbl_m09_w0 0 sky130_fd_pr__nfet_01v8 L=0.15 W=0.42 nf=1 ad=0.1218 as=0.1218 pd=1.42 ps=1.42 nrd=0.69047619047619 nrs=0.69047619047619 sa=0 sb=0 sd=0 mult=1 m=1
XMNSR_m09_w0 sref_m09_w0 sel_69500 ref_m09_w0 0 sky130_fd_pr__nfet_01v8 L=0.15 W=0.42 nf=1 ad=0.1218 as=0.1218 pd=1.42 ps=1.42 nrd=0.69047619047619 nrs=0.69047619047619 sa=0 sb=0 sd=0 mult=1 m=1
XMPPREF_m09_w0 ref_m09_w0 pcb_100 pref pref sky130_fd_pr__pfet_01v8 L=0.15 W=4 nf=1 ad=1.16 as=1.16 pd=8.58 ps=8.58 nrd=0.0725 nrs=0.0725 sa=0 sb=0 sd=0 mult=1 m=1   $ reference-side precharge: copy of MPPRE
XMN1_m09_w0 sbl_m09_w0 sref_m09_w0 vn_m09_w0 0 sky130_fd_pr__nfet_01v8 L=0.15 W=1 nf=1 ad=0.29 as=0.29 pd=2.58 ps=2.58 nrd=0.29 nrs=0.29 sa=0 sb=0 sd=0 mult=1 m=1
XMN2_m09_w0 sref_m09_w0 sbl_m09_w0 vn_m09_w0 0 sky130_fd_pr__nfet_01v8 L=0.15 W=1 nf=1 ad=0.29 as=0.29 pd=2.58 ps=2.58 nrd=0.29 nrs=0.29 sa=0 sb=0 sd=0 mult=1 m=1
XMP1_m09_w0 sbl_m09_w0 sref_m09_w0 vp_m09_w0 vdd sky130_fd_pr__pfet_01v8 L=0.15 W=2 nf=1 ad=0.58 as=0.58 pd=4.58 ps=4.58 nrd=0.145 nrs=0.145 sa=0 sb=0 sd=0 mult=1 m=1
XMP2_m09_w0 sref_m09_w0 sbl_m09_w0 vp_m09_w0 vdd sky130_fd_pr__pfet_01v8 L=0.15 W=2 nf=1 ad=0.58 as=0.58 pd=4.58 ps=4.58 nrd=0.145 nrs=0.145 sa=0 sb=0 sd=0 mult=1 m=1
XMNF_m09_w0 vn_m09_w0 en 0 0 sky130_fd_pr__nfet_01v8 L=0.15 W=2 nf=1 ad=0.58 as=0.58 pd=4.58 ps=4.58 nrd=0.145 nrs=0.145 sa=0 sb=0 sd=0 mult=1 m=1
XMPH_m09_w0 vp_m09_w0 enb vdd vdd sky130_fd_pr__pfet_01v8 L=0.15 W=4 nf=1 ad=1.16 as=1.16 pd=8.58 ps=8.58 nrd=0.0725 nrs=0.0725 sa=0 sb=0 sd=0 mult=1 m=1
bd_m09_w0 d_m09_w0 0 v=v(sbl_m09_w0)-v(sref_m09_w0)
bdabs_m09_w0 dabs_m09_w0 0 v=abs(v(sbl_m09_w0)-v(sref_m09_w0))

* ---- instance 54: m10_w1 (pfet only 1.0 [matched ref precharge]) ----
XMWR_m10_w1_0 sn_m10_w1_0 wl wbl_m10_w1 0 sky130_fd_pr__nfet_01v8 L=0.15 W=0.42 nf=1 ad=0.1218 as=0.1218 pd=1.42 ps=1.42 nrd=0.69047619047619 nrs=0.69047619047619 sa=0 sb=0 sd=0 mult=1 m=1
XMRD_m10_w1_0 rbl_m10_w1 sn_m10_w1_0 rwl_sel 0 sky130_fd_pr__nfet_01v8 L=0.15 W=0.42 nf=1 ad=0.1218 as=0.1218 pd=1.42 ps=1.42 nrd=0.69047619047619 nrs=0.69047619047619 sa=0 sb=0 sd=0 mult=1 m=1
csn_m10_w1_0 sn_m10_w1_0 0 {C_SN}
XMWR_m10_w1_1 sn_m10_w1_1 0 wbl_m10_w1 0 sky130_fd_pr__nfet_01v8 L=0.15 W=0.42 nf=1 ad=0.1218 as=0.1218 pd=1.42 ps=1.42 nrd=0.69047619047619 nrs=0.69047619047619 sa=0 sb=0 sd=0 mult=1 m=1
XMRD_m10_w1_1 rbl_m10_w1 sn_m10_w1_1 rwl_des 0 sky130_fd_pr__nfet_01v8 L=0.15 W=0.42 nf=1 ad=0.1218 as=0.1218 pd=1.42 ps=1.42 nrd=0.69047619047619 nrs=0.69047619047619 sa=0 sb=0 sd=0 mult=1 m=1
csn_m10_w1_1 sn_m10_w1_1 0 {C_SN}
XMWR_m10_w1_2 sn_m10_w1_2 0 wbl_m10_w1 0 sky130_fd_pr__nfet_01v8 L=0.15 W=0.42 nf=1 ad=0.1218 as=0.1218 pd=1.42 ps=1.42 nrd=0.69047619047619 nrs=0.69047619047619 sa=0 sb=0 sd=0 mult=1 m=1
XMRD_m10_w1_2 rbl_m10_w1 sn_m10_w1_2 rwl_des 0 sky130_fd_pr__nfet_01v8 L=0.15 W=0.42 nf=1 ad=0.1218 as=0.1218 pd=1.42 ps=1.42 nrd=0.69047619047619 nrs=0.69047619047619 sa=0 sb=0 sd=0 mult=1 m=1
csn_m10_w1_2 sn_m10_w1_2 0 {C_SN}
XMWR_m10_w1_3 sn_m10_w1_3 0 wbl_m10_w1 0 sky130_fd_pr__nfet_01v8 L=0.15 W=0.42 nf=1 ad=0.1218 as=0.1218 pd=1.42 ps=1.42 nrd=0.69047619047619 nrs=0.69047619047619 sa=0 sb=0 sd=0 mult=1 m=1
XMRD_m10_w1_3 rbl_m10_w1 sn_m10_w1_3 rwl_des 0 sky130_fd_pr__nfet_01v8 L=0.15 W=0.42 nf=1 ad=0.1218 as=0.1218 pd=1.42 ps=1.42 nrd=0.69047619047619 nrs=0.69047619047619 sa=0 sb=0 sd=0 mult=1 m=1
csn_m10_w1_3 sn_m10_w1_3 0 {C_SN}
crbl_m10_w1 rbl_m10_w1 0 {C_RBL}
cwbl_m10_w1 wbl_m10_w1 0 {C_WBL}
cref_m10_w1 ref_m10_w1 0 {C_RBL}   $ ASSUMPTION: ideal matched dummy load
XMPPRE_m10_w1 rbl_m10_w1 pcb_100 prea prea sky130_fd_pr__pfet_01v8 L=0.15 W=4 nf=1 ad=1.16 as=1.16 pd=8.58 ps=8.58 nrd=0.0725 nrs=0.0725 sa=0 sb=0 sd=0 mult=1 m=1
XMPU1_m10_w1 x_m10_w1 dinb1 vdd vdd sky130_fd_pr__pfet_01v8 L=0.15 W=1 nf=1 ad=0.29 as=0.29 pd=2.58 ps=2.58 nrd=0.29 nrs=0.29 sa=0 sb=0 sd=0 mult=1 m=1
XMPU2_m10_w1 wbl_m10_w1 wenb x_m10_w1 vdd sky130_fd_pr__pfet_01v8 L=0.15 W=1 nf=1 ad=0.29 as=0.29 pd=2.58 ps=2.58 nrd=0.29 nrs=0.29 sa=0 sb=0 sd=0 mult=1 m=1
XMND2_m10_w1 wbl_m10_w1 wen y_m10_w1 0 sky130_fd_pr__nfet_01v8 L=0.15 W=0.5 nf=1 ad=0.145 as=0.145 pd=1.58 ps=1.58 nrd=0.58 nrs=0.58 sa=0 sb=0 sd=0 mult=1 m=1
XMND1_m10_w1 y_m10_w1 dinb1 0 0 sky130_fd_pr__nfet_01v8 L=0.15 W=0.5 nf=1 ad=0.145 as=0.145 pd=1.58 ps=1.58 nrd=0.58 nrs=0.58 sa=0 sb=0 sd=0 mult=1 m=1
XMNI_m10_w1 wbl_m10_w1 wenb 0 0 sky130_fd_pr__nfet_01v8 L=0.15 W=0.42 nf=1 ad=0.1218 as=0.1218 pd=1.42 ps=1.42 nrd=0.69047619047619 nrs=0.69047619047619 sa=0 sb=0 sd=0 mult=1 m=1
XMPS_m10_w1 sbl_m10_w1 selb_69500 rbl_m10_w1 vdd sky130_fd_pr__pfet_01v8 L=0.15 W=1 nf=1 ad=0.29 as=0.29 pd=2.58 ps=2.58 nrd=0.29 nrs=0.29 sa=0 sb=0 sd=0 mult=1 m=1
XMPSR_m10_w1 sref_m10_w1 selb_69500 ref_m10_w1 vdd sky130_fd_pr__pfet_01v8 L=0.15 W=1 nf=1 ad=0.29 as=0.29 pd=2.58 ps=2.58 nrd=0.29 nrs=0.29 sa=0 sb=0 sd=0 mult=1 m=1
XMPPREF_m10_w1 ref_m10_w1 pcb_100 pref pref sky130_fd_pr__pfet_01v8 L=0.15 W=4 nf=1 ad=1.16 as=1.16 pd=8.58 ps=8.58 nrd=0.0725 nrs=0.0725 sa=0 sb=0 sd=0 mult=1 m=1   $ reference-side precharge: copy of MPPRE
XMN1_m10_w1 sbl_m10_w1 sref_m10_w1 vn_m10_w1 0 sky130_fd_pr__nfet_01v8 L=0.15 W=1 nf=1 ad=0.29 as=0.29 pd=2.58 ps=2.58 nrd=0.29 nrs=0.29 sa=0 sb=0 sd=0 mult=1 m=1
XMN2_m10_w1 sref_m10_w1 sbl_m10_w1 vn_m10_w1 0 sky130_fd_pr__nfet_01v8 L=0.15 W=1 nf=1 ad=0.29 as=0.29 pd=2.58 ps=2.58 nrd=0.29 nrs=0.29 sa=0 sb=0 sd=0 mult=1 m=1
XMP1_m10_w1 sbl_m10_w1 sref_m10_w1 vp_m10_w1 vdd sky130_fd_pr__pfet_01v8 L=0.15 W=2 nf=1 ad=0.58 as=0.58 pd=4.58 ps=4.58 nrd=0.145 nrs=0.145 sa=0 sb=0 sd=0 mult=1 m=1
XMP2_m10_w1 sref_m10_w1 sbl_m10_w1 vp_m10_w1 vdd sky130_fd_pr__pfet_01v8 L=0.15 W=2 nf=1 ad=0.58 as=0.58 pd=4.58 ps=4.58 nrd=0.145 nrs=0.145 sa=0 sb=0 sd=0 mult=1 m=1
XMNF_m10_w1 vn_m10_w1 en 0 0 sky130_fd_pr__nfet_01v8 L=0.15 W=2 nf=1 ad=0.58 as=0.58 pd=4.58 ps=4.58 nrd=0.145 nrs=0.145 sa=0 sb=0 sd=0 mult=1 m=1
XMPH_m10_w1 vp_m10_w1 enb vdd vdd sky130_fd_pr__pfet_01v8 L=0.15 W=4 nf=1 ad=1.16 as=1.16 pd=8.58 ps=8.58 nrd=0.0725 nrs=0.0725 sa=0 sb=0 sd=0 mult=1 m=1
bd_m10_w1 d_m10_w1 0 v=v(sbl_m10_w1)-v(sref_m10_w1)
bdabs_m10_w1 dabs_m10_w1 0 v=abs(v(sbl_m10_w1)-v(sref_m10_w1))

* ---- instance 55: m10_w0 (pfet only 1.0 [matched ref precharge]) ----
XMWR_m10_w0_0 sn_m10_w0_0 wl wbl_m10_w0 0 sky130_fd_pr__nfet_01v8 L=0.15 W=0.42 nf=1 ad=0.1218 as=0.1218 pd=1.42 ps=1.42 nrd=0.69047619047619 nrs=0.69047619047619 sa=0 sb=0 sd=0 mult=1 m=1
XMRD_m10_w0_0 rbl_m10_w0 sn_m10_w0_0 rwl_sel 0 sky130_fd_pr__nfet_01v8 L=0.15 W=0.42 nf=1 ad=0.1218 as=0.1218 pd=1.42 ps=1.42 nrd=0.69047619047619 nrs=0.69047619047619 sa=0 sb=0 sd=0 mult=1 m=1
csn_m10_w0_0 sn_m10_w0_0 0 {C_SN}
XMWR_m10_w0_1 sn_m10_w0_1 0 wbl_m10_w0 0 sky130_fd_pr__nfet_01v8 L=0.15 W=0.42 nf=1 ad=0.1218 as=0.1218 pd=1.42 ps=1.42 nrd=0.69047619047619 nrs=0.69047619047619 sa=0 sb=0 sd=0 mult=1 m=1
XMRD_m10_w0_1 rbl_m10_w0 sn_m10_w0_1 rwl_des 0 sky130_fd_pr__nfet_01v8 L=0.15 W=0.42 nf=1 ad=0.1218 as=0.1218 pd=1.42 ps=1.42 nrd=0.69047619047619 nrs=0.69047619047619 sa=0 sb=0 sd=0 mult=1 m=1
csn_m10_w0_1 sn_m10_w0_1 0 {C_SN}
XMWR_m10_w0_2 sn_m10_w0_2 0 wbl_m10_w0 0 sky130_fd_pr__nfet_01v8 L=0.15 W=0.42 nf=1 ad=0.1218 as=0.1218 pd=1.42 ps=1.42 nrd=0.69047619047619 nrs=0.69047619047619 sa=0 sb=0 sd=0 mult=1 m=1
XMRD_m10_w0_2 rbl_m10_w0 sn_m10_w0_2 rwl_des 0 sky130_fd_pr__nfet_01v8 L=0.15 W=0.42 nf=1 ad=0.1218 as=0.1218 pd=1.42 ps=1.42 nrd=0.69047619047619 nrs=0.69047619047619 sa=0 sb=0 sd=0 mult=1 m=1
csn_m10_w0_2 sn_m10_w0_2 0 {C_SN}
XMWR_m10_w0_3 sn_m10_w0_3 0 wbl_m10_w0 0 sky130_fd_pr__nfet_01v8 L=0.15 W=0.42 nf=1 ad=0.1218 as=0.1218 pd=1.42 ps=1.42 nrd=0.69047619047619 nrs=0.69047619047619 sa=0 sb=0 sd=0 mult=1 m=1
XMRD_m10_w0_3 rbl_m10_w0 sn_m10_w0_3 rwl_des 0 sky130_fd_pr__nfet_01v8 L=0.15 W=0.42 nf=1 ad=0.1218 as=0.1218 pd=1.42 ps=1.42 nrd=0.69047619047619 nrs=0.69047619047619 sa=0 sb=0 sd=0 mult=1 m=1
csn_m10_w0_3 sn_m10_w0_3 0 {C_SN}
crbl_m10_w0 rbl_m10_w0 0 {C_RBL}
cwbl_m10_w0 wbl_m10_w0 0 {C_WBL}
cref_m10_w0 ref_m10_w0 0 {C_RBL}   $ ASSUMPTION: ideal matched dummy load
XMPPRE_m10_w0 rbl_m10_w0 pcb_100 prea prea sky130_fd_pr__pfet_01v8 L=0.15 W=4 nf=1 ad=1.16 as=1.16 pd=8.58 ps=8.58 nrd=0.0725 nrs=0.0725 sa=0 sb=0 sd=0 mult=1 m=1
XMPU1_m10_w0 x_m10_w0 dinb0 vdd vdd sky130_fd_pr__pfet_01v8 L=0.15 W=1 nf=1 ad=0.29 as=0.29 pd=2.58 ps=2.58 nrd=0.29 nrs=0.29 sa=0 sb=0 sd=0 mult=1 m=1
XMPU2_m10_w0 wbl_m10_w0 wenb x_m10_w0 vdd sky130_fd_pr__pfet_01v8 L=0.15 W=1 nf=1 ad=0.29 as=0.29 pd=2.58 ps=2.58 nrd=0.29 nrs=0.29 sa=0 sb=0 sd=0 mult=1 m=1
XMND2_m10_w0 wbl_m10_w0 wen y_m10_w0 0 sky130_fd_pr__nfet_01v8 L=0.15 W=0.5 nf=1 ad=0.145 as=0.145 pd=1.58 ps=1.58 nrd=0.58 nrs=0.58 sa=0 sb=0 sd=0 mult=1 m=1
XMND1_m10_w0 y_m10_w0 dinb0 0 0 sky130_fd_pr__nfet_01v8 L=0.15 W=0.5 nf=1 ad=0.145 as=0.145 pd=1.58 ps=1.58 nrd=0.58 nrs=0.58 sa=0 sb=0 sd=0 mult=1 m=1
XMNI_m10_w0 wbl_m10_w0 wenb 0 0 sky130_fd_pr__nfet_01v8 L=0.15 W=0.42 nf=1 ad=0.1218 as=0.1218 pd=1.42 ps=1.42 nrd=0.69047619047619 nrs=0.69047619047619 sa=0 sb=0 sd=0 mult=1 m=1
XMPS_m10_w0 sbl_m10_w0 selb_69500 rbl_m10_w0 vdd sky130_fd_pr__pfet_01v8 L=0.15 W=1 nf=1 ad=0.29 as=0.29 pd=2.58 ps=2.58 nrd=0.29 nrs=0.29 sa=0 sb=0 sd=0 mult=1 m=1
XMPSR_m10_w0 sref_m10_w0 selb_69500 ref_m10_w0 vdd sky130_fd_pr__pfet_01v8 L=0.15 W=1 nf=1 ad=0.29 as=0.29 pd=2.58 ps=2.58 nrd=0.29 nrs=0.29 sa=0 sb=0 sd=0 mult=1 m=1
XMPPREF_m10_w0 ref_m10_w0 pcb_100 pref pref sky130_fd_pr__pfet_01v8 L=0.15 W=4 nf=1 ad=1.16 as=1.16 pd=8.58 ps=8.58 nrd=0.0725 nrs=0.0725 sa=0 sb=0 sd=0 mult=1 m=1   $ reference-side precharge: copy of MPPRE
XMN1_m10_w0 sbl_m10_w0 sref_m10_w0 vn_m10_w0 0 sky130_fd_pr__nfet_01v8 L=0.15 W=1 nf=1 ad=0.29 as=0.29 pd=2.58 ps=2.58 nrd=0.29 nrs=0.29 sa=0 sb=0 sd=0 mult=1 m=1
XMN2_m10_w0 sref_m10_w0 sbl_m10_w0 vn_m10_w0 0 sky130_fd_pr__nfet_01v8 L=0.15 W=1 nf=1 ad=0.29 as=0.29 pd=2.58 ps=2.58 nrd=0.29 nrs=0.29 sa=0 sb=0 sd=0 mult=1 m=1
XMP1_m10_w0 sbl_m10_w0 sref_m10_w0 vp_m10_w0 vdd sky130_fd_pr__pfet_01v8 L=0.15 W=2 nf=1 ad=0.58 as=0.58 pd=4.58 ps=4.58 nrd=0.145 nrs=0.145 sa=0 sb=0 sd=0 mult=1 m=1
XMP2_m10_w0 sref_m10_w0 sbl_m10_w0 vp_m10_w0 vdd sky130_fd_pr__pfet_01v8 L=0.15 W=2 nf=1 ad=0.58 as=0.58 pd=4.58 ps=4.58 nrd=0.145 nrs=0.145 sa=0 sb=0 sd=0 mult=1 m=1
XMNF_m10_w0 vn_m10_w0 en 0 0 sky130_fd_pr__nfet_01v8 L=0.15 W=2 nf=1 ad=0.58 as=0.58 pd=4.58 ps=4.58 nrd=0.145 nrs=0.145 sa=0 sb=0 sd=0 mult=1 m=1
XMPH_m10_w0 vp_m10_w0 enb vdd vdd sky130_fd_pr__pfet_01v8 L=0.15 W=4 nf=1 ad=1.16 as=1.16 pd=8.58 ps=8.58 nrd=0.0725 nrs=0.0725 sa=0 sb=0 sd=0 mult=1 m=1
bd_m10_w0 d_m10_w0 0 v=v(sbl_m10_w0)-v(sref_m10_w0)
bdabs_m10_w0 dabs_m10_w0 0 v=abs(v(sbl_m10_w0)-v(sref_m10_w0))

* ---- instance 56: m11_w1 (pfet only 0.5 [matched ref precharge]) ----
XMWR_m11_w1_0 sn_m11_w1_0 wl wbl_m11_w1 0 sky130_fd_pr__nfet_01v8 L=0.15 W=0.42 nf=1 ad=0.1218 as=0.1218 pd=1.42 ps=1.42 nrd=0.69047619047619 nrs=0.69047619047619 sa=0 sb=0 sd=0 mult=1 m=1
XMRD_m11_w1_0 rbl_m11_w1 sn_m11_w1_0 rwl_sel 0 sky130_fd_pr__nfet_01v8 L=0.15 W=0.42 nf=1 ad=0.1218 as=0.1218 pd=1.42 ps=1.42 nrd=0.69047619047619 nrs=0.69047619047619 sa=0 sb=0 sd=0 mult=1 m=1
csn_m11_w1_0 sn_m11_w1_0 0 {C_SN}
XMWR_m11_w1_1 sn_m11_w1_1 0 wbl_m11_w1 0 sky130_fd_pr__nfet_01v8 L=0.15 W=0.42 nf=1 ad=0.1218 as=0.1218 pd=1.42 ps=1.42 nrd=0.69047619047619 nrs=0.69047619047619 sa=0 sb=0 sd=0 mult=1 m=1
XMRD_m11_w1_1 rbl_m11_w1 sn_m11_w1_1 rwl_des 0 sky130_fd_pr__nfet_01v8 L=0.15 W=0.42 nf=1 ad=0.1218 as=0.1218 pd=1.42 ps=1.42 nrd=0.69047619047619 nrs=0.69047619047619 sa=0 sb=0 sd=0 mult=1 m=1
csn_m11_w1_1 sn_m11_w1_1 0 {C_SN}
XMWR_m11_w1_2 sn_m11_w1_2 0 wbl_m11_w1 0 sky130_fd_pr__nfet_01v8 L=0.15 W=0.42 nf=1 ad=0.1218 as=0.1218 pd=1.42 ps=1.42 nrd=0.69047619047619 nrs=0.69047619047619 sa=0 sb=0 sd=0 mult=1 m=1
XMRD_m11_w1_2 rbl_m11_w1 sn_m11_w1_2 rwl_des 0 sky130_fd_pr__nfet_01v8 L=0.15 W=0.42 nf=1 ad=0.1218 as=0.1218 pd=1.42 ps=1.42 nrd=0.69047619047619 nrs=0.69047619047619 sa=0 sb=0 sd=0 mult=1 m=1
csn_m11_w1_2 sn_m11_w1_2 0 {C_SN}
XMWR_m11_w1_3 sn_m11_w1_3 0 wbl_m11_w1 0 sky130_fd_pr__nfet_01v8 L=0.15 W=0.42 nf=1 ad=0.1218 as=0.1218 pd=1.42 ps=1.42 nrd=0.69047619047619 nrs=0.69047619047619 sa=0 sb=0 sd=0 mult=1 m=1
XMRD_m11_w1_3 rbl_m11_w1 sn_m11_w1_3 rwl_des 0 sky130_fd_pr__nfet_01v8 L=0.15 W=0.42 nf=1 ad=0.1218 as=0.1218 pd=1.42 ps=1.42 nrd=0.69047619047619 nrs=0.69047619047619 sa=0 sb=0 sd=0 mult=1 m=1
csn_m11_w1_3 sn_m11_w1_3 0 {C_SN}
crbl_m11_w1 rbl_m11_w1 0 {C_RBL}
cwbl_m11_w1 wbl_m11_w1 0 {C_WBL}
cref_m11_w1 ref_m11_w1 0 {C_RBL}   $ ASSUMPTION: ideal matched dummy load
XMPPRE_m11_w1 rbl_m11_w1 pcb_100 prea prea sky130_fd_pr__pfet_01v8 L=0.15 W=4 nf=1 ad=1.16 as=1.16 pd=8.58 ps=8.58 nrd=0.0725 nrs=0.0725 sa=0 sb=0 sd=0 mult=1 m=1
XMPU1_m11_w1 x_m11_w1 dinb1 vdd vdd sky130_fd_pr__pfet_01v8 L=0.15 W=1 nf=1 ad=0.29 as=0.29 pd=2.58 ps=2.58 nrd=0.29 nrs=0.29 sa=0 sb=0 sd=0 mult=1 m=1
XMPU2_m11_w1 wbl_m11_w1 wenb x_m11_w1 vdd sky130_fd_pr__pfet_01v8 L=0.15 W=1 nf=1 ad=0.29 as=0.29 pd=2.58 ps=2.58 nrd=0.29 nrs=0.29 sa=0 sb=0 sd=0 mult=1 m=1
XMND2_m11_w1 wbl_m11_w1 wen y_m11_w1 0 sky130_fd_pr__nfet_01v8 L=0.15 W=0.5 nf=1 ad=0.145 as=0.145 pd=1.58 ps=1.58 nrd=0.58 nrs=0.58 sa=0 sb=0 sd=0 mult=1 m=1
XMND1_m11_w1 y_m11_w1 dinb1 0 0 sky130_fd_pr__nfet_01v8 L=0.15 W=0.5 nf=1 ad=0.145 as=0.145 pd=1.58 ps=1.58 nrd=0.58 nrs=0.58 sa=0 sb=0 sd=0 mult=1 m=1
XMNI_m11_w1 wbl_m11_w1 wenb 0 0 sky130_fd_pr__nfet_01v8 L=0.15 W=0.42 nf=1 ad=0.1218 as=0.1218 pd=1.42 ps=1.42 nrd=0.69047619047619 nrs=0.69047619047619 sa=0 sb=0 sd=0 mult=1 m=1
XMPS_m11_w1 sbl_m11_w1 selb_69500 rbl_m11_w1 vdd sky130_fd_pr__pfet_01v8 L=0.15 W=0.5 nf=1 ad=0.145 as=0.145 pd=1.58 ps=1.58 nrd=0.58 nrs=0.58 sa=0 sb=0 sd=0 mult=1 m=1
XMPSR_m11_w1 sref_m11_w1 selb_69500 ref_m11_w1 vdd sky130_fd_pr__pfet_01v8 L=0.15 W=0.5 nf=1 ad=0.145 as=0.145 pd=1.58 ps=1.58 nrd=0.58 nrs=0.58 sa=0 sb=0 sd=0 mult=1 m=1
XMPPREF_m11_w1 ref_m11_w1 pcb_100 pref pref sky130_fd_pr__pfet_01v8 L=0.15 W=4 nf=1 ad=1.16 as=1.16 pd=8.58 ps=8.58 nrd=0.0725 nrs=0.0725 sa=0 sb=0 sd=0 mult=1 m=1   $ reference-side precharge: copy of MPPRE
XMN1_m11_w1 sbl_m11_w1 sref_m11_w1 vn_m11_w1 0 sky130_fd_pr__nfet_01v8 L=0.15 W=1 nf=1 ad=0.29 as=0.29 pd=2.58 ps=2.58 nrd=0.29 nrs=0.29 sa=0 sb=0 sd=0 mult=1 m=1
XMN2_m11_w1 sref_m11_w1 sbl_m11_w1 vn_m11_w1 0 sky130_fd_pr__nfet_01v8 L=0.15 W=1 nf=1 ad=0.29 as=0.29 pd=2.58 ps=2.58 nrd=0.29 nrs=0.29 sa=0 sb=0 sd=0 mult=1 m=1
XMP1_m11_w1 sbl_m11_w1 sref_m11_w1 vp_m11_w1 vdd sky130_fd_pr__pfet_01v8 L=0.15 W=2 nf=1 ad=0.58 as=0.58 pd=4.58 ps=4.58 nrd=0.145 nrs=0.145 sa=0 sb=0 sd=0 mult=1 m=1
XMP2_m11_w1 sref_m11_w1 sbl_m11_w1 vp_m11_w1 vdd sky130_fd_pr__pfet_01v8 L=0.15 W=2 nf=1 ad=0.58 as=0.58 pd=4.58 ps=4.58 nrd=0.145 nrs=0.145 sa=0 sb=0 sd=0 mult=1 m=1
XMNF_m11_w1 vn_m11_w1 en 0 0 sky130_fd_pr__nfet_01v8 L=0.15 W=2 nf=1 ad=0.58 as=0.58 pd=4.58 ps=4.58 nrd=0.145 nrs=0.145 sa=0 sb=0 sd=0 mult=1 m=1
XMPH_m11_w1 vp_m11_w1 enb vdd vdd sky130_fd_pr__pfet_01v8 L=0.15 W=4 nf=1 ad=1.16 as=1.16 pd=8.58 ps=8.58 nrd=0.0725 nrs=0.0725 sa=0 sb=0 sd=0 mult=1 m=1
bd_m11_w1 d_m11_w1 0 v=v(sbl_m11_w1)-v(sref_m11_w1)
bdabs_m11_w1 dabs_m11_w1 0 v=abs(v(sbl_m11_w1)-v(sref_m11_w1))

* ---- instance 57: m11_w0 (pfet only 0.5 [matched ref precharge]) ----
XMWR_m11_w0_0 sn_m11_w0_0 wl wbl_m11_w0 0 sky130_fd_pr__nfet_01v8 L=0.15 W=0.42 nf=1 ad=0.1218 as=0.1218 pd=1.42 ps=1.42 nrd=0.69047619047619 nrs=0.69047619047619 sa=0 sb=0 sd=0 mult=1 m=1
XMRD_m11_w0_0 rbl_m11_w0 sn_m11_w0_0 rwl_sel 0 sky130_fd_pr__nfet_01v8 L=0.15 W=0.42 nf=1 ad=0.1218 as=0.1218 pd=1.42 ps=1.42 nrd=0.69047619047619 nrs=0.69047619047619 sa=0 sb=0 sd=0 mult=1 m=1
csn_m11_w0_0 sn_m11_w0_0 0 {C_SN}
XMWR_m11_w0_1 sn_m11_w0_1 0 wbl_m11_w0 0 sky130_fd_pr__nfet_01v8 L=0.15 W=0.42 nf=1 ad=0.1218 as=0.1218 pd=1.42 ps=1.42 nrd=0.69047619047619 nrs=0.69047619047619 sa=0 sb=0 sd=0 mult=1 m=1
XMRD_m11_w0_1 rbl_m11_w0 sn_m11_w0_1 rwl_des 0 sky130_fd_pr__nfet_01v8 L=0.15 W=0.42 nf=1 ad=0.1218 as=0.1218 pd=1.42 ps=1.42 nrd=0.69047619047619 nrs=0.69047619047619 sa=0 sb=0 sd=0 mult=1 m=1
csn_m11_w0_1 sn_m11_w0_1 0 {C_SN}
XMWR_m11_w0_2 sn_m11_w0_2 0 wbl_m11_w0 0 sky130_fd_pr__nfet_01v8 L=0.15 W=0.42 nf=1 ad=0.1218 as=0.1218 pd=1.42 ps=1.42 nrd=0.69047619047619 nrs=0.69047619047619 sa=0 sb=0 sd=0 mult=1 m=1
XMRD_m11_w0_2 rbl_m11_w0 sn_m11_w0_2 rwl_des 0 sky130_fd_pr__nfet_01v8 L=0.15 W=0.42 nf=1 ad=0.1218 as=0.1218 pd=1.42 ps=1.42 nrd=0.69047619047619 nrs=0.69047619047619 sa=0 sb=0 sd=0 mult=1 m=1
csn_m11_w0_2 sn_m11_w0_2 0 {C_SN}
XMWR_m11_w0_3 sn_m11_w0_3 0 wbl_m11_w0 0 sky130_fd_pr__nfet_01v8 L=0.15 W=0.42 nf=1 ad=0.1218 as=0.1218 pd=1.42 ps=1.42 nrd=0.69047619047619 nrs=0.69047619047619 sa=0 sb=0 sd=0 mult=1 m=1
XMRD_m11_w0_3 rbl_m11_w0 sn_m11_w0_3 rwl_des 0 sky130_fd_pr__nfet_01v8 L=0.15 W=0.42 nf=1 ad=0.1218 as=0.1218 pd=1.42 ps=1.42 nrd=0.69047619047619 nrs=0.69047619047619 sa=0 sb=0 sd=0 mult=1 m=1
csn_m11_w0_3 sn_m11_w0_3 0 {C_SN}
crbl_m11_w0 rbl_m11_w0 0 {C_RBL}
cwbl_m11_w0 wbl_m11_w0 0 {C_WBL}
cref_m11_w0 ref_m11_w0 0 {C_RBL}   $ ASSUMPTION: ideal matched dummy load
XMPPRE_m11_w0 rbl_m11_w0 pcb_100 prea prea sky130_fd_pr__pfet_01v8 L=0.15 W=4 nf=1 ad=1.16 as=1.16 pd=8.58 ps=8.58 nrd=0.0725 nrs=0.0725 sa=0 sb=0 sd=0 mult=1 m=1
XMPU1_m11_w0 x_m11_w0 dinb0 vdd vdd sky130_fd_pr__pfet_01v8 L=0.15 W=1 nf=1 ad=0.29 as=0.29 pd=2.58 ps=2.58 nrd=0.29 nrs=0.29 sa=0 sb=0 sd=0 mult=1 m=1
XMPU2_m11_w0 wbl_m11_w0 wenb x_m11_w0 vdd sky130_fd_pr__pfet_01v8 L=0.15 W=1 nf=1 ad=0.29 as=0.29 pd=2.58 ps=2.58 nrd=0.29 nrs=0.29 sa=0 sb=0 sd=0 mult=1 m=1
XMND2_m11_w0 wbl_m11_w0 wen y_m11_w0 0 sky130_fd_pr__nfet_01v8 L=0.15 W=0.5 nf=1 ad=0.145 as=0.145 pd=1.58 ps=1.58 nrd=0.58 nrs=0.58 sa=0 sb=0 sd=0 mult=1 m=1
XMND1_m11_w0 y_m11_w0 dinb0 0 0 sky130_fd_pr__nfet_01v8 L=0.15 W=0.5 nf=1 ad=0.145 as=0.145 pd=1.58 ps=1.58 nrd=0.58 nrs=0.58 sa=0 sb=0 sd=0 mult=1 m=1
XMNI_m11_w0 wbl_m11_w0 wenb 0 0 sky130_fd_pr__nfet_01v8 L=0.15 W=0.42 nf=1 ad=0.1218 as=0.1218 pd=1.42 ps=1.42 nrd=0.69047619047619 nrs=0.69047619047619 sa=0 sb=0 sd=0 mult=1 m=1
XMPS_m11_w0 sbl_m11_w0 selb_69500 rbl_m11_w0 vdd sky130_fd_pr__pfet_01v8 L=0.15 W=0.5 nf=1 ad=0.145 as=0.145 pd=1.58 ps=1.58 nrd=0.58 nrs=0.58 sa=0 sb=0 sd=0 mult=1 m=1
XMPSR_m11_w0 sref_m11_w0 selb_69500 ref_m11_w0 vdd sky130_fd_pr__pfet_01v8 L=0.15 W=0.5 nf=1 ad=0.145 as=0.145 pd=1.58 ps=1.58 nrd=0.58 nrs=0.58 sa=0 sb=0 sd=0 mult=1 m=1
XMPPREF_m11_w0 ref_m11_w0 pcb_100 pref pref sky130_fd_pr__pfet_01v8 L=0.15 W=4 nf=1 ad=1.16 as=1.16 pd=8.58 ps=8.58 nrd=0.0725 nrs=0.0725 sa=0 sb=0 sd=0 mult=1 m=1   $ reference-side precharge: copy of MPPRE
XMN1_m11_w0 sbl_m11_w0 sref_m11_w0 vn_m11_w0 0 sky130_fd_pr__nfet_01v8 L=0.15 W=1 nf=1 ad=0.29 as=0.29 pd=2.58 ps=2.58 nrd=0.29 nrs=0.29 sa=0 sb=0 sd=0 mult=1 m=1
XMN2_m11_w0 sref_m11_w0 sbl_m11_w0 vn_m11_w0 0 sky130_fd_pr__nfet_01v8 L=0.15 W=1 nf=1 ad=0.29 as=0.29 pd=2.58 ps=2.58 nrd=0.29 nrs=0.29 sa=0 sb=0 sd=0 mult=1 m=1
XMP1_m11_w0 sbl_m11_w0 sref_m11_w0 vp_m11_w0 vdd sky130_fd_pr__pfet_01v8 L=0.15 W=2 nf=1 ad=0.58 as=0.58 pd=4.58 ps=4.58 nrd=0.145 nrs=0.145 sa=0 sb=0 sd=0 mult=1 m=1
XMP2_m11_w0 sref_m11_w0 sbl_m11_w0 vp_m11_w0 vdd sky130_fd_pr__pfet_01v8 L=0.15 W=2 nf=1 ad=0.58 as=0.58 pd=4.58 ps=4.58 nrd=0.145 nrs=0.145 sa=0 sb=0 sd=0 mult=1 m=1
XMNF_m11_w0 vn_m11_w0 en 0 0 sky130_fd_pr__nfet_01v8 L=0.15 W=2 nf=1 ad=0.58 as=0.58 pd=4.58 ps=4.58 nrd=0.145 nrs=0.145 sa=0 sb=0 sd=0 mult=1 m=1
XMPH_m11_w0 vp_m11_w0 enb vdd vdd sky130_fd_pr__pfet_01v8 L=0.15 W=4 nf=1 ad=1.16 as=1.16 pd=8.58 ps=8.58 nrd=0.0725 nrs=0.0725 sa=0 sb=0 sd=0 mult=1 m=1
bd_m11_w0 d_m11_w0 0 v=v(sbl_m11_w0)-v(sref_m11_w0)
bdabs_m11_w0 dabs_m11_w0 0 v=abs(v(sbl_m11_w0)-v(sref_m11_w0))

* ---- instance 58: m12_w1 (baseline TG, dummy 0.5x [matched ref precharge]) ----
XMWR_m12_w1_0 sn_m12_w1_0 wl wbl_m12_w1 0 sky130_fd_pr__nfet_01v8 L=0.15 W=0.42 nf=1 ad=0.1218 as=0.1218 pd=1.42 ps=1.42 nrd=0.69047619047619 nrs=0.69047619047619 sa=0 sb=0 sd=0 mult=1 m=1
XMRD_m12_w1_0 rbl_m12_w1 sn_m12_w1_0 rwl_sel 0 sky130_fd_pr__nfet_01v8 L=0.15 W=0.42 nf=1 ad=0.1218 as=0.1218 pd=1.42 ps=1.42 nrd=0.69047619047619 nrs=0.69047619047619 sa=0 sb=0 sd=0 mult=1 m=1
csn_m12_w1_0 sn_m12_w1_0 0 {C_SN}
XMWR_m12_w1_1 sn_m12_w1_1 0 wbl_m12_w1 0 sky130_fd_pr__nfet_01v8 L=0.15 W=0.42 nf=1 ad=0.1218 as=0.1218 pd=1.42 ps=1.42 nrd=0.69047619047619 nrs=0.69047619047619 sa=0 sb=0 sd=0 mult=1 m=1
XMRD_m12_w1_1 rbl_m12_w1 sn_m12_w1_1 rwl_des 0 sky130_fd_pr__nfet_01v8 L=0.15 W=0.42 nf=1 ad=0.1218 as=0.1218 pd=1.42 ps=1.42 nrd=0.69047619047619 nrs=0.69047619047619 sa=0 sb=0 sd=0 mult=1 m=1
csn_m12_w1_1 sn_m12_w1_1 0 {C_SN}
XMWR_m12_w1_2 sn_m12_w1_2 0 wbl_m12_w1 0 sky130_fd_pr__nfet_01v8 L=0.15 W=0.42 nf=1 ad=0.1218 as=0.1218 pd=1.42 ps=1.42 nrd=0.69047619047619 nrs=0.69047619047619 sa=0 sb=0 sd=0 mult=1 m=1
XMRD_m12_w1_2 rbl_m12_w1 sn_m12_w1_2 rwl_des 0 sky130_fd_pr__nfet_01v8 L=0.15 W=0.42 nf=1 ad=0.1218 as=0.1218 pd=1.42 ps=1.42 nrd=0.69047619047619 nrs=0.69047619047619 sa=0 sb=0 sd=0 mult=1 m=1
csn_m12_w1_2 sn_m12_w1_2 0 {C_SN}
XMWR_m12_w1_3 sn_m12_w1_3 0 wbl_m12_w1 0 sky130_fd_pr__nfet_01v8 L=0.15 W=0.42 nf=1 ad=0.1218 as=0.1218 pd=1.42 ps=1.42 nrd=0.69047619047619 nrs=0.69047619047619 sa=0 sb=0 sd=0 mult=1 m=1
XMRD_m12_w1_3 rbl_m12_w1 sn_m12_w1_3 rwl_des 0 sky130_fd_pr__nfet_01v8 L=0.15 W=0.42 nf=1 ad=0.1218 as=0.1218 pd=1.42 ps=1.42 nrd=0.69047619047619 nrs=0.69047619047619 sa=0 sb=0 sd=0 mult=1 m=1
csn_m12_w1_3 sn_m12_w1_3 0 {C_SN}
crbl_m12_w1 rbl_m12_w1 0 {C_RBL}
cwbl_m12_w1 wbl_m12_w1 0 {C_WBL}
cref_m12_w1 ref_m12_w1 0 {C_RBL}   $ ASSUMPTION: ideal matched dummy load
XMPPRE_m12_w1 rbl_m12_w1 pcb_100 prea prea sky130_fd_pr__pfet_01v8 L=0.15 W=4 nf=1 ad=1.16 as=1.16 pd=8.58 ps=8.58 nrd=0.0725 nrs=0.0725 sa=0 sb=0 sd=0 mult=1 m=1
XMPU1_m12_w1 x_m12_w1 dinb1 vdd vdd sky130_fd_pr__pfet_01v8 L=0.15 W=1 nf=1 ad=0.29 as=0.29 pd=2.58 ps=2.58 nrd=0.29 nrs=0.29 sa=0 sb=0 sd=0 mult=1 m=1
XMPU2_m12_w1 wbl_m12_w1 wenb x_m12_w1 vdd sky130_fd_pr__pfet_01v8 L=0.15 W=1 nf=1 ad=0.29 as=0.29 pd=2.58 ps=2.58 nrd=0.29 nrs=0.29 sa=0 sb=0 sd=0 mult=1 m=1
XMND2_m12_w1 wbl_m12_w1 wen y_m12_w1 0 sky130_fd_pr__nfet_01v8 L=0.15 W=0.5 nf=1 ad=0.145 as=0.145 pd=1.58 ps=1.58 nrd=0.58 nrs=0.58 sa=0 sb=0 sd=0 mult=1 m=1
XMND1_m12_w1 y_m12_w1 dinb1 0 0 sky130_fd_pr__nfet_01v8 L=0.15 W=0.5 nf=1 ad=0.145 as=0.145 pd=1.58 ps=1.58 nrd=0.58 nrs=0.58 sa=0 sb=0 sd=0 mult=1 m=1
XMNI_m12_w1 wbl_m12_w1 wenb 0 0 sky130_fd_pr__nfet_01v8 L=0.15 W=0.42 nf=1 ad=0.1218 as=0.1218 pd=1.42 ps=1.42 nrd=0.69047619047619 nrs=0.69047619047619 sa=0 sb=0 sd=0 mult=1 m=1
XMNS_m12_w1 sbl_m12_w1 sel_69500 rbl_m12_w1 0 sky130_fd_pr__nfet_01v8 L=0.15 W=1 nf=1 ad=0.29 as=0.29 pd=2.58 ps=2.58 nrd=0.29 nrs=0.29 sa=0 sb=0 sd=0 mult=1 m=1
XMPS_m12_w1 sbl_m12_w1 selb_69500 rbl_m12_w1 vdd sky130_fd_pr__pfet_01v8 L=0.15 W=2 nf=1 ad=0.58 as=0.58 pd=4.58 ps=4.58 nrd=0.145 nrs=0.145 sa=0 sb=0 sd=0 mult=1 m=1
XMNSR_m12_w1 sref_m12_w1 sel_69500 ref_m12_w1 0 sky130_fd_pr__nfet_01v8 L=0.15 W=0.5 nf=1 ad=0.145 as=0.145 pd=1.58 ps=1.58 nrd=0.58 nrs=0.58 sa=0 sb=0 sd=0 mult=1 m=1
XMPSR_m12_w1 sref_m12_w1 selb_69500 ref_m12_w1 vdd sky130_fd_pr__pfet_01v8 L=0.15 W=1 nf=1 ad=0.29 as=0.29 pd=2.58 ps=2.58 nrd=0.29 nrs=0.29 sa=0 sb=0 sd=0 mult=1 m=1
XMPPREF_m12_w1 ref_m12_w1 pcb_100 pref pref sky130_fd_pr__pfet_01v8 L=0.15 W=4 nf=1 ad=1.16 as=1.16 pd=8.58 ps=8.58 nrd=0.0725 nrs=0.0725 sa=0 sb=0 sd=0 mult=1 m=1   $ reference-side precharge: copy of MPPRE
XMN1_m12_w1 sbl_m12_w1 sref_m12_w1 vn_m12_w1 0 sky130_fd_pr__nfet_01v8 L=0.15 W=1 nf=1 ad=0.29 as=0.29 pd=2.58 ps=2.58 nrd=0.29 nrs=0.29 sa=0 sb=0 sd=0 mult=1 m=1
XMN2_m12_w1 sref_m12_w1 sbl_m12_w1 vn_m12_w1 0 sky130_fd_pr__nfet_01v8 L=0.15 W=1 nf=1 ad=0.29 as=0.29 pd=2.58 ps=2.58 nrd=0.29 nrs=0.29 sa=0 sb=0 sd=0 mult=1 m=1
XMP1_m12_w1 sbl_m12_w1 sref_m12_w1 vp_m12_w1 vdd sky130_fd_pr__pfet_01v8 L=0.15 W=2 nf=1 ad=0.58 as=0.58 pd=4.58 ps=4.58 nrd=0.145 nrs=0.145 sa=0 sb=0 sd=0 mult=1 m=1
XMP2_m12_w1 sref_m12_w1 sbl_m12_w1 vp_m12_w1 vdd sky130_fd_pr__pfet_01v8 L=0.15 W=2 nf=1 ad=0.58 as=0.58 pd=4.58 ps=4.58 nrd=0.145 nrs=0.145 sa=0 sb=0 sd=0 mult=1 m=1
XMNF_m12_w1 vn_m12_w1 en 0 0 sky130_fd_pr__nfet_01v8 L=0.15 W=2 nf=1 ad=0.58 as=0.58 pd=4.58 ps=4.58 nrd=0.145 nrs=0.145 sa=0 sb=0 sd=0 mult=1 m=1
XMPH_m12_w1 vp_m12_w1 enb vdd vdd sky130_fd_pr__pfet_01v8 L=0.15 W=4 nf=1 ad=1.16 as=1.16 pd=8.58 ps=8.58 nrd=0.0725 nrs=0.0725 sa=0 sb=0 sd=0 mult=1 m=1
bd_m12_w1 d_m12_w1 0 v=v(sbl_m12_w1)-v(sref_m12_w1)
bdabs_m12_w1 dabs_m12_w1 0 v=abs(v(sbl_m12_w1)-v(sref_m12_w1))

* ---- instance 59: m12_w0 (baseline TG, dummy 0.5x [matched ref precharge]) ----
XMWR_m12_w0_0 sn_m12_w0_0 wl wbl_m12_w0 0 sky130_fd_pr__nfet_01v8 L=0.15 W=0.42 nf=1 ad=0.1218 as=0.1218 pd=1.42 ps=1.42 nrd=0.69047619047619 nrs=0.69047619047619 sa=0 sb=0 sd=0 mult=1 m=1
XMRD_m12_w0_0 rbl_m12_w0 sn_m12_w0_0 rwl_sel 0 sky130_fd_pr__nfet_01v8 L=0.15 W=0.42 nf=1 ad=0.1218 as=0.1218 pd=1.42 ps=1.42 nrd=0.69047619047619 nrs=0.69047619047619 sa=0 sb=0 sd=0 mult=1 m=1
csn_m12_w0_0 sn_m12_w0_0 0 {C_SN}
XMWR_m12_w0_1 sn_m12_w0_1 0 wbl_m12_w0 0 sky130_fd_pr__nfet_01v8 L=0.15 W=0.42 nf=1 ad=0.1218 as=0.1218 pd=1.42 ps=1.42 nrd=0.69047619047619 nrs=0.69047619047619 sa=0 sb=0 sd=0 mult=1 m=1
XMRD_m12_w0_1 rbl_m12_w0 sn_m12_w0_1 rwl_des 0 sky130_fd_pr__nfet_01v8 L=0.15 W=0.42 nf=1 ad=0.1218 as=0.1218 pd=1.42 ps=1.42 nrd=0.69047619047619 nrs=0.69047619047619 sa=0 sb=0 sd=0 mult=1 m=1
csn_m12_w0_1 sn_m12_w0_1 0 {C_SN}
XMWR_m12_w0_2 sn_m12_w0_2 0 wbl_m12_w0 0 sky130_fd_pr__nfet_01v8 L=0.15 W=0.42 nf=1 ad=0.1218 as=0.1218 pd=1.42 ps=1.42 nrd=0.69047619047619 nrs=0.69047619047619 sa=0 sb=0 sd=0 mult=1 m=1
XMRD_m12_w0_2 rbl_m12_w0 sn_m12_w0_2 rwl_des 0 sky130_fd_pr__nfet_01v8 L=0.15 W=0.42 nf=1 ad=0.1218 as=0.1218 pd=1.42 ps=1.42 nrd=0.69047619047619 nrs=0.69047619047619 sa=0 sb=0 sd=0 mult=1 m=1
csn_m12_w0_2 sn_m12_w0_2 0 {C_SN}
XMWR_m12_w0_3 sn_m12_w0_3 0 wbl_m12_w0 0 sky130_fd_pr__nfet_01v8 L=0.15 W=0.42 nf=1 ad=0.1218 as=0.1218 pd=1.42 ps=1.42 nrd=0.69047619047619 nrs=0.69047619047619 sa=0 sb=0 sd=0 mult=1 m=1
XMRD_m12_w0_3 rbl_m12_w0 sn_m12_w0_3 rwl_des 0 sky130_fd_pr__nfet_01v8 L=0.15 W=0.42 nf=1 ad=0.1218 as=0.1218 pd=1.42 ps=1.42 nrd=0.69047619047619 nrs=0.69047619047619 sa=0 sb=0 sd=0 mult=1 m=1
csn_m12_w0_3 sn_m12_w0_3 0 {C_SN}
crbl_m12_w0 rbl_m12_w0 0 {C_RBL}
cwbl_m12_w0 wbl_m12_w0 0 {C_WBL}
cref_m12_w0 ref_m12_w0 0 {C_RBL}   $ ASSUMPTION: ideal matched dummy load
XMPPRE_m12_w0 rbl_m12_w0 pcb_100 prea prea sky130_fd_pr__pfet_01v8 L=0.15 W=4 nf=1 ad=1.16 as=1.16 pd=8.58 ps=8.58 nrd=0.0725 nrs=0.0725 sa=0 sb=0 sd=0 mult=1 m=1
XMPU1_m12_w0 x_m12_w0 dinb0 vdd vdd sky130_fd_pr__pfet_01v8 L=0.15 W=1 nf=1 ad=0.29 as=0.29 pd=2.58 ps=2.58 nrd=0.29 nrs=0.29 sa=0 sb=0 sd=0 mult=1 m=1
XMPU2_m12_w0 wbl_m12_w0 wenb x_m12_w0 vdd sky130_fd_pr__pfet_01v8 L=0.15 W=1 nf=1 ad=0.29 as=0.29 pd=2.58 ps=2.58 nrd=0.29 nrs=0.29 sa=0 sb=0 sd=0 mult=1 m=1
XMND2_m12_w0 wbl_m12_w0 wen y_m12_w0 0 sky130_fd_pr__nfet_01v8 L=0.15 W=0.5 nf=1 ad=0.145 as=0.145 pd=1.58 ps=1.58 nrd=0.58 nrs=0.58 sa=0 sb=0 sd=0 mult=1 m=1
XMND1_m12_w0 y_m12_w0 dinb0 0 0 sky130_fd_pr__nfet_01v8 L=0.15 W=0.5 nf=1 ad=0.145 as=0.145 pd=1.58 ps=1.58 nrd=0.58 nrs=0.58 sa=0 sb=0 sd=0 mult=1 m=1
XMNI_m12_w0 wbl_m12_w0 wenb 0 0 sky130_fd_pr__nfet_01v8 L=0.15 W=0.42 nf=1 ad=0.1218 as=0.1218 pd=1.42 ps=1.42 nrd=0.69047619047619 nrs=0.69047619047619 sa=0 sb=0 sd=0 mult=1 m=1
XMNS_m12_w0 sbl_m12_w0 sel_69500 rbl_m12_w0 0 sky130_fd_pr__nfet_01v8 L=0.15 W=1 nf=1 ad=0.29 as=0.29 pd=2.58 ps=2.58 nrd=0.29 nrs=0.29 sa=0 sb=0 sd=0 mult=1 m=1
XMPS_m12_w0 sbl_m12_w0 selb_69500 rbl_m12_w0 vdd sky130_fd_pr__pfet_01v8 L=0.15 W=2 nf=1 ad=0.58 as=0.58 pd=4.58 ps=4.58 nrd=0.145 nrs=0.145 sa=0 sb=0 sd=0 mult=1 m=1
XMNSR_m12_w0 sref_m12_w0 sel_69500 ref_m12_w0 0 sky130_fd_pr__nfet_01v8 L=0.15 W=0.5 nf=1 ad=0.145 as=0.145 pd=1.58 ps=1.58 nrd=0.58 nrs=0.58 sa=0 sb=0 sd=0 mult=1 m=1
XMPSR_m12_w0 sref_m12_w0 selb_69500 ref_m12_w0 vdd sky130_fd_pr__pfet_01v8 L=0.15 W=1 nf=1 ad=0.29 as=0.29 pd=2.58 ps=2.58 nrd=0.29 nrs=0.29 sa=0 sb=0 sd=0 mult=1 m=1
XMPPREF_m12_w0 ref_m12_w0 pcb_100 pref pref sky130_fd_pr__pfet_01v8 L=0.15 W=4 nf=1 ad=1.16 as=1.16 pd=8.58 ps=8.58 nrd=0.0725 nrs=0.0725 sa=0 sb=0 sd=0 mult=1 m=1   $ reference-side precharge: copy of MPPRE
XMN1_m12_w0 sbl_m12_w0 sref_m12_w0 vn_m12_w0 0 sky130_fd_pr__nfet_01v8 L=0.15 W=1 nf=1 ad=0.29 as=0.29 pd=2.58 ps=2.58 nrd=0.29 nrs=0.29 sa=0 sb=0 sd=0 mult=1 m=1
XMN2_m12_w0 sref_m12_w0 sbl_m12_w0 vn_m12_w0 0 sky130_fd_pr__nfet_01v8 L=0.15 W=1 nf=1 ad=0.29 as=0.29 pd=2.58 ps=2.58 nrd=0.29 nrs=0.29 sa=0 sb=0 sd=0 mult=1 m=1
XMP1_m12_w0 sbl_m12_w0 sref_m12_w0 vp_m12_w0 vdd sky130_fd_pr__pfet_01v8 L=0.15 W=2 nf=1 ad=0.58 as=0.58 pd=4.58 ps=4.58 nrd=0.145 nrs=0.145 sa=0 sb=0 sd=0 mult=1 m=1
XMP2_m12_w0 sref_m12_w0 sbl_m12_w0 vp_m12_w0 vdd sky130_fd_pr__pfet_01v8 L=0.15 W=2 nf=1 ad=0.58 as=0.58 pd=4.58 ps=4.58 nrd=0.145 nrs=0.145 sa=0 sb=0 sd=0 mult=1 m=1
XMNF_m12_w0 vn_m12_w0 en 0 0 sky130_fd_pr__nfet_01v8 L=0.15 W=2 nf=1 ad=0.58 as=0.58 pd=4.58 ps=4.58 nrd=0.145 nrs=0.145 sa=0 sb=0 sd=0 mult=1 m=1
XMPH_m12_w0 vp_m12_w0 enb vdd vdd sky130_fd_pr__pfet_01v8 L=0.15 W=4 nf=1 ad=1.16 as=1.16 pd=8.58 ps=8.58 nrd=0.0725 nrs=0.0725 sa=0 sb=0 sd=0 mult=1 m=1
bd_m12_w0 d_m12_w0 0 v=v(sbl_m12_w0)-v(sref_m12_w0)
bdabs_m12_w0 dabs_m12_w0 0 v=abs(v(sbl_m12_w0)-v(sref_m12_w0))

* ---- instance 60: m13_w1 (baseline TG, dummy 0.75x [matched ref precharge]) ----
XMWR_m13_w1_0 sn_m13_w1_0 wl wbl_m13_w1 0 sky130_fd_pr__nfet_01v8 L=0.15 W=0.42 nf=1 ad=0.1218 as=0.1218 pd=1.42 ps=1.42 nrd=0.69047619047619 nrs=0.69047619047619 sa=0 sb=0 sd=0 mult=1 m=1
XMRD_m13_w1_0 rbl_m13_w1 sn_m13_w1_0 rwl_sel 0 sky130_fd_pr__nfet_01v8 L=0.15 W=0.42 nf=1 ad=0.1218 as=0.1218 pd=1.42 ps=1.42 nrd=0.69047619047619 nrs=0.69047619047619 sa=0 sb=0 sd=0 mult=1 m=1
csn_m13_w1_0 sn_m13_w1_0 0 {C_SN}
XMWR_m13_w1_1 sn_m13_w1_1 0 wbl_m13_w1 0 sky130_fd_pr__nfet_01v8 L=0.15 W=0.42 nf=1 ad=0.1218 as=0.1218 pd=1.42 ps=1.42 nrd=0.69047619047619 nrs=0.69047619047619 sa=0 sb=0 sd=0 mult=1 m=1
XMRD_m13_w1_1 rbl_m13_w1 sn_m13_w1_1 rwl_des 0 sky130_fd_pr__nfet_01v8 L=0.15 W=0.42 nf=1 ad=0.1218 as=0.1218 pd=1.42 ps=1.42 nrd=0.69047619047619 nrs=0.69047619047619 sa=0 sb=0 sd=0 mult=1 m=1
csn_m13_w1_1 sn_m13_w1_1 0 {C_SN}
XMWR_m13_w1_2 sn_m13_w1_2 0 wbl_m13_w1 0 sky130_fd_pr__nfet_01v8 L=0.15 W=0.42 nf=1 ad=0.1218 as=0.1218 pd=1.42 ps=1.42 nrd=0.69047619047619 nrs=0.69047619047619 sa=0 sb=0 sd=0 mult=1 m=1
XMRD_m13_w1_2 rbl_m13_w1 sn_m13_w1_2 rwl_des 0 sky130_fd_pr__nfet_01v8 L=0.15 W=0.42 nf=1 ad=0.1218 as=0.1218 pd=1.42 ps=1.42 nrd=0.69047619047619 nrs=0.69047619047619 sa=0 sb=0 sd=0 mult=1 m=1
csn_m13_w1_2 sn_m13_w1_2 0 {C_SN}
XMWR_m13_w1_3 sn_m13_w1_3 0 wbl_m13_w1 0 sky130_fd_pr__nfet_01v8 L=0.15 W=0.42 nf=1 ad=0.1218 as=0.1218 pd=1.42 ps=1.42 nrd=0.69047619047619 nrs=0.69047619047619 sa=0 sb=0 sd=0 mult=1 m=1
XMRD_m13_w1_3 rbl_m13_w1 sn_m13_w1_3 rwl_des 0 sky130_fd_pr__nfet_01v8 L=0.15 W=0.42 nf=1 ad=0.1218 as=0.1218 pd=1.42 ps=1.42 nrd=0.69047619047619 nrs=0.69047619047619 sa=0 sb=0 sd=0 mult=1 m=1
csn_m13_w1_3 sn_m13_w1_3 0 {C_SN}
crbl_m13_w1 rbl_m13_w1 0 {C_RBL}
cwbl_m13_w1 wbl_m13_w1 0 {C_WBL}
cref_m13_w1 ref_m13_w1 0 {C_RBL}   $ ASSUMPTION: ideal matched dummy load
XMPPRE_m13_w1 rbl_m13_w1 pcb_100 prea prea sky130_fd_pr__pfet_01v8 L=0.15 W=4 nf=1 ad=1.16 as=1.16 pd=8.58 ps=8.58 nrd=0.0725 nrs=0.0725 sa=0 sb=0 sd=0 mult=1 m=1
XMPU1_m13_w1 x_m13_w1 dinb1 vdd vdd sky130_fd_pr__pfet_01v8 L=0.15 W=1 nf=1 ad=0.29 as=0.29 pd=2.58 ps=2.58 nrd=0.29 nrs=0.29 sa=0 sb=0 sd=0 mult=1 m=1
XMPU2_m13_w1 wbl_m13_w1 wenb x_m13_w1 vdd sky130_fd_pr__pfet_01v8 L=0.15 W=1 nf=1 ad=0.29 as=0.29 pd=2.58 ps=2.58 nrd=0.29 nrs=0.29 sa=0 sb=0 sd=0 mult=1 m=1
XMND2_m13_w1 wbl_m13_w1 wen y_m13_w1 0 sky130_fd_pr__nfet_01v8 L=0.15 W=0.5 nf=1 ad=0.145 as=0.145 pd=1.58 ps=1.58 nrd=0.58 nrs=0.58 sa=0 sb=0 sd=0 mult=1 m=1
XMND1_m13_w1 y_m13_w1 dinb1 0 0 sky130_fd_pr__nfet_01v8 L=0.15 W=0.5 nf=1 ad=0.145 as=0.145 pd=1.58 ps=1.58 nrd=0.58 nrs=0.58 sa=0 sb=0 sd=0 mult=1 m=1
XMNI_m13_w1 wbl_m13_w1 wenb 0 0 sky130_fd_pr__nfet_01v8 L=0.15 W=0.42 nf=1 ad=0.1218 as=0.1218 pd=1.42 ps=1.42 nrd=0.69047619047619 nrs=0.69047619047619 sa=0 sb=0 sd=0 mult=1 m=1
XMNS_m13_w1 sbl_m13_w1 sel_69500 rbl_m13_w1 0 sky130_fd_pr__nfet_01v8 L=0.15 W=1 nf=1 ad=0.29 as=0.29 pd=2.58 ps=2.58 nrd=0.29 nrs=0.29 sa=0 sb=0 sd=0 mult=1 m=1
XMPS_m13_w1 sbl_m13_w1 selb_69500 rbl_m13_w1 vdd sky130_fd_pr__pfet_01v8 L=0.15 W=2 nf=1 ad=0.58 as=0.58 pd=4.58 ps=4.58 nrd=0.145 nrs=0.145 sa=0 sb=0 sd=0 mult=1 m=1
XMNSR_m13_w1 sref_m13_w1 sel_69500 ref_m13_w1 0 sky130_fd_pr__nfet_01v8 L=0.15 W=0.75 nf=1 ad=0.2175 as=0.2175 pd=2.08 ps=2.08 nrd=0.38666666666667 nrs=0.38666666666667 sa=0 sb=0 sd=0 mult=1 m=1
XMPSR_m13_w1 sref_m13_w1 selb_69500 ref_m13_w1 vdd sky130_fd_pr__pfet_01v8 L=0.15 W=1.5 nf=1 ad=0.435 as=0.435 pd=3.58 ps=3.58 nrd=0.19333333333333 nrs=0.19333333333333 sa=0 sb=0 sd=0 mult=1 m=1
XMPPREF_m13_w1 ref_m13_w1 pcb_100 pref pref sky130_fd_pr__pfet_01v8 L=0.15 W=4 nf=1 ad=1.16 as=1.16 pd=8.58 ps=8.58 nrd=0.0725 nrs=0.0725 sa=0 sb=0 sd=0 mult=1 m=1   $ reference-side precharge: copy of MPPRE
XMN1_m13_w1 sbl_m13_w1 sref_m13_w1 vn_m13_w1 0 sky130_fd_pr__nfet_01v8 L=0.15 W=1 nf=1 ad=0.29 as=0.29 pd=2.58 ps=2.58 nrd=0.29 nrs=0.29 sa=0 sb=0 sd=0 mult=1 m=1
XMN2_m13_w1 sref_m13_w1 sbl_m13_w1 vn_m13_w1 0 sky130_fd_pr__nfet_01v8 L=0.15 W=1 nf=1 ad=0.29 as=0.29 pd=2.58 ps=2.58 nrd=0.29 nrs=0.29 sa=0 sb=0 sd=0 mult=1 m=1
XMP1_m13_w1 sbl_m13_w1 sref_m13_w1 vp_m13_w1 vdd sky130_fd_pr__pfet_01v8 L=0.15 W=2 nf=1 ad=0.58 as=0.58 pd=4.58 ps=4.58 nrd=0.145 nrs=0.145 sa=0 sb=0 sd=0 mult=1 m=1
XMP2_m13_w1 sref_m13_w1 sbl_m13_w1 vp_m13_w1 vdd sky130_fd_pr__pfet_01v8 L=0.15 W=2 nf=1 ad=0.58 as=0.58 pd=4.58 ps=4.58 nrd=0.145 nrs=0.145 sa=0 sb=0 sd=0 mult=1 m=1
XMNF_m13_w1 vn_m13_w1 en 0 0 sky130_fd_pr__nfet_01v8 L=0.15 W=2 nf=1 ad=0.58 as=0.58 pd=4.58 ps=4.58 nrd=0.145 nrs=0.145 sa=0 sb=0 sd=0 mult=1 m=1
XMPH_m13_w1 vp_m13_w1 enb vdd vdd sky130_fd_pr__pfet_01v8 L=0.15 W=4 nf=1 ad=1.16 as=1.16 pd=8.58 ps=8.58 nrd=0.0725 nrs=0.0725 sa=0 sb=0 sd=0 mult=1 m=1
bd_m13_w1 d_m13_w1 0 v=v(sbl_m13_w1)-v(sref_m13_w1)
bdabs_m13_w1 dabs_m13_w1 0 v=abs(v(sbl_m13_w1)-v(sref_m13_w1))

* ---- instance 61: m13_w0 (baseline TG, dummy 0.75x [matched ref precharge]) ----
XMWR_m13_w0_0 sn_m13_w0_0 wl wbl_m13_w0 0 sky130_fd_pr__nfet_01v8 L=0.15 W=0.42 nf=1 ad=0.1218 as=0.1218 pd=1.42 ps=1.42 nrd=0.69047619047619 nrs=0.69047619047619 sa=0 sb=0 sd=0 mult=1 m=1
XMRD_m13_w0_0 rbl_m13_w0 sn_m13_w0_0 rwl_sel 0 sky130_fd_pr__nfet_01v8 L=0.15 W=0.42 nf=1 ad=0.1218 as=0.1218 pd=1.42 ps=1.42 nrd=0.69047619047619 nrs=0.69047619047619 sa=0 sb=0 sd=0 mult=1 m=1
csn_m13_w0_0 sn_m13_w0_0 0 {C_SN}
XMWR_m13_w0_1 sn_m13_w0_1 0 wbl_m13_w0 0 sky130_fd_pr__nfet_01v8 L=0.15 W=0.42 nf=1 ad=0.1218 as=0.1218 pd=1.42 ps=1.42 nrd=0.69047619047619 nrs=0.69047619047619 sa=0 sb=0 sd=0 mult=1 m=1
XMRD_m13_w0_1 rbl_m13_w0 sn_m13_w0_1 rwl_des 0 sky130_fd_pr__nfet_01v8 L=0.15 W=0.42 nf=1 ad=0.1218 as=0.1218 pd=1.42 ps=1.42 nrd=0.69047619047619 nrs=0.69047619047619 sa=0 sb=0 sd=0 mult=1 m=1
csn_m13_w0_1 sn_m13_w0_1 0 {C_SN}
XMWR_m13_w0_2 sn_m13_w0_2 0 wbl_m13_w0 0 sky130_fd_pr__nfet_01v8 L=0.15 W=0.42 nf=1 ad=0.1218 as=0.1218 pd=1.42 ps=1.42 nrd=0.69047619047619 nrs=0.69047619047619 sa=0 sb=0 sd=0 mult=1 m=1
XMRD_m13_w0_2 rbl_m13_w0 sn_m13_w0_2 rwl_des 0 sky130_fd_pr__nfet_01v8 L=0.15 W=0.42 nf=1 ad=0.1218 as=0.1218 pd=1.42 ps=1.42 nrd=0.69047619047619 nrs=0.69047619047619 sa=0 sb=0 sd=0 mult=1 m=1
csn_m13_w0_2 sn_m13_w0_2 0 {C_SN}
XMWR_m13_w0_3 sn_m13_w0_3 0 wbl_m13_w0 0 sky130_fd_pr__nfet_01v8 L=0.15 W=0.42 nf=1 ad=0.1218 as=0.1218 pd=1.42 ps=1.42 nrd=0.69047619047619 nrs=0.69047619047619 sa=0 sb=0 sd=0 mult=1 m=1
XMRD_m13_w0_3 rbl_m13_w0 sn_m13_w0_3 rwl_des 0 sky130_fd_pr__nfet_01v8 L=0.15 W=0.42 nf=1 ad=0.1218 as=0.1218 pd=1.42 ps=1.42 nrd=0.69047619047619 nrs=0.69047619047619 sa=0 sb=0 sd=0 mult=1 m=1
csn_m13_w0_3 sn_m13_w0_3 0 {C_SN}
crbl_m13_w0 rbl_m13_w0 0 {C_RBL}
cwbl_m13_w0 wbl_m13_w0 0 {C_WBL}
cref_m13_w0 ref_m13_w0 0 {C_RBL}   $ ASSUMPTION: ideal matched dummy load
XMPPRE_m13_w0 rbl_m13_w0 pcb_100 prea prea sky130_fd_pr__pfet_01v8 L=0.15 W=4 nf=1 ad=1.16 as=1.16 pd=8.58 ps=8.58 nrd=0.0725 nrs=0.0725 sa=0 sb=0 sd=0 mult=1 m=1
XMPU1_m13_w0 x_m13_w0 dinb0 vdd vdd sky130_fd_pr__pfet_01v8 L=0.15 W=1 nf=1 ad=0.29 as=0.29 pd=2.58 ps=2.58 nrd=0.29 nrs=0.29 sa=0 sb=0 sd=0 mult=1 m=1
XMPU2_m13_w0 wbl_m13_w0 wenb x_m13_w0 vdd sky130_fd_pr__pfet_01v8 L=0.15 W=1 nf=1 ad=0.29 as=0.29 pd=2.58 ps=2.58 nrd=0.29 nrs=0.29 sa=0 sb=0 sd=0 mult=1 m=1
XMND2_m13_w0 wbl_m13_w0 wen y_m13_w0 0 sky130_fd_pr__nfet_01v8 L=0.15 W=0.5 nf=1 ad=0.145 as=0.145 pd=1.58 ps=1.58 nrd=0.58 nrs=0.58 sa=0 sb=0 sd=0 mult=1 m=1
XMND1_m13_w0 y_m13_w0 dinb0 0 0 sky130_fd_pr__nfet_01v8 L=0.15 W=0.5 nf=1 ad=0.145 as=0.145 pd=1.58 ps=1.58 nrd=0.58 nrs=0.58 sa=0 sb=0 sd=0 mult=1 m=1
XMNI_m13_w0 wbl_m13_w0 wenb 0 0 sky130_fd_pr__nfet_01v8 L=0.15 W=0.42 nf=1 ad=0.1218 as=0.1218 pd=1.42 ps=1.42 nrd=0.69047619047619 nrs=0.69047619047619 sa=0 sb=0 sd=0 mult=1 m=1
XMNS_m13_w0 sbl_m13_w0 sel_69500 rbl_m13_w0 0 sky130_fd_pr__nfet_01v8 L=0.15 W=1 nf=1 ad=0.29 as=0.29 pd=2.58 ps=2.58 nrd=0.29 nrs=0.29 sa=0 sb=0 sd=0 mult=1 m=1
XMPS_m13_w0 sbl_m13_w0 selb_69500 rbl_m13_w0 vdd sky130_fd_pr__pfet_01v8 L=0.15 W=2 nf=1 ad=0.58 as=0.58 pd=4.58 ps=4.58 nrd=0.145 nrs=0.145 sa=0 sb=0 sd=0 mult=1 m=1
XMNSR_m13_w0 sref_m13_w0 sel_69500 ref_m13_w0 0 sky130_fd_pr__nfet_01v8 L=0.15 W=0.75 nf=1 ad=0.2175 as=0.2175 pd=2.08 ps=2.08 nrd=0.38666666666667 nrs=0.38666666666667 sa=0 sb=0 sd=0 mult=1 m=1
XMPSR_m13_w0 sref_m13_w0 selb_69500 ref_m13_w0 vdd sky130_fd_pr__pfet_01v8 L=0.15 W=1.5 nf=1 ad=0.435 as=0.435 pd=3.58 ps=3.58 nrd=0.19333333333333 nrs=0.19333333333333 sa=0 sb=0 sd=0 mult=1 m=1
XMPPREF_m13_w0 ref_m13_w0 pcb_100 pref pref sky130_fd_pr__pfet_01v8 L=0.15 W=4 nf=1 ad=1.16 as=1.16 pd=8.58 ps=8.58 nrd=0.0725 nrs=0.0725 sa=0 sb=0 sd=0 mult=1 m=1   $ reference-side precharge: copy of MPPRE
XMN1_m13_w0 sbl_m13_w0 sref_m13_w0 vn_m13_w0 0 sky130_fd_pr__nfet_01v8 L=0.15 W=1 nf=1 ad=0.29 as=0.29 pd=2.58 ps=2.58 nrd=0.29 nrs=0.29 sa=0 sb=0 sd=0 mult=1 m=1
XMN2_m13_w0 sref_m13_w0 sbl_m13_w0 vn_m13_w0 0 sky130_fd_pr__nfet_01v8 L=0.15 W=1 nf=1 ad=0.29 as=0.29 pd=2.58 ps=2.58 nrd=0.29 nrs=0.29 sa=0 sb=0 sd=0 mult=1 m=1
XMP1_m13_w0 sbl_m13_w0 sref_m13_w0 vp_m13_w0 vdd sky130_fd_pr__pfet_01v8 L=0.15 W=2 nf=1 ad=0.58 as=0.58 pd=4.58 ps=4.58 nrd=0.145 nrs=0.145 sa=0 sb=0 sd=0 mult=1 m=1
XMP2_m13_w0 sref_m13_w0 sbl_m13_w0 vp_m13_w0 vdd sky130_fd_pr__pfet_01v8 L=0.15 W=2 nf=1 ad=0.58 as=0.58 pd=4.58 ps=4.58 nrd=0.145 nrs=0.145 sa=0 sb=0 sd=0 mult=1 m=1
XMNF_m13_w0 vn_m13_w0 en 0 0 sky130_fd_pr__nfet_01v8 L=0.15 W=2 nf=1 ad=0.58 as=0.58 pd=4.58 ps=4.58 nrd=0.145 nrs=0.145 sa=0 sb=0 sd=0 mult=1 m=1
XMPH_m13_w0 vp_m13_w0 enb vdd vdd sky130_fd_pr__pfet_01v8 L=0.15 W=4 nf=1 ad=1.16 as=1.16 pd=8.58 ps=8.58 nrd=0.0725 nrs=0.0725 sa=0 sb=0 sd=0 mult=1 m=1
bd_m13_w0 d_m13_w0 0 v=v(sbl_m13_w0)-v(sref_m13_w0)
bdabs_m13_w0 dabs_m13_w0 0 v=abs(v(sbl_m13_w0)-v(sref_m13_w0))

* ---- instance 62: m14_w1 (baseline TG, dummy 1.5x [matched ref precharge]) ----
XMWR_m14_w1_0 sn_m14_w1_0 wl wbl_m14_w1 0 sky130_fd_pr__nfet_01v8 L=0.15 W=0.42 nf=1 ad=0.1218 as=0.1218 pd=1.42 ps=1.42 nrd=0.69047619047619 nrs=0.69047619047619 sa=0 sb=0 sd=0 mult=1 m=1
XMRD_m14_w1_0 rbl_m14_w1 sn_m14_w1_0 rwl_sel 0 sky130_fd_pr__nfet_01v8 L=0.15 W=0.42 nf=1 ad=0.1218 as=0.1218 pd=1.42 ps=1.42 nrd=0.69047619047619 nrs=0.69047619047619 sa=0 sb=0 sd=0 mult=1 m=1
csn_m14_w1_0 sn_m14_w1_0 0 {C_SN}
XMWR_m14_w1_1 sn_m14_w1_1 0 wbl_m14_w1 0 sky130_fd_pr__nfet_01v8 L=0.15 W=0.42 nf=1 ad=0.1218 as=0.1218 pd=1.42 ps=1.42 nrd=0.69047619047619 nrs=0.69047619047619 sa=0 sb=0 sd=0 mult=1 m=1
XMRD_m14_w1_1 rbl_m14_w1 sn_m14_w1_1 rwl_des 0 sky130_fd_pr__nfet_01v8 L=0.15 W=0.42 nf=1 ad=0.1218 as=0.1218 pd=1.42 ps=1.42 nrd=0.69047619047619 nrs=0.69047619047619 sa=0 sb=0 sd=0 mult=1 m=1
csn_m14_w1_1 sn_m14_w1_1 0 {C_SN}
XMWR_m14_w1_2 sn_m14_w1_2 0 wbl_m14_w1 0 sky130_fd_pr__nfet_01v8 L=0.15 W=0.42 nf=1 ad=0.1218 as=0.1218 pd=1.42 ps=1.42 nrd=0.69047619047619 nrs=0.69047619047619 sa=0 sb=0 sd=0 mult=1 m=1
XMRD_m14_w1_2 rbl_m14_w1 sn_m14_w1_2 rwl_des 0 sky130_fd_pr__nfet_01v8 L=0.15 W=0.42 nf=1 ad=0.1218 as=0.1218 pd=1.42 ps=1.42 nrd=0.69047619047619 nrs=0.69047619047619 sa=0 sb=0 sd=0 mult=1 m=1
csn_m14_w1_2 sn_m14_w1_2 0 {C_SN}
XMWR_m14_w1_3 sn_m14_w1_3 0 wbl_m14_w1 0 sky130_fd_pr__nfet_01v8 L=0.15 W=0.42 nf=1 ad=0.1218 as=0.1218 pd=1.42 ps=1.42 nrd=0.69047619047619 nrs=0.69047619047619 sa=0 sb=0 sd=0 mult=1 m=1
XMRD_m14_w1_3 rbl_m14_w1 sn_m14_w1_3 rwl_des 0 sky130_fd_pr__nfet_01v8 L=0.15 W=0.42 nf=1 ad=0.1218 as=0.1218 pd=1.42 ps=1.42 nrd=0.69047619047619 nrs=0.69047619047619 sa=0 sb=0 sd=0 mult=1 m=1
csn_m14_w1_3 sn_m14_w1_3 0 {C_SN}
crbl_m14_w1 rbl_m14_w1 0 {C_RBL}
cwbl_m14_w1 wbl_m14_w1 0 {C_WBL}
cref_m14_w1 ref_m14_w1 0 {C_RBL}   $ ASSUMPTION: ideal matched dummy load
XMPPRE_m14_w1 rbl_m14_w1 pcb_100 prea prea sky130_fd_pr__pfet_01v8 L=0.15 W=4 nf=1 ad=1.16 as=1.16 pd=8.58 ps=8.58 nrd=0.0725 nrs=0.0725 sa=0 sb=0 sd=0 mult=1 m=1
XMPU1_m14_w1 x_m14_w1 dinb1 vdd vdd sky130_fd_pr__pfet_01v8 L=0.15 W=1 nf=1 ad=0.29 as=0.29 pd=2.58 ps=2.58 nrd=0.29 nrs=0.29 sa=0 sb=0 sd=0 mult=1 m=1
XMPU2_m14_w1 wbl_m14_w1 wenb x_m14_w1 vdd sky130_fd_pr__pfet_01v8 L=0.15 W=1 nf=1 ad=0.29 as=0.29 pd=2.58 ps=2.58 nrd=0.29 nrs=0.29 sa=0 sb=0 sd=0 mult=1 m=1
XMND2_m14_w1 wbl_m14_w1 wen y_m14_w1 0 sky130_fd_pr__nfet_01v8 L=0.15 W=0.5 nf=1 ad=0.145 as=0.145 pd=1.58 ps=1.58 nrd=0.58 nrs=0.58 sa=0 sb=0 sd=0 mult=1 m=1
XMND1_m14_w1 y_m14_w1 dinb1 0 0 sky130_fd_pr__nfet_01v8 L=0.15 W=0.5 nf=1 ad=0.145 as=0.145 pd=1.58 ps=1.58 nrd=0.58 nrs=0.58 sa=0 sb=0 sd=0 mult=1 m=1
XMNI_m14_w1 wbl_m14_w1 wenb 0 0 sky130_fd_pr__nfet_01v8 L=0.15 W=0.42 nf=1 ad=0.1218 as=0.1218 pd=1.42 ps=1.42 nrd=0.69047619047619 nrs=0.69047619047619 sa=0 sb=0 sd=0 mult=1 m=1
XMNS_m14_w1 sbl_m14_w1 sel_69500 rbl_m14_w1 0 sky130_fd_pr__nfet_01v8 L=0.15 W=1 nf=1 ad=0.29 as=0.29 pd=2.58 ps=2.58 nrd=0.29 nrs=0.29 sa=0 sb=0 sd=0 mult=1 m=1
XMPS_m14_w1 sbl_m14_w1 selb_69500 rbl_m14_w1 vdd sky130_fd_pr__pfet_01v8 L=0.15 W=2 nf=1 ad=0.58 as=0.58 pd=4.58 ps=4.58 nrd=0.145 nrs=0.145 sa=0 sb=0 sd=0 mult=1 m=1
XMNSR_m14_w1 sref_m14_w1 sel_69500 ref_m14_w1 0 sky130_fd_pr__nfet_01v8 L=0.15 W=1.5 nf=1 ad=0.435 as=0.435 pd=3.58 ps=3.58 nrd=0.19333333333333 nrs=0.19333333333333 sa=0 sb=0 sd=0 mult=1 m=1
XMPSR_m14_w1 sref_m14_w1 selb_69500 ref_m14_w1 vdd sky130_fd_pr__pfet_01v8 L=0.15 W=3 nf=1 ad=0.87 as=0.87 pd=6.58 ps=6.58 nrd=0.096666666666667 nrs=0.096666666666667 sa=0 sb=0 sd=0 mult=1 m=1
XMPPREF_m14_w1 ref_m14_w1 pcb_100 pref pref sky130_fd_pr__pfet_01v8 L=0.15 W=4 nf=1 ad=1.16 as=1.16 pd=8.58 ps=8.58 nrd=0.0725 nrs=0.0725 sa=0 sb=0 sd=0 mult=1 m=1   $ reference-side precharge: copy of MPPRE
XMN1_m14_w1 sbl_m14_w1 sref_m14_w1 vn_m14_w1 0 sky130_fd_pr__nfet_01v8 L=0.15 W=1 nf=1 ad=0.29 as=0.29 pd=2.58 ps=2.58 nrd=0.29 nrs=0.29 sa=0 sb=0 sd=0 mult=1 m=1
XMN2_m14_w1 sref_m14_w1 sbl_m14_w1 vn_m14_w1 0 sky130_fd_pr__nfet_01v8 L=0.15 W=1 nf=1 ad=0.29 as=0.29 pd=2.58 ps=2.58 nrd=0.29 nrs=0.29 sa=0 sb=0 sd=0 mult=1 m=1
XMP1_m14_w1 sbl_m14_w1 sref_m14_w1 vp_m14_w1 vdd sky130_fd_pr__pfet_01v8 L=0.15 W=2 nf=1 ad=0.58 as=0.58 pd=4.58 ps=4.58 nrd=0.145 nrs=0.145 sa=0 sb=0 sd=0 mult=1 m=1
XMP2_m14_w1 sref_m14_w1 sbl_m14_w1 vp_m14_w1 vdd sky130_fd_pr__pfet_01v8 L=0.15 W=2 nf=1 ad=0.58 as=0.58 pd=4.58 ps=4.58 nrd=0.145 nrs=0.145 sa=0 sb=0 sd=0 mult=1 m=1
XMNF_m14_w1 vn_m14_w1 en 0 0 sky130_fd_pr__nfet_01v8 L=0.15 W=2 nf=1 ad=0.58 as=0.58 pd=4.58 ps=4.58 nrd=0.145 nrs=0.145 sa=0 sb=0 sd=0 mult=1 m=1
XMPH_m14_w1 vp_m14_w1 enb vdd vdd sky130_fd_pr__pfet_01v8 L=0.15 W=4 nf=1 ad=1.16 as=1.16 pd=8.58 ps=8.58 nrd=0.0725 nrs=0.0725 sa=0 sb=0 sd=0 mult=1 m=1
bd_m14_w1 d_m14_w1 0 v=v(sbl_m14_w1)-v(sref_m14_w1)
bdabs_m14_w1 dabs_m14_w1 0 v=abs(v(sbl_m14_w1)-v(sref_m14_w1))

* ---- instance 63: m14_w0 (baseline TG, dummy 1.5x [matched ref precharge]) ----
XMWR_m14_w0_0 sn_m14_w0_0 wl wbl_m14_w0 0 sky130_fd_pr__nfet_01v8 L=0.15 W=0.42 nf=1 ad=0.1218 as=0.1218 pd=1.42 ps=1.42 nrd=0.69047619047619 nrs=0.69047619047619 sa=0 sb=0 sd=0 mult=1 m=1
XMRD_m14_w0_0 rbl_m14_w0 sn_m14_w0_0 rwl_sel 0 sky130_fd_pr__nfet_01v8 L=0.15 W=0.42 nf=1 ad=0.1218 as=0.1218 pd=1.42 ps=1.42 nrd=0.69047619047619 nrs=0.69047619047619 sa=0 sb=0 sd=0 mult=1 m=1
csn_m14_w0_0 sn_m14_w0_0 0 {C_SN}
XMWR_m14_w0_1 sn_m14_w0_1 0 wbl_m14_w0 0 sky130_fd_pr__nfet_01v8 L=0.15 W=0.42 nf=1 ad=0.1218 as=0.1218 pd=1.42 ps=1.42 nrd=0.69047619047619 nrs=0.69047619047619 sa=0 sb=0 sd=0 mult=1 m=1
XMRD_m14_w0_1 rbl_m14_w0 sn_m14_w0_1 rwl_des 0 sky130_fd_pr__nfet_01v8 L=0.15 W=0.42 nf=1 ad=0.1218 as=0.1218 pd=1.42 ps=1.42 nrd=0.69047619047619 nrs=0.69047619047619 sa=0 sb=0 sd=0 mult=1 m=1
csn_m14_w0_1 sn_m14_w0_1 0 {C_SN}
XMWR_m14_w0_2 sn_m14_w0_2 0 wbl_m14_w0 0 sky130_fd_pr__nfet_01v8 L=0.15 W=0.42 nf=1 ad=0.1218 as=0.1218 pd=1.42 ps=1.42 nrd=0.69047619047619 nrs=0.69047619047619 sa=0 sb=0 sd=0 mult=1 m=1
XMRD_m14_w0_2 rbl_m14_w0 sn_m14_w0_2 rwl_des 0 sky130_fd_pr__nfet_01v8 L=0.15 W=0.42 nf=1 ad=0.1218 as=0.1218 pd=1.42 ps=1.42 nrd=0.69047619047619 nrs=0.69047619047619 sa=0 sb=0 sd=0 mult=1 m=1
csn_m14_w0_2 sn_m14_w0_2 0 {C_SN}
XMWR_m14_w0_3 sn_m14_w0_3 0 wbl_m14_w0 0 sky130_fd_pr__nfet_01v8 L=0.15 W=0.42 nf=1 ad=0.1218 as=0.1218 pd=1.42 ps=1.42 nrd=0.69047619047619 nrs=0.69047619047619 sa=0 sb=0 sd=0 mult=1 m=1
XMRD_m14_w0_3 rbl_m14_w0 sn_m14_w0_3 rwl_des 0 sky130_fd_pr__nfet_01v8 L=0.15 W=0.42 nf=1 ad=0.1218 as=0.1218 pd=1.42 ps=1.42 nrd=0.69047619047619 nrs=0.69047619047619 sa=0 sb=0 sd=0 mult=1 m=1
csn_m14_w0_3 sn_m14_w0_3 0 {C_SN}
crbl_m14_w0 rbl_m14_w0 0 {C_RBL}
cwbl_m14_w0 wbl_m14_w0 0 {C_WBL}
cref_m14_w0 ref_m14_w0 0 {C_RBL}   $ ASSUMPTION: ideal matched dummy load
XMPPRE_m14_w0 rbl_m14_w0 pcb_100 prea prea sky130_fd_pr__pfet_01v8 L=0.15 W=4 nf=1 ad=1.16 as=1.16 pd=8.58 ps=8.58 nrd=0.0725 nrs=0.0725 sa=0 sb=0 sd=0 mult=1 m=1
XMPU1_m14_w0 x_m14_w0 dinb0 vdd vdd sky130_fd_pr__pfet_01v8 L=0.15 W=1 nf=1 ad=0.29 as=0.29 pd=2.58 ps=2.58 nrd=0.29 nrs=0.29 sa=0 sb=0 sd=0 mult=1 m=1
XMPU2_m14_w0 wbl_m14_w0 wenb x_m14_w0 vdd sky130_fd_pr__pfet_01v8 L=0.15 W=1 nf=1 ad=0.29 as=0.29 pd=2.58 ps=2.58 nrd=0.29 nrs=0.29 sa=0 sb=0 sd=0 mult=1 m=1
XMND2_m14_w0 wbl_m14_w0 wen y_m14_w0 0 sky130_fd_pr__nfet_01v8 L=0.15 W=0.5 nf=1 ad=0.145 as=0.145 pd=1.58 ps=1.58 nrd=0.58 nrs=0.58 sa=0 sb=0 sd=0 mult=1 m=1
XMND1_m14_w0 y_m14_w0 dinb0 0 0 sky130_fd_pr__nfet_01v8 L=0.15 W=0.5 nf=1 ad=0.145 as=0.145 pd=1.58 ps=1.58 nrd=0.58 nrs=0.58 sa=0 sb=0 sd=0 mult=1 m=1
XMNI_m14_w0 wbl_m14_w0 wenb 0 0 sky130_fd_pr__nfet_01v8 L=0.15 W=0.42 nf=1 ad=0.1218 as=0.1218 pd=1.42 ps=1.42 nrd=0.69047619047619 nrs=0.69047619047619 sa=0 sb=0 sd=0 mult=1 m=1
XMNS_m14_w0 sbl_m14_w0 sel_69500 rbl_m14_w0 0 sky130_fd_pr__nfet_01v8 L=0.15 W=1 nf=1 ad=0.29 as=0.29 pd=2.58 ps=2.58 nrd=0.29 nrs=0.29 sa=0 sb=0 sd=0 mult=1 m=1
XMPS_m14_w0 sbl_m14_w0 selb_69500 rbl_m14_w0 vdd sky130_fd_pr__pfet_01v8 L=0.15 W=2 nf=1 ad=0.58 as=0.58 pd=4.58 ps=4.58 nrd=0.145 nrs=0.145 sa=0 sb=0 sd=0 mult=1 m=1
XMNSR_m14_w0 sref_m14_w0 sel_69500 ref_m14_w0 0 sky130_fd_pr__nfet_01v8 L=0.15 W=1.5 nf=1 ad=0.435 as=0.435 pd=3.58 ps=3.58 nrd=0.19333333333333 nrs=0.19333333333333 sa=0 sb=0 sd=0 mult=1 m=1
XMPSR_m14_w0 sref_m14_w0 selb_69500 ref_m14_w0 vdd sky130_fd_pr__pfet_01v8 L=0.15 W=3 nf=1 ad=0.87 as=0.87 pd=6.58 ps=6.58 nrd=0.096666666666667 nrs=0.096666666666667 sa=0 sb=0 sd=0 mult=1 m=1
XMPPREF_m14_w0 ref_m14_w0 pcb_100 pref pref sky130_fd_pr__pfet_01v8 L=0.15 W=4 nf=1 ad=1.16 as=1.16 pd=8.58 ps=8.58 nrd=0.0725 nrs=0.0725 sa=0 sb=0 sd=0 mult=1 m=1   $ reference-side precharge: copy of MPPRE
XMN1_m14_w0 sbl_m14_w0 sref_m14_w0 vn_m14_w0 0 sky130_fd_pr__nfet_01v8 L=0.15 W=1 nf=1 ad=0.29 as=0.29 pd=2.58 ps=2.58 nrd=0.29 nrs=0.29 sa=0 sb=0 sd=0 mult=1 m=1
XMN2_m14_w0 sref_m14_w0 sbl_m14_w0 vn_m14_w0 0 sky130_fd_pr__nfet_01v8 L=0.15 W=1 nf=1 ad=0.29 as=0.29 pd=2.58 ps=2.58 nrd=0.29 nrs=0.29 sa=0 sb=0 sd=0 mult=1 m=1
XMP1_m14_w0 sbl_m14_w0 sref_m14_w0 vp_m14_w0 vdd sky130_fd_pr__pfet_01v8 L=0.15 W=2 nf=1 ad=0.58 as=0.58 pd=4.58 ps=4.58 nrd=0.145 nrs=0.145 sa=0 sb=0 sd=0 mult=1 m=1
XMP2_m14_w0 sref_m14_w0 sbl_m14_w0 vp_m14_w0 vdd sky130_fd_pr__pfet_01v8 L=0.15 W=2 nf=1 ad=0.58 as=0.58 pd=4.58 ps=4.58 nrd=0.145 nrs=0.145 sa=0 sb=0 sd=0 mult=1 m=1
XMNF_m14_w0 vn_m14_w0 en 0 0 sky130_fd_pr__nfet_01v8 L=0.15 W=2 nf=1 ad=0.58 as=0.58 pd=4.58 ps=4.58 nrd=0.145 nrs=0.145 sa=0 sb=0 sd=0 mult=1 m=1
XMPH_m14_w0 vp_m14_w0 enb vdd vdd sky130_fd_pr__pfet_01v8 L=0.15 W=4 nf=1 ad=1.16 as=1.16 pd=8.58 ps=8.58 nrd=0.0725 nrs=0.0725 sa=0 sb=0 sd=0 mult=1 m=1
bd_m14_w0 d_m14_w0 0 v=v(sbl_m14_w0)-v(sref_m14_w0)
bdabs_m14_w0 dabs_m14_w0 0 v=abs(v(sbl_m14_w0)-v(sref_m14_w0))

* ---- instance 64: m15_w1 (TG 0.42 / 0.84, +5 fF on sbl and sref [matched ref precharge]) ----
XMWR_m15_w1_0 sn_m15_w1_0 wl wbl_m15_w1 0 sky130_fd_pr__nfet_01v8 L=0.15 W=0.42 nf=1 ad=0.1218 as=0.1218 pd=1.42 ps=1.42 nrd=0.69047619047619 nrs=0.69047619047619 sa=0 sb=0 sd=0 mult=1 m=1
XMRD_m15_w1_0 rbl_m15_w1 sn_m15_w1_0 rwl_sel 0 sky130_fd_pr__nfet_01v8 L=0.15 W=0.42 nf=1 ad=0.1218 as=0.1218 pd=1.42 ps=1.42 nrd=0.69047619047619 nrs=0.69047619047619 sa=0 sb=0 sd=0 mult=1 m=1
csn_m15_w1_0 sn_m15_w1_0 0 {C_SN}
XMWR_m15_w1_1 sn_m15_w1_1 0 wbl_m15_w1 0 sky130_fd_pr__nfet_01v8 L=0.15 W=0.42 nf=1 ad=0.1218 as=0.1218 pd=1.42 ps=1.42 nrd=0.69047619047619 nrs=0.69047619047619 sa=0 sb=0 sd=0 mult=1 m=1
XMRD_m15_w1_1 rbl_m15_w1 sn_m15_w1_1 rwl_des 0 sky130_fd_pr__nfet_01v8 L=0.15 W=0.42 nf=1 ad=0.1218 as=0.1218 pd=1.42 ps=1.42 nrd=0.69047619047619 nrs=0.69047619047619 sa=0 sb=0 sd=0 mult=1 m=1
csn_m15_w1_1 sn_m15_w1_1 0 {C_SN}
XMWR_m15_w1_2 sn_m15_w1_2 0 wbl_m15_w1 0 sky130_fd_pr__nfet_01v8 L=0.15 W=0.42 nf=1 ad=0.1218 as=0.1218 pd=1.42 ps=1.42 nrd=0.69047619047619 nrs=0.69047619047619 sa=0 sb=0 sd=0 mult=1 m=1
XMRD_m15_w1_2 rbl_m15_w1 sn_m15_w1_2 rwl_des 0 sky130_fd_pr__nfet_01v8 L=0.15 W=0.42 nf=1 ad=0.1218 as=0.1218 pd=1.42 ps=1.42 nrd=0.69047619047619 nrs=0.69047619047619 sa=0 sb=0 sd=0 mult=1 m=1
csn_m15_w1_2 sn_m15_w1_2 0 {C_SN}
XMWR_m15_w1_3 sn_m15_w1_3 0 wbl_m15_w1 0 sky130_fd_pr__nfet_01v8 L=0.15 W=0.42 nf=1 ad=0.1218 as=0.1218 pd=1.42 ps=1.42 nrd=0.69047619047619 nrs=0.69047619047619 sa=0 sb=0 sd=0 mult=1 m=1
XMRD_m15_w1_3 rbl_m15_w1 sn_m15_w1_3 rwl_des 0 sky130_fd_pr__nfet_01v8 L=0.15 W=0.42 nf=1 ad=0.1218 as=0.1218 pd=1.42 ps=1.42 nrd=0.69047619047619 nrs=0.69047619047619 sa=0 sb=0 sd=0 mult=1 m=1
csn_m15_w1_3 sn_m15_w1_3 0 {C_SN}
crbl_m15_w1 rbl_m15_w1 0 {C_RBL}
cwbl_m15_w1 wbl_m15_w1 0 {C_WBL}
cref_m15_w1 ref_m15_w1 0 {C_RBL}   $ ASSUMPTION: ideal matched dummy load
XMPPRE_m15_w1 rbl_m15_w1 pcb_100 prea prea sky130_fd_pr__pfet_01v8 L=0.15 W=4 nf=1 ad=1.16 as=1.16 pd=8.58 ps=8.58 nrd=0.0725 nrs=0.0725 sa=0 sb=0 sd=0 mult=1 m=1
XMPU1_m15_w1 x_m15_w1 dinb1 vdd vdd sky130_fd_pr__pfet_01v8 L=0.15 W=1 nf=1 ad=0.29 as=0.29 pd=2.58 ps=2.58 nrd=0.29 nrs=0.29 sa=0 sb=0 sd=0 mult=1 m=1
XMPU2_m15_w1 wbl_m15_w1 wenb x_m15_w1 vdd sky130_fd_pr__pfet_01v8 L=0.15 W=1 nf=1 ad=0.29 as=0.29 pd=2.58 ps=2.58 nrd=0.29 nrs=0.29 sa=0 sb=0 sd=0 mult=1 m=1
XMND2_m15_w1 wbl_m15_w1 wen y_m15_w1 0 sky130_fd_pr__nfet_01v8 L=0.15 W=0.5 nf=1 ad=0.145 as=0.145 pd=1.58 ps=1.58 nrd=0.58 nrs=0.58 sa=0 sb=0 sd=0 mult=1 m=1
XMND1_m15_w1 y_m15_w1 dinb1 0 0 sky130_fd_pr__nfet_01v8 L=0.15 W=0.5 nf=1 ad=0.145 as=0.145 pd=1.58 ps=1.58 nrd=0.58 nrs=0.58 sa=0 sb=0 sd=0 mult=1 m=1
XMNI_m15_w1 wbl_m15_w1 wenb 0 0 sky130_fd_pr__nfet_01v8 L=0.15 W=0.42 nf=1 ad=0.1218 as=0.1218 pd=1.42 ps=1.42 nrd=0.69047619047619 nrs=0.69047619047619 sa=0 sb=0 sd=0 mult=1 m=1
XMNS_m15_w1 sbl_m15_w1 sel_69500 rbl_m15_w1 0 sky130_fd_pr__nfet_01v8 L=0.15 W=0.42 nf=1 ad=0.1218 as=0.1218 pd=1.42 ps=1.42 nrd=0.69047619047619 nrs=0.69047619047619 sa=0 sb=0 sd=0 mult=1 m=1
XMPS_m15_w1 sbl_m15_w1 selb_69500 rbl_m15_w1 vdd sky130_fd_pr__pfet_01v8 L=0.15 W=0.84 nf=1 ad=0.2436 as=0.2436 pd=2.26 ps=2.26 nrd=0.3452380952381 nrs=0.3452380952381 sa=0 sb=0 sd=0 mult=1 m=1
XMNSR_m15_w1 sref_m15_w1 sel_69500 ref_m15_w1 0 sky130_fd_pr__nfet_01v8 L=0.15 W=0.42 nf=1 ad=0.1218 as=0.1218 pd=1.42 ps=1.42 nrd=0.69047619047619 nrs=0.69047619047619 sa=0 sb=0 sd=0 mult=1 m=1
XMPSR_m15_w1 sref_m15_w1 selb_69500 ref_m15_w1 vdd sky130_fd_pr__pfet_01v8 L=0.15 W=0.84 nf=1 ad=0.2436 as=0.2436 pd=2.26 ps=2.26 nrd=0.3452380952381 nrs=0.3452380952381 sa=0 sb=0 sd=0 mult=1 m=1
XMPPREF_m15_w1 ref_m15_w1 pcb_100 pref pref sky130_fd_pr__pfet_01v8 L=0.15 W=4 nf=1 ad=1.16 as=1.16 pd=8.58 ps=8.58 nrd=0.0725 nrs=0.0725 sa=0 sb=0 sd=0 mult=1 m=1   $ reference-side precharge: copy of MPPRE
csb_m15_w1 sbl_m15_w1 0 5e-15   $ STUDY option: extra latch-input hold capacitance
csr_m15_w1 sref_m15_w1 0 5e-15
XMN1_m15_w1 sbl_m15_w1 sref_m15_w1 vn_m15_w1 0 sky130_fd_pr__nfet_01v8 L=0.15 W=1 nf=1 ad=0.29 as=0.29 pd=2.58 ps=2.58 nrd=0.29 nrs=0.29 sa=0 sb=0 sd=0 mult=1 m=1
XMN2_m15_w1 sref_m15_w1 sbl_m15_w1 vn_m15_w1 0 sky130_fd_pr__nfet_01v8 L=0.15 W=1 nf=1 ad=0.29 as=0.29 pd=2.58 ps=2.58 nrd=0.29 nrs=0.29 sa=0 sb=0 sd=0 mult=1 m=1
XMP1_m15_w1 sbl_m15_w1 sref_m15_w1 vp_m15_w1 vdd sky130_fd_pr__pfet_01v8 L=0.15 W=2 nf=1 ad=0.58 as=0.58 pd=4.58 ps=4.58 nrd=0.145 nrs=0.145 sa=0 sb=0 sd=0 mult=1 m=1
XMP2_m15_w1 sref_m15_w1 sbl_m15_w1 vp_m15_w1 vdd sky130_fd_pr__pfet_01v8 L=0.15 W=2 nf=1 ad=0.58 as=0.58 pd=4.58 ps=4.58 nrd=0.145 nrs=0.145 sa=0 sb=0 sd=0 mult=1 m=1
XMNF_m15_w1 vn_m15_w1 en 0 0 sky130_fd_pr__nfet_01v8 L=0.15 W=2 nf=1 ad=0.58 as=0.58 pd=4.58 ps=4.58 nrd=0.145 nrs=0.145 sa=0 sb=0 sd=0 mult=1 m=1
XMPH_m15_w1 vp_m15_w1 enb vdd vdd sky130_fd_pr__pfet_01v8 L=0.15 W=4 nf=1 ad=1.16 as=1.16 pd=8.58 ps=8.58 nrd=0.0725 nrs=0.0725 sa=0 sb=0 sd=0 mult=1 m=1
bd_m15_w1 d_m15_w1 0 v=v(sbl_m15_w1)-v(sref_m15_w1)
bdabs_m15_w1 dabs_m15_w1 0 v=abs(v(sbl_m15_w1)-v(sref_m15_w1))

* ---- instance 65: m15_w0 (TG 0.42 / 0.84, +5 fF on sbl and sref [matched ref precharge]) ----
XMWR_m15_w0_0 sn_m15_w0_0 wl wbl_m15_w0 0 sky130_fd_pr__nfet_01v8 L=0.15 W=0.42 nf=1 ad=0.1218 as=0.1218 pd=1.42 ps=1.42 nrd=0.69047619047619 nrs=0.69047619047619 sa=0 sb=0 sd=0 mult=1 m=1
XMRD_m15_w0_0 rbl_m15_w0 sn_m15_w0_0 rwl_sel 0 sky130_fd_pr__nfet_01v8 L=0.15 W=0.42 nf=1 ad=0.1218 as=0.1218 pd=1.42 ps=1.42 nrd=0.69047619047619 nrs=0.69047619047619 sa=0 sb=0 sd=0 mult=1 m=1
csn_m15_w0_0 sn_m15_w0_0 0 {C_SN}
XMWR_m15_w0_1 sn_m15_w0_1 0 wbl_m15_w0 0 sky130_fd_pr__nfet_01v8 L=0.15 W=0.42 nf=1 ad=0.1218 as=0.1218 pd=1.42 ps=1.42 nrd=0.69047619047619 nrs=0.69047619047619 sa=0 sb=0 sd=0 mult=1 m=1
XMRD_m15_w0_1 rbl_m15_w0 sn_m15_w0_1 rwl_des 0 sky130_fd_pr__nfet_01v8 L=0.15 W=0.42 nf=1 ad=0.1218 as=0.1218 pd=1.42 ps=1.42 nrd=0.69047619047619 nrs=0.69047619047619 sa=0 sb=0 sd=0 mult=1 m=1
csn_m15_w0_1 sn_m15_w0_1 0 {C_SN}
XMWR_m15_w0_2 sn_m15_w0_2 0 wbl_m15_w0 0 sky130_fd_pr__nfet_01v8 L=0.15 W=0.42 nf=1 ad=0.1218 as=0.1218 pd=1.42 ps=1.42 nrd=0.69047619047619 nrs=0.69047619047619 sa=0 sb=0 sd=0 mult=1 m=1
XMRD_m15_w0_2 rbl_m15_w0 sn_m15_w0_2 rwl_des 0 sky130_fd_pr__nfet_01v8 L=0.15 W=0.42 nf=1 ad=0.1218 as=0.1218 pd=1.42 ps=1.42 nrd=0.69047619047619 nrs=0.69047619047619 sa=0 sb=0 sd=0 mult=1 m=1
csn_m15_w0_2 sn_m15_w0_2 0 {C_SN}
XMWR_m15_w0_3 sn_m15_w0_3 0 wbl_m15_w0 0 sky130_fd_pr__nfet_01v8 L=0.15 W=0.42 nf=1 ad=0.1218 as=0.1218 pd=1.42 ps=1.42 nrd=0.69047619047619 nrs=0.69047619047619 sa=0 sb=0 sd=0 mult=1 m=1
XMRD_m15_w0_3 rbl_m15_w0 sn_m15_w0_3 rwl_des 0 sky130_fd_pr__nfet_01v8 L=0.15 W=0.42 nf=1 ad=0.1218 as=0.1218 pd=1.42 ps=1.42 nrd=0.69047619047619 nrs=0.69047619047619 sa=0 sb=0 sd=0 mult=1 m=1
csn_m15_w0_3 sn_m15_w0_3 0 {C_SN}
crbl_m15_w0 rbl_m15_w0 0 {C_RBL}
cwbl_m15_w0 wbl_m15_w0 0 {C_WBL}
cref_m15_w0 ref_m15_w0 0 {C_RBL}   $ ASSUMPTION: ideal matched dummy load
XMPPRE_m15_w0 rbl_m15_w0 pcb_100 prea prea sky130_fd_pr__pfet_01v8 L=0.15 W=4 nf=1 ad=1.16 as=1.16 pd=8.58 ps=8.58 nrd=0.0725 nrs=0.0725 sa=0 sb=0 sd=0 mult=1 m=1
XMPU1_m15_w0 x_m15_w0 dinb0 vdd vdd sky130_fd_pr__pfet_01v8 L=0.15 W=1 nf=1 ad=0.29 as=0.29 pd=2.58 ps=2.58 nrd=0.29 nrs=0.29 sa=0 sb=0 sd=0 mult=1 m=1
XMPU2_m15_w0 wbl_m15_w0 wenb x_m15_w0 vdd sky130_fd_pr__pfet_01v8 L=0.15 W=1 nf=1 ad=0.29 as=0.29 pd=2.58 ps=2.58 nrd=0.29 nrs=0.29 sa=0 sb=0 sd=0 mult=1 m=1
XMND2_m15_w0 wbl_m15_w0 wen y_m15_w0 0 sky130_fd_pr__nfet_01v8 L=0.15 W=0.5 nf=1 ad=0.145 as=0.145 pd=1.58 ps=1.58 nrd=0.58 nrs=0.58 sa=0 sb=0 sd=0 mult=1 m=1
XMND1_m15_w0 y_m15_w0 dinb0 0 0 sky130_fd_pr__nfet_01v8 L=0.15 W=0.5 nf=1 ad=0.145 as=0.145 pd=1.58 ps=1.58 nrd=0.58 nrs=0.58 sa=0 sb=0 sd=0 mult=1 m=1
XMNI_m15_w0 wbl_m15_w0 wenb 0 0 sky130_fd_pr__nfet_01v8 L=0.15 W=0.42 nf=1 ad=0.1218 as=0.1218 pd=1.42 ps=1.42 nrd=0.69047619047619 nrs=0.69047619047619 sa=0 sb=0 sd=0 mult=1 m=1
XMNS_m15_w0 sbl_m15_w0 sel_69500 rbl_m15_w0 0 sky130_fd_pr__nfet_01v8 L=0.15 W=0.42 nf=1 ad=0.1218 as=0.1218 pd=1.42 ps=1.42 nrd=0.69047619047619 nrs=0.69047619047619 sa=0 sb=0 sd=0 mult=1 m=1
XMPS_m15_w0 sbl_m15_w0 selb_69500 rbl_m15_w0 vdd sky130_fd_pr__pfet_01v8 L=0.15 W=0.84 nf=1 ad=0.2436 as=0.2436 pd=2.26 ps=2.26 nrd=0.3452380952381 nrs=0.3452380952381 sa=0 sb=0 sd=0 mult=1 m=1
XMNSR_m15_w0 sref_m15_w0 sel_69500 ref_m15_w0 0 sky130_fd_pr__nfet_01v8 L=0.15 W=0.42 nf=1 ad=0.1218 as=0.1218 pd=1.42 ps=1.42 nrd=0.69047619047619 nrs=0.69047619047619 sa=0 sb=0 sd=0 mult=1 m=1
XMPSR_m15_w0 sref_m15_w0 selb_69500 ref_m15_w0 vdd sky130_fd_pr__pfet_01v8 L=0.15 W=0.84 nf=1 ad=0.2436 as=0.2436 pd=2.26 ps=2.26 nrd=0.3452380952381 nrs=0.3452380952381 sa=0 sb=0 sd=0 mult=1 m=1
XMPPREF_m15_w0 ref_m15_w0 pcb_100 pref pref sky130_fd_pr__pfet_01v8 L=0.15 W=4 nf=1 ad=1.16 as=1.16 pd=8.58 ps=8.58 nrd=0.0725 nrs=0.0725 sa=0 sb=0 sd=0 mult=1 m=1   $ reference-side precharge: copy of MPPRE
csb_m15_w0 sbl_m15_w0 0 5e-15   $ STUDY option: extra latch-input hold capacitance
csr_m15_w0 sref_m15_w0 0 5e-15
XMN1_m15_w0 sbl_m15_w0 sref_m15_w0 vn_m15_w0 0 sky130_fd_pr__nfet_01v8 L=0.15 W=1 nf=1 ad=0.29 as=0.29 pd=2.58 ps=2.58 nrd=0.29 nrs=0.29 sa=0 sb=0 sd=0 mult=1 m=1
XMN2_m15_w0 sref_m15_w0 sbl_m15_w0 vn_m15_w0 0 sky130_fd_pr__nfet_01v8 L=0.15 W=1 nf=1 ad=0.29 as=0.29 pd=2.58 ps=2.58 nrd=0.29 nrs=0.29 sa=0 sb=0 sd=0 mult=1 m=1
XMP1_m15_w0 sbl_m15_w0 sref_m15_w0 vp_m15_w0 vdd sky130_fd_pr__pfet_01v8 L=0.15 W=2 nf=1 ad=0.58 as=0.58 pd=4.58 ps=4.58 nrd=0.145 nrs=0.145 sa=0 sb=0 sd=0 mult=1 m=1
XMP2_m15_w0 sref_m15_w0 sbl_m15_w0 vp_m15_w0 vdd sky130_fd_pr__pfet_01v8 L=0.15 W=2 nf=1 ad=0.58 as=0.58 pd=4.58 ps=4.58 nrd=0.145 nrs=0.145 sa=0 sb=0 sd=0 mult=1 m=1
XMNF_m15_w0 vn_m15_w0 en 0 0 sky130_fd_pr__nfet_01v8 L=0.15 W=2 nf=1 ad=0.58 as=0.58 pd=4.58 ps=4.58 nrd=0.145 nrs=0.145 sa=0 sb=0 sd=0 mult=1 m=1
XMPH_m15_w0 vp_m15_w0 enb vdd vdd sky130_fd_pr__pfet_01v8 L=0.15 W=4 nf=1 ad=1.16 as=1.16 pd=8.58 ps=8.58 nrd=0.0725 nrs=0.0725 sa=0 sb=0 sd=0 mult=1 m=1
bd_m15_w0 d_m15_w0 0 v=v(sbl_m15_w0)-v(sref_m15_w0)
bdabs_m15_w0 dabs_m15_w0 0 v=abs(v(sbl_m15_w0)-v(sref_m15_w0))

* ---- instance 66: p00_w1 (ref-side precharge = matched copy of MPPRE) ----
XMWR_p00_w1_0 sn_p00_w1_0 wl wbl_p00_w1 0 sky130_fd_pr__nfet_01v8 L=0.15 W=0.42 nf=1 ad=0.1218 as=0.1218 pd=1.42 ps=1.42 nrd=0.69047619047619 nrs=0.69047619047619 sa=0 sb=0 sd=0 mult=1 m=1
XMRD_p00_w1_0 rbl_p00_w1 sn_p00_w1_0 rwl_sel 0 sky130_fd_pr__nfet_01v8 L=0.15 W=0.42 nf=1 ad=0.1218 as=0.1218 pd=1.42 ps=1.42 nrd=0.69047619047619 nrs=0.69047619047619 sa=0 sb=0 sd=0 mult=1 m=1
csn_p00_w1_0 sn_p00_w1_0 0 {C_SN}
XMWR_p00_w1_1 sn_p00_w1_1 0 wbl_p00_w1 0 sky130_fd_pr__nfet_01v8 L=0.15 W=0.42 nf=1 ad=0.1218 as=0.1218 pd=1.42 ps=1.42 nrd=0.69047619047619 nrs=0.69047619047619 sa=0 sb=0 sd=0 mult=1 m=1
XMRD_p00_w1_1 rbl_p00_w1 sn_p00_w1_1 rwl_des 0 sky130_fd_pr__nfet_01v8 L=0.15 W=0.42 nf=1 ad=0.1218 as=0.1218 pd=1.42 ps=1.42 nrd=0.69047619047619 nrs=0.69047619047619 sa=0 sb=0 sd=0 mult=1 m=1
csn_p00_w1_1 sn_p00_w1_1 0 {C_SN}
XMWR_p00_w1_2 sn_p00_w1_2 0 wbl_p00_w1 0 sky130_fd_pr__nfet_01v8 L=0.15 W=0.42 nf=1 ad=0.1218 as=0.1218 pd=1.42 ps=1.42 nrd=0.69047619047619 nrs=0.69047619047619 sa=0 sb=0 sd=0 mult=1 m=1
XMRD_p00_w1_2 rbl_p00_w1 sn_p00_w1_2 rwl_des 0 sky130_fd_pr__nfet_01v8 L=0.15 W=0.42 nf=1 ad=0.1218 as=0.1218 pd=1.42 ps=1.42 nrd=0.69047619047619 nrs=0.69047619047619 sa=0 sb=0 sd=0 mult=1 m=1
csn_p00_w1_2 sn_p00_w1_2 0 {C_SN}
XMWR_p00_w1_3 sn_p00_w1_3 0 wbl_p00_w1 0 sky130_fd_pr__nfet_01v8 L=0.15 W=0.42 nf=1 ad=0.1218 as=0.1218 pd=1.42 ps=1.42 nrd=0.69047619047619 nrs=0.69047619047619 sa=0 sb=0 sd=0 mult=1 m=1
XMRD_p00_w1_3 rbl_p00_w1 sn_p00_w1_3 rwl_des 0 sky130_fd_pr__nfet_01v8 L=0.15 W=0.42 nf=1 ad=0.1218 as=0.1218 pd=1.42 ps=1.42 nrd=0.69047619047619 nrs=0.69047619047619 sa=0 sb=0 sd=0 mult=1 m=1
csn_p00_w1_3 sn_p00_w1_3 0 {C_SN}
crbl_p00_w1 rbl_p00_w1 0 {C_RBL}
cwbl_p00_w1 wbl_p00_w1 0 {C_WBL}
cref_p00_w1 ref_p00_w1 0 {C_RBL}   $ ASSUMPTION: ideal matched dummy load
XMPPRE_p00_w1 rbl_p00_w1 pcb_100 prea prea sky130_fd_pr__pfet_01v8 L=0.15 W=4 nf=1 ad=1.16 as=1.16 pd=8.58 ps=8.58 nrd=0.0725 nrs=0.0725 sa=0 sb=0 sd=0 mult=1 m=1
XMPU1_p00_w1 x_p00_w1 dinb1 vdd vdd sky130_fd_pr__pfet_01v8 L=0.15 W=1 nf=1 ad=0.29 as=0.29 pd=2.58 ps=2.58 nrd=0.29 nrs=0.29 sa=0 sb=0 sd=0 mult=1 m=1
XMPU2_p00_w1 wbl_p00_w1 wenb x_p00_w1 vdd sky130_fd_pr__pfet_01v8 L=0.15 W=1 nf=1 ad=0.29 as=0.29 pd=2.58 ps=2.58 nrd=0.29 nrs=0.29 sa=0 sb=0 sd=0 mult=1 m=1
XMND2_p00_w1 wbl_p00_w1 wen y_p00_w1 0 sky130_fd_pr__nfet_01v8 L=0.15 W=0.5 nf=1 ad=0.145 as=0.145 pd=1.58 ps=1.58 nrd=0.58 nrs=0.58 sa=0 sb=0 sd=0 mult=1 m=1
XMND1_p00_w1 y_p00_w1 dinb1 0 0 sky130_fd_pr__nfet_01v8 L=0.15 W=0.5 nf=1 ad=0.145 as=0.145 pd=1.58 ps=1.58 nrd=0.58 nrs=0.58 sa=0 sb=0 sd=0 mult=1 m=1
XMNI_p00_w1 wbl_p00_w1 wenb 0 0 sky130_fd_pr__nfet_01v8 L=0.15 W=0.42 nf=1 ad=0.1218 as=0.1218 pd=1.42 ps=1.42 nrd=0.69047619047619 nrs=0.69047619047619 sa=0 sb=0 sd=0 mult=1 m=1
XMNS_p00_w1 sbl_p00_w1 sel_69500 rbl_p00_w1 0 sky130_fd_pr__nfet_01v8 L=0.15 W=1 nf=1 ad=0.29 as=0.29 pd=2.58 ps=2.58 nrd=0.29 nrs=0.29 sa=0 sb=0 sd=0 mult=1 m=1
XMPS_p00_w1 sbl_p00_w1 selb_69500 rbl_p00_w1 vdd sky130_fd_pr__pfet_01v8 L=0.15 W=2 nf=1 ad=0.58 as=0.58 pd=4.58 ps=4.58 nrd=0.145 nrs=0.145 sa=0 sb=0 sd=0 mult=1 m=1
XMNSR_p00_w1 sref_p00_w1 sel_69500 ref_p00_w1 0 sky130_fd_pr__nfet_01v8 L=0.15 W=1 nf=1 ad=0.29 as=0.29 pd=2.58 ps=2.58 nrd=0.29 nrs=0.29 sa=0 sb=0 sd=0 mult=1 m=1
XMPSR_p00_w1 sref_p00_w1 selb_69500 ref_p00_w1 vdd sky130_fd_pr__pfet_01v8 L=0.15 W=2 nf=1 ad=0.58 as=0.58 pd=4.58 ps=4.58 nrd=0.145 nrs=0.145 sa=0 sb=0 sd=0 mult=1 m=1
XMPPREF_p00_w1 ref_p00_w1 pcb_100 pref pref sky130_fd_pr__pfet_01v8 L=0.15 W=4 nf=1 ad=1.16 as=1.16 pd=8.58 ps=8.58 nrd=0.0725 nrs=0.0725 sa=0 sb=0 sd=0 mult=1 m=1   $ reference-side precharge: copy of MPPRE
XMN1_p00_w1 sbl_p00_w1 sref_p00_w1 vn_p00_w1 0 sky130_fd_pr__nfet_01v8 L=0.15 W=1 nf=1 ad=0.29 as=0.29 pd=2.58 ps=2.58 nrd=0.29 nrs=0.29 sa=0 sb=0 sd=0 mult=1 m=1
XMN2_p00_w1 sref_p00_w1 sbl_p00_w1 vn_p00_w1 0 sky130_fd_pr__nfet_01v8 L=0.15 W=1 nf=1 ad=0.29 as=0.29 pd=2.58 ps=2.58 nrd=0.29 nrs=0.29 sa=0 sb=0 sd=0 mult=1 m=1
XMP1_p00_w1 sbl_p00_w1 sref_p00_w1 vp_p00_w1 vdd sky130_fd_pr__pfet_01v8 L=0.15 W=2 nf=1 ad=0.58 as=0.58 pd=4.58 ps=4.58 nrd=0.145 nrs=0.145 sa=0 sb=0 sd=0 mult=1 m=1
XMP2_p00_w1 sref_p00_w1 sbl_p00_w1 vp_p00_w1 vdd sky130_fd_pr__pfet_01v8 L=0.15 W=2 nf=1 ad=0.58 as=0.58 pd=4.58 ps=4.58 nrd=0.145 nrs=0.145 sa=0 sb=0 sd=0 mult=1 m=1
XMNF_p00_w1 vn_p00_w1 en 0 0 sky130_fd_pr__nfet_01v8 L=0.15 W=2 nf=1 ad=0.58 as=0.58 pd=4.58 ps=4.58 nrd=0.145 nrs=0.145 sa=0 sb=0 sd=0 mult=1 m=1
XMPH_p00_w1 vp_p00_w1 enb vdd vdd sky130_fd_pr__pfet_01v8 L=0.15 W=4 nf=1 ad=1.16 as=1.16 pd=8.58 ps=8.58 nrd=0.0725 nrs=0.0725 sa=0 sb=0 sd=0 mult=1 m=1
bd_p00_w1 d_p00_w1 0 v=v(sbl_p00_w1)-v(sref_p00_w1)
bdabs_p00_w1 dabs_p00_w1 0 v=abs(v(sbl_p00_w1)-v(sref_p00_w1))

* ---- instance 67: p00_w0 (ref-side precharge = matched copy of MPPRE) ----
XMWR_p00_w0_0 sn_p00_w0_0 wl wbl_p00_w0 0 sky130_fd_pr__nfet_01v8 L=0.15 W=0.42 nf=1 ad=0.1218 as=0.1218 pd=1.42 ps=1.42 nrd=0.69047619047619 nrs=0.69047619047619 sa=0 sb=0 sd=0 mult=1 m=1
XMRD_p00_w0_0 rbl_p00_w0 sn_p00_w0_0 rwl_sel 0 sky130_fd_pr__nfet_01v8 L=0.15 W=0.42 nf=1 ad=0.1218 as=0.1218 pd=1.42 ps=1.42 nrd=0.69047619047619 nrs=0.69047619047619 sa=0 sb=0 sd=0 mult=1 m=1
csn_p00_w0_0 sn_p00_w0_0 0 {C_SN}
XMWR_p00_w0_1 sn_p00_w0_1 0 wbl_p00_w0 0 sky130_fd_pr__nfet_01v8 L=0.15 W=0.42 nf=1 ad=0.1218 as=0.1218 pd=1.42 ps=1.42 nrd=0.69047619047619 nrs=0.69047619047619 sa=0 sb=0 sd=0 mult=1 m=1
XMRD_p00_w0_1 rbl_p00_w0 sn_p00_w0_1 rwl_des 0 sky130_fd_pr__nfet_01v8 L=0.15 W=0.42 nf=1 ad=0.1218 as=0.1218 pd=1.42 ps=1.42 nrd=0.69047619047619 nrs=0.69047619047619 sa=0 sb=0 sd=0 mult=1 m=1
csn_p00_w0_1 sn_p00_w0_1 0 {C_SN}
XMWR_p00_w0_2 sn_p00_w0_2 0 wbl_p00_w0 0 sky130_fd_pr__nfet_01v8 L=0.15 W=0.42 nf=1 ad=0.1218 as=0.1218 pd=1.42 ps=1.42 nrd=0.69047619047619 nrs=0.69047619047619 sa=0 sb=0 sd=0 mult=1 m=1
XMRD_p00_w0_2 rbl_p00_w0 sn_p00_w0_2 rwl_des 0 sky130_fd_pr__nfet_01v8 L=0.15 W=0.42 nf=1 ad=0.1218 as=0.1218 pd=1.42 ps=1.42 nrd=0.69047619047619 nrs=0.69047619047619 sa=0 sb=0 sd=0 mult=1 m=1
csn_p00_w0_2 sn_p00_w0_2 0 {C_SN}
XMWR_p00_w0_3 sn_p00_w0_3 0 wbl_p00_w0 0 sky130_fd_pr__nfet_01v8 L=0.15 W=0.42 nf=1 ad=0.1218 as=0.1218 pd=1.42 ps=1.42 nrd=0.69047619047619 nrs=0.69047619047619 sa=0 sb=0 sd=0 mult=1 m=1
XMRD_p00_w0_3 rbl_p00_w0 sn_p00_w0_3 rwl_des 0 sky130_fd_pr__nfet_01v8 L=0.15 W=0.42 nf=1 ad=0.1218 as=0.1218 pd=1.42 ps=1.42 nrd=0.69047619047619 nrs=0.69047619047619 sa=0 sb=0 sd=0 mult=1 m=1
csn_p00_w0_3 sn_p00_w0_3 0 {C_SN}
crbl_p00_w0 rbl_p00_w0 0 {C_RBL}
cwbl_p00_w0 wbl_p00_w0 0 {C_WBL}
cref_p00_w0 ref_p00_w0 0 {C_RBL}   $ ASSUMPTION: ideal matched dummy load
XMPPRE_p00_w0 rbl_p00_w0 pcb_100 prea prea sky130_fd_pr__pfet_01v8 L=0.15 W=4 nf=1 ad=1.16 as=1.16 pd=8.58 ps=8.58 nrd=0.0725 nrs=0.0725 sa=0 sb=0 sd=0 mult=1 m=1
XMPU1_p00_w0 x_p00_w0 dinb0 vdd vdd sky130_fd_pr__pfet_01v8 L=0.15 W=1 nf=1 ad=0.29 as=0.29 pd=2.58 ps=2.58 nrd=0.29 nrs=0.29 sa=0 sb=0 sd=0 mult=1 m=1
XMPU2_p00_w0 wbl_p00_w0 wenb x_p00_w0 vdd sky130_fd_pr__pfet_01v8 L=0.15 W=1 nf=1 ad=0.29 as=0.29 pd=2.58 ps=2.58 nrd=0.29 nrs=0.29 sa=0 sb=0 sd=0 mult=1 m=1
XMND2_p00_w0 wbl_p00_w0 wen y_p00_w0 0 sky130_fd_pr__nfet_01v8 L=0.15 W=0.5 nf=1 ad=0.145 as=0.145 pd=1.58 ps=1.58 nrd=0.58 nrs=0.58 sa=0 sb=0 sd=0 mult=1 m=1
XMND1_p00_w0 y_p00_w0 dinb0 0 0 sky130_fd_pr__nfet_01v8 L=0.15 W=0.5 nf=1 ad=0.145 as=0.145 pd=1.58 ps=1.58 nrd=0.58 nrs=0.58 sa=0 sb=0 sd=0 mult=1 m=1
XMNI_p00_w0 wbl_p00_w0 wenb 0 0 sky130_fd_pr__nfet_01v8 L=0.15 W=0.42 nf=1 ad=0.1218 as=0.1218 pd=1.42 ps=1.42 nrd=0.69047619047619 nrs=0.69047619047619 sa=0 sb=0 sd=0 mult=1 m=1
XMNS_p00_w0 sbl_p00_w0 sel_69500 rbl_p00_w0 0 sky130_fd_pr__nfet_01v8 L=0.15 W=1 nf=1 ad=0.29 as=0.29 pd=2.58 ps=2.58 nrd=0.29 nrs=0.29 sa=0 sb=0 sd=0 mult=1 m=1
XMPS_p00_w0 sbl_p00_w0 selb_69500 rbl_p00_w0 vdd sky130_fd_pr__pfet_01v8 L=0.15 W=2 nf=1 ad=0.58 as=0.58 pd=4.58 ps=4.58 nrd=0.145 nrs=0.145 sa=0 sb=0 sd=0 mult=1 m=1
XMNSR_p00_w0 sref_p00_w0 sel_69500 ref_p00_w0 0 sky130_fd_pr__nfet_01v8 L=0.15 W=1 nf=1 ad=0.29 as=0.29 pd=2.58 ps=2.58 nrd=0.29 nrs=0.29 sa=0 sb=0 sd=0 mult=1 m=1
XMPSR_p00_w0 sref_p00_w0 selb_69500 ref_p00_w0 vdd sky130_fd_pr__pfet_01v8 L=0.15 W=2 nf=1 ad=0.58 as=0.58 pd=4.58 ps=4.58 nrd=0.145 nrs=0.145 sa=0 sb=0 sd=0 mult=1 m=1
XMPPREF_p00_w0 ref_p00_w0 pcb_100 pref pref sky130_fd_pr__pfet_01v8 L=0.15 W=4 nf=1 ad=1.16 as=1.16 pd=8.58 ps=8.58 nrd=0.0725 nrs=0.0725 sa=0 sb=0 sd=0 mult=1 m=1   $ reference-side precharge: copy of MPPRE
XMN1_p00_w0 sbl_p00_w0 sref_p00_w0 vn_p00_w0 0 sky130_fd_pr__nfet_01v8 L=0.15 W=1 nf=1 ad=0.29 as=0.29 pd=2.58 ps=2.58 nrd=0.29 nrs=0.29 sa=0 sb=0 sd=0 mult=1 m=1
XMN2_p00_w0 sref_p00_w0 sbl_p00_w0 vn_p00_w0 0 sky130_fd_pr__nfet_01v8 L=0.15 W=1 nf=1 ad=0.29 as=0.29 pd=2.58 ps=2.58 nrd=0.29 nrs=0.29 sa=0 sb=0 sd=0 mult=1 m=1
XMP1_p00_w0 sbl_p00_w0 sref_p00_w0 vp_p00_w0 vdd sky130_fd_pr__pfet_01v8 L=0.15 W=2 nf=1 ad=0.58 as=0.58 pd=4.58 ps=4.58 nrd=0.145 nrs=0.145 sa=0 sb=0 sd=0 mult=1 m=1
XMP2_p00_w0 sref_p00_w0 sbl_p00_w0 vp_p00_w0 vdd sky130_fd_pr__pfet_01v8 L=0.15 W=2 nf=1 ad=0.58 as=0.58 pd=4.58 ps=4.58 nrd=0.145 nrs=0.145 sa=0 sb=0 sd=0 mult=1 m=1
XMNF_p00_w0 vn_p00_w0 en 0 0 sky130_fd_pr__nfet_01v8 L=0.15 W=2 nf=1 ad=0.58 as=0.58 pd=4.58 ps=4.58 nrd=0.145 nrs=0.145 sa=0 sb=0 sd=0 mult=1 m=1
XMPH_p00_w0 vp_p00_w0 enb vdd vdd sky130_fd_pr__pfet_01v8 L=0.15 W=4 nf=1 ad=1.16 as=1.16 pd=8.58 ps=8.58 nrd=0.0725 nrs=0.0725 sa=0 sb=0 sd=0 mult=1 m=1
bd_p00_w0 d_p00_w0 0 v=v(sbl_p00_w0)-v(sref_p00_w0)
bdabs_p00_w0 dabs_p00_w0 0 v=abs(v(sbl_p00_w0)-v(sref_p00_w0))

* ---- instance 68: p01_w1 (matched ref precharge, MPPRE 2.0) ----
XMWR_p01_w1_0 sn_p01_w1_0 wl wbl_p01_w1 0 sky130_fd_pr__nfet_01v8 L=0.15 W=0.42 nf=1 ad=0.1218 as=0.1218 pd=1.42 ps=1.42 nrd=0.69047619047619 nrs=0.69047619047619 sa=0 sb=0 sd=0 mult=1 m=1
XMRD_p01_w1_0 rbl_p01_w1 sn_p01_w1_0 rwl_sel 0 sky130_fd_pr__nfet_01v8 L=0.15 W=0.42 nf=1 ad=0.1218 as=0.1218 pd=1.42 ps=1.42 nrd=0.69047619047619 nrs=0.69047619047619 sa=0 sb=0 sd=0 mult=1 m=1
csn_p01_w1_0 sn_p01_w1_0 0 {C_SN}
XMWR_p01_w1_1 sn_p01_w1_1 0 wbl_p01_w1 0 sky130_fd_pr__nfet_01v8 L=0.15 W=0.42 nf=1 ad=0.1218 as=0.1218 pd=1.42 ps=1.42 nrd=0.69047619047619 nrs=0.69047619047619 sa=0 sb=0 sd=0 mult=1 m=1
XMRD_p01_w1_1 rbl_p01_w1 sn_p01_w1_1 rwl_des 0 sky130_fd_pr__nfet_01v8 L=0.15 W=0.42 nf=1 ad=0.1218 as=0.1218 pd=1.42 ps=1.42 nrd=0.69047619047619 nrs=0.69047619047619 sa=0 sb=0 sd=0 mult=1 m=1
csn_p01_w1_1 sn_p01_w1_1 0 {C_SN}
XMWR_p01_w1_2 sn_p01_w1_2 0 wbl_p01_w1 0 sky130_fd_pr__nfet_01v8 L=0.15 W=0.42 nf=1 ad=0.1218 as=0.1218 pd=1.42 ps=1.42 nrd=0.69047619047619 nrs=0.69047619047619 sa=0 sb=0 sd=0 mult=1 m=1
XMRD_p01_w1_2 rbl_p01_w1 sn_p01_w1_2 rwl_des 0 sky130_fd_pr__nfet_01v8 L=0.15 W=0.42 nf=1 ad=0.1218 as=0.1218 pd=1.42 ps=1.42 nrd=0.69047619047619 nrs=0.69047619047619 sa=0 sb=0 sd=0 mult=1 m=1
csn_p01_w1_2 sn_p01_w1_2 0 {C_SN}
XMWR_p01_w1_3 sn_p01_w1_3 0 wbl_p01_w1 0 sky130_fd_pr__nfet_01v8 L=0.15 W=0.42 nf=1 ad=0.1218 as=0.1218 pd=1.42 ps=1.42 nrd=0.69047619047619 nrs=0.69047619047619 sa=0 sb=0 sd=0 mult=1 m=1
XMRD_p01_w1_3 rbl_p01_w1 sn_p01_w1_3 rwl_des 0 sky130_fd_pr__nfet_01v8 L=0.15 W=0.42 nf=1 ad=0.1218 as=0.1218 pd=1.42 ps=1.42 nrd=0.69047619047619 nrs=0.69047619047619 sa=0 sb=0 sd=0 mult=1 m=1
csn_p01_w1_3 sn_p01_w1_3 0 {C_SN}
crbl_p01_w1 rbl_p01_w1 0 {C_RBL}
cwbl_p01_w1 wbl_p01_w1 0 {C_WBL}
cref_p01_w1 ref_p01_w1 0 {C_RBL}   $ ASSUMPTION: ideal matched dummy load
XMPPRE_p01_w1 rbl_p01_w1 pcb_100 prea prea sky130_fd_pr__pfet_01v8 L=0.15 W=2 nf=1 ad=0.58 as=0.58 pd=4.58 ps=4.58 nrd=0.145 nrs=0.145 sa=0 sb=0 sd=0 mult=1 m=1
XMPU1_p01_w1 x_p01_w1 dinb1 vdd vdd sky130_fd_pr__pfet_01v8 L=0.15 W=1 nf=1 ad=0.29 as=0.29 pd=2.58 ps=2.58 nrd=0.29 nrs=0.29 sa=0 sb=0 sd=0 mult=1 m=1
XMPU2_p01_w1 wbl_p01_w1 wenb x_p01_w1 vdd sky130_fd_pr__pfet_01v8 L=0.15 W=1 nf=1 ad=0.29 as=0.29 pd=2.58 ps=2.58 nrd=0.29 nrs=0.29 sa=0 sb=0 sd=0 mult=1 m=1
XMND2_p01_w1 wbl_p01_w1 wen y_p01_w1 0 sky130_fd_pr__nfet_01v8 L=0.15 W=0.5 nf=1 ad=0.145 as=0.145 pd=1.58 ps=1.58 nrd=0.58 nrs=0.58 sa=0 sb=0 sd=0 mult=1 m=1
XMND1_p01_w1 y_p01_w1 dinb1 0 0 sky130_fd_pr__nfet_01v8 L=0.15 W=0.5 nf=1 ad=0.145 as=0.145 pd=1.58 ps=1.58 nrd=0.58 nrs=0.58 sa=0 sb=0 sd=0 mult=1 m=1
XMNI_p01_w1 wbl_p01_w1 wenb 0 0 sky130_fd_pr__nfet_01v8 L=0.15 W=0.42 nf=1 ad=0.1218 as=0.1218 pd=1.42 ps=1.42 nrd=0.69047619047619 nrs=0.69047619047619 sa=0 sb=0 sd=0 mult=1 m=1
XMNS_p01_w1 sbl_p01_w1 sel_69500 rbl_p01_w1 0 sky130_fd_pr__nfet_01v8 L=0.15 W=1 nf=1 ad=0.29 as=0.29 pd=2.58 ps=2.58 nrd=0.29 nrs=0.29 sa=0 sb=0 sd=0 mult=1 m=1
XMPS_p01_w1 sbl_p01_w1 selb_69500 rbl_p01_w1 vdd sky130_fd_pr__pfet_01v8 L=0.15 W=2 nf=1 ad=0.58 as=0.58 pd=4.58 ps=4.58 nrd=0.145 nrs=0.145 sa=0 sb=0 sd=0 mult=1 m=1
XMNSR_p01_w1 sref_p01_w1 sel_69500 ref_p01_w1 0 sky130_fd_pr__nfet_01v8 L=0.15 W=1 nf=1 ad=0.29 as=0.29 pd=2.58 ps=2.58 nrd=0.29 nrs=0.29 sa=0 sb=0 sd=0 mult=1 m=1
XMPSR_p01_w1 sref_p01_w1 selb_69500 ref_p01_w1 vdd sky130_fd_pr__pfet_01v8 L=0.15 W=2 nf=1 ad=0.58 as=0.58 pd=4.58 ps=4.58 nrd=0.145 nrs=0.145 sa=0 sb=0 sd=0 mult=1 m=1
XMPPREF_p01_w1 ref_p01_w1 pcb_100 pref pref sky130_fd_pr__pfet_01v8 L=0.15 W=2 nf=1 ad=0.58 as=0.58 pd=4.58 ps=4.58 nrd=0.145 nrs=0.145 sa=0 sb=0 sd=0 mult=1 m=1   $ reference-side precharge: copy of MPPRE
XMN1_p01_w1 sbl_p01_w1 sref_p01_w1 vn_p01_w1 0 sky130_fd_pr__nfet_01v8 L=0.15 W=1 nf=1 ad=0.29 as=0.29 pd=2.58 ps=2.58 nrd=0.29 nrs=0.29 sa=0 sb=0 sd=0 mult=1 m=1
XMN2_p01_w1 sref_p01_w1 sbl_p01_w1 vn_p01_w1 0 sky130_fd_pr__nfet_01v8 L=0.15 W=1 nf=1 ad=0.29 as=0.29 pd=2.58 ps=2.58 nrd=0.29 nrs=0.29 sa=0 sb=0 sd=0 mult=1 m=1
XMP1_p01_w1 sbl_p01_w1 sref_p01_w1 vp_p01_w1 vdd sky130_fd_pr__pfet_01v8 L=0.15 W=2 nf=1 ad=0.58 as=0.58 pd=4.58 ps=4.58 nrd=0.145 nrs=0.145 sa=0 sb=0 sd=0 mult=1 m=1
XMP2_p01_w1 sref_p01_w1 sbl_p01_w1 vp_p01_w1 vdd sky130_fd_pr__pfet_01v8 L=0.15 W=2 nf=1 ad=0.58 as=0.58 pd=4.58 ps=4.58 nrd=0.145 nrs=0.145 sa=0 sb=0 sd=0 mult=1 m=1
XMNF_p01_w1 vn_p01_w1 en 0 0 sky130_fd_pr__nfet_01v8 L=0.15 W=2 nf=1 ad=0.58 as=0.58 pd=4.58 ps=4.58 nrd=0.145 nrs=0.145 sa=0 sb=0 sd=0 mult=1 m=1
XMPH_p01_w1 vp_p01_w1 enb vdd vdd sky130_fd_pr__pfet_01v8 L=0.15 W=4 nf=1 ad=1.16 as=1.16 pd=8.58 ps=8.58 nrd=0.0725 nrs=0.0725 sa=0 sb=0 sd=0 mult=1 m=1
bd_p01_w1 d_p01_w1 0 v=v(sbl_p01_w1)-v(sref_p01_w1)
bdabs_p01_w1 dabs_p01_w1 0 v=abs(v(sbl_p01_w1)-v(sref_p01_w1))

* ---- instance 69: p01_w0 (matched ref precharge, MPPRE 2.0) ----
XMWR_p01_w0_0 sn_p01_w0_0 wl wbl_p01_w0 0 sky130_fd_pr__nfet_01v8 L=0.15 W=0.42 nf=1 ad=0.1218 as=0.1218 pd=1.42 ps=1.42 nrd=0.69047619047619 nrs=0.69047619047619 sa=0 sb=0 sd=0 mult=1 m=1
XMRD_p01_w0_0 rbl_p01_w0 sn_p01_w0_0 rwl_sel 0 sky130_fd_pr__nfet_01v8 L=0.15 W=0.42 nf=1 ad=0.1218 as=0.1218 pd=1.42 ps=1.42 nrd=0.69047619047619 nrs=0.69047619047619 sa=0 sb=0 sd=0 mult=1 m=1
csn_p01_w0_0 sn_p01_w0_0 0 {C_SN}
XMWR_p01_w0_1 sn_p01_w0_1 0 wbl_p01_w0 0 sky130_fd_pr__nfet_01v8 L=0.15 W=0.42 nf=1 ad=0.1218 as=0.1218 pd=1.42 ps=1.42 nrd=0.69047619047619 nrs=0.69047619047619 sa=0 sb=0 sd=0 mult=1 m=1
XMRD_p01_w0_1 rbl_p01_w0 sn_p01_w0_1 rwl_des 0 sky130_fd_pr__nfet_01v8 L=0.15 W=0.42 nf=1 ad=0.1218 as=0.1218 pd=1.42 ps=1.42 nrd=0.69047619047619 nrs=0.69047619047619 sa=0 sb=0 sd=0 mult=1 m=1
csn_p01_w0_1 sn_p01_w0_1 0 {C_SN}
XMWR_p01_w0_2 sn_p01_w0_2 0 wbl_p01_w0 0 sky130_fd_pr__nfet_01v8 L=0.15 W=0.42 nf=1 ad=0.1218 as=0.1218 pd=1.42 ps=1.42 nrd=0.69047619047619 nrs=0.69047619047619 sa=0 sb=0 sd=0 mult=1 m=1
XMRD_p01_w0_2 rbl_p01_w0 sn_p01_w0_2 rwl_des 0 sky130_fd_pr__nfet_01v8 L=0.15 W=0.42 nf=1 ad=0.1218 as=0.1218 pd=1.42 ps=1.42 nrd=0.69047619047619 nrs=0.69047619047619 sa=0 sb=0 sd=0 mult=1 m=1
csn_p01_w0_2 sn_p01_w0_2 0 {C_SN}
XMWR_p01_w0_3 sn_p01_w0_3 0 wbl_p01_w0 0 sky130_fd_pr__nfet_01v8 L=0.15 W=0.42 nf=1 ad=0.1218 as=0.1218 pd=1.42 ps=1.42 nrd=0.69047619047619 nrs=0.69047619047619 sa=0 sb=0 sd=0 mult=1 m=1
XMRD_p01_w0_3 rbl_p01_w0 sn_p01_w0_3 rwl_des 0 sky130_fd_pr__nfet_01v8 L=0.15 W=0.42 nf=1 ad=0.1218 as=0.1218 pd=1.42 ps=1.42 nrd=0.69047619047619 nrs=0.69047619047619 sa=0 sb=0 sd=0 mult=1 m=1
csn_p01_w0_3 sn_p01_w0_3 0 {C_SN}
crbl_p01_w0 rbl_p01_w0 0 {C_RBL}
cwbl_p01_w0 wbl_p01_w0 0 {C_WBL}
cref_p01_w0 ref_p01_w0 0 {C_RBL}   $ ASSUMPTION: ideal matched dummy load
XMPPRE_p01_w0 rbl_p01_w0 pcb_100 prea prea sky130_fd_pr__pfet_01v8 L=0.15 W=2 nf=1 ad=0.58 as=0.58 pd=4.58 ps=4.58 nrd=0.145 nrs=0.145 sa=0 sb=0 sd=0 mult=1 m=1
XMPU1_p01_w0 x_p01_w0 dinb0 vdd vdd sky130_fd_pr__pfet_01v8 L=0.15 W=1 nf=1 ad=0.29 as=0.29 pd=2.58 ps=2.58 nrd=0.29 nrs=0.29 sa=0 sb=0 sd=0 mult=1 m=1
XMPU2_p01_w0 wbl_p01_w0 wenb x_p01_w0 vdd sky130_fd_pr__pfet_01v8 L=0.15 W=1 nf=1 ad=0.29 as=0.29 pd=2.58 ps=2.58 nrd=0.29 nrs=0.29 sa=0 sb=0 sd=0 mult=1 m=1
XMND2_p01_w0 wbl_p01_w0 wen y_p01_w0 0 sky130_fd_pr__nfet_01v8 L=0.15 W=0.5 nf=1 ad=0.145 as=0.145 pd=1.58 ps=1.58 nrd=0.58 nrs=0.58 sa=0 sb=0 sd=0 mult=1 m=1
XMND1_p01_w0 y_p01_w0 dinb0 0 0 sky130_fd_pr__nfet_01v8 L=0.15 W=0.5 nf=1 ad=0.145 as=0.145 pd=1.58 ps=1.58 nrd=0.58 nrs=0.58 sa=0 sb=0 sd=0 mult=1 m=1
XMNI_p01_w0 wbl_p01_w0 wenb 0 0 sky130_fd_pr__nfet_01v8 L=0.15 W=0.42 nf=1 ad=0.1218 as=0.1218 pd=1.42 ps=1.42 nrd=0.69047619047619 nrs=0.69047619047619 sa=0 sb=0 sd=0 mult=1 m=1
XMNS_p01_w0 sbl_p01_w0 sel_69500 rbl_p01_w0 0 sky130_fd_pr__nfet_01v8 L=0.15 W=1 nf=1 ad=0.29 as=0.29 pd=2.58 ps=2.58 nrd=0.29 nrs=0.29 sa=0 sb=0 sd=0 mult=1 m=1
XMPS_p01_w0 sbl_p01_w0 selb_69500 rbl_p01_w0 vdd sky130_fd_pr__pfet_01v8 L=0.15 W=2 nf=1 ad=0.58 as=0.58 pd=4.58 ps=4.58 nrd=0.145 nrs=0.145 sa=0 sb=0 sd=0 mult=1 m=1
XMNSR_p01_w0 sref_p01_w0 sel_69500 ref_p01_w0 0 sky130_fd_pr__nfet_01v8 L=0.15 W=1 nf=1 ad=0.29 as=0.29 pd=2.58 ps=2.58 nrd=0.29 nrs=0.29 sa=0 sb=0 sd=0 mult=1 m=1
XMPSR_p01_w0 sref_p01_w0 selb_69500 ref_p01_w0 vdd sky130_fd_pr__pfet_01v8 L=0.15 W=2 nf=1 ad=0.58 as=0.58 pd=4.58 ps=4.58 nrd=0.145 nrs=0.145 sa=0 sb=0 sd=0 mult=1 m=1
XMPPREF_p01_w0 ref_p01_w0 pcb_100 pref pref sky130_fd_pr__pfet_01v8 L=0.15 W=2 nf=1 ad=0.58 as=0.58 pd=4.58 ps=4.58 nrd=0.145 nrs=0.145 sa=0 sb=0 sd=0 mult=1 m=1   $ reference-side precharge: copy of MPPRE
XMN1_p01_w0 sbl_p01_w0 sref_p01_w0 vn_p01_w0 0 sky130_fd_pr__nfet_01v8 L=0.15 W=1 nf=1 ad=0.29 as=0.29 pd=2.58 ps=2.58 nrd=0.29 nrs=0.29 sa=0 sb=0 sd=0 mult=1 m=1
XMN2_p01_w0 sref_p01_w0 sbl_p01_w0 vn_p01_w0 0 sky130_fd_pr__nfet_01v8 L=0.15 W=1 nf=1 ad=0.29 as=0.29 pd=2.58 ps=2.58 nrd=0.29 nrs=0.29 sa=0 sb=0 sd=0 mult=1 m=1
XMP1_p01_w0 sbl_p01_w0 sref_p01_w0 vp_p01_w0 vdd sky130_fd_pr__pfet_01v8 L=0.15 W=2 nf=1 ad=0.58 as=0.58 pd=4.58 ps=4.58 nrd=0.145 nrs=0.145 sa=0 sb=0 sd=0 mult=1 m=1
XMP2_p01_w0 sref_p01_w0 sbl_p01_w0 vp_p01_w0 vdd sky130_fd_pr__pfet_01v8 L=0.15 W=2 nf=1 ad=0.58 as=0.58 pd=4.58 ps=4.58 nrd=0.145 nrs=0.145 sa=0 sb=0 sd=0 mult=1 m=1
XMNF_p01_w0 vn_p01_w0 en 0 0 sky130_fd_pr__nfet_01v8 L=0.15 W=2 nf=1 ad=0.58 as=0.58 pd=4.58 ps=4.58 nrd=0.145 nrs=0.145 sa=0 sb=0 sd=0 mult=1 m=1
XMPH_p01_w0 vp_p01_w0 enb vdd vdd sky130_fd_pr__pfet_01v8 L=0.15 W=4 nf=1 ad=1.16 as=1.16 pd=8.58 ps=8.58 nrd=0.0725 nrs=0.0725 sa=0 sb=0 sd=0 mult=1 m=1
bd_p01_w0 d_p01_w0 0 v=v(sbl_p01_w0)-v(sref_p01_w0)
bdabs_p01_w0 dabs_p01_w0 0 v=abs(v(sbl_p01_w0)-v(sref_p01_w0))

* ---- instance 70: p02_w1 (ideal ref, MPPRE 2.0) ----
XMWR_p02_w1_0 sn_p02_w1_0 wl wbl_p02_w1 0 sky130_fd_pr__nfet_01v8 L=0.15 W=0.42 nf=1 ad=0.1218 as=0.1218 pd=1.42 ps=1.42 nrd=0.69047619047619 nrs=0.69047619047619 sa=0 sb=0 sd=0 mult=1 m=1
XMRD_p02_w1_0 rbl_p02_w1 sn_p02_w1_0 rwl_sel 0 sky130_fd_pr__nfet_01v8 L=0.15 W=0.42 nf=1 ad=0.1218 as=0.1218 pd=1.42 ps=1.42 nrd=0.69047619047619 nrs=0.69047619047619 sa=0 sb=0 sd=0 mult=1 m=1
csn_p02_w1_0 sn_p02_w1_0 0 {C_SN}
XMWR_p02_w1_1 sn_p02_w1_1 0 wbl_p02_w1 0 sky130_fd_pr__nfet_01v8 L=0.15 W=0.42 nf=1 ad=0.1218 as=0.1218 pd=1.42 ps=1.42 nrd=0.69047619047619 nrs=0.69047619047619 sa=0 sb=0 sd=0 mult=1 m=1
XMRD_p02_w1_1 rbl_p02_w1 sn_p02_w1_1 rwl_des 0 sky130_fd_pr__nfet_01v8 L=0.15 W=0.42 nf=1 ad=0.1218 as=0.1218 pd=1.42 ps=1.42 nrd=0.69047619047619 nrs=0.69047619047619 sa=0 sb=0 sd=0 mult=1 m=1
csn_p02_w1_1 sn_p02_w1_1 0 {C_SN}
XMWR_p02_w1_2 sn_p02_w1_2 0 wbl_p02_w1 0 sky130_fd_pr__nfet_01v8 L=0.15 W=0.42 nf=1 ad=0.1218 as=0.1218 pd=1.42 ps=1.42 nrd=0.69047619047619 nrs=0.69047619047619 sa=0 sb=0 sd=0 mult=1 m=1
XMRD_p02_w1_2 rbl_p02_w1 sn_p02_w1_2 rwl_des 0 sky130_fd_pr__nfet_01v8 L=0.15 W=0.42 nf=1 ad=0.1218 as=0.1218 pd=1.42 ps=1.42 nrd=0.69047619047619 nrs=0.69047619047619 sa=0 sb=0 sd=0 mult=1 m=1
csn_p02_w1_2 sn_p02_w1_2 0 {C_SN}
XMWR_p02_w1_3 sn_p02_w1_3 0 wbl_p02_w1 0 sky130_fd_pr__nfet_01v8 L=0.15 W=0.42 nf=1 ad=0.1218 as=0.1218 pd=1.42 ps=1.42 nrd=0.69047619047619 nrs=0.69047619047619 sa=0 sb=0 sd=0 mult=1 m=1
XMRD_p02_w1_3 rbl_p02_w1 sn_p02_w1_3 rwl_des 0 sky130_fd_pr__nfet_01v8 L=0.15 W=0.42 nf=1 ad=0.1218 as=0.1218 pd=1.42 ps=1.42 nrd=0.69047619047619 nrs=0.69047619047619 sa=0 sb=0 sd=0 mult=1 m=1
csn_p02_w1_3 sn_p02_w1_3 0 {C_SN}
crbl_p02_w1 rbl_p02_w1 0 {C_RBL}
cwbl_p02_w1 wbl_p02_w1 0 {C_WBL}
cref_p02_w1 ref_p02_w1 0 {C_RBL}   $ ASSUMPTION: ideal matched dummy load
spr_p02_w1 pref ref_p02_w1 pca 0 swpre   $ reference-side precharge: ideal switch (#114 convention)
XMPPRE_p02_w1 rbl_p02_w1 pcb_100 prea prea sky130_fd_pr__pfet_01v8 L=0.15 W=2 nf=1 ad=0.58 as=0.58 pd=4.58 ps=4.58 nrd=0.145 nrs=0.145 sa=0 sb=0 sd=0 mult=1 m=1
XMPU1_p02_w1 x_p02_w1 dinb1 vdd vdd sky130_fd_pr__pfet_01v8 L=0.15 W=1 nf=1 ad=0.29 as=0.29 pd=2.58 ps=2.58 nrd=0.29 nrs=0.29 sa=0 sb=0 sd=0 mult=1 m=1
XMPU2_p02_w1 wbl_p02_w1 wenb x_p02_w1 vdd sky130_fd_pr__pfet_01v8 L=0.15 W=1 nf=1 ad=0.29 as=0.29 pd=2.58 ps=2.58 nrd=0.29 nrs=0.29 sa=0 sb=0 sd=0 mult=1 m=1
XMND2_p02_w1 wbl_p02_w1 wen y_p02_w1 0 sky130_fd_pr__nfet_01v8 L=0.15 W=0.5 nf=1 ad=0.145 as=0.145 pd=1.58 ps=1.58 nrd=0.58 nrs=0.58 sa=0 sb=0 sd=0 mult=1 m=1
XMND1_p02_w1 y_p02_w1 dinb1 0 0 sky130_fd_pr__nfet_01v8 L=0.15 W=0.5 nf=1 ad=0.145 as=0.145 pd=1.58 ps=1.58 nrd=0.58 nrs=0.58 sa=0 sb=0 sd=0 mult=1 m=1
XMNI_p02_w1 wbl_p02_w1 wenb 0 0 sky130_fd_pr__nfet_01v8 L=0.15 W=0.42 nf=1 ad=0.1218 as=0.1218 pd=1.42 ps=1.42 nrd=0.69047619047619 nrs=0.69047619047619 sa=0 sb=0 sd=0 mult=1 m=1
XMNS_p02_w1 sbl_p02_w1 sel_69500 rbl_p02_w1 0 sky130_fd_pr__nfet_01v8 L=0.15 W=1 nf=1 ad=0.29 as=0.29 pd=2.58 ps=2.58 nrd=0.29 nrs=0.29 sa=0 sb=0 sd=0 mult=1 m=1
XMPS_p02_w1 sbl_p02_w1 selb_69500 rbl_p02_w1 vdd sky130_fd_pr__pfet_01v8 L=0.15 W=2 nf=1 ad=0.58 as=0.58 pd=4.58 ps=4.58 nrd=0.145 nrs=0.145 sa=0 sb=0 sd=0 mult=1 m=1
XMNSR_p02_w1 sref_p02_w1 sel_69500 ref_p02_w1 0 sky130_fd_pr__nfet_01v8 L=0.15 W=1 nf=1 ad=0.29 as=0.29 pd=2.58 ps=2.58 nrd=0.29 nrs=0.29 sa=0 sb=0 sd=0 mult=1 m=1
XMPSR_p02_w1 sref_p02_w1 selb_69500 ref_p02_w1 vdd sky130_fd_pr__pfet_01v8 L=0.15 W=2 nf=1 ad=0.58 as=0.58 pd=4.58 ps=4.58 nrd=0.145 nrs=0.145 sa=0 sb=0 sd=0 mult=1 m=1
XMN1_p02_w1 sbl_p02_w1 sref_p02_w1 vn_p02_w1 0 sky130_fd_pr__nfet_01v8 L=0.15 W=1 nf=1 ad=0.29 as=0.29 pd=2.58 ps=2.58 nrd=0.29 nrs=0.29 sa=0 sb=0 sd=0 mult=1 m=1
XMN2_p02_w1 sref_p02_w1 sbl_p02_w1 vn_p02_w1 0 sky130_fd_pr__nfet_01v8 L=0.15 W=1 nf=1 ad=0.29 as=0.29 pd=2.58 ps=2.58 nrd=0.29 nrs=0.29 sa=0 sb=0 sd=0 mult=1 m=1
XMP1_p02_w1 sbl_p02_w1 sref_p02_w1 vp_p02_w1 vdd sky130_fd_pr__pfet_01v8 L=0.15 W=2 nf=1 ad=0.58 as=0.58 pd=4.58 ps=4.58 nrd=0.145 nrs=0.145 sa=0 sb=0 sd=0 mult=1 m=1
XMP2_p02_w1 sref_p02_w1 sbl_p02_w1 vp_p02_w1 vdd sky130_fd_pr__pfet_01v8 L=0.15 W=2 nf=1 ad=0.58 as=0.58 pd=4.58 ps=4.58 nrd=0.145 nrs=0.145 sa=0 sb=0 sd=0 mult=1 m=1
XMNF_p02_w1 vn_p02_w1 en 0 0 sky130_fd_pr__nfet_01v8 L=0.15 W=2 nf=1 ad=0.58 as=0.58 pd=4.58 ps=4.58 nrd=0.145 nrs=0.145 sa=0 sb=0 sd=0 mult=1 m=1
XMPH_p02_w1 vp_p02_w1 enb vdd vdd sky130_fd_pr__pfet_01v8 L=0.15 W=4 nf=1 ad=1.16 as=1.16 pd=8.58 ps=8.58 nrd=0.0725 nrs=0.0725 sa=0 sb=0 sd=0 mult=1 m=1
bd_p02_w1 d_p02_w1 0 v=v(sbl_p02_w1)-v(sref_p02_w1)
bdabs_p02_w1 dabs_p02_w1 0 v=abs(v(sbl_p02_w1)-v(sref_p02_w1))

* ---- instance 71: p02_w0 (ideal ref, MPPRE 2.0) ----
XMWR_p02_w0_0 sn_p02_w0_0 wl wbl_p02_w0 0 sky130_fd_pr__nfet_01v8 L=0.15 W=0.42 nf=1 ad=0.1218 as=0.1218 pd=1.42 ps=1.42 nrd=0.69047619047619 nrs=0.69047619047619 sa=0 sb=0 sd=0 mult=1 m=1
XMRD_p02_w0_0 rbl_p02_w0 sn_p02_w0_0 rwl_sel 0 sky130_fd_pr__nfet_01v8 L=0.15 W=0.42 nf=1 ad=0.1218 as=0.1218 pd=1.42 ps=1.42 nrd=0.69047619047619 nrs=0.69047619047619 sa=0 sb=0 sd=0 mult=1 m=1
csn_p02_w0_0 sn_p02_w0_0 0 {C_SN}
XMWR_p02_w0_1 sn_p02_w0_1 0 wbl_p02_w0 0 sky130_fd_pr__nfet_01v8 L=0.15 W=0.42 nf=1 ad=0.1218 as=0.1218 pd=1.42 ps=1.42 nrd=0.69047619047619 nrs=0.69047619047619 sa=0 sb=0 sd=0 mult=1 m=1
XMRD_p02_w0_1 rbl_p02_w0 sn_p02_w0_1 rwl_des 0 sky130_fd_pr__nfet_01v8 L=0.15 W=0.42 nf=1 ad=0.1218 as=0.1218 pd=1.42 ps=1.42 nrd=0.69047619047619 nrs=0.69047619047619 sa=0 sb=0 sd=0 mult=1 m=1
csn_p02_w0_1 sn_p02_w0_1 0 {C_SN}
XMWR_p02_w0_2 sn_p02_w0_2 0 wbl_p02_w0 0 sky130_fd_pr__nfet_01v8 L=0.15 W=0.42 nf=1 ad=0.1218 as=0.1218 pd=1.42 ps=1.42 nrd=0.69047619047619 nrs=0.69047619047619 sa=0 sb=0 sd=0 mult=1 m=1
XMRD_p02_w0_2 rbl_p02_w0 sn_p02_w0_2 rwl_des 0 sky130_fd_pr__nfet_01v8 L=0.15 W=0.42 nf=1 ad=0.1218 as=0.1218 pd=1.42 ps=1.42 nrd=0.69047619047619 nrs=0.69047619047619 sa=0 sb=0 sd=0 mult=1 m=1
csn_p02_w0_2 sn_p02_w0_2 0 {C_SN}
XMWR_p02_w0_3 sn_p02_w0_3 0 wbl_p02_w0 0 sky130_fd_pr__nfet_01v8 L=0.15 W=0.42 nf=1 ad=0.1218 as=0.1218 pd=1.42 ps=1.42 nrd=0.69047619047619 nrs=0.69047619047619 sa=0 sb=0 sd=0 mult=1 m=1
XMRD_p02_w0_3 rbl_p02_w0 sn_p02_w0_3 rwl_des 0 sky130_fd_pr__nfet_01v8 L=0.15 W=0.42 nf=1 ad=0.1218 as=0.1218 pd=1.42 ps=1.42 nrd=0.69047619047619 nrs=0.69047619047619 sa=0 sb=0 sd=0 mult=1 m=1
csn_p02_w0_3 sn_p02_w0_3 0 {C_SN}
crbl_p02_w0 rbl_p02_w0 0 {C_RBL}
cwbl_p02_w0 wbl_p02_w0 0 {C_WBL}
cref_p02_w0 ref_p02_w0 0 {C_RBL}   $ ASSUMPTION: ideal matched dummy load
spr_p02_w0 pref ref_p02_w0 pca 0 swpre   $ reference-side precharge: ideal switch (#114 convention)
XMPPRE_p02_w0 rbl_p02_w0 pcb_100 prea prea sky130_fd_pr__pfet_01v8 L=0.15 W=2 nf=1 ad=0.58 as=0.58 pd=4.58 ps=4.58 nrd=0.145 nrs=0.145 sa=0 sb=0 sd=0 mult=1 m=1
XMPU1_p02_w0 x_p02_w0 dinb0 vdd vdd sky130_fd_pr__pfet_01v8 L=0.15 W=1 nf=1 ad=0.29 as=0.29 pd=2.58 ps=2.58 nrd=0.29 nrs=0.29 sa=0 sb=0 sd=0 mult=1 m=1
XMPU2_p02_w0 wbl_p02_w0 wenb x_p02_w0 vdd sky130_fd_pr__pfet_01v8 L=0.15 W=1 nf=1 ad=0.29 as=0.29 pd=2.58 ps=2.58 nrd=0.29 nrs=0.29 sa=0 sb=0 sd=0 mult=1 m=1
XMND2_p02_w0 wbl_p02_w0 wen y_p02_w0 0 sky130_fd_pr__nfet_01v8 L=0.15 W=0.5 nf=1 ad=0.145 as=0.145 pd=1.58 ps=1.58 nrd=0.58 nrs=0.58 sa=0 sb=0 sd=0 mult=1 m=1
XMND1_p02_w0 y_p02_w0 dinb0 0 0 sky130_fd_pr__nfet_01v8 L=0.15 W=0.5 nf=1 ad=0.145 as=0.145 pd=1.58 ps=1.58 nrd=0.58 nrs=0.58 sa=0 sb=0 sd=0 mult=1 m=1
XMNI_p02_w0 wbl_p02_w0 wenb 0 0 sky130_fd_pr__nfet_01v8 L=0.15 W=0.42 nf=1 ad=0.1218 as=0.1218 pd=1.42 ps=1.42 nrd=0.69047619047619 nrs=0.69047619047619 sa=0 sb=0 sd=0 mult=1 m=1
XMNS_p02_w0 sbl_p02_w0 sel_69500 rbl_p02_w0 0 sky130_fd_pr__nfet_01v8 L=0.15 W=1 nf=1 ad=0.29 as=0.29 pd=2.58 ps=2.58 nrd=0.29 nrs=0.29 sa=0 sb=0 sd=0 mult=1 m=1
XMPS_p02_w0 sbl_p02_w0 selb_69500 rbl_p02_w0 vdd sky130_fd_pr__pfet_01v8 L=0.15 W=2 nf=1 ad=0.58 as=0.58 pd=4.58 ps=4.58 nrd=0.145 nrs=0.145 sa=0 sb=0 sd=0 mult=1 m=1
XMNSR_p02_w0 sref_p02_w0 sel_69500 ref_p02_w0 0 sky130_fd_pr__nfet_01v8 L=0.15 W=1 nf=1 ad=0.29 as=0.29 pd=2.58 ps=2.58 nrd=0.29 nrs=0.29 sa=0 sb=0 sd=0 mult=1 m=1
XMPSR_p02_w0 sref_p02_w0 selb_69500 ref_p02_w0 vdd sky130_fd_pr__pfet_01v8 L=0.15 W=2 nf=1 ad=0.58 as=0.58 pd=4.58 ps=4.58 nrd=0.145 nrs=0.145 sa=0 sb=0 sd=0 mult=1 m=1
XMN1_p02_w0 sbl_p02_w0 sref_p02_w0 vn_p02_w0 0 sky130_fd_pr__nfet_01v8 L=0.15 W=1 nf=1 ad=0.29 as=0.29 pd=2.58 ps=2.58 nrd=0.29 nrs=0.29 sa=0 sb=0 sd=0 mult=1 m=1
XMN2_p02_w0 sref_p02_w0 sbl_p02_w0 vn_p02_w0 0 sky130_fd_pr__nfet_01v8 L=0.15 W=1 nf=1 ad=0.29 as=0.29 pd=2.58 ps=2.58 nrd=0.29 nrs=0.29 sa=0 sb=0 sd=0 mult=1 m=1
XMP1_p02_w0 sbl_p02_w0 sref_p02_w0 vp_p02_w0 vdd sky130_fd_pr__pfet_01v8 L=0.15 W=2 nf=1 ad=0.58 as=0.58 pd=4.58 ps=4.58 nrd=0.145 nrs=0.145 sa=0 sb=0 sd=0 mult=1 m=1
XMP2_p02_w0 sref_p02_w0 sbl_p02_w0 vp_p02_w0 vdd sky130_fd_pr__pfet_01v8 L=0.15 W=2 nf=1 ad=0.58 as=0.58 pd=4.58 ps=4.58 nrd=0.145 nrs=0.145 sa=0 sb=0 sd=0 mult=1 m=1
XMNF_p02_w0 vn_p02_w0 en 0 0 sky130_fd_pr__nfet_01v8 L=0.15 W=2 nf=1 ad=0.58 as=0.58 pd=4.58 ps=4.58 nrd=0.145 nrs=0.145 sa=0 sb=0 sd=0 mult=1 m=1
XMPH_p02_w0 vp_p02_w0 enb vdd vdd sky130_fd_pr__pfet_01v8 L=0.15 W=4 nf=1 ad=1.16 as=1.16 pd=8.58 ps=8.58 nrd=0.0725 nrs=0.0725 sa=0 sb=0 sd=0 mult=1 m=1
bd_p02_w0 d_p02_w0 0 v=v(sbl_p02_w0)-v(sref_p02_w0)
bdabs_p02_w0 dabs_p02_w0 0 v=abs(v(sbl_p02_w0)-v(sref_p02_w0))

* ---- instance 72: p03_w1 (ideal ref, MPPRE 1.0) ----
XMWR_p03_w1_0 sn_p03_w1_0 wl wbl_p03_w1 0 sky130_fd_pr__nfet_01v8 L=0.15 W=0.42 nf=1 ad=0.1218 as=0.1218 pd=1.42 ps=1.42 nrd=0.69047619047619 nrs=0.69047619047619 sa=0 sb=0 sd=0 mult=1 m=1
XMRD_p03_w1_0 rbl_p03_w1 sn_p03_w1_0 rwl_sel 0 sky130_fd_pr__nfet_01v8 L=0.15 W=0.42 nf=1 ad=0.1218 as=0.1218 pd=1.42 ps=1.42 nrd=0.69047619047619 nrs=0.69047619047619 sa=0 sb=0 sd=0 mult=1 m=1
csn_p03_w1_0 sn_p03_w1_0 0 {C_SN}
XMWR_p03_w1_1 sn_p03_w1_1 0 wbl_p03_w1 0 sky130_fd_pr__nfet_01v8 L=0.15 W=0.42 nf=1 ad=0.1218 as=0.1218 pd=1.42 ps=1.42 nrd=0.69047619047619 nrs=0.69047619047619 sa=0 sb=0 sd=0 mult=1 m=1
XMRD_p03_w1_1 rbl_p03_w1 sn_p03_w1_1 rwl_des 0 sky130_fd_pr__nfet_01v8 L=0.15 W=0.42 nf=1 ad=0.1218 as=0.1218 pd=1.42 ps=1.42 nrd=0.69047619047619 nrs=0.69047619047619 sa=0 sb=0 sd=0 mult=1 m=1
csn_p03_w1_1 sn_p03_w1_1 0 {C_SN}
XMWR_p03_w1_2 sn_p03_w1_2 0 wbl_p03_w1 0 sky130_fd_pr__nfet_01v8 L=0.15 W=0.42 nf=1 ad=0.1218 as=0.1218 pd=1.42 ps=1.42 nrd=0.69047619047619 nrs=0.69047619047619 sa=0 sb=0 sd=0 mult=1 m=1
XMRD_p03_w1_2 rbl_p03_w1 sn_p03_w1_2 rwl_des 0 sky130_fd_pr__nfet_01v8 L=0.15 W=0.42 nf=1 ad=0.1218 as=0.1218 pd=1.42 ps=1.42 nrd=0.69047619047619 nrs=0.69047619047619 sa=0 sb=0 sd=0 mult=1 m=1
csn_p03_w1_2 sn_p03_w1_2 0 {C_SN}
XMWR_p03_w1_3 sn_p03_w1_3 0 wbl_p03_w1 0 sky130_fd_pr__nfet_01v8 L=0.15 W=0.42 nf=1 ad=0.1218 as=0.1218 pd=1.42 ps=1.42 nrd=0.69047619047619 nrs=0.69047619047619 sa=0 sb=0 sd=0 mult=1 m=1
XMRD_p03_w1_3 rbl_p03_w1 sn_p03_w1_3 rwl_des 0 sky130_fd_pr__nfet_01v8 L=0.15 W=0.42 nf=1 ad=0.1218 as=0.1218 pd=1.42 ps=1.42 nrd=0.69047619047619 nrs=0.69047619047619 sa=0 sb=0 sd=0 mult=1 m=1
csn_p03_w1_3 sn_p03_w1_3 0 {C_SN}
crbl_p03_w1 rbl_p03_w1 0 {C_RBL}
cwbl_p03_w1 wbl_p03_w1 0 {C_WBL}
cref_p03_w1 ref_p03_w1 0 {C_RBL}   $ ASSUMPTION: ideal matched dummy load
spr_p03_w1 pref ref_p03_w1 pca 0 swpre   $ reference-side precharge: ideal switch (#114 convention)
XMPPRE_p03_w1 rbl_p03_w1 pcb_100 prea prea sky130_fd_pr__pfet_01v8 L=0.15 W=1 nf=1 ad=0.29 as=0.29 pd=2.58 ps=2.58 nrd=0.29 nrs=0.29 sa=0 sb=0 sd=0 mult=1 m=1
XMPU1_p03_w1 x_p03_w1 dinb1 vdd vdd sky130_fd_pr__pfet_01v8 L=0.15 W=1 nf=1 ad=0.29 as=0.29 pd=2.58 ps=2.58 nrd=0.29 nrs=0.29 sa=0 sb=0 sd=0 mult=1 m=1
XMPU2_p03_w1 wbl_p03_w1 wenb x_p03_w1 vdd sky130_fd_pr__pfet_01v8 L=0.15 W=1 nf=1 ad=0.29 as=0.29 pd=2.58 ps=2.58 nrd=0.29 nrs=0.29 sa=0 sb=0 sd=0 mult=1 m=1
XMND2_p03_w1 wbl_p03_w1 wen y_p03_w1 0 sky130_fd_pr__nfet_01v8 L=0.15 W=0.5 nf=1 ad=0.145 as=0.145 pd=1.58 ps=1.58 nrd=0.58 nrs=0.58 sa=0 sb=0 sd=0 mult=1 m=1
XMND1_p03_w1 y_p03_w1 dinb1 0 0 sky130_fd_pr__nfet_01v8 L=0.15 W=0.5 nf=1 ad=0.145 as=0.145 pd=1.58 ps=1.58 nrd=0.58 nrs=0.58 sa=0 sb=0 sd=0 mult=1 m=1
XMNI_p03_w1 wbl_p03_w1 wenb 0 0 sky130_fd_pr__nfet_01v8 L=0.15 W=0.42 nf=1 ad=0.1218 as=0.1218 pd=1.42 ps=1.42 nrd=0.69047619047619 nrs=0.69047619047619 sa=0 sb=0 sd=0 mult=1 m=1
XMNS_p03_w1 sbl_p03_w1 sel_69500 rbl_p03_w1 0 sky130_fd_pr__nfet_01v8 L=0.15 W=1 nf=1 ad=0.29 as=0.29 pd=2.58 ps=2.58 nrd=0.29 nrs=0.29 sa=0 sb=0 sd=0 mult=1 m=1
XMPS_p03_w1 sbl_p03_w1 selb_69500 rbl_p03_w1 vdd sky130_fd_pr__pfet_01v8 L=0.15 W=2 nf=1 ad=0.58 as=0.58 pd=4.58 ps=4.58 nrd=0.145 nrs=0.145 sa=0 sb=0 sd=0 mult=1 m=1
XMNSR_p03_w1 sref_p03_w1 sel_69500 ref_p03_w1 0 sky130_fd_pr__nfet_01v8 L=0.15 W=1 nf=1 ad=0.29 as=0.29 pd=2.58 ps=2.58 nrd=0.29 nrs=0.29 sa=0 sb=0 sd=0 mult=1 m=1
XMPSR_p03_w1 sref_p03_w1 selb_69500 ref_p03_w1 vdd sky130_fd_pr__pfet_01v8 L=0.15 W=2 nf=1 ad=0.58 as=0.58 pd=4.58 ps=4.58 nrd=0.145 nrs=0.145 sa=0 sb=0 sd=0 mult=1 m=1
XMN1_p03_w1 sbl_p03_w1 sref_p03_w1 vn_p03_w1 0 sky130_fd_pr__nfet_01v8 L=0.15 W=1 nf=1 ad=0.29 as=0.29 pd=2.58 ps=2.58 nrd=0.29 nrs=0.29 sa=0 sb=0 sd=0 mult=1 m=1
XMN2_p03_w1 sref_p03_w1 sbl_p03_w1 vn_p03_w1 0 sky130_fd_pr__nfet_01v8 L=0.15 W=1 nf=1 ad=0.29 as=0.29 pd=2.58 ps=2.58 nrd=0.29 nrs=0.29 sa=0 sb=0 sd=0 mult=1 m=1
XMP1_p03_w1 sbl_p03_w1 sref_p03_w1 vp_p03_w1 vdd sky130_fd_pr__pfet_01v8 L=0.15 W=2 nf=1 ad=0.58 as=0.58 pd=4.58 ps=4.58 nrd=0.145 nrs=0.145 sa=0 sb=0 sd=0 mult=1 m=1
XMP2_p03_w1 sref_p03_w1 sbl_p03_w1 vp_p03_w1 vdd sky130_fd_pr__pfet_01v8 L=0.15 W=2 nf=1 ad=0.58 as=0.58 pd=4.58 ps=4.58 nrd=0.145 nrs=0.145 sa=0 sb=0 sd=0 mult=1 m=1
XMNF_p03_w1 vn_p03_w1 en 0 0 sky130_fd_pr__nfet_01v8 L=0.15 W=2 nf=1 ad=0.58 as=0.58 pd=4.58 ps=4.58 nrd=0.145 nrs=0.145 sa=0 sb=0 sd=0 mult=1 m=1
XMPH_p03_w1 vp_p03_w1 enb vdd vdd sky130_fd_pr__pfet_01v8 L=0.15 W=4 nf=1 ad=1.16 as=1.16 pd=8.58 ps=8.58 nrd=0.0725 nrs=0.0725 sa=0 sb=0 sd=0 mult=1 m=1
bd_p03_w1 d_p03_w1 0 v=v(sbl_p03_w1)-v(sref_p03_w1)
bdabs_p03_w1 dabs_p03_w1 0 v=abs(v(sbl_p03_w1)-v(sref_p03_w1))

* ---- instance 73: p03_w0 (ideal ref, MPPRE 1.0) ----
XMWR_p03_w0_0 sn_p03_w0_0 wl wbl_p03_w0 0 sky130_fd_pr__nfet_01v8 L=0.15 W=0.42 nf=1 ad=0.1218 as=0.1218 pd=1.42 ps=1.42 nrd=0.69047619047619 nrs=0.69047619047619 sa=0 sb=0 sd=0 mult=1 m=1
XMRD_p03_w0_0 rbl_p03_w0 sn_p03_w0_0 rwl_sel 0 sky130_fd_pr__nfet_01v8 L=0.15 W=0.42 nf=1 ad=0.1218 as=0.1218 pd=1.42 ps=1.42 nrd=0.69047619047619 nrs=0.69047619047619 sa=0 sb=0 sd=0 mult=1 m=1
csn_p03_w0_0 sn_p03_w0_0 0 {C_SN}
XMWR_p03_w0_1 sn_p03_w0_1 0 wbl_p03_w0 0 sky130_fd_pr__nfet_01v8 L=0.15 W=0.42 nf=1 ad=0.1218 as=0.1218 pd=1.42 ps=1.42 nrd=0.69047619047619 nrs=0.69047619047619 sa=0 sb=0 sd=0 mult=1 m=1
XMRD_p03_w0_1 rbl_p03_w0 sn_p03_w0_1 rwl_des 0 sky130_fd_pr__nfet_01v8 L=0.15 W=0.42 nf=1 ad=0.1218 as=0.1218 pd=1.42 ps=1.42 nrd=0.69047619047619 nrs=0.69047619047619 sa=0 sb=0 sd=0 mult=1 m=1
csn_p03_w0_1 sn_p03_w0_1 0 {C_SN}
XMWR_p03_w0_2 sn_p03_w0_2 0 wbl_p03_w0 0 sky130_fd_pr__nfet_01v8 L=0.15 W=0.42 nf=1 ad=0.1218 as=0.1218 pd=1.42 ps=1.42 nrd=0.69047619047619 nrs=0.69047619047619 sa=0 sb=0 sd=0 mult=1 m=1
XMRD_p03_w0_2 rbl_p03_w0 sn_p03_w0_2 rwl_des 0 sky130_fd_pr__nfet_01v8 L=0.15 W=0.42 nf=1 ad=0.1218 as=0.1218 pd=1.42 ps=1.42 nrd=0.69047619047619 nrs=0.69047619047619 sa=0 sb=0 sd=0 mult=1 m=1
csn_p03_w0_2 sn_p03_w0_2 0 {C_SN}
XMWR_p03_w0_3 sn_p03_w0_3 0 wbl_p03_w0 0 sky130_fd_pr__nfet_01v8 L=0.15 W=0.42 nf=1 ad=0.1218 as=0.1218 pd=1.42 ps=1.42 nrd=0.69047619047619 nrs=0.69047619047619 sa=0 sb=0 sd=0 mult=1 m=1
XMRD_p03_w0_3 rbl_p03_w0 sn_p03_w0_3 rwl_des 0 sky130_fd_pr__nfet_01v8 L=0.15 W=0.42 nf=1 ad=0.1218 as=0.1218 pd=1.42 ps=1.42 nrd=0.69047619047619 nrs=0.69047619047619 sa=0 sb=0 sd=0 mult=1 m=1
csn_p03_w0_3 sn_p03_w0_3 0 {C_SN}
crbl_p03_w0 rbl_p03_w0 0 {C_RBL}
cwbl_p03_w0 wbl_p03_w0 0 {C_WBL}
cref_p03_w0 ref_p03_w0 0 {C_RBL}   $ ASSUMPTION: ideal matched dummy load
spr_p03_w0 pref ref_p03_w0 pca 0 swpre   $ reference-side precharge: ideal switch (#114 convention)
XMPPRE_p03_w0 rbl_p03_w0 pcb_100 prea prea sky130_fd_pr__pfet_01v8 L=0.15 W=1 nf=1 ad=0.29 as=0.29 pd=2.58 ps=2.58 nrd=0.29 nrs=0.29 sa=0 sb=0 sd=0 mult=1 m=1
XMPU1_p03_w0 x_p03_w0 dinb0 vdd vdd sky130_fd_pr__pfet_01v8 L=0.15 W=1 nf=1 ad=0.29 as=0.29 pd=2.58 ps=2.58 nrd=0.29 nrs=0.29 sa=0 sb=0 sd=0 mult=1 m=1
XMPU2_p03_w0 wbl_p03_w0 wenb x_p03_w0 vdd sky130_fd_pr__pfet_01v8 L=0.15 W=1 nf=1 ad=0.29 as=0.29 pd=2.58 ps=2.58 nrd=0.29 nrs=0.29 sa=0 sb=0 sd=0 mult=1 m=1
XMND2_p03_w0 wbl_p03_w0 wen y_p03_w0 0 sky130_fd_pr__nfet_01v8 L=0.15 W=0.5 nf=1 ad=0.145 as=0.145 pd=1.58 ps=1.58 nrd=0.58 nrs=0.58 sa=0 sb=0 sd=0 mult=1 m=1
XMND1_p03_w0 y_p03_w0 dinb0 0 0 sky130_fd_pr__nfet_01v8 L=0.15 W=0.5 nf=1 ad=0.145 as=0.145 pd=1.58 ps=1.58 nrd=0.58 nrs=0.58 sa=0 sb=0 sd=0 mult=1 m=1
XMNI_p03_w0 wbl_p03_w0 wenb 0 0 sky130_fd_pr__nfet_01v8 L=0.15 W=0.42 nf=1 ad=0.1218 as=0.1218 pd=1.42 ps=1.42 nrd=0.69047619047619 nrs=0.69047619047619 sa=0 sb=0 sd=0 mult=1 m=1
XMNS_p03_w0 sbl_p03_w0 sel_69500 rbl_p03_w0 0 sky130_fd_pr__nfet_01v8 L=0.15 W=1 nf=1 ad=0.29 as=0.29 pd=2.58 ps=2.58 nrd=0.29 nrs=0.29 sa=0 sb=0 sd=0 mult=1 m=1
XMPS_p03_w0 sbl_p03_w0 selb_69500 rbl_p03_w0 vdd sky130_fd_pr__pfet_01v8 L=0.15 W=2 nf=1 ad=0.58 as=0.58 pd=4.58 ps=4.58 nrd=0.145 nrs=0.145 sa=0 sb=0 sd=0 mult=1 m=1
XMNSR_p03_w0 sref_p03_w0 sel_69500 ref_p03_w0 0 sky130_fd_pr__nfet_01v8 L=0.15 W=1 nf=1 ad=0.29 as=0.29 pd=2.58 ps=2.58 nrd=0.29 nrs=0.29 sa=0 sb=0 sd=0 mult=1 m=1
XMPSR_p03_w0 sref_p03_w0 selb_69500 ref_p03_w0 vdd sky130_fd_pr__pfet_01v8 L=0.15 W=2 nf=1 ad=0.58 as=0.58 pd=4.58 ps=4.58 nrd=0.145 nrs=0.145 sa=0 sb=0 sd=0 mult=1 m=1
XMN1_p03_w0 sbl_p03_w0 sref_p03_w0 vn_p03_w0 0 sky130_fd_pr__nfet_01v8 L=0.15 W=1 nf=1 ad=0.29 as=0.29 pd=2.58 ps=2.58 nrd=0.29 nrs=0.29 sa=0 sb=0 sd=0 mult=1 m=1
XMN2_p03_w0 sref_p03_w0 sbl_p03_w0 vn_p03_w0 0 sky130_fd_pr__nfet_01v8 L=0.15 W=1 nf=1 ad=0.29 as=0.29 pd=2.58 ps=2.58 nrd=0.29 nrs=0.29 sa=0 sb=0 sd=0 mult=1 m=1
XMP1_p03_w0 sbl_p03_w0 sref_p03_w0 vp_p03_w0 vdd sky130_fd_pr__pfet_01v8 L=0.15 W=2 nf=1 ad=0.58 as=0.58 pd=4.58 ps=4.58 nrd=0.145 nrs=0.145 sa=0 sb=0 sd=0 mult=1 m=1
XMP2_p03_w0 sref_p03_w0 sbl_p03_w0 vp_p03_w0 vdd sky130_fd_pr__pfet_01v8 L=0.15 W=2 nf=1 ad=0.58 as=0.58 pd=4.58 ps=4.58 nrd=0.145 nrs=0.145 sa=0 sb=0 sd=0 mult=1 m=1
XMNF_p03_w0 vn_p03_w0 en 0 0 sky130_fd_pr__nfet_01v8 L=0.15 W=2 nf=1 ad=0.58 as=0.58 pd=4.58 ps=4.58 nrd=0.145 nrs=0.145 sa=0 sb=0 sd=0 mult=1 m=1
XMPH_p03_w0 vp_p03_w0 enb vdd vdd sky130_fd_pr__pfet_01v8 L=0.15 W=4 nf=1 ad=1.16 as=1.16 pd=8.58 ps=8.58 nrd=0.0725 nrs=0.0725 sa=0 sb=0 sd=0 mult=1 m=1
bd_p03_w0 d_p03_w0 0 v=v(sbl_p03_w0)-v(sref_p03_w0)
bdabs_p03_w0 dabs_p03_w0 0 v=abs(v(sbl_p03_w0)-v(sref_p03_w0))

* ---- instance 74: p04_w1 (ideal ref, dummy switch 0.5 x MPPRE) ----
XMWR_p04_w1_0 sn_p04_w1_0 wl wbl_p04_w1 0 sky130_fd_pr__nfet_01v8 L=0.15 W=0.42 nf=1 ad=0.1218 as=0.1218 pd=1.42 ps=1.42 nrd=0.69047619047619 nrs=0.69047619047619 sa=0 sb=0 sd=0 mult=1 m=1
XMRD_p04_w1_0 rbl_p04_w1 sn_p04_w1_0 rwl_sel 0 sky130_fd_pr__nfet_01v8 L=0.15 W=0.42 nf=1 ad=0.1218 as=0.1218 pd=1.42 ps=1.42 nrd=0.69047619047619 nrs=0.69047619047619 sa=0 sb=0 sd=0 mult=1 m=1
csn_p04_w1_0 sn_p04_w1_0 0 {C_SN}
XMWR_p04_w1_1 sn_p04_w1_1 0 wbl_p04_w1 0 sky130_fd_pr__nfet_01v8 L=0.15 W=0.42 nf=1 ad=0.1218 as=0.1218 pd=1.42 ps=1.42 nrd=0.69047619047619 nrs=0.69047619047619 sa=0 sb=0 sd=0 mult=1 m=1
XMRD_p04_w1_1 rbl_p04_w1 sn_p04_w1_1 rwl_des 0 sky130_fd_pr__nfet_01v8 L=0.15 W=0.42 nf=1 ad=0.1218 as=0.1218 pd=1.42 ps=1.42 nrd=0.69047619047619 nrs=0.69047619047619 sa=0 sb=0 sd=0 mult=1 m=1
csn_p04_w1_1 sn_p04_w1_1 0 {C_SN}
XMWR_p04_w1_2 sn_p04_w1_2 0 wbl_p04_w1 0 sky130_fd_pr__nfet_01v8 L=0.15 W=0.42 nf=1 ad=0.1218 as=0.1218 pd=1.42 ps=1.42 nrd=0.69047619047619 nrs=0.69047619047619 sa=0 sb=0 sd=0 mult=1 m=1
XMRD_p04_w1_2 rbl_p04_w1 sn_p04_w1_2 rwl_des 0 sky130_fd_pr__nfet_01v8 L=0.15 W=0.42 nf=1 ad=0.1218 as=0.1218 pd=1.42 ps=1.42 nrd=0.69047619047619 nrs=0.69047619047619 sa=0 sb=0 sd=0 mult=1 m=1
csn_p04_w1_2 sn_p04_w1_2 0 {C_SN}
XMWR_p04_w1_3 sn_p04_w1_3 0 wbl_p04_w1 0 sky130_fd_pr__nfet_01v8 L=0.15 W=0.42 nf=1 ad=0.1218 as=0.1218 pd=1.42 ps=1.42 nrd=0.69047619047619 nrs=0.69047619047619 sa=0 sb=0 sd=0 mult=1 m=1
XMRD_p04_w1_3 rbl_p04_w1 sn_p04_w1_3 rwl_des 0 sky130_fd_pr__nfet_01v8 L=0.15 W=0.42 nf=1 ad=0.1218 as=0.1218 pd=1.42 ps=1.42 nrd=0.69047619047619 nrs=0.69047619047619 sa=0 sb=0 sd=0 mult=1 m=1
csn_p04_w1_3 sn_p04_w1_3 0 {C_SN}
crbl_p04_w1 rbl_p04_w1 0 {C_RBL}
cwbl_p04_w1 wbl_p04_w1 0 {C_WBL}
cref_p04_w1 ref_p04_w1 0 {C_RBL}   $ ASSUMPTION: ideal matched dummy load
spr_p04_w1 pref ref_p04_w1 pca 0 swpre   $ reference-side precharge: ideal switch (#114 convention)
XMPPRE_p04_w1 rbl_p04_w1 pcb_100 prea prea sky130_fd_pr__pfet_01v8 L=0.15 W=4 nf=1 ad=1.16 as=1.16 pd=8.58 ps=8.58 nrd=0.0725 nrs=0.0725 sa=0 sb=0 sd=0 mult=1 m=1
XMPU1_p04_w1 x_p04_w1 dinb1 vdd vdd sky130_fd_pr__pfet_01v8 L=0.15 W=1 nf=1 ad=0.29 as=0.29 pd=2.58 ps=2.58 nrd=0.29 nrs=0.29 sa=0 sb=0 sd=0 mult=1 m=1
XMPU2_p04_w1 wbl_p04_w1 wenb x_p04_w1 vdd sky130_fd_pr__pfet_01v8 L=0.15 W=1 nf=1 ad=0.29 as=0.29 pd=2.58 ps=2.58 nrd=0.29 nrs=0.29 sa=0 sb=0 sd=0 mult=1 m=1
XMND2_p04_w1 wbl_p04_w1 wen y_p04_w1 0 sky130_fd_pr__nfet_01v8 L=0.15 W=0.5 nf=1 ad=0.145 as=0.145 pd=1.58 ps=1.58 nrd=0.58 nrs=0.58 sa=0 sb=0 sd=0 mult=1 m=1
XMND1_p04_w1 y_p04_w1 dinb1 0 0 sky130_fd_pr__nfet_01v8 L=0.15 W=0.5 nf=1 ad=0.145 as=0.145 pd=1.58 ps=1.58 nrd=0.58 nrs=0.58 sa=0 sb=0 sd=0 mult=1 m=1
XMNI_p04_w1 wbl_p04_w1 wenb 0 0 sky130_fd_pr__nfet_01v8 L=0.15 W=0.42 nf=1 ad=0.1218 as=0.1218 pd=1.42 ps=1.42 nrd=0.69047619047619 nrs=0.69047619047619 sa=0 sb=0 sd=0 mult=1 m=1
XMNS_p04_w1 sbl_p04_w1 sel_69500 rbl_p04_w1 0 sky130_fd_pr__nfet_01v8 L=0.15 W=1 nf=1 ad=0.29 as=0.29 pd=2.58 ps=2.58 nrd=0.29 nrs=0.29 sa=0 sb=0 sd=0 mult=1 m=1
XMPS_p04_w1 sbl_p04_w1 selb_69500 rbl_p04_w1 vdd sky130_fd_pr__pfet_01v8 L=0.15 W=2 nf=1 ad=0.58 as=0.58 pd=4.58 ps=4.58 nrd=0.145 nrs=0.145 sa=0 sb=0 sd=0 mult=1 m=1
XMNSR_p04_w1 sref_p04_w1 sel_69500 ref_p04_w1 0 sky130_fd_pr__nfet_01v8 L=0.15 W=1 nf=1 ad=0.29 as=0.29 pd=2.58 ps=2.58 nrd=0.29 nrs=0.29 sa=0 sb=0 sd=0 mult=1 m=1
XMPSR_p04_w1 sref_p04_w1 selb_69500 ref_p04_w1 vdd sky130_fd_pr__pfet_01v8 L=0.15 W=2 nf=1 ad=0.58 as=0.58 pd=4.58 ps=4.58 nrd=0.145 nrs=0.145 sa=0 sb=0 sd=0 mult=1 m=1
XMPDUM_p04_w1 rbl_p04_w1 pca_100 rbl_p04_w1 prea sky130_fd_pr__pfet_01v8 L=0.15 W=2 nf=1 ad=0.58 as=0.58 pd=4.58 ps=4.58 nrd=0.145 nrs=0.145 sa=0 sb=0 sd=0 mult=1 m=1   $ STUDY option: dummy switch, opposite-phase gate
XMN1_p04_w1 sbl_p04_w1 sref_p04_w1 vn_p04_w1 0 sky130_fd_pr__nfet_01v8 L=0.15 W=1 nf=1 ad=0.29 as=0.29 pd=2.58 ps=2.58 nrd=0.29 nrs=0.29 sa=0 sb=0 sd=0 mult=1 m=1
XMN2_p04_w1 sref_p04_w1 sbl_p04_w1 vn_p04_w1 0 sky130_fd_pr__nfet_01v8 L=0.15 W=1 nf=1 ad=0.29 as=0.29 pd=2.58 ps=2.58 nrd=0.29 nrs=0.29 sa=0 sb=0 sd=0 mult=1 m=1
XMP1_p04_w1 sbl_p04_w1 sref_p04_w1 vp_p04_w1 vdd sky130_fd_pr__pfet_01v8 L=0.15 W=2 nf=1 ad=0.58 as=0.58 pd=4.58 ps=4.58 nrd=0.145 nrs=0.145 sa=0 sb=0 sd=0 mult=1 m=1
XMP2_p04_w1 sref_p04_w1 sbl_p04_w1 vp_p04_w1 vdd sky130_fd_pr__pfet_01v8 L=0.15 W=2 nf=1 ad=0.58 as=0.58 pd=4.58 ps=4.58 nrd=0.145 nrs=0.145 sa=0 sb=0 sd=0 mult=1 m=1
XMNF_p04_w1 vn_p04_w1 en 0 0 sky130_fd_pr__nfet_01v8 L=0.15 W=2 nf=1 ad=0.58 as=0.58 pd=4.58 ps=4.58 nrd=0.145 nrs=0.145 sa=0 sb=0 sd=0 mult=1 m=1
XMPH_p04_w1 vp_p04_w1 enb vdd vdd sky130_fd_pr__pfet_01v8 L=0.15 W=4 nf=1 ad=1.16 as=1.16 pd=8.58 ps=8.58 nrd=0.0725 nrs=0.0725 sa=0 sb=0 sd=0 mult=1 m=1
bd_p04_w1 d_p04_w1 0 v=v(sbl_p04_w1)-v(sref_p04_w1)
bdabs_p04_w1 dabs_p04_w1 0 v=abs(v(sbl_p04_w1)-v(sref_p04_w1))

* ---- instance 75: p04_w0 (ideal ref, dummy switch 0.5 x MPPRE) ----
XMWR_p04_w0_0 sn_p04_w0_0 wl wbl_p04_w0 0 sky130_fd_pr__nfet_01v8 L=0.15 W=0.42 nf=1 ad=0.1218 as=0.1218 pd=1.42 ps=1.42 nrd=0.69047619047619 nrs=0.69047619047619 sa=0 sb=0 sd=0 mult=1 m=1
XMRD_p04_w0_0 rbl_p04_w0 sn_p04_w0_0 rwl_sel 0 sky130_fd_pr__nfet_01v8 L=0.15 W=0.42 nf=1 ad=0.1218 as=0.1218 pd=1.42 ps=1.42 nrd=0.69047619047619 nrs=0.69047619047619 sa=0 sb=0 sd=0 mult=1 m=1
csn_p04_w0_0 sn_p04_w0_0 0 {C_SN}
XMWR_p04_w0_1 sn_p04_w0_1 0 wbl_p04_w0 0 sky130_fd_pr__nfet_01v8 L=0.15 W=0.42 nf=1 ad=0.1218 as=0.1218 pd=1.42 ps=1.42 nrd=0.69047619047619 nrs=0.69047619047619 sa=0 sb=0 sd=0 mult=1 m=1
XMRD_p04_w0_1 rbl_p04_w0 sn_p04_w0_1 rwl_des 0 sky130_fd_pr__nfet_01v8 L=0.15 W=0.42 nf=1 ad=0.1218 as=0.1218 pd=1.42 ps=1.42 nrd=0.69047619047619 nrs=0.69047619047619 sa=0 sb=0 sd=0 mult=1 m=1
csn_p04_w0_1 sn_p04_w0_1 0 {C_SN}
XMWR_p04_w0_2 sn_p04_w0_2 0 wbl_p04_w0 0 sky130_fd_pr__nfet_01v8 L=0.15 W=0.42 nf=1 ad=0.1218 as=0.1218 pd=1.42 ps=1.42 nrd=0.69047619047619 nrs=0.69047619047619 sa=0 sb=0 sd=0 mult=1 m=1
XMRD_p04_w0_2 rbl_p04_w0 sn_p04_w0_2 rwl_des 0 sky130_fd_pr__nfet_01v8 L=0.15 W=0.42 nf=1 ad=0.1218 as=0.1218 pd=1.42 ps=1.42 nrd=0.69047619047619 nrs=0.69047619047619 sa=0 sb=0 sd=0 mult=1 m=1
csn_p04_w0_2 sn_p04_w0_2 0 {C_SN}
XMWR_p04_w0_3 sn_p04_w0_3 0 wbl_p04_w0 0 sky130_fd_pr__nfet_01v8 L=0.15 W=0.42 nf=1 ad=0.1218 as=0.1218 pd=1.42 ps=1.42 nrd=0.69047619047619 nrs=0.69047619047619 sa=0 sb=0 sd=0 mult=1 m=1
XMRD_p04_w0_3 rbl_p04_w0 sn_p04_w0_3 rwl_des 0 sky130_fd_pr__nfet_01v8 L=0.15 W=0.42 nf=1 ad=0.1218 as=0.1218 pd=1.42 ps=1.42 nrd=0.69047619047619 nrs=0.69047619047619 sa=0 sb=0 sd=0 mult=1 m=1
csn_p04_w0_3 sn_p04_w0_3 0 {C_SN}
crbl_p04_w0 rbl_p04_w0 0 {C_RBL}
cwbl_p04_w0 wbl_p04_w0 0 {C_WBL}
cref_p04_w0 ref_p04_w0 0 {C_RBL}   $ ASSUMPTION: ideal matched dummy load
spr_p04_w0 pref ref_p04_w0 pca 0 swpre   $ reference-side precharge: ideal switch (#114 convention)
XMPPRE_p04_w0 rbl_p04_w0 pcb_100 prea prea sky130_fd_pr__pfet_01v8 L=0.15 W=4 nf=1 ad=1.16 as=1.16 pd=8.58 ps=8.58 nrd=0.0725 nrs=0.0725 sa=0 sb=0 sd=0 mult=1 m=1
XMPU1_p04_w0 x_p04_w0 dinb0 vdd vdd sky130_fd_pr__pfet_01v8 L=0.15 W=1 nf=1 ad=0.29 as=0.29 pd=2.58 ps=2.58 nrd=0.29 nrs=0.29 sa=0 sb=0 sd=0 mult=1 m=1
XMPU2_p04_w0 wbl_p04_w0 wenb x_p04_w0 vdd sky130_fd_pr__pfet_01v8 L=0.15 W=1 nf=1 ad=0.29 as=0.29 pd=2.58 ps=2.58 nrd=0.29 nrs=0.29 sa=0 sb=0 sd=0 mult=1 m=1
XMND2_p04_w0 wbl_p04_w0 wen y_p04_w0 0 sky130_fd_pr__nfet_01v8 L=0.15 W=0.5 nf=1 ad=0.145 as=0.145 pd=1.58 ps=1.58 nrd=0.58 nrs=0.58 sa=0 sb=0 sd=0 mult=1 m=1
XMND1_p04_w0 y_p04_w0 dinb0 0 0 sky130_fd_pr__nfet_01v8 L=0.15 W=0.5 nf=1 ad=0.145 as=0.145 pd=1.58 ps=1.58 nrd=0.58 nrs=0.58 sa=0 sb=0 sd=0 mult=1 m=1
XMNI_p04_w0 wbl_p04_w0 wenb 0 0 sky130_fd_pr__nfet_01v8 L=0.15 W=0.42 nf=1 ad=0.1218 as=0.1218 pd=1.42 ps=1.42 nrd=0.69047619047619 nrs=0.69047619047619 sa=0 sb=0 sd=0 mult=1 m=1
XMNS_p04_w0 sbl_p04_w0 sel_69500 rbl_p04_w0 0 sky130_fd_pr__nfet_01v8 L=0.15 W=1 nf=1 ad=0.29 as=0.29 pd=2.58 ps=2.58 nrd=0.29 nrs=0.29 sa=0 sb=0 sd=0 mult=1 m=1
XMPS_p04_w0 sbl_p04_w0 selb_69500 rbl_p04_w0 vdd sky130_fd_pr__pfet_01v8 L=0.15 W=2 nf=1 ad=0.58 as=0.58 pd=4.58 ps=4.58 nrd=0.145 nrs=0.145 sa=0 sb=0 sd=0 mult=1 m=1
XMNSR_p04_w0 sref_p04_w0 sel_69500 ref_p04_w0 0 sky130_fd_pr__nfet_01v8 L=0.15 W=1 nf=1 ad=0.29 as=0.29 pd=2.58 ps=2.58 nrd=0.29 nrs=0.29 sa=0 sb=0 sd=0 mult=1 m=1
XMPSR_p04_w0 sref_p04_w0 selb_69500 ref_p04_w0 vdd sky130_fd_pr__pfet_01v8 L=0.15 W=2 nf=1 ad=0.58 as=0.58 pd=4.58 ps=4.58 nrd=0.145 nrs=0.145 sa=0 sb=0 sd=0 mult=1 m=1
XMPDUM_p04_w0 rbl_p04_w0 pca_100 rbl_p04_w0 prea sky130_fd_pr__pfet_01v8 L=0.15 W=2 nf=1 ad=0.58 as=0.58 pd=4.58 ps=4.58 nrd=0.145 nrs=0.145 sa=0 sb=0 sd=0 mult=1 m=1   $ STUDY option: dummy switch, opposite-phase gate
XMN1_p04_w0 sbl_p04_w0 sref_p04_w0 vn_p04_w0 0 sky130_fd_pr__nfet_01v8 L=0.15 W=1 nf=1 ad=0.29 as=0.29 pd=2.58 ps=2.58 nrd=0.29 nrs=0.29 sa=0 sb=0 sd=0 mult=1 m=1
XMN2_p04_w0 sref_p04_w0 sbl_p04_w0 vn_p04_w0 0 sky130_fd_pr__nfet_01v8 L=0.15 W=1 nf=1 ad=0.29 as=0.29 pd=2.58 ps=2.58 nrd=0.29 nrs=0.29 sa=0 sb=0 sd=0 mult=1 m=1
XMP1_p04_w0 sbl_p04_w0 sref_p04_w0 vp_p04_w0 vdd sky130_fd_pr__pfet_01v8 L=0.15 W=2 nf=1 ad=0.58 as=0.58 pd=4.58 ps=4.58 nrd=0.145 nrs=0.145 sa=0 sb=0 sd=0 mult=1 m=1
XMP2_p04_w0 sref_p04_w0 sbl_p04_w0 vp_p04_w0 vdd sky130_fd_pr__pfet_01v8 L=0.15 W=2 nf=1 ad=0.58 as=0.58 pd=4.58 ps=4.58 nrd=0.145 nrs=0.145 sa=0 sb=0 sd=0 mult=1 m=1
XMNF_p04_w0 vn_p04_w0 en 0 0 sky130_fd_pr__nfet_01v8 L=0.15 W=2 nf=1 ad=0.58 as=0.58 pd=4.58 ps=4.58 nrd=0.145 nrs=0.145 sa=0 sb=0 sd=0 mult=1 m=1
XMPH_p04_w0 vp_p04_w0 enb vdd vdd sky130_fd_pr__pfet_01v8 L=0.15 W=4 nf=1 ad=1.16 as=1.16 pd=8.58 ps=8.58 nrd=0.0725 nrs=0.0725 sa=0 sb=0 sd=0 mult=1 m=1
bd_p04_w0 d_p04_w0 0 v=v(sbl_p04_w0)-v(sref_p04_w0)
bdabs_p04_w0 dabs_p04_w0 0 v=abs(v(sbl_p04_w0)-v(sref_p04_w0))

* ---- instance 76: p05_w1 (ideal ref, dummy switch 0.25 x MPPRE) ----
XMWR_p05_w1_0 sn_p05_w1_0 wl wbl_p05_w1 0 sky130_fd_pr__nfet_01v8 L=0.15 W=0.42 nf=1 ad=0.1218 as=0.1218 pd=1.42 ps=1.42 nrd=0.69047619047619 nrs=0.69047619047619 sa=0 sb=0 sd=0 mult=1 m=1
XMRD_p05_w1_0 rbl_p05_w1 sn_p05_w1_0 rwl_sel 0 sky130_fd_pr__nfet_01v8 L=0.15 W=0.42 nf=1 ad=0.1218 as=0.1218 pd=1.42 ps=1.42 nrd=0.69047619047619 nrs=0.69047619047619 sa=0 sb=0 sd=0 mult=1 m=1
csn_p05_w1_0 sn_p05_w1_0 0 {C_SN}
XMWR_p05_w1_1 sn_p05_w1_1 0 wbl_p05_w1 0 sky130_fd_pr__nfet_01v8 L=0.15 W=0.42 nf=1 ad=0.1218 as=0.1218 pd=1.42 ps=1.42 nrd=0.69047619047619 nrs=0.69047619047619 sa=0 sb=0 sd=0 mult=1 m=1
XMRD_p05_w1_1 rbl_p05_w1 sn_p05_w1_1 rwl_des 0 sky130_fd_pr__nfet_01v8 L=0.15 W=0.42 nf=1 ad=0.1218 as=0.1218 pd=1.42 ps=1.42 nrd=0.69047619047619 nrs=0.69047619047619 sa=0 sb=0 sd=0 mult=1 m=1
csn_p05_w1_1 sn_p05_w1_1 0 {C_SN}
XMWR_p05_w1_2 sn_p05_w1_2 0 wbl_p05_w1 0 sky130_fd_pr__nfet_01v8 L=0.15 W=0.42 nf=1 ad=0.1218 as=0.1218 pd=1.42 ps=1.42 nrd=0.69047619047619 nrs=0.69047619047619 sa=0 sb=0 sd=0 mult=1 m=1
XMRD_p05_w1_2 rbl_p05_w1 sn_p05_w1_2 rwl_des 0 sky130_fd_pr__nfet_01v8 L=0.15 W=0.42 nf=1 ad=0.1218 as=0.1218 pd=1.42 ps=1.42 nrd=0.69047619047619 nrs=0.69047619047619 sa=0 sb=0 sd=0 mult=1 m=1
csn_p05_w1_2 sn_p05_w1_2 0 {C_SN}
XMWR_p05_w1_3 sn_p05_w1_3 0 wbl_p05_w1 0 sky130_fd_pr__nfet_01v8 L=0.15 W=0.42 nf=1 ad=0.1218 as=0.1218 pd=1.42 ps=1.42 nrd=0.69047619047619 nrs=0.69047619047619 sa=0 sb=0 sd=0 mult=1 m=1
XMRD_p05_w1_3 rbl_p05_w1 sn_p05_w1_3 rwl_des 0 sky130_fd_pr__nfet_01v8 L=0.15 W=0.42 nf=1 ad=0.1218 as=0.1218 pd=1.42 ps=1.42 nrd=0.69047619047619 nrs=0.69047619047619 sa=0 sb=0 sd=0 mult=1 m=1
csn_p05_w1_3 sn_p05_w1_3 0 {C_SN}
crbl_p05_w1 rbl_p05_w1 0 {C_RBL}
cwbl_p05_w1 wbl_p05_w1 0 {C_WBL}
cref_p05_w1 ref_p05_w1 0 {C_RBL}   $ ASSUMPTION: ideal matched dummy load
spr_p05_w1 pref ref_p05_w1 pca 0 swpre   $ reference-side precharge: ideal switch (#114 convention)
XMPPRE_p05_w1 rbl_p05_w1 pcb_100 prea prea sky130_fd_pr__pfet_01v8 L=0.15 W=4 nf=1 ad=1.16 as=1.16 pd=8.58 ps=8.58 nrd=0.0725 nrs=0.0725 sa=0 sb=0 sd=0 mult=1 m=1
XMPU1_p05_w1 x_p05_w1 dinb1 vdd vdd sky130_fd_pr__pfet_01v8 L=0.15 W=1 nf=1 ad=0.29 as=0.29 pd=2.58 ps=2.58 nrd=0.29 nrs=0.29 sa=0 sb=0 sd=0 mult=1 m=1
XMPU2_p05_w1 wbl_p05_w1 wenb x_p05_w1 vdd sky130_fd_pr__pfet_01v8 L=0.15 W=1 nf=1 ad=0.29 as=0.29 pd=2.58 ps=2.58 nrd=0.29 nrs=0.29 sa=0 sb=0 sd=0 mult=1 m=1
XMND2_p05_w1 wbl_p05_w1 wen y_p05_w1 0 sky130_fd_pr__nfet_01v8 L=0.15 W=0.5 nf=1 ad=0.145 as=0.145 pd=1.58 ps=1.58 nrd=0.58 nrs=0.58 sa=0 sb=0 sd=0 mult=1 m=1
XMND1_p05_w1 y_p05_w1 dinb1 0 0 sky130_fd_pr__nfet_01v8 L=0.15 W=0.5 nf=1 ad=0.145 as=0.145 pd=1.58 ps=1.58 nrd=0.58 nrs=0.58 sa=0 sb=0 sd=0 mult=1 m=1
XMNI_p05_w1 wbl_p05_w1 wenb 0 0 sky130_fd_pr__nfet_01v8 L=0.15 W=0.42 nf=1 ad=0.1218 as=0.1218 pd=1.42 ps=1.42 nrd=0.69047619047619 nrs=0.69047619047619 sa=0 sb=0 sd=0 mult=1 m=1
XMNS_p05_w1 sbl_p05_w1 sel_69500 rbl_p05_w1 0 sky130_fd_pr__nfet_01v8 L=0.15 W=1 nf=1 ad=0.29 as=0.29 pd=2.58 ps=2.58 nrd=0.29 nrs=0.29 sa=0 sb=0 sd=0 mult=1 m=1
XMPS_p05_w1 sbl_p05_w1 selb_69500 rbl_p05_w1 vdd sky130_fd_pr__pfet_01v8 L=0.15 W=2 nf=1 ad=0.58 as=0.58 pd=4.58 ps=4.58 nrd=0.145 nrs=0.145 sa=0 sb=0 sd=0 mult=1 m=1
XMNSR_p05_w1 sref_p05_w1 sel_69500 ref_p05_w1 0 sky130_fd_pr__nfet_01v8 L=0.15 W=1 nf=1 ad=0.29 as=0.29 pd=2.58 ps=2.58 nrd=0.29 nrs=0.29 sa=0 sb=0 sd=0 mult=1 m=1
XMPSR_p05_w1 sref_p05_w1 selb_69500 ref_p05_w1 vdd sky130_fd_pr__pfet_01v8 L=0.15 W=2 nf=1 ad=0.58 as=0.58 pd=4.58 ps=4.58 nrd=0.145 nrs=0.145 sa=0 sb=0 sd=0 mult=1 m=1
XMPDUM_p05_w1 rbl_p05_w1 pca_100 rbl_p05_w1 prea sky130_fd_pr__pfet_01v8 L=0.15 W=1 nf=1 ad=0.29 as=0.29 pd=2.58 ps=2.58 nrd=0.29 nrs=0.29 sa=0 sb=0 sd=0 mult=1 m=1   $ STUDY option: dummy switch, opposite-phase gate
XMN1_p05_w1 sbl_p05_w1 sref_p05_w1 vn_p05_w1 0 sky130_fd_pr__nfet_01v8 L=0.15 W=1 nf=1 ad=0.29 as=0.29 pd=2.58 ps=2.58 nrd=0.29 nrs=0.29 sa=0 sb=0 sd=0 mult=1 m=1
XMN2_p05_w1 sref_p05_w1 sbl_p05_w1 vn_p05_w1 0 sky130_fd_pr__nfet_01v8 L=0.15 W=1 nf=1 ad=0.29 as=0.29 pd=2.58 ps=2.58 nrd=0.29 nrs=0.29 sa=0 sb=0 sd=0 mult=1 m=1
XMP1_p05_w1 sbl_p05_w1 sref_p05_w1 vp_p05_w1 vdd sky130_fd_pr__pfet_01v8 L=0.15 W=2 nf=1 ad=0.58 as=0.58 pd=4.58 ps=4.58 nrd=0.145 nrs=0.145 sa=0 sb=0 sd=0 mult=1 m=1
XMP2_p05_w1 sref_p05_w1 sbl_p05_w1 vp_p05_w1 vdd sky130_fd_pr__pfet_01v8 L=0.15 W=2 nf=1 ad=0.58 as=0.58 pd=4.58 ps=4.58 nrd=0.145 nrs=0.145 sa=0 sb=0 sd=0 mult=1 m=1
XMNF_p05_w1 vn_p05_w1 en 0 0 sky130_fd_pr__nfet_01v8 L=0.15 W=2 nf=1 ad=0.58 as=0.58 pd=4.58 ps=4.58 nrd=0.145 nrs=0.145 sa=0 sb=0 sd=0 mult=1 m=1
XMPH_p05_w1 vp_p05_w1 enb vdd vdd sky130_fd_pr__pfet_01v8 L=0.15 W=4 nf=1 ad=1.16 as=1.16 pd=8.58 ps=8.58 nrd=0.0725 nrs=0.0725 sa=0 sb=0 sd=0 mult=1 m=1
bd_p05_w1 d_p05_w1 0 v=v(sbl_p05_w1)-v(sref_p05_w1)
bdabs_p05_w1 dabs_p05_w1 0 v=abs(v(sbl_p05_w1)-v(sref_p05_w1))

* ---- instance 77: p05_w0 (ideal ref, dummy switch 0.25 x MPPRE) ----
XMWR_p05_w0_0 sn_p05_w0_0 wl wbl_p05_w0 0 sky130_fd_pr__nfet_01v8 L=0.15 W=0.42 nf=1 ad=0.1218 as=0.1218 pd=1.42 ps=1.42 nrd=0.69047619047619 nrs=0.69047619047619 sa=0 sb=0 sd=0 mult=1 m=1
XMRD_p05_w0_0 rbl_p05_w0 sn_p05_w0_0 rwl_sel 0 sky130_fd_pr__nfet_01v8 L=0.15 W=0.42 nf=1 ad=0.1218 as=0.1218 pd=1.42 ps=1.42 nrd=0.69047619047619 nrs=0.69047619047619 sa=0 sb=0 sd=0 mult=1 m=1
csn_p05_w0_0 sn_p05_w0_0 0 {C_SN}
XMWR_p05_w0_1 sn_p05_w0_1 0 wbl_p05_w0 0 sky130_fd_pr__nfet_01v8 L=0.15 W=0.42 nf=1 ad=0.1218 as=0.1218 pd=1.42 ps=1.42 nrd=0.69047619047619 nrs=0.69047619047619 sa=0 sb=0 sd=0 mult=1 m=1
XMRD_p05_w0_1 rbl_p05_w0 sn_p05_w0_1 rwl_des 0 sky130_fd_pr__nfet_01v8 L=0.15 W=0.42 nf=1 ad=0.1218 as=0.1218 pd=1.42 ps=1.42 nrd=0.69047619047619 nrs=0.69047619047619 sa=0 sb=0 sd=0 mult=1 m=1
csn_p05_w0_1 sn_p05_w0_1 0 {C_SN}
XMWR_p05_w0_2 sn_p05_w0_2 0 wbl_p05_w0 0 sky130_fd_pr__nfet_01v8 L=0.15 W=0.42 nf=1 ad=0.1218 as=0.1218 pd=1.42 ps=1.42 nrd=0.69047619047619 nrs=0.69047619047619 sa=0 sb=0 sd=0 mult=1 m=1
XMRD_p05_w0_2 rbl_p05_w0 sn_p05_w0_2 rwl_des 0 sky130_fd_pr__nfet_01v8 L=0.15 W=0.42 nf=1 ad=0.1218 as=0.1218 pd=1.42 ps=1.42 nrd=0.69047619047619 nrs=0.69047619047619 sa=0 sb=0 sd=0 mult=1 m=1
csn_p05_w0_2 sn_p05_w0_2 0 {C_SN}
XMWR_p05_w0_3 sn_p05_w0_3 0 wbl_p05_w0 0 sky130_fd_pr__nfet_01v8 L=0.15 W=0.42 nf=1 ad=0.1218 as=0.1218 pd=1.42 ps=1.42 nrd=0.69047619047619 nrs=0.69047619047619 sa=0 sb=0 sd=0 mult=1 m=1
XMRD_p05_w0_3 rbl_p05_w0 sn_p05_w0_3 rwl_des 0 sky130_fd_pr__nfet_01v8 L=0.15 W=0.42 nf=1 ad=0.1218 as=0.1218 pd=1.42 ps=1.42 nrd=0.69047619047619 nrs=0.69047619047619 sa=0 sb=0 sd=0 mult=1 m=1
csn_p05_w0_3 sn_p05_w0_3 0 {C_SN}
crbl_p05_w0 rbl_p05_w0 0 {C_RBL}
cwbl_p05_w0 wbl_p05_w0 0 {C_WBL}
cref_p05_w0 ref_p05_w0 0 {C_RBL}   $ ASSUMPTION: ideal matched dummy load
spr_p05_w0 pref ref_p05_w0 pca 0 swpre   $ reference-side precharge: ideal switch (#114 convention)
XMPPRE_p05_w0 rbl_p05_w0 pcb_100 prea prea sky130_fd_pr__pfet_01v8 L=0.15 W=4 nf=1 ad=1.16 as=1.16 pd=8.58 ps=8.58 nrd=0.0725 nrs=0.0725 sa=0 sb=0 sd=0 mult=1 m=1
XMPU1_p05_w0 x_p05_w0 dinb0 vdd vdd sky130_fd_pr__pfet_01v8 L=0.15 W=1 nf=1 ad=0.29 as=0.29 pd=2.58 ps=2.58 nrd=0.29 nrs=0.29 sa=0 sb=0 sd=0 mult=1 m=1
XMPU2_p05_w0 wbl_p05_w0 wenb x_p05_w0 vdd sky130_fd_pr__pfet_01v8 L=0.15 W=1 nf=1 ad=0.29 as=0.29 pd=2.58 ps=2.58 nrd=0.29 nrs=0.29 sa=0 sb=0 sd=0 mult=1 m=1
XMND2_p05_w0 wbl_p05_w0 wen y_p05_w0 0 sky130_fd_pr__nfet_01v8 L=0.15 W=0.5 nf=1 ad=0.145 as=0.145 pd=1.58 ps=1.58 nrd=0.58 nrs=0.58 sa=0 sb=0 sd=0 mult=1 m=1
XMND1_p05_w0 y_p05_w0 dinb0 0 0 sky130_fd_pr__nfet_01v8 L=0.15 W=0.5 nf=1 ad=0.145 as=0.145 pd=1.58 ps=1.58 nrd=0.58 nrs=0.58 sa=0 sb=0 sd=0 mult=1 m=1
XMNI_p05_w0 wbl_p05_w0 wenb 0 0 sky130_fd_pr__nfet_01v8 L=0.15 W=0.42 nf=1 ad=0.1218 as=0.1218 pd=1.42 ps=1.42 nrd=0.69047619047619 nrs=0.69047619047619 sa=0 sb=0 sd=0 mult=1 m=1
XMNS_p05_w0 sbl_p05_w0 sel_69500 rbl_p05_w0 0 sky130_fd_pr__nfet_01v8 L=0.15 W=1 nf=1 ad=0.29 as=0.29 pd=2.58 ps=2.58 nrd=0.29 nrs=0.29 sa=0 sb=0 sd=0 mult=1 m=1
XMPS_p05_w0 sbl_p05_w0 selb_69500 rbl_p05_w0 vdd sky130_fd_pr__pfet_01v8 L=0.15 W=2 nf=1 ad=0.58 as=0.58 pd=4.58 ps=4.58 nrd=0.145 nrs=0.145 sa=0 sb=0 sd=0 mult=1 m=1
XMNSR_p05_w0 sref_p05_w0 sel_69500 ref_p05_w0 0 sky130_fd_pr__nfet_01v8 L=0.15 W=1 nf=1 ad=0.29 as=0.29 pd=2.58 ps=2.58 nrd=0.29 nrs=0.29 sa=0 sb=0 sd=0 mult=1 m=1
XMPSR_p05_w0 sref_p05_w0 selb_69500 ref_p05_w0 vdd sky130_fd_pr__pfet_01v8 L=0.15 W=2 nf=1 ad=0.58 as=0.58 pd=4.58 ps=4.58 nrd=0.145 nrs=0.145 sa=0 sb=0 sd=0 mult=1 m=1
XMPDUM_p05_w0 rbl_p05_w0 pca_100 rbl_p05_w0 prea sky130_fd_pr__pfet_01v8 L=0.15 W=1 nf=1 ad=0.29 as=0.29 pd=2.58 ps=2.58 nrd=0.29 nrs=0.29 sa=0 sb=0 sd=0 mult=1 m=1   $ STUDY option: dummy switch, opposite-phase gate
XMN1_p05_w0 sbl_p05_w0 sref_p05_w0 vn_p05_w0 0 sky130_fd_pr__nfet_01v8 L=0.15 W=1 nf=1 ad=0.29 as=0.29 pd=2.58 ps=2.58 nrd=0.29 nrs=0.29 sa=0 sb=0 sd=0 mult=1 m=1
XMN2_p05_w0 sref_p05_w0 sbl_p05_w0 vn_p05_w0 0 sky130_fd_pr__nfet_01v8 L=0.15 W=1 nf=1 ad=0.29 as=0.29 pd=2.58 ps=2.58 nrd=0.29 nrs=0.29 sa=0 sb=0 sd=0 mult=1 m=1
XMP1_p05_w0 sbl_p05_w0 sref_p05_w0 vp_p05_w0 vdd sky130_fd_pr__pfet_01v8 L=0.15 W=2 nf=1 ad=0.58 as=0.58 pd=4.58 ps=4.58 nrd=0.145 nrs=0.145 sa=0 sb=0 sd=0 mult=1 m=1
XMP2_p05_w0 sref_p05_w0 sbl_p05_w0 vp_p05_w0 vdd sky130_fd_pr__pfet_01v8 L=0.15 W=2 nf=1 ad=0.58 as=0.58 pd=4.58 ps=4.58 nrd=0.145 nrs=0.145 sa=0 sb=0 sd=0 mult=1 m=1
XMNF_p05_w0 vn_p05_w0 en 0 0 sky130_fd_pr__nfet_01v8 L=0.15 W=2 nf=1 ad=0.58 as=0.58 pd=4.58 ps=4.58 nrd=0.145 nrs=0.145 sa=0 sb=0 sd=0 mult=1 m=1
XMPH_p05_w0 vp_p05_w0 enb vdd vdd sky130_fd_pr__pfet_01v8 L=0.15 W=4 nf=1 ad=1.16 as=1.16 pd=8.58 ps=8.58 nrd=0.0725 nrs=0.0725 sa=0 sb=0 sd=0 mult=1 m=1
bd_p05_w0 d_p05_w0 0 v=v(sbl_p05_w0)-v(sref_p05_w0)
bdabs_p05_w0 dabs_p05_w0 0 v=abs(v(sbl_p05_w0)-v(sref_p05_w0))

* ---- instance 78: p06_w1 (ideal ref, release edge 0.5 ns) ----
XMWR_p06_w1_0 sn_p06_w1_0 wl wbl_p06_w1 0 sky130_fd_pr__nfet_01v8 L=0.15 W=0.42 nf=1 ad=0.1218 as=0.1218 pd=1.42 ps=1.42 nrd=0.69047619047619 nrs=0.69047619047619 sa=0 sb=0 sd=0 mult=1 m=1
XMRD_p06_w1_0 rbl_p06_w1 sn_p06_w1_0 rwl_sel 0 sky130_fd_pr__nfet_01v8 L=0.15 W=0.42 nf=1 ad=0.1218 as=0.1218 pd=1.42 ps=1.42 nrd=0.69047619047619 nrs=0.69047619047619 sa=0 sb=0 sd=0 mult=1 m=1
csn_p06_w1_0 sn_p06_w1_0 0 {C_SN}
XMWR_p06_w1_1 sn_p06_w1_1 0 wbl_p06_w1 0 sky130_fd_pr__nfet_01v8 L=0.15 W=0.42 nf=1 ad=0.1218 as=0.1218 pd=1.42 ps=1.42 nrd=0.69047619047619 nrs=0.69047619047619 sa=0 sb=0 sd=0 mult=1 m=1
XMRD_p06_w1_1 rbl_p06_w1 sn_p06_w1_1 rwl_des 0 sky130_fd_pr__nfet_01v8 L=0.15 W=0.42 nf=1 ad=0.1218 as=0.1218 pd=1.42 ps=1.42 nrd=0.69047619047619 nrs=0.69047619047619 sa=0 sb=0 sd=0 mult=1 m=1
csn_p06_w1_1 sn_p06_w1_1 0 {C_SN}
XMWR_p06_w1_2 sn_p06_w1_2 0 wbl_p06_w1 0 sky130_fd_pr__nfet_01v8 L=0.15 W=0.42 nf=1 ad=0.1218 as=0.1218 pd=1.42 ps=1.42 nrd=0.69047619047619 nrs=0.69047619047619 sa=0 sb=0 sd=0 mult=1 m=1
XMRD_p06_w1_2 rbl_p06_w1 sn_p06_w1_2 rwl_des 0 sky130_fd_pr__nfet_01v8 L=0.15 W=0.42 nf=1 ad=0.1218 as=0.1218 pd=1.42 ps=1.42 nrd=0.69047619047619 nrs=0.69047619047619 sa=0 sb=0 sd=0 mult=1 m=1
csn_p06_w1_2 sn_p06_w1_2 0 {C_SN}
XMWR_p06_w1_3 sn_p06_w1_3 0 wbl_p06_w1 0 sky130_fd_pr__nfet_01v8 L=0.15 W=0.42 nf=1 ad=0.1218 as=0.1218 pd=1.42 ps=1.42 nrd=0.69047619047619 nrs=0.69047619047619 sa=0 sb=0 sd=0 mult=1 m=1
XMRD_p06_w1_3 rbl_p06_w1 sn_p06_w1_3 rwl_des 0 sky130_fd_pr__nfet_01v8 L=0.15 W=0.42 nf=1 ad=0.1218 as=0.1218 pd=1.42 ps=1.42 nrd=0.69047619047619 nrs=0.69047619047619 sa=0 sb=0 sd=0 mult=1 m=1
csn_p06_w1_3 sn_p06_w1_3 0 {C_SN}
crbl_p06_w1 rbl_p06_w1 0 {C_RBL}
cwbl_p06_w1 wbl_p06_w1 0 {C_WBL}
cref_p06_w1 ref_p06_w1 0 {C_RBL}   $ ASSUMPTION: ideal matched dummy load
spr_p06_w1 pref ref_p06_w1 pca 0 swpre   $ reference-side precharge: ideal switch (#114 convention)
XMPPRE_p06_w1 rbl_p06_w1 pcb_500 prea prea sky130_fd_pr__pfet_01v8 L=0.15 W=4 nf=1 ad=1.16 as=1.16 pd=8.58 ps=8.58 nrd=0.0725 nrs=0.0725 sa=0 sb=0 sd=0 mult=1 m=1
XMPU1_p06_w1 x_p06_w1 dinb1 vdd vdd sky130_fd_pr__pfet_01v8 L=0.15 W=1 nf=1 ad=0.29 as=0.29 pd=2.58 ps=2.58 nrd=0.29 nrs=0.29 sa=0 sb=0 sd=0 mult=1 m=1
XMPU2_p06_w1 wbl_p06_w1 wenb x_p06_w1 vdd sky130_fd_pr__pfet_01v8 L=0.15 W=1 nf=1 ad=0.29 as=0.29 pd=2.58 ps=2.58 nrd=0.29 nrs=0.29 sa=0 sb=0 sd=0 mult=1 m=1
XMND2_p06_w1 wbl_p06_w1 wen y_p06_w1 0 sky130_fd_pr__nfet_01v8 L=0.15 W=0.5 nf=1 ad=0.145 as=0.145 pd=1.58 ps=1.58 nrd=0.58 nrs=0.58 sa=0 sb=0 sd=0 mult=1 m=1
XMND1_p06_w1 y_p06_w1 dinb1 0 0 sky130_fd_pr__nfet_01v8 L=0.15 W=0.5 nf=1 ad=0.145 as=0.145 pd=1.58 ps=1.58 nrd=0.58 nrs=0.58 sa=0 sb=0 sd=0 mult=1 m=1
XMNI_p06_w1 wbl_p06_w1 wenb 0 0 sky130_fd_pr__nfet_01v8 L=0.15 W=0.42 nf=1 ad=0.1218 as=0.1218 pd=1.42 ps=1.42 nrd=0.69047619047619 nrs=0.69047619047619 sa=0 sb=0 sd=0 mult=1 m=1
XMNS_p06_w1 sbl_p06_w1 sel_69500 rbl_p06_w1 0 sky130_fd_pr__nfet_01v8 L=0.15 W=1 nf=1 ad=0.29 as=0.29 pd=2.58 ps=2.58 nrd=0.29 nrs=0.29 sa=0 sb=0 sd=0 mult=1 m=1
XMPS_p06_w1 sbl_p06_w1 selb_69500 rbl_p06_w1 vdd sky130_fd_pr__pfet_01v8 L=0.15 W=2 nf=1 ad=0.58 as=0.58 pd=4.58 ps=4.58 nrd=0.145 nrs=0.145 sa=0 sb=0 sd=0 mult=1 m=1
XMNSR_p06_w1 sref_p06_w1 sel_69500 ref_p06_w1 0 sky130_fd_pr__nfet_01v8 L=0.15 W=1 nf=1 ad=0.29 as=0.29 pd=2.58 ps=2.58 nrd=0.29 nrs=0.29 sa=0 sb=0 sd=0 mult=1 m=1
XMPSR_p06_w1 sref_p06_w1 selb_69500 ref_p06_w1 vdd sky130_fd_pr__pfet_01v8 L=0.15 W=2 nf=1 ad=0.58 as=0.58 pd=4.58 ps=4.58 nrd=0.145 nrs=0.145 sa=0 sb=0 sd=0 mult=1 m=1
XMN1_p06_w1 sbl_p06_w1 sref_p06_w1 vn_p06_w1 0 sky130_fd_pr__nfet_01v8 L=0.15 W=1 nf=1 ad=0.29 as=0.29 pd=2.58 ps=2.58 nrd=0.29 nrs=0.29 sa=0 sb=0 sd=0 mult=1 m=1
XMN2_p06_w1 sref_p06_w1 sbl_p06_w1 vn_p06_w1 0 sky130_fd_pr__nfet_01v8 L=0.15 W=1 nf=1 ad=0.29 as=0.29 pd=2.58 ps=2.58 nrd=0.29 nrs=0.29 sa=0 sb=0 sd=0 mult=1 m=1
XMP1_p06_w1 sbl_p06_w1 sref_p06_w1 vp_p06_w1 vdd sky130_fd_pr__pfet_01v8 L=0.15 W=2 nf=1 ad=0.58 as=0.58 pd=4.58 ps=4.58 nrd=0.145 nrs=0.145 sa=0 sb=0 sd=0 mult=1 m=1
XMP2_p06_w1 sref_p06_w1 sbl_p06_w1 vp_p06_w1 vdd sky130_fd_pr__pfet_01v8 L=0.15 W=2 nf=1 ad=0.58 as=0.58 pd=4.58 ps=4.58 nrd=0.145 nrs=0.145 sa=0 sb=0 sd=0 mult=1 m=1
XMNF_p06_w1 vn_p06_w1 en 0 0 sky130_fd_pr__nfet_01v8 L=0.15 W=2 nf=1 ad=0.58 as=0.58 pd=4.58 ps=4.58 nrd=0.145 nrs=0.145 sa=0 sb=0 sd=0 mult=1 m=1
XMPH_p06_w1 vp_p06_w1 enb vdd vdd sky130_fd_pr__pfet_01v8 L=0.15 W=4 nf=1 ad=1.16 as=1.16 pd=8.58 ps=8.58 nrd=0.0725 nrs=0.0725 sa=0 sb=0 sd=0 mult=1 m=1
bd_p06_w1 d_p06_w1 0 v=v(sbl_p06_w1)-v(sref_p06_w1)
bdabs_p06_w1 dabs_p06_w1 0 v=abs(v(sbl_p06_w1)-v(sref_p06_w1))

* ---- instance 79: p06_w0 (ideal ref, release edge 0.5 ns) ----
XMWR_p06_w0_0 sn_p06_w0_0 wl wbl_p06_w0 0 sky130_fd_pr__nfet_01v8 L=0.15 W=0.42 nf=1 ad=0.1218 as=0.1218 pd=1.42 ps=1.42 nrd=0.69047619047619 nrs=0.69047619047619 sa=0 sb=0 sd=0 mult=1 m=1
XMRD_p06_w0_0 rbl_p06_w0 sn_p06_w0_0 rwl_sel 0 sky130_fd_pr__nfet_01v8 L=0.15 W=0.42 nf=1 ad=0.1218 as=0.1218 pd=1.42 ps=1.42 nrd=0.69047619047619 nrs=0.69047619047619 sa=0 sb=0 sd=0 mult=1 m=1
csn_p06_w0_0 sn_p06_w0_0 0 {C_SN}
XMWR_p06_w0_1 sn_p06_w0_1 0 wbl_p06_w0 0 sky130_fd_pr__nfet_01v8 L=0.15 W=0.42 nf=1 ad=0.1218 as=0.1218 pd=1.42 ps=1.42 nrd=0.69047619047619 nrs=0.69047619047619 sa=0 sb=0 sd=0 mult=1 m=1
XMRD_p06_w0_1 rbl_p06_w0 sn_p06_w0_1 rwl_des 0 sky130_fd_pr__nfet_01v8 L=0.15 W=0.42 nf=1 ad=0.1218 as=0.1218 pd=1.42 ps=1.42 nrd=0.69047619047619 nrs=0.69047619047619 sa=0 sb=0 sd=0 mult=1 m=1
csn_p06_w0_1 sn_p06_w0_1 0 {C_SN}
XMWR_p06_w0_2 sn_p06_w0_2 0 wbl_p06_w0 0 sky130_fd_pr__nfet_01v8 L=0.15 W=0.42 nf=1 ad=0.1218 as=0.1218 pd=1.42 ps=1.42 nrd=0.69047619047619 nrs=0.69047619047619 sa=0 sb=0 sd=0 mult=1 m=1
XMRD_p06_w0_2 rbl_p06_w0 sn_p06_w0_2 rwl_des 0 sky130_fd_pr__nfet_01v8 L=0.15 W=0.42 nf=1 ad=0.1218 as=0.1218 pd=1.42 ps=1.42 nrd=0.69047619047619 nrs=0.69047619047619 sa=0 sb=0 sd=0 mult=1 m=1
csn_p06_w0_2 sn_p06_w0_2 0 {C_SN}
XMWR_p06_w0_3 sn_p06_w0_3 0 wbl_p06_w0 0 sky130_fd_pr__nfet_01v8 L=0.15 W=0.42 nf=1 ad=0.1218 as=0.1218 pd=1.42 ps=1.42 nrd=0.69047619047619 nrs=0.69047619047619 sa=0 sb=0 sd=0 mult=1 m=1
XMRD_p06_w0_3 rbl_p06_w0 sn_p06_w0_3 rwl_des 0 sky130_fd_pr__nfet_01v8 L=0.15 W=0.42 nf=1 ad=0.1218 as=0.1218 pd=1.42 ps=1.42 nrd=0.69047619047619 nrs=0.69047619047619 sa=0 sb=0 sd=0 mult=1 m=1
csn_p06_w0_3 sn_p06_w0_3 0 {C_SN}
crbl_p06_w0 rbl_p06_w0 0 {C_RBL}
cwbl_p06_w0 wbl_p06_w0 0 {C_WBL}
cref_p06_w0 ref_p06_w0 0 {C_RBL}   $ ASSUMPTION: ideal matched dummy load
spr_p06_w0 pref ref_p06_w0 pca 0 swpre   $ reference-side precharge: ideal switch (#114 convention)
XMPPRE_p06_w0 rbl_p06_w0 pcb_500 prea prea sky130_fd_pr__pfet_01v8 L=0.15 W=4 nf=1 ad=1.16 as=1.16 pd=8.58 ps=8.58 nrd=0.0725 nrs=0.0725 sa=0 sb=0 sd=0 mult=1 m=1
XMPU1_p06_w0 x_p06_w0 dinb0 vdd vdd sky130_fd_pr__pfet_01v8 L=0.15 W=1 nf=1 ad=0.29 as=0.29 pd=2.58 ps=2.58 nrd=0.29 nrs=0.29 sa=0 sb=0 sd=0 mult=1 m=1
XMPU2_p06_w0 wbl_p06_w0 wenb x_p06_w0 vdd sky130_fd_pr__pfet_01v8 L=0.15 W=1 nf=1 ad=0.29 as=0.29 pd=2.58 ps=2.58 nrd=0.29 nrs=0.29 sa=0 sb=0 sd=0 mult=1 m=1
XMND2_p06_w0 wbl_p06_w0 wen y_p06_w0 0 sky130_fd_pr__nfet_01v8 L=0.15 W=0.5 nf=1 ad=0.145 as=0.145 pd=1.58 ps=1.58 nrd=0.58 nrs=0.58 sa=0 sb=0 sd=0 mult=1 m=1
XMND1_p06_w0 y_p06_w0 dinb0 0 0 sky130_fd_pr__nfet_01v8 L=0.15 W=0.5 nf=1 ad=0.145 as=0.145 pd=1.58 ps=1.58 nrd=0.58 nrs=0.58 sa=0 sb=0 sd=0 mult=1 m=1
XMNI_p06_w0 wbl_p06_w0 wenb 0 0 sky130_fd_pr__nfet_01v8 L=0.15 W=0.42 nf=1 ad=0.1218 as=0.1218 pd=1.42 ps=1.42 nrd=0.69047619047619 nrs=0.69047619047619 sa=0 sb=0 sd=0 mult=1 m=1
XMNS_p06_w0 sbl_p06_w0 sel_69500 rbl_p06_w0 0 sky130_fd_pr__nfet_01v8 L=0.15 W=1 nf=1 ad=0.29 as=0.29 pd=2.58 ps=2.58 nrd=0.29 nrs=0.29 sa=0 sb=0 sd=0 mult=1 m=1
XMPS_p06_w0 sbl_p06_w0 selb_69500 rbl_p06_w0 vdd sky130_fd_pr__pfet_01v8 L=0.15 W=2 nf=1 ad=0.58 as=0.58 pd=4.58 ps=4.58 nrd=0.145 nrs=0.145 sa=0 sb=0 sd=0 mult=1 m=1
XMNSR_p06_w0 sref_p06_w0 sel_69500 ref_p06_w0 0 sky130_fd_pr__nfet_01v8 L=0.15 W=1 nf=1 ad=0.29 as=0.29 pd=2.58 ps=2.58 nrd=0.29 nrs=0.29 sa=0 sb=0 sd=0 mult=1 m=1
XMPSR_p06_w0 sref_p06_w0 selb_69500 ref_p06_w0 vdd sky130_fd_pr__pfet_01v8 L=0.15 W=2 nf=1 ad=0.58 as=0.58 pd=4.58 ps=4.58 nrd=0.145 nrs=0.145 sa=0 sb=0 sd=0 mult=1 m=1
XMN1_p06_w0 sbl_p06_w0 sref_p06_w0 vn_p06_w0 0 sky130_fd_pr__nfet_01v8 L=0.15 W=1 nf=1 ad=0.29 as=0.29 pd=2.58 ps=2.58 nrd=0.29 nrs=0.29 sa=0 sb=0 sd=0 mult=1 m=1
XMN2_p06_w0 sref_p06_w0 sbl_p06_w0 vn_p06_w0 0 sky130_fd_pr__nfet_01v8 L=0.15 W=1 nf=1 ad=0.29 as=0.29 pd=2.58 ps=2.58 nrd=0.29 nrs=0.29 sa=0 sb=0 sd=0 mult=1 m=1
XMP1_p06_w0 sbl_p06_w0 sref_p06_w0 vp_p06_w0 vdd sky130_fd_pr__pfet_01v8 L=0.15 W=2 nf=1 ad=0.58 as=0.58 pd=4.58 ps=4.58 nrd=0.145 nrs=0.145 sa=0 sb=0 sd=0 mult=1 m=1
XMP2_p06_w0 sref_p06_w0 sbl_p06_w0 vp_p06_w0 vdd sky130_fd_pr__pfet_01v8 L=0.15 W=2 nf=1 ad=0.58 as=0.58 pd=4.58 ps=4.58 nrd=0.145 nrs=0.145 sa=0 sb=0 sd=0 mult=1 m=1
XMNF_p06_w0 vn_p06_w0 en 0 0 sky130_fd_pr__nfet_01v8 L=0.15 W=2 nf=1 ad=0.58 as=0.58 pd=4.58 ps=4.58 nrd=0.145 nrs=0.145 sa=0 sb=0 sd=0 mult=1 m=1
XMPH_p06_w0 vp_p06_w0 enb vdd vdd sky130_fd_pr__pfet_01v8 L=0.15 W=4 nf=1 ad=1.16 as=1.16 pd=8.58 ps=8.58 nrd=0.0725 nrs=0.0725 sa=0 sb=0 sd=0 mult=1 m=1
bd_p06_w0 d_p06_w0 0 v=v(sbl_p06_w0)-v(sref_p06_w0)
bdabs_p06_w0 dabs_p06_w0 0 v=abs(v(sbl_p06_w0)-v(sref_p06_w0))

* ---- instance 80: p07_w1 (ideal ref, release edge 1.0 ns) ----
XMWR_p07_w1_0 sn_p07_w1_0 wl wbl_p07_w1 0 sky130_fd_pr__nfet_01v8 L=0.15 W=0.42 nf=1 ad=0.1218 as=0.1218 pd=1.42 ps=1.42 nrd=0.69047619047619 nrs=0.69047619047619 sa=0 sb=0 sd=0 mult=1 m=1
XMRD_p07_w1_0 rbl_p07_w1 sn_p07_w1_0 rwl_sel 0 sky130_fd_pr__nfet_01v8 L=0.15 W=0.42 nf=1 ad=0.1218 as=0.1218 pd=1.42 ps=1.42 nrd=0.69047619047619 nrs=0.69047619047619 sa=0 sb=0 sd=0 mult=1 m=1
csn_p07_w1_0 sn_p07_w1_0 0 {C_SN}
XMWR_p07_w1_1 sn_p07_w1_1 0 wbl_p07_w1 0 sky130_fd_pr__nfet_01v8 L=0.15 W=0.42 nf=1 ad=0.1218 as=0.1218 pd=1.42 ps=1.42 nrd=0.69047619047619 nrs=0.69047619047619 sa=0 sb=0 sd=0 mult=1 m=1
XMRD_p07_w1_1 rbl_p07_w1 sn_p07_w1_1 rwl_des 0 sky130_fd_pr__nfet_01v8 L=0.15 W=0.42 nf=1 ad=0.1218 as=0.1218 pd=1.42 ps=1.42 nrd=0.69047619047619 nrs=0.69047619047619 sa=0 sb=0 sd=0 mult=1 m=1
csn_p07_w1_1 sn_p07_w1_1 0 {C_SN}
XMWR_p07_w1_2 sn_p07_w1_2 0 wbl_p07_w1 0 sky130_fd_pr__nfet_01v8 L=0.15 W=0.42 nf=1 ad=0.1218 as=0.1218 pd=1.42 ps=1.42 nrd=0.69047619047619 nrs=0.69047619047619 sa=0 sb=0 sd=0 mult=1 m=1
XMRD_p07_w1_2 rbl_p07_w1 sn_p07_w1_2 rwl_des 0 sky130_fd_pr__nfet_01v8 L=0.15 W=0.42 nf=1 ad=0.1218 as=0.1218 pd=1.42 ps=1.42 nrd=0.69047619047619 nrs=0.69047619047619 sa=0 sb=0 sd=0 mult=1 m=1
csn_p07_w1_2 sn_p07_w1_2 0 {C_SN}
XMWR_p07_w1_3 sn_p07_w1_3 0 wbl_p07_w1 0 sky130_fd_pr__nfet_01v8 L=0.15 W=0.42 nf=1 ad=0.1218 as=0.1218 pd=1.42 ps=1.42 nrd=0.69047619047619 nrs=0.69047619047619 sa=0 sb=0 sd=0 mult=1 m=1
XMRD_p07_w1_3 rbl_p07_w1 sn_p07_w1_3 rwl_des 0 sky130_fd_pr__nfet_01v8 L=0.15 W=0.42 nf=1 ad=0.1218 as=0.1218 pd=1.42 ps=1.42 nrd=0.69047619047619 nrs=0.69047619047619 sa=0 sb=0 sd=0 mult=1 m=1
csn_p07_w1_3 sn_p07_w1_3 0 {C_SN}
crbl_p07_w1 rbl_p07_w1 0 {C_RBL}
cwbl_p07_w1 wbl_p07_w1 0 {C_WBL}
cref_p07_w1 ref_p07_w1 0 {C_RBL}   $ ASSUMPTION: ideal matched dummy load
spr_p07_w1 pref ref_p07_w1 pca 0 swpre   $ reference-side precharge: ideal switch (#114 convention)
XMPPRE_p07_w1 rbl_p07_w1 pcb_1000 prea prea sky130_fd_pr__pfet_01v8 L=0.15 W=4 nf=1 ad=1.16 as=1.16 pd=8.58 ps=8.58 nrd=0.0725 nrs=0.0725 sa=0 sb=0 sd=0 mult=1 m=1
XMPU1_p07_w1 x_p07_w1 dinb1 vdd vdd sky130_fd_pr__pfet_01v8 L=0.15 W=1 nf=1 ad=0.29 as=0.29 pd=2.58 ps=2.58 nrd=0.29 nrs=0.29 sa=0 sb=0 sd=0 mult=1 m=1
XMPU2_p07_w1 wbl_p07_w1 wenb x_p07_w1 vdd sky130_fd_pr__pfet_01v8 L=0.15 W=1 nf=1 ad=0.29 as=0.29 pd=2.58 ps=2.58 nrd=0.29 nrs=0.29 sa=0 sb=0 sd=0 mult=1 m=1
XMND2_p07_w1 wbl_p07_w1 wen y_p07_w1 0 sky130_fd_pr__nfet_01v8 L=0.15 W=0.5 nf=1 ad=0.145 as=0.145 pd=1.58 ps=1.58 nrd=0.58 nrs=0.58 sa=0 sb=0 sd=0 mult=1 m=1
XMND1_p07_w1 y_p07_w1 dinb1 0 0 sky130_fd_pr__nfet_01v8 L=0.15 W=0.5 nf=1 ad=0.145 as=0.145 pd=1.58 ps=1.58 nrd=0.58 nrs=0.58 sa=0 sb=0 sd=0 mult=1 m=1
XMNI_p07_w1 wbl_p07_w1 wenb 0 0 sky130_fd_pr__nfet_01v8 L=0.15 W=0.42 nf=1 ad=0.1218 as=0.1218 pd=1.42 ps=1.42 nrd=0.69047619047619 nrs=0.69047619047619 sa=0 sb=0 sd=0 mult=1 m=1
XMNS_p07_w1 sbl_p07_w1 sel_69500 rbl_p07_w1 0 sky130_fd_pr__nfet_01v8 L=0.15 W=1 nf=1 ad=0.29 as=0.29 pd=2.58 ps=2.58 nrd=0.29 nrs=0.29 sa=0 sb=0 sd=0 mult=1 m=1
XMPS_p07_w1 sbl_p07_w1 selb_69500 rbl_p07_w1 vdd sky130_fd_pr__pfet_01v8 L=0.15 W=2 nf=1 ad=0.58 as=0.58 pd=4.58 ps=4.58 nrd=0.145 nrs=0.145 sa=0 sb=0 sd=0 mult=1 m=1
XMNSR_p07_w1 sref_p07_w1 sel_69500 ref_p07_w1 0 sky130_fd_pr__nfet_01v8 L=0.15 W=1 nf=1 ad=0.29 as=0.29 pd=2.58 ps=2.58 nrd=0.29 nrs=0.29 sa=0 sb=0 sd=0 mult=1 m=1
XMPSR_p07_w1 sref_p07_w1 selb_69500 ref_p07_w1 vdd sky130_fd_pr__pfet_01v8 L=0.15 W=2 nf=1 ad=0.58 as=0.58 pd=4.58 ps=4.58 nrd=0.145 nrs=0.145 sa=0 sb=0 sd=0 mult=1 m=1
XMN1_p07_w1 sbl_p07_w1 sref_p07_w1 vn_p07_w1 0 sky130_fd_pr__nfet_01v8 L=0.15 W=1 nf=1 ad=0.29 as=0.29 pd=2.58 ps=2.58 nrd=0.29 nrs=0.29 sa=0 sb=0 sd=0 mult=1 m=1
XMN2_p07_w1 sref_p07_w1 sbl_p07_w1 vn_p07_w1 0 sky130_fd_pr__nfet_01v8 L=0.15 W=1 nf=1 ad=0.29 as=0.29 pd=2.58 ps=2.58 nrd=0.29 nrs=0.29 sa=0 sb=0 sd=0 mult=1 m=1
XMP1_p07_w1 sbl_p07_w1 sref_p07_w1 vp_p07_w1 vdd sky130_fd_pr__pfet_01v8 L=0.15 W=2 nf=1 ad=0.58 as=0.58 pd=4.58 ps=4.58 nrd=0.145 nrs=0.145 sa=0 sb=0 sd=0 mult=1 m=1
XMP2_p07_w1 sref_p07_w1 sbl_p07_w1 vp_p07_w1 vdd sky130_fd_pr__pfet_01v8 L=0.15 W=2 nf=1 ad=0.58 as=0.58 pd=4.58 ps=4.58 nrd=0.145 nrs=0.145 sa=0 sb=0 sd=0 mult=1 m=1
XMNF_p07_w1 vn_p07_w1 en 0 0 sky130_fd_pr__nfet_01v8 L=0.15 W=2 nf=1 ad=0.58 as=0.58 pd=4.58 ps=4.58 nrd=0.145 nrs=0.145 sa=0 sb=0 sd=0 mult=1 m=1
XMPH_p07_w1 vp_p07_w1 enb vdd vdd sky130_fd_pr__pfet_01v8 L=0.15 W=4 nf=1 ad=1.16 as=1.16 pd=8.58 ps=8.58 nrd=0.0725 nrs=0.0725 sa=0 sb=0 sd=0 mult=1 m=1
bd_p07_w1 d_p07_w1 0 v=v(sbl_p07_w1)-v(sref_p07_w1)
bdabs_p07_w1 dabs_p07_w1 0 v=abs(v(sbl_p07_w1)-v(sref_p07_w1))

* ---- instance 81: p07_w0 (ideal ref, release edge 1.0 ns) ----
XMWR_p07_w0_0 sn_p07_w0_0 wl wbl_p07_w0 0 sky130_fd_pr__nfet_01v8 L=0.15 W=0.42 nf=1 ad=0.1218 as=0.1218 pd=1.42 ps=1.42 nrd=0.69047619047619 nrs=0.69047619047619 sa=0 sb=0 sd=0 mult=1 m=1
XMRD_p07_w0_0 rbl_p07_w0 sn_p07_w0_0 rwl_sel 0 sky130_fd_pr__nfet_01v8 L=0.15 W=0.42 nf=1 ad=0.1218 as=0.1218 pd=1.42 ps=1.42 nrd=0.69047619047619 nrs=0.69047619047619 sa=0 sb=0 sd=0 mult=1 m=1
csn_p07_w0_0 sn_p07_w0_0 0 {C_SN}
XMWR_p07_w0_1 sn_p07_w0_1 0 wbl_p07_w0 0 sky130_fd_pr__nfet_01v8 L=0.15 W=0.42 nf=1 ad=0.1218 as=0.1218 pd=1.42 ps=1.42 nrd=0.69047619047619 nrs=0.69047619047619 sa=0 sb=0 sd=0 mult=1 m=1
XMRD_p07_w0_1 rbl_p07_w0 sn_p07_w0_1 rwl_des 0 sky130_fd_pr__nfet_01v8 L=0.15 W=0.42 nf=1 ad=0.1218 as=0.1218 pd=1.42 ps=1.42 nrd=0.69047619047619 nrs=0.69047619047619 sa=0 sb=0 sd=0 mult=1 m=1
csn_p07_w0_1 sn_p07_w0_1 0 {C_SN}
XMWR_p07_w0_2 sn_p07_w0_2 0 wbl_p07_w0 0 sky130_fd_pr__nfet_01v8 L=0.15 W=0.42 nf=1 ad=0.1218 as=0.1218 pd=1.42 ps=1.42 nrd=0.69047619047619 nrs=0.69047619047619 sa=0 sb=0 sd=0 mult=1 m=1
XMRD_p07_w0_2 rbl_p07_w0 sn_p07_w0_2 rwl_des 0 sky130_fd_pr__nfet_01v8 L=0.15 W=0.42 nf=1 ad=0.1218 as=0.1218 pd=1.42 ps=1.42 nrd=0.69047619047619 nrs=0.69047619047619 sa=0 sb=0 sd=0 mult=1 m=1
csn_p07_w0_2 sn_p07_w0_2 0 {C_SN}
XMWR_p07_w0_3 sn_p07_w0_3 0 wbl_p07_w0 0 sky130_fd_pr__nfet_01v8 L=0.15 W=0.42 nf=1 ad=0.1218 as=0.1218 pd=1.42 ps=1.42 nrd=0.69047619047619 nrs=0.69047619047619 sa=0 sb=0 sd=0 mult=1 m=1
XMRD_p07_w0_3 rbl_p07_w0 sn_p07_w0_3 rwl_des 0 sky130_fd_pr__nfet_01v8 L=0.15 W=0.42 nf=1 ad=0.1218 as=0.1218 pd=1.42 ps=1.42 nrd=0.69047619047619 nrs=0.69047619047619 sa=0 sb=0 sd=0 mult=1 m=1
csn_p07_w0_3 sn_p07_w0_3 0 {C_SN}
crbl_p07_w0 rbl_p07_w0 0 {C_RBL}
cwbl_p07_w0 wbl_p07_w0 0 {C_WBL}
cref_p07_w0 ref_p07_w0 0 {C_RBL}   $ ASSUMPTION: ideal matched dummy load
spr_p07_w0 pref ref_p07_w0 pca 0 swpre   $ reference-side precharge: ideal switch (#114 convention)
XMPPRE_p07_w0 rbl_p07_w0 pcb_1000 prea prea sky130_fd_pr__pfet_01v8 L=0.15 W=4 nf=1 ad=1.16 as=1.16 pd=8.58 ps=8.58 nrd=0.0725 nrs=0.0725 sa=0 sb=0 sd=0 mult=1 m=1
XMPU1_p07_w0 x_p07_w0 dinb0 vdd vdd sky130_fd_pr__pfet_01v8 L=0.15 W=1 nf=1 ad=0.29 as=0.29 pd=2.58 ps=2.58 nrd=0.29 nrs=0.29 sa=0 sb=0 sd=0 mult=1 m=1
XMPU2_p07_w0 wbl_p07_w0 wenb x_p07_w0 vdd sky130_fd_pr__pfet_01v8 L=0.15 W=1 nf=1 ad=0.29 as=0.29 pd=2.58 ps=2.58 nrd=0.29 nrs=0.29 sa=0 sb=0 sd=0 mult=1 m=1
XMND2_p07_w0 wbl_p07_w0 wen y_p07_w0 0 sky130_fd_pr__nfet_01v8 L=0.15 W=0.5 nf=1 ad=0.145 as=0.145 pd=1.58 ps=1.58 nrd=0.58 nrs=0.58 sa=0 sb=0 sd=0 mult=1 m=1
XMND1_p07_w0 y_p07_w0 dinb0 0 0 sky130_fd_pr__nfet_01v8 L=0.15 W=0.5 nf=1 ad=0.145 as=0.145 pd=1.58 ps=1.58 nrd=0.58 nrs=0.58 sa=0 sb=0 sd=0 mult=1 m=1
XMNI_p07_w0 wbl_p07_w0 wenb 0 0 sky130_fd_pr__nfet_01v8 L=0.15 W=0.42 nf=1 ad=0.1218 as=0.1218 pd=1.42 ps=1.42 nrd=0.69047619047619 nrs=0.69047619047619 sa=0 sb=0 sd=0 mult=1 m=1
XMNS_p07_w0 sbl_p07_w0 sel_69500 rbl_p07_w0 0 sky130_fd_pr__nfet_01v8 L=0.15 W=1 nf=1 ad=0.29 as=0.29 pd=2.58 ps=2.58 nrd=0.29 nrs=0.29 sa=0 sb=0 sd=0 mult=1 m=1
XMPS_p07_w0 sbl_p07_w0 selb_69500 rbl_p07_w0 vdd sky130_fd_pr__pfet_01v8 L=0.15 W=2 nf=1 ad=0.58 as=0.58 pd=4.58 ps=4.58 nrd=0.145 nrs=0.145 sa=0 sb=0 sd=0 mult=1 m=1
XMNSR_p07_w0 sref_p07_w0 sel_69500 ref_p07_w0 0 sky130_fd_pr__nfet_01v8 L=0.15 W=1 nf=1 ad=0.29 as=0.29 pd=2.58 ps=2.58 nrd=0.29 nrs=0.29 sa=0 sb=0 sd=0 mult=1 m=1
XMPSR_p07_w0 sref_p07_w0 selb_69500 ref_p07_w0 vdd sky130_fd_pr__pfet_01v8 L=0.15 W=2 nf=1 ad=0.58 as=0.58 pd=4.58 ps=4.58 nrd=0.145 nrs=0.145 sa=0 sb=0 sd=0 mult=1 m=1
XMN1_p07_w0 sbl_p07_w0 sref_p07_w0 vn_p07_w0 0 sky130_fd_pr__nfet_01v8 L=0.15 W=1 nf=1 ad=0.29 as=0.29 pd=2.58 ps=2.58 nrd=0.29 nrs=0.29 sa=0 sb=0 sd=0 mult=1 m=1
XMN2_p07_w0 sref_p07_w0 sbl_p07_w0 vn_p07_w0 0 sky130_fd_pr__nfet_01v8 L=0.15 W=1 nf=1 ad=0.29 as=0.29 pd=2.58 ps=2.58 nrd=0.29 nrs=0.29 sa=0 sb=0 sd=0 mult=1 m=1
XMP1_p07_w0 sbl_p07_w0 sref_p07_w0 vp_p07_w0 vdd sky130_fd_pr__pfet_01v8 L=0.15 W=2 nf=1 ad=0.58 as=0.58 pd=4.58 ps=4.58 nrd=0.145 nrs=0.145 sa=0 sb=0 sd=0 mult=1 m=1
XMP2_p07_w0 sref_p07_w0 sbl_p07_w0 vp_p07_w0 vdd sky130_fd_pr__pfet_01v8 L=0.15 W=2 nf=1 ad=0.58 as=0.58 pd=4.58 ps=4.58 nrd=0.145 nrs=0.145 sa=0 sb=0 sd=0 mult=1 m=1
XMNF_p07_w0 vn_p07_w0 en 0 0 sky130_fd_pr__nfet_01v8 L=0.15 W=2 nf=1 ad=0.58 as=0.58 pd=4.58 ps=4.58 nrd=0.145 nrs=0.145 sa=0 sb=0 sd=0 mult=1 m=1
XMPH_p07_w0 vp_p07_w0 enb vdd vdd sky130_fd_pr__pfet_01v8 L=0.15 W=4 nf=1 ad=1.16 as=1.16 pd=8.58 ps=8.58 nrd=0.0725 nrs=0.0725 sa=0 sb=0 sd=0 mult=1 m=1
bd_p07_w0 d_p07_w0 0 v=v(sbl_p07_w0)-v(sref_p07_w0)
bdabs_p07_w0 dabs_p07_w0 0 v=abs(v(sbl_p07_w0)-v(sref_p07_w0))

* ---- instance 82: p08_w1 (matched ref precharge, release edge 0.5 ns) ----
XMWR_p08_w1_0 sn_p08_w1_0 wl wbl_p08_w1 0 sky130_fd_pr__nfet_01v8 L=0.15 W=0.42 nf=1 ad=0.1218 as=0.1218 pd=1.42 ps=1.42 nrd=0.69047619047619 nrs=0.69047619047619 sa=0 sb=0 sd=0 mult=1 m=1
XMRD_p08_w1_0 rbl_p08_w1 sn_p08_w1_0 rwl_sel 0 sky130_fd_pr__nfet_01v8 L=0.15 W=0.42 nf=1 ad=0.1218 as=0.1218 pd=1.42 ps=1.42 nrd=0.69047619047619 nrs=0.69047619047619 sa=0 sb=0 sd=0 mult=1 m=1
csn_p08_w1_0 sn_p08_w1_0 0 {C_SN}
XMWR_p08_w1_1 sn_p08_w1_1 0 wbl_p08_w1 0 sky130_fd_pr__nfet_01v8 L=0.15 W=0.42 nf=1 ad=0.1218 as=0.1218 pd=1.42 ps=1.42 nrd=0.69047619047619 nrs=0.69047619047619 sa=0 sb=0 sd=0 mult=1 m=1
XMRD_p08_w1_1 rbl_p08_w1 sn_p08_w1_1 rwl_des 0 sky130_fd_pr__nfet_01v8 L=0.15 W=0.42 nf=1 ad=0.1218 as=0.1218 pd=1.42 ps=1.42 nrd=0.69047619047619 nrs=0.69047619047619 sa=0 sb=0 sd=0 mult=1 m=1
csn_p08_w1_1 sn_p08_w1_1 0 {C_SN}
XMWR_p08_w1_2 sn_p08_w1_2 0 wbl_p08_w1 0 sky130_fd_pr__nfet_01v8 L=0.15 W=0.42 nf=1 ad=0.1218 as=0.1218 pd=1.42 ps=1.42 nrd=0.69047619047619 nrs=0.69047619047619 sa=0 sb=0 sd=0 mult=1 m=1
XMRD_p08_w1_2 rbl_p08_w1 sn_p08_w1_2 rwl_des 0 sky130_fd_pr__nfet_01v8 L=0.15 W=0.42 nf=1 ad=0.1218 as=0.1218 pd=1.42 ps=1.42 nrd=0.69047619047619 nrs=0.69047619047619 sa=0 sb=0 sd=0 mult=1 m=1
csn_p08_w1_2 sn_p08_w1_2 0 {C_SN}
XMWR_p08_w1_3 sn_p08_w1_3 0 wbl_p08_w1 0 sky130_fd_pr__nfet_01v8 L=0.15 W=0.42 nf=1 ad=0.1218 as=0.1218 pd=1.42 ps=1.42 nrd=0.69047619047619 nrs=0.69047619047619 sa=0 sb=0 sd=0 mult=1 m=1
XMRD_p08_w1_3 rbl_p08_w1 sn_p08_w1_3 rwl_des 0 sky130_fd_pr__nfet_01v8 L=0.15 W=0.42 nf=1 ad=0.1218 as=0.1218 pd=1.42 ps=1.42 nrd=0.69047619047619 nrs=0.69047619047619 sa=0 sb=0 sd=0 mult=1 m=1
csn_p08_w1_3 sn_p08_w1_3 0 {C_SN}
crbl_p08_w1 rbl_p08_w1 0 {C_RBL}
cwbl_p08_w1 wbl_p08_w1 0 {C_WBL}
cref_p08_w1 ref_p08_w1 0 {C_RBL}   $ ASSUMPTION: ideal matched dummy load
XMPPRE_p08_w1 rbl_p08_w1 pcb_500 prea prea sky130_fd_pr__pfet_01v8 L=0.15 W=4 nf=1 ad=1.16 as=1.16 pd=8.58 ps=8.58 nrd=0.0725 nrs=0.0725 sa=0 sb=0 sd=0 mult=1 m=1
XMPU1_p08_w1 x_p08_w1 dinb1 vdd vdd sky130_fd_pr__pfet_01v8 L=0.15 W=1 nf=1 ad=0.29 as=0.29 pd=2.58 ps=2.58 nrd=0.29 nrs=0.29 sa=0 sb=0 sd=0 mult=1 m=1
XMPU2_p08_w1 wbl_p08_w1 wenb x_p08_w1 vdd sky130_fd_pr__pfet_01v8 L=0.15 W=1 nf=1 ad=0.29 as=0.29 pd=2.58 ps=2.58 nrd=0.29 nrs=0.29 sa=0 sb=0 sd=0 mult=1 m=1
XMND2_p08_w1 wbl_p08_w1 wen y_p08_w1 0 sky130_fd_pr__nfet_01v8 L=0.15 W=0.5 nf=1 ad=0.145 as=0.145 pd=1.58 ps=1.58 nrd=0.58 nrs=0.58 sa=0 sb=0 sd=0 mult=1 m=1
XMND1_p08_w1 y_p08_w1 dinb1 0 0 sky130_fd_pr__nfet_01v8 L=0.15 W=0.5 nf=1 ad=0.145 as=0.145 pd=1.58 ps=1.58 nrd=0.58 nrs=0.58 sa=0 sb=0 sd=0 mult=1 m=1
XMNI_p08_w1 wbl_p08_w1 wenb 0 0 sky130_fd_pr__nfet_01v8 L=0.15 W=0.42 nf=1 ad=0.1218 as=0.1218 pd=1.42 ps=1.42 nrd=0.69047619047619 nrs=0.69047619047619 sa=0 sb=0 sd=0 mult=1 m=1
XMNS_p08_w1 sbl_p08_w1 sel_69500 rbl_p08_w1 0 sky130_fd_pr__nfet_01v8 L=0.15 W=1 nf=1 ad=0.29 as=0.29 pd=2.58 ps=2.58 nrd=0.29 nrs=0.29 sa=0 sb=0 sd=0 mult=1 m=1
XMPS_p08_w1 sbl_p08_w1 selb_69500 rbl_p08_w1 vdd sky130_fd_pr__pfet_01v8 L=0.15 W=2 nf=1 ad=0.58 as=0.58 pd=4.58 ps=4.58 nrd=0.145 nrs=0.145 sa=0 sb=0 sd=0 mult=1 m=1
XMNSR_p08_w1 sref_p08_w1 sel_69500 ref_p08_w1 0 sky130_fd_pr__nfet_01v8 L=0.15 W=1 nf=1 ad=0.29 as=0.29 pd=2.58 ps=2.58 nrd=0.29 nrs=0.29 sa=0 sb=0 sd=0 mult=1 m=1
XMPSR_p08_w1 sref_p08_w1 selb_69500 ref_p08_w1 vdd sky130_fd_pr__pfet_01v8 L=0.15 W=2 nf=1 ad=0.58 as=0.58 pd=4.58 ps=4.58 nrd=0.145 nrs=0.145 sa=0 sb=0 sd=0 mult=1 m=1
XMPPREF_p08_w1 ref_p08_w1 pcb_500 pref pref sky130_fd_pr__pfet_01v8 L=0.15 W=4 nf=1 ad=1.16 as=1.16 pd=8.58 ps=8.58 nrd=0.0725 nrs=0.0725 sa=0 sb=0 sd=0 mult=1 m=1   $ reference-side precharge: copy of MPPRE
XMN1_p08_w1 sbl_p08_w1 sref_p08_w1 vn_p08_w1 0 sky130_fd_pr__nfet_01v8 L=0.15 W=1 nf=1 ad=0.29 as=0.29 pd=2.58 ps=2.58 nrd=0.29 nrs=0.29 sa=0 sb=0 sd=0 mult=1 m=1
XMN2_p08_w1 sref_p08_w1 sbl_p08_w1 vn_p08_w1 0 sky130_fd_pr__nfet_01v8 L=0.15 W=1 nf=1 ad=0.29 as=0.29 pd=2.58 ps=2.58 nrd=0.29 nrs=0.29 sa=0 sb=0 sd=0 mult=1 m=1
XMP1_p08_w1 sbl_p08_w1 sref_p08_w1 vp_p08_w1 vdd sky130_fd_pr__pfet_01v8 L=0.15 W=2 nf=1 ad=0.58 as=0.58 pd=4.58 ps=4.58 nrd=0.145 nrs=0.145 sa=0 sb=0 sd=0 mult=1 m=1
XMP2_p08_w1 sref_p08_w1 sbl_p08_w1 vp_p08_w1 vdd sky130_fd_pr__pfet_01v8 L=0.15 W=2 nf=1 ad=0.58 as=0.58 pd=4.58 ps=4.58 nrd=0.145 nrs=0.145 sa=0 sb=0 sd=0 mult=1 m=1
XMNF_p08_w1 vn_p08_w1 en 0 0 sky130_fd_pr__nfet_01v8 L=0.15 W=2 nf=1 ad=0.58 as=0.58 pd=4.58 ps=4.58 nrd=0.145 nrs=0.145 sa=0 sb=0 sd=0 mult=1 m=1
XMPH_p08_w1 vp_p08_w1 enb vdd vdd sky130_fd_pr__pfet_01v8 L=0.15 W=4 nf=1 ad=1.16 as=1.16 pd=8.58 ps=8.58 nrd=0.0725 nrs=0.0725 sa=0 sb=0 sd=0 mult=1 m=1
bd_p08_w1 d_p08_w1 0 v=v(sbl_p08_w1)-v(sref_p08_w1)
bdabs_p08_w1 dabs_p08_w1 0 v=abs(v(sbl_p08_w1)-v(sref_p08_w1))

* ---- instance 83: p08_w0 (matched ref precharge, release edge 0.5 ns) ----
XMWR_p08_w0_0 sn_p08_w0_0 wl wbl_p08_w0 0 sky130_fd_pr__nfet_01v8 L=0.15 W=0.42 nf=1 ad=0.1218 as=0.1218 pd=1.42 ps=1.42 nrd=0.69047619047619 nrs=0.69047619047619 sa=0 sb=0 sd=0 mult=1 m=1
XMRD_p08_w0_0 rbl_p08_w0 sn_p08_w0_0 rwl_sel 0 sky130_fd_pr__nfet_01v8 L=0.15 W=0.42 nf=1 ad=0.1218 as=0.1218 pd=1.42 ps=1.42 nrd=0.69047619047619 nrs=0.69047619047619 sa=0 sb=0 sd=0 mult=1 m=1
csn_p08_w0_0 sn_p08_w0_0 0 {C_SN}
XMWR_p08_w0_1 sn_p08_w0_1 0 wbl_p08_w0 0 sky130_fd_pr__nfet_01v8 L=0.15 W=0.42 nf=1 ad=0.1218 as=0.1218 pd=1.42 ps=1.42 nrd=0.69047619047619 nrs=0.69047619047619 sa=0 sb=0 sd=0 mult=1 m=1
XMRD_p08_w0_1 rbl_p08_w0 sn_p08_w0_1 rwl_des 0 sky130_fd_pr__nfet_01v8 L=0.15 W=0.42 nf=1 ad=0.1218 as=0.1218 pd=1.42 ps=1.42 nrd=0.69047619047619 nrs=0.69047619047619 sa=0 sb=0 sd=0 mult=1 m=1
csn_p08_w0_1 sn_p08_w0_1 0 {C_SN}
XMWR_p08_w0_2 sn_p08_w0_2 0 wbl_p08_w0 0 sky130_fd_pr__nfet_01v8 L=0.15 W=0.42 nf=1 ad=0.1218 as=0.1218 pd=1.42 ps=1.42 nrd=0.69047619047619 nrs=0.69047619047619 sa=0 sb=0 sd=0 mult=1 m=1
XMRD_p08_w0_2 rbl_p08_w0 sn_p08_w0_2 rwl_des 0 sky130_fd_pr__nfet_01v8 L=0.15 W=0.42 nf=1 ad=0.1218 as=0.1218 pd=1.42 ps=1.42 nrd=0.69047619047619 nrs=0.69047619047619 sa=0 sb=0 sd=0 mult=1 m=1
csn_p08_w0_2 sn_p08_w0_2 0 {C_SN}
XMWR_p08_w0_3 sn_p08_w0_3 0 wbl_p08_w0 0 sky130_fd_pr__nfet_01v8 L=0.15 W=0.42 nf=1 ad=0.1218 as=0.1218 pd=1.42 ps=1.42 nrd=0.69047619047619 nrs=0.69047619047619 sa=0 sb=0 sd=0 mult=1 m=1
XMRD_p08_w0_3 rbl_p08_w0 sn_p08_w0_3 rwl_des 0 sky130_fd_pr__nfet_01v8 L=0.15 W=0.42 nf=1 ad=0.1218 as=0.1218 pd=1.42 ps=1.42 nrd=0.69047619047619 nrs=0.69047619047619 sa=0 sb=0 sd=0 mult=1 m=1
csn_p08_w0_3 sn_p08_w0_3 0 {C_SN}
crbl_p08_w0 rbl_p08_w0 0 {C_RBL}
cwbl_p08_w0 wbl_p08_w0 0 {C_WBL}
cref_p08_w0 ref_p08_w0 0 {C_RBL}   $ ASSUMPTION: ideal matched dummy load
XMPPRE_p08_w0 rbl_p08_w0 pcb_500 prea prea sky130_fd_pr__pfet_01v8 L=0.15 W=4 nf=1 ad=1.16 as=1.16 pd=8.58 ps=8.58 nrd=0.0725 nrs=0.0725 sa=0 sb=0 sd=0 mult=1 m=1
XMPU1_p08_w0 x_p08_w0 dinb0 vdd vdd sky130_fd_pr__pfet_01v8 L=0.15 W=1 nf=1 ad=0.29 as=0.29 pd=2.58 ps=2.58 nrd=0.29 nrs=0.29 sa=0 sb=0 sd=0 mult=1 m=1
XMPU2_p08_w0 wbl_p08_w0 wenb x_p08_w0 vdd sky130_fd_pr__pfet_01v8 L=0.15 W=1 nf=1 ad=0.29 as=0.29 pd=2.58 ps=2.58 nrd=0.29 nrs=0.29 sa=0 sb=0 sd=0 mult=1 m=1
XMND2_p08_w0 wbl_p08_w0 wen y_p08_w0 0 sky130_fd_pr__nfet_01v8 L=0.15 W=0.5 nf=1 ad=0.145 as=0.145 pd=1.58 ps=1.58 nrd=0.58 nrs=0.58 sa=0 sb=0 sd=0 mult=1 m=1
XMND1_p08_w0 y_p08_w0 dinb0 0 0 sky130_fd_pr__nfet_01v8 L=0.15 W=0.5 nf=1 ad=0.145 as=0.145 pd=1.58 ps=1.58 nrd=0.58 nrs=0.58 sa=0 sb=0 sd=0 mult=1 m=1
XMNI_p08_w0 wbl_p08_w0 wenb 0 0 sky130_fd_pr__nfet_01v8 L=0.15 W=0.42 nf=1 ad=0.1218 as=0.1218 pd=1.42 ps=1.42 nrd=0.69047619047619 nrs=0.69047619047619 sa=0 sb=0 sd=0 mult=1 m=1
XMNS_p08_w0 sbl_p08_w0 sel_69500 rbl_p08_w0 0 sky130_fd_pr__nfet_01v8 L=0.15 W=1 nf=1 ad=0.29 as=0.29 pd=2.58 ps=2.58 nrd=0.29 nrs=0.29 sa=0 sb=0 sd=0 mult=1 m=1
XMPS_p08_w0 sbl_p08_w0 selb_69500 rbl_p08_w0 vdd sky130_fd_pr__pfet_01v8 L=0.15 W=2 nf=1 ad=0.58 as=0.58 pd=4.58 ps=4.58 nrd=0.145 nrs=0.145 sa=0 sb=0 sd=0 mult=1 m=1
XMNSR_p08_w0 sref_p08_w0 sel_69500 ref_p08_w0 0 sky130_fd_pr__nfet_01v8 L=0.15 W=1 nf=1 ad=0.29 as=0.29 pd=2.58 ps=2.58 nrd=0.29 nrs=0.29 sa=0 sb=0 sd=0 mult=1 m=1
XMPSR_p08_w0 sref_p08_w0 selb_69500 ref_p08_w0 vdd sky130_fd_pr__pfet_01v8 L=0.15 W=2 nf=1 ad=0.58 as=0.58 pd=4.58 ps=4.58 nrd=0.145 nrs=0.145 sa=0 sb=0 sd=0 mult=1 m=1
XMPPREF_p08_w0 ref_p08_w0 pcb_500 pref pref sky130_fd_pr__pfet_01v8 L=0.15 W=4 nf=1 ad=1.16 as=1.16 pd=8.58 ps=8.58 nrd=0.0725 nrs=0.0725 sa=0 sb=0 sd=0 mult=1 m=1   $ reference-side precharge: copy of MPPRE
XMN1_p08_w0 sbl_p08_w0 sref_p08_w0 vn_p08_w0 0 sky130_fd_pr__nfet_01v8 L=0.15 W=1 nf=1 ad=0.29 as=0.29 pd=2.58 ps=2.58 nrd=0.29 nrs=0.29 sa=0 sb=0 sd=0 mult=1 m=1
XMN2_p08_w0 sref_p08_w0 sbl_p08_w0 vn_p08_w0 0 sky130_fd_pr__nfet_01v8 L=0.15 W=1 nf=1 ad=0.29 as=0.29 pd=2.58 ps=2.58 nrd=0.29 nrs=0.29 sa=0 sb=0 sd=0 mult=1 m=1
XMP1_p08_w0 sbl_p08_w0 sref_p08_w0 vp_p08_w0 vdd sky130_fd_pr__pfet_01v8 L=0.15 W=2 nf=1 ad=0.58 as=0.58 pd=4.58 ps=4.58 nrd=0.145 nrs=0.145 sa=0 sb=0 sd=0 mult=1 m=1
XMP2_p08_w0 sref_p08_w0 sbl_p08_w0 vp_p08_w0 vdd sky130_fd_pr__pfet_01v8 L=0.15 W=2 nf=1 ad=0.58 as=0.58 pd=4.58 ps=4.58 nrd=0.145 nrs=0.145 sa=0 sb=0 sd=0 mult=1 m=1
XMNF_p08_w0 vn_p08_w0 en 0 0 sky130_fd_pr__nfet_01v8 L=0.15 W=2 nf=1 ad=0.58 as=0.58 pd=4.58 ps=4.58 nrd=0.145 nrs=0.145 sa=0 sb=0 sd=0 mult=1 m=1
XMPH_p08_w0 vp_p08_w0 enb vdd vdd sky130_fd_pr__pfet_01v8 L=0.15 W=4 nf=1 ad=1.16 as=1.16 pd=8.58 ps=8.58 nrd=0.0725 nrs=0.0725 sa=0 sb=0 sd=0 mult=1 m=1
bd_p08_w0 d_p08_w0 0 v=v(sbl_p08_w0)-v(sref_p08_w0)
bdabs_p08_w0 dabs_p08_w0 0 v=abs(v(sbl_p08_w0)-v(sref_p08_w0))

* ---- instance 84: c00_w1 (nfet-only 0.42, matched ref precharge) ----
XMWR_c00_w1_0 sn_c00_w1_0 wl wbl_c00_w1 0 sky130_fd_pr__nfet_01v8 L=0.15 W=0.42 nf=1 ad=0.1218 as=0.1218 pd=1.42 ps=1.42 nrd=0.69047619047619 nrs=0.69047619047619 sa=0 sb=0 sd=0 mult=1 m=1
XMRD_c00_w1_0 rbl_c00_w1 sn_c00_w1_0 rwl_sel 0 sky130_fd_pr__nfet_01v8 L=0.15 W=0.42 nf=1 ad=0.1218 as=0.1218 pd=1.42 ps=1.42 nrd=0.69047619047619 nrs=0.69047619047619 sa=0 sb=0 sd=0 mult=1 m=1
csn_c00_w1_0 sn_c00_w1_0 0 {C_SN}
XMWR_c00_w1_1 sn_c00_w1_1 0 wbl_c00_w1 0 sky130_fd_pr__nfet_01v8 L=0.15 W=0.42 nf=1 ad=0.1218 as=0.1218 pd=1.42 ps=1.42 nrd=0.69047619047619 nrs=0.69047619047619 sa=0 sb=0 sd=0 mult=1 m=1
XMRD_c00_w1_1 rbl_c00_w1 sn_c00_w1_1 rwl_des 0 sky130_fd_pr__nfet_01v8 L=0.15 W=0.42 nf=1 ad=0.1218 as=0.1218 pd=1.42 ps=1.42 nrd=0.69047619047619 nrs=0.69047619047619 sa=0 sb=0 sd=0 mult=1 m=1
csn_c00_w1_1 sn_c00_w1_1 0 {C_SN}
XMWR_c00_w1_2 sn_c00_w1_2 0 wbl_c00_w1 0 sky130_fd_pr__nfet_01v8 L=0.15 W=0.42 nf=1 ad=0.1218 as=0.1218 pd=1.42 ps=1.42 nrd=0.69047619047619 nrs=0.69047619047619 sa=0 sb=0 sd=0 mult=1 m=1
XMRD_c00_w1_2 rbl_c00_w1 sn_c00_w1_2 rwl_des 0 sky130_fd_pr__nfet_01v8 L=0.15 W=0.42 nf=1 ad=0.1218 as=0.1218 pd=1.42 ps=1.42 nrd=0.69047619047619 nrs=0.69047619047619 sa=0 sb=0 sd=0 mult=1 m=1
csn_c00_w1_2 sn_c00_w1_2 0 {C_SN}
XMWR_c00_w1_3 sn_c00_w1_3 0 wbl_c00_w1 0 sky130_fd_pr__nfet_01v8 L=0.15 W=0.42 nf=1 ad=0.1218 as=0.1218 pd=1.42 ps=1.42 nrd=0.69047619047619 nrs=0.69047619047619 sa=0 sb=0 sd=0 mult=1 m=1
XMRD_c00_w1_3 rbl_c00_w1 sn_c00_w1_3 rwl_des 0 sky130_fd_pr__nfet_01v8 L=0.15 W=0.42 nf=1 ad=0.1218 as=0.1218 pd=1.42 ps=1.42 nrd=0.69047619047619 nrs=0.69047619047619 sa=0 sb=0 sd=0 mult=1 m=1
csn_c00_w1_3 sn_c00_w1_3 0 {C_SN}
crbl_c00_w1 rbl_c00_w1 0 {C_RBL}
cwbl_c00_w1 wbl_c00_w1 0 {C_WBL}
cref_c00_w1 ref_c00_w1 0 {C_RBL}   $ ASSUMPTION: ideal matched dummy load
XMPPRE_c00_w1 rbl_c00_w1 pcb_100 prea prea sky130_fd_pr__pfet_01v8 L=0.15 W=4 nf=1 ad=1.16 as=1.16 pd=8.58 ps=8.58 nrd=0.0725 nrs=0.0725 sa=0 sb=0 sd=0 mult=1 m=1
XMPU1_c00_w1 x_c00_w1 dinb1 vdd vdd sky130_fd_pr__pfet_01v8 L=0.15 W=1 nf=1 ad=0.29 as=0.29 pd=2.58 ps=2.58 nrd=0.29 nrs=0.29 sa=0 sb=0 sd=0 mult=1 m=1
XMPU2_c00_w1 wbl_c00_w1 wenb x_c00_w1 vdd sky130_fd_pr__pfet_01v8 L=0.15 W=1 nf=1 ad=0.29 as=0.29 pd=2.58 ps=2.58 nrd=0.29 nrs=0.29 sa=0 sb=0 sd=0 mult=1 m=1
XMND2_c00_w1 wbl_c00_w1 wen y_c00_w1 0 sky130_fd_pr__nfet_01v8 L=0.15 W=0.5 nf=1 ad=0.145 as=0.145 pd=1.58 ps=1.58 nrd=0.58 nrs=0.58 sa=0 sb=0 sd=0 mult=1 m=1
XMND1_c00_w1 y_c00_w1 dinb1 0 0 sky130_fd_pr__nfet_01v8 L=0.15 W=0.5 nf=1 ad=0.145 as=0.145 pd=1.58 ps=1.58 nrd=0.58 nrs=0.58 sa=0 sb=0 sd=0 mult=1 m=1
XMNI_c00_w1 wbl_c00_w1 wenb 0 0 sky130_fd_pr__nfet_01v8 L=0.15 W=0.42 nf=1 ad=0.1218 as=0.1218 pd=1.42 ps=1.42 nrd=0.69047619047619 nrs=0.69047619047619 sa=0 sb=0 sd=0 mult=1 m=1
XMNS_c00_w1 sbl_c00_w1 sel_69500 rbl_c00_w1 0 sky130_fd_pr__nfet_01v8 L=0.15 W=0.42 nf=1 ad=0.1218 as=0.1218 pd=1.42 ps=1.42 nrd=0.69047619047619 nrs=0.69047619047619 sa=0 sb=0 sd=0 mult=1 m=1
XMNSR_c00_w1 sref_c00_w1 sel_69500 ref_c00_w1 0 sky130_fd_pr__nfet_01v8 L=0.15 W=0.42 nf=1 ad=0.1218 as=0.1218 pd=1.42 ps=1.42 nrd=0.69047619047619 nrs=0.69047619047619 sa=0 sb=0 sd=0 mult=1 m=1
XMPPREF_c00_w1 ref_c00_w1 pcb_100 pref pref sky130_fd_pr__pfet_01v8 L=0.15 W=4 nf=1 ad=1.16 as=1.16 pd=8.58 ps=8.58 nrd=0.0725 nrs=0.0725 sa=0 sb=0 sd=0 mult=1 m=1   $ reference-side precharge: copy of MPPRE
XMN1_c00_w1 sbl_c00_w1 sref_c00_w1 vn_c00_w1 0 sky130_fd_pr__nfet_01v8 L=0.15 W=1 nf=1 ad=0.29 as=0.29 pd=2.58 ps=2.58 nrd=0.29 nrs=0.29 sa=0 sb=0 sd=0 mult=1 m=1
XMN2_c00_w1 sref_c00_w1 sbl_c00_w1 vn_c00_w1 0 sky130_fd_pr__nfet_01v8 L=0.15 W=1 nf=1 ad=0.29 as=0.29 pd=2.58 ps=2.58 nrd=0.29 nrs=0.29 sa=0 sb=0 sd=0 mult=1 m=1
XMP1_c00_w1 sbl_c00_w1 sref_c00_w1 vp_c00_w1 vdd sky130_fd_pr__pfet_01v8 L=0.15 W=2 nf=1 ad=0.58 as=0.58 pd=4.58 ps=4.58 nrd=0.145 nrs=0.145 sa=0 sb=0 sd=0 mult=1 m=1
XMP2_c00_w1 sref_c00_w1 sbl_c00_w1 vp_c00_w1 vdd sky130_fd_pr__pfet_01v8 L=0.15 W=2 nf=1 ad=0.58 as=0.58 pd=4.58 ps=4.58 nrd=0.145 nrs=0.145 sa=0 sb=0 sd=0 mult=1 m=1
XMNF_c00_w1 vn_c00_w1 en 0 0 sky130_fd_pr__nfet_01v8 L=0.15 W=2 nf=1 ad=0.58 as=0.58 pd=4.58 ps=4.58 nrd=0.145 nrs=0.145 sa=0 sb=0 sd=0 mult=1 m=1
XMPH_c00_w1 vp_c00_w1 enb vdd vdd sky130_fd_pr__pfet_01v8 L=0.15 W=4 nf=1 ad=1.16 as=1.16 pd=8.58 ps=8.58 nrd=0.0725 nrs=0.0725 sa=0 sb=0 sd=0 mult=1 m=1
bd_c00_w1 d_c00_w1 0 v=v(sbl_c00_w1)-v(sref_c00_w1)
bdabs_c00_w1 dabs_c00_w1 0 v=abs(v(sbl_c00_w1)-v(sref_c00_w1))

* ---- instance 85: c00_w0 (nfet-only 0.42, matched ref precharge) ----
XMWR_c00_w0_0 sn_c00_w0_0 wl wbl_c00_w0 0 sky130_fd_pr__nfet_01v8 L=0.15 W=0.42 nf=1 ad=0.1218 as=0.1218 pd=1.42 ps=1.42 nrd=0.69047619047619 nrs=0.69047619047619 sa=0 sb=0 sd=0 mult=1 m=1
XMRD_c00_w0_0 rbl_c00_w0 sn_c00_w0_0 rwl_sel 0 sky130_fd_pr__nfet_01v8 L=0.15 W=0.42 nf=1 ad=0.1218 as=0.1218 pd=1.42 ps=1.42 nrd=0.69047619047619 nrs=0.69047619047619 sa=0 sb=0 sd=0 mult=1 m=1
csn_c00_w0_0 sn_c00_w0_0 0 {C_SN}
XMWR_c00_w0_1 sn_c00_w0_1 0 wbl_c00_w0 0 sky130_fd_pr__nfet_01v8 L=0.15 W=0.42 nf=1 ad=0.1218 as=0.1218 pd=1.42 ps=1.42 nrd=0.69047619047619 nrs=0.69047619047619 sa=0 sb=0 sd=0 mult=1 m=1
XMRD_c00_w0_1 rbl_c00_w0 sn_c00_w0_1 rwl_des 0 sky130_fd_pr__nfet_01v8 L=0.15 W=0.42 nf=1 ad=0.1218 as=0.1218 pd=1.42 ps=1.42 nrd=0.69047619047619 nrs=0.69047619047619 sa=0 sb=0 sd=0 mult=1 m=1
csn_c00_w0_1 sn_c00_w0_1 0 {C_SN}
XMWR_c00_w0_2 sn_c00_w0_2 0 wbl_c00_w0 0 sky130_fd_pr__nfet_01v8 L=0.15 W=0.42 nf=1 ad=0.1218 as=0.1218 pd=1.42 ps=1.42 nrd=0.69047619047619 nrs=0.69047619047619 sa=0 sb=0 sd=0 mult=1 m=1
XMRD_c00_w0_2 rbl_c00_w0 sn_c00_w0_2 rwl_des 0 sky130_fd_pr__nfet_01v8 L=0.15 W=0.42 nf=1 ad=0.1218 as=0.1218 pd=1.42 ps=1.42 nrd=0.69047619047619 nrs=0.69047619047619 sa=0 sb=0 sd=0 mult=1 m=1
csn_c00_w0_2 sn_c00_w0_2 0 {C_SN}
XMWR_c00_w0_3 sn_c00_w0_3 0 wbl_c00_w0 0 sky130_fd_pr__nfet_01v8 L=0.15 W=0.42 nf=1 ad=0.1218 as=0.1218 pd=1.42 ps=1.42 nrd=0.69047619047619 nrs=0.69047619047619 sa=0 sb=0 sd=0 mult=1 m=1
XMRD_c00_w0_3 rbl_c00_w0 sn_c00_w0_3 rwl_des 0 sky130_fd_pr__nfet_01v8 L=0.15 W=0.42 nf=1 ad=0.1218 as=0.1218 pd=1.42 ps=1.42 nrd=0.69047619047619 nrs=0.69047619047619 sa=0 sb=0 sd=0 mult=1 m=1
csn_c00_w0_3 sn_c00_w0_3 0 {C_SN}
crbl_c00_w0 rbl_c00_w0 0 {C_RBL}
cwbl_c00_w0 wbl_c00_w0 0 {C_WBL}
cref_c00_w0 ref_c00_w0 0 {C_RBL}   $ ASSUMPTION: ideal matched dummy load
XMPPRE_c00_w0 rbl_c00_w0 pcb_100 prea prea sky130_fd_pr__pfet_01v8 L=0.15 W=4 nf=1 ad=1.16 as=1.16 pd=8.58 ps=8.58 nrd=0.0725 nrs=0.0725 sa=0 sb=0 sd=0 mult=1 m=1
XMPU1_c00_w0 x_c00_w0 dinb0 vdd vdd sky130_fd_pr__pfet_01v8 L=0.15 W=1 nf=1 ad=0.29 as=0.29 pd=2.58 ps=2.58 nrd=0.29 nrs=0.29 sa=0 sb=0 sd=0 mult=1 m=1
XMPU2_c00_w0 wbl_c00_w0 wenb x_c00_w0 vdd sky130_fd_pr__pfet_01v8 L=0.15 W=1 nf=1 ad=0.29 as=0.29 pd=2.58 ps=2.58 nrd=0.29 nrs=0.29 sa=0 sb=0 sd=0 mult=1 m=1
XMND2_c00_w0 wbl_c00_w0 wen y_c00_w0 0 sky130_fd_pr__nfet_01v8 L=0.15 W=0.5 nf=1 ad=0.145 as=0.145 pd=1.58 ps=1.58 nrd=0.58 nrs=0.58 sa=0 sb=0 sd=0 mult=1 m=1
XMND1_c00_w0 y_c00_w0 dinb0 0 0 sky130_fd_pr__nfet_01v8 L=0.15 W=0.5 nf=1 ad=0.145 as=0.145 pd=1.58 ps=1.58 nrd=0.58 nrs=0.58 sa=0 sb=0 sd=0 mult=1 m=1
XMNI_c00_w0 wbl_c00_w0 wenb 0 0 sky130_fd_pr__nfet_01v8 L=0.15 W=0.42 nf=1 ad=0.1218 as=0.1218 pd=1.42 ps=1.42 nrd=0.69047619047619 nrs=0.69047619047619 sa=0 sb=0 sd=0 mult=1 m=1
XMNS_c00_w0 sbl_c00_w0 sel_69500 rbl_c00_w0 0 sky130_fd_pr__nfet_01v8 L=0.15 W=0.42 nf=1 ad=0.1218 as=0.1218 pd=1.42 ps=1.42 nrd=0.69047619047619 nrs=0.69047619047619 sa=0 sb=0 sd=0 mult=1 m=1
XMNSR_c00_w0 sref_c00_w0 sel_69500 ref_c00_w0 0 sky130_fd_pr__nfet_01v8 L=0.15 W=0.42 nf=1 ad=0.1218 as=0.1218 pd=1.42 ps=1.42 nrd=0.69047619047619 nrs=0.69047619047619 sa=0 sb=0 sd=0 mult=1 m=1
XMPPREF_c00_w0 ref_c00_w0 pcb_100 pref pref sky130_fd_pr__pfet_01v8 L=0.15 W=4 nf=1 ad=1.16 as=1.16 pd=8.58 ps=8.58 nrd=0.0725 nrs=0.0725 sa=0 sb=0 sd=0 mult=1 m=1   $ reference-side precharge: copy of MPPRE
XMN1_c00_w0 sbl_c00_w0 sref_c00_w0 vn_c00_w0 0 sky130_fd_pr__nfet_01v8 L=0.15 W=1 nf=1 ad=0.29 as=0.29 pd=2.58 ps=2.58 nrd=0.29 nrs=0.29 sa=0 sb=0 sd=0 mult=1 m=1
XMN2_c00_w0 sref_c00_w0 sbl_c00_w0 vn_c00_w0 0 sky130_fd_pr__nfet_01v8 L=0.15 W=1 nf=1 ad=0.29 as=0.29 pd=2.58 ps=2.58 nrd=0.29 nrs=0.29 sa=0 sb=0 sd=0 mult=1 m=1
XMP1_c00_w0 sbl_c00_w0 sref_c00_w0 vp_c00_w0 vdd sky130_fd_pr__pfet_01v8 L=0.15 W=2 nf=1 ad=0.58 as=0.58 pd=4.58 ps=4.58 nrd=0.145 nrs=0.145 sa=0 sb=0 sd=0 mult=1 m=1
XMP2_c00_w0 sref_c00_w0 sbl_c00_w0 vp_c00_w0 vdd sky130_fd_pr__pfet_01v8 L=0.15 W=2 nf=1 ad=0.58 as=0.58 pd=4.58 ps=4.58 nrd=0.145 nrs=0.145 sa=0 sb=0 sd=0 mult=1 m=1
XMNF_c00_w0 vn_c00_w0 en 0 0 sky130_fd_pr__nfet_01v8 L=0.15 W=2 nf=1 ad=0.58 as=0.58 pd=4.58 ps=4.58 nrd=0.145 nrs=0.145 sa=0 sb=0 sd=0 mult=1 m=1
XMPH_c00_w0 vp_c00_w0 enb vdd vdd sky130_fd_pr__pfet_01v8 L=0.15 W=4 nf=1 ad=1.16 as=1.16 pd=8.58 ps=8.58 nrd=0.0725 nrs=0.0725 sa=0 sb=0 sd=0 mult=1 m=1
bd_c00_w0 d_c00_w0 0 v=v(sbl_c00_w0)-v(sref_c00_w0)
bdabs_c00_w0 dabs_c00_w0 0 v=abs(v(sbl_c00_w0)-v(sref_c00_w0))

* ---- instance 86: c01_w1 (nfet-only 0.42, matched ref, release edge 0.5 ns) ----
XMWR_c01_w1_0 sn_c01_w1_0 wl wbl_c01_w1 0 sky130_fd_pr__nfet_01v8 L=0.15 W=0.42 nf=1 ad=0.1218 as=0.1218 pd=1.42 ps=1.42 nrd=0.69047619047619 nrs=0.69047619047619 sa=0 sb=0 sd=0 mult=1 m=1
XMRD_c01_w1_0 rbl_c01_w1 sn_c01_w1_0 rwl_sel 0 sky130_fd_pr__nfet_01v8 L=0.15 W=0.42 nf=1 ad=0.1218 as=0.1218 pd=1.42 ps=1.42 nrd=0.69047619047619 nrs=0.69047619047619 sa=0 sb=0 sd=0 mult=1 m=1
csn_c01_w1_0 sn_c01_w1_0 0 {C_SN}
XMWR_c01_w1_1 sn_c01_w1_1 0 wbl_c01_w1 0 sky130_fd_pr__nfet_01v8 L=0.15 W=0.42 nf=1 ad=0.1218 as=0.1218 pd=1.42 ps=1.42 nrd=0.69047619047619 nrs=0.69047619047619 sa=0 sb=0 sd=0 mult=1 m=1
XMRD_c01_w1_1 rbl_c01_w1 sn_c01_w1_1 rwl_des 0 sky130_fd_pr__nfet_01v8 L=0.15 W=0.42 nf=1 ad=0.1218 as=0.1218 pd=1.42 ps=1.42 nrd=0.69047619047619 nrs=0.69047619047619 sa=0 sb=0 sd=0 mult=1 m=1
csn_c01_w1_1 sn_c01_w1_1 0 {C_SN}
XMWR_c01_w1_2 sn_c01_w1_2 0 wbl_c01_w1 0 sky130_fd_pr__nfet_01v8 L=0.15 W=0.42 nf=1 ad=0.1218 as=0.1218 pd=1.42 ps=1.42 nrd=0.69047619047619 nrs=0.69047619047619 sa=0 sb=0 sd=0 mult=1 m=1
XMRD_c01_w1_2 rbl_c01_w1 sn_c01_w1_2 rwl_des 0 sky130_fd_pr__nfet_01v8 L=0.15 W=0.42 nf=1 ad=0.1218 as=0.1218 pd=1.42 ps=1.42 nrd=0.69047619047619 nrs=0.69047619047619 sa=0 sb=0 sd=0 mult=1 m=1
csn_c01_w1_2 sn_c01_w1_2 0 {C_SN}
XMWR_c01_w1_3 sn_c01_w1_3 0 wbl_c01_w1 0 sky130_fd_pr__nfet_01v8 L=0.15 W=0.42 nf=1 ad=0.1218 as=0.1218 pd=1.42 ps=1.42 nrd=0.69047619047619 nrs=0.69047619047619 sa=0 sb=0 sd=0 mult=1 m=1
XMRD_c01_w1_3 rbl_c01_w1 sn_c01_w1_3 rwl_des 0 sky130_fd_pr__nfet_01v8 L=0.15 W=0.42 nf=1 ad=0.1218 as=0.1218 pd=1.42 ps=1.42 nrd=0.69047619047619 nrs=0.69047619047619 sa=0 sb=0 sd=0 mult=1 m=1
csn_c01_w1_3 sn_c01_w1_3 0 {C_SN}
crbl_c01_w1 rbl_c01_w1 0 {C_RBL}
cwbl_c01_w1 wbl_c01_w1 0 {C_WBL}
cref_c01_w1 ref_c01_w1 0 {C_RBL}   $ ASSUMPTION: ideal matched dummy load
XMPPRE_c01_w1 rbl_c01_w1 pcb_500 prea prea sky130_fd_pr__pfet_01v8 L=0.15 W=4 nf=1 ad=1.16 as=1.16 pd=8.58 ps=8.58 nrd=0.0725 nrs=0.0725 sa=0 sb=0 sd=0 mult=1 m=1
XMPU1_c01_w1 x_c01_w1 dinb1 vdd vdd sky130_fd_pr__pfet_01v8 L=0.15 W=1 nf=1 ad=0.29 as=0.29 pd=2.58 ps=2.58 nrd=0.29 nrs=0.29 sa=0 sb=0 sd=0 mult=1 m=1
XMPU2_c01_w1 wbl_c01_w1 wenb x_c01_w1 vdd sky130_fd_pr__pfet_01v8 L=0.15 W=1 nf=1 ad=0.29 as=0.29 pd=2.58 ps=2.58 nrd=0.29 nrs=0.29 sa=0 sb=0 sd=0 mult=1 m=1
XMND2_c01_w1 wbl_c01_w1 wen y_c01_w1 0 sky130_fd_pr__nfet_01v8 L=0.15 W=0.5 nf=1 ad=0.145 as=0.145 pd=1.58 ps=1.58 nrd=0.58 nrs=0.58 sa=0 sb=0 sd=0 mult=1 m=1
XMND1_c01_w1 y_c01_w1 dinb1 0 0 sky130_fd_pr__nfet_01v8 L=0.15 W=0.5 nf=1 ad=0.145 as=0.145 pd=1.58 ps=1.58 nrd=0.58 nrs=0.58 sa=0 sb=0 sd=0 mult=1 m=1
XMNI_c01_w1 wbl_c01_w1 wenb 0 0 sky130_fd_pr__nfet_01v8 L=0.15 W=0.42 nf=1 ad=0.1218 as=0.1218 pd=1.42 ps=1.42 nrd=0.69047619047619 nrs=0.69047619047619 sa=0 sb=0 sd=0 mult=1 m=1
XMNS_c01_w1 sbl_c01_w1 sel_69500 rbl_c01_w1 0 sky130_fd_pr__nfet_01v8 L=0.15 W=0.42 nf=1 ad=0.1218 as=0.1218 pd=1.42 ps=1.42 nrd=0.69047619047619 nrs=0.69047619047619 sa=0 sb=0 sd=0 mult=1 m=1
XMNSR_c01_w1 sref_c01_w1 sel_69500 ref_c01_w1 0 sky130_fd_pr__nfet_01v8 L=0.15 W=0.42 nf=1 ad=0.1218 as=0.1218 pd=1.42 ps=1.42 nrd=0.69047619047619 nrs=0.69047619047619 sa=0 sb=0 sd=0 mult=1 m=1
XMPPREF_c01_w1 ref_c01_w1 pcb_500 pref pref sky130_fd_pr__pfet_01v8 L=0.15 W=4 nf=1 ad=1.16 as=1.16 pd=8.58 ps=8.58 nrd=0.0725 nrs=0.0725 sa=0 sb=0 sd=0 mult=1 m=1   $ reference-side precharge: copy of MPPRE
XMN1_c01_w1 sbl_c01_w1 sref_c01_w1 vn_c01_w1 0 sky130_fd_pr__nfet_01v8 L=0.15 W=1 nf=1 ad=0.29 as=0.29 pd=2.58 ps=2.58 nrd=0.29 nrs=0.29 sa=0 sb=0 sd=0 mult=1 m=1
XMN2_c01_w1 sref_c01_w1 sbl_c01_w1 vn_c01_w1 0 sky130_fd_pr__nfet_01v8 L=0.15 W=1 nf=1 ad=0.29 as=0.29 pd=2.58 ps=2.58 nrd=0.29 nrs=0.29 sa=0 sb=0 sd=0 mult=1 m=1
XMP1_c01_w1 sbl_c01_w1 sref_c01_w1 vp_c01_w1 vdd sky130_fd_pr__pfet_01v8 L=0.15 W=2 nf=1 ad=0.58 as=0.58 pd=4.58 ps=4.58 nrd=0.145 nrs=0.145 sa=0 sb=0 sd=0 mult=1 m=1
XMP2_c01_w1 sref_c01_w1 sbl_c01_w1 vp_c01_w1 vdd sky130_fd_pr__pfet_01v8 L=0.15 W=2 nf=1 ad=0.58 as=0.58 pd=4.58 ps=4.58 nrd=0.145 nrs=0.145 sa=0 sb=0 sd=0 mult=1 m=1
XMNF_c01_w1 vn_c01_w1 en 0 0 sky130_fd_pr__nfet_01v8 L=0.15 W=2 nf=1 ad=0.58 as=0.58 pd=4.58 ps=4.58 nrd=0.145 nrs=0.145 sa=0 sb=0 sd=0 mult=1 m=1
XMPH_c01_w1 vp_c01_w1 enb vdd vdd sky130_fd_pr__pfet_01v8 L=0.15 W=4 nf=1 ad=1.16 as=1.16 pd=8.58 ps=8.58 nrd=0.0725 nrs=0.0725 sa=0 sb=0 sd=0 mult=1 m=1
bd_c01_w1 d_c01_w1 0 v=v(sbl_c01_w1)-v(sref_c01_w1)
bdabs_c01_w1 dabs_c01_w1 0 v=abs(v(sbl_c01_w1)-v(sref_c01_w1))

* ---- instance 87: c01_w0 (nfet-only 0.42, matched ref, release edge 0.5 ns) ----
XMWR_c01_w0_0 sn_c01_w0_0 wl wbl_c01_w0 0 sky130_fd_pr__nfet_01v8 L=0.15 W=0.42 nf=1 ad=0.1218 as=0.1218 pd=1.42 ps=1.42 nrd=0.69047619047619 nrs=0.69047619047619 sa=0 sb=0 sd=0 mult=1 m=1
XMRD_c01_w0_0 rbl_c01_w0 sn_c01_w0_0 rwl_sel 0 sky130_fd_pr__nfet_01v8 L=0.15 W=0.42 nf=1 ad=0.1218 as=0.1218 pd=1.42 ps=1.42 nrd=0.69047619047619 nrs=0.69047619047619 sa=0 sb=0 sd=0 mult=1 m=1
csn_c01_w0_0 sn_c01_w0_0 0 {C_SN}
XMWR_c01_w0_1 sn_c01_w0_1 0 wbl_c01_w0 0 sky130_fd_pr__nfet_01v8 L=0.15 W=0.42 nf=1 ad=0.1218 as=0.1218 pd=1.42 ps=1.42 nrd=0.69047619047619 nrs=0.69047619047619 sa=0 sb=0 sd=0 mult=1 m=1
XMRD_c01_w0_1 rbl_c01_w0 sn_c01_w0_1 rwl_des 0 sky130_fd_pr__nfet_01v8 L=0.15 W=0.42 nf=1 ad=0.1218 as=0.1218 pd=1.42 ps=1.42 nrd=0.69047619047619 nrs=0.69047619047619 sa=0 sb=0 sd=0 mult=1 m=1
csn_c01_w0_1 sn_c01_w0_1 0 {C_SN}
XMWR_c01_w0_2 sn_c01_w0_2 0 wbl_c01_w0 0 sky130_fd_pr__nfet_01v8 L=0.15 W=0.42 nf=1 ad=0.1218 as=0.1218 pd=1.42 ps=1.42 nrd=0.69047619047619 nrs=0.69047619047619 sa=0 sb=0 sd=0 mult=1 m=1
XMRD_c01_w0_2 rbl_c01_w0 sn_c01_w0_2 rwl_des 0 sky130_fd_pr__nfet_01v8 L=0.15 W=0.42 nf=1 ad=0.1218 as=0.1218 pd=1.42 ps=1.42 nrd=0.69047619047619 nrs=0.69047619047619 sa=0 sb=0 sd=0 mult=1 m=1
csn_c01_w0_2 sn_c01_w0_2 0 {C_SN}
XMWR_c01_w0_3 sn_c01_w0_3 0 wbl_c01_w0 0 sky130_fd_pr__nfet_01v8 L=0.15 W=0.42 nf=1 ad=0.1218 as=0.1218 pd=1.42 ps=1.42 nrd=0.69047619047619 nrs=0.69047619047619 sa=0 sb=0 sd=0 mult=1 m=1
XMRD_c01_w0_3 rbl_c01_w0 sn_c01_w0_3 rwl_des 0 sky130_fd_pr__nfet_01v8 L=0.15 W=0.42 nf=1 ad=0.1218 as=0.1218 pd=1.42 ps=1.42 nrd=0.69047619047619 nrs=0.69047619047619 sa=0 sb=0 sd=0 mult=1 m=1
csn_c01_w0_3 sn_c01_w0_3 0 {C_SN}
crbl_c01_w0 rbl_c01_w0 0 {C_RBL}
cwbl_c01_w0 wbl_c01_w0 0 {C_WBL}
cref_c01_w0 ref_c01_w0 0 {C_RBL}   $ ASSUMPTION: ideal matched dummy load
XMPPRE_c01_w0 rbl_c01_w0 pcb_500 prea prea sky130_fd_pr__pfet_01v8 L=0.15 W=4 nf=1 ad=1.16 as=1.16 pd=8.58 ps=8.58 nrd=0.0725 nrs=0.0725 sa=0 sb=0 sd=0 mult=1 m=1
XMPU1_c01_w0 x_c01_w0 dinb0 vdd vdd sky130_fd_pr__pfet_01v8 L=0.15 W=1 nf=1 ad=0.29 as=0.29 pd=2.58 ps=2.58 nrd=0.29 nrs=0.29 sa=0 sb=0 sd=0 mult=1 m=1
XMPU2_c01_w0 wbl_c01_w0 wenb x_c01_w0 vdd sky130_fd_pr__pfet_01v8 L=0.15 W=1 nf=1 ad=0.29 as=0.29 pd=2.58 ps=2.58 nrd=0.29 nrs=0.29 sa=0 sb=0 sd=0 mult=1 m=1
XMND2_c01_w0 wbl_c01_w0 wen y_c01_w0 0 sky130_fd_pr__nfet_01v8 L=0.15 W=0.5 nf=1 ad=0.145 as=0.145 pd=1.58 ps=1.58 nrd=0.58 nrs=0.58 sa=0 sb=0 sd=0 mult=1 m=1
XMND1_c01_w0 y_c01_w0 dinb0 0 0 sky130_fd_pr__nfet_01v8 L=0.15 W=0.5 nf=1 ad=0.145 as=0.145 pd=1.58 ps=1.58 nrd=0.58 nrs=0.58 sa=0 sb=0 sd=0 mult=1 m=1
XMNI_c01_w0 wbl_c01_w0 wenb 0 0 sky130_fd_pr__nfet_01v8 L=0.15 W=0.42 nf=1 ad=0.1218 as=0.1218 pd=1.42 ps=1.42 nrd=0.69047619047619 nrs=0.69047619047619 sa=0 sb=0 sd=0 mult=1 m=1
XMNS_c01_w0 sbl_c01_w0 sel_69500 rbl_c01_w0 0 sky130_fd_pr__nfet_01v8 L=0.15 W=0.42 nf=1 ad=0.1218 as=0.1218 pd=1.42 ps=1.42 nrd=0.69047619047619 nrs=0.69047619047619 sa=0 sb=0 sd=0 mult=1 m=1
XMNSR_c01_w0 sref_c01_w0 sel_69500 ref_c01_w0 0 sky130_fd_pr__nfet_01v8 L=0.15 W=0.42 nf=1 ad=0.1218 as=0.1218 pd=1.42 ps=1.42 nrd=0.69047619047619 nrs=0.69047619047619 sa=0 sb=0 sd=0 mult=1 m=1
XMPPREF_c01_w0 ref_c01_w0 pcb_500 pref pref sky130_fd_pr__pfet_01v8 L=0.15 W=4 nf=1 ad=1.16 as=1.16 pd=8.58 ps=8.58 nrd=0.0725 nrs=0.0725 sa=0 sb=0 sd=0 mult=1 m=1   $ reference-side precharge: copy of MPPRE
XMN1_c01_w0 sbl_c01_w0 sref_c01_w0 vn_c01_w0 0 sky130_fd_pr__nfet_01v8 L=0.15 W=1 nf=1 ad=0.29 as=0.29 pd=2.58 ps=2.58 nrd=0.29 nrs=0.29 sa=0 sb=0 sd=0 mult=1 m=1
XMN2_c01_w0 sref_c01_w0 sbl_c01_w0 vn_c01_w0 0 sky130_fd_pr__nfet_01v8 L=0.15 W=1 nf=1 ad=0.29 as=0.29 pd=2.58 ps=2.58 nrd=0.29 nrs=0.29 sa=0 sb=0 sd=0 mult=1 m=1
XMP1_c01_w0 sbl_c01_w0 sref_c01_w0 vp_c01_w0 vdd sky130_fd_pr__pfet_01v8 L=0.15 W=2 nf=1 ad=0.58 as=0.58 pd=4.58 ps=4.58 nrd=0.145 nrs=0.145 sa=0 sb=0 sd=0 mult=1 m=1
XMP2_c01_w0 sref_c01_w0 sbl_c01_w0 vp_c01_w0 vdd sky130_fd_pr__pfet_01v8 L=0.15 W=2 nf=1 ad=0.58 as=0.58 pd=4.58 ps=4.58 nrd=0.145 nrs=0.145 sa=0 sb=0 sd=0 mult=1 m=1
XMNF_c01_w0 vn_c01_w0 en 0 0 sky130_fd_pr__nfet_01v8 L=0.15 W=2 nf=1 ad=0.58 as=0.58 pd=4.58 ps=4.58 nrd=0.145 nrs=0.145 sa=0 sb=0 sd=0 mult=1 m=1
XMPH_c01_w0 vp_c01_w0 enb vdd vdd sky130_fd_pr__pfet_01v8 L=0.15 W=4 nf=1 ad=1.16 as=1.16 pd=8.58 ps=8.58 nrd=0.0725 nrs=0.0725 sa=0 sb=0 sd=0 mult=1 m=1
bd_c01_w0 d_c01_w0 0 v=v(sbl_c01_w0)-v(sref_c01_w0)
bdabs_c01_w0 dabs_c01_w0 0 v=abs(v(sbl_c01_w0)-v(sref_c01_w0))

* ---- instance 88: c02_w1 (nfet-only 0.42, dummy switch 0.25 x MPPRE) ----
XMWR_c02_w1_0 sn_c02_w1_0 wl wbl_c02_w1 0 sky130_fd_pr__nfet_01v8 L=0.15 W=0.42 nf=1 ad=0.1218 as=0.1218 pd=1.42 ps=1.42 nrd=0.69047619047619 nrs=0.69047619047619 sa=0 sb=0 sd=0 mult=1 m=1
XMRD_c02_w1_0 rbl_c02_w1 sn_c02_w1_0 rwl_sel 0 sky130_fd_pr__nfet_01v8 L=0.15 W=0.42 nf=1 ad=0.1218 as=0.1218 pd=1.42 ps=1.42 nrd=0.69047619047619 nrs=0.69047619047619 sa=0 sb=0 sd=0 mult=1 m=1
csn_c02_w1_0 sn_c02_w1_0 0 {C_SN}
XMWR_c02_w1_1 sn_c02_w1_1 0 wbl_c02_w1 0 sky130_fd_pr__nfet_01v8 L=0.15 W=0.42 nf=1 ad=0.1218 as=0.1218 pd=1.42 ps=1.42 nrd=0.69047619047619 nrs=0.69047619047619 sa=0 sb=0 sd=0 mult=1 m=1
XMRD_c02_w1_1 rbl_c02_w1 sn_c02_w1_1 rwl_des 0 sky130_fd_pr__nfet_01v8 L=0.15 W=0.42 nf=1 ad=0.1218 as=0.1218 pd=1.42 ps=1.42 nrd=0.69047619047619 nrs=0.69047619047619 sa=0 sb=0 sd=0 mult=1 m=1
csn_c02_w1_1 sn_c02_w1_1 0 {C_SN}
XMWR_c02_w1_2 sn_c02_w1_2 0 wbl_c02_w1 0 sky130_fd_pr__nfet_01v8 L=0.15 W=0.42 nf=1 ad=0.1218 as=0.1218 pd=1.42 ps=1.42 nrd=0.69047619047619 nrs=0.69047619047619 sa=0 sb=0 sd=0 mult=1 m=1
XMRD_c02_w1_2 rbl_c02_w1 sn_c02_w1_2 rwl_des 0 sky130_fd_pr__nfet_01v8 L=0.15 W=0.42 nf=1 ad=0.1218 as=0.1218 pd=1.42 ps=1.42 nrd=0.69047619047619 nrs=0.69047619047619 sa=0 sb=0 sd=0 mult=1 m=1
csn_c02_w1_2 sn_c02_w1_2 0 {C_SN}
XMWR_c02_w1_3 sn_c02_w1_3 0 wbl_c02_w1 0 sky130_fd_pr__nfet_01v8 L=0.15 W=0.42 nf=1 ad=0.1218 as=0.1218 pd=1.42 ps=1.42 nrd=0.69047619047619 nrs=0.69047619047619 sa=0 sb=0 sd=0 mult=1 m=1
XMRD_c02_w1_3 rbl_c02_w1 sn_c02_w1_3 rwl_des 0 sky130_fd_pr__nfet_01v8 L=0.15 W=0.42 nf=1 ad=0.1218 as=0.1218 pd=1.42 ps=1.42 nrd=0.69047619047619 nrs=0.69047619047619 sa=0 sb=0 sd=0 mult=1 m=1
csn_c02_w1_3 sn_c02_w1_3 0 {C_SN}
crbl_c02_w1 rbl_c02_w1 0 {C_RBL}
cwbl_c02_w1 wbl_c02_w1 0 {C_WBL}
cref_c02_w1 ref_c02_w1 0 {C_RBL}   $ ASSUMPTION: ideal matched dummy load
spr_c02_w1 pref ref_c02_w1 pca 0 swpre   $ reference-side precharge: ideal switch (#114 convention)
XMPPRE_c02_w1 rbl_c02_w1 pcb_100 prea prea sky130_fd_pr__pfet_01v8 L=0.15 W=4 nf=1 ad=1.16 as=1.16 pd=8.58 ps=8.58 nrd=0.0725 nrs=0.0725 sa=0 sb=0 sd=0 mult=1 m=1
XMPU1_c02_w1 x_c02_w1 dinb1 vdd vdd sky130_fd_pr__pfet_01v8 L=0.15 W=1 nf=1 ad=0.29 as=0.29 pd=2.58 ps=2.58 nrd=0.29 nrs=0.29 sa=0 sb=0 sd=0 mult=1 m=1
XMPU2_c02_w1 wbl_c02_w1 wenb x_c02_w1 vdd sky130_fd_pr__pfet_01v8 L=0.15 W=1 nf=1 ad=0.29 as=0.29 pd=2.58 ps=2.58 nrd=0.29 nrs=0.29 sa=0 sb=0 sd=0 mult=1 m=1
XMND2_c02_w1 wbl_c02_w1 wen y_c02_w1 0 sky130_fd_pr__nfet_01v8 L=0.15 W=0.5 nf=1 ad=0.145 as=0.145 pd=1.58 ps=1.58 nrd=0.58 nrs=0.58 sa=0 sb=0 sd=0 mult=1 m=1
XMND1_c02_w1 y_c02_w1 dinb1 0 0 sky130_fd_pr__nfet_01v8 L=0.15 W=0.5 nf=1 ad=0.145 as=0.145 pd=1.58 ps=1.58 nrd=0.58 nrs=0.58 sa=0 sb=0 sd=0 mult=1 m=1
XMNI_c02_w1 wbl_c02_w1 wenb 0 0 sky130_fd_pr__nfet_01v8 L=0.15 W=0.42 nf=1 ad=0.1218 as=0.1218 pd=1.42 ps=1.42 nrd=0.69047619047619 nrs=0.69047619047619 sa=0 sb=0 sd=0 mult=1 m=1
XMNS_c02_w1 sbl_c02_w1 sel_69500 rbl_c02_w1 0 sky130_fd_pr__nfet_01v8 L=0.15 W=0.42 nf=1 ad=0.1218 as=0.1218 pd=1.42 ps=1.42 nrd=0.69047619047619 nrs=0.69047619047619 sa=0 sb=0 sd=0 mult=1 m=1
XMNSR_c02_w1 sref_c02_w1 sel_69500 ref_c02_w1 0 sky130_fd_pr__nfet_01v8 L=0.15 W=0.42 nf=1 ad=0.1218 as=0.1218 pd=1.42 ps=1.42 nrd=0.69047619047619 nrs=0.69047619047619 sa=0 sb=0 sd=0 mult=1 m=1
XMPDUM_c02_w1 rbl_c02_w1 pca_100 rbl_c02_w1 prea sky130_fd_pr__pfet_01v8 L=0.15 W=1 nf=1 ad=0.29 as=0.29 pd=2.58 ps=2.58 nrd=0.29 nrs=0.29 sa=0 sb=0 sd=0 mult=1 m=1   $ STUDY option: dummy switch, opposite-phase gate
XMN1_c02_w1 sbl_c02_w1 sref_c02_w1 vn_c02_w1 0 sky130_fd_pr__nfet_01v8 L=0.15 W=1 nf=1 ad=0.29 as=0.29 pd=2.58 ps=2.58 nrd=0.29 nrs=0.29 sa=0 sb=0 sd=0 mult=1 m=1
XMN2_c02_w1 sref_c02_w1 sbl_c02_w1 vn_c02_w1 0 sky130_fd_pr__nfet_01v8 L=0.15 W=1 nf=1 ad=0.29 as=0.29 pd=2.58 ps=2.58 nrd=0.29 nrs=0.29 sa=0 sb=0 sd=0 mult=1 m=1
XMP1_c02_w1 sbl_c02_w1 sref_c02_w1 vp_c02_w1 vdd sky130_fd_pr__pfet_01v8 L=0.15 W=2 nf=1 ad=0.58 as=0.58 pd=4.58 ps=4.58 nrd=0.145 nrs=0.145 sa=0 sb=0 sd=0 mult=1 m=1
XMP2_c02_w1 sref_c02_w1 sbl_c02_w1 vp_c02_w1 vdd sky130_fd_pr__pfet_01v8 L=0.15 W=2 nf=1 ad=0.58 as=0.58 pd=4.58 ps=4.58 nrd=0.145 nrs=0.145 sa=0 sb=0 sd=0 mult=1 m=1
XMNF_c02_w1 vn_c02_w1 en 0 0 sky130_fd_pr__nfet_01v8 L=0.15 W=2 nf=1 ad=0.58 as=0.58 pd=4.58 ps=4.58 nrd=0.145 nrs=0.145 sa=0 sb=0 sd=0 mult=1 m=1
XMPH_c02_w1 vp_c02_w1 enb vdd vdd sky130_fd_pr__pfet_01v8 L=0.15 W=4 nf=1 ad=1.16 as=1.16 pd=8.58 ps=8.58 nrd=0.0725 nrs=0.0725 sa=0 sb=0 sd=0 mult=1 m=1
bd_c02_w1 d_c02_w1 0 v=v(sbl_c02_w1)-v(sref_c02_w1)
bdabs_c02_w1 dabs_c02_w1 0 v=abs(v(sbl_c02_w1)-v(sref_c02_w1))

* ---- instance 89: c02_w0 (nfet-only 0.42, dummy switch 0.25 x MPPRE) ----
XMWR_c02_w0_0 sn_c02_w0_0 wl wbl_c02_w0 0 sky130_fd_pr__nfet_01v8 L=0.15 W=0.42 nf=1 ad=0.1218 as=0.1218 pd=1.42 ps=1.42 nrd=0.69047619047619 nrs=0.69047619047619 sa=0 sb=0 sd=0 mult=1 m=1
XMRD_c02_w0_0 rbl_c02_w0 sn_c02_w0_0 rwl_sel 0 sky130_fd_pr__nfet_01v8 L=0.15 W=0.42 nf=1 ad=0.1218 as=0.1218 pd=1.42 ps=1.42 nrd=0.69047619047619 nrs=0.69047619047619 sa=0 sb=0 sd=0 mult=1 m=1
csn_c02_w0_0 sn_c02_w0_0 0 {C_SN}
XMWR_c02_w0_1 sn_c02_w0_1 0 wbl_c02_w0 0 sky130_fd_pr__nfet_01v8 L=0.15 W=0.42 nf=1 ad=0.1218 as=0.1218 pd=1.42 ps=1.42 nrd=0.69047619047619 nrs=0.69047619047619 sa=0 sb=0 sd=0 mult=1 m=1
XMRD_c02_w0_1 rbl_c02_w0 sn_c02_w0_1 rwl_des 0 sky130_fd_pr__nfet_01v8 L=0.15 W=0.42 nf=1 ad=0.1218 as=0.1218 pd=1.42 ps=1.42 nrd=0.69047619047619 nrs=0.69047619047619 sa=0 sb=0 sd=0 mult=1 m=1
csn_c02_w0_1 sn_c02_w0_1 0 {C_SN}
XMWR_c02_w0_2 sn_c02_w0_2 0 wbl_c02_w0 0 sky130_fd_pr__nfet_01v8 L=0.15 W=0.42 nf=1 ad=0.1218 as=0.1218 pd=1.42 ps=1.42 nrd=0.69047619047619 nrs=0.69047619047619 sa=0 sb=0 sd=0 mult=1 m=1
XMRD_c02_w0_2 rbl_c02_w0 sn_c02_w0_2 rwl_des 0 sky130_fd_pr__nfet_01v8 L=0.15 W=0.42 nf=1 ad=0.1218 as=0.1218 pd=1.42 ps=1.42 nrd=0.69047619047619 nrs=0.69047619047619 sa=0 sb=0 sd=0 mult=1 m=1
csn_c02_w0_2 sn_c02_w0_2 0 {C_SN}
XMWR_c02_w0_3 sn_c02_w0_3 0 wbl_c02_w0 0 sky130_fd_pr__nfet_01v8 L=0.15 W=0.42 nf=1 ad=0.1218 as=0.1218 pd=1.42 ps=1.42 nrd=0.69047619047619 nrs=0.69047619047619 sa=0 sb=0 sd=0 mult=1 m=1
XMRD_c02_w0_3 rbl_c02_w0 sn_c02_w0_3 rwl_des 0 sky130_fd_pr__nfet_01v8 L=0.15 W=0.42 nf=1 ad=0.1218 as=0.1218 pd=1.42 ps=1.42 nrd=0.69047619047619 nrs=0.69047619047619 sa=0 sb=0 sd=0 mult=1 m=1
csn_c02_w0_3 sn_c02_w0_3 0 {C_SN}
crbl_c02_w0 rbl_c02_w0 0 {C_RBL}
cwbl_c02_w0 wbl_c02_w0 0 {C_WBL}
cref_c02_w0 ref_c02_w0 0 {C_RBL}   $ ASSUMPTION: ideal matched dummy load
spr_c02_w0 pref ref_c02_w0 pca 0 swpre   $ reference-side precharge: ideal switch (#114 convention)
XMPPRE_c02_w0 rbl_c02_w0 pcb_100 prea prea sky130_fd_pr__pfet_01v8 L=0.15 W=4 nf=1 ad=1.16 as=1.16 pd=8.58 ps=8.58 nrd=0.0725 nrs=0.0725 sa=0 sb=0 sd=0 mult=1 m=1
XMPU1_c02_w0 x_c02_w0 dinb0 vdd vdd sky130_fd_pr__pfet_01v8 L=0.15 W=1 nf=1 ad=0.29 as=0.29 pd=2.58 ps=2.58 nrd=0.29 nrs=0.29 sa=0 sb=0 sd=0 mult=1 m=1
XMPU2_c02_w0 wbl_c02_w0 wenb x_c02_w0 vdd sky130_fd_pr__pfet_01v8 L=0.15 W=1 nf=1 ad=0.29 as=0.29 pd=2.58 ps=2.58 nrd=0.29 nrs=0.29 sa=0 sb=0 sd=0 mult=1 m=1
XMND2_c02_w0 wbl_c02_w0 wen y_c02_w0 0 sky130_fd_pr__nfet_01v8 L=0.15 W=0.5 nf=1 ad=0.145 as=0.145 pd=1.58 ps=1.58 nrd=0.58 nrs=0.58 sa=0 sb=0 sd=0 mult=1 m=1
XMND1_c02_w0 y_c02_w0 dinb0 0 0 sky130_fd_pr__nfet_01v8 L=0.15 W=0.5 nf=1 ad=0.145 as=0.145 pd=1.58 ps=1.58 nrd=0.58 nrs=0.58 sa=0 sb=0 sd=0 mult=1 m=1
XMNI_c02_w0 wbl_c02_w0 wenb 0 0 sky130_fd_pr__nfet_01v8 L=0.15 W=0.42 nf=1 ad=0.1218 as=0.1218 pd=1.42 ps=1.42 nrd=0.69047619047619 nrs=0.69047619047619 sa=0 sb=0 sd=0 mult=1 m=1
XMNS_c02_w0 sbl_c02_w0 sel_69500 rbl_c02_w0 0 sky130_fd_pr__nfet_01v8 L=0.15 W=0.42 nf=1 ad=0.1218 as=0.1218 pd=1.42 ps=1.42 nrd=0.69047619047619 nrs=0.69047619047619 sa=0 sb=0 sd=0 mult=1 m=1
XMNSR_c02_w0 sref_c02_w0 sel_69500 ref_c02_w0 0 sky130_fd_pr__nfet_01v8 L=0.15 W=0.42 nf=1 ad=0.1218 as=0.1218 pd=1.42 ps=1.42 nrd=0.69047619047619 nrs=0.69047619047619 sa=0 sb=0 sd=0 mult=1 m=1
XMPDUM_c02_w0 rbl_c02_w0 pca_100 rbl_c02_w0 prea sky130_fd_pr__pfet_01v8 L=0.15 W=1 nf=1 ad=0.29 as=0.29 pd=2.58 ps=2.58 nrd=0.29 nrs=0.29 sa=0 sb=0 sd=0 mult=1 m=1   $ STUDY option: dummy switch, opposite-phase gate
XMN1_c02_w0 sbl_c02_w0 sref_c02_w0 vn_c02_w0 0 sky130_fd_pr__nfet_01v8 L=0.15 W=1 nf=1 ad=0.29 as=0.29 pd=2.58 ps=2.58 nrd=0.29 nrs=0.29 sa=0 sb=0 sd=0 mult=1 m=1
XMN2_c02_w0 sref_c02_w0 sbl_c02_w0 vn_c02_w0 0 sky130_fd_pr__nfet_01v8 L=0.15 W=1 nf=1 ad=0.29 as=0.29 pd=2.58 ps=2.58 nrd=0.29 nrs=0.29 sa=0 sb=0 sd=0 mult=1 m=1
XMP1_c02_w0 sbl_c02_w0 sref_c02_w0 vp_c02_w0 vdd sky130_fd_pr__pfet_01v8 L=0.15 W=2 nf=1 ad=0.58 as=0.58 pd=4.58 ps=4.58 nrd=0.145 nrs=0.145 sa=0 sb=0 sd=0 mult=1 m=1
XMP2_c02_w0 sref_c02_w0 sbl_c02_w0 vp_c02_w0 vdd sky130_fd_pr__pfet_01v8 L=0.15 W=2 nf=1 ad=0.58 as=0.58 pd=4.58 ps=4.58 nrd=0.145 nrs=0.145 sa=0 sb=0 sd=0 mult=1 m=1
XMNF_c02_w0 vn_c02_w0 en 0 0 sky130_fd_pr__nfet_01v8 L=0.15 W=2 nf=1 ad=0.58 as=0.58 pd=4.58 ps=4.58 nrd=0.145 nrs=0.145 sa=0 sb=0 sd=0 mult=1 m=1
XMPH_c02_w0 vp_c02_w0 enb vdd vdd sky130_fd_pr__pfet_01v8 L=0.15 W=4 nf=1 ad=1.16 as=1.16 pd=8.58 ps=8.58 nrd=0.0725 nrs=0.0725 sa=0 sb=0 sd=0 mult=1 m=1
bd_c02_w0 d_c02_w0 0 v=v(sbl_c02_w0)-v(sref_c02_w0)
bdabs_c02_w0 dabs_c02_w0 0 v=abs(v(sbl_c02_w0)-v(sref_c02_w0))

* ---- instance 90: c03_w1 (nfet-only 0.42, dummy switch 0.5 x MPPRE) ----
XMWR_c03_w1_0 sn_c03_w1_0 wl wbl_c03_w1 0 sky130_fd_pr__nfet_01v8 L=0.15 W=0.42 nf=1 ad=0.1218 as=0.1218 pd=1.42 ps=1.42 nrd=0.69047619047619 nrs=0.69047619047619 sa=0 sb=0 sd=0 mult=1 m=1
XMRD_c03_w1_0 rbl_c03_w1 sn_c03_w1_0 rwl_sel 0 sky130_fd_pr__nfet_01v8 L=0.15 W=0.42 nf=1 ad=0.1218 as=0.1218 pd=1.42 ps=1.42 nrd=0.69047619047619 nrs=0.69047619047619 sa=0 sb=0 sd=0 mult=1 m=1
csn_c03_w1_0 sn_c03_w1_0 0 {C_SN}
XMWR_c03_w1_1 sn_c03_w1_1 0 wbl_c03_w1 0 sky130_fd_pr__nfet_01v8 L=0.15 W=0.42 nf=1 ad=0.1218 as=0.1218 pd=1.42 ps=1.42 nrd=0.69047619047619 nrs=0.69047619047619 sa=0 sb=0 sd=0 mult=1 m=1
XMRD_c03_w1_1 rbl_c03_w1 sn_c03_w1_1 rwl_des 0 sky130_fd_pr__nfet_01v8 L=0.15 W=0.42 nf=1 ad=0.1218 as=0.1218 pd=1.42 ps=1.42 nrd=0.69047619047619 nrs=0.69047619047619 sa=0 sb=0 sd=0 mult=1 m=1
csn_c03_w1_1 sn_c03_w1_1 0 {C_SN}
XMWR_c03_w1_2 sn_c03_w1_2 0 wbl_c03_w1 0 sky130_fd_pr__nfet_01v8 L=0.15 W=0.42 nf=1 ad=0.1218 as=0.1218 pd=1.42 ps=1.42 nrd=0.69047619047619 nrs=0.69047619047619 sa=0 sb=0 sd=0 mult=1 m=1
XMRD_c03_w1_2 rbl_c03_w1 sn_c03_w1_2 rwl_des 0 sky130_fd_pr__nfet_01v8 L=0.15 W=0.42 nf=1 ad=0.1218 as=0.1218 pd=1.42 ps=1.42 nrd=0.69047619047619 nrs=0.69047619047619 sa=0 sb=0 sd=0 mult=1 m=1
csn_c03_w1_2 sn_c03_w1_2 0 {C_SN}
XMWR_c03_w1_3 sn_c03_w1_3 0 wbl_c03_w1 0 sky130_fd_pr__nfet_01v8 L=0.15 W=0.42 nf=1 ad=0.1218 as=0.1218 pd=1.42 ps=1.42 nrd=0.69047619047619 nrs=0.69047619047619 sa=0 sb=0 sd=0 mult=1 m=1
XMRD_c03_w1_3 rbl_c03_w1 sn_c03_w1_3 rwl_des 0 sky130_fd_pr__nfet_01v8 L=0.15 W=0.42 nf=1 ad=0.1218 as=0.1218 pd=1.42 ps=1.42 nrd=0.69047619047619 nrs=0.69047619047619 sa=0 sb=0 sd=0 mult=1 m=1
csn_c03_w1_3 sn_c03_w1_3 0 {C_SN}
crbl_c03_w1 rbl_c03_w1 0 {C_RBL}
cwbl_c03_w1 wbl_c03_w1 0 {C_WBL}
cref_c03_w1 ref_c03_w1 0 {C_RBL}   $ ASSUMPTION: ideal matched dummy load
spr_c03_w1 pref ref_c03_w1 pca 0 swpre   $ reference-side precharge: ideal switch (#114 convention)
XMPPRE_c03_w1 rbl_c03_w1 pcb_100 prea prea sky130_fd_pr__pfet_01v8 L=0.15 W=4 nf=1 ad=1.16 as=1.16 pd=8.58 ps=8.58 nrd=0.0725 nrs=0.0725 sa=0 sb=0 sd=0 mult=1 m=1
XMPU1_c03_w1 x_c03_w1 dinb1 vdd vdd sky130_fd_pr__pfet_01v8 L=0.15 W=1 nf=1 ad=0.29 as=0.29 pd=2.58 ps=2.58 nrd=0.29 nrs=0.29 sa=0 sb=0 sd=0 mult=1 m=1
XMPU2_c03_w1 wbl_c03_w1 wenb x_c03_w1 vdd sky130_fd_pr__pfet_01v8 L=0.15 W=1 nf=1 ad=0.29 as=0.29 pd=2.58 ps=2.58 nrd=0.29 nrs=0.29 sa=0 sb=0 sd=0 mult=1 m=1
XMND2_c03_w1 wbl_c03_w1 wen y_c03_w1 0 sky130_fd_pr__nfet_01v8 L=0.15 W=0.5 nf=1 ad=0.145 as=0.145 pd=1.58 ps=1.58 nrd=0.58 nrs=0.58 sa=0 sb=0 sd=0 mult=1 m=1
XMND1_c03_w1 y_c03_w1 dinb1 0 0 sky130_fd_pr__nfet_01v8 L=0.15 W=0.5 nf=1 ad=0.145 as=0.145 pd=1.58 ps=1.58 nrd=0.58 nrs=0.58 sa=0 sb=0 sd=0 mult=1 m=1
XMNI_c03_w1 wbl_c03_w1 wenb 0 0 sky130_fd_pr__nfet_01v8 L=0.15 W=0.42 nf=1 ad=0.1218 as=0.1218 pd=1.42 ps=1.42 nrd=0.69047619047619 nrs=0.69047619047619 sa=0 sb=0 sd=0 mult=1 m=1
XMNS_c03_w1 sbl_c03_w1 sel_69500 rbl_c03_w1 0 sky130_fd_pr__nfet_01v8 L=0.15 W=0.42 nf=1 ad=0.1218 as=0.1218 pd=1.42 ps=1.42 nrd=0.69047619047619 nrs=0.69047619047619 sa=0 sb=0 sd=0 mult=1 m=1
XMNSR_c03_w1 sref_c03_w1 sel_69500 ref_c03_w1 0 sky130_fd_pr__nfet_01v8 L=0.15 W=0.42 nf=1 ad=0.1218 as=0.1218 pd=1.42 ps=1.42 nrd=0.69047619047619 nrs=0.69047619047619 sa=0 sb=0 sd=0 mult=1 m=1
XMPDUM_c03_w1 rbl_c03_w1 pca_100 rbl_c03_w1 prea sky130_fd_pr__pfet_01v8 L=0.15 W=2 nf=1 ad=0.58 as=0.58 pd=4.58 ps=4.58 nrd=0.145 nrs=0.145 sa=0 sb=0 sd=0 mult=1 m=1   $ STUDY option: dummy switch, opposite-phase gate
XMN1_c03_w1 sbl_c03_w1 sref_c03_w1 vn_c03_w1 0 sky130_fd_pr__nfet_01v8 L=0.15 W=1 nf=1 ad=0.29 as=0.29 pd=2.58 ps=2.58 nrd=0.29 nrs=0.29 sa=0 sb=0 sd=0 mult=1 m=1
XMN2_c03_w1 sref_c03_w1 sbl_c03_w1 vn_c03_w1 0 sky130_fd_pr__nfet_01v8 L=0.15 W=1 nf=1 ad=0.29 as=0.29 pd=2.58 ps=2.58 nrd=0.29 nrs=0.29 sa=0 sb=0 sd=0 mult=1 m=1
XMP1_c03_w1 sbl_c03_w1 sref_c03_w1 vp_c03_w1 vdd sky130_fd_pr__pfet_01v8 L=0.15 W=2 nf=1 ad=0.58 as=0.58 pd=4.58 ps=4.58 nrd=0.145 nrs=0.145 sa=0 sb=0 sd=0 mult=1 m=1
XMP2_c03_w1 sref_c03_w1 sbl_c03_w1 vp_c03_w1 vdd sky130_fd_pr__pfet_01v8 L=0.15 W=2 nf=1 ad=0.58 as=0.58 pd=4.58 ps=4.58 nrd=0.145 nrs=0.145 sa=0 sb=0 sd=0 mult=1 m=1
XMNF_c03_w1 vn_c03_w1 en 0 0 sky130_fd_pr__nfet_01v8 L=0.15 W=2 nf=1 ad=0.58 as=0.58 pd=4.58 ps=4.58 nrd=0.145 nrs=0.145 sa=0 sb=0 sd=0 mult=1 m=1
XMPH_c03_w1 vp_c03_w1 enb vdd vdd sky130_fd_pr__pfet_01v8 L=0.15 W=4 nf=1 ad=1.16 as=1.16 pd=8.58 ps=8.58 nrd=0.0725 nrs=0.0725 sa=0 sb=0 sd=0 mult=1 m=1
bd_c03_w1 d_c03_w1 0 v=v(sbl_c03_w1)-v(sref_c03_w1)
bdabs_c03_w1 dabs_c03_w1 0 v=abs(v(sbl_c03_w1)-v(sref_c03_w1))

* ---- instance 91: c03_w0 (nfet-only 0.42, dummy switch 0.5 x MPPRE) ----
XMWR_c03_w0_0 sn_c03_w0_0 wl wbl_c03_w0 0 sky130_fd_pr__nfet_01v8 L=0.15 W=0.42 nf=1 ad=0.1218 as=0.1218 pd=1.42 ps=1.42 nrd=0.69047619047619 nrs=0.69047619047619 sa=0 sb=0 sd=0 mult=1 m=1
XMRD_c03_w0_0 rbl_c03_w0 sn_c03_w0_0 rwl_sel 0 sky130_fd_pr__nfet_01v8 L=0.15 W=0.42 nf=1 ad=0.1218 as=0.1218 pd=1.42 ps=1.42 nrd=0.69047619047619 nrs=0.69047619047619 sa=0 sb=0 sd=0 mult=1 m=1
csn_c03_w0_0 sn_c03_w0_0 0 {C_SN}
XMWR_c03_w0_1 sn_c03_w0_1 0 wbl_c03_w0 0 sky130_fd_pr__nfet_01v8 L=0.15 W=0.42 nf=1 ad=0.1218 as=0.1218 pd=1.42 ps=1.42 nrd=0.69047619047619 nrs=0.69047619047619 sa=0 sb=0 sd=0 mult=1 m=1
XMRD_c03_w0_1 rbl_c03_w0 sn_c03_w0_1 rwl_des 0 sky130_fd_pr__nfet_01v8 L=0.15 W=0.42 nf=1 ad=0.1218 as=0.1218 pd=1.42 ps=1.42 nrd=0.69047619047619 nrs=0.69047619047619 sa=0 sb=0 sd=0 mult=1 m=1
csn_c03_w0_1 sn_c03_w0_1 0 {C_SN}
XMWR_c03_w0_2 sn_c03_w0_2 0 wbl_c03_w0 0 sky130_fd_pr__nfet_01v8 L=0.15 W=0.42 nf=1 ad=0.1218 as=0.1218 pd=1.42 ps=1.42 nrd=0.69047619047619 nrs=0.69047619047619 sa=0 sb=0 sd=0 mult=1 m=1
XMRD_c03_w0_2 rbl_c03_w0 sn_c03_w0_2 rwl_des 0 sky130_fd_pr__nfet_01v8 L=0.15 W=0.42 nf=1 ad=0.1218 as=0.1218 pd=1.42 ps=1.42 nrd=0.69047619047619 nrs=0.69047619047619 sa=0 sb=0 sd=0 mult=1 m=1
csn_c03_w0_2 sn_c03_w0_2 0 {C_SN}
XMWR_c03_w0_3 sn_c03_w0_3 0 wbl_c03_w0 0 sky130_fd_pr__nfet_01v8 L=0.15 W=0.42 nf=1 ad=0.1218 as=0.1218 pd=1.42 ps=1.42 nrd=0.69047619047619 nrs=0.69047619047619 sa=0 sb=0 sd=0 mult=1 m=1
XMRD_c03_w0_3 rbl_c03_w0 sn_c03_w0_3 rwl_des 0 sky130_fd_pr__nfet_01v8 L=0.15 W=0.42 nf=1 ad=0.1218 as=0.1218 pd=1.42 ps=1.42 nrd=0.69047619047619 nrs=0.69047619047619 sa=0 sb=0 sd=0 mult=1 m=1
csn_c03_w0_3 sn_c03_w0_3 0 {C_SN}
crbl_c03_w0 rbl_c03_w0 0 {C_RBL}
cwbl_c03_w0 wbl_c03_w0 0 {C_WBL}
cref_c03_w0 ref_c03_w0 0 {C_RBL}   $ ASSUMPTION: ideal matched dummy load
spr_c03_w0 pref ref_c03_w0 pca 0 swpre   $ reference-side precharge: ideal switch (#114 convention)
XMPPRE_c03_w0 rbl_c03_w0 pcb_100 prea prea sky130_fd_pr__pfet_01v8 L=0.15 W=4 nf=1 ad=1.16 as=1.16 pd=8.58 ps=8.58 nrd=0.0725 nrs=0.0725 sa=0 sb=0 sd=0 mult=1 m=1
XMPU1_c03_w0 x_c03_w0 dinb0 vdd vdd sky130_fd_pr__pfet_01v8 L=0.15 W=1 nf=1 ad=0.29 as=0.29 pd=2.58 ps=2.58 nrd=0.29 nrs=0.29 sa=0 sb=0 sd=0 mult=1 m=1
XMPU2_c03_w0 wbl_c03_w0 wenb x_c03_w0 vdd sky130_fd_pr__pfet_01v8 L=0.15 W=1 nf=1 ad=0.29 as=0.29 pd=2.58 ps=2.58 nrd=0.29 nrs=0.29 sa=0 sb=0 sd=0 mult=1 m=1
XMND2_c03_w0 wbl_c03_w0 wen y_c03_w0 0 sky130_fd_pr__nfet_01v8 L=0.15 W=0.5 nf=1 ad=0.145 as=0.145 pd=1.58 ps=1.58 nrd=0.58 nrs=0.58 sa=0 sb=0 sd=0 mult=1 m=1
XMND1_c03_w0 y_c03_w0 dinb0 0 0 sky130_fd_pr__nfet_01v8 L=0.15 W=0.5 nf=1 ad=0.145 as=0.145 pd=1.58 ps=1.58 nrd=0.58 nrs=0.58 sa=0 sb=0 sd=0 mult=1 m=1
XMNI_c03_w0 wbl_c03_w0 wenb 0 0 sky130_fd_pr__nfet_01v8 L=0.15 W=0.42 nf=1 ad=0.1218 as=0.1218 pd=1.42 ps=1.42 nrd=0.69047619047619 nrs=0.69047619047619 sa=0 sb=0 sd=0 mult=1 m=1
XMNS_c03_w0 sbl_c03_w0 sel_69500 rbl_c03_w0 0 sky130_fd_pr__nfet_01v8 L=0.15 W=0.42 nf=1 ad=0.1218 as=0.1218 pd=1.42 ps=1.42 nrd=0.69047619047619 nrs=0.69047619047619 sa=0 sb=0 sd=0 mult=1 m=1
XMNSR_c03_w0 sref_c03_w0 sel_69500 ref_c03_w0 0 sky130_fd_pr__nfet_01v8 L=0.15 W=0.42 nf=1 ad=0.1218 as=0.1218 pd=1.42 ps=1.42 nrd=0.69047619047619 nrs=0.69047619047619 sa=0 sb=0 sd=0 mult=1 m=1
XMPDUM_c03_w0 rbl_c03_w0 pca_100 rbl_c03_w0 prea sky130_fd_pr__pfet_01v8 L=0.15 W=2 nf=1 ad=0.58 as=0.58 pd=4.58 ps=4.58 nrd=0.145 nrs=0.145 sa=0 sb=0 sd=0 mult=1 m=1   $ STUDY option: dummy switch, opposite-phase gate
XMN1_c03_w0 sbl_c03_w0 sref_c03_w0 vn_c03_w0 0 sky130_fd_pr__nfet_01v8 L=0.15 W=1 nf=1 ad=0.29 as=0.29 pd=2.58 ps=2.58 nrd=0.29 nrs=0.29 sa=0 sb=0 sd=0 mult=1 m=1
XMN2_c03_w0 sref_c03_w0 sbl_c03_w0 vn_c03_w0 0 sky130_fd_pr__nfet_01v8 L=0.15 W=1 nf=1 ad=0.29 as=0.29 pd=2.58 ps=2.58 nrd=0.29 nrs=0.29 sa=0 sb=0 sd=0 mult=1 m=1
XMP1_c03_w0 sbl_c03_w0 sref_c03_w0 vp_c03_w0 vdd sky130_fd_pr__pfet_01v8 L=0.15 W=2 nf=1 ad=0.58 as=0.58 pd=4.58 ps=4.58 nrd=0.145 nrs=0.145 sa=0 sb=0 sd=0 mult=1 m=1
XMP2_c03_w0 sref_c03_w0 sbl_c03_w0 vp_c03_w0 vdd sky130_fd_pr__pfet_01v8 L=0.15 W=2 nf=1 ad=0.58 as=0.58 pd=4.58 ps=4.58 nrd=0.145 nrs=0.145 sa=0 sb=0 sd=0 mult=1 m=1
XMNF_c03_w0 vn_c03_w0 en 0 0 sky130_fd_pr__nfet_01v8 L=0.15 W=2 nf=1 ad=0.58 as=0.58 pd=4.58 ps=4.58 nrd=0.145 nrs=0.145 sa=0 sb=0 sd=0 mult=1 m=1
XMPH_c03_w0 vp_c03_w0 enb vdd vdd sky130_fd_pr__pfet_01v8 L=0.15 W=4 nf=1 ad=1.16 as=1.16 pd=8.58 ps=8.58 nrd=0.0725 nrs=0.0725 sa=0 sb=0 sd=0 mult=1 m=1
bd_c03_w0 d_c03_w0 0 v=v(sbl_c03_w0)-v(sref_c03_w0)
bdabs_c03_w0 dabs_c03_w0 0 v=abs(v(sbl_c03_w0)-v(sref_c03_w0))

* ---- instance 92: c04_w1 (nfet-only 0.42, release edge 0.5 ns) ----
XMWR_c04_w1_0 sn_c04_w1_0 wl wbl_c04_w1 0 sky130_fd_pr__nfet_01v8 L=0.15 W=0.42 nf=1 ad=0.1218 as=0.1218 pd=1.42 ps=1.42 nrd=0.69047619047619 nrs=0.69047619047619 sa=0 sb=0 sd=0 mult=1 m=1
XMRD_c04_w1_0 rbl_c04_w1 sn_c04_w1_0 rwl_sel 0 sky130_fd_pr__nfet_01v8 L=0.15 W=0.42 nf=1 ad=0.1218 as=0.1218 pd=1.42 ps=1.42 nrd=0.69047619047619 nrs=0.69047619047619 sa=0 sb=0 sd=0 mult=1 m=1
csn_c04_w1_0 sn_c04_w1_0 0 {C_SN}
XMWR_c04_w1_1 sn_c04_w1_1 0 wbl_c04_w1 0 sky130_fd_pr__nfet_01v8 L=0.15 W=0.42 nf=1 ad=0.1218 as=0.1218 pd=1.42 ps=1.42 nrd=0.69047619047619 nrs=0.69047619047619 sa=0 sb=0 sd=0 mult=1 m=1
XMRD_c04_w1_1 rbl_c04_w1 sn_c04_w1_1 rwl_des 0 sky130_fd_pr__nfet_01v8 L=0.15 W=0.42 nf=1 ad=0.1218 as=0.1218 pd=1.42 ps=1.42 nrd=0.69047619047619 nrs=0.69047619047619 sa=0 sb=0 sd=0 mult=1 m=1
csn_c04_w1_1 sn_c04_w1_1 0 {C_SN}
XMWR_c04_w1_2 sn_c04_w1_2 0 wbl_c04_w1 0 sky130_fd_pr__nfet_01v8 L=0.15 W=0.42 nf=1 ad=0.1218 as=0.1218 pd=1.42 ps=1.42 nrd=0.69047619047619 nrs=0.69047619047619 sa=0 sb=0 sd=0 mult=1 m=1
XMRD_c04_w1_2 rbl_c04_w1 sn_c04_w1_2 rwl_des 0 sky130_fd_pr__nfet_01v8 L=0.15 W=0.42 nf=1 ad=0.1218 as=0.1218 pd=1.42 ps=1.42 nrd=0.69047619047619 nrs=0.69047619047619 sa=0 sb=0 sd=0 mult=1 m=1
csn_c04_w1_2 sn_c04_w1_2 0 {C_SN}
XMWR_c04_w1_3 sn_c04_w1_3 0 wbl_c04_w1 0 sky130_fd_pr__nfet_01v8 L=0.15 W=0.42 nf=1 ad=0.1218 as=0.1218 pd=1.42 ps=1.42 nrd=0.69047619047619 nrs=0.69047619047619 sa=0 sb=0 sd=0 mult=1 m=1
XMRD_c04_w1_3 rbl_c04_w1 sn_c04_w1_3 rwl_des 0 sky130_fd_pr__nfet_01v8 L=0.15 W=0.42 nf=1 ad=0.1218 as=0.1218 pd=1.42 ps=1.42 nrd=0.69047619047619 nrs=0.69047619047619 sa=0 sb=0 sd=0 mult=1 m=1
csn_c04_w1_3 sn_c04_w1_3 0 {C_SN}
crbl_c04_w1 rbl_c04_w1 0 {C_RBL}
cwbl_c04_w1 wbl_c04_w1 0 {C_WBL}
cref_c04_w1 ref_c04_w1 0 {C_RBL}   $ ASSUMPTION: ideal matched dummy load
spr_c04_w1 pref ref_c04_w1 pca 0 swpre   $ reference-side precharge: ideal switch (#114 convention)
XMPPRE_c04_w1 rbl_c04_w1 pcb_500 prea prea sky130_fd_pr__pfet_01v8 L=0.15 W=4 nf=1 ad=1.16 as=1.16 pd=8.58 ps=8.58 nrd=0.0725 nrs=0.0725 sa=0 sb=0 sd=0 mult=1 m=1
XMPU1_c04_w1 x_c04_w1 dinb1 vdd vdd sky130_fd_pr__pfet_01v8 L=0.15 W=1 nf=1 ad=0.29 as=0.29 pd=2.58 ps=2.58 nrd=0.29 nrs=0.29 sa=0 sb=0 sd=0 mult=1 m=1
XMPU2_c04_w1 wbl_c04_w1 wenb x_c04_w1 vdd sky130_fd_pr__pfet_01v8 L=0.15 W=1 nf=1 ad=0.29 as=0.29 pd=2.58 ps=2.58 nrd=0.29 nrs=0.29 sa=0 sb=0 sd=0 mult=1 m=1
XMND2_c04_w1 wbl_c04_w1 wen y_c04_w1 0 sky130_fd_pr__nfet_01v8 L=0.15 W=0.5 nf=1 ad=0.145 as=0.145 pd=1.58 ps=1.58 nrd=0.58 nrs=0.58 sa=0 sb=0 sd=0 mult=1 m=1
XMND1_c04_w1 y_c04_w1 dinb1 0 0 sky130_fd_pr__nfet_01v8 L=0.15 W=0.5 nf=1 ad=0.145 as=0.145 pd=1.58 ps=1.58 nrd=0.58 nrs=0.58 sa=0 sb=0 sd=0 mult=1 m=1
XMNI_c04_w1 wbl_c04_w1 wenb 0 0 sky130_fd_pr__nfet_01v8 L=0.15 W=0.42 nf=1 ad=0.1218 as=0.1218 pd=1.42 ps=1.42 nrd=0.69047619047619 nrs=0.69047619047619 sa=0 sb=0 sd=0 mult=1 m=1
XMNS_c04_w1 sbl_c04_w1 sel_69500 rbl_c04_w1 0 sky130_fd_pr__nfet_01v8 L=0.15 W=0.42 nf=1 ad=0.1218 as=0.1218 pd=1.42 ps=1.42 nrd=0.69047619047619 nrs=0.69047619047619 sa=0 sb=0 sd=0 mult=1 m=1
XMNSR_c04_w1 sref_c04_w1 sel_69500 ref_c04_w1 0 sky130_fd_pr__nfet_01v8 L=0.15 W=0.42 nf=1 ad=0.1218 as=0.1218 pd=1.42 ps=1.42 nrd=0.69047619047619 nrs=0.69047619047619 sa=0 sb=0 sd=0 mult=1 m=1
XMN1_c04_w1 sbl_c04_w1 sref_c04_w1 vn_c04_w1 0 sky130_fd_pr__nfet_01v8 L=0.15 W=1 nf=1 ad=0.29 as=0.29 pd=2.58 ps=2.58 nrd=0.29 nrs=0.29 sa=0 sb=0 sd=0 mult=1 m=1
XMN2_c04_w1 sref_c04_w1 sbl_c04_w1 vn_c04_w1 0 sky130_fd_pr__nfet_01v8 L=0.15 W=1 nf=1 ad=0.29 as=0.29 pd=2.58 ps=2.58 nrd=0.29 nrs=0.29 sa=0 sb=0 sd=0 mult=1 m=1
XMP1_c04_w1 sbl_c04_w1 sref_c04_w1 vp_c04_w1 vdd sky130_fd_pr__pfet_01v8 L=0.15 W=2 nf=1 ad=0.58 as=0.58 pd=4.58 ps=4.58 nrd=0.145 nrs=0.145 sa=0 sb=0 sd=0 mult=1 m=1
XMP2_c04_w1 sref_c04_w1 sbl_c04_w1 vp_c04_w1 vdd sky130_fd_pr__pfet_01v8 L=0.15 W=2 nf=1 ad=0.58 as=0.58 pd=4.58 ps=4.58 nrd=0.145 nrs=0.145 sa=0 sb=0 sd=0 mult=1 m=1
XMNF_c04_w1 vn_c04_w1 en 0 0 sky130_fd_pr__nfet_01v8 L=0.15 W=2 nf=1 ad=0.58 as=0.58 pd=4.58 ps=4.58 nrd=0.145 nrs=0.145 sa=0 sb=0 sd=0 mult=1 m=1
XMPH_c04_w1 vp_c04_w1 enb vdd vdd sky130_fd_pr__pfet_01v8 L=0.15 W=4 nf=1 ad=1.16 as=1.16 pd=8.58 ps=8.58 nrd=0.0725 nrs=0.0725 sa=0 sb=0 sd=0 mult=1 m=1
bd_c04_w1 d_c04_w1 0 v=v(sbl_c04_w1)-v(sref_c04_w1)
bdabs_c04_w1 dabs_c04_w1 0 v=abs(v(sbl_c04_w1)-v(sref_c04_w1))

* ---- instance 93: c04_w0 (nfet-only 0.42, release edge 0.5 ns) ----
XMWR_c04_w0_0 sn_c04_w0_0 wl wbl_c04_w0 0 sky130_fd_pr__nfet_01v8 L=0.15 W=0.42 nf=1 ad=0.1218 as=0.1218 pd=1.42 ps=1.42 nrd=0.69047619047619 nrs=0.69047619047619 sa=0 sb=0 sd=0 mult=1 m=1
XMRD_c04_w0_0 rbl_c04_w0 sn_c04_w0_0 rwl_sel 0 sky130_fd_pr__nfet_01v8 L=0.15 W=0.42 nf=1 ad=0.1218 as=0.1218 pd=1.42 ps=1.42 nrd=0.69047619047619 nrs=0.69047619047619 sa=0 sb=0 sd=0 mult=1 m=1
csn_c04_w0_0 sn_c04_w0_0 0 {C_SN}
XMWR_c04_w0_1 sn_c04_w0_1 0 wbl_c04_w0 0 sky130_fd_pr__nfet_01v8 L=0.15 W=0.42 nf=1 ad=0.1218 as=0.1218 pd=1.42 ps=1.42 nrd=0.69047619047619 nrs=0.69047619047619 sa=0 sb=0 sd=0 mult=1 m=1
XMRD_c04_w0_1 rbl_c04_w0 sn_c04_w0_1 rwl_des 0 sky130_fd_pr__nfet_01v8 L=0.15 W=0.42 nf=1 ad=0.1218 as=0.1218 pd=1.42 ps=1.42 nrd=0.69047619047619 nrs=0.69047619047619 sa=0 sb=0 sd=0 mult=1 m=1
csn_c04_w0_1 sn_c04_w0_1 0 {C_SN}
XMWR_c04_w0_2 sn_c04_w0_2 0 wbl_c04_w0 0 sky130_fd_pr__nfet_01v8 L=0.15 W=0.42 nf=1 ad=0.1218 as=0.1218 pd=1.42 ps=1.42 nrd=0.69047619047619 nrs=0.69047619047619 sa=0 sb=0 sd=0 mult=1 m=1
XMRD_c04_w0_2 rbl_c04_w0 sn_c04_w0_2 rwl_des 0 sky130_fd_pr__nfet_01v8 L=0.15 W=0.42 nf=1 ad=0.1218 as=0.1218 pd=1.42 ps=1.42 nrd=0.69047619047619 nrs=0.69047619047619 sa=0 sb=0 sd=0 mult=1 m=1
csn_c04_w0_2 sn_c04_w0_2 0 {C_SN}
XMWR_c04_w0_3 sn_c04_w0_3 0 wbl_c04_w0 0 sky130_fd_pr__nfet_01v8 L=0.15 W=0.42 nf=1 ad=0.1218 as=0.1218 pd=1.42 ps=1.42 nrd=0.69047619047619 nrs=0.69047619047619 sa=0 sb=0 sd=0 mult=1 m=1
XMRD_c04_w0_3 rbl_c04_w0 sn_c04_w0_3 rwl_des 0 sky130_fd_pr__nfet_01v8 L=0.15 W=0.42 nf=1 ad=0.1218 as=0.1218 pd=1.42 ps=1.42 nrd=0.69047619047619 nrs=0.69047619047619 sa=0 sb=0 sd=0 mult=1 m=1
csn_c04_w0_3 sn_c04_w0_3 0 {C_SN}
crbl_c04_w0 rbl_c04_w0 0 {C_RBL}
cwbl_c04_w0 wbl_c04_w0 0 {C_WBL}
cref_c04_w0 ref_c04_w0 0 {C_RBL}   $ ASSUMPTION: ideal matched dummy load
spr_c04_w0 pref ref_c04_w0 pca 0 swpre   $ reference-side precharge: ideal switch (#114 convention)
XMPPRE_c04_w0 rbl_c04_w0 pcb_500 prea prea sky130_fd_pr__pfet_01v8 L=0.15 W=4 nf=1 ad=1.16 as=1.16 pd=8.58 ps=8.58 nrd=0.0725 nrs=0.0725 sa=0 sb=0 sd=0 mult=1 m=1
XMPU1_c04_w0 x_c04_w0 dinb0 vdd vdd sky130_fd_pr__pfet_01v8 L=0.15 W=1 nf=1 ad=0.29 as=0.29 pd=2.58 ps=2.58 nrd=0.29 nrs=0.29 sa=0 sb=0 sd=0 mult=1 m=1
XMPU2_c04_w0 wbl_c04_w0 wenb x_c04_w0 vdd sky130_fd_pr__pfet_01v8 L=0.15 W=1 nf=1 ad=0.29 as=0.29 pd=2.58 ps=2.58 nrd=0.29 nrs=0.29 sa=0 sb=0 sd=0 mult=1 m=1
XMND2_c04_w0 wbl_c04_w0 wen y_c04_w0 0 sky130_fd_pr__nfet_01v8 L=0.15 W=0.5 nf=1 ad=0.145 as=0.145 pd=1.58 ps=1.58 nrd=0.58 nrs=0.58 sa=0 sb=0 sd=0 mult=1 m=1
XMND1_c04_w0 y_c04_w0 dinb0 0 0 sky130_fd_pr__nfet_01v8 L=0.15 W=0.5 nf=1 ad=0.145 as=0.145 pd=1.58 ps=1.58 nrd=0.58 nrs=0.58 sa=0 sb=0 sd=0 mult=1 m=1
XMNI_c04_w0 wbl_c04_w0 wenb 0 0 sky130_fd_pr__nfet_01v8 L=0.15 W=0.42 nf=1 ad=0.1218 as=0.1218 pd=1.42 ps=1.42 nrd=0.69047619047619 nrs=0.69047619047619 sa=0 sb=0 sd=0 mult=1 m=1
XMNS_c04_w0 sbl_c04_w0 sel_69500 rbl_c04_w0 0 sky130_fd_pr__nfet_01v8 L=0.15 W=0.42 nf=1 ad=0.1218 as=0.1218 pd=1.42 ps=1.42 nrd=0.69047619047619 nrs=0.69047619047619 sa=0 sb=0 sd=0 mult=1 m=1
XMNSR_c04_w0 sref_c04_w0 sel_69500 ref_c04_w0 0 sky130_fd_pr__nfet_01v8 L=0.15 W=0.42 nf=1 ad=0.1218 as=0.1218 pd=1.42 ps=1.42 nrd=0.69047619047619 nrs=0.69047619047619 sa=0 sb=0 sd=0 mult=1 m=1
XMN1_c04_w0 sbl_c04_w0 sref_c04_w0 vn_c04_w0 0 sky130_fd_pr__nfet_01v8 L=0.15 W=1 nf=1 ad=0.29 as=0.29 pd=2.58 ps=2.58 nrd=0.29 nrs=0.29 sa=0 sb=0 sd=0 mult=1 m=1
XMN2_c04_w0 sref_c04_w0 sbl_c04_w0 vn_c04_w0 0 sky130_fd_pr__nfet_01v8 L=0.15 W=1 nf=1 ad=0.29 as=0.29 pd=2.58 ps=2.58 nrd=0.29 nrs=0.29 sa=0 sb=0 sd=0 mult=1 m=1
XMP1_c04_w0 sbl_c04_w0 sref_c04_w0 vp_c04_w0 vdd sky130_fd_pr__pfet_01v8 L=0.15 W=2 nf=1 ad=0.58 as=0.58 pd=4.58 ps=4.58 nrd=0.145 nrs=0.145 sa=0 sb=0 sd=0 mult=1 m=1
XMP2_c04_w0 sref_c04_w0 sbl_c04_w0 vp_c04_w0 vdd sky130_fd_pr__pfet_01v8 L=0.15 W=2 nf=1 ad=0.58 as=0.58 pd=4.58 ps=4.58 nrd=0.145 nrs=0.145 sa=0 sb=0 sd=0 mult=1 m=1
XMNF_c04_w0 vn_c04_w0 en 0 0 sky130_fd_pr__nfet_01v8 L=0.15 W=2 nf=1 ad=0.58 as=0.58 pd=4.58 ps=4.58 nrd=0.145 nrs=0.145 sa=0 sb=0 sd=0 mult=1 m=1
XMPH_c04_w0 vp_c04_w0 enb vdd vdd sky130_fd_pr__pfet_01v8 L=0.15 W=4 nf=1 ad=1.16 as=1.16 pd=8.58 ps=8.58 nrd=0.0725 nrs=0.0725 sa=0 sb=0 sd=0 mult=1 m=1
bd_c04_w0 d_c04_w0 0 v=v(sbl_c04_w0)-v(sref_c04_w0)
bdabs_c04_w0 dabs_c04_w0 0 v=abs(v(sbl_c04_w0)-v(sref_c04_w0))

* ---- instance 94: c05_w1 (nfet-only 0.42, MPPRE 3.0, matched ref) ----
XMWR_c05_w1_0 sn_c05_w1_0 wl wbl_c05_w1 0 sky130_fd_pr__nfet_01v8 L=0.15 W=0.42 nf=1 ad=0.1218 as=0.1218 pd=1.42 ps=1.42 nrd=0.69047619047619 nrs=0.69047619047619 sa=0 sb=0 sd=0 mult=1 m=1
XMRD_c05_w1_0 rbl_c05_w1 sn_c05_w1_0 rwl_sel 0 sky130_fd_pr__nfet_01v8 L=0.15 W=0.42 nf=1 ad=0.1218 as=0.1218 pd=1.42 ps=1.42 nrd=0.69047619047619 nrs=0.69047619047619 sa=0 sb=0 sd=0 mult=1 m=1
csn_c05_w1_0 sn_c05_w1_0 0 {C_SN}
XMWR_c05_w1_1 sn_c05_w1_1 0 wbl_c05_w1 0 sky130_fd_pr__nfet_01v8 L=0.15 W=0.42 nf=1 ad=0.1218 as=0.1218 pd=1.42 ps=1.42 nrd=0.69047619047619 nrs=0.69047619047619 sa=0 sb=0 sd=0 mult=1 m=1
XMRD_c05_w1_1 rbl_c05_w1 sn_c05_w1_1 rwl_des 0 sky130_fd_pr__nfet_01v8 L=0.15 W=0.42 nf=1 ad=0.1218 as=0.1218 pd=1.42 ps=1.42 nrd=0.69047619047619 nrs=0.69047619047619 sa=0 sb=0 sd=0 mult=1 m=1
csn_c05_w1_1 sn_c05_w1_1 0 {C_SN}
XMWR_c05_w1_2 sn_c05_w1_2 0 wbl_c05_w1 0 sky130_fd_pr__nfet_01v8 L=0.15 W=0.42 nf=1 ad=0.1218 as=0.1218 pd=1.42 ps=1.42 nrd=0.69047619047619 nrs=0.69047619047619 sa=0 sb=0 sd=0 mult=1 m=1
XMRD_c05_w1_2 rbl_c05_w1 sn_c05_w1_2 rwl_des 0 sky130_fd_pr__nfet_01v8 L=0.15 W=0.42 nf=1 ad=0.1218 as=0.1218 pd=1.42 ps=1.42 nrd=0.69047619047619 nrs=0.69047619047619 sa=0 sb=0 sd=0 mult=1 m=1
csn_c05_w1_2 sn_c05_w1_2 0 {C_SN}
XMWR_c05_w1_3 sn_c05_w1_3 0 wbl_c05_w1 0 sky130_fd_pr__nfet_01v8 L=0.15 W=0.42 nf=1 ad=0.1218 as=0.1218 pd=1.42 ps=1.42 nrd=0.69047619047619 nrs=0.69047619047619 sa=0 sb=0 sd=0 mult=1 m=1
XMRD_c05_w1_3 rbl_c05_w1 sn_c05_w1_3 rwl_des 0 sky130_fd_pr__nfet_01v8 L=0.15 W=0.42 nf=1 ad=0.1218 as=0.1218 pd=1.42 ps=1.42 nrd=0.69047619047619 nrs=0.69047619047619 sa=0 sb=0 sd=0 mult=1 m=1
csn_c05_w1_3 sn_c05_w1_3 0 {C_SN}
crbl_c05_w1 rbl_c05_w1 0 {C_RBL}
cwbl_c05_w1 wbl_c05_w1 0 {C_WBL}
cref_c05_w1 ref_c05_w1 0 {C_RBL}   $ ASSUMPTION: ideal matched dummy load
XMPPRE_c05_w1 rbl_c05_w1 pcb_100 prea prea sky130_fd_pr__pfet_01v8 L=0.15 W=3 nf=1 ad=0.87 as=0.87 pd=6.58 ps=6.58 nrd=0.096666666666667 nrs=0.096666666666667 sa=0 sb=0 sd=0 mult=1 m=1
XMPU1_c05_w1 x_c05_w1 dinb1 vdd vdd sky130_fd_pr__pfet_01v8 L=0.15 W=1 nf=1 ad=0.29 as=0.29 pd=2.58 ps=2.58 nrd=0.29 nrs=0.29 sa=0 sb=0 sd=0 mult=1 m=1
XMPU2_c05_w1 wbl_c05_w1 wenb x_c05_w1 vdd sky130_fd_pr__pfet_01v8 L=0.15 W=1 nf=1 ad=0.29 as=0.29 pd=2.58 ps=2.58 nrd=0.29 nrs=0.29 sa=0 sb=0 sd=0 mult=1 m=1
XMND2_c05_w1 wbl_c05_w1 wen y_c05_w1 0 sky130_fd_pr__nfet_01v8 L=0.15 W=0.5 nf=1 ad=0.145 as=0.145 pd=1.58 ps=1.58 nrd=0.58 nrs=0.58 sa=0 sb=0 sd=0 mult=1 m=1
XMND1_c05_w1 y_c05_w1 dinb1 0 0 sky130_fd_pr__nfet_01v8 L=0.15 W=0.5 nf=1 ad=0.145 as=0.145 pd=1.58 ps=1.58 nrd=0.58 nrs=0.58 sa=0 sb=0 sd=0 mult=1 m=1
XMNI_c05_w1 wbl_c05_w1 wenb 0 0 sky130_fd_pr__nfet_01v8 L=0.15 W=0.42 nf=1 ad=0.1218 as=0.1218 pd=1.42 ps=1.42 nrd=0.69047619047619 nrs=0.69047619047619 sa=0 sb=0 sd=0 mult=1 m=1
XMNS_c05_w1 sbl_c05_w1 sel_69500 rbl_c05_w1 0 sky130_fd_pr__nfet_01v8 L=0.15 W=0.42 nf=1 ad=0.1218 as=0.1218 pd=1.42 ps=1.42 nrd=0.69047619047619 nrs=0.69047619047619 sa=0 sb=0 sd=0 mult=1 m=1
XMNSR_c05_w1 sref_c05_w1 sel_69500 ref_c05_w1 0 sky130_fd_pr__nfet_01v8 L=0.15 W=0.42 nf=1 ad=0.1218 as=0.1218 pd=1.42 ps=1.42 nrd=0.69047619047619 nrs=0.69047619047619 sa=0 sb=0 sd=0 mult=1 m=1
XMPPREF_c05_w1 ref_c05_w1 pcb_100 pref pref sky130_fd_pr__pfet_01v8 L=0.15 W=3 nf=1 ad=0.87 as=0.87 pd=6.58 ps=6.58 nrd=0.096666666666667 nrs=0.096666666666667 sa=0 sb=0 sd=0 mult=1 m=1   $ reference-side precharge: copy of MPPRE
XMN1_c05_w1 sbl_c05_w1 sref_c05_w1 vn_c05_w1 0 sky130_fd_pr__nfet_01v8 L=0.15 W=1 nf=1 ad=0.29 as=0.29 pd=2.58 ps=2.58 nrd=0.29 nrs=0.29 sa=0 sb=0 sd=0 mult=1 m=1
XMN2_c05_w1 sref_c05_w1 sbl_c05_w1 vn_c05_w1 0 sky130_fd_pr__nfet_01v8 L=0.15 W=1 nf=1 ad=0.29 as=0.29 pd=2.58 ps=2.58 nrd=0.29 nrs=0.29 sa=0 sb=0 sd=0 mult=1 m=1
XMP1_c05_w1 sbl_c05_w1 sref_c05_w1 vp_c05_w1 vdd sky130_fd_pr__pfet_01v8 L=0.15 W=2 nf=1 ad=0.58 as=0.58 pd=4.58 ps=4.58 nrd=0.145 nrs=0.145 sa=0 sb=0 sd=0 mult=1 m=1
XMP2_c05_w1 sref_c05_w1 sbl_c05_w1 vp_c05_w1 vdd sky130_fd_pr__pfet_01v8 L=0.15 W=2 nf=1 ad=0.58 as=0.58 pd=4.58 ps=4.58 nrd=0.145 nrs=0.145 sa=0 sb=0 sd=0 mult=1 m=1
XMNF_c05_w1 vn_c05_w1 en 0 0 sky130_fd_pr__nfet_01v8 L=0.15 W=2 nf=1 ad=0.58 as=0.58 pd=4.58 ps=4.58 nrd=0.145 nrs=0.145 sa=0 sb=0 sd=0 mult=1 m=1
XMPH_c05_w1 vp_c05_w1 enb vdd vdd sky130_fd_pr__pfet_01v8 L=0.15 W=4 nf=1 ad=1.16 as=1.16 pd=8.58 ps=8.58 nrd=0.0725 nrs=0.0725 sa=0 sb=0 sd=0 mult=1 m=1
bd_c05_w1 d_c05_w1 0 v=v(sbl_c05_w1)-v(sref_c05_w1)
bdabs_c05_w1 dabs_c05_w1 0 v=abs(v(sbl_c05_w1)-v(sref_c05_w1))

* ---- instance 95: c05_w0 (nfet-only 0.42, MPPRE 3.0, matched ref) ----
XMWR_c05_w0_0 sn_c05_w0_0 wl wbl_c05_w0 0 sky130_fd_pr__nfet_01v8 L=0.15 W=0.42 nf=1 ad=0.1218 as=0.1218 pd=1.42 ps=1.42 nrd=0.69047619047619 nrs=0.69047619047619 sa=0 sb=0 sd=0 mult=1 m=1
XMRD_c05_w0_0 rbl_c05_w0 sn_c05_w0_0 rwl_sel 0 sky130_fd_pr__nfet_01v8 L=0.15 W=0.42 nf=1 ad=0.1218 as=0.1218 pd=1.42 ps=1.42 nrd=0.69047619047619 nrs=0.69047619047619 sa=0 sb=0 sd=0 mult=1 m=1
csn_c05_w0_0 sn_c05_w0_0 0 {C_SN}
XMWR_c05_w0_1 sn_c05_w0_1 0 wbl_c05_w0 0 sky130_fd_pr__nfet_01v8 L=0.15 W=0.42 nf=1 ad=0.1218 as=0.1218 pd=1.42 ps=1.42 nrd=0.69047619047619 nrs=0.69047619047619 sa=0 sb=0 sd=0 mult=1 m=1
XMRD_c05_w0_1 rbl_c05_w0 sn_c05_w0_1 rwl_des 0 sky130_fd_pr__nfet_01v8 L=0.15 W=0.42 nf=1 ad=0.1218 as=0.1218 pd=1.42 ps=1.42 nrd=0.69047619047619 nrs=0.69047619047619 sa=0 sb=0 sd=0 mult=1 m=1
csn_c05_w0_1 sn_c05_w0_1 0 {C_SN}
XMWR_c05_w0_2 sn_c05_w0_2 0 wbl_c05_w0 0 sky130_fd_pr__nfet_01v8 L=0.15 W=0.42 nf=1 ad=0.1218 as=0.1218 pd=1.42 ps=1.42 nrd=0.69047619047619 nrs=0.69047619047619 sa=0 sb=0 sd=0 mult=1 m=1
XMRD_c05_w0_2 rbl_c05_w0 sn_c05_w0_2 rwl_des 0 sky130_fd_pr__nfet_01v8 L=0.15 W=0.42 nf=1 ad=0.1218 as=0.1218 pd=1.42 ps=1.42 nrd=0.69047619047619 nrs=0.69047619047619 sa=0 sb=0 sd=0 mult=1 m=1
csn_c05_w0_2 sn_c05_w0_2 0 {C_SN}
XMWR_c05_w0_3 sn_c05_w0_3 0 wbl_c05_w0 0 sky130_fd_pr__nfet_01v8 L=0.15 W=0.42 nf=1 ad=0.1218 as=0.1218 pd=1.42 ps=1.42 nrd=0.69047619047619 nrs=0.69047619047619 sa=0 sb=0 sd=0 mult=1 m=1
XMRD_c05_w0_3 rbl_c05_w0 sn_c05_w0_3 rwl_des 0 sky130_fd_pr__nfet_01v8 L=0.15 W=0.42 nf=1 ad=0.1218 as=0.1218 pd=1.42 ps=1.42 nrd=0.69047619047619 nrs=0.69047619047619 sa=0 sb=0 sd=0 mult=1 m=1
csn_c05_w0_3 sn_c05_w0_3 0 {C_SN}
crbl_c05_w0 rbl_c05_w0 0 {C_RBL}
cwbl_c05_w0 wbl_c05_w0 0 {C_WBL}
cref_c05_w0 ref_c05_w0 0 {C_RBL}   $ ASSUMPTION: ideal matched dummy load
XMPPRE_c05_w0 rbl_c05_w0 pcb_100 prea prea sky130_fd_pr__pfet_01v8 L=0.15 W=3 nf=1 ad=0.87 as=0.87 pd=6.58 ps=6.58 nrd=0.096666666666667 nrs=0.096666666666667 sa=0 sb=0 sd=0 mult=1 m=1
XMPU1_c05_w0 x_c05_w0 dinb0 vdd vdd sky130_fd_pr__pfet_01v8 L=0.15 W=1 nf=1 ad=0.29 as=0.29 pd=2.58 ps=2.58 nrd=0.29 nrs=0.29 sa=0 sb=0 sd=0 mult=1 m=1
XMPU2_c05_w0 wbl_c05_w0 wenb x_c05_w0 vdd sky130_fd_pr__pfet_01v8 L=0.15 W=1 nf=1 ad=0.29 as=0.29 pd=2.58 ps=2.58 nrd=0.29 nrs=0.29 sa=0 sb=0 sd=0 mult=1 m=1
XMND2_c05_w0 wbl_c05_w0 wen y_c05_w0 0 sky130_fd_pr__nfet_01v8 L=0.15 W=0.5 nf=1 ad=0.145 as=0.145 pd=1.58 ps=1.58 nrd=0.58 nrs=0.58 sa=0 sb=0 sd=0 mult=1 m=1
XMND1_c05_w0 y_c05_w0 dinb0 0 0 sky130_fd_pr__nfet_01v8 L=0.15 W=0.5 nf=1 ad=0.145 as=0.145 pd=1.58 ps=1.58 nrd=0.58 nrs=0.58 sa=0 sb=0 sd=0 mult=1 m=1
XMNI_c05_w0 wbl_c05_w0 wenb 0 0 sky130_fd_pr__nfet_01v8 L=0.15 W=0.42 nf=1 ad=0.1218 as=0.1218 pd=1.42 ps=1.42 nrd=0.69047619047619 nrs=0.69047619047619 sa=0 sb=0 sd=0 mult=1 m=1
XMNS_c05_w0 sbl_c05_w0 sel_69500 rbl_c05_w0 0 sky130_fd_pr__nfet_01v8 L=0.15 W=0.42 nf=1 ad=0.1218 as=0.1218 pd=1.42 ps=1.42 nrd=0.69047619047619 nrs=0.69047619047619 sa=0 sb=0 sd=0 mult=1 m=1
XMNSR_c05_w0 sref_c05_w0 sel_69500 ref_c05_w0 0 sky130_fd_pr__nfet_01v8 L=0.15 W=0.42 nf=1 ad=0.1218 as=0.1218 pd=1.42 ps=1.42 nrd=0.69047619047619 nrs=0.69047619047619 sa=0 sb=0 sd=0 mult=1 m=1
XMPPREF_c05_w0 ref_c05_w0 pcb_100 pref pref sky130_fd_pr__pfet_01v8 L=0.15 W=3 nf=1 ad=0.87 as=0.87 pd=6.58 ps=6.58 nrd=0.096666666666667 nrs=0.096666666666667 sa=0 sb=0 sd=0 mult=1 m=1   $ reference-side precharge: copy of MPPRE
XMN1_c05_w0 sbl_c05_w0 sref_c05_w0 vn_c05_w0 0 sky130_fd_pr__nfet_01v8 L=0.15 W=1 nf=1 ad=0.29 as=0.29 pd=2.58 ps=2.58 nrd=0.29 nrs=0.29 sa=0 sb=0 sd=0 mult=1 m=1
XMN2_c05_w0 sref_c05_w0 sbl_c05_w0 vn_c05_w0 0 sky130_fd_pr__nfet_01v8 L=0.15 W=1 nf=1 ad=0.29 as=0.29 pd=2.58 ps=2.58 nrd=0.29 nrs=0.29 sa=0 sb=0 sd=0 mult=1 m=1
XMP1_c05_w0 sbl_c05_w0 sref_c05_w0 vp_c05_w0 vdd sky130_fd_pr__pfet_01v8 L=0.15 W=2 nf=1 ad=0.58 as=0.58 pd=4.58 ps=4.58 nrd=0.145 nrs=0.145 sa=0 sb=0 sd=0 mult=1 m=1
XMP2_c05_w0 sref_c05_w0 sbl_c05_w0 vp_c05_w0 vdd sky130_fd_pr__pfet_01v8 L=0.15 W=2 nf=1 ad=0.58 as=0.58 pd=4.58 ps=4.58 nrd=0.145 nrs=0.145 sa=0 sb=0 sd=0 mult=1 m=1
XMNF_c05_w0 vn_c05_w0 en 0 0 sky130_fd_pr__nfet_01v8 L=0.15 W=2 nf=1 ad=0.58 as=0.58 pd=4.58 ps=4.58 nrd=0.145 nrs=0.145 sa=0 sb=0 sd=0 mult=1 m=1
XMPH_c05_w0 vp_c05_w0 enb vdd vdd sky130_fd_pr__pfet_01v8 L=0.15 W=4 nf=1 ad=1.16 as=1.16 pd=8.58 ps=8.58 nrd=0.0725 nrs=0.0725 sa=0 sb=0 sd=0 mult=1 m=1
bd_c05_w0 d_c05_w0 0 v=v(sbl_c05_w0)-v(sref_c05_w0)
bdabs_c05_w0 dabs_c05_w0 0 v=abs(v(sbl_c05_w0)-v(sref_c05_w0))

* ---- instance 96: f00_w1 (FINAL: nfet-only 0.42 isolation, matched ref precharge 5.0, MND1/MND2 4.0, MNI 2.0) ----
XMWR_f00_w1_0 sn_f00_w1_0 wl wbl_f00_w1 0 sky130_fd_pr__nfet_01v8 L=0.15 W=0.42 nf=1 ad=0.1218 as=0.1218 pd=1.42 ps=1.42 nrd=0.69047619047619 nrs=0.69047619047619 sa=0 sb=0 sd=0 mult=1 m=1
XMRD_f00_w1_0 rbl_f00_w1 sn_f00_w1_0 rwl_sel 0 sky130_fd_pr__nfet_01v8 L=0.15 W=0.42 nf=1 ad=0.1218 as=0.1218 pd=1.42 ps=1.42 nrd=0.69047619047619 nrs=0.69047619047619 sa=0 sb=0 sd=0 mult=1 m=1
csn_f00_w1_0 sn_f00_w1_0 0 {C_SN}
XMWR_f00_w1_1 sn_f00_w1_1 0 wbl_f00_w1 0 sky130_fd_pr__nfet_01v8 L=0.15 W=0.42 nf=1 ad=0.1218 as=0.1218 pd=1.42 ps=1.42 nrd=0.69047619047619 nrs=0.69047619047619 sa=0 sb=0 sd=0 mult=1 m=1
XMRD_f00_w1_1 rbl_f00_w1 sn_f00_w1_1 rwl_des 0 sky130_fd_pr__nfet_01v8 L=0.15 W=0.42 nf=1 ad=0.1218 as=0.1218 pd=1.42 ps=1.42 nrd=0.69047619047619 nrs=0.69047619047619 sa=0 sb=0 sd=0 mult=1 m=1
csn_f00_w1_1 sn_f00_w1_1 0 {C_SN}
XMWR_f00_w1_2 sn_f00_w1_2 0 wbl_f00_w1 0 sky130_fd_pr__nfet_01v8 L=0.15 W=0.42 nf=1 ad=0.1218 as=0.1218 pd=1.42 ps=1.42 nrd=0.69047619047619 nrs=0.69047619047619 sa=0 sb=0 sd=0 mult=1 m=1
XMRD_f00_w1_2 rbl_f00_w1 sn_f00_w1_2 rwl_des 0 sky130_fd_pr__nfet_01v8 L=0.15 W=0.42 nf=1 ad=0.1218 as=0.1218 pd=1.42 ps=1.42 nrd=0.69047619047619 nrs=0.69047619047619 sa=0 sb=0 sd=0 mult=1 m=1
csn_f00_w1_2 sn_f00_w1_2 0 {C_SN}
XMWR_f00_w1_3 sn_f00_w1_3 0 wbl_f00_w1 0 sky130_fd_pr__nfet_01v8 L=0.15 W=0.42 nf=1 ad=0.1218 as=0.1218 pd=1.42 ps=1.42 nrd=0.69047619047619 nrs=0.69047619047619 sa=0 sb=0 sd=0 mult=1 m=1
XMRD_f00_w1_3 rbl_f00_w1 sn_f00_w1_3 rwl_des 0 sky130_fd_pr__nfet_01v8 L=0.15 W=0.42 nf=1 ad=0.1218 as=0.1218 pd=1.42 ps=1.42 nrd=0.69047619047619 nrs=0.69047619047619 sa=0 sb=0 sd=0 mult=1 m=1
csn_f00_w1_3 sn_f00_w1_3 0 {C_SN}
crbl_f00_w1 rbl_f00_w1 0 {C_RBL}
cwbl_f00_w1 wbl_f00_w1 0 {C_WBL}
cref_f00_w1 ref_f00_w1 0 {C_RBL}   $ ASSUMPTION: ideal matched dummy load
XMPPRE_f00_w1 rbl_f00_w1 pcb_100 prea prea sky130_fd_pr__pfet_01v8 L=0.15 W=5 nf=1 ad=1.45 as=1.45 pd=10.58 ps=10.58 nrd=0.058 nrs=0.058 sa=0 sb=0 sd=0 mult=1 m=1
XMPU1_f00_w1 x_f00_w1 dinb1 vdd vdd sky130_fd_pr__pfet_01v8 L=0.15 W=1 nf=1 ad=0.29 as=0.29 pd=2.58 ps=2.58 nrd=0.29 nrs=0.29 sa=0 sb=0 sd=0 mult=1 m=1
XMPU2_f00_w1 wbl_f00_w1 wenb x_f00_w1 vdd sky130_fd_pr__pfet_01v8 L=0.15 W=1 nf=1 ad=0.29 as=0.29 pd=2.58 ps=2.58 nrd=0.29 nrs=0.29 sa=0 sb=0 sd=0 mult=1 m=1
XMND2_f00_w1 wbl_f00_w1 wen y_f00_w1 0 sky130_fd_pr__nfet_01v8 L=0.15 W=4 nf=1 ad=1.16 as=1.16 pd=8.58 ps=8.58 nrd=0.0725 nrs=0.0725 sa=0 sb=0 sd=0 mult=1 m=1
XMND1_f00_w1 y_f00_w1 dinb1 0 0 sky130_fd_pr__nfet_01v8 L=0.15 W=4 nf=1 ad=1.16 as=1.16 pd=8.58 ps=8.58 nrd=0.0725 nrs=0.0725 sa=0 sb=0 sd=0 mult=1 m=1
XMNI_f00_w1 wbl_f00_w1 wenb 0 0 sky130_fd_pr__nfet_01v8 L=0.15 W=2 nf=1 ad=0.58 as=0.58 pd=4.58 ps=4.58 nrd=0.145 nrs=0.145 sa=0 sb=0 sd=0 mult=1 m=1
XMNS_f00_w1 sbl_f00_w1 sel_69500 rbl_f00_w1 0 sky130_fd_pr__nfet_01v8 L=0.15 W=0.42 nf=1 ad=0.1218 as=0.1218 pd=1.42 ps=1.42 nrd=0.69047619047619 nrs=0.69047619047619 sa=0 sb=0 sd=0 mult=1 m=1
XMNSR_f00_w1 sref_f00_w1 sel_69500 ref_f00_w1 0 sky130_fd_pr__nfet_01v8 L=0.15 W=0.42 nf=1 ad=0.1218 as=0.1218 pd=1.42 ps=1.42 nrd=0.69047619047619 nrs=0.69047619047619 sa=0 sb=0 sd=0 mult=1 m=1
XMPPREF_f00_w1 ref_f00_w1 pcb_100 pref pref sky130_fd_pr__pfet_01v8 L=0.15 W=5 nf=1 ad=1.45 as=1.45 pd=10.58 ps=10.58 nrd=0.058 nrs=0.058 sa=0 sb=0 sd=0 mult=1 m=1   $ reference-side precharge: copy of MPPRE
XMN1_f00_w1 sbl_f00_w1 sref_f00_w1 vn_f00_w1 0 sky130_fd_pr__nfet_01v8 L=0.15 W=1 nf=1 ad=0.29 as=0.29 pd=2.58 ps=2.58 nrd=0.29 nrs=0.29 sa=0 sb=0 sd=0 mult=1 m=1
XMN2_f00_w1 sref_f00_w1 sbl_f00_w1 vn_f00_w1 0 sky130_fd_pr__nfet_01v8 L=0.15 W=1 nf=1 ad=0.29 as=0.29 pd=2.58 ps=2.58 nrd=0.29 nrs=0.29 sa=0 sb=0 sd=0 mult=1 m=1
XMP1_f00_w1 sbl_f00_w1 sref_f00_w1 vp_f00_w1 vdd sky130_fd_pr__pfet_01v8 L=0.15 W=2 nf=1 ad=0.58 as=0.58 pd=4.58 ps=4.58 nrd=0.145 nrs=0.145 sa=0 sb=0 sd=0 mult=1 m=1
XMP2_f00_w1 sref_f00_w1 sbl_f00_w1 vp_f00_w1 vdd sky130_fd_pr__pfet_01v8 L=0.15 W=2 nf=1 ad=0.58 as=0.58 pd=4.58 ps=4.58 nrd=0.145 nrs=0.145 sa=0 sb=0 sd=0 mult=1 m=1
XMNF_f00_w1 vn_f00_w1 en 0 0 sky130_fd_pr__nfet_01v8 L=0.15 W=2 nf=1 ad=0.58 as=0.58 pd=4.58 ps=4.58 nrd=0.145 nrs=0.145 sa=0 sb=0 sd=0 mult=1 m=1
XMPH_f00_w1 vp_f00_w1 enb vdd vdd sky130_fd_pr__pfet_01v8 L=0.15 W=4 nf=1 ad=1.16 as=1.16 pd=8.58 ps=8.58 nrd=0.0725 nrs=0.0725 sa=0 sb=0 sd=0 mult=1 m=1
bd_f00_w1 d_f00_w1 0 v=v(sbl_f00_w1)-v(sref_f00_w1)
bdabs_f00_w1 dabs_f00_w1 0 v=abs(v(sbl_f00_w1)-v(sref_f00_w1))

* ---- instance 97: f00_w0 (FINAL: nfet-only 0.42 isolation, matched ref precharge 5.0, MND1/MND2 4.0, MNI 2.0) ----
XMWR_f00_w0_0 sn_f00_w0_0 wl wbl_f00_w0 0 sky130_fd_pr__nfet_01v8 L=0.15 W=0.42 nf=1 ad=0.1218 as=0.1218 pd=1.42 ps=1.42 nrd=0.69047619047619 nrs=0.69047619047619 sa=0 sb=0 sd=0 mult=1 m=1
XMRD_f00_w0_0 rbl_f00_w0 sn_f00_w0_0 rwl_sel 0 sky130_fd_pr__nfet_01v8 L=0.15 W=0.42 nf=1 ad=0.1218 as=0.1218 pd=1.42 ps=1.42 nrd=0.69047619047619 nrs=0.69047619047619 sa=0 sb=0 sd=0 mult=1 m=1
csn_f00_w0_0 sn_f00_w0_0 0 {C_SN}
XMWR_f00_w0_1 sn_f00_w0_1 0 wbl_f00_w0 0 sky130_fd_pr__nfet_01v8 L=0.15 W=0.42 nf=1 ad=0.1218 as=0.1218 pd=1.42 ps=1.42 nrd=0.69047619047619 nrs=0.69047619047619 sa=0 sb=0 sd=0 mult=1 m=1
XMRD_f00_w0_1 rbl_f00_w0 sn_f00_w0_1 rwl_des 0 sky130_fd_pr__nfet_01v8 L=0.15 W=0.42 nf=1 ad=0.1218 as=0.1218 pd=1.42 ps=1.42 nrd=0.69047619047619 nrs=0.69047619047619 sa=0 sb=0 sd=0 mult=1 m=1
csn_f00_w0_1 sn_f00_w0_1 0 {C_SN}
XMWR_f00_w0_2 sn_f00_w0_2 0 wbl_f00_w0 0 sky130_fd_pr__nfet_01v8 L=0.15 W=0.42 nf=1 ad=0.1218 as=0.1218 pd=1.42 ps=1.42 nrd=0.69047619047619 nrs=0.69047619047619 sa=0 sb=0 sd=0 mult=1 m=1
XMRD_f00_w0_2 rbl_f00_w0 sn_f00_w0_2 rwl_des 0 sky130_fd_pr__nfet_01v8 L=0.15 W=0.42 nf=1 ad=0.1218 as=0.1218 pd=1.42 ps=1.42 nrd=0.69047619047619 nrs=0.69047619047619 sa=0 sb=0 sd=0 mult=1 m=1
csn_f00_w0_2 sn_f00_w0_2 0 {C_SN}
XMWR_f00_w0_3 sn_f00_w0_3 0 wbl_f00_w0 0 sky130_fd_pr__nfet_01v8 L=0.15 W=0.42 nf=1 ad=0.1218 as=0.1218 pd=1.42 ps=1.42 nrd=0.69047619047619 nrs=0.69047619047619 sa=0 sb=0 sd=0 mult=1 m=1
XMRD_f00_w0_3 rbl_f00_w0 sn_f00_w0_3 rwl_des 0 sky130_fd_pr__nfet_01v8 L=0.15 W=0.42 nf=1 ad=0.1218 as=0.1218 pd=1.42 ps=1.42 nrd=0.69047619047619 nrs=0.69047619047619 sa=0 sb=0 sd=0 mult=1 m=1
csn_f00_w0_3 sn_f00_w0_3 0 {C_SN}
crbl_f00_w0 rbl_f00_w0 0 {C_RBL}
cwbl_f00_w0 wbl_f00_w0 0 {C_WBL}
cref_f00_w0 ref_f00_w0 0 {C_RBL}   $ ASSUMPTION: ideal matched dummy load
XMPPRE_f00_w0 rbl_f00_w0 pcb_100 prea prea sky130_fd_pr__pfet_01v8 L=0.15 W=5 nf=1 ad=1.45 as=1.45 pd=10.58 ps=10.58 nrd=0.058 nrs=0.058 sa=0 sb=0 sd=0 mult=1 m=1
XMPU1_f00_w0 x_f00_w0 dinb0 vdd vdd sky130_fd_pr__pfet_01v8 L=0.15 W=1 nf=1 ad=0.29 as=0.29 pd=2.58 ps=2.58 nrd=0.29 nrs=0.29 sa=0 sb=0 sd=0 mult=1 m=1
XMPU2_f00_w0 wbl_f00_w0 wenb x_f00_w0 vdd sky130_fd_pr__pfet_01v8 L=0.15 W=1 nf=1 ad=0.29 as=0.29 pd=2.58 ps=2.58 nrd=0.29 nrs=0.29 sa=0 sb=0 sd=0 mult=1 m=1
XMND2_f00_w0 wbl_f00_w0 wen y_f00_w0 0 sky130_fd_pr__nfet_01v8 L=0.15 W=4 nf=1 ad=1.16 as=1.16 pd=8.58 ps=8.58 nrd=0.0725 nrs=0.0725 sa=0 sb=0 sd=0 mult=1 m=1
XMND1_f00_w0 y_f00_w0 dinb0 0 0 sky130_fd_pr__nfet_01v8 L=0.15 W=4 nf=1 ad=1.16 as=1.16 pd=8.58 ps=8.58 nrd=0.0725 nrs=0.0725 sa=0 sb=0 sd=0 mult=1 m=1
XMNI_f00_w0 wbl_f00_w0 wenb 0 0 sky130_fd_pr__nfet_01v8 L=0.15 W=2 nf=1 ad=0.58 as=0.58 pd=4.58 ps=4.58 nrd=0.145 nrs=0.145 sa=0 sb=0 sd=0 mult=1 m=1
XMNS_f00_w0 sbl_f00_w0 sel_69500 rbl_f00_w0 0 sky130_fd_pr__nfet_01v8 L=0.15 W=0.42 nf=1 ad=0.1218 as=0.1218 pd=1.42 ps=1.42 nrd=0.69047619047619 nrs=0.69047619047619 sa=0 sb=0 sd=0 mult=1 m=1
XMNSR_f00_w0 sref_f00_w0 sel_69500 ref_f00_w0 0 sky130_fd_pr__nfet_01v8 L=0.15 W=0.42 nf=1 ad=0.1218 as=0.1218 pd=1.42 ps=1.42 nrd=0.69047619047619 nrs=0.69047619047619 sa=0 sb=0 sd=0 mult=1 m=1
XMPPREF_f00_w0 ref_f00_w0 pcb_100 pref pref sky130_fd_pr__pfet_01v8 L=0.15 W=5 nf=1 ad=1.45 as=1.45 pd=10.58 ps=10.58 nrd=0.058 nrs=0.058 sa=0 sb=0 sd=0 mult=1 m=1   $ reference-side precharge: copy of MPPRE
XMN1_f00_w0 sbl_f00_w0 sref_f00_w0 vn_f00_w0 0 sky130_fd_pr__nfet_01v8 L=0.15 W=1 nf=1 ad=0.29 as=0.29 pd=2.58 ps=2.58 nrd=0.29 nrs=0.29 sa=0 sb=0 sd=0 mult=1 m=1
XMN2_f00_w0 sref_f00_w0 sbl_f00_w0 vn_f00_w0 0 sky130_fd_pr__nfet_01v8 L=0.15 W=1 nf=1 ad=0.29 as=0.29 pd=2.58 ps=2.58 nrd=0.29 nrs=0.29 sa=0 sb=0 sd=0 mult=1 m=1
XMP1_f00_w0 sbl_f00_w0 sref_f00_w0 vp_f00_w0 vdd sky130_fd_pr__pfet_01v8 L=0.15 W=2 nf=1 ad=0.58 as=0.58 pd=4.58 ps=4.58 nrd=0.145 nrs=0.145 sa=0 sb=0 sd=0 mult=1 m=1
XMP2_f00_w0 sref_f00_w0 sbl_f00_w0 vp_f00_w0 vdd sky130_fd_pr__pfet_01v8 L=0.15 W=2 nf=1 ad=0.58 as=0.58 pd=4.58 ps=4.58 nrd=0.145 nrs=0.145 sa=0 sb=0 sd=0 mult=1 m=1
XMNF_f00_w0 vn_f00_w0 en 0 0 sky130_fd_pr__nfet_01v8 L=0.15 W=2 nf=1 ad=0.58 as=0.58 pd=4.58 ps=4.58 nrd=0.145 nrs=0.145 sa=0 sb=0 sd=0 mult=1 m=1
XMPH_f00_w0 vp_f00_w0 enb vdd vdd sky130_fd_pr__pfet_01v8 L=0.15 W=4 nf=1 ad=1.16 as=1.16 pd=8.58 ps=8.58 nrd=0.0725 nrs=0.0725 sa=0 sb=0 sd=0 mult=1 m=1
bd_f00_w0 d_f00_w0 0 v=v(sbl_f00_w0)-v(sref_f00_w0)
bdabs_f00_w0 dabs_f00_w0 0 v=abs(v(sbl_f00_w0)-v(sref_f00_w0))

* ---- instance 98: f01_w1 (final with MPPRE = MPPREF 4.0) ----
XMWR_f01_w1_0 sn_f01_w1_0 wl wbl_f01_w1 0 sky130_fd_pr__nfet_01v8 L=0.15 W=0.42 nf=1 ad=0.1218 as=0.1218 pd=1.42 ps=1.42 nrd=0.69047619047619 nrs=0.69047619047619 sa=0 sb=0 sd=0 mult=1 m=1
XMRD_f01_w1_0 rbl_f01_w1 sn_f01_w1_0 rwl_sel 0 sky130_fd_pr__nfet_01v8 L=0.15 W=0.42 nf=1 ad=0.1218 as=0.1218 pd=1.42 ps=1.42 nrd=0.69047619047619 nrs=0.69047619047619 sa=0 sb=0 sd=0 mult=1 m=1
csn_f01_w1_0 sn_f01_w1_0 0 {C_SN}
XMWR_f01_w1_1 sn_f01_w1_1 0 wbl_f01_w1 0 sky130_fd_pr__nfet_01v8 L=0.15 W=0.42 nf=1 ad=0.1218 as=0.1218 pd=1.42 ps=1.42 nrd=0.69047619047619 nrs=0.69047619047619 sa=0 sb=0 sd=0 mult=1 m=1
XMRD_f01_w1_1 rbl_f01_w1 sn_f01_w1_1 rwl_des 0 sky130_fd_pr__nfet_01v8 L=0.15 W=0.42 nf=1 ad=0.1218 as=0.1218 pd=1.42 ps=1.42 nrd=0.69047619047619 nrs=0.69047619047619 sa=0 sb=0 sd=0 mult=1 m=1
csn_f01_w1_1 sn_f01_w1_1 0 {C_SN}
XMWR_f01_w1_2 sn_f01_w1_2 0 wbl_f01_w1 0 sky130_fd_pr__nfet_01v8 L=0.15 W=0.42 nf=1 ad=0.1218 as=0.1218 pd=1.42 ps=1.42 nrd=0.69047619047619 nrs=0.69047619047619 sa=0 sb=0 sd=0 mult=1 m=1
XMRD_f01_w1_2 rbl_f01_w1 sn_f01_w1_2 rwl_des 0 sky130_fd_pr__nfet_01v8 L=0.15 W=0.42 nf=1 ad=0.1218 as=0.1218 pd=1.42 ps=1.42 nrd=0.69047619047619 nrs=0.69047619047619 sa=0 sb=0 sd=0 mult=1 m=1
csn_f01_w1_2 sn_f01_w1_2 0 {C_SN}
XMWR_f01_w1_3 sn_f01_w1_3 0 wbl_f01_w1 0 sky130_fd_pr__nfet_01v8 L=0.15 W=0.42 nf=1 ad=0.1218 as=0.1218 pd=1.42 ps=1.42 nrd=0.69047619047619 nrs=0.69047619047619 sa=0 sb=0 sd=0 mult=1 m=1
XMRD_f01_w1_3 rbl_f01_w1 sn_f01_w1_3 rwl_des 0 sky130_fd_pr__nfet_01v8 L=0.15 W=0.42 nf=1 ad=0.1218 as=0.1218 pd=1.42 ps=1.42 nrd=0.69047619047619 nrs=0.69047619047619 sa=0 sb=0 sd=0 mult=1 m=1
csn_f01_w1_3 sn_f01_w1_3 0 {C_SN}
crbl_f01_w1 rbl_f01_w1 0 {C_RBL}
cwbl_f01_w1 wbl_f01_w1 0 {C_WBL}
cref_f01_w1 ref_f01_w1 0 {C_RBL}   $ ASSUMPTION: ideal matched dummy load
XMPPRE_f01_w1 rbl_f01_w1 pcb_100 prea prea sky130_fd_pr__pfet_01v8 L=0.15 W=4 nf=1 ad=1.16 as=1.16 pd=8.58 ps=8.58 nrd=0.0725 nrs=0.0725 sa=0 sb=0 sd=0 mult=1 m=1
XMPU1_f01_w1 x_f01_w1 dinb1 vdd vdd sky130_fd_pr__pfet_01v8 L=0.15 W=1 nf=1 ad=0.29 as=0.29 pd=2.58 ps=2.58 nrd=0.29 nrs=0.29 sa=0 sb=0 sd=0 mult=1 m=1
XMPU2_f01_w1 wbl_f01_w1 wenb x_f01_w1 vdd sky130_fd_pr__pfet_01v8 L=0.15 W=1 nf=1 ad=0.29 as=0.29 pd=2.58 ps=2.58 nrd=0.29 nrs=0.29 sa=0 sb=0 sd=0 mult=1 m=1
XMND2_f01_w1 wbl_f01_w1 wen y_f01_w1 0 sky130_fd_pr__nfet_01v8 L=0.15 W=4 nf=1 ad=1.16 as=1.16 pd=8.58 ps=8.58 nrd=0.0725 nrs=0.0725 sa=0 sb=0 sd=0 mult=1 m=1
XMND1_f01_w1 y_f01_w1 dinb1 0 0 sky130_fd_pr__nfet_01v8 L=0.15 W=4 nf=1 ad=1.16 as=1.16 pd=8.58 ps=8.58 nrd=0.0725 nrs=0.0725 sa=0 sb=0 sd=0 mult=1 m=1
XMNI_f01_w1 wbl_f01_w1 wenb 0 0 sky130_fd_pr__nfet_01v8 L=0.15 W=2 nf=1 ad=0.58 as=0.58 pd=4.58 ps=4.58 nrd=0.145 nrs=0.145 sa=0 sb=0 sd=0 mult=1 m=1
XMNS_f01_w1 sbl_f01_w1 sel_69500 rbl_f01_w1 0 sky130_fd_pr__nfet_01v8 L=0.15 W=0.42 nf=1 ad=0.1218 as=0.1218 pd=1.42 ps=1.42 nrd=0.69047619047619 nrs=0.69047619047619 sa=0 sb=0 sd=0 mult=1 m=1
XMNSR_f01_w1 sref_f01_w1 sel_69500 ref_f01_w1 0 sky130_fd_pr__nfet_01v8 L=0.15 W=0.42 nf=1 ad=0.1218 as=0.1218 pd=1.42 ps=1.42 nrd=0.69047619047619 nrs=0.69047619047619 sa=0 sb=0 sd=0 mult=1 m=1
XMPPREF_f01_w1 ref_f01_w1 pcb_100 pref pref sky130_fd_pr__pfet_01v8 L=0.15 W=4 nf=1 ad=1.16 as=1.16 pd=8.58 ps=8.58 nrd=0.0725 nrs=0.0725 sa=0 sb=0 sd=0 mult=1 m=1   $ reference-side precharge: copy of MPPRE
XMN1_f01_w1 sbl_f01_w1 sref_f01_w1 vn_f01_w1 0 sky130_fd_pr__nfet_01v8 L=0.15 W=1 nf=1 ad=0.29 as=0.29 pd=2.58 ps=2.58 nrd=0.29 nrs=0.29 sa=0 sb=0 sd=0 mult=1 m=1
XMN2_f01_w1 sref_f01_w1 sbl_f01_w1 vn_f01_w1 0 sky130_fd_pr__nfet_01v8 L=0.15 W=1 nf=1 ad=0.29 as=0.29 pd=2.58 ps=2.58 nrd=0.29 nrs=0.29 sa=0 sb=0 sd=0 mult=1 m=1
XMP1_f01_w1 sbl_f01_w1 sref_f01_w1 vp_f01_w1 vdd sky130_fd_pr__pfet_01v8 L=0.15 W=2 nf=1 ad=0.58 as=0.58 pd=4.58 ps=4.58 nrd=0.145 nrs=0.145 sa=0 sb=0 sd=0 mult=1 m=1
XMP2_f01_w1 sref_f01_w1 sbl_f01_w1 vp_f01_w1 vdd sky130_fd_pr__pfet_01v8 L=0.15 W=2 nf=1 ad=0.58 as=0.58 pd=4.58 ps=4.58 nrd=0.145 nrs=0.145 sa=0 sb=0 sd=0 mult=1 m=1
XMNF_f01_w1 vn_f01_w1 en 0 0 sky130_fd_pr__nfet_01v8 L=0.15 W=2 nf=1 ad=0.58 as=0.58 pd=4.58 ps=4.58 nrd=0.145 nrs=0.145 sa=0 sb=0 sd=0 mult=1 m=1
XMPH_f01_w1 vp_f01_w1 enb vdd vdd sky130_fd_pr__pfet_01v8 L=0.15 W=4 nf=1 ad=1.16 as=1.16 pd=8.58 ps=8.58 nrd=0.0725 nrs=0.0725 sa=0 sb=0 sd=0 mult=1 m=1
bd_f01_w1 d_f01_w1 0 v=v(sbl_f01_w1)-v(sref_f01_w1)
bdabs_f01_w1 dabs_f01_w1 0 v=abs(v(sbl_f01_w1)-v(sref_f01_w1))

* ---- instance 99: f01_w0 (final with MPPRE = MPPREF 4.0) ----
XMWR_f01_w0_0 sn_f01_w0_0 wl wbl_f01_w0 0 sky130_fd_pr__nfet_01v8 L=0.15 W=0.42 nf=1 ad=0.1218 as=0.1218 pd=1.42 ps=1.42 nrd=0.69047619047619 nrs=0.69047619047619 sa=0 sb=0 sd=0 mult=1 m=1
XMRD_f01_w0_0 rbl_f01_w0 sn_f01_w0_0 rwl_sel 0 sky130_fd_pr__nfet_01v8 L=0.15 W=0.42 nf=1 ad=0.1218 as=0.1218 pd=1.42 ps=1.42 nrd=0.69047619047619 nrs=0.69047619047619 sa=0 sb=0 sd=0 mult=1 m=1
csn_f01_w0_0 sn_f01_w0_0 0 {C_SN}
XMWR_f01_w0_1 sn_f01_w0_1 0 wbl_f01_w0 0 sky130_fd_pr__nfet_01v8 L=0.15 W=0.42 nf=1 ad=0.1218 as=0.1218 pd=1.42 ps=1.42 nrd=0.69047619047619 nrs=0.69047619047619 sa=0 sb=0 sd=0 mult=1 m=1
XMRD_f01_w0_1 rbl_f01_w0 sn_f01_w0_1 rwl_des 0 sky130_fd_pr__nfet_01v8 L=0.15 W=0.42 nf=1 ad=0.1218 as=0.1218 pd=1.42 ps=1.42 nrd=0.69047619047619 nrs=0.69047619047619 sa=0 sb=0 sd=0 mult=1 m=1
csn_f01_w0_1 sn_f01_w0_1 0 {C_SN}
XMWR_f01_w0_2 sn_f01_w0_2 0 wbl_f01_w0 0 sky130_fd_pr__nfet_01v8 L=0.15 W=0.42 nf=1 ad=0.1218 as=0.1218 pd=1.42 ps=1.42 nrd=0.69047619047619 nrs=0.69047619047619 sa=0 sb=0 sd=0 mult=1 m=1
XMRD_f01_w0_2 rbl_f01_w0 sn_f01_w0_2 rwl_des 0 sky130_fd_pr__nfet_01v8 L=0.15 W=0.42 nf=1 ad=0.1218 as=0.1218 pd=1.42 ps=1.42 nrd=0.69047619047619 nrs=0.69047619047619 sa=0 sb=0 sd=0 mult=1 m=1
csn_f01_w0_2 sn_f01_w0_2 0 {C_SN}
XMWR_f01_w0_3 sn_f01_w0_3 0 wbl_f01_w0 0 sky130_fd_pr__nfet_01v8 L=0.15 W=0.42 nf=1 ad=0.1218 as=0.1218 pd=1.42 ps=1.42 nrd=0.69047619047619 nrs=0.69047619047619 sa=0 sb=0 sd=0 mult=1 m=1
XMRD_f01_w0_3 rbl_f01_w0 sn_f01_w0_3 rwl_des 0 sky130_fd_pr__nfet_01v8 L=0.15 W=0.42 nf=1 ad=0.1218 as=0.1218 pd=1.42 ps=1.42 nrd=0.69047619047619 nrs=0.69047619047619 sa=0 sb=0 sd=0 mult=1 m=1
csn_f01_w0_3 sn_f01_w0_3 0 {C_SN}
crbl_f01_w0 rbl_f01_w0 0 {C_RBL}
cwbl_f01_w0 wbl_f01_w0 0 {C_WBL}
cref_f01_w0 ref_f01_w0 0 {C_RBL}   $ ASSUMPTION: ideal matched dummy load
XMPPRE_f01_w0 rbl_f01_w0 pcb_100 prea prea sky130_fd_pr__pfet_01v8 L=0.15 W=4 nf=1 ad=1.16 as=1.16 pd=8.58 ps=8.58 nrd=0.0725 nrs=0.0725 sa=0 sb=0 sd=0 mult=1 m=1
XMPU1_f01_w0 x_f01_w0 dinb0 vdd vdd sky130_fd_pr__pfet_01v8 L=0.15 W=1 nf=1 ad=0.29 as=0.29 pd=2.58 ps=2.58 nrd=0.29 nrs=0.29 sa=0 sb=0 sd=0 mult=1 m=1
XMPU2_f01_w0 wbl_f01_w0 wenb x_f01_w0 vdd sky130_fd_pr__pfet_01v8 L=0.15 W=1 nf=1 ad=0.29 as=0.29 pd=2.58 ps=2.58 nrd=0.29 nrs=0.29 sa=0 sb=0 sd=0 mult=1 m=1
XMND2_f01_w0 wbl_f01_w0 wen y_f01_w0 0 sky130_fd_pr__nfet_01v8 L=0.15 W=4 nf=1 ad=1.16 as=1.16 pd=8.58 ps=8.58 nrd=0.0725 nrs=0.0725 sa=0 sb=0 sd=0 mult=1 m=1
XMND1_f01_w0 y_f01_w0 dinb0 0 0 sky130_fd_pr__nfet_01v8 L=0.15 W=4 nf=1 ad=1.16 as=1.16 pd=8.58 ps=8.58 nrd=0.0725 nrs=0.0725 sa=0 sb=0 sd=0 mult=1 m=1
XMNI_f01_w0 wbl_f01_w0 wenb 0 0 sky130_fd_pr__nfet_01v8 L=0.15 W=2 nf=1 ad=0.58 as=0.58 pd=4.58 ps=4.58 nrd=0.145 nrs=0.145 sa=0 sb=0 sd=0 mult=1 m=1
XMNS_f01_w0 sbl_f01_w0 sel_69500 rbl_f01_w0 0 sky130_fd_pr__nfet_01v8 L=0.15 W=0.42 nf=1 ad=0.1218 as=0.1218 pd=1.42 ps=1.42 nrd=0.69047619047619 nrs=0.69047619047619 sa=0 sb=0 sd=0 mult=1 m=1
XMNSR_f01_w0 sref_f01_w0 sel_69500 ref_f01_w0 0 sky130_fd_pr__nfet_01v8 L=0.15 W=0.42 nf=1 ad=0.1218 as=0.1218 pd=1.42 ps=1.42 nrd=0.69047619047619 nrs=0.69047619047619 sa=0 sb=0 sd=0 mult=1 m=1
XMPPREF_f01_w0 ref_f01_w0 pcb_100 pref pref sky130_fd_pr__pfet_01v8 L=0.15 W=4 nf=1 ad=1.16 as=1.16 pd=8.58 ps=8.58 nrd=0.0725 nrs=0.0725 sa=0 sb=0 sd=0 mult=1 m=1   $ reference-side precharge: copy of MPPRE
XMN1_f01_w0 sbl_f01_w0 sref_f01_w0 vn_f01_w0 0 sky130_fd_pr__nfet_01v8 L=0.15 W=1 nf=1 ad=0.29 as=0.29 pd=2.58 ps=2.58 nrd=0.29 nrs=0.29 sa=0 sb=0 sd=0 mult=1 m=1
XMN2_f01_w0 sref_f01_w0 sbl_f01_w0 vn_f01_w0 0 sky130_fd_pr__nfet_01v8 L=0.15 W=1 nf=1 ad=0.29 as=0.29 pd=2.58 ps=2.58 nrd=0.29 nrs=0.29 sa=0 sb=0 sd=0 mult=1 m=1
XMP1_f01_w0 sbl_f01_w0 sref_f01_w0 vp_f01_w0 vdd sky130_fd_pr__pfet_01v8 L=0.15 W=2 nf=1 ad=0.58 as=0.58 pd=4.58 ps=4.58 nrd=0.145 nrs=0.145 sa=0 sb=0 sd=0 mult=1 m=1
XMP2_f01_w0 sref_f01_w0 sbl_f01_w0 vp_f01_w0 vdd sky130_fd_pr__pfet_01v8 L=0.15 W=2 nf=1 ad=0.58 as=0.58 pd=4.58 ps=4.58 nrd=0.145 nrs=0.145 sa=0 sb=0 sd=0 mult=1 m=1
XMNF_f01_w0 vn_f01_w0 en 0 0 sky130_fd_pr__nfet_01v8 L=0.15 W=2 nf=1 ad=0.58 as=0.58 pd=4.58 ps=4.58 nrd=0.145 nrs=0.145 sa=0 sb=0 sd=0 mult=1 m=1
XMPH_f01_w0 vp_f01_w0 enb vdd vdd sky130_fd_pr__pfet_01v8 L=0.15 W=4 nf=1 ad=1.16 as=1.16 pd=8.58 ps=8.58 nrd=0.0725 nrs=0.0725 sa=0 sb=0 sd=0 mult=1 m=1
bd_f01_w0 d_f01_w0 0 v=v(sbl_f01_w0)-v(sref_f01_w0)
bdabs_f01_w0 dabs_f01_w0 0 v=abs(v(sbl_f01_w0)-v(sref_f01_w0))

* ---- instance 100: f02_w1 (final with MPPRE = MPPREF 4.5) ----
XMWR_f02_w1_0 sn_f02_w1_0 wl wbl_f02_w1 0 sky130_fd_pr__nfet_01v8 L=0.15 W=0.42 nf=1 ad=0.1218 as=0.1218 pd=1.42 ps=1.42 nrd=0.69047619047619 nrs=0.69047619047619 sa=0 sb=0 sd=0 mult=1 m=1
XMRD_f02_w1_0 rbl_f02_w1 sn_f02_w1_0 rwl_sel 0 sky130_fd_pr__nfet_01v8 L=0.15 W=0.42 nf=1 ad=0.1218 as=0.1218 pd=1.42 ps=1.42 nrd=0.69047619047619 nrs=0.69047619047619 sa=0 sb=0 sd=0 mult=1 m=1
csn_f02_w1_0 sn_f02_w1_0 0 {C_SN}
XMWR_f02_w1_1 sn_f02_w1_1 0 wbl_f02_w1 0 sky130_fd_pr__nfet_01v8 L=0.15 W=0.42 nf=1 ad=0.1218 as=0.1218 pd=1.42 ps=1.42 nrd=0.69047619047619 nrs=0.69047619047619 sa=0 sb=0 sd=0 mult=1 m=1
XMRD_f02_w1_1 rbl_f02_w1 sn_f02_w1_1 rwl_des 0 sky130_fd_pr__nfet_01v8 L=0.15 W=0.42 nf=1 ad=0.1218 as=0.1218 pd=1.42 ps=1.42 nrd=0.69047619047619 nrs=0.69047619047619 sa=0 sb=0 sd=0 mult=1 m=1
csn_f02_w1_1 sn_f02_w1_1 0 {C_SN}
XMWR_f02_w1_2 sn_f02_w1_2 0 wbl_f02_w1 0 sky130_fd_pr__nfet_01v8 L=0.15 W=0.42 nf=1 ad=0.1218 as=0.1218 pd=1.42 ps=1.42 nrd=0.69047619047619 nrs=0.69047619047619 sa=0 sb=0 sd=0 mult=1 m=1
XMRD_f02_w1_2 rbl_f02_w1 sn_f02_w1_2 rwl_des 0 sky130_fd_pr__nfet_01v8 L=0.15 W=0.42 nf=1 ad=0.1218 as=0.1218 pd=1.42 ps=1.42 nrd=0.69047619047619 nrs=0.69047619047619 sa=0 sb=0 sd=0 mult=1 m=1
csn_f02_w1_2 sn_f02_w1_2 0 {C_SN}
XMWR_f02_w1_3 sn_f02_w1_3 0 wbl_f02_w1 0 sky130_fd_pr__nfet_01v8 L=0.15 W=0.42 nf=1 ad=0.1218 as=0.1218 pd=1.42 ps=1.42 nrd=0.69047619047619 nrs=0.69047619047619 sa=0 sb=0 sd=0 mult=1 m=1
XMRD_f02_w1_3 rbl_f02_w1 sn_f02_w1_3 rwl_des 0 sky130_fd_pr__nfet_01v8 L=0.15 W=0.42 nf=1 ad=0.1218 as=0.1218 pd=1.42 ps=1.42 nrd=0.69047619047619 nrs=0.69047619047619 sa=0 sb=0 sd=0 mult=1 m=1
csn_f02_w1_3 sn_f02_w1_3 0 {C_SN}
crbl_f02_w1 rbl_f02_w1 0 {C_RBL}
cwbl_f02_w1 wbl_f02_w1 0 {C_WBL}
cref_f02_w1 ref_f02_w1 0 {C_RBL}   $ ASSUMPTION: ideal matched dummy load
XMPPRE_f02_w1 rbl_f02_w1 pcb_100 prea prea sky130_fd_pr__pfet_01v8 L=0.15 W=4.5 nf=1 ad=1.305 as=1.305 pd=9.58 ps=9.58 nrd=0.064444444444444 nrs=0.064444444444444 sa=0 sb=0 sd=0 mult=1 m=1
XMPU1_f02_w1 x_f02_w1 dinb1 vdd vdd sky130_fd_pr__pfet_01v8 L=0.15 W=1 nf=1 ad=0.29 as=0.29 pd=2.58 ps=2.58 nrd=0.29 nrs=0.29 sa=0 sb=0 sd=0 mult=1 m=1
XMPU2_f02_w1 wbl_f02_w1 wenb x_f02_w1 vdd sky130_fd_pr__pfet_01v8 L=0.15 W=1 nf=1 ad=0.29 as=0.29 pd=2.58 ps=2.58 nrd=0.29 nrs=0.29 sa=0 sb=0 sd=0 mult=1 m=1
XMND2_f02_w1 wbl_f02_w1 wen y_f02_w1 0 sky130_fd_pr__nfet_01v8 L=0.15 W=4 nf=1 ad=1.16 as=1.16 pd=8.58 ps=8.58 nrd=0.0725 nrs=0.0725 sa=0 sb=0 sd=0 mult=1 m=1
XMND1_f02_w1 y_f02_w1 dinb1 0 0 sky130_fd_pr__nfet_01v8 L=0.15 W=4 nf=1 ad=1.16 as=1.16 pd=8.58 ps=8.58 nrd=0.0725 nrs=0.0725 sa=0 sb=0 sd=0 mult=1 m=1
XMNI_f02_w1 wbl_f02_w1 wenb 0 0 sky130_fd_pr__nfet_01v8 L=0.15 W=2 nf=1 ad=0.58 as=0.58 pd=4.58 ps=4.58 nrd=0.145 nrs=0.145 sa=0 sb=0 sd=0 mult=1 m=1
XMNS_f02_w1 sbl_f02_w1 sel_69500 rbl_f02_w1 0 sky130_fd_pr__nfet_01v8 L=0.15 W=0.42 nf=1 ad=0.1218 as=0.1218 pd=1.42 ps=1.42 nrd=0.69047619047619 nrs=0.69047619047619 sa=0 sb=0 sd=0 mult=1 m=1
XMNSR_f02_w1 sref_f02_w1 sel_69500 ref_f02_w1 0 sky130_fd_pr__nfet_01v8 L=0.15 W=0.42 nf=1 ad=0.1218 as=0.1218 pd=1.42 ps=1.42 nrd=0.69047619047619 nrs=0.69047619047619 sa=0 sb=0 sd=0 mult=1 m=1
XMPPREF_f02_w1 ref_f02_w1 pcb_100 pref pref sky130_fd_pr__pfet_01v8 L=0.15 W=4.5 nf=1 ad=1.305 as=1.305 pd=9.58 ps=9.58 nrd=0.064444444444444 nrs=0.064444444444444 sa=0 sb=0 sd=0 mult=1 m=1   $ reference-side precharge: copy of MPPRE
XMN1_f02_w1 sbl_f02_w1 sref_f02_w1 vn_f02_w1 0 sky130_fd_pr__nfet_01v8 L=0.15 W=1 nf=1 ad=0.29 as=0.29 pd=2.58 ps=2.58 nrd=0.29 nrs=0.29 sa=0 sb=0 sd=0 mult=1 m=1
XMN2_f02_w1 sref_f02_w1 sbl_f02_w1 vn_f02_w1 0 sky130_fd_pr__nfet_01v8 L=0.15 W=1 nf=1 ad=0.29 as=0.29 pd=2.58 ps=2.58 nrd=0.29 nrs=0.29 sa=0 sb=0 sd=0 mult=1 m=1
XMP1_f02_w1 sbl_f02_w1 sref_f02_w1 vp_f02_w1 vdd sky130_fd_pr__pfet_01v8 L=0.15 W=2 nf=1 ad=0.58 as=0.58 pd=4.58 ps=4.58 nrd=0.145 nrs=0.145 sa=0 sb=0 sd=0 mult=1 m=1
XMP2_f02_w1 sref_f02_w1 sbl_f02_w1 vp_f02_w1 vdd sky130_fd_pr__pfet_01v8 L=0.15 W=2 nf=1 ad=0.58 as=0.58 pd=4.58 ps=4.58 nrd=0.145 nrs=0.145 sa=0 sb=0 sd=0 mult=1 m=1
XMNF_f02_w1 vn_f02_w1 en 0 0 sky130_fd_pr__nfet_01v8 L=0.15 W=2 nf=1 ad=0.58 as=0.58 pd=4.58 ps=4.58 nrd=0.145 nrs=0.145 sa=0 sb=0 sd=0 mult=1 m=1
XMPH_f02_w1 vp_f02_w1 enb vdd vdd sky130_fd_pr__pfet_01v8 L=0.15 W=4 nf=1 ad=1.16 as=1.16 pd=8.58 ps=8.58 nrd=0.0725 nrs=0.0725 sa=0 sb=0 sd=0 mult=1 m=1
bd_f02_w1 d_f02_w1 0 v=v(sbl_f02_w1)-v(sref_f02_w1)
bdabs_f02_w1 dabs_f02_w1 0 v=abs(v(sbl_f02_w1)-v(sref_f02_w1))

* ---- instance 101: f02_w0 (final with MPPRE = MPPREF 4.5) ----
XMWR_f02_w0_0 sn_f02_w0_0 wl wbl_f02_w0 0 sky130_fd_pr__nfet_01v8 L=0.15 W=0.42 nf=1 ad=0.1218 as=0.1218 pd=1.42 ps=1.42 nrd=0.69047619047619 nrs=0.69047619047619 sa=0 sb=0 sd=0 mult=1 m=1
XMRD_f02_w0_0 rbl_f02_w0 sn_f02_w0_0 rwl_sel 0 sky130_fd_pr__nfet_01v8 L=0.15 W=0.42 nf=1 ad=0.1218 as=0.1218 pd=1.42 ps=1.42 nrd=0.69047619047619 nrs=0.69047619047619 sa=0 sb=0 sd=0 mult=1 m=1
csn_f02_w0_0 sn_f02_w0_0 0 {C_SN}
XMWR_f02_w0_1 sn_f02_w0_1 0 wbl_f02_w0 0 sky130_fd_pr__nfet_01v8 L=0.15 W=0.42 nf=1 ad=0.1218 as=0.1218 pd=1.42 ps=1.42 nrd=0.69047619047619 nrs=0.69047619047619 sa=0 sb=0 sd=0 mult=1 m=1
XMRD_f02_w0_1 rbl_f02_w0 sn_f02_w0_1 rwl_des 0 sky130_fd_pr__nfet_01v8 L=0.15 W=0.42 nf=1 ad=0.1218 as=0.1218 pd=1.42 ps=1.42 nrd=0.69047619047619 nrs=0.69047619047619 sa=0 sb=0 sd=0 mult=1 m=1
csn_f02_w0_1 sn_f02_w0_1 0 {C_SN}
XMWR_f02_w0_2 sn_f02_w0_2 0 wbl_f02_w0 0 sky130_fd_pr__nfet_01v8 L=0.15 W=0.42 nf=1 ad=0.1218 as=0.1218 pd=1.42 ps=1.42 nrd=0.69047619047619 nrs=0.69047619047619 sa=0 sb=0 sd=0 mult=1 m=1
XMRD_f02_w0_2 rbl_f02_w0 sn_f02_w0_2 rwl_des 0 sky130_fd_pr__nfet_01v8 L=0.15 W=0.42 nf=1 ad=0.1218 as=0.1218 pd=1.42 ps=1.42 nrd=0.69047619047619 nrs=0.69047619047619 sa=0 sb=0 sd=0 mult=1 m=1
csn_f02_w0_2 sn_f02_w0_2 0 {C_SN}
XMWR_f02_w0_3 sn_f02_w0_3 0 wbl_f02_w0 0 sky130_fd_pr__nfet_01v8 L=0.15 W=0.42 nf=1 ad=0.1218 as=0.1218 pd=1.42 ps=1.42 nrd=0.69047619047619 nrs=0.69047619047619 sa=0 sb=0 sd=0 mult=1 m=1
XMRD_f02_w0_3 rbl_f02_w0 sn_f02_w0_3 rwl_des 0 sky130_fd_pr__nfet_01v8 L=0.15 W=0.42 nf=1 ad=0.1218 as=0.1218 pd=1.42 ps=1.42 nrd=0.69047619047619 nrs=0.69047619047619 sa=0 sb=0 sd=0 mult=1 m=1
csn_f02_w0_3 sn_f02_w0_3 0 {C_SN}
crbl_f02_w0 rbl_f02_w0 0 {C_RBL}
cwbl_f02_w0 wbl_f02_w0 0 {C_WBL}
cref_f02_w0 ref_f02_w0 0 {C_RBL}   $ ASSUMPTION: ideal matched dummy load
XMPPRE_f02_w0 rbl_f02_w0 pcb_100 prea prea sky130_fd_pr__pfet_01v8 L=0.15 W=4.5 nf=1 ad=1.305 as=1.305 pd=9.58 ps=9.58 nrd=0.064444444444444 nrs=0.064444444444444 sa=0 sb=0 sd=0 mult=1 m=1
XMPU1_f02_w0 x_f02_w0 dinb0 vdd vdd sky130_fd_pr__pfet_01v8 L=0.15 W=1 nf=1 ad=0.29 as=0.29 pd=2.58 ps=2.58 nrd=0.29 nrs=0.29 sa=0 sb=0 sd=0 mult=1 m=1
XMPU2_f02_w0 wbl_f02_w0 wenb x_f02_w0 vdd sky130_fd_pr__pfet_01v8 L=0.15 W=1 nf=1 ad=0.29 as=0.29 pd=2.58 ps=2.58 nrd=0.29 nrs=0.29 sa=0 sb=0 sd=0 mult=1 m=1
XMND2_f02_w0 wbl_f02_w0 wen y_f02_w0 0 sky130_fd_pr__nfet_01v8 L=0.15 W=4 nf=1 ad=1.16 as=1.16 pd=8.58 ps=8.58 nrd=0.0725 nrs=0.0725 sa=0 sb=0 sd=0 mult=1 m=1
XMND1_f02_w0 y_f02_w0 dinb0 0 0 sky130_fd_pr__nfet_01v8 L=0.15 W=4 nf=1 ad=1.16 as=1.16 pd=8.58 ps=8.58 nrd=0.0725 nrs=0.0725 sa=0 sb=0 sd=0 mult=1 m=1
XMNI_f02_w0 wbl_f02_w0 wenb 0 0 sky130_fd_pr__nfet_01v8 L=0.15 W=2 nf=1 ad=0.58 as=0.58 pd=4.58 ps=4.58 nrd=0.145 nrs=0.145 sa=0 sb=0 sd=0 mult=1 m=1
XMNS_f02_w0 sbl_f02_w0 sel_69500 rbl_f02_w0 0 sky130_fd_pr__nfet_01v8 L=0.15 W=0.42 nf=1 ad=0.1218 as=0.1218 pd=1.42 ps=1.42 nrd=0.69047619047619 nrs=0.69047619047619 sa=0 sb=0 sd=0 mult=1 m=1
XMNSR_f02_w0 sref_f02_w0 sel_69500 ref_f02_w0 0 sky130_fd_pr__nfet_01v8 L=0.15 W=0.42 nf=1 ad=0.1218 as=0.1218 pd=1.42 ps=1.42 nrd=0.69047619047619 nrs=0.69047619047619 sa=0 sb=0 sd=0 mult=1 m=1
XMPPREF_f02_w0 ref_f02_w0 pcb_100 pref pref sky130_fd_pr__pfet_01v8 L=0.15 W=4.5 nf=1 ad=1.305 as=1.305 pd=9.58 ps=9.58 nrd=0.064444444444444 nrs=0.064444444444444 sa=0 sb=0 sd=0 mult=1 m=1   $ reference-side precharge: copy of MPPRE
XMN1_f02_w0 sbl_f02_w0 sref_f02_w0 vn_f02_w0 0 sky130_fd_pr__nfet_01v8 L=0.15 W=1 nf=1 ad=0.29 as=0.29 pd=2.58 ps=2.58 nrd=0.29 nrs=0.29 sa=0 sb=0 sd=0 mult=1 m=1
XMN2_f02_w0 sref_f02_w0 sbl_f02_w0 vn_f02_w0 0 sky130_fd_pr__nfet_01v8 L=0.15 W=1 nf=1 ad=0.29 as=0.29 pd=2.58 ps=2.58 nrd=0.29 nrs=0.29 sa=0 sb=0 sd=0 mult=1 m=1
XMP1_f02_w0 sbl_f02_w0 sref_f02_w0 vp_f02_w0 vdd sky130_fd_pr__pfet_01v8 L=0.15 W=2 nf=1 ad=0.58 as=0.58 pd=4.58 ps=4.58 nrd=0.145 nrs=0.145 sa=0 sb=0 sd=0 mult=1 m=1
XMP2_f02_w0 sref_f02_w0 sbl_f02_w0 vp_f02_w0 vdd sky130_fd_pr__pfet_01v8 L=0.15 W=2 nf=1 ad=0.58 as=0.58 pd=4.58 ps=4.58 nrd=0.145 nrs=0.145 sa=0 sb=0 sd=0 mult=1 m=1
XMNF_f02_w0 vn_f02_w0 en 0 0 sky130_fd_pr__nfet_01v8 L=0.15 W=2 nf=1 ad=0.58 as=0.58 pd=4.58 ps=4.58 nrd=0.145 nrs=0.145 sa=0 sb=0 sd=0 mult=1 m=1
XMPH_f02_w0 vp_f02_w0 enb vdd vdd sky130_fd_pr__pfet_01v8 L=0.15 W=4 nf=1 ad=1.16 as=1.16 pd=8.58 ps=8.58 nrd=0.0725 nrs=0.0725 sa=0 sb=0 sd=0 mult=1 m=1
bd_f02_w0 d_f02_w0 0 v=v(sbl_f02_w0)-v(sref_f02_w0)
bdabs_f02_w0 dabs_f02_w0 0 v=abs(v(sbl_f02_w0)-v(sref_f02_w0))

* ---- instance 102: f03_w1 (final with MPPRE = MPPREF 6.0) ----
XMWR_f03_w1_0 sn_f03_w1_0 wl wbl_f03_w1 0 sky130_fd_pr__nfet_01v8 L=0.15 W=0.42 nf=1 ad=0.1218 as=0.1218 pd=1.42 ps=1.42 nrd=0.69047619047619 nrs=0.69047619047619 sa=0 sb=0 sd=0 mult=1 m=1
XMRD_f03_w1_0 rbl_f03_w1 sn_f03_w1_0 rwl_sel 0 sky130_fd_pr__nfet_01v8 L=0.15 W=0.42 nf=1 ad=0.1218 as=0.1218 pd=1.42 ps=1.42 nrd=0.69047619047619 nrs=0.69047619047619 sa=0 sb=0 sd=0 mult=1 m=1
csn_f03_w1_0 sn_f03_w1_0 0 {C_SN}
XMWR_f03_w1_1 sn_f03_w1_1 0 wbl_f03_w1 0 sky130_fd_pr__nfet_01v8 L=0.15 W=0.42 nf=1 ad=0.1218 as=0.1218 pd=1.42 ps=1.42 nrd=0.69047619047619 nrs=0.69047619047619 sa=0 sb=0 sd=0 mult=1 m=1
XMRD_f03_w1_1 rbl_f03_w1 sn_f03_w1_1 rwl_des 0 sky130_fd_pr__nfet_01v8 L=0.15 W=0.42 nf=1 ad=0.1218 as=0.1218 pd=1.42 ps=1.42 nrd=0.69047619047619 nrs=0.69047619047619 sa=0 sb=0 sd=0 mult=1 m=1
csn_f03_w1_1 sn_f03_w1_1 0 {C_SN}
XMWR_f03_w1_2 sn_f03_w1_2 0 wbl_f03_w1 0 sky130_fd_pr__nfet_01v8 L=0.15 W=0.42 nf=1 ad=0.1218 as=0.1218 pd=1.42 ps=1.42 nrd=0.69047619047619 nrs=0.69047619047619 sa=0 sb=0 sd=0 mult=1 m=1
XMRD_f03_w1_2 rbl_f03_w1 sn_f03_w1_2 rwl_des 0 sky130_fd_pr__nfet_01v8 L=0.15 W=0.42 nf=1 ad=0.1218 as=0.1218 pd=1.42 ps=1.42 nrd=0.69047619047619 nrs=0.69047619047619 sa=0 sb=0 sd=0 mult=1 m=1
csn_f03_w1_2 sn_f03_w1_2 0 {C_SN}
XMWR_f03_w1_3 sn_f03_w1_3 0 wbl_f03_w1 0 sky130_fd_pr__nfet_01v8 L=0.15 W=0.42 nf=1 ad=0.1218 as=0.1218 pd=1.42 ps=1.42 nrd=0.69047619047619 nrs=0.69047619047619 sa=0 sb=0 sd=0 mult=1 m=1
XMRD_f03_w1_3 rbl_f03_w1 sn_f03_w1_3 rwl_des 0 sky130_fd_pr__nfet_01v8 L=0.15 W=0.42 nf=1 ad=0.1218 as=0.1218 pd=1.42 ps=1.42 nrd=0.69047619047619 nrs=0.69047619047619 sa=0 sb=0 sd=0 mult=1 m=1
csn_f03_w1_3 sn_f03_w1_3 0 {C_SN}
crbl_f03_w1 rbl_f03_w1 0 {C_RBL}
cwbl_f03_w1 wbl_f03_w1 0 {C_WBL}
cref_f03_w1 ref_f03_w1 0 {C_RBL}   $ ASSUMPTION: ideal matched dummy load
XMPPRE_f03_w1 rbl_f03_w1 pcb_100 prea prea sky130_fd_pr__pfet_01v8 L=0.15 W=6 nf=1 ad=1.74 as=1.74 pd=12.58 ps=12.58 nrd=0.048333333333333 nrs=0.048333333333333 sa=0 sb=0 sd=0 mult=1 m=1
XMPU1_f03_w1 x_f03_w1 dinb1 vdd vdd sky130_fd_pr__pfet_01v8 L=0.15 W=1 nf=1 ad=0.29 as=0.29 pd=2.58 ps=2.58 nrd=0.29 nrs=0.29 sa=0 sb=0 sd=0 mult=1 m=1
XMPU2_f03_w1 wbl_f03_w1 wenb x_f03_w1 vdd sky130_fd_pr__pfet_01v8 L=0.15 W=1 nf=1 ad=0.29 as=0.29 pd=2.58 ps=2.58 nrd=0.29 nrs=0.29 sa=0 sb=0 sd=0 mult=1 m=1
XMND2_f03_w1 wbl_f03_w1 wen y_f03_w1 0 sky130_fd_pr__nfet_01v8 L=0.15 W=4 nf=1 ad=1.16 as=1.16 pd=8.58 ps=8.58 nrd=0.0725 nrs=0.0725 sa=0 sb=0 sd=0 mult=1 m=1
XMND1_f03_w1 y_f03_w1 dinb1 0 0 sky130_fd_pr__nfet_01v8 L=0.15 W=4 nf=1 ad=1.16 as=1.16 pd=8.58 ps=8.58 nrd=0.0725 nrs=0.0725 sa=0 sb=0 sd=0 mult=1 m=1
XMNI_f03_w1 wbl_f03_w1 wenb 0 0 sky130_fd_pr__nfet_01v8 L=0.15 W=2 nf=1 ad=0.58 as=0.58 pd=4.58 ps=4.58 nrd=0.145 nrs=0.145 sa=0 sb=0 sd=0 mult=1 m=1
XMNS_f03_w1 sbl_f03_w1 sel_69500 rbl_f03_w1 0 sky130_fd_pr__nfet_01v8 L=0.15 W=0.42 nf=1 ad=0.1218 as=0.1218 pd=1.42 ps=1.42 nrd=0.69047619047619 nrs=0.69047619047619 sa=0 sb=0 sd=0 mult=1 m=1
XMNSR_f03_w1 sref_f03_w1 sel_69500 ref_f03_w1 0 sky130_fd_pr__nfet_01v8 L=0.15 W=0.42 nf=1 ad=0.1218 as=0.1218 pd=1.42 ps=1.42 nrd=0.69047619047619 nrs=0.69047619047619 sa=0 sb=0 sd=0 mult=1 m=1
XMPPREF_f03_w1 ref_f03_w1 pcb_100 pref pref sky130_fd_pr__pfet_01v8 L=0.15 W=6 nf=1 ad=1.74 as=1.74 pd=12.58 ps=12.58 nrd=0.048333333333333 nrs=0.048333333333333 sa=0 sb=0 sd=0 mult=1 m=1   $ reference-side precharge: copy of MPPRE
XMN1_f03_w1 sbl_f03_w1 sref_f03_w1 vn_f03_w1 0 sky130_fd_pr__nfet_01v8 L=0.15 W=1 nf=1 ad=0.29 as=0.29 pd=2.58 ps=2.58 nrd=0.29 nrs=0.29 sa=0 sb=0 sd=0 mult=1 m=1
XMN2_f03_w1 sref_f03_w1 sbl_f03_w1 vn_f03_w1 0 sky130_fd_pr__nfet_01v8 L=0.15 W=1 nf=1 ad=0.29 as=0.29 pd=2.58 ps=2.58 nrd=0.29 nrs=0.29 sa=0 sb=0 sd=0 mult=1 m=1
XMP1_f03_w1 sbl_f03_w1 sref_f03_w1 vp_f03_w1 vdd sky130_fd_pr__pfet_01v8 L=0.15 W=2 nf=1 ad=0.58 as=0.58 pd=4.58 ps=4.58 nrd=0.145 nrs=0.145 sa=0 sb=0 sd=0 mult=1 m=1
XMP2_f03_w1 sref_f03_w1 sbl_f03_w1 vp_f03_w1 vdd sky130_fd_pr__pfet_01v8 L=0.15 W=2 nf=1 ad=0.58 as=0.58 pd=4.58 ps=4.58 nrd=0.145 nrs=0.145 sa=0 sb=0 sd=0 mult=1 m=1
XMNF_f03_w1 vn_f03_w1 en 0 0 sky130_fd_pr__nfet_01v8 L=0.15 W=2 nf=1 ad=0.58 as=0.58 pd=4.58 ps=4.58 nrd=0.145 nrs=0.145 sa=0 sb=0 sd=0 mult=1 m=1
XMPH_f03_w1 vp_f03_w1 enb vdd vdd sky130_fd_pr__pfet_01v8 L=0.15 W=4 nf=1 ad=1.16 as=1.16 pd=8.58 ps=8.58 nrd=0.0725 nrs=0.0725 sa=0 sb=0 sd=0 mult=1 m=1
bd_f03_w1 d_f03_w1 0 v=v(sbl_f03_w1)-v(sref_f03_w1)
bdabs_f03_w1 dabs_f03_w1 0 v=abs(v(sbl_f03_w1)-v(sref_f03_w1))

* ---- instance 103: f03_w0 (final with MPPRE = MPPREF 6.0) ----
XMWR_f03_w0_0 sn_f03_w0_0 wl wbl_f03_w0 0 sky130_fd_pr__nfet_01v8 L=0.15 W=0.42 nf=1 ad=0.1218 as=0.1218 pd=1.42 ps=1.42 nrd=0.69047619047619 nrs=0.69047619047619 sa=0 sb=0 sd=0 mult=1 m=1
XMRD_f03_w0_0 rbl_f03_w0 sn_f03_w0_0 rwl_sel 0 sky130_fd_pr__nfet_01v8 L=0.15 W=0.42 nf=1 ad=0.1218 as=0.1218 pd=1.42 ps=1.42 nrd=0.69047619047619 nrs=0.69047619047619 sa=0 sb=0 sd=0 mult=1 m=1
csn_f03_w0_0 sn_f03_w0_0 0 {C_SN}
XMWR_f03_w0_1 sn_f03_w0_1 0 wbl_f03_w0 0 sky130_fd_pr__nfet_01v8 L=0.15 W=0.42 nf=1 ad=0.1218 as=0.1218 pd=1.42 ps=1.42 nrd=0.69047619047619 nrs=0.69047619047619 sa=0 sb=0 sd=0 mult=1 m=1
XMRD_f03_w0_1 rbl_f03_w0 sn_f03_w0_1 rwl_des 0 sky130_fd_pr__nfet_01v8 L=0.15 W=0.42 nf=1 ad=0.1218 as=0.1218 pd=1.42 ps=1.42 nrd=0.69047619047619 nrs=0.69047619047619 sa=0 sb=0 sd=0 mult=1 m=1
csn_f03_w0_1 sn_f03_w0_1 0 {C_SN}
XMWR_f03_w0_2 sn_f03_w0_2 0 wbl_f03_w0 0 sky130_fd_pr__nfet_01v8 L=0.15 W=0.42 nf=1 ad=0.1218 as=0.1218 pd=1.42 ps=1.42 nrd=0.69047619047619 nrs=0.69047619047619 sa=0 sb=0 sd=0 mult=1 m=1
XMRD_f03_w0_2 rbl_f03_w0 sn_f03_w0_2 rwl_des 0 sky130_fd_pr__nfet_01v8 L=0.15 W=0.42 nf=1 ad=0.1218 as=0.1218 pd=1.42 ps=1.42 nrd=0.69047619047619 nrs=0.69047619047619 sa=0 sb=0 sd=0 mult=1 m=1
csn_f03_w0_2 sn_f03_w0_2 0 {C_SN}
XMWR_f03_w0_3 sn_f03_w0_3 0 wbl_f03_w0 0 sky130_fd_pr__nfet_01v8 L=0.15 W=0.42 nf=1 ad=0.1218 as=0.1218 pd=1.42 ps=1.42 nrd=0.69047619047619 nrs=0.69047619047619 sa=0 sb=0 sd=0 mult=1 m=1
XMRD_f03_w0_3 rbl_f03_w0 sn_f03_w0_3 rwl_des 0 sky130_fd_pr__nfet_01v8 L=0.15 W=0.42 nf=1 ad=0.1218 as=0.1218 pd=1.42 ps=1.42 nrd=0.69047619047619 nrs=0.69047619047619 sa=0 sb=0 sd=0 mult=1 m=1
csn_f03_w0_3 sn_f03_w0_3 0 {C_SN}
crbl_f03_w0 rbl_f03_w0 0 {C_RBL}
cwbl_f03_w0 wbl_f03_w0 0 {C_WBL}
cref_f03_w0 ref_f03_w0 0 {C_RBL}   $ ASSUMPTION: ideal matched dummy load
XMPPRE_f03_w0 rbl_f03_w0 pcb_100 prea prea sky130_fd_pr__pfet_01v8 L=0.15 W=6 nf=1 ad=1.74 as=1.74 pd=12.58 ps=12.58 nrd=0.048333333333333 nrs=0.048333333333333 sa=0 sb=0 sd=0 mult=1 m=1
XMPU1_f03_w0 x_f03_w0 dinb0 vdd vdd sky130_fd_pr__pfet_01v8 L=0.15 W=1 nf=1 ad=0.29 as=0.29 pd=2.58 ps=2.58 nrd=0.29 nrs=0.29 sa=0 sb=0 sd=0 mult=1 m=1
XMPU2_f03_w0 wbl_f03_w0 wenb x_f03_w0 vdd sky130_fd_pr__pfet_01v8 L=0.15 W=1 nf=1 ad=0.29 as=0.29 pd=2.58 ps=2.58 nrd=0.29 nrs=0.29 sa=0 sb=0 sd=0 mult=1 m=1
XMND2_f03_w0 wbl_f03_w0 wen y_f03_w0 0 sky130_fd_pr__nfet_01v8 L=0.15 W=4 nf=1 ad=1.16 as=1.16 pd=8.58 ps=8.58 nrd=0.0725 nrs=0.0725 sa=0 sb=0 sd=0 mult=1 m=1
XMND1_f03_w0 y_f03_w0 dinb0 0 0 sky130_fd_pr__nfet_01v8 L=0.15 W=4 nf=1 ad=1.16 as=1.16 pd=8.58 ps=8.58 nrd=0.0725 nrs=0.0725 sa=0 sb=0 sd=0 mult=1 m=1
XMNI_f03_w0 wbl_f03_w0 wenb 0 0 sky130_fd_pr__nfet_01v8 L=0.15 W=2 nf=1 ad=0.58 as=0.58 pd=4.58 ps=4.58 nrd=0.145 nrs=0.145 sa=0 sb=0 sd=0 mult=1 m=1
XMNS_f03_w0 sbl_f03_w0 sel_69500 rbl_f03_w0 0 sky130_fd_pr__nfet_01v8 L=0.15 W=0.42 nf=1 ad=0.1218 as=0.1218 pd=1.42 ps=1.42 nrd=0.69047619047619 nrs=0.69047619047619 sa=0 sb=0 sd=0 mult=1 m=1
XMNSR_f03_w0 sref_f03_w0 sel_69500 ref_f03_w0 0 sky130_fd_pr__nfet_01v8 L=0.15 W=0.42 nf=1 ad=0.1218 as=0.1218 pd=1.42 ps=1.42 nrd=0.69047619047619 nrs=0.69047619047619 sa=0 sb=0 sd=0 mult=1 m=1
XMPPREF_f03_w0 ref_f03_w0 pcb_100 pref pref sky130_fd_pr__pfet_01v8 L=0.15 W=6 nf=1 ad=1.74 as=1.74 pd=12.58 ps=12.58 nrd=0.048333333333333 nrs=0.048333333333333 sa=0 sb=0 sd=0 mult=1 m=1   $ reference-side precharge: copy of MPPRE
XMN1_f03_w0 sbl_f03_w0 sref_f03_w0 vn_f03_w0 0 sky130_fd_pr__nfet_01v8 L=0.15 W=1 nf=1 ad=0.29 as=0.29 pd=2.58 ps=2.58 nrd=0.29 nrs=0.29 sa=0 sb=0 sd=0 mult=1 m=1
XMN2_f03_w0 sref_f03_w0 sbl_f03_w0 vn_f03_w0 0 sky130_fd_pr__nfet_01v8 L=0.15 W=1 nf=1 ad=0.29 as=0.29 pd=2.58 ps=2.58 nrd=0.29 nrs=0.29 sa=0 sb=0 sd=0 mult=1 m=1
XMP1_f03_w0 sbl_f03_w0 sref_f03_w0 vp_f03_w0 vdd sky130_fd_pr__pfet_01v8 L=0.15 W=2 nf=1 ad=0.58 as=0.58 pd=4.58 ps=4.58 nrd=0.145 nrs=0.145 sa=0 sb=0 sd=0 mult=1 m=1
XMP2_f03_w0 sref_f03_w0 sbl_f03_w0 vp_f03_w0 vdd sky130_fd_pr__pfet_01v8 L=0.15 W=2 nf=1 ad=0.58 as=0.58 pd=4.58 ps=4.58 nrd=0.145 nrs=0.145 sa=0 sb=0 sd=0 mult=1 m=1
XMNF_f03_w0 vn_f03_w0 en 0 0 sky130_fd_pr__nfet_01v8 L=0.15 W=2 nf=1 ad=0.58 as=0.58 pd=4.58 ps=4.58 nrd=0.145 nrs=0.145 sa=0 sb=0 sd=0 mult=1 m=1
XMPH_f03_w0 vp_f03_w0 enb vdd vdd sky130_fd_pr__pfet_01v8 L=0.15 W=4 nf=1 ad=1.16 as=1.16 pd=8.58 ps=8.58 nrd=0.0725 nrs=0.0725 sa=0 sb=0 sd=0 mult=1 m=1
bd_f03_w0 d_f03_w0 0 v=v(sbl_f03_w0)-v(sref_f03_w0)
bdabs_f03_w0 dabs_f03_w0 0 v=abs(v(sbl_f03_w0)-v(sref_f03_w0))

* ---- instance 104: f04_w1 (final with array-side rbl C = 6.26 fF (total 10 fF incl. the 3.74 fF fs/27 C periphery probe value; the 'C_RBL is the total' reading)) ----
XMWR_f04_w1_0 sn_f04_w1_0 wl wbl_f04_w1 0 sky130_fd_pr__nfet_01v8 L=0.15 W=0.42 nf=1 ad=0.1218 as=0.1218 pd=1.42 ps=1.42 nrd=0.69047619047619 nrs=0.69047619047619 sa=0 sb=0 sd=0 mult=1 m=1
XMRD_f04_w1_0 rbl_f04_w1 sn_f04_w1_0 rwl_sel 0 sky130_fd_pr__nfet_01v8 L=0.15 W=0.42 nf=1 ad=0.1218 as=0.1218 pd=1.42 ps=1.42 nrd=0.69047619047619 nrs=0.69047619047619 sa=0 sb=0 sd=0 mult=1 m=1
csn_f04_w1_0 sn_f04_w1_0 0 {C_SN}
XMWR_f04_w1_1 sn_f04_w1_1 0 wbl_f04_w1 0 sky130_fd_pr__nfet_01v8 L=0.15 W=0.42 nf=1 ad=0.1218 as=0.1218 pd=1.42 ps=1.42 nrd=0.69047619047619 nrs=0.69047619047619 sa=0 sb=0 sd=0 mult=1 m=1
XMRD_f04_w1_1 rbl_f04_w1 sn_f04_w1_1 rwl_des 0 sky130_fd_pr__nfet_01v8 L=0.15 W=0.42 nf=1 ad=0.1218 as=0.1218 pd=1.42 ps=1.42 nrd=0.69047619047619 nrs=0.69047619047619 sa=0 sb=0 sd=0 mult=1 m=1
csn_f04_w1_1 sn_f04_w1_1 0 {C_SN}
XMWR_f04_w1_2 sn_f04_w1_2 0 wbl_f04_w1 0 sky130_fd_pr__nfet_01v8 L=0.15 W=0.42 nf=1 ad=0.1218 as=0.1218 pd=1.42 ps=1.42 nrd=0.69047619047619 nrs=0.69047619047619 sa=0 sb=0 sd=0 mult=1 m=1
XMRD_f04_w1_2 rbl_f04_w1 sn_f04_w1_2 rwl_des 0 sky130_fd_pr__nfet_01v8 L=0.15 W=0.42 nf=1 ad=0.1218 as=0.1218 pd=1.42 ps=1.42 nrd=0.69047619047619 nrs=0.69047619047619 sa=0 sb=0 sd=0 mult=1 m=1
csn_f04_w1_2 sn_f04_w1_2 0 {C_SN}
XMWR_f04_w1_3 sn_f04_w1_3 0 wbl_f04_w1 0 sky130_fd_pr__nfet_01v8 L=0.15 W=0.42 nf=1 ad=0.1218 as=0.1218 pd=1.42 ps=1.42 nrd=0.69047619047619 nrs=0.69047619047619 sa=0 sb=0 sd=0 mult=1 m=1
XMRD_f04_w1_3 rbl_f04_w1 sn_f04_w1_3 rwl_des 0 sky130_fd_pr__nfet_01v8 L=0.15 W=0.42 nf=1 ad=0.1218 as=0.1218 pd=1.42 ps=1.42 nrd=0.69047619047619 nrs=0.69047619047619 sa=0 sb=0 sd=0 mult=1 m=1
csn_f04_w1_3 sn_f04_w1_3 0 {C_SN}
crbl_f04_w1 rbl_f04_w1 0 6.26e-15
cwbl_f04_w1 wbl_f04_w1 0 {C_WBL}
cref_f04_w1 ref_f04_w1 0 {C_RBL}   $ ASSUMPTION: ideal matched dummy load
XMPPRE_f04_w1 rbl_f04_w1 pcb_100 prea prea sky130_fd_pr__pfet_01v8 L=0.15 W=5 nf=1 ad=1.45 as=1.45 pd=10.58 ps=10.58 nrd=0.058 nrs=0.058 sa=0 sb=0 sd=0 mult=1 m=1
XMPU1_f04_w1 x_f04_w1 dinb1 vdd vdd sky130_fd_pr__pfet_01v8 L=0.15 W=1 nf=1 ad=0.29 as=0.29 pd=2.58 ps=2.58 nrd=0.29 nrs=0.29 sa=0 sb=0 sd=0 mult=1 m=1
XMPU2_f04_w1 wbl_f04_w1 wenb x_f04_w1 vdd sky130_fd_pr__pfet_01v8 L=0.15 W=1 nf=1 ad=0.29 as=0.29 pd=2.58 ps=2.58 nrd=0.29 nrs=0.29 sa=0 sb=0 sd=0 mult=1 m=1
XMND2_f04_w1 wbl_f04_w1 wen y_f04_w1 0 sky130_fd_pr__nfet_01v8 L=0.15 W=4 nf=1 ad=1.16 as=1.16 pd=8.58 ps=8.58 nrd=0.0725 nrs=0.0725 sa=0 sb=0 sd=0 mult=1 m=1
XMND1_f04_w1 y_f04_w1 dinb1 0 0 sky130_fd_pr__nfet_01v8 L=0.15 W=4 nf=1 ad=1.16 as=1.16 pd=8.58 ps=8.58 nrd=0.0725 nrs=0.0725 sa=0 sb=0 sd=0 mult=1 m=1
XMNI_f04_w1 wbl_f04_w1 wenb 0 0 sky130_fd_pr__nfet_01v8 L=0.15 W=2 nf=1 ad=0.58 as=0.58 pd=4.58 ps=4.58 nrd=0.145 nrs=0.145 sa=0 sb=0 sd=0 mult=1 m=1
XMNS_f04_w1 sbl_f04_w1 sel_69500 rbl_f04_w1 0 sky130_fd_pr__nfet_01v8 L=0.15 W=0.42 nf=1 ad=0.1218 as=0.1218 pd=1.42 ps=1.42 nrd=0.69047619047619 nrs=0.69047619047619 sa=0 sb=0 sd=0 mult=1 m=1
XMNSR_f04_w1 sref_f04_w1 sel_69500 ref_f04_w1 0 sky130_fd_pr__nfet_01v8 L=0.15 W=0.42 nf=1 ad=0.1218 as=0.1218 pd=1.42 ps=1.42 nrd=0.69047619047619 nrs=0.69047619047619 sa=0 sb=0 sd=0 mult=1 m=1
XMPPREF_f04_w1 ref_f04_w1 pcb_100 pref pref sky130_fd_pr__pfet_01v8 L=0.15 W=5 nf=1 ad=1.45 as=1.45 pd=10.58 ps=10.58 nrd=0.058 nrs=0.058 sa=0 sb=0 sd=0 mult=1 m=1   $ reference-side precharge: copy of MPPRE
XMN1_f04_w1 sbl_f04_w1 sref_f04_w1 vn_f04_w1 0 sky130_fd_pr__nfet_01v8 L=0.15 W=1 nf=1 ad=0.29 as=0.29 pd=2.58 ps=2.58 nrd=0.29 nrs=0.29 sa=0 sb=0 sd=0 mult=1 m=1
XMN2_f04_w1 sref_f04_w1 sbl_f04_w1 vn_f04_w1 0 sky130_fd_pr__nfet_01v8 L=0.15 W=1 nf=1 ad=0.29 as=0.29 pd=2.58 ps=2.58 nrd=0.29 nrs=0.29 sa=0 sb=0 sd=0 mult=1 m=1
XMP1_f04_w1 sbl_f04_w1 sref_f04_w1 vp_f04_w1 vdd sky130_fd_pr__pfet_01v8 L=0.15 W=2 nf=1 ad=0.58 as=0.58 pd=4.58 ps=4.58 nrd=0.145 nrs=0.145 sa=0 sb=0 sd=0 mult=1 m=1
XMP2_f04_w1 sref_f04_w1 sbl_f04_w1 vp_f04_w1 vdd sky130_fd_pr__pfet_01v8 L=0.15 W=2 nf=1 ad=0.58 as=0.58 pd=4.58 ps=4.58 nrd=0.145 nrs=0.145 sa=0 sb=0 sd=0 mult=1 m=1
XMNF_f04_w1 vn_f04_w1 en 0 0 sky130_fd_pr__nfet_01v8 L=0.15 W=2 nf=1 ad=0.58 as=0.58 pd=4.58 ps=4.58 nrd=0.145 nrs=0.145 sa=0 sb=0 sd=0 mult=1 m=1
XMPH_f04_w1 vp_f04_w1 enb vdd vdd sky130_fd_pr__pfet_01v8 L=0.15 W=4 nf=1 ad=1.16 as=1.16 pd=8.58 ps=8.58 nrd=0.0725 nrs=0.0725 sa=0 sb=0 sd=0 mult=1 m=1
bd_f04_w1 d_f04_w1 0 v=v(sbl_f04_w1)-v(sref_f04_w1)
bdabs_f04_w1 dabs_f04_w1 0 v=abs(v(sbl_f04_w1)-v(sref_f04_w1))

* ---- instance 105: f04_w0 (final with array-side rbl C = 6.26 fF (total 10 fF incl. the 3.74 fF fs/27 C periphery probe value; the 'C_RBL is the total' reading)) ----
XMWR_f04_w0_0 sn_f04_w0_0 wl wbl_f04_w0 0 sky130_fd_pr__nfet_01v8 L=0.15 W=0.42 nf=1 ad=0.1218 as=0.1218 pd=1.42 ps=1.42 nrd=0.69047619047619 nrs=0.69047619047619 sa=0 sb=0 sd=0 mult=1 m=1
XMRD_f04_w0_0 rbl_f04_w0 sn_f04_w0_0 rwl_sel 0 sky130_fd_pr__nfet_01v8 L=0.15 W=0.42 nf=1 ad=0.1218 as=0.1218 pd=1.42 ps=1.42 nrd=0.69047619047619 nrs=0.69047619047619 sa=0 sb=0 sd=0 mult=1 m=1
csn_f04_w0_0 sn_f04_w0_0 0 {C_SN}
XMWR_f04_w0_1 sn_f04_w0_1 0 wbl_f04_w0 0 sky130_fd_pr__nfet_01v8 L=0.15 W=0.42 nf=1 ad=0.1218 as=0.1218 pd=1.42 ps=1.42 nrd=0.69047619047619 nrs=0.69047619047619 sa=0 sb=0 sd=0 mult=1 m=1
XMRD_f04_w0_1 rbl_f04_w0 sn_f04_w0_1 rwl_des 0 sky130_fd_pr__nfet_01v8 L=0.15 W=0.42 nf=1 ad=0.1218 as=0.1218 pd=1.42 ps=1.42 nrd=0.69047619047619 nrs=0.69047619047619 sa=0 sb=0 sd=0 mult=1 m=1
csn_f04_w0_1 sn_f04_w0_1 0 {C_SN}
XMWR_f04_w0_2 sn_f04_w0_2 0 wbl_f04_w0 0 sky130_fd_pr__nfet_01v8 L=0.15 W=0.42 nf=1 ad=0.1218 as=0.1218 pd=1.42 ps=1.42 nrd=0.69047619047619 nrs=0.69047619047619 sa=0 sb=0 sd=0 mult=1 m=1
XMRD_f04_w0_2 rbl_f04_w0 sn_f04_w0_2 rwl_des 0 sky130_fd_pr__nfet_01v8 L=0.15 W=0.42 nf=1 ad=0.1218 as=0.1218 pd=1.42 ps=1.42 nrd=0.69047619047619 nrs=0.69047619047619 sa=0 sb=0 sd=0 mult=1 m=1
csn_f04_w0_2 sn_f04_w0_2 0 {C_SN}
XMWR_f04_w0_3 sn_f04_w0_3 0 wbl_f04_w0 0 sky130_fd_pr__nfet_01v8 L=0.15 W=0.42 nf=1 ad=0.1218 as=0.1218 pd=1.42 ps=1.42 nrd=0.69047619047619 nrs=0.69047619047619 sa=0 sb=0 sd=0 mult=1 m=1
XMRD_f04_w0_3 rbl_f04_w0 sn_f04_w0_3 rwl_des 0 sky130_fd_pr__nfet_01v8 L=0.15 W=0.42 nf=1 ad=0.1218 as=0.1218 pd=1.42 ps=1.42 nrd=0.69047619047619 nrs=0.69047619047619 sa=0 sb=0 sd=0 mult=1 m=1
csn_f04_w0_3 sn_f04_w0_3 0 {C_SN}
crbl_f04_w0 rbl_f04_w0 0 6.26e-15
cwbl_f04_w0 wbl_f04_w0 0 {C_WBL}
cref_f04_w0 ref_f04_w0 0 {C_RBL}   $ ASSUMPTION: ideal matched dummy load
XMPPRE_f04_w0 rbl_f04_w0 pcb_100 prea prea sky130_fd_pr__pfet_01v8 L=0.15 W=5 nf=1 ad=1.45 as=1.45 pd=10.58 ps=10.58 nrd=0.058 nrs=0.058 sa=0 sb=0 sd=0 mult=1 m=1
XMPU1_f04_w0 x_f04_w0 dinb0 vdd vdd sky130_fd_pr__pfet_01v8 L=0.15 W=1 nf=1 ad=0.29 as=0.29 pd=2.58 ps=2.58 nrd=0.29 nrs=0.29 sa=0 sb=0 sd=0 mult=1 m=1
XMPU2_f04_w0 wbl_f04_w0 wenb x_f04_w0 vdd sky130_fd_pr__pfet_01v8 L=0.15 W=1 nf=1 ad=0.29 as=0.29 pd=2.58 ps=2.58 nrd=0.29 nrs=0.29 sa=0 sb=0 sd=0 mult=1 m=1
XMND2_f04_w0 wbl_f04_w0 wen y_f04_w0 0 sky130_fd_pr__nfet_01v8 L=0.15 W=4 nf=1 ad=1.16 as=1.16 pd=8.58 ps=8.58 nrd=0.0725 nrs=0.0725 sa=0 sb=0 sd=0 mult=1 m=1
XMND1_f04_w0 y_f04_w0 dinb0 0 0 sky130_fd_pr__nfet_01v8 L=0.15 W=4 nf=1 ad=1.16 as=1.16 pd=8.58 ps=8.58 nrd=0.0725 nrs=0.0725 sa=0 sb=0 sd=0 mult=1 m=1
XMNI_f04_w0 wbl_f04_w0 wenb 0 0 sky130_fd_pr__nfet_01v8 L=0.15 W=2 nf=1 ad=0.58 as=0.58 pd=4.58 ps=4.58 nrd=0.145 nrs=0.145 sa=0 sb=0 sd=0 mult=1 m=1
XMNS_f04_w0 sbl_f04_w0 sel_69500 rbl_f04_w0 0 sky130_fd_pr__nfet_01v8 L=0.15 W=0.42 nf=1 ad=0.1218 as=0.1218 pd=1.42 ps=1.42 nrd=0.69047619047619 nrs=0.69047619047619 sa=0 sb=0 sd=0 mult=1 m=1
XMNSR_f04_w0 sref_f04_w0 sel_69500 ref_f04_w0 0 sky130_fd_pr__nfet_01v8 L=0.15 W=0.42 nf=1 ad=0.1218 as=0.1218 pd=1.42 ps=1.42 nrd=0.69047619047619 nrs=0.69047619047619 sa=0 sb=0 sd=0 mult=1 m=1
XMPPREF_f04_w0 ref_f04_w0 pcb_100 pref pref sky130_fd_pr__pfet_01v8 L=0.15 W=5 nf=1 ad=1.45 as=1.45 pd=10.58 ps=10.58 nrd=0.058 nrs=0.058 sa=0 sb=0 sd=0 mult=1 m=1   $ reference-side precharge: copy of MPPRE
XMN1_f04_w0 sbl_f04_w0 sref_f04_w0 vn_f04_w0 0 sky130_fd_pr__nfet_01v8 L=0.15 W=1 nf=1 ad=0.29 as=0.29 pd=2.58 ps=2.58 nrd=0.29 nrs=0.29 sa=0 sb=0 sd=0 mult=1 m=1
XMN2_f04_w0 sref_f04_w0 sbl_f04_w0 vn_f04_w0 0 sky130_fd_pr__nfet_01v8 L=0.15 W=1 nf=1 ad=0.29 as=0.29 pd=2.58 ps=2.58 nrd=0.29 nrs=0.29 sa=0 sb=0 sd=0 mult=1 m=1
XMP1_f04_w0 sbl_f04_w0 sref_f04_w0 vp_f04_w0 vdd sky130_fd_pr__pfet_01v8 L=0.15 W=2 nf=1 ad=0.58 as=0.58 pd=4.58 ps=4.58 nrd=0.145 nrs=0.145 sa=0 sb=0 sd=0 mult=1 m=1
XMP2_f04_w0 sref_f04_w0 sbl_f04_w0 vp_f04_w0 vdd sky130_fd_pr__pfet_01v8 L=0.15 W=2 nf=1 ad=0.58 as=0.58 pd=4.58 ps=4.58 nrd=0.145 nrs=0.145 sa=0 sb=0 sd=0 mult=1 m=1
XMNF_f04_w0 vn_f04_w0 en 0 0 sky130_fd_pr__nfet_01v8 L=0.15 W=2 nf=1 ad=0.58 as=0.58 pd=4.58 ps=4.58 nrd=0.145 nrs=0.145 sa=0 sb=0 sd=0 mult=1 m=1
XMPH_f04_w0 vp_f04_w0 enb vdd vdd sky130_fd_pr__pfet_01v8 L=0.15 W=4 nf=1 ad=1.16 as=1.16 pd=8.58 ps=8.58 nrd=0.0725 nrs=0.0725 sa=0 sb=0 sd=0 mult=1 m=1
bd_f04_w0 d_f04_w0 0 v=v(sbl_f04_w0)-v(sref_f04_w0)
bdabs_f04_w0 dabs_f04_w0 0 v=abs(v(sbl_f04_w0)-v(sref_f04_w0))

* ---- instance 106: d00_w0 (driver as #114 (control)) ----
XMWR_d00_w0_0 sn_d00_w0_0 wl wbl_d00_w0 0 sky130_fd_pr__nfet_01v8 L=0.15 W=0.42 nf=1 ad=0.1218 as=0.1218 pd=1.42 ps=1.42 nrd=0.69047619047619 nrs=0.69047619047619 sa=0 sb=0 sd=0 mult=1 m=1
XMRD_d00_w0_0 rbl_d00_w0 sn_d00_w0_0 rwl_sel 0 sky130_fd_pr__nfet_01v8 L=0.15 W=0.42 nf=1 ad=0.1218 as=0.1218 pd=1.42 ps=1.42 nrd=0.69047619047619 nrs=0.69047619047619 sa=0 sb=0 sd=0 mult=1 m=1
csn_d00_w0_0 sn_d00_w0_0 0 {C_SN}
XMWR_d00_w0_1 sn_d00_w0_1 0 wbl_d00_w0 0 sky130_fd_pr__nfet_01v8 L=0.15 W=0.42 nf=1 ad=0.1218 as=0.1218 pd=1.42 ps=1.42 nrd=0.69047619047619 nrs=0.69047619047619 sa=0 sb=0 sd=0 mult=1 m=1
XMRD_d00_w0_1 rbl_d00_w0 sn_d00_w0_1 rwl_des 0 sky130_fd_pr__nfet_01v8 L=0.15 W=0.42 nf=1 ad=0.1218 as=0.1218 pd=1.42 ps=1.42 nrd=0.69047619047619 nrs=0.69047619047619 sa=0 sb=0 sd=0 mult=1 m=1
csn_d00_w0_1 sn_d00_w0_1 0 {C_SN}
XMWR_d00_w0_2 sn_d00_w0_2 0 wbl_d00_w0 0 sky130_fd_pr__nfet_01v8 L=0.15 W=0.42 nf=1 ad=0.1218 as=0.1218 pd=1.42 ps=1.42 nrd=0.69047619047619 nrs=0.69047619047619 sa=0 sb=0 sd=0 mult=1 m=1
XMRD_d00_w0_2 rbl_d00_w0 sn_d00_w0_2 rwl_des 0 sky130_fd_pr__nfet_01v8 L=0.15 W=0.42 nf=1 ad=0.1218 as=0.1218 pd=1.42 ps=1.42 nrd=0.69047619047619 nrs=0.69047619047619 sa=0 sb=0 sd=0 mult=1 m=1
csn_d00_w0_2 sn_d00_w0_2 0 {C_SN}
XMWR_d00_w0_3 sn_d00_w0_3 0 wbl_d00_w0 0 sky130_fd_pr__nfet_01v8 L=0.15 W=0.42 nf=1 ad=0.1218 as=0.1218 pd=1.42 ps=1.42 nrd=0.69047619047619 nrs=0.69047619047619 sa=0 sb=0 sd=0 mult=1 m=1
XMRD_d00_w0_3 rbl_d00_w0 sn_d00_w0_3 rwl_des 0 sky130_fd_pr__nfet_01v8 L=0.15 W=0.42 nf=1 ad=0.1218 as=0.1218 pd=1.42 ps=1.42 nrd=0.69047619047619 nrs=0.69047619047619 sa=0 sb=0 sd=0 mult=1 m=1
csn_d00_w0_3 sn_d00_w0_3 0 {C_SN}
crbl_d00_w0 rbl_d00_w0 0 {C_RBL}
cwbl_d00_w0 wbl_d00_w0 0 {C_WBL}
cref_d00_w0 ref_d00_w0 0 {C_RBL}   $ ASSUMPTION: ideal matched dummy load
spr_d00_w0 pref ref_d00_w0 pca 0 swpre   $ reference-side precharge: ideal switch (#114 convention)
XMPPRE_d00_w0 rbl_d00_w0 pcb_100 prea prea sky130_fd_pr__pfet_01v8 L=0.15 W=4 nf=1 ad=1.16 as=1.16 pd=8.58 ps=8.58 nrd=0.0725 nrs=0.0725 sa=0 sb=0 sd=0 mult=1 m=1
XMPU1_d00_w0 x_d00_w0 dinb0 vdd vdd sky130_fd_pr__pfet_01v8 L=0.15 W=1 nf=1 ad=0.29 as=0.29 pd=2.58 ps=2.58 nrd=0.29 nrs=0.29 sa=0 sb=0 sd=0 mult=1 m=1
XMPU2_d00_w0 wbl_d00_w0 wenb x_d00_w0 vdd sky130_fd_pr__pfet_01v8 L=0.15 W=1 nf=1 ad=0.29 as=0.29 pd=2.58 ps=2.58 nrd=0.29 nrs=0.29 sa=0 sb=0 sd=0 mult=1 m=1
XMND2_d00_w0 wbl_d00_w0 wen y_d00_w0 0 sky130_fd_pr__nfet_01v8 L=0.15 W=0.5 nf=1 ad=0.145 as=0.145 pd=1.58 ps=1.58 nrd=0.58 nrs=0.58 sa=0 sb=0 sd=0 mult=1 m=1
XMND1_d00_w0 y_d00_w0 dinb0 0 0 sky130_fd_pr__nfet_01v8 L=0.15 W=0.5 nf=1 ad=0.145 as=0.145 pd=1.58 ps=1.58 nrd=0.58 nrs=0.58 sa=0 sb=0 sd=0 mult=1 m=1
XMNI_d00_w0 wbl_d00_w0 wenb 0 0 sky130_fd_pr__nfet_01v8 L=0.15 W=0.42 nf=1 ad=0.1218 as=0.1218 pd=1.42 ps=1.42 nrd=0.69047619047619 nrs=0.69047619047619 sa=0 sb=0 sd=0 mult=1 m=1
XMNS_d00_w0 sbl_d00_w0 sel_69500 rbl_d00_w0 0 sky130_fd_pr__nfet_01v8 L=0.15 W=1 nf=1 ad=0.29 as=0.29 pd=2.58 ps=2.58 nrd=0.29 nrs=0.29 sa=0 sb=0 sd=0 mult=1 m=1
XMPS_d00_w0 sbl_d00_w0 selb_69500 rbl_d00_w0 vdd sky130_fd_pr__pfet_01v8 L=0.15 W=2 nf=1 ad=0.58 as=0.58 pd=4.58 ps=4.58 nrd=0.145 nrs=0.145 sa=0 sb=0 sd=0 mult=1 m=1
XMNSR_d00_w0 sref_d00_w0 sel_69500 ref_d00_w0 0 sky130_fd_pr__nfet_01v8 L=0.15 W=1 nf=1 ad=0.29 as=0.29 pd=2.58 ps=2.58 nrd=0.29 nrs=0.29 sa=0 sb=0 sd=0 mult=1 m=1
XMPSR_d00_w0 sref_d00_w0 selb_69500 ref_d00_w0 vdd sky130_fd_pr__pfet_01v8 L=0.15 W=2 nf=1 ad=0.58 as=0.58 pd=4.58 ps=4.58 nrd=0.145 nrs=0.145 sa=0 sb=0 sd=0 mult=1 m=1
XMN1_d00_w0 sbl_d00_w0 sref_d00_w0 vn_d00_w0 0 sky130_fd_pr__nfet_01v8 L=0.15 W=1 nf=1 ad=0.29 as=0.29 pd=2.58 ps=2.58 nrd=0.29 nrs=0.29 sa=0 sb=0 sd=0 mult=1 m=1
XMN2_d00_w0 sref_d00_w0 sbl_d00_w0 vn_d00_w0 0 sky130_fd_pr__nfet_01v8 L=0.15 W=1 nf=1 ad=0.29 as=0.29 pd=2.58 ps=2.58 nrd=0.29 nrs=0.29 sa=0 sb=0 sd=0 mult=1 m=1
XMP1_d00_w0 sbl_d00_w0 sref_d00_w0 vp_d00_w0 vdd sky130_fd_pr__pfet_01v8 L=0.15 W=2 nf=1 ad=0.58 as=0.58 pd=4.58 ps=4.58 nrd=0.145 nrs=0.145 sa=0 sb=0 sd=0 mult=1 m=1
XMP2_d00_w0 sref_d00_w0 sbl_d00_w0 vp_d00_w0 vdd sky130_fd_pr__pfet_01v8 L=0.15 W=2 nf=1 ad=0.58 as=0.58 pd=4.58 ps=4.58 nrd=0.145 nrs=0.145 sa=0 sb=0 sd=0 mult=1 m=1
XMNF_d00_w0 vn_d00_w0 en 0 0 sky130_fd_pr__nfet_01v8 L=0.15 W=2 nf=1 ad=0.58 as=0.58 pd=4.58 ps=4.58 nrd=0.145 nrs=0.145 sa=0 sb=0 sd=0 mult=1 m=1
XMPH_d00_w0 vp_d00_w0 enb vdd vdd sky130_fd_pr__pfet_01v8 L=0.15 W=4 nf=1 ad=1.16 as=1.16 pd=8.58 ps=8.58 nrd=0.0725 nrs=0.0725 sa=0 sb=0 sd=0 mult=1 m=1
bd_d00_w0 d_d00_w0 0 v=v(sbl_d00_w0)-v(sref_d00_w0)
bdabs_d00_w0 dabs_d00_w0 0 v=abs(v(sbl_d00_w0)-v(sref_d00_w0))

* ---- instance 107: d01_w0 (pull-down stack MND1/MND2 1.0) ----
XMWR_d01_w0_0 sn_d01_w0_0 wl wbl_d01_w0 0 sky130_fd_pr__nfet_01v8 L=0.15 W=0.42 nf=1 ad=0.1218 as=0.1218 pd=1.42 ps=1.42 nrd=0.69047619047619 nrs=0.69047619047619 sa=0 sb=0 sd=0 mult=1 m=1
XMRD_d01_w0_0 rbl_d01_w0 sn_d01_w0_0 rwl_sel 0 sky130_fd_pr__nfet_01v8 L=0.15 W=0.42 nf=1 ad=0.1218 as=0.1218 pd=1.42 ps=1.42 nrd=0.69047619047619 nrs=0.69047619047619 sa=0 sb=0 sd=0 mult=1 m=1
csn_d01_w0_0 sn_d01_w0_0 0 {C_SN}
XMWR_d01_w0_1 sn_d01_w0_1 0 wbl_d01_w0 0 sky130_fd_pr__nfet_01v8 L=0.15 W=0.42 nf=1 ad=0.1218 as=0.1218 pd=1.42 ps=1.42 nrd=0.69047619047619 nrs=0.69047619047619 sa=0 sb=0 sd=0 mult=1 m=1
XMRD_d01_w0_1 rbl_d01_w0 sn_d01_w0_1 rwl_des 0 sky130_fd_pr__nfet_01v8 L=0.15 W=0.42 nf=1 ad=0.1218 as=0.1218 pd=1.42 ps=1.42 nrd=0.69047619047619 nrs=0.69047619047619 sa=0 sb=0 sd=0 mult=1 m=1
csn_d01_w0_1 sn_d01_w0_1 0 {C_SN}
XMWR_d01_w0_2 sn_d01_w0_2 0 wbl_d01_w0 0 sky130_fd_pr__nfet_01v8 L=0.15 W=0.42 nf=1 ad=0.1218 as=0.1218 pd=1.42 ps=1.42 nrd=0.69047619047619 nrs=0.69047619047619 sa=0 sb=0 sd=0 mult=1 m=1
XMRD_d01_w0_2 rbl_d01_w0 sn_d01_w0_2 rwl_des 0 sky130_fd_pr__nfet_01v8 L=0.15 W=0.42 nf=1 ad=0.1218 as=0.1218 pd=1.42 ps=1.42 nrd=0.69047619047619 nrs=0.69047619047619 sa=0 sb=0 sd=0 mult=1 m=1
csn_d01_w0_2 sn_d01_w0_2 0 {C_SN}
XMWR_d01_w0_3 sn_d01_w0_3 0 wbl_d01_w0 0 sky130_fd_pr__nfet_01v8 L=0.15 W=0.42 nf=1 ad=0.1218 as=0.1218 pd=1.42 ps=1.42 nrd=0.69047619047619 nrs=0.69047619047619 sa=0 sb=0 sd=0 mult=1 m=1
XMRD_d01_w0_3 rbl_d01_w0 sn_d01_w0_3 rwl_des 0 sky130_fd_pr__nfet_01v8 L=0.15 W=0.42 nf=1 ad=0.1218 as=0.1218 pd=1.42 ps=1.42 nrd=0.69047619047619 nrs=0.69047619047619 sa=0 sb=0 sd=0 mult=1 m=1
csn_d01_w0_3 sn_d01_w0_3 0 {C_SN}
crbl_d01_w0 rbl_d01_w0 0 {C_RBL}
cwbl_d01_w0 wbl_d01_w0 0 {C_WBL}
cref_d01_w0 ref_d01_w0 0 {C_RBL}   $ ASSUMPTION: ideal matched dummy load
spr_d01_w0 pref ref_d01_w0 pca 0 swpre   $ reference-side precharge: ideal switch (#114 convention)
XMPPRE_d01_w0 rbl_d01_w0 pcb_100 prea prea sky130_fd_pr__pfet_01v8 L=0.15 W=4 nf=1 ad=1.16 as=1.16 pd=8.58 ps=8.58 nrd=0.0725 nrs=0.0725 sa=0 sb=0 sd=0 mult=1 m=1
XMPU1_d01_w0 x_d01_w0 dinb0 vdd vdd sky130_fd_pr__pfet_01v8 L=0.15 W=1 nf=1 ad=0.29 as=0.29 pd=2.58 ps=2.58 nrd=0.29 nrs=0.29 sa=0 sb=0 sd=0 mult=1 m=1
XMPU2_d01_w0 wbl_d01_w0 wenb x_d01_w0 vdd sky130_fd_pr__pfet_01v8 L=0.15 W=1 nf=1 ad=0.29 as=0.29 pd=2.58 ps=2.58 nrd=0.29 nrs=0.29 sa=0 sb=0 sd=0 mult=1 m=1
XMND2_d01_w0 wbl_d01_w0 wen y_d01_w0 0 sky130_fd_pr__nfet_01v8 L=0.15 W=1 nf=1 ad=0.29 as=0.29 pd=2.58 ps=2.58 nrd=0.29 nrs=0.29 sa=0 sb=0 sd=0 mult=1 m=1
XMND1_d01_w0 y_d01_w0 dinb0 0 0 sky130_fd_pr__nfet_01v8 L=0.15 W=1 nf=1 ad=0.29 as=0.29 pd=2.58 ps=2.58 nrd=0.29 nrs=0.29 sa=0 sb=0 sd=0 mult=1 m=1
XMNI_d01_w0 wbl_d01_w0 wenb 0 0 sky130_fd_pr__nfet_01v8 L=0.15 W=0.42 nf=1 ad=0.1218 as=0.1218 pd=1.42 ps=1.42 nrd=0.69047619047619 nrs=0.69047619047619 sa=0 sb=0 sd=0 mult=1 m=1
XMNS_d01_w0 sbl_d01_w0 sel_69500 rbl_d01_w0 0 sky130_fd_pr__nfet_01v8 L=0.15 W=1 nf=1 ad=0.29 as=0.29 pd=2.58 ps=2.58 nrd=0.29 nrs=0.29 sa=0 sb=0 sd=0 mult=1 m=1
XMPS_d01_w0 sbl_d01_w0 selb_69500 rbl_d01_w0 vdd sky130_fd_pr__pfet_01v8 L=0.15 W=2 nf=1 ad=0.58 as=0.58 pd=4.58 ps=4.58 nrd=0.145 nrs=0.145 sa=0 sb=0 sd=0 mult=1 m=1
XMNSR_d01_w0 sref_d01_w0 sel_69500 ref_d01_w0 0 sky130_fd_pr__nfet_01v8 L=0.15 W=1 nf=1 ad=0.29 as=0.29 pd=2.58 ps=2.58 nrd=0.29 nrs=0.29 sa=0 sb=0 sd=0 mult=1 m=1
XMPSR_d01_w0 sref_d01_w0 selb_69500 ref_d01_w0 vdd sky130_fd_pr__pfet_01v8 L=0.15 W=2 nf=1 ad=0.58 as=0.58 pd=4.58 ps=4.58 nrd=0.145 nrs=0.145 sa=0 sb=0 sd=0 mult=1 m=1
XMN1_d01_w0 sbl_d01_w0 sref_d01_w0 vn_d01_w0 0 sky130_fd_pr__nfet_01v8 L=0.15 W=1 nf=1 ad=0.29 as=0.29 pd=2.58 ps=2.58 nrd=0.29 nrs=0.29 sa=0 sb=0 sd=0 mult=1 m=1
XMN2_d01_w0 sref_d01_w0 sbl_d01_w0 vn_d01_w0 0 sky130_fd_pr__nfet_01v8 L=0.15 W=1 nf=1 ad=0.29 as=0.29 pd=2.58 ps=2.58 nrd=0.29 nrs=0.29 sa=0 sb=0 sd=0 mult=1 m=1
XMP1_d01_w0 sbl_d01_w0 sref_d01_w0 vp_d01_w0 vdd sky130_fd_pr__pfet_01v8 L=0.15 W=2 nf=1 ad=0.58 as=0.58 pd=4.58 ps=4.58 nrd=0.145 nrs=0.145 sa=0 sb=0 sd=0 mult=1 m=1
XMP2_d01_w0 sref_d01_w0 sbl_d01_w0 vp_d01_w0 vdd sky130_fd_pr__pfet_01v8 L=0.15 W=2 nf=1 ad=0.58 as=0.58 pd=4.58 ps=4.58 nrd=0.145 nrs=0.145 sa=0 sb=0 sd=0 mult=1 m=1
XMNF_d01_w0 vn_d01_w0 en 0 0 sky130_fd_pr__nfet_01v8 L=0.15 W=2 nf=1 ad=0.58 as=0.58 pd=4.58 ps=4.58 nrd=0.145 nrs=0.145 sa=0 sb=0 sd=0 mult=1 m=1
XMPH_d01_w0 vp_d01_w0 enb vdd vdd sky130_fd_pr__pfet_01v8 L=0.15 W=4 nf=1 ad=1.16 as=1.16 pd=8.58 ps=8.58 nrd=0.0725 nrs=0.0725 sa=0 sb=0 sd=0 mult=1 m=1
bd_d01_w0 d_d01_w0 0 v=v(sbl_d01_w0)-v(sref_d01_w0)
bdabs_d01_w0 dabs_d01_w0 0 v=abs(v(sbl_d01_w0)-v(sref_d01_w0))

* ---- instance 108: d02_w0 (pull-down stack MND1/MND2 2.0) ----
XMWR_d02_w0_0 sn_d02_w0_0 wl wbl_d02_w0 0 sky130_fd_pr__nfet_01v8 L=0.15 W=0.42 nf=1 ad=0.1218 as=0.1218 pd=1.42 ps=1.42 nrd=0.69047619047619 nrs=0.69047619047619 sa=0 sb=0 sd=0 mult=1 m=1
XMRD_d02_w0_0 rbl_d02_w0 sn_d02_w0_0 rwl_sel 0 sky130_fd_pr__nfet_01v8 L=0.15 W=0.42 nf=1 ad=0.1218 as=0.1218 pd=1.42 ps=1.42 nrd=0.69047619047619 nrs=0.69047619047619 sa=0 sb=0 sd=0 mult=1 m=1
csn_d02_w0_0 sn_d02_w0_0 0 {C_SN}
XMWR_d02_w0_1 sn_d02_w0_1 0 wbl_d02_w0 0 sky130_fd_pr__nfet_01v8 L=0.15 W=0.42 nf=1 ad=0.1218 as=0.1218 pd=1.42 ps=1.42 nrd=0.69047619047619 nrs=0.69047619047619 sa=0 sb=0 sd=0 mult=1 m=1
XMRD_d02_w0_1 rbl_d02_w0 sn_d02_w0_1 rwl_des 0 sky130_fd_pr__nfet_01v8 L=0.15 W=0.42 nf=1 ad=0.1218 as=0.1218 pd=1.42 ps=1.42 nrd=0.69047619047619 nrs=0.69047619047619 sa=0 sb=0 sd=0 mult=1 m=1
csn_d02_w0_1 sn_d02_w0_1 0 {C_SN}
XMWR_d02_w0_2 sn_d02_w0_2 0 wbl_d02_w0 0 sky130_fd_pr__nfet_01v8 L=0.15 W=0.42 nf=1 ad=0.1218 as=0.1218 pd=1.42 ps=1.42 nrd=0.69047619047619 nrs=0.69047619047619 sa=0 sb=0 sd=0 mult=1 m=1
XMRD_d02_w0_2 rbl_d02_w0 sn_d02_w0_2 rwl_des 0 sky130_fd_pr__nfet_01v8 L=0.15 W=0.42 nf=1 ad=0.1218 as=0.1218 pd=1.42 ps=1.42 nrd=0.69047619047619 nrs=0.69047619047619 sa=0 sb=0 sd=0 mult=1 m=1
csn_d02_w0_2 sn_d02_w0_2 0 {C_SN}
XMWR_d02_w0_3 sn_d02_w0_3 0 wbl_d02_w0 0 sky130_fd_pr__nfet_01v8 L=0.15 W=0.42 nf=1 ad=0.1218 as=0.1218 pd=1.42 ps=1.42 nrd=0.69047619047619 nrs=0.69047619047619 sa=0 sb=0 sd=0 mult=1 m=1
XMRD_d02_w0_3 rbl_d02_w0 sn_d02_w0_3 rwl_des 0 sky130_fd_pr__nfet_01v8 L=0.15 W=0.42 nf=1 ad=0.1218 as=0.1218 pd=1.42 ps=1.42 nrd=0.69047619047619 nrs=0.69047619047619 sa=0 sb=0 sd=0 mult=1 m=1
csn_d02_w0_3 sn_d02_w0_3 0 {C_SN}
crbl_d02_w0 rbl_d02_w0 0 {C_RBL}
cwbl_d02_w0 wbl_d02_w0 0 {C_WBL}
cref_d02_w0 ref_d02_w0 0 {C_RBL}   $ ASSUMPTION: ideal matched dummy load
spr_d02_w0 pref ref_d02_w0 pca 0 swpre   $ reference-side precharge: ideal switch (#114 convention)
XMPPRE_d02_w0 rbl_d02_w0 pcb_100 prea prea sky130_fd_pr__pfet_01v8 L=0.15 W=4 nf=1 ad=1.16 as=1.16 pd=8.58 ps=8.58 nrd=0.0725 nrs=0.0725 sa=0 sb=0 sd=0 mult=1 m=1
XMPU1_d02_w0 x_d02_w0 dinb0 vdd vdd sky130_fd_pr__pfet_01v8 L=0.15 W=1 nf=1 ad=0.29 as=0.29 pd=2.58 ps=2.58 nrd=0.29 nrs=0.29 sa=0 sb=0 sd=0 mult=1 m=1
XMPU2_d02_w0 wbl_d02_w0 wenb x_d02_w0 vdd sky130_fd_pr__pfet_01v8 L=0.15 W=1 nf=1 ad=0.29 as=0.29 pd=2.58 ps=2.58 nrd=0.29 nrs=0.29 sa=0 sb=0 sd=0 mult=1 m=1
XMND2_d02_w0 wbl_d02_w0 wen y_d02_w0 0 sky130_fd_pr__nfet_01v8 L=0.15 W=2 nf=1 ad=0.58 as=0.58 pd=4.58 ps=4.58 nrd=0.145 nrs=0.145 sa=0 sb=0 sd=0 mult=1 m=1
XMND1_d02_w0 y_d02_w0 dinb0 0 0 sky130_fd_pr__nfet_01v8 L=0.15 W=2 nf=1 ad=0.58 as=0.58 pd=4.58 ps=4.58 nrd=0.145 nrs=0.145 sa=0 sb=0 sd=0 mult=1 m=1
XMNI_d02_w0 wbl_d02_w0 wenb 0 0 sky130_fd_pr__nfet_01v8 L=0.15 W=0.42 nf=1 ad=0.1218 as=0.1218 pd=1.42 ps=1.42 nrd=0.69047619047619 nrs=0.69047619047619 sa=0 sb=0 sd=0 mult=1 m=1
XMNS_d02_w0 sbl_d02_w0 sel_69500 rbl_d02_w0 0 sky130_fd_pr__nfet_01v8 L=0.15 W=1 nf=1 ad=0.29 as=0.29 pd=2.58 ps=2.58 nrd=0.29 nrs=0.29 sa=0 sb=0 sd=0 mult=1 m=1
XMPS_d02_w0 sbl_d02_w0 selb_69500 rbl_d02_w0 vdd sky130_fd_pr__pfet_01v8 L=0.15 W=2 nf=1 ad=0.58 as=0.58 pd=4.58 ps=4.58 nrd=0.145 nrs=0.145 sa=0 sb=0 sd=0 mult=1 m=1
XMNSR_d02_w0 sref_d02_w0 sel_69500 ref_d02_w0 0 sky130_fd_pr__nfet_01v8 L=0.15 W=1 nf=1 ad=0.29 as=0.29 pd=2.58 ps=2.58 nrd=0.29 nrs=0.29 sa=0 sb=0 sd=0 mult=1 m=1
XMPSR_d02_w0 sref_d02_w0 selb_69500 ref_d02_w0 vdd sky130_fd_pr__pfet_01v8 L=0.15 W=2 nf=1 ad=0.58 as=0.58 pd=4.58 ps=4.58 nrd=0.145 nrs=0.145 sa=0 sb=0 sd=0 mult=1 m=1
XMN1_d02_w0 sbl_d02_w0 sref_d02_w0 vn_d02_w0 0 sky130_fd_pr__nfet_01v8 L=0.15 W=1 nf=1 ad=0.29 as=0.29 pd=2.58 ps=2.58 nrd=0.29 nrs=0.29 sa=0 sb=0 sd=0 mult=1 m=1
XMN2_d02_w0 sref_d02_w0 sbl_d02_w0 vn_d02_w0 0 sky130_fd_pr__nfet_01v8 L=0.15 W=1 nf=1 ad=0.29 as=0.29 pd=2.58 ps=2.58 nrd=0.29 nrs=0.29 sa=0 sb=0 sd=0 mult=1 m=1
XMP1_d02_w0 sbl_d02_w0 sref_d02_w0 vp_d02_w0 vdd sky130_fd_pr__pfet_01v8 L=0.15 W=2 nf=1 ad=0.58 as=0.58 pd=4.58 ps=4.58 nrd=0.145 nrs=0.145 sa=0 sb=0 sd=0 mult=1 m=1
XMP2_d02_w0 sref_d02_w0 sbl_d02_w0 vp_d02_w0 vdd sky130_fd_pr__pfet_01v8 L=0.15 W=2 nf=1 ad=0.58 as=0.58 pd=4.58 ps=4.58 nrd=0.145 nrs=0.145 sa=0 sb=0 sd=0 mult=1 m=1
XMNF_d02_w0 vn_d02_w0 en 0 0 sky130_fd_pr__nfet_01v8 L=0.15 W=2 nf=1 ad=0.58 as=0.58 pd=4.58 ps=4.58 nrd=0.145 nrs=0.145 sa=0 sb=0 sd=0 mult=1 m=1
XMPH_d02_w0 vp_d02_w0 enb vdd vdd sky130_fd_pr__pfet_01v8 L=0.15 W=4 nf=1 ad=1.16 as=1.16 pd=8.58 ps=8.58 nrd=0.0725 nrs=0.0725 sa=0 sb=0 sd=0 mult=1 m=1
bd_d02_w0 d_d02_w0 0 v=v(sbl_d02_w0)-v(sref_d02_w0)
bdabs_d02_w0 dabs_d02_w0 0 v=abs(v(sbl_d02_w0)-v(sref_d02_w0))

* ---- instance 109: d03_w0 (idle pull-down MNI 1.0) ----
XMWR_d03_w0_0 sn_d03_w0_0 wl wbl_d03_w0 0 sky130_fd_pr__nfet_01v8 L=0.15 W=0.42 nf=1 ad=0.1218 as=0.1218 pd=1.42 ps=1.42 nrd=0.69047619047619 nrs=0.69047619047619 sa=0 sb=0 sd=0 mult=1 m=1
XMRD_d03_w0_0 rbl_d03_w0 sn_d03_w0_0 rwl_sel 0 sky130_fd_pr__nfet_01v8 L=0.15 W=0.42 nf=1 ad=0.1218 as=0.1218 pd=1.42 ps=1.42 nrd=0.69047619047619 nrs=0.69047619047619 sa=0 sb=0 sd=0 mult=1 m=1
csn_d03_w0_0 sn_d03_w0_0 0 {C_SN}
XMWR_d03_w0_1 sn_d03_w0_1 0 wbl_d03_w0 0 sky130_fd_pr__nfet_01v8 L=0.15 W=0.42 nf=1 ad=0.1218 as=0.1218 pd=1.42 ps=1.42 nrd=0.69047619047619 nrs=0.69047619047619 sa=0 sb=0 sd=0 mult=1 m=1
XMRD_d03_w0_1 rbl_d03_w0 sn_d03_w0_1 rwl_des 0 sky130_fd_pr__nfet_01v8 L=0.15 W=0.42 nf=1 ad=0.1218 as=0.1218 pd=1.42 ps=1.42 nrd=0.69047619047619 nrs=0.69047619047619 sa=0 sb=0 sd=0 mult=1 m=1
csn_d03_w0_1 sn_d03_w0_1 0 {C_SN}
XMWR_d03_w0_2 sn_d03_w0_2 0 wbl_d03_w0 0 sky130_fd_pr__nfet_01v8 L=0.15 W=0.42 nf=1 ad=0.1218 as=0.1218 pd=1.42 ps=1.42 nrd=0.69047619047619 nrs=0.69047619047619 sa=0 sb=0 sd=0 mult=1 m=1
XMRD_d03_w0_2 rbl_d03_w0 sn_d03_w0_2 rwl_des 0 sky130_fd_pr__nfet_01v8 L=0.15 W=0.42 nf=1 ad=0.1218 as=0.1218 pd=1.42 ps=1.42 nrd=0.69047619047619 nrs=0.69047619047619 sa=0 sb=0 sd=0 mult=1 m=1
csn_d03_w0_2 sn_d03_w0_2 0 {C_SN}
XMWR_d03_w0_3 sn_d03_w0_3 0 wbl_d03_w0 0 sky130_fd_pr__nfet_01v8 L=0.15 W=0.42 nf=1 ad=0.1218 as=0.1218 pd=1.42 ps=1.42 nrd=0.69047619047619 nrs=0.69047619047619 sa=0 sb=0 sd=0 mult=1 m=1
XMRD_d03_w0_3 rbl_d03_w0 sn_d03_w0_3 rwl_des 0 sky130_fd_pr__nfet_01v8 L=0.15 W=0.42 nf=1 ad=0.1218 as=0.1218 pd=1.42 ps=1.42 nrd=0.69047619047619 nrs=0.69047619047619 sa=0 sb=0 sd=0 mult=1 m=1
csn_d03_w0_3 sn_d03_w0_3 0 {C_SN}
crbl_d03_w0 rbl_d03_w0 0 {C_RBL}
cwbl_d03_w0 wbl_d03_w0 0 {C_WBL}
cref_d03_w0 ref_d03_w0 0 {C_RBL}   $ ASSUMPTION: ideal matched dummy load
spr_d03_w0 pref ref_d03_w0 pca 0 swpre   $ reference-side precharge: ideal switch (#114 convention)
XMPPRE_d03_w0 rbl_d03_w0 pcb_100 prea prea sky130_fd_pr__pfet_01v8 L=0.15 W=4 nf=1 ad=1.16 as=1.16 pd=8.58 ps=8.58 nrd=0.0725 nrs=0.0725 sa=0 sb=0 sd=0 mult=1 m=1
XMPU1_d03_w0 x_d03_w0 dinb0 vdd vdd sky130_fd_pr__pfet_01v8 L=0.15 W=1 nf=1 ad=0.29 as=0.29 pd=2.58 ps=2.58 nrd=0.29 nrs=0.29 sa=0 sb=0 sd=0 mult=1 m=1
XMPU2_d03_w0 wbl_d03_w0 wenb x_d03_w0 vdd sky130_fd_pr__pfet_01v8 L=0.15 W=1 nf=1 ad=0.29 as=0.29 pd=2.58 ps=2.58 nrd=0.29 nrs=0.29 sa=0 sb=0 sd=0 mult=1 m=1
XMND2_d03_w0 wbl_d03_w0 wen y_d03_w0 0 sky130_fd_pr__nfet_01v8 L=0.15 W=0.5 nf=1 ad=0.145 as=0.145 pd=1.58 ps=1.58 nrd=0.58 nrs=0.58 sa=0 sb=0 sd=0 mult=1 m=1
XMND1_d03_w0 y_d03_w0 dinb0 0 0 sky130_fd_pr__nfet_01v8 L=0.15 W=0.5 nf=1 ad=0.145 as=0.145 pd=1.58 ps=1.58 nrd=0.58 nrs=0.58 sa=0 sb=0 sd=0 mult=1 m=1
XMNI_d03_w0 wbl_d03_w0 wenb 0 0 sky130_fd_pr__nfet_01v8 L=0.15 W=1 nf=1 ad=0.29 as=0.29 pd=2.58 ps=2.58 nrd=0.29 nrs=0.29 sa=0 sb=0 sd=0 mult=1 m=1
XMNS_d03_w0 sbl_d03_w0 sel_69500 rbl_d03_w0 0 sky130_fd_pr__nfet_01v8 L=0.15 W=1 nf=1 ad=0.29 as=0.29 pd=2.58 ps=2.58 nrd=0.29 nrs=0.29 sa=0 sb=0 sd=0 mult=1 m=1
XMPS_d03_w0 sbl_d03_w0 selb_69500 rbl_d03_w0 vdd sky130_fd_pr__pfet_01v8 L=0.15 W=2 nf=1 ad=0.58 as=0.58 pd=4.58 ps=4.58 nrd=0.145 nrs=0.145 sa=0 sb=0 sd=0 mult=1 m=1
XMNSR_d03_w0 sref_d03_w0 sel_69500 ref_d03_w0 0 sky130_fd_pr__nfet_01v8 L=0.15 W=1 nf=1 ad=0.29 as=0.29 pd=2.58 ps=2.58 nrd=0.29 nrs=0.29 sa=0 sb=0 sd=0 mult=1 m=1
XMPSR_d03_w0 sref_d03_w0 selb_69500 ref_d03_w0 vdd sky130_fd_pr__pfet_01v8 L=0.15 W=2 nf=1 ad=0.58 as=0.58 pd=4.58 ps=4.58 nrd=0.145 nrs=0.145 sa=0 sb=0 sd=0 mult=1 m=1
XMN1_d03_w0 sbl_d03_w0 sref_d03_w0 vn_d03_w0 0 sky130_fd_pr__nfet_01v8 L=0.15 W=1 nf=1 ad=0.29 as=0.29 pd=2.58 ps=2.58 nrd=0.29 nrs=0.29 sa=0 sb=0 sd=0 mult=1 m=1
XMN2_d03_w0 sref_d03_w0 sbl_d03_w0 vn_d03_w0 0 sky130_fd_pr__nfet_01v8 L=0.15 W=1 nf=1 ad=0.29 as=0.29 pd=2.58 ps=2.58 nrd=0.29 nrs=0.29 sa=0 sb=0 sd=0 mult=1 m=1
XMP1_d03_w0 sbl_d03_w0 sref_d03_w0 vp_d03_w0 vdd sky130_fd_pr__pfet_01v8 L=0.15 W=2 nf=1 ad=0.58 as=0.58 pd=4.58 ps=4.58 nrd=0.145 nrs=0.145 sa=0 sb=0 sd=0 mult=1 m=1
XMP2_d03_w0 sref_d03_w0 sbl_d03_w0 vp_d03_w0 vdd sky130_fd_pr__pfet_01v8 L=0.15 W=2 nf=1 ad=0.58 as=0.58 pd=4.58 ps=4.58 nrd=0.145 nrs=0.145 sa=0 sb=0 sd=0 mult=1 m=1
XMNF_d03_w0 vn_d03_w0 en 0 0 sky130_fd_pr__nfet_01v8 L=0.15 W=2 nf=1 ad=0.58 as=0.58 pd=4.58 ps=4.58 nrd=0.145 nrs=0.145 sa=0 sb=0 sd=0 mult=1 m=1
XMPH_d03_w0 vp_d03_w0 enb vdd vdd sky130_fd_pr__pfet_01v8 L=0.15 W=4 nf=1 ad=1.16 as=1.16 pd=8.58 ps=8.58 nrd=0.0725 nrs=0.0725 sa=0 sb=0 sd=0 mult=1 m=1
bd_d03_w0 d_d03_w0 0 v=v(sbl_d03_w0)-v(sref_d03_w0)
bdabs_d03_w0 dabs_d03_w0 0 v=abs(v(sbl_d03_w0)-v(sref_d03_w0))

* ---- instance 110: d04_w0 (MND1/MND2 2.0 + MNI 1.0) ----
XMWR_d04_w0_0 sn_d04_w0_0 wl wbl_d04_w0 0 sky130_fd_pr__nfet_01v8 L=0.15 W=0.42 nf=1 ad=0.1218 as=0.1218 pd=1.42 ps=1.42 nrd=0.69047619047619 nrs=0.69047619047619 sa=0 sb=0 sd=0 mult=1 m=1
XMRD_d04_w0_0 rbl_d04_w0 sn_d04_w0_0 rwl_sel 0 sky130_fd_pr__nfet_01v8 L=0.15 W=0.42 nf=1 ad=0.1218 as=0.1218 pd=1.42 ps=1.42 nrd=0.69047619047619 nrs=0.69047619047619 sa=0 sb=0 sd=0 mult=1 m=1
csn_d04_w0_0 sn_d04_w0_0 0 {C_SN}
XMWR_d04_w0_1 sn_d04_w0_1 0 wbl_d04_w0 0 sky130_fd_pr__nfet_01v8 L=0.15 W=0.42 nf=1 ad=0.1218 as=0.1218 pd=1.42 ps=1.42 nrd=0.69047619047619 nrs=0.69047619047619 sa=0 sb=0 sd=0 mult=1 m=1
XMRD_d04_w0_1 rbl_d04_w0 sn_d04_w0_1 rwl_des 0 sky130_fd_pr__nfet_01v8 L=0.15 W=0.42 nf=1 ad=0.1218 as=0.1218 pd=1.42 ps=1.42 nrd=0.69047619047619 nrs=0.69047619047619 sa=0 sb=0 sd=0 mult=1 m=1
csn_d04_w0_1 sn_d04_w0_1 0 {C_SN}
XMWR_d04_w0_2 sn_d04_w0_2 0 wbl_d04_w0 0 sky130_fd_pr__nfet_01v8 L=0.15 W=0.42 nf=1 ad=0.1218 as=0.1218 pd=1.42 ps=1.42 nrd=0.69047619047619 nrs=0.69047619047619 sa=0 sb=0 sd=0 mult=1 m=1
XMRD_d04_w0_2 rbl_d04_w0 sn_d04_w0_2 rwl_des 0 sky130_fd_pr__nfet_01v8 L=0.15 W=0.42 nf=1 ad=0.1218 as=0.1218 pd=1.42 ps=1.42 nrd=0.69047619047619 nrs=0.69047619047619 sa=0 sb=0 sd=0 mult=1 m=1
csn_d04_w0_2 sn_d04_w0_2 0 {C_SN}
XMWR_d04_w0_3 sn_d04_w0_3 0 wbl_d04_w0 0 sky130_fd_pr__nfet_01v8 L=0.15 W=0.42 nf=1 ad=0.1218 as=0.1218 pd=1.42 ps=1.42 nrd=0.69047619047619 nrs=0.69047619047619 sa=0 sb=0 sd=0 mult=1 m=1
XMRD_d04_w0_3 rbl_d04_w0 sn_d04_w0_3 rwl_des 0 sky130_fd_pr__nfet_01v8 L=0.15 W=0.42 nf=1 ad=0.1218 as=0.1218 pd=1.42 ps=1.42 nrd=0.69047619047619 nrs=0.69047619047619 sa=0 sb=0 sd=0 mult=1 m=1
csn_d04_w0_3 sn_d04_w0_3 0 {C_SN}
crbl_d04_w0 rbl_d04_w0 0 {C_RBL}
cwbl_d04_w0 wbl_d04_w0 0 {C_WBL}
cref_d04_w0 ref_d04_w0 0 {C_RBL}   $ ASSUMPTION: ideal matched dummy load
spr_d04_w0 pref ref_d04_w0 pca 0 swpre   $ reference-side precharge: ideal switch (#114 convention)
XMPPRE_d04_w0 rbl_d04_w0 pcb_100 prea prea sky130_fd_pr__pfet_01v8 L=0.15 W=4 nf=1 ad=1.16 as=1.16 pd=8.58 ps=8.58 nrd=0.0725 nrs=0.0725 sa=0 sb=0 sd=0 mult=1 m=1
XMPU1_d04_w0 x_d04_w0 dinb0 vdd vdd sky130_fd_pr__pfet_01v8 L=0.15 W=1 nf=1 ad=0.29 as=0.29 pd=2.58 ps=2.58 nrd=0.29 nrs=0.29 sa=0 sb=0 sd=0 mult=1 m=1
XMPU2_d04_w0 wbl_d04_w0 wenb x_d04_w0 vdd sky130_fd_pr__pfet_01v8 L=0.15 W=1 nf=1 ad=0.29 as=0.29 pd=2.58 ps=2.58 nrd=0.29 nrs=0.29 sa=0 sb=0 sd=0 mult=1 m=1
XMND2_d04_w0 wbl_d04_w0 wen y_d04_w0 0 sky130_fd_pr__nfet_01v8 L=0.15 W=2 nf=1 ad=0.58 as=0.58 pd=4.58 ps=4.58 nrd=0.145 nrs=0.145 sa=0 sb=0 sd=0 mult=1 m=1
XMND1_d04_w0 y_d04_w0 dinb0 0 0 sky130_fd_pr__nfet_01v8 L=0.15 W=2 nf=1 ad=0.58 as=0.58 pd=4.58 ps=4.58 nrd=0.145 nrs=0.145 sa=0 sb=0 sd=0 mult=1 m=1
XMNI_d04_w0 wbl_d04_w0 wenb 0 0 sky130_fd_pr__nfet_01v8 L=0.15 W=1 nf=1 ad=0.29 as=0.29 pd=2.58 ps=2.58 nrd=0.29 nrs=0.29 sa=0 sb=0 sd=0 mult=1 m=1
XMNS_d04_w0 sbl_d04_w0 sel_69500 rbl_d04_w0 0 sky130_fd_pr__nfet_01v8 L=0.15 W=1 nf=1 ad=0.29 as=0.29 pd=2.58 ps=2.58 nrd=0.29 nrs=0.29 sa=0 sb=0 sd=0 mult=1 m=1
XMPS_d04_w0 sbl_d04_w0 selb_69500 rbl_d04_w0 vdd sky130_fd_pr__pfet_01v8 L=0.15 W=2 nf=1 ad=0.58 as=0.58 pd=4.58 ps=4.58 nrd=0.145 nrs=0.145 sa=0 sb=0 sd=0 mult=1 m=1
XMNSR_d04_w0 sref_d04_w0 sel_69500 ref_d04_w0 0 sky130_fd_pr__nfet_01v8 L=0.15 W=1 nf=1 ad=0.29 as=0.29 pd=2.58 ps=2.58 nrd=0.29 nrs=0.29 sa=0 sb=0 sd=0 mult=1 m=1
XMPSR_d04_w0 sref_d04_w0 selb_69500 ref_d04_w0 vdd sky130_fd_pr__pfet_01v8 L=0.15 W=2 nf=1 ad=0.58 as=0.58 pd=4.58 ps=4.58 nrd=0.145 nrs=0.145 sa=0 sb=0 sd=0 mult=1 m=1
XMN1_d04_w0 sbl_d04_w0 sref_d04_w0 vn_d04_w0 0 sky130_fd_pr__nfet_01v8 L=0.15 W=1 nf=1 ad=0.29 as=0.29 pd=2.58 ps=2.58 nrd=0.29 nrs=0.29 sa=0 sb=0 sd=0 mult=1 m=1
XMN2_d04_w0 sref_d04_w0 sbl_d04_w0 vn_d04_w0 0 sky130_fd_pr__nfet_01v8 L=0.15 W=1 nf=1 ad=0.29 as=0.29 pd=2.58 ps=2.58 nrd=0.29 nrs=0.29 sa=0 sb=0 sd=0 mult=1 m=1
XMP1_d04_w0 sbl_d04_w0 sref_d04_w0 vp_d04_w0 vdd sky130_fd_pr__pfet_01v8 L=0.15 W=2 nf=1 ad=0.58 as=0.58 pd=4.58 ps=4.58 nrd=0.145 nrs=0.145 sa=0 sb=0 sd=0 mult=1 m=1
XMP2_d04_w0 sref_d04_w0 sbl_d04_w0 vp_d04_w0 vdd sky130_fd_pr__pfet_01v8 L=0.15 W=2 nf=1 ad=0.58 as=0.58 pd=4.58 ps=4.58 nrd=0.145 nrs=0.145 sa=0 sb=0 sd=0 mult=1 m=1
XMNF_d04_w0 vn_d04_w0 en 0 0 sky130_fd_pr__nfet_01v8 L=0.15 W=2 nf=1 ad=0.58 as=0.58 pd=4.58 ps=4.58 nrd=0.145 nrs=0.145 sa=0 sb=0 sd=0 mult=1 m=1
XMPH_d04_w0 vp_d04_w0 enb vdd vdd sky130_fd_pr__pfet_01v8 L=0.15 W=4 nf=1 ad=1.16 as=1.16 pd=8.58 ps=8.58 nrd=0.0725 nrs=0.0725 sa=0 sb=0 sd=0 mult=1 m=1
bd_d04_w0 d_d04_w0 0 v=v(sbl_d04_w0)-v(sref_d04_w0)
bdabs_d04_w0 dabs_d04_w0 0 v=abs(v(sbl_d04_w0)-v(sref_d04_w0))

* ---- instance 111: d05_w0 (MND1/MND2 4.0 + MNI 2.0) ----
XMWR_d05_w0_0 sn_d05_w0_0 wl wbl_d05_w0 0 sky130_fd_pr__nfet_01v8 L=0.15 W=0.42 nf=1 ad=0.1218 as=0.1218 pd=1.42 ps=1.42 nrd=0.69047619047619 nrs=0.69047619047619 sa=0 sb=0 sd=0 mult=1 m=1
XMRD_d05_w0_0 rbl_d05_w0 sn_d05_w0_0 rwl_sel 0 sky130_fd_pr__nfet_01v8 L=0.15 W=0.42 nf=1 ad=0.1218 as=0.1218 pd=1.42 ps=1.42 nrd=0.69047619047619 nrs=0.69047619047619 sa=0 sb=0 sd=0 mult=1 m=1
csn_d05_w0_0 sn_d05_w0_0 0 {C_SN}
XMWR_d05_w0_1 sn_d05_w0_1 0 wbl_d05_w0 0 sky130_fd_pr__nfet_01v8 L=0.15 W=0.42 nf=1 ad=0.1218 as=0.1218 pd=1.42 ps=1.42 nrd=0.69047619047619 nrs=0.69047619047619 sa=0 sb=0 sd=0 mult=1 m=1
XMRD_d05_w0_1 rbl_d05_w0 sn_d05_w0_1 rwl_des 0 sky130_fd_pr__nfet_01v8 L=0.15 W=0.42 nf=1 ad=0.1218 as=0.1218 pd=1.42 ps=1.42 nrd=0.69047619047619 nrs=0.69047619047619 sa=0 sb=0 sd=0 mult=1 m=1
csn_d05_w0_1 sn_d05_w0_1 0 {C_SN}
XMWR_d05_w0_2 sn_d05_w0_2 0 wbl_d05_w0 0 sky130_fd_pr__nfet_01v8 L=0.15 W=0.42 nf=1 ad=0.1218 as=0.1218 pd=1.42 ps=1.42 nrd=0.69047619047619 nrs=0.69047619047619 sa=0 sb=0 sd=0 mult=1 m=1
XMRD_d05_w0_2 rbl_d05_w0 sn_d05_w0_2 rwl_des 0 sky130_fd_pr__nfet_01v8 L=0.15 W=0.42 nf=1 ad=0.1218 as=0.1218 pd=1.42 ps=1.42 nrd=0.69047619047619 nrs=0.69047619047619 sa=0 sb=0 sd=0 mult=1 m=1
csn_d05_w0_2 sn_d05_w0_2 0 {C_SN}
XMWR_d05_w0_3 sn_d05_w0_3 0 wbl_d05_w0 0 sky130_fd_pr__nfet_01v8 L=0.15 W=0.42 nf=1 ad=0.1218 as=0.1218 pd=1.42 ps=1.42 nrd=0.69047619047619 nrs=0.69047619047619 sa=0 sb=0 sd=0 mult=1 m=1
XMRD_d05_w0_3 rbl_d05_w0 sn_d05_w0_3 rwl_des 0 sky130_fd_pr__nfet_01v8 L=0.15 W=0.42 nf=1 ad=0.1218 as=0.1218 pd=1.42 ps=1.42 nrd=0.69047619047619 nrs=0.69047619047619 sa=0 sb=0 sd=0 mult=1 m=1
csn_d05_w0_3 sn_d05_w0_3 0 {C_SN}
crbl_d05_w0 rbl_d05_w0 0 {C_RBL}
cwbl_d05_w0 wbl_d05_w0 0 {C_WBL}
cref_d05_w0 ref_d05_w0 0 {C_RBL}   $ ASSUMPTION: ideal matched dummy load
spr_d05_w0 pref ref_d05_w0 pca 0 swpre   $ reference-side precharge: ideal switch (#114 convention)
XMPPRE_d05_w0 rbl_d05_w0 pcb_100 prea prea sky130_fd_pr__pfet_01v8 L=0.15 W=4 nf=1 ad=1.16 as=1.16 pd=8.58 ps=8.58 nrd=0.0725 nrs=0.0725 sa=0 sb=0 sd=0 mult=1 m=1
XMPU1_d05_w0 x_d05_w0 dinb0 vdd vdd sky130_fd_pr__pfet_01v8 L=0.15 W=1 nf=1 ad=0.29 as=0.29 pd=2.58 ps=2.58 nrd=0.29 nrs=0.29 sa=0 sb=0 sd=0 mult=1 m=1
XMPU2_d05_w0 wbl_d05_w0 wenb x_d05_w0 vdd sky130_fd_pr__pfet_01v8 L=0.15 W=1 nf=1 ad=0.29 as=0.29 pd=2.58 ps=2.58 nrd=0.29 nrs=0.29 sa=0 sb=0 sd=0 mult=1 m=1
XMND2_d05_w0 wbl_d05_w0 wen y_d05_w0 0 sky130_fd_pr__nfet_01v8 L=0.15 W=4 nf=1 ad=1.16 as=1.16 pd=8.58 ps=8.58 nrd=0.0725 nrs=0.0725 sa=0 sb=0 sd=0 mult=1 m=1
XMND1_d05_w0 y_d05_w0 dinb0 0 0 sky130_fd_pr__nfet_01v8 L=0.15 W=4 nf=1 ad=1.16 as=1.16 pd=8.58 ps=8.58 nrd=0.0725 nrs=0.0725 sa=0 sb=0 sd=0 mult=1 m=1
XMNI_d05_w0 wbl_d05_w0 wenb 0 0 sky130_fd_pr__nfet_01v8 L=0.15 W=2 nf=1 ad=0.58 as=0.58 pd=4.58 ps=4.58 nrd=0.145 nrs=0.145 sa=0 sb=0 sd=0 mult=1 m=1
XMNS_d05_w0 sbl_d05_w0 sel_69500 rbl_d05_w0 0 sky130_fd_pr__nfet_01v8 L=0.15 W=1 nf=1 ad=0.29 as=0.29 pd=2.58 ps=2.58 nrd=0.29 nrs=0.29 sa=0 sb=0 sd=0 mult=1 m=1
XMPS_d05_w0 sbl_d05_w0 selb_69500 rbl_d05_w0 vdd sky130_fd_pr__pfet_01v8 L=0.15 W=2 nf=1 ad=0.58 as=0.58 pd=4.58 ps=4.58 nrd=0.145 nrs=0.145 sa=0 sb=0 sd=0 mult=1 m=1
XMNSR_d05_w0 sref_d05_w0 sel_69500 ref_d05_w0 0 sky130_fd_pr__nfet_01v8 L=0.15 W=1 nf=1 ad=0.29 as=0.29 pd=2.58 ps=2.58 nrd=0.29 nrs=0.29 sa=0 sb=0 sd=0 mult=1 m=1
XMPSR_d05_w0 sref_d05_w0 selb_69500 ref_d05_w0 vdd sky130_fd_pr__pfet_01v8 L=0.15 W=2 nf=1 ad=0.58 as=0.58 pd=4.58 ps=4.58 nrd=0.145 nrs=0.145 sa=0 sb=0 sd=0 mult=1 m=1
XMN1_d05_w0 sbl_d05_w0 sref_d05_w0 vn_d05_w0 0 sky130_fd_pr__nfet_01v8 L=0.15 W=1 nf=1 ad=0.29 as=0.29 pd=2.58 ps=2.58 nrd=0.29 nrs=0.29 sa=0 sb=0 sd=0 mult=1 m=1
XMN2_d05_w0 sref_d05_w0 sbl_d05_w0 vn_d05_w0 0 sky130_fd_pr__nfet_01v8 L=0.15 W=1 nf=1 ad=0.29 as=0.29 pd=2.58 ps=2.58 nrd=0.29 nrs=0.29 sa=0 sb=0 sd=0 mult=1 m=1
XMP1_d05_w0 sbl_d05_w0 sref_d05_w0 vp_d05_w0 vdd sky130_fd_pr__pfet_01v8 L=0.15 W=2 nf=1 ad=0.58 as=0.58 pd=4.58 ps=4.58 nrd=0.145 nrs=0.145 sa=0 sb=0 sd=0 mult=1 m=1
XMP2_d05_w0 sref_d05_w0 sbl_d05_w0 vp_d05_w0 vdd sky130_fd_pr__pfet_01v8 L=0.15 W=2 nf=1 ad=0.58 as=0.58 pd=4.58 ps=4.58 nrd=0.145 nrs=0.145 sa=0 sb=0 sd=0 mult=1 m=1
XMNF_d05_w0 vn_d05_w0 en 0 0 sky130_fd_pr__nfet_01v8 L=0.15 W=2 nf=1 ad=0.58 as=0.58 pd=4.58 ps=4.58 nrd=0.145 nrs=0.145 sa=0 sb=0 sd=0 mult=1 m=1
XMPH_d05_w0 vp_d05_w0 enb vdd vdd sky130_fd_pr__pfet_01v8 L=0.15 W=4 nf=1 ad=1.16 as=1.16 pd=8.58 ps=8.58 nrd=0.0725 nrs=0.0725 sa=0 sb=0 sd=0 mult=1 m=1
bd_d05_w0 d_d05_w0 0 v=v(sbl_d05_w0)-v(sref_d05_w0)
bdabs_d05_w0 dabs_d05_w0 0 v=abs(v(sbl_d05_w0)-v(sref_d05_w0))

* ---- instance 112: d06_w0 (MND1/MND2 8.0 + MNI 4.0) ----
XMWR_d06_w0_0 sn_d06_w0_0 wl wbl_d06_w0 0 sky130_fd_pr__nfet_01v8 L=0.15 W=0.42 nf=1 ad=0.1218 as=0.1218 pd=1.42 ps=1.42 nrd=0.69047619047619 nrs=0.69047619047619 sa=0 sb=0 sd=0 mult=1 m=1
XMRD_d06_w0_0 rbl_d06_w0 sn_d06_w0_0 rwl_sel 0 sky130_fd_pr__nfet_01v8 L=0.15 W=0.42 nf=1 ad=0.1218 as=0.1218 pd=1.42 ps=1.42 nrd=0.69047619047619 nrs=0.69047619047619 sa=0 sb=0 sd=0 mult=1 m=1
csn_d06_w0_0 sn_d06_w0_0 0 {C_SN}
XMWR_d06_w0_1 sn_d06_w0_1 0 wbl_d06_w0 0 sky130_fd_pr__nfet_01v8 L=0.15 W=0.42 nf=1 ad=0.1218 as=0.1218 pd=1.42 ps=1.42 nrd=0.69047619047619 nrs=0.69047619047619 sa=0 sb=0 sd=0 mult=1 m=1
XMRD_d06_w0_1 rbl_d06_w0 sn_d06_w0_1 rwl_des 0 sky130_fd_pr__nfet_01v8 L=0.15 W=0.42 nf=1 ad=0.1218 as=0.1218 pd=1.42 ps=1.42 nrd=0.69047619047619 nrs=0.69047619047619 sa=0 sb=0 sd=0 mult=1 m=1
csn_d06_w0_1 sn_d06_w0_1 0 {C_SN}
XMWR_d06_w0_2 sn_d06_w0_2 0 wbl_d06_w0 0 sky130_fd_pr__nfet_01v8 L=0.15 W=0.42 nf=1 ad=0.1218 as=0.1218 pd=1.42 ps=1.42 nrd=0.69047619047619 nrs=0.69047619047619 sa=0 sb=0 sd=0 mult=1 m=1
XMRD_d06_w0_2 rbl_d06_w0 sn_d06_w0_2 rwl_des 0 sky130_fd_pr__nfet_01v8 L=0.15 W=0.42 nf=1 ad=0.1218 as=0.1218 pd=1.42 ps=1.42 nrd=0.69047619047619 nrs=0.69047619047619 sa=0 sb=0 sd=0 mult=1 m=1
csn_d06_w0_2 sn_d06_w0_2 0 {C_SN}
XMWR_d06_w0_3 sn_d06_w0_3 0 wbl_d06_w0 0 sky130_fd_pr__nfet_01v8 L=0.15 W=0.42 nf=1 ad=0.1218 as=0.1218 pd=1.42 ps=1.42 nrd=0.69047619047619 nrs=0.69047619047619 sa=0 sb=0 sd=0 mult=1 m=1
XMRD_d06_w0_3 rbl_d06_w0 sn_d06_w0_3 rwl_des 0 sky130_fd_pr__nfet_01v8 L=0.15 W=0.42 nf=1 ad=0.1218 as=0.1218 pd=1.42 ps=1.42 nrd=0.69047619047619 nrs=0.69047619047619 sa=0 sb=0 sd=0 mult=1 m=1
csn_d06_w0_3 sn_d06_w0_3 0 {C_SN}
crbl_d06_w0 rbl_d06_w0 0 {C_RBL}
cwbl_d06_w0 wbl_d06_w0 0 {C_WBL}
cref_d06_w0 ref_d06_w0 0 {C_RBL}   $ ASSUMPTION: ideal matched dummy load
spr_d06_w0 pref ref_d06_w0 pca 0 swpre   $ reference-side precharge: ideal switch (#114 convention)
XMPPRE_d06_w0 rbl_d06_w0 pcb_100 prea prea sky130_fd_pr__pfet_01v8 L=0.15 W=4 nf=1 ad=1.16 as=1.16 pd=8.58 ps=8.58 nrd=0.0725 nrs=0.0725 sa=0 sb=0 sd=0 mult=1 m=1
XMPU1_d06_w0 x_d06_w0 dinb0 vdd vdd sky130_fd_pr__pfet_01v8 L=0.15 W=1 nf=1 ad=0.29 as=0.29 pd=2.58 ps=2.58 nrd=0.29 nrs=0.29 sa=0 sb=0 sd=0 mult=1 m=1
XMPU2_d06_w0 wbl_d06_w0 wenb x_d06_w0 vdd sky130_fd_pr__pfet_01v8 L=0.15 W=1 nf=1 ad=0.29 as=0.29 pd=2.58 ps=2.58 nrd=0.29 nrs=0.29 sa=0 sb=0 sd=0 mult=1 m=1
XMND2_d06_w0 wbl_d06_w0 wen y_d06_w0 0 sky130_fd_pr__nfet_01v8 L=0.15 W=8 nf=1 ad=2.32 as=2.32 pd=16.58 ps=16.58 nrd=0.03625 nrs=0.03625 sa=0 sb=0 sd=0 mult=1 m=1
XMND1_d06_w0 y_d06_w0 dinb0 0 0 sky130_fd_pr__nfet_01v8 L=0.15 W=8 nf=1 ad=2.32 as=2.32 pd=16.58 ps=16.58 nrd=0.03625 nrs=0.03625 sa=0 sb=0 sd=0 mult=1 m=1
XMNI_d06_w0 wbl_d06_w0 wenb 0 0 sky130_fd_pr__nfet_01v8 L=0.15 W=4 nf=1 ad=1.16 as=1.16 pd=8.58 ps=8.58 nrd=0.0725 nrs=0.0725 sa=0 sb=0 sd=0 mult=1 m=1
XMNS_d06_w0 sbl_d06_w0 sel_69500 rbl_d06_w0 0 sky130_fd_pr__nfet_01v8 L=0.15 W=1 nf=1 ad=0.29 as=0.29 pd=2.58 ps=2.58 nrd=0.29 nrs=0.29 sa=0 sb=0 sd=0 mult=1 m=1
XMPS_d06_w0 sbl_d06_w0 selb_69500 rbl_d06_w0 vdd sky130_fd_pr__pfet_01v8 L=0.15 W=2 nf=1 ad=0.58 as=0.58 pd=4.58 ps=4.58 nrd=0.145 nrs=0.145 sa=0 sb=0 sd=0 mult=1 m=1
XMNSR_d06_w0 sref_d06_w0 sel_69500 ref_d06_w0 0 sky130_fd_pr__nfet_01v8 L=0.15 W=1 nf=1 ad=0.29 as=0.29 pd=2.58 ps=2.58 nrd=0.29 nrs=0.29 sa=0 sb=0 sd=0 mult=1 m=1
XMPSR_d06_w0 sref_d06_w0 selb_69500 ref_d06_w0 vdd sky130_fd_pr__pfet_01v8 L=0.15 W=2 nf=1 ad=0.58 as=0.58 pd=4.58 ps=4.58 nrd=0.145 nrs=0.145 sa=0 sb=0 sd=0 mult=1 m=1
XMN1_d06_w0 sbl_d06_w0 sref_d06_w0 vn_d06_w0 0 sky130_fd_pr__nfet_01v8 L=0.15 W=1 nf=1 ad=0.29 as=0.29 pd=2.58 ps=2.58 nrd=0.29 nrs=0.29 sa=0 sb=0 sd=0 mult=1 m=1
XMN2_d06_w0 sref_d06_w0 sbl_d06_w0 vn_d06_w0 0 sky130_fd_pr__nfet_01v8 L=0.15 W=1 nf=1 ad=0.29 as=0.29 pd=2.58 ps=2.58 nrd=0.29 nrs=0.29 sa=0 sb=0 sd=0 mult=1 m=1
XMP1_d06_w0 sbl_d06_w0 sref_d06_w0 vp_d06_w0 vdd sky130_fd_pr__pfet_01v8 L=0.15 W=2 nf=1 ad=0.58 as=0.58 pd=4.58 ps=4.58 nrd=0.145 nrs=0.145 sa=0 sb=0 sd=0 mult=1 m=1
XMP2_d06_w0 sref_d06_w0 sbl_d06_w0 vp_d06_w0 vdd sky130_fd_pr__pfet_01v8 L=0.15 W=2 nf=1 ad=0.58 as=0.58 pd=4.58 ps=4.58 nrd=0.145 nrs=0.145 sa=0 sb=0 sd=0 mult=1 m=1
XMNF_d06_w0 vn_d06_w0 en 0 0 sky130_fd_pr__nfet_01v8 L=0.15 W=2 nf=1 ad=0.58 as=0.58 pd=4.58 ps=4.58 nrd=0.145 nrs=0.145 sa=0 sb=0 sd=0 mult=1 m=1
XMPH_d06_w0 vp_d06_w0 enb vdd vdd sky130_fd_pr__pfet_01v8 L=0.15 W=4 nf=1 ad=1.16 as=1.16 pd=8.58 ps=8.58 nrd=0.0725 nrs=0.0725 sa=0 sb=0 sd=0 mult=1 m=1
bd_d06_w0 d_d06_w0 0 v=v(sbl_d06_w0)-v(sref_d06_w0)
bdabs_d06_w0 dabs_d06_w0 0 v=abs(v(sbl_d06_w0)-v(sref_d06_w0))

* ---- instance 113: d07_w0 (MND1/MND2 4.0 + MNI 0.42 (idle clamp unchanged)) ----
XMWR_d07_w0_0 sn_d07_w0_0 wl wbl_d07_w0 0 sky130_fd_pr__nfet_01v8 L=0.15 W=0.42 nf=1 ad=0.1218 as=0.1218 pd=1.42 ps=1.42 nrd=0.69047619047619 nrs=0.69047619047619 sa=0 sb=0 sd=0 mult=1 m=1
XMRD_d07_w0_0 rbl_d07_w0 sn_d07_w0_0 rwl_sel 0 sky130_fd_pr__nfet_01v8 L=0.15 W=0.42 nf=1 ad=0.1218 as=0.1218 pd=1.42 ps=1.42 nrd=0.69047619047619 nrs=0.69047619047619 sa=0 sb=0 sd=0 mult=1 m=1
csn_d07_w0_0 sn_d07_w0_0 0 {C_SN}
XMWR_d07_w0_1 sn_d07_w0_1 0 wbl_d07_w0 0 sky130_fd_pr__nfet_01v8 L=0.15 W=0.42 nf=1 ad=0.1218 as=0.1218 pd=1.42 ps=1.42 nrd=0.69047619047619 nrs=0.69047619047619 sa=0 sb=0 sd=0 mult=1 m=1
XMRD_d07_w0_1 rbl_d07_w0 sn_d07_w0_1 rwl_des 0 sky130_fd_pr__nfet_01v8 L=0.15 W=0.42 nf=1 ad=0.1218 as=0.1218 pd=1.42 ps=1.42 nrd=0.69047619047619 nrs=0.69047619047619 sa=0 sb=0 sd=0 mult=1 m=1
csn_d07_w0_1 sn_d07_w0_1 0 {C_SN}
XMWR_d07_w0_2 sn_d07_w0_2 0 wbl_d07_w0 0 sky130_fd_pr__nfet_01v8 L=0.15 W=0.42 nf=1 ad=0.1218 as=0.1218 pd=1.42 ps=1.42 nrd=0.69047619047619 nrs=0.69047619047619 sa=0 sb=0 sd=0 mult=1 m=1
XMRD_d07_w0_2 rbl_d07_w0 sn_d07_w0_2 rwl_des 0 sky130_fd_pr__nfet_01v8 L=0.15 W=0.42 nf=1 ad=0.1218 as=0.1218 pd=1.42 ps=1.42 nrd=0.69047619047619 nrs=0.69047619047619 sa=0 sb=0 sd=0 mult=1 m=1
csn_d07_w0_2 sn_d07_w0_2 0 {C_SN}
XMWR_d07_w0_3 sn_d07_w0_3 0 wbl_d07_w0 0 sky130_fd_pr__nfet_01v8 L=0.15 W=0.42 nf=1 ad=0.1218 as=0.1218 pd=1.42 ps=1.42 nrd=0.69047619047619 nrs=0.69047619047619 sa=0 sb=0 sd=0 mult=1 m=1
XMRD_d07_w0_3 rbl_d07_w0 sn_d07_w0_3 rwl_des 0 sky130_fd_pr__nfet_01v8 L=0.15 W=0.42 nf=1 ad=0.1218 as=0.1218 pd=1.42 ps=1.42 nrd=0.69047619047619 nrs=0.69047619047619 sa=0 sb=0 sd=0 mult=1 m=1
csn_d07_w0_3 sn_d07_w0_3 0 {C_SN}
crbl_d07_w0 rbl_d07_w0 0 {C_RBL}
cwbl_d07_w0 wbl_d07_w0 0 {C_WBL}
cref_d07_w0 ref_d07_w0 0 {C_RBL}   $ ASSUMPTION: ideal matched dummy load
spr_d07_w0 pref ref_d07_w0 pca 0 swpre   $ reference-side precharge: ideal switch (#114 convention)
XMPPRE_d07_w0 rbl_d07_w0 pcb_100 prea prea sky130_fd_pr__pfet_01v8 L=0.15 W=4 nf=1 ad=1.16 as=1.16 pd=8.58 ps=8.58 nrd=0.0725 nrs=0.0725 sa=0 sb=0 sd=0 mult=1 m=1
XMPU1_d07_w0 x_d07_w0 dinb0 vdd vdd sky130_fd_pr__pfet_01v8 L=0.15 W=1 nf=1 ad=0.29 as=0.29 pd=2.58 ps=2.58 nrd=0.29 nrs=0.29 sa=0 sb=0 sd=0 mult=1 m=1
XMPU2_d07_w0 wbl_d07_w0 wenb x_d07_w0 vdd sky130_fd_pr__pfet_01v8 L=0.15 W=1 nf=1 ad=0.29 as=0.29 pd=2.58 ps=2.58 nrd=0.29 nrs=0.29 sa=0 sb=0 sd=0 mult=1 m=1
XMND2_d07_w0 wbl_d07_w0 wen y_d07_w0 0 sky130_fd_pr__nfet_01v8 L=0.15 W=4 nf=1 ad=1.16 as=1.16 pd=8.58 ps=8.58 nrd=0.0725 nrs=0.0725 sa=0 sb=0 sd=0 mult=1 m=1
XMND1_d07_w0 y_d07_w0 dinb0 0 0 sky130_fd_pr__nfet_01v8 L=0.15 W=4 nf=1 ad=1.16 as=1.16 pd=8.58 ps=8.58 nrd=0.0725 nrs=0.0725 sa=0 sb=0 sd=0 mult=1 m=1
XMNI_d07_w0 wbl_d07_w0 wenb 0 0 sky130_fd_pr__nfet_01v8 L=0.15 W=0.42 nf=1 ad=0.1218 as=0.1218 pd=1.42 ps=1.42 nrd=0.69047619047619 nrs=0.69047619047619 sa=0 sb=0 sd=0 mult=1 m=1
XMNS_d07_w0 sbl_d07_w0 sel_69500 rbl_d07_w0 0 sky130_fd_pr__nfet_01v8 L=0.15 W=1 nf=1 ad=0.29 as=0.29 pd=2.58 ps=2.58 nrd=0.29 nrs=0.29 sa=0 sb=0 sd=0 mult=1 m=1
XMPS_d07_w0 sbl_d07_w0 selb_69500 rbl_d07_w0 vdd sky130_fd_pr__pfet_01v8 L=0.15 W=2 nf=1 ad=0.58 as=0.58 pd=4.58 ps=4.58 nrd=0.145 nrs=0.145 sa=0 sb=0 sd=0 mult=1 m=1
XMNSR_d07_w0 sref_d07_w0 sel_69500 ref_d07_w0 0 sky130_fd_pr__nfet_01v8 L=0.15 W=1 nf=1 ad=0.29 as=0.29 pd=2.58 ps=2.58 nrd=0.29 nrs=0.29 sa=0 sb=0 sd=0 mult=1 m=1
XMPSR_d07_w0 sref_d07_w0 selb_69500 ref_d07_w0 vdd sky130_fd_pr__pfet_01v8 L=0.15 W=2 nf=1 ad=0.58 as=0.58 pd=4.58 ps=4.58 nrd=0.145 nrs=0.145 sa=0 sb=0 sd=0 mult=1 m=1
XMN1_d07_w0 sbl_d07_w0 sref_d07_w0 vn_d07_w0 0 sky130_fd_pr__nfet_01v8 L=0.15 W=1 nf=1 ad=0.29 as=0.29 pd=2.58 ps=2.58 nrd=0.29 nrs=0.29 sa=0 sb=0 sd=0 mult=1 m=1
XMN2_d07_w0 sref_d07_w0 sbl_d07_w0 vn_d07_w0 0 sky130_fd_pr__nfet_01v8 L=0.15 W=1 nf=1 ad=0.29 as=0.29 pd=2.58 ps=2.58 nrd=0.29 nrs=0.29 sa=0 sb=0 sd=0 mult=1 m=1
XMP1_d07_w0 sbl_d07_w0 sref_d07_w0 vp_d07_w0 vdd sky130_fd_pr__pfet_01v8 L=0.15 W=2 nf=1 ad=0.58 as=0.58 pd=4.58 ps=4.58 nrd=0.145 nrs=0.145 sa=0 sb=0 sd=0 mult=1 m=1
XMP2_d07_w0 sref_d07_w0 sbl_d07_w0 vp_d07_w0 vdd sky130_fd_pr__pfet_01v8 L=0.15 W=2 nf=1 ad=0.58 as=0.58 pd=4.58 ps=4.58 nrd=0.145 nrs=0.145 sa=0 sb=0 sd=0 mult=1 m=1
XMNF_d07_w0 vn_d07_w0 en 0 0 sky130_fd_pr__nfet_01v8 L=0.15 W=2 nf=1 ad=0.58 as=0.58 pd=4.58 ps=4.58 nrd=0.145 nrs=0.145 sa=0 sb=0 sd=0 mult=1 m=1
XMPH_d07_w0 vp_d07_w0 enb vdd vdd sky130_fd_pr__pfet_01v8 L=0.15 W=4 nf=1 ad=1.16 as=1.16 pd=8.58 ps=8.58 nrd=0.0725 nrs=0.0725 sa=0 sb=0 sd=0 mult=1 m=1
bd_d07_w0 d_d07_w0 0 v=v(sbl_d07_w0)-v(sref_d07_w0)
bdabs_d07_w0 dabs_d07_w0 0 v=abs(v(sbl_d07_w0)-v(sref_d07_w0))

* ---- instance 114: cp_f00 (capacitance probe, no array load) ----
icp_cp_f00 rbl_cp_f00 0 dc 1e-07
XMPPRE_cp_f00 rbl_cp_f00 vdd prea prea sky130_fd_pr__pfet_01v8 L=0.15 W=5 nf=1 ad=1.45 as=1.45 pd=10.58 ps=10.58 nrd=0.058 nrs=0.058 sa=0 sb=0 sd=0 mult=1 m=1
XMNS_cp_f00 sbl_cp_f00 vdd rbl_cp_f00 0 sky130_fd_pr__nfet_01v8 L=0.15 W=0.42 nf=1 ad=0.1218 as=0.1218 pd=1.42 ps=1.42 nrd=0.69047619047619 nrs=0.69047619047619 sa=0 sb=0 sd=0 mult=1 m=1

* ---- instance 115: cp_f03 (capacitance probe, no array load) ----
icp_cp_f03 rbl_cp_f03 0 dc 1e-07
XMPPRE_cp_f03 rbl_cp_f03 vdd prea prea sky130_fd_pr__pfet_01v8 L=0.15 W=6 nf=1 ad=1.74 as=1.74 pd=12.58 ps=12.58 nrd=0.048333333333333 nrs=0.048333333333333 sa=0 sb=0 sd=0 mult=1 m=1
XMNS_cp_f03 sbl_cp_f03 vdd rbl_cp_f03 0 sky130_fd_pr__nfet_01v8 L=0.15 W=0.42 nf=1 ad=0.1218 as=0.1218 pd=1.42 ps=1.42 nrd=0.69047619047619 nrs=0.69047619047619 sa=0 sb=0 sd=0 mult=1 m=1

* ---- instance 116: cp_f01 (capacitance probe, no array load) ----
icp_cp_f01 rbl_cp_f01 0 dc 1e-07
XMPPRE_cp_f01 rbl_cp_f01 vdd prea prea sky130_fd_pr__pfet_01v8 L=0.15 W=4 nf=1 ad=1.16 as=1.16 pd=8.58 ps=8.58 nrd=0.0725 nrs=0.0725 sa=0 sb=0 sd=0 mult=1 m=1
XMNS_cp_f01 sbl_cp_f01 vdd rbl_cp_f01 0 sky130_fd_pr__nfet_01v8 L=0.15 W=0.42 nf=1 ad=0.1218 as=0.1218 pd=1.42 ps=1.42 nrd=0.69047619047619 nrs=0.69047619047619 sa=0 sb=0 sd=0 mult=1 m=1

* ---- instance 117: cp_c04 (capacitance probe, no array load) ----
icp_cp_c04 rbl_cp_c04 0 dc 1e-07
XMPPRE_cp_c04 rbl_cp_c04 vdd prea prea sky130_fd_pr__pfet_01v8 L=0.15 W=4 nf=1 ad=1.16 as=1.16 pd=8.58 ps=8.58 nrd=0.0725 nrs=0.0725 sa=0 sb=0 sd=0 mult=1 m=1
XMNS_cp_c04 sbl_cp_c04 vdd rbl_cp_c04 0 sky130_fd_pr__nfet_01v8 L=0.15 W=0.42 nf=1 ad=0.1218 as=0.1218 pd=1.42 ps=1.42 nrd=0.69047619047619 nrs=0.69047619047619 sa=0 sb=0 sd=0 mult=1 m=1

* ---- instance 118: cp_c03 (capacitance probe, no array load) ----
icp_cp_c03 rbl_cp_c03 0 dc 1e-07
XMPPRE_cp_c03 rbl_cp_c03 vdd prea prea sky130_fd_pr__pfet_01v8 L=0.15 W=4 nf=1 ad=1.16 as=1.16 pd=8.58 ps=8.58 nrd=0.0725 nrs=0.0725 sa=0 sb=0 sd=0 mult=1 m=1
XMNS_cp_c03 sbl_cp_c03 vdd rbl_cp_c03 0 sky130_fd_pr__nfet_01v8 L=0.15 W=0.42 nf=1 ad=0.1218 as=0.1218 pd=1.42 ps=1.42 nrd=0.69047619047619 nrs=0.69047619047619 sa=0 sb=0 sd=0 mult=1 m=1
XMPDUM_cp_c03 rbl_cp_c03 vdd rbl_cp_c03 prea sky130_fd_pr__pfet_01v8 L=0.15 W=2 nf=1 ad=0.58 as=0.58 pd=4.58 ps=4.58 nrd=0.145 nrs=0.145 sa=0 sb=0 sd=0 mult=1 m=1

* ---- instance 119: cp_c05 (capacitance probe, no array load) ----
icp_cp_c05 rbl_cp_c05 0 dc 1e-07
XMPPRE_cp_c05 rbl_cp_c05 vdd prea prea sky130_fd_pr__pfet_01v8 L=0.15 W=3 nf=1 ad=0.87 as=0.87 pd=6.58 ps=6.58 nrd=0.096666666666667 nrs=0.096666666666667 sa=0 sb=0 sd=0 mult=1 m=1
XMNS_cp_c05 sbl_cp_c05 vdd rbl_cp_c05 0 sky130_fd_pr__nfet_01v8 L=0.15 W=0.42 nf=1 ad=0.1218 as=0.1218 pd=1.42 ps=1.42 nrd=0.69047619047619 nrs=0.69047619047619 sa=0 sb=0 sd=0 mult=1 m=1

* ---- instance 120: cp_i00 (capacitance probe, no array load) ----
icp_cp_i00 rbl_cp_i00 0 dc 1e-07
XMPPRE_cp_i00 rbl_cp_i00 vdd prea prea sky130_fd_pr__pfet_01v8 L=0.15 W=4 nf=1 ad=1.16 as=1.16 pd=8.58 ps=8.58 nrd=0.0725 nrs=0.0725 sa=0 sb=0 sd=0 mult=1 m=1
XMNS_cp_i00 sbl_cp_i00 vdd rbl_cp_i00 0 sky130_fd_pr__nfet_01v8 L=0.15 W=1 nf=1 ad=0.29 as=0.29 pd=2.58 ps=2.58 nrd=0.29 nrs=0.29 sa=0 sb=0 sd=0 mult=1 m=1
XMPS_cp_i00 sbl_cp_i00 0 rbl_cp_i00 vdd sky130_fd_pr__pfet_01v8 L=0.15 W=2 nf=1 ad=0.58 as=0.58 pd=4.58 ps=4.58 nrd=0.145 nrs=0.145 sa=0 sb=0 sd=0 mult=1 m=1

* ---- instance 121: cp_i04 (capacitance probe, no array load) ----
icp_cp_i04 rbl_cp_i04 0 dc 1e-07
XMPPRE_cp_i04 rbl_cp_i04 vdd prea prea sky130_fd_pr__pfet_01v8 L=0.15 W=4 nf=1 ad=1.16 as=1.16 pd=8.58 ps=8.58 nrd=0.0725 nrs=0.0725 sa=0 sb=0 sd=0 mult=1 m=1
XMNS_cp_i04 sbl_cp_i04 vdd rbl_cp_i04 0 sky130_fd_pr__nfet_01v8 L=0.15 W=0.5 nf=1 ad=0.145 as=0.145 pd=1.58 ps=1.58 nrd=0.58 nrs=0.58 sa=0 sb=0 sd=0 mult=1 m=1
XMPS_cp_i04 sbl_cp_i04 0 rbl_cp_i04 vdd sky130_fd_pr__pfet_01v8 L=0.15 W=1 nf=1 ad=0.29 as=0.29 pd=2.58 ps=2.58 nrd=0.29 nrs=0.29 sa=0 sb=0 sd=0 mult=1 m=1

* ---- instance 122: cp_i05 (capacitance probe, no array load) ----
icp_cp_i05 rbl_cp_i05 0 dc 1e-07
XMPPRE_cp_i05 rbl_cp_i05 vdd prea prea sky130_fd_pr__pfet_01v8 L=0.15 W=4 nf=1 ad=1.16 as=1.16 pd=8.58 ps=8.58 nrd=0.0725 nrs=0.0725 sa=0 sb=0 sd=0 mult=1 m=1
XMNS_cp_i05 sbl_cp_i05 vdd rbl_cp_i05 0 sky130_fd_pr__nfet_01v8 L=0.15 W=0.42 nf=1 ad=0.1218 as=0.1218 pd=1.42 ps=1.42 nrd=0.69047619047619 nrs=0.69047619047619 sa=0 sb=0 sd=0 mult=1 m=1
XMPS_cp_i05 sbl_cp_i05 0 rbl_cp_i05 vdd sky130_fd_pr__pfet_01v8 L=0.15 W=0.42 nf=1 ad=0.1218 as=0.1218 pd=1.42 ps=1.42 nrd=0.69047619047619 nrs=0.69047619047619 sa=0 sb=0 sd=0 mult=1 m=1

* ---- instance 123: cp_i06 (capacitance probe, no array load) ----
icp_cp_i06 rbl_cp_i06 0 dc 1e-07
XMPPRE_cp_i06 rbl_cp_i06 vdd prea prea sky130_fd_pr__pfet_01v8 L=0.15 W=4 nf=1 ad=1.16 as=1.16 pd=8.58 ps=8.58 nrd=0.0725 nrs=0.0725 sa=0 sb=0 sd=0 mult=1 m=1
XMNS_cp_i06 sbl_cp_i06 vdd rbl_cp_i06 0 sky130_fd_pr__nfet_01v8 L=0.15 W=0.42 nf=1 ad=0.1218 as=0.1218 pd=1.42 ps=1.42 nrd=0.69047619047619 nrs=0.69047619047619 sa=0 sb=0 sd=0 mult=1 m=1
XMPS_cp_i06 sbl_cp_i06 0 rbl_cp_i06 vdd sky130_fd_pr__pfet_01v8 L=0.15 W=0.84 nf=1 ad=0.2436 as=0.2436 pd=2.26 ps=2.26 nrd=0.3452380952381 nrs=0.3452380952381 sa=0 sb=0 sd=0 mult=1 m=1

* ---- instance 124: cp_i07 (capacitance probe, no array load) ----
icp_cp_i07 rbl_cp_i07 0 dc 1e-07
XMPPRE_cp_i07 rbl_cp_i07 vdd prea prea sky130_fd_pr__pfet_01v8 L=0.15 W=4 nf=1 ad=1.16 as=1.16 pd=8.58 ps=8.58 nrd=0.0725 nrs=0.0725 sa=0 sb=0 sd=0 mult=1 m=1
XMNS_cp_i07 sbl_cp_i07 vdd rbl_cp_i07 0 sky130_fd_pr__nfet_01v8 L=0.15 W=2 nf=1 ad=0.58 as=0.58 pd=4.58 ps=4.58 nrd=0.145 nrs=0.145 sa=0 sb=0 sd=0 mult=1 m=1
XMPS_cp_i07 sbl_cp_i07 0 rbl_cp_i07 vdd sky130_fd_pr__pfet_01v8 L=0.15 W=4 nf=1 ad=1.16 as=1.16 pd=8.58 ps=8.58 nrd=0.0725 nrs=0.0725 sa=0 sb=0 sd=0 mult=1 m=1

* ---- instance 125: cp_i08 (capacitance probe, no array load) ----
icp_cp_i08 rbl_cp_i08 0 dc 1e-07
XMPPRE_cp_i08 rbl_cp_i08 vdd prea prea sky130_fd_pr__pfet_01v8 L=0.15 W=4 nf=1 ad=1.16 as=1.16 pd=8.58 ps=8.58 nrd=0.0725 nrs=0.0725 sa=0 sb=0 sd=0 mult=1 m=1
XMNS_cp_i08 sbl_cp_i08 vdd rbl_cp_i08 0 sky130_fd_pr__nfet_01v8 L=0.15 W=1 nf=1 ad=0.29 as=0.29 pd=2.58 ps=2.58 nrd=0.29 nrs=0.29 sa=0 sb=0 sd=0 mult=1 m=1

* ---- instance 126: cp_i09 (capacitance probe, no array load) ----
icp_cp_i09 rbl_cp_i09 0 dc 1e-07
XMPPRE_cp_i09 rbl_cp_i09 vdd prea prea sky130_fd_pr__pfet_01v8 L=0.15 W=4 nf=1 ad=1.16 as=1.16 pd=8.58 ps=8.58 nrd=0.0725 nrs=0.0725 sa=0 sb=0 sd=0 mult=1 m=1
XMNS_cp_i09 sbl_cp_i09 vdd rbl_cp_i09 0 sky130_fd_pr__nfet_01v8 L=0.15 W=0.42 nf=1 ad=0.1218 as=0.1218 pd=1.42 ps=1.42 nrd=0.69047619047619 nrs=0.69047619047619 sa=0 sb=0 sd=0 mult=1 m=1

* ---- instance 127: cp_i10 (capacitance probe, no array load) ----
icp_cp_i10 rbl_cp_i10 0 dc 1e-07
XMPPRE_cp_i10 rbl_cp_i10 vdd prea prea sky130_fd_pr__pfet_01v8 L=0.15 W=4 nf=1 ad=1.16 as=1.16 pd=8.58 ps=8.58 nrd=0.0725 nrs=0.0725 sa=0 sb=0 sd=0 mult=1 m=1
XMPS_cp_i10 sbl_cp_i10 0 rbl_cp_i10 vdd sky130_fd_pr__pfet_01v8 L=0.15 W=1 nf=1 ad=0.29 as=0.29 pd=2.58 ps=2.58 nrd=0.29 nrs=0.29 sa=0 sb=0 sd=0 mult=1 m=1

* ---- instance 128: cp_i11 (capacitance probe, no array load) ----
icp_cp_i11 rbl_cp_i11 0 dc 1e-07
XMPPRE_cp_i11 rbl_cp_i11 vdd prea prea sky130_fd_pr__pfet_01v8 L=0.15 W=4 nf=1 ad=1.16 as=1.16 pd=8.58 ps=8.58 nrd=0.0725 nrs=0.0725 sa=0 sb=0 sd=0 mult=1 m=1
XMPS_cp_i11 sbl_cp_i11 0 rbl_cp_i11 vdd sky130_fd_pr__pfet_01v8 L=0.15 W=0.5 nf=1 ad=0.145 as=0.145 pd=1.58 ps=1.58 nrd=0.58 nrs=0.58 sa=0 sb=0 sd=0 mult=1 m=1

* ---- instance 129: cp_i15 (capacitance probe, no array load) ----
icp_cp_i15 rbl_cp_i15 0 dc 1e-07
XMPPRE_cp_i15 rbl_cp_i15 vdd prea prea sky130_fd_pr__pfet_01v8 L=0.15 W=4 nf=1 ad=1.16 as=1.16 pd=8.58 ps=8.58 nrd=0.0725 nrs=0.0725 sa=0 sb=0 sd=0 mult=1 m=1
XMNS_cp_i15 sbl_cp_i15 vdd rbl_cp_i15 0 sky130_fd_pr__nfet_01v8 L=0.15 W=0.42 nf=1 ad=0.1218 as=0.1218 pd=1.42 ps=1.42 nrd=0.69047619047619 nrs=0.69047619047619 sa=0 sb=0 sd=0 mult=1 m=1
XMPS_cp_i15 sbl_cp_i15 0 rbl_cp_i15 vdd sky130_fd_pr__pfet_01v8 L=0.15 W=0.84 nf=1 ad=0.2436 as=0.2436 pd=2.26 ps=2.26 nrd=0.3452380952381 nrs=0.3452380952381 sa=0 sb=0 sd=0 mult=1 m=1
csb_cp_i15 sbl_cp_i15 0 5e-15

* ---- instance 130: cp_p02 (capacitance probe, no array load) ----
icp_cp_p02 rbl_cp_p02 0 dc 1e-07
XMPPRE_cp_p02 rbl_cp_p02 vdd prea prea sky130_fd_pr__pfet_01v8 L=0.15 W=2 nf=1 ad=0.58 as=0.58 pd=4.58 ps=4.58 nrd=0.145 nrs=0.145 sa=0 sb=0 sd=0 mult=1 m=1
XMNS_cp_p02 sbl_cp_p02 vdd rbl_cp_p02 0 sky130_fd_pr__nfet_01v8 L=0.15 W=1 nf=1 ad=0.29 as=0.29 pd=2.58 ps=2.58 nrd=0.29 nrs=0.29 sa=0 sb=0 sd=0 mult=1 m=1
XMPS_cp_p02 sbl_cp_p02 0 rbl_cp_p02 vdd sky130_fd_pr__pfet_01v8 L=0.15 W=2 nf=1 ad=0.58 as=0.58 pd=4.58 ps=4.58 nrd=0.145 nrs=0.145 sa=0 sb=0 sd=0 mult=1 m=1

* ---- instance 131: cp_p03 (capacitance probe, no array load) ----
icp_cp_p03 rbl_cp_p03 0 dc 1e-07
XMPPRE_cp_p03 rbl_cp_p03 vdd prea prea sky130_fd_pr__pfet_01v8 L=0.15 W=1 nf=1 ad=0.29 as=0.29 pd=2.58 ps=2.58 nrd=0.29 nrs=0.29 sa=0 sb=0 sd=0 mult=1 m=1
XMNS_cp_p03 sbl_cp_p03 vdd rbl_cp_p03 0 sky130_fd_pr__nfet_01v8 L=0.15 W=1 nf=1 ad=0.29 as=0.29 pd=2.58 ps=2.58 nrd=0.29 nrs=0.29 sa=0 sb=0 sd=0 mult=1 m=1
XMPS_cp_p03 sbl_cp_p03 0 rbl_cp_p03 vdd sky130_fd_pr__pfet_01v8 L=0.15 W=2 nf=1 ad=0.58 as=0.58 pd=4.58 ps=4.58 nrd=0.145 nrs=0.145 sa=0 sb=0 sd=0 mult=1 m=1

* ---- instance 132: cp_p04 (capacitance probe, no array load) ----
icp_cp_p04 rbl_cp_p04 0 dc 1e-07
XMPPRE_cp_p04 rbl_cp_p04 vdd prea prea sky130_fd_pr__pfet_01v8 L=0.15 W=4 nf=1 ad=1.16 as=1.16 pd=8.58 ps=8.58 nrd=0.0725 nrs=0.0725 sa=0 sb=0 sd=0 mult=1 m=1
XMNS_cp_p04 sbl_cp_p04 vdd rbl_cp_p04 0 sky130_fd_pr__nfet_01v8 L=0.15 W=1 nf=1 ad=0.29 as=0.29 pd=2.58 ps=2.58 nrd=0.29 nrs=0.29 sa=0 sb=0 sd=0 mult=1 m=1
XMPS_cp_p04 sbl_cp_p04 0 rbl_cp_p04 vdd sky130_fd_pr__pfet_01v8 L=0.15 W=2 nf=1 ad=0.58 as=0.58 pd=4.58 ps=4.58 nrd=0.145 nrs=0.145 sa=0 sb=0 sd=0 mult=1 m=1
XMPDUM_cp_p04 rbl_cp_p04 vdd rbl_cp_p04 prea sky130_fd_pr__pfet_01v8 L=0.15 W=2 nf=1 ad=0.58 as=0.58 pd=4.58 ps=4.58 nrd=0.145 nrs=0.145 sa=0 sb=0 sd=0 mult=1 m=1

* initial conditions (tran uic): rbl fully discharged, stored levels, tail nodes
.ic v(sn_ideal_w1_0)=0 v(sn_ideal_w1_1)=1 v(sn_ideal_w1_2)=1 v(sn_ideal_w1_3)=1 v(rbl_ideal_w1)=0 v(ref_ideal_w1)=0.8
.ic v(wbl_ideal_w1)=0 v(vn_ideal_w1)=0.45 v(vp_ideal_w1)=1.35 v(sn_ideal_w0_0)=1 v(sn_ideal_w0_1)=0 v(sn_ideal_w0_2)=0
.ic v(sn_ideal_w0_3)=0 v(rbl_ideal_w0)=0 v(ref_ideal_w0)=0.8 v(wbl_ideal_w0)=0 v(vn_ideal_w0)=0.45 v(vp_ideal_w0)=1.35
.ic v(sn_i00_w1_0)=0 v(sn_i00_w1_1)=1 v(sn_i00_w1_2)=1 v(sn_i00_w1_3)=1 v(rbl_i00_w1)=0 v(ref_i00_w1)=0.8
.ic v(wbl_i00_w1)=0 v(sbl_i00_w1)=0 v(sref_i00_w1)=0.8 v(vn_i00_w1)=0.45 v(vp_i00_w1)=1.35 v(sn_i00_w0_0)=1
.ic v(sn_i00_w0_1)=0 v(sn_i00_w0_2)=0 v(sn_i00_w0_3)=0 v(rbl_i00_w0)=0 v(ref_i00_w0)=0.8 v(wbl_i00_w0)=0
.ic v(sbl_i00_w0)=0 v(sref_i00_w0)=0.8 v(vn_i00_w0)=0.45 v(vp_i00_w0)=1.35 v(sn_i01_w1_0)=0 v(sn_i01_w1_1)=1
.ic v(sn_i01_w1_2)=1 v(sn_i01_w1_3)=1 v(rbl_i01_w1)=0 v(ref_i01_w1)=0.8 v(wbl_i01_w1)=0 v(sbl_i01_w1)=0
.ic v(sref_i01_w1)=0.8 v(vn_i01_w1)=0.45 v(vp_i01_w1)=1.35 v(sn_i01_w0_0)=1 v(sn_i01_w0_1)=0 v(sn_i01_w0_2)=0
.ic v(sn_i01_w0_3)=0 v(rbl_i01_w0)=0 v(ref_i01_w0)=0.8 v(wbl_i01_w0)=0 v(sbl_i01_w0)=0 v(sref_i01_w0)=0.8
.ic v(vn_i01_w0)=0.45 v(vp_i01_w0)=1.35 v(sn_i02_w1_0)=0 v(sn_i02_w1_1)=1 v(sn_i02_w1_2)=1 v(sn_i02_w1_3)=1
.ic v(rbl_i02_w1)=0 v(ref_i02_w1)=0.8 v(wbl_i02_w1)=0 v(sbl_i02_w1)=0 v(sref_i02_w1)=0.8 v(vn_i02_w1)=0.45
.ic v(vp_i02_w1)=1.35 v(sn_i02_w0_0)=1 v(sn_i02_w0_1)=0 v(sn_i02_w0_2)=0 v(sn_i02_w0_3)=0 v(rbl_i02_w0)=0
.ic v(ref_i02_w0)=0.8 v(wbl_i02_w0)=0 v(sbl_i02_w0)=0 v(sref_i02_w0)=0.8 v(vn_i02_w0)=0.45 v(vp_i02_w0)=1.35
.ic v(sn_i03_w1_0)=0 v(sn_i03_w1_1)=1 v(sn_i03_w1_2)=1 v(sn_i03_w1_3)=1 v(rbl_i03_w1)=0 v(ref_i03_w1)=0.8
.ic v(wbl_i03_w1)=0 v(sbl_i03_w1)=0 v(sref_i03_w1)=0.8 v(vn_i03_w1)=0.45 v(vp_i03_w1)=1.35 v(sn_i03_w0_0)=1
.ic v(sn_i03_w0_1)=0 v(sn_i03_w0_2)=0 v(sn_i03_w0_3)=0 v(rbl_i03_w0)=0 v(ref_i03_w0)=0.8 v(wbl_i03_w0)=0
.ic v(sbl_i03_w0)=0 v(sref_i03_w0)=0.8 v(vn_i03_w0)=0.45 v(vp_i03_w0)=1.35 v(sn_i04_w1_0)=0 v(sn_i04_w1_1)=1
.ic v(sn_i04_w1_2)=1 v(sn_i04_w1_3)=1 v(rbl_i04_w1)=0 v(ref_i04_w1)=0.8 v(wbl_i04_w1)=0 v(sbl_i04_w1)=0
.ic v(sref_i04_w1)=0.8 v(vn_i04_w1)=0.45 v(vp_i04_w1)=1.35 v(sn_i04_w0_0)=1 v(sn_i04_w0_1)=0 v(sn_i04_w0_2)=0
.ic v(sn_i04_w0_3)=0 v(rbl_i04_w0)=0 v(ref_i04_w0)=0.8 v(wbl_i04_w0)=0 v(sbl_i04_w0)=0 v(sref_i04_w0)=0.8
.ic v(vn_i04_w0)=0.45 v(vp_i04_w0)=1.35 v(sn_i05_w1_0)=0 v(sn_i05_w1_1)=1 v(sn_i05_w1_2)=1 v(sn_i05_w1_3)=1
.ic v(rbl_i05_w1)=0 v(ref_i05_w1)=0.8 v(wbl_i05_w1)=0 v(sbl_i05_w1)=0 v(sref_i05_w1)=0.8 v(vn_i05_w1)=0.45
.ic v(vp_i05_w1)=1.35 v(sn_i05_w0_0)=1 v(sn_i05_w0_1)=0 v(sn_i05_w0_2)=0 v(sn_i05_w0_3)=0 v(rbl_i05_w0)=0
.ic v(ref_i05_w0)=0.8 v(wbl_i05_w0)=0 v(sbl_i05_w0)=0 v(sref_i05_w0)=0.8 v(vn_i05_w0)=0.45 v(vp_i05_w0)=1.35
.ic v(sn_i06_w1_0)=0 v(sn_i06_w1_1)=1 v(sn_i06_w1_2)=1 v(sn_i06_w1_3)=1 v(rbl_i06_w1)=0 v(ref_i06_w1)=0.8
.ic v(wbl_i06_w1)=0 v(sbl_i06_w1)=0 v(sref_i06_w1)=0.8 v(vn_i06_w1)=0.45 v(vp_i06_w1)=1.35 v(sn_i06_w0_0)=1
.ic v(sn_i06_w0_1)=0 v(sn_i06_w0_2)=0 v(sn_i06_w0_3)=0 v(rbl_i06_w0)=0 v(ref_i06_w0)=0.8 v(wbl_i06_w0)=0
.ic v(sbl_i06_w0)=0 v(sref_i06_w0)=0.8 v(vn_i06_w0)=0.45 v(vp_i06_w0)=1.35 v(sn_i07_w1_0)=0 v(sn_i07_w1_1)=1
.ic v(sn_i07_w1_2)=1 v(sn_i07_w1_3)=1 v(rbl_i07_w1)=0 v(ref_i07_w1)=0.8 v(wbl_i07_w1)=0 v(sbl_i07_w1)=0
.ic v(sref_i07_w1)=0.8 v(vn_i07_w1)=0.45 v(vp_i07_w1)=1.35 v(sn_i07_w0_0)=1 v(sn_i07_w0_1)=0 v(sn_i07_w0_2)=0
.ic v(sn_i07_w0_3)=0 v(rbl_i07_w0)=0 v(ref_i07_w0)=0.8 v(wbl_i07_w0)=0 v(sbl_i07_w0)=0 v(sref_i07_w0)=0.8
.ic v(vn_i07_w0)=0.45 v(vp_i07_w0)=1.35 v(sn_i08_w1_0)=0 v(sn_i08_w1_1)=1 v(sn_i08_w1_2)=1 v(sn_i08_w1_3)=1
.ic v(rbl_i08_w1)=0 v(ref_i08_w1)=0.8 v(wbl_i08_w1)=0 v(sbl_i08_w1)=0 v(sref_i08_w1)=0.8 v(vn_i08_w1)=0.45
.ic v(vp_i08_w1)=1.35 v(sn_i08_w0_0)=1 v(sn_i08_w0_1)=0 v(sn_i08_w0_2)=0 v(sn_i08_w0_3)=0 v(rbl_i08_w0)=0
.ic v(ref_i08_w0)=0.8 v(wbl_i08_w0)=0 v(sbl_i08_w0)=0 v(sref_i08_w0)=0.8 v(vn_i08_w0)=0.45 v(vp_i08_w0)=1.35
.ic v(sn_i09_w1_0)=0 v(sn_i09_w1_1)=1 v(sn_i09_w1_2)=1 v(sn_i09_w1_3)=1 v(rbl_i09_w1)=0 v(ref_i09_w1)=0.8
.ic v(wbl_i09_w1)=0 v(sbl_i09_w1)=0 v(sref_i09_w1)=0.8 v(vn_i09_w1)=0.45 v(vp_i09_w1)=1.35 v(sn_i09_w0_0)=1
.ic v(sn_i09_w0_1)=0 v(sn_i09_w0_2)=0 v(sn_i09_w0_3)=0 v(rbl_i09_w0)=0 v(ref_i09_w0)=0.8 v(wbl_i09_w0)=0
.ic v(sbl_i09_w0)=0 v(sref_i09_w0)=0.8 v(vn_i09_w0)=0.45 v(vp_i09_w0)=1.35 v(sn_i10_w1_0)=0 v(sn_i10_w1_1)=1
.ic v(sn_i10_w1_2)=1 v(sn_i10_w1_3)=1 v(rbl_i10_w1)=0 v(ref_i10_w1)=0.8 v(wbl_i10_w1)=0 v(sbl_i10_w1)=0
.ic v(sref_i10_w1)=0.8 v(vn_i10_w1)=0.45 v(vp_i10_w1)=1.35 v(sn_i10_w0_0)=1 v(sn_i10_w0_1)=0 v(sn_i10_w0_2)=0
.ic v(sn_i10_w0_3)=0 v(rbl_i10_w0)=0 v(ref_i10_w0)=0.8 v(wbl_i10_w0)=0 v(sbl_i10_w0)=0 v(sref_i10_w0)=0.8
.ic v(vn_i10_w0)=0.45 v(vp_i10_w0)=1.35 v(sn_i11_w1_0)=0 v(sn_i11_w1_1)=1 v(sn_i11_w1_2)=1 v(sn_i11_w1_3)=1
.ic v(rbl_i11_w1)=0 v(ref_i11_w1)=0.8 v(wbl_i11_w1)=0 v(sbl_i11_w1)=0 v(sref_i11_w1)=0.8 v(vn_i11_w1)=0.45
.ic v(vp_i11_w1)=1.35 v(sn_i11_w0_0)=1 v(sn_i11_w0_1)=0 v(sn_i11_w0_2)=0 v(sn_i11_w0_3)=0 v(rbl_i11_w0)=0
.ic v(ref_i11_w0)=0.8 v(wbl_i11_w0)=0 v(sbl_i11_w0)=0 v(sref_i11_w0)=0.8 v(vn_i11_w0)=0.45 v(vp_i11_w0)=1.35
.ic v(sn_i12_w1_0)=0 v(sn_i12_w1_1)=1 v(sn_i12_w1_2)=1 v(sn_i12_w1_3)=1 v(rbl_i12_w1)=0 v(ref_i12_w1)=0.8
.ic v(wbl_i12_w1)=0 v(sbl_i12_w1)=0 v(sref_i12_w1)=0.8 v(vn_i12_w1)=0.45 v(vp_i12_w1)=1.35 v(sn_i12_w0_0)=1
.ic v(sn_i12_w0_1)=0 v(sn_i12_w0_2)=0 v(sn_i12_w0_3)=0 v(rbl_i12_w0)=0 v(ref_i12_w0)=0.8 v(wbl_i12_w0)=0
.ic v(sbl_i12_w0)=0 v(sref_i12_w0)=0.8 v(vn_i12_w0)=0.45 v(vp_i12_w0)=1.35 v(sn_i13_w1_0)=0 v(sn_i13_w1_1)=1
.ic v(sn_i13_w1_2)=1 v(sn_i13_w1_3)=1 v(rbl_i13_w1)=0 v(ref_i13_w1)=0.8 v(wbl_i13_w1)=0 v(sbl_i13_w1)=0
.ic v(sref_i13_w1)=0.8 v(vn_i13_w1)=0.45 v(vp_i13_w1)=1.35 v(sn_i13_w0_0)=1 v(sn_i13_w0_1)=0 v(sn_i13_w0_2)=0
.ic v(sn_i13_w0_3)=0 v(rbl_i13_w0)=0 v(ref_i13_w0)=0.8 v(wbl_i13_w0)=0 v(sbl_i13_w0)=0 v(sref_i13_w0)=0.8
.ic v(vn_i13_w0)=0.45 v(vp_i13_w0)=1.35 v(sn_i14_w1_0)=0 v(sn_i14_w1_1)=1 v(sn_i14_w1_2)=1 v(sn_i14_w1_3)=1
.ic v(rbl_i14_w1)=0 v(ref_i14_w1)=0.8 v(wbl_i14_w1)=0 v(sbl_i14_w1)=0 v(sref_i14_w1)=0.8 v(vn_i14_w1)=0.45
.ic v(vp_i14_w1)=1.35 v(sn_i14_w0_0)=1 v(sn_i14_w0_1)=0 v(sn_i14_w0_2)=0 v(sn_i14_w0_3)=0 v(rbl_i14_w0)=0
.ic v(ref_i14_w0)=0.8 v(wbl_i14_w0)=0 v(sbl_i14_w0)=0 v(sref_i14_w0)=0.8 v(vn_i14_w0)=0.45 v(vp_i14_w0)=1.35
.ic v(sn_i15_w1_0)=0 v(sn_i15_w1_1)=1 v(sn_i15_w1_2)=1 v(sn_i15_w1_3)=1 v(rbl_i15_w1)=0 v(ref_i15_w1)=0.8
.ic v(wbl_i15_w1)=0 v(sbl_i15_w1)=0 v(sref_i15_w1)=0.8 v(vn_i15_w1)=0.45 v(vp_i15_w1)=1.35 v(sn_i15_w0_0)=1
.ic v(sn_i15_w0_1)=0 v(sn_i15_w0_2)=0 v(sn_i15_w0_3)=0 v(rbl_i15_w0)=0 v(ref_i15_w0)=0.8 v(wbl_i15_w0)=0
.ic v(sbl_i15_w0)=0 v(sref_i15_w0)=0.8 v(vn_i15_w0)=0.45 v(vp_i15_w0)=1.35 v(sn_m00_w1_0)=0 v(sn_m00_w1_1)=1
.ic v(sn_m00_w1_2)=1 v(sn_m00_w1_3)=1 v(rbl_m00_w1)=0 v(ref_m00_w1)=0.8 v(wbl_m00_w1)=0 v(sbl_m00_w1)=0
.ic v(sref_m00_w1)=0.8 v(vn_m00_w1)=0.45 v(vp_m00_w1)=1.35 v(sn_m00_w0_0)=1 v(sn_m00_w0_1)=0 v(sn_m00_w0_2)=0
.ic v(sn_m00_w0_3)=0 v(rbl_m00_w0)=0 v(ref_m00_w0)=0.8 v(wbl_m00_w0)=0 v(sbl_m00_w0)=0 v(sref_m00_w0)=0.8
.ic v(vn_m00_w0)=0.45 v(vp_m00_w0)=1.35 v(sn_m01_w1_0)=0 v(sn_m01_w1_1)=1 v(sn_m01_w1_2)=1 v(sn_m01_w1_3)=1
.ic v(rbl_m01_w1)=0 v(ref_m01_w1)=0.8 v(wbl_m01_w1)=0 v(sbl_m01_w1)=0 v(sref_m01_w1)=0.8 v(vn_m01_w1)=0.45
.ic v(vp_m01_w1)=1.35 v(sn_m01_w0_0)=1 v(sn_m01_w0_1)=0 v(sn_m01_w0_2)=0 v(sn_m01_w0_3)=0 v(rbl_m01_w0)=0
.ic v(ref_m01_w0)=0.8 v(wbl_m01_w0)=0 v(sbl_m01_w0)=0 v(sref_m01_w0)=0.8 v(vn_m01_w0)=0.45 v(vp_m01_w0)=1.35
.ic v(sn_m02_w1_0)=0 v(sn_m02_w1_1)=1 v(sn_m02_w1_2)=1 v(sn_m02_w1_3)=1 v(rbl_m02_w1)=0 v(ref_m02_w1)=0.8
.ic v(wbl_m02_w1)=0 v(sbl_m02_w1)=0 v(sref_m02_w1)=0.8 v(vn_m02_w1)=0.45 v(vp_m02_w1)=1.35 v(sn_m02_w0_0)=1
.ic v(sn_m02_w0_1)=0 v(sn_m02_w0_2)=0 v(sn_m02_w0_3)=0 v(rbl_m02_w0)=0 v(ref_m02_w0)=0.8 v(wbl_m02_w0)=0
.ic v(sbl_m02_w0)=0 v(sref_m02_w0)=0.8 v(vn_m02_w0)=0.45 v(vp_m02_w0)=1.35 v(sn_m03_w1_0)=0 v(sn_m03_w1_1)=1
.ic v(sn_m03_w1_2)=1 v(sn_m03_w1_3)=1 v(rbl_m03_w1)=0 v(ref_m03_w1)=0.8 v(wbl_m03_w1)=0 v(sbl_m03_w1)=0
.ic v(sref_m03_w1)=0.8 v(vn_m03_w1)=0.45 v(vp_m03_w1)=1.35 v(sn_m03_w0_0)=1 v(sn_m03_w0_1)=0 v(sn_m03_w0_2)=0
.ic v(sn_m03_w0_3)=0 v(rbl_m03_w0)=0 v(ref_m03_w0)=0.8 v(wbl_m03_w0)=0 v(sbl_m03_w0)=0 v(sref_m03_w0)=0.8
.ic v(vn_m03_w0)=0.45 v(vp_m03_w0)=1.35 v(sn_m04_w1_0)=0 v(sn_m04_w1_1)=1 v(sn_m04_w1_2)=1 v(sn_m04_w1_3)=1
.ic v(rbl_m04_w1)=0 v(ref_m04_w1)=0.8 v(wbl_m04_w1)=0 v(sbl_m04_w1)=0 v(sref_m04_w1)=0.8 v(vn_m04_w1)=0.45
.ic v(vp_m04_w1)=1.35 v(sn_m04_w0_0)=1 v(sn_m04_w0_1)=0 v(sn_m04_w0_2)=0 v(sn_m04_w0_3)=0 v(rbl_m04_w0)=0
.ic v(ref_m04_w0)=0.8 v(wbl_m04_w0)=0 v(sbl_m04_w0)=0 v(sref_m04_w0)=0.8 v(vn_m04_w0)=0.45 v(vp_m04_w0)=1.35
.ic v(sn_m05_w1_0)=0 v(sn_m05_w1_1)=1 v(sn_m05_w1_2)=1 v(sn_m05_w1_3)=1 v(rbl_m05_w1)=0 v(ref_m05_w1)=0.8
.ic v(wbl_m05_w1)=0 v(sbl_m05_w1)=0 v(sref_m05_w1)=0.8 v(vn_m05_w1)=0.45 v(vp_m05_w1)=1.35 v(sn_m05_w0_0)=1
.ic v(sn_m05_w0_1)=0 v(sn_m05_w0_2)=0 v(sn_m05_w0_3)=0 v(rbl_m05_w0)=0 v(ref_m05_w0)=0.8 v(wbl_m05_w0)=0
.ic v(sbl_m05_w0)=0 v(sref_m05_w0)=0.8 v(vn_m05_w0)=0.45 v(vp_m05_w0)=1.35 v(sn_m06_w1_0)=0 v(sn_m06_w1_1)=1
.ic v(sn_m06_w1_2)=1 v(sn_m06_w1_3)=1 v(rbl_m06_w1)=0 v(ref_m06_w1)=0.8 v(wbl_m06_w1)=0 v(sbl_m06_w1)=0
.ic v(sref_m06_w1)=0.8 v(vn_m06_w1)=0.45 v(vp_m06_w1)=1.35 v(sn_m06_w0_0)=1 v(sn_m06_w0_1)=0 v(sn_m06_w0_2)=0
.ic v(sn_m06_w0_3)=0 v(rbl_m06_w0)=0 v(ref_m06_w0)=0.8 v(wbl_m06_w0)=0 v(sbl_m06_w0)=0 v(sref_m06_w0)=0.8
.ic v(vn_m06_w0)=0.45 v(vp_m06_w0)=1.35 v(sn_m07_w1_0)=0 v(sn_m07_w1_1)=1 v(sn_m07_w1_2)=1 v(sn_m07_w1_3)=1
.ic v(rbl_m07_w1)=0 v(ref_m07_w1)=0.8 v(wbl_m07_w1)=0 v(sbl_m07_w1)=0 v(sref_m07_w1)=0.8 v(vn_m07_w1)=0.45
.ic v(vp_m07_w1)=1.35 v(sn_m07_w0_0)=1 v(sn_m07_w0_1)=0 v(sn_m07_w0_2)=0 v(sn_m07_w0_3)=0 v(rbl_m07_w0)=0
.ic v(ref_m07_w0)=0.8 v(wbl_m07_w0)=0 v(sbl_m07_w0)=0 v(sref_m07_w0)=0.8 v(vn_m07_w0)=0.45 v(vp_m07_w0)=1.35
.ic v(sn_m08_w1_0)=0 v(sn_m08_w1_1)=1 v(sn_m08_w1_2)=1 v(sn_m08_w1_3)=1 v(rbl_m08_w1)=0 v(ref_m08_w1)=0.8
.ic v(wbl_m08_w1)=0 v(sbl_m08_w1)=0 v(sref_m08_w1)=0.8 v(vn_m08_w1)=0.45 v(vp_m08_w1)=1.35 v(sn_m08_w0_0)=1
.ic v(sn_m08_w0_1)=0 v(sn_m08_w0_2)=0 v(sn_m08_w0_3)=0 v(rbl_m08_w0)=0 v(ref_m08_w0)=0.8 v(wbl_m08_w0)=0
.ic v(sbl_m08_w0)=0 v(sref_m08_w0)=0.8 v(vn_m08_w0)=0.45 v(vp_m08_w0)=1.35 v(sn_m09_w1_0)=0 v(sn_m09_w1_1)=1
.ic v(sn_m09_w1_2)=1 v(sn_m09_w1_3)=1 v(rbl_m09_w1)=0 v(ref_m09_w1)=0.8 v(wbl_m09_w1)=0 v(sbl_m09_w1)=0
.ic v(sref_m09_w1)=0.8 v(vn_m09_w1)=0.45 v(vp_m09_w1)=1.35 v(sn_m09_w0_0)=1 v(sn_m09_w0_1)=0 v(sn_m09_w0_2)=0
.ic v(sn_m09_w0_3)=0 v(rbl_m09_w0)=0 v(ref_m09_w0)=0.8 v(wbl_m09_w0)=0 v(sbl_m09_w0)=0 v(sref_m09_w0)=0.8
.ic v(vn_m09_w0)=0.45 v(vp_m09_w0)=1.35 v(sn_m10_w1_0)=0 v(sn_m10_w1_1)=1 v(sn_m10_w1_2)=1 v(sn_m10_w1_3)=1
.ic v(rbl_m10_w1)=0 v(ref_m10_w1)=0.8 v(wbl_m10_w1)=0 v(sbl_m10_w1)=0 v(sref_m10_w1)=0.8 v(vn_m10_w1)=0.45
.ic v(vp_m10_w1)=1.35 v(sn_m10_w0_0)=1 v(sn_m10_w0_1)=0 v(sn_m10_w0_2)=0 v(sn_m10_w0_3)=0 v(rbl_m10_w0)=0
.ic v(ref_m10_w0)=0.8 v(wbl_m10_w0)=0 v(sbl_m10_w0)=0 v(sref_m10_w0)=0.8 v(vn_m10_w0)=0.45 v(vp_m10_w0)=1.35
.ic v(sn_m11_w1_0)=0 v(sn_m11_w1_1)=1 v(sn_m11_w1_2)=1 v(sn_m11_w1_3)=1 v(rbl_m11_w1)=0 v(ref_m11_w1)=0.8
.ic v(wbl_m11_w1)=0 v(sbl_m11_w1)=0 v(sref_m11_w1)=0.8 v(vn_m11_w1)=0.45 v(vp_m11_w1)=1.35 v(sn_m11_w0_0)=1
.ic v(sn_m11_w0_1)=0 v(sn_m11_w0_2)=0 v(sn_m11_w0_3)=0 v(rbl_m11_w0)=0 v(ref_m11_w0)=0.8 v(wbl_m11_w0)=0
.ic v(sbl_m11_w0)=0 v(sref_m11_w0)=0.8 v(vn_m11_w0)=0.45 v(vp_m11_w0)=1.35 v(sn_m12_w1_0)=0 v(sn_m12_w1_1)=1
.ic v(sn_m12_w1_2)=1 v(sn_m12_w1_3)=1 v(rbl_m12_w1)=0 v(ref_m12_w1)=0.8 v(wbl_m12_w1)=0 v(sbl_m12_w1)=0
.ic v(sref_m12_w1)=0.8 v(vn_m12_w1)=0.45 v(vp_m12_w1)=1.35 v(sn_m12_w0_0)=1 v(sn_m12_w0_1)=0 v(sn_m12_w0_2)=0
.ic v(sn_m12_w0_3)=0 v(rbl_m12_w0)=0 v(ref_m12_w0)=0.8 v(wbl_m12_w0)=0 v(sbl_m12_w0)=0 v(sref_m12_w0)=0.8
.ic v(vn_m12_w0)=0.45 v(vp_m12_w0)=1.35 v(sn_m13_w1_0)=0 v(sn_m13_w1_1)=1 v(sn_m13_w1_2)=1 v(sn_m13_w1_3)=1
.ic v(rbl_m13_w1)=0 v(ref_m13_w1)=0.8 v(wbl_m13_w1)=0 v(sbl_m13_w1)=0 v(sref_m13_w1)=0.8 v(vn_m13_w1)=0.45
.ic v(vp_m13_w1)=1.35 v(sn_m13_w0_0)=1 v(sn_m13_w0_1)=0 v(sn_m13_w0_2)=0 v(sn_m13_w0_3)=0 v(rbl_m13_w0)=0
.ic v(ref_m13_w0)=0.8 v(wbl_m13_w0)=0 v(sbl_m13_w0)=0 v(sref_m13_w0)=0.8 v(vn_m13_w0)=0.45 v(vp_m13_w0)=1.35
.ic v(sn_m14_w1_0)=0 v(sn_m14_w1_1)=1 v(sn_m14_w1_2)=1 v(sn_m14_w1_3)=1 v(rbl_m14_w1)=0 v(ref_m14_w1)=0.8
.ic v(wbl_m14_w1)=0 v(sbl_m14_w1)=0 v(sref_m14_w1)=0.8 v(vn_m14_w1)=0.45 v(vp_m14_w1)=1.35 v(sn_m14_w0_0)=1
.ic v(sn_m14_w0_1)=0 v(sn_m14_w0_2)=0 v(sn_m14_w0_3)=0 v(rbl_m14_w0)=0 v(ref_m14_w0)=0.8 v(wbl_m14_w0)=0
.ic v(sbl_m14_w0)=0 v(sref_m14_w0)=0.8 v(vn_m14_w0)=0.45 v(vp_m14_w0)=1.35 v(sn_m15_w1_0)=0 v(sn_m15_w1_1)=1
.ic v(sn_m15_w1_2)=1 v(sn_m15_w1_3)=1 v(rbl_m15_w1)=0 v(ref_m15_w1)=0.8 v(wbl_m15_w1)=0 v(sbl_m15_w1)=0
.ic v(sref_m15_w1)=0.8 v(vn_m15_w1)=0.45 v(vp_m15_w1)=1.35 v(sn_m15_w0_0)=1 v(sn_m15_w0_1)=0 v(sn_m15_w0_2)=0
.ic v(sn_m15_w0_3)=0 v(rbl_m15_w0)=0 v(ref_m15_w0)=0.8 v(wbl_m15_w0)=0 v(sbl_m15_w0)=0 v(sref_m15_w0)=0.8
.ic v(vn_m15_w0)=0.45 v(vp_m15_w0)=1.35 v(sn_p00_w1_0)=0 v(sn_p00_w1_1)=1 v(sn_p00_w1_2)=1 v(sn_p00_w1_3)=1
.ic v(rbl_p00_w1)=0 v(ref_p00_w1)=0.8 v(wbl_p00_w1)=0 v(sbl_p00_w1)=0 v(sref_p00_w1)=0.8 v(vn_p00_w1)=0.45
.ic v(vp_p00_w1)=1.35 v(sn_p00_w0_0)=1 v(sn_p00_w0_1)=0 v(sn_p00_w0_2)=0 v(sn_p00_w0_3)=0 v(rbl_p00_w0)=0
.ic v(ref_p00_w0)=0.8 v(wbl_p00_w0)=0 v(sbl_p00_w0)=0 v(sref_p00_w0)=0.8 v(vn_p00_w0)=0.45 v(vp_p00_w0)=1.35
.ic v(sn_p01_w1_0)=0 v(sn_p01_w1_1)=1 v(sn_p01_w1_2)=1 v(sn_p01_w1_3)=1 v(rbl_p01_w1)=0 v(ref_p01_w1)=0.8
.ic v(wbl_p01_w1)=0 v(sbl_p01_w1)=0 v(sref_p01_w1)=0.8 v(vn_p01_w1)=0.45 v(vp_p01_w1)=1.35 v(sn_p01_w0_0)=1
.ic v(sn_p01_w0_1)=0 v(sn_p01_w0_2)=0 v(sn_p01_w0_3)=0 v(rbl_p01_w0)=0 v(ref_p01_w0)=0.8 v(wbl_p01_w0)=0
.ic v(sbl_p01_w0)=0 v(sref_p01_w0)=0.8 v(vn_p01_w0)=0.45 v(vp_p01_w0)=1.35 v(sn_p02_w1_0)=0 v(sn_p02_w1_1)=1
.ic v(sn_p02_w1_2)=1 v(sn_p02_w1_3)=1 v(rbl_p02_w1)=0 v(ref_p02_w1)=0.8 v(wbl_p02_w1)=0 v(sbl_p02_w1)=0
.ic v(sref_p02_w1)=0.8 v(vn_p02_w1)=0.45 v(vp_p02_w1)=1.35 v(sn_p02_w0_0)=1 v(sn_p02_w0_1)=0 v(sn_p02_w0_2)=0
.ic v(sn_p02_w0_3)=0 v(rbl_p02_w0)=0 v(ref_p02_w0)=0.8 v(wbl_p02_w0)=0 v(sbl_p02_w0)=0 v(sref_p02_w0)=0.8
.ic v(vn_p02_w0)=0.45 v(vp_p02_w0)=1.35 v(sn_p03_w1_0)=0 v(sn_p03_w1_1)=1 v(sn_p03_w1_2)=1 v(sn_p03_w1_3)=1
.ic v(rbl_p03_w1)=0 v(ref_p03_w1)=0.8 v(wbl_p03_w1)=0 v(sbl_p03_w1)=0 v(sref_p03_w1)=0.8 v(vn_p03_w1)=0.45
.ic v(vp_p03_w1)=1.35 v(sn_p03_w0_0)=1 v(sn_p03_w0_1)=0 v(sn_p03_w0_2)=0 v(sn_p03_w0_3)=0 v(rbl_p03_w0)=0
.ic v(ref_p03_w0)=0.8 v(wbl_p03_w0)=0 v(sbl_p03_w0)=0 v(sref_p03_w0)=0.8 v(vn_p03_w0)=0.45 v(vp_p03_w0)=1.35
.ic v(sn_p04_w1_0)=0 v(sn_p04_w1_1)=1 v(sn_p04_w1_2)=1 v(sn_p04_w1_3)=1 v(rbl_p04_w1)=0 v(ref_p04_w1)=0.8
.ic v(wbl_p04_w1)=0 v(sbl_p04_w1)=0 v(sref_p04_w1)=0.8 v(vn_p04_w1)=0.45 v(vp_p04_w1)=1.35 v(sn_p04_w0_0)=1
.ic v(sn_p04_w0_1)=0 v(sn_p04_w0_2)=0 v(sn_p04_w0_3)=0 v(rbl_p04_w0)=0 v(ref_p04_w0)=0.8 v(wbl_p04_w0)=0
.ic v(sbl_p04_w0)=0 v(sref_p04_w0)=0.8 v(vn_p04_w0)=0.45 v(vp_p04_w0)=1.35 v(sn_p05_w1_0)=0 v(sn_p05_w1_1)=1
.ic v(sn_p05_w1_2)=1 v(sn_p05_w1_3)=1 v(rbl_p05_w1)=0 v(ref_p05_w1)=0.8 v(wbl_p05_w1)=0 v(sbl_p05_w1)=0
.ic v(sref_p05_w1)=0.8 v(vn_p05_w1)=0.45 v(vp_p05_w1)=1.35 v(sn_p05_w0_0)=1 v(sn_p05_w0_1)=0 v(sn_p05_w0_2)=0
.ic v(sn_p05_w0_3)=0 v(rbl_p05_w0)=0 v(ref_p05_w0)=0.8 v(wbl_p05_w0)=0 v(sbl_p05_w0)=0 v(sref_p05_w0)=0.8
.ic v(vn_p05_w0)=0.45 v(vp_p05_w0)=1.35 v(sn_p06_w1_0)=0 v(sn_p06_w1_1)=1 v(sn_p06_w1_2)=1 v(sn_p06_w1_3)=1
.ic v(rbl_p06_w1)=0 v(ref_p06_w1)=0.8 v(wbl_p06_w1)=0 v(sbl_p06_w1)=0 v(sref_p06_w1)=0.8 v(vn_p06_w1)=0.45
.ic v(vp_p06_w1)=1.35 v(sn_p06_w0_0)=1 v(sn_p06_w0_1)=0 v(sn_p06_w0_2)=0 v(sn_p06_w0_3)=0 v(rbl_p06_w0)=0
.ic v(ref_p06_w0)=0.8 v(wbl_p06_w0)=0 v(sbl_p06_w0)=0 v(sref_p06_w0)=0.8 v(vn_p06_w0)=0.45 v(vp_p06_w0)=1.35
.ic v(sn_p07_w1_0)=0 v(sn_p07_w1_1)=1 v(sn_p07_w1_2)=1 v(sn_p07_w1_3)=1 v(rbl_p07_w1)=0 v(ref_p07_w1)=0.8
.ic v(wbl_p07_w1)=0 v(sbl_p07_w1)=0 v(sref_p07_w1)=0.8 v(vn_p07_w1)=0.45 v(vp_p07_w1)=1.35 v(sn_p07_w0_0)=1
.ic v(sn_p07_w0_1)=0 v(sn_p07_w0_2)=0 v(sn_p07_w0_3)=0 v(rbl_p07_w0)=0 v(ref_p07_w0)=0.8 v(wbl_p07_w0)=0
.ic v(sbl_p07_w0)=0 v(sref_p07_w0)=0.8 v(vn_p07_w0)=0.45 v(vp_p07_w0)=1.35 v(sn_p08_w1_0)=0 v(sn_p08_w1_1)=1
.ic v(sn_p08_w1_2)=1 v(sn_p08_w1_3)=1 v(rbl_p08_w1)=0 v(ref_p08_w1)=0.8 v(wbl_p08_w1)=0 v(sbl_p08_w1)=0
.ic v(sref_p08_w1)=0.8 v(vn_p08_w1)=0.45 v(vp_p08_w1)=1.35 v(sn_p08_w0_0)=1 v(sn_p08_w0_1)=0 v(sn_p08_w0_2)=0
.ic v(sn_p08_w0_3)=0 v(rbl_p08_w0)=0 v(ref_p08_w0)=0.8 v(wbl_p08_w0)=0 v(sbl_p08_w0)=0 v(sref_p08_w0)=0.8
.ic v(vn_p08_w0)=0.45 v(vp_p08_w0)=1.35 v(sn_c00_w1_0)=0 v(sn_c00_w1_1)=1 v(sn_c00_w1_2)=1 v(sn_c00_w1_3)=1
.ic v(rbl_c00_w1)=0 v(ref_c00_w1)=0.8 v(wbl_c00_w1)=0 v(sbl_c00_w1)=0 v(sref_c00_w1)=0.8 v(vn_c00_w1)=0.45
.ic v(vp_c00_w1)=1.35 v(sn_c00_w0_0)=1 v(sn_c00_w0_1)=0 v(sn_c00_w0_2)=0 v(sn_c00_w0_3)=0 v(rbl_c00_w0)=0
.ic v(ref_c00_w0)=0.8 v(wbl_c00_w0)=0 v(sbl_c00_w0)=0 v(sref_c00_w0)=0.8 v(vn_c00_w0)=0.45 v(vp_c00_w0)=1.35
.ic v(sn_c01_w1_0)=0 v(sn_c01_w1_1)=1 v(sn_c01_w1_2)=1 v(sn_c01_w1_3)=1 v(rbl_c01_w1)=0 v(ref_c01_w1)=0.8
.ic v(wbl_c01_w1)=0 v(sbl_c01_w1)=0 v(sref_c01_w1)=0.8 v(vn_c01_w1)=0.45 v(vp_c01_w1)=1.35 v(sn_c01_w0_0)=1
.ic v(sn_c01_w0_1)=0 v(sn_c01_w0_2)=0 v(sn_c01_w0_3)=0 v(rbl_c01_w0)=0 v(ref_c01_w0)=0.8 v(wbl_c01_w0)=0
.ic v(sbl_c01_w0)=0 v(sref_c01_w0)=0.8 v(vn_c01_w0)=0.45 v(vp_c01_w0)=1.35 v(sn_c02_w1_0)=0 v(sn_c02_w1_1)=1
.ic v(sn_c02_w1_2)=1 v(sn_c02_w1_3)=1 v(rbl_c02_w1)=0 v(ref_c02_w1)=0.8 v(wbl_c02_w1)=0 v(sbl_c02_w1)=0
.ic v(sref_c02_w1)=0.8 v(vn_c02_w1)=0.45 v(vp_c02_w1)=1.35 v(sn_c02_w0_0)=1 v(sn_c02_w0_1)=0 v(sn_c02_w0_2)=0
.ic v(sn_c02_w0_3)=0 v(rbl_c02_w0)=0 v(ref_c02_w0)=0.8 v(wbl_c02_w0)=0 v(sbl_c02_w0)=0 v(sref_c02_w0)=0.8
.ic v(vn_c02_w0)=0.45 v(vp_c02_w0)=1.35 v(sn_c03_w1_0)=0 v(sn_c03_w1_1)=1 v(sn_c03_w1_2)=1 v(sn_c03_w1_3)=1
.ic v(rbl_c03_w1)=0 v(ref_c03_w1)=0.8 v(wbl_c03_w1)=0 v(sbl_c03_w1)=0 v(sref_c03_w1)=0.8 v(vn_c03_w1)=0.45
.ic v(vp_c03_w1)=1.35 v(sn_c03_w0_0)=1 v(sn_c03_w0_1)=0 v(sn_c03_w0_2)=0 v(sn_c03_w0_3)=0 v(rbl_c03_w0)=0
.ic v(ref_c03_w0)=0.8 v(wbl_c03_w0)=0 v(sbl_c03_w0)=0 v(sref_c03_w0)=0.8 v(vn_c03_w0)=0.45 v(vp_c03_w0)=1.35
.ic v(sn_c04_w1_0)=0 v(sn_c04_w1_1)=1 v(sn_c04_w1_2)=1 v(sn_c04_w1_3)=1 v(rbl_c04_w1)=0 v(ref_c04_w1)=0.8
.ic v(wbl_c04_w1)=0 v(sbl_c04_w1)=0 v(sref_c04_w1)=0.8 v(vn_c04_w1)=0.45 v(vp_c04_w1)=1.35 v(sn_c04_w0_0)=1
.ic v(sn_c04_w0_1)=0 v(sn_c04_w0_2)=0 v(sn_c04_w0_3)=0 v(rbl_c04_w0)=0 v(ref_c04_w0)=0.8 v(wbl_c04_w0)=0
.ic v(sbl_c04_w0)=0 v(sref_c04_w0)=0.8 v(vn_c04_w0)=0.45 v(vp_c04_w0)=1.35 v(sn_c05_w1_0)=0 v(sn_c05_w1_1)=1
.ic v(sn_c05_w1_2)=1 v(sn_c05_w1_3)=1 v(rbl_c05_w1)=0 v(ref_c05_w1)=0.8 v(wbl_c05_w1)=0 v(sbl_c05_w1)=0
.ic v(sref_c05_w1)=0.8 v(vn_c05_w1)=0.45 v(vp_c05_w1)=1.35 v(sn_c05_w0_0)=1 v(sn_c05_w0_1)=0 v(sn_c05_w0_2)=0
.ic v(sn_c05_w0_3)=0 v(rbl_c05_w0)=0 v(ref_c05_w0)=0.8 v(wbl_c05_w0)=0 v(sbl_c05_w0)=0 v(sref_c05_w0)=0.8
.ic v(vn_c05_w0)=0.45 v(vp_c05_w0)=1.35 v(sn_f00_w1_0)=0 v(sn_f00_w1_1)=1 v(sn_f00_w1_2)=1 v(sn_f00_w1_3)=1
.ic v(rbl_f00_w1)=0 v(ref_f00_w1)=0.8 v(wbl_f00_w1)=0 v(sbl_f00_w1)=0 v(sref_f00_w1)=0.8 v(vn_f00_w1)=0.45
.ic v(vp_f00_w1)=1.35 v(sn_f00_w0_0)=1 v(sn_f00_w0_1)=0 v(sn_f00_w0_2)=0 v(sn_f00_w0_3)=0 v(rbl_f00_w0)=0
.ic v(ref_f00_w0)=0.8 v(wbl_f00_w0)=0 v(sbl_f00_w0)=0 v(sref_f00_w0)=0.8 v(vn_f00_w0)=0.45 v(vp_f00_w0)=1.35
.ic v(sn_f01_w1_0)=0 v(sn_f01_w1_1)=1 v(sn_f01_w1_2)=1 v(sn_f01_w1_3)=1 v(rbl_f01_w1)=0 v(ref_f01_w1)=0.8
.ic v(wbl_f01_w1)=0 v(sbl_f01_w1)=0 v(sref_f01_w1)=0.8 v(vn_f01_w1)=0.45 v(vp_f01_w1)=1.35 v(sn_f01_w0_0)=1
.ic v(sn_f01_w0_1)=0 v(sn_f01_w0_2)=0 v(sn_f01_w0_3)=0 v(rbl_f01_w0)=0 v(ref_f01_w0)=0.8 v(wbl_f01_w0)=0
.ic v(sbl_f01_w0)=0 v(sref_f01_w0)=0.8 v(vn_f01_w0)=0.45 v(vp_f01_w0)=1.35 v(sn_f02_w1_0)=0 v(sn_f02_w1_1)=1
.ic v(sn_f02_w1_2)=1 v(sn_f02_w1_3)=1 v(rbl_f02_w1)=0 v(ref_f02_w1)=0.8 v(wbl_f02_w1)=0 v(sbl_f02_w1)=0
.ic v(sref_f02_w1)=0.8 v(vn_f02_w1)=0.45 v(vp_f02_w1)=1.35 v(sn_f02_w0_0)=1 v(sn_f02_w0_1)=0 v(sn_f02_w0_2)=0
.ic v(sn_f02_w0_3)=0 v(rbl_f02_w0)=0 v(ref_f02_w0)=0.8 v(wbl_f02_w0)=0 v(sbl_f02_w0)=0 v(sref_f02_w0)=0.8
.ic v(vn_f02_w0)=0.45 v(vp_f02_w0)=1.35 v(sn_f03_w1_0)=0 v(sn_f03_w1_1)=1 v(sn_f03_w1_2)=1 v(sn_f03_w1_3)=1
.ic v(rbl_f03_w1)=0 v(ref_f03_w1)=0.8 v(wbl_f03_w1)=0 v(sbl_f03_w1)=0 v(sref_f03_w1)=0.8 v(vn_f03_w1)=0.45
.ic v(vp_f03_w1)=1.35 v(sn_f03_w0_0)=1 v(sn_f03_w0_1)=0 v(sn_f03_w0_2)=0 v(sn_f03_w0_3)=0 v(rbl_f03_w0)=0
.ic v(ref_f03_w0)=0.8 v(wbl_f03_w0)=0 v(sbl_f03_w0)=0 v(sref_f03_w0)=0.8 v(vn_f03_w0)=0.45 v(vp_f03_w0)=1.35
.ic v(sn_f04_w1_0)=0 v(sn_f04_w1_1)=1 v(sn_f04_w1_2)=1 v(sn_f04_w1_3)=1 v(rbl_f04_w1)=0 v(ref_f04_w1)=0.8
.ic v(wbl_f04_w1)=0 v(sbl_f04_w1)=0 v(sref_f04_w1)=0.8 v(vn_f04_w1)=0.45 v(vp_f04_w1)=1.35 v(sn_f04_w0_0)=1
.ic v(sn_f04_w0_1)=0 v(sn_f04_w0_2)=0 v(sn_f04_w0_3)=0 v(rbl_f04_w0)=0 v(ref_f04_w0)=0.8 v(wbl_f04_w0)=0
.ic v(sbl_f04_w0)=0 v(sref_f04_w0)=0.8 v(vn_f04_w0)=0.45 v(vp_f04_w0)=1.35 v(sn_d00_w0_0)=1 v(sn_d00_w0_1)=0
.ic v(sn_d00_w0_2)=0 v(sn_d00_w0_3)=0 v(rbl_d00_w0)=0 v(ref_d00_w0)=0.8 v(wbl_d00_w0)=0 v(sbl_d00_w0)=0
.ic v(sref_d00_w0)=0.8 v(vn_d00_w0)=0.45 v(vp_d00_w0)=1.35 v(sn_d01_w0_0)=1 v(sn_d01_w0_1)=0 v(sn_d01_w0_2)=0
.ic v(sn_d01_w0_3)=0 v(rbl_d01_w0)=0 v(ref_d01_w0)=0.8 v(wbl_d01_w0)=0 v(sbl_d01_w0)=0 v(sref_d01_w0)=0.8
.ic v(vn_d01_w0)=0.45 v(vp_d01_w0)=1.35 v(sn_d02_w0_0)=1 v(sn_d02_w0_1)=0 v(sn_d02_w0_2)=0 v(sn_d02_w0_3)=0
.ic v(rbl_d02_w0)=0 v(ref_d02_w0)=0.8 v(wbl_d02_w0)=0 v(sbl_d02_w0)=0 v(sref_d02_w0)=0.8 v(vn_d02_w0)=0.45
.ic v(vp_d02_w0)=1.35 v(sn_d03_w0_0)=1 v(sn_d03_w0_1)=0 v(sn_d03_w0_2)=0 v(sn_d03_w0_3)=0 v(rbl_d03_w0)=0
.ic v(ref_d03_w0)=0.8 v(wbl_d03_w0)=0 v(sbl_d03_w0)=0 v(sref_d03_w0)=0.8 v(vn_d03_w0)=0.45 v(vp_d03_w0)=1.35
.ic v(sn_d04_w0_0)=1 v(sn_d04_w0_1)=0 v(sn_d04_w0_2)=0 v(sn_d04_w0_3)=0 v(rbl_d04_w0)=0 v(ref_d04_w0)=0.8
.ic v(wbl_d04_w0)=0 v(sbl_d04_w0)=0 v(sref_d04_w0)=0.8 v(vn_d04_w0)=0.45 v(vp_d04_w0)=1.35 v(sn_d05_w0_0)=1
.ic v(sn_d05_w0_1)=0 v(sn_d05_w0_2)=0 v(sn_d05_w0_3)=0 v(rbl_d05_w0)=0 v(ref_d05_w0)=0.8 v(wbl_d05_w0)=0
.ic v(sbl_d05_w0)=0 v(sref_d05_w0)=0.8 v(vn_d05_w0)=0.45 v(vp_d05_w0)=1.35 v(sn_d06_w0_0)=1 v(sn_d06_w0_1)=0
.ic v(sn_d06_w0_2)=0 v(sn_d06_w0_3)=0 v(rbl_d06_w0)=0 v(ref_d06_w0)=0.8 v(wbl_d06_w0)=0 v(sbl_d06_w0)=0
.ic v(sref_d06_w0)=0.8 v(vn_d06_w0)=0.45 v(vp_d06_w0)=1.35 v(sn_d07_w0_0)=1 v(sn_d07_w0_1)=0 v(sn_d07_w0_2)=0
.ic v(sn_d07_w0_3)=0 v(rbl_d07_w0)=0 v(ref_d07_w0)=0.8 v(wbl_d07_w0)=0 v(sbl_d07_w0)=0 v(sref_d07_w0)=0.8
.ic v(vn_d07_w0)=0.45 v(vp_d07_w0)=1.35 v(rbl_cp_f00)=0.9 v(sbl_cp_f00)=0.9 v(rbl_cp_f03)=0.9 v(sbl_cp_f03)=0.9
.ic v(rbl_cp_f01)=0.9 v(sbl_cp_f01)=0.9 v(rbl_cp_c04)=0.9 v(sbl_cp_c04)=0.9 v(rbl_cp_c03)=0.9 v(sbl_cp_c03)=0.9
.ic v(rbl_cp_c05)=0.9 v(sbl_cp_c05)=0.9 v(rbl_cp_i00)=0.9 v(sbl_cp_i00)=0.9 v(rbl_cp_i04)=0.9 v(sbl_cp_i04)=0.9
.ic v(rbl_cp_i05)=0.9 v(sbl_cp_i05)=0.9 v(rbl_cp_i06)=0.9 v(sbl_cp_i06)=0.9 v(rbl_cp_i07)=0.9 v(sbl_cp_i07)=0.9
.ic v(rbl_cp_i08)=0.9 v(sbl_cp_i08)=0.9 v(rbl_cp_i09)=0.9 v(sbl_cp_i09)=0.9 v(rbl_cp_i10)=0.9 v(sbl_cp_i10)=0.9
.ic v(rbl_cp_i11)=0.9 v(sbl_cp_i11)=0.9 v(rbl_cp_i15)=0.9 v(sbl_cp_i15)=0.9 v(rbl_cp_p02)=0.9 v(sbl_cp_p02)=0.9
.ic v(rbl_cp_p03)=0.9 v(sbl_cp_p03)=0.9 v(rbl_cp_p04)=0.9 v(sbl_cp_p04)=0.9
