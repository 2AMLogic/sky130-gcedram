* sense_stage_crbl_ext4row_layoutcard.spice -- issue #88 variant of the issue #60 sense-stage deck.
* GENERATED by gen_sense_stage.py --variant crbl_ext4row_layoutcard; do not edit by hand.
* Changed from the default deck ONLY: C_RBL on rbl and on the matched dummy reference load, and the bitcell diffusion card (layout: ad=as=0.1974 pd=ps=1.78).
*
* PROPOSED/UNRATIFIED SCOPE: the corners/temperatures this deck is run over come from
* spec/operating-range-decision-PROPOSED.md (27 C and 125 C only). Inputs follow
* sim/loaded-column/cold-corner/SENSE_INPUT_CONTRACT.md (baseline column).
* CIRCUIT BODY for `klt sim`: no .control/.end; the PDK .lib/.temp cards are appended per
* corner by klt. Flat and self-contained (batch fleet gets only this file + request.json).
*
* Every swept point is an independent parallel instance (own rbl/ref/latch/cells), so a
* corner needs ONE tran. Instance kinds:
*   st_*     stage-only: rbl precharged to VREF+d, no cells (offset / resolution of the latch)
*   cell1_*  end-to-end: 4-row column, all four SN pre-read at the stated level (stored '1')
*   cell0_*  same, stored '0' level
* Naming r<mV> = reference offset below the precharge level (VREF = VRBL - r).
*
* ASSUMPTIONS (all labelled; none is a spec value): C_RBL, VRBL, 4-row column, sense instant,
* reference level, latch/footer/header sizes, ideal precharge switch, ideal drivers, ideal
* matched dummy load on the reference side, all four SN at one level, global corners only.

.param VDD     = 1.8
.param VRBL    = 0.9   $ ASSUMPTION (contract)
.param TEDGE   = 1e-10
.param T_READ  = 1e-08   $ select edge
.param T_PGAP  = 2e-09   $ precharge released this long before T_READ
.param T_EN    = 2e-08   $ ASSUMPTION: latch enable = contract sense instant (T_READ+10n)
.param C_RBL   = 8.59179e-16   $ EXTRACTED-4-ROW (layout/gain_cell_2t_array.parasitics.summary.json comparison.c_rbl.extracted_4row_worst_total_ff; N_rows = 4 is a STUDY-ASSUMPTION)
.param C_SN    = 6.05354e-16   $ extracted-from-netlist (layout/gain_cell_2t.extract.parasitics.json)

* ---- shared drivers (ideal) ----
vdd   vdd 0 dc {VDD}
vctl  ctl 0 pwl(0 {VDD} {T_READ-T_PGAP} {VDD} {T_READ-T_PGAP+TEDGE} 0)
ven   en  0 pwl(0 0 {T_EN} 0 {T_EN+TEDGE} {VDD})
venb  enb 0 pwl(0 {VDD} {T_EN} {VDD} {T_EN+TEDGE} 0)
vrwls rwl_sel 0 pwl(0 {VDD} {T_READ} {VDD} {T_READ+TEDGE} 0)
vrwld rwl_des 0 dc {VDD}
vpre  prea 0 dc {VRBL}
vref_020 pref_020 0 dc 0.88   $ reference = VRBL - 0.02 (ASSUMPTION)
vref_050 pref_050 0 dc 0.85   $ reference = VRBL - 0.05 (ASSUMPTION)
vref_100 pref_100 0 dc 0.8   $ reference = VRBL - 0.1 (ASSUMPTION)
vref_200 pref_200 0 dc 0.7   $ reference = VRBL - 0.2 (ASSUMPTION)
.model swpre sw(vt=0.9 vh=0.1 ron=100 roff=1e12)

* ---- instance 0: st_m100mv ----
vpa_st_m100mv pa_st_m100mv 0 dc 0.700000
spa_st_m100mv pa_st_m100mv rbl_st_m100mv ctl 0 swpre
crbl_st_m100mv rbl_st_m100mv 0 {C_RBL}
spr_st_m100mv pref_100 ref_st_m100mv ctl 0 swpre
cref_st_m100mv ref_st_m100mv 0 {C_RBL}   $ ASSUMPTION: ideal matched dummy load
XMN1_st_m100mv rbl_st_m100mv ref_st_m100mv vn_st_m100mv 0 sky130_fd_pr__nfet_01v8 L=0.15 W=1 nf=1 ad=0.29 as=0.29 pd=2.58 ps=2.58 mult=1 m=1
XMN2_st_m100mv ref_st_m100mv rbl_st_m100mv vn_st_m100mv 0 sky130_fd_pr__nfet_01v8 L=0.15 W=1 nf=1 ad=0.29 as=0.29 pd=2.58 ps=2.58 mult=1 m=1
XMP1_st_m100mv rbl_st_m100mv ref_st_m100mv vp_st_m100mv vdd sky130_fd_pr__pfet_01v8 L=0.15 W=2 nf=1 ad=0.58 as=0.58 pd=4.58 ps=4.58 mult=1 m=1
XMP2_st_m100mv ref_st_m100mv rbl_st_m100mv vp_st_m100mv vdd sky130_fd_pr__pfet_01v8 L=0.15 W=2 nf=1 ad=0.58 as=0.58 pd=4.58 ps=4.58 mult=1 m=1
XMNF_st_m100mv vn_st_m100mv en 0 0 sky130_fd_pr__nfet_01v8 L=0.15 W=2 nf=1 ad=0.58 as=0.58 pd=4.58 ps=4.58 mult=1 m=1
XMPH_st_m100mv vp_st_m100mv enb vdd vdd sky130_fd_pr__pfet_01v8 L=0.15 W=4 nf=1 ad=1.16 as=1.16 pd=8.58 ps=8.58 mult=1 m=1
bd_st_m100mv d_st_m100mv 0 v=v(rbl_st_m100mv)-v(ref_st_m100mv)
bdabs_st_m100mv dabs_st_m100mv 0 v=abs(v(rbl_st_m100mv)-v(ref_st_m100mv))

* ---- instance 1: st_m50mv ----
vpa_st_m50mv pa_st_m50mv 0 dc 0.750000
spa_st_m50mv pa_st_m50mv rbl_st_m50mv ctl 0 swpre
crbl_st_m50mv rbl_st_m50mv 0 {C_RBL}
spr_st_m50mv pref_100 ref_st_m50mv ctl 0 swpre
cref_st_m50mv ref_st_m50mv 0 {C_RBL}   $ ASSUMPTION: ideal matched dummy load
XMN1_st_m50mv rbl_st_m50mv ref_st_m50mv vn_st_m50mv 0 sky130_fd_pr__nfet_01v8 L=0.15 W=1 nf=1 ad=0.29 as=0.29 pd=2.58 ps=2.58 mult=1 m=1
XMN2_st_m50mv ref_st_m50mv rbl_st_m50mv vn_st_m50mv 0 sky130_fd_pr__nfet_01v8 L=0.15 W=1 nf=1 ad=0.29 as=0.29 pd=2.58 ps=2.58 mult=1 m=1
XMP1_st_m50mv rbl_st_m50mv ref_st_m50mv vp_st_m50mv vdd sky130_fd_pr__pfet_01v8 L=0.15 W=2 nf=1 ad=0.58 as=0.58 pd=4.58 ps=4.58 mult=1 m=1
XMP2_st_m50mv ref_st_m50mv rbl_st_m50mv vp_st_m50mv vdd sky130_fd_pr__pfet_01v8 L=0.15 W=2 nf=1 ad=0.58 as=0.58 pd=4.58 ps=4.58 mult=1 m=1
XMNF_st_m50mv vn_st_m50mv en 0 0 sky130_fd_pr__nfet_01v8 L=0.15 W=2 nf=1 ad=0.58 as=0.58 pd=4.58 ps=4.58 mult=1 m=1
XMPH_st_m50mv vp_st_m50mv enb vdd vdd sky130_fd_pr__pfet_01v8 L=0.15 W=4 nf=1 ad=1.16 as=1.16 pd=8.58 ps=8.58 mult=1 m=1
bd_st_m50mv d_st_m50mv 0 v=v(rbl_st_m50mv)-v(ref_st_m50mv)
bdabs_st_m50mv dabs_st_m50mv 0 v=abs(v(rbl_st_m50mv)-v(ref_st_m50mv))

* ---- instance 2: st_m20mv ----
vpa_st_m20mv pa_st_m20mv 0 dc 0.780000
spa_st_m20mv pa_st_m20mv rbl_st_m20mv ctl 0 swpre
crbl_st_m20mv rbl_st_m20mv 0 {C_RBL}
spr_st_m20mv pref_100 ref_st_m20mv ctl 0 swpre
cref_st_m20mv ref_st_m20mv 0 {C_RBL}   $ ASSUMPTION: ideal matched dummy load
XMN1_st_m20mv rbl_st_m20mv ref_st_m20mv vn_st_m20mv 0 sky130_fd_pr__nfet_01v8 L=0.15 W=1 nf=1 ad=0.29 as=0.29 pd=2.58 ps=2.58 mult=1 m=1
XMN2_st_m20mv ref_st_m20mv rbl_st_m20mv vn_st_m20mv 0 sky130_fd_pr__nfet_01v8 L=0.15 W=1 nf=1 ad=0.29 as=0.29 pd=2.58 ps=2.58 mult=1 m=1
XMP1_st_m20mv rbl_st_m20mv ref_st_m20mv vp_st_m20mv vdd sky130_fd_pr__pfet_01v8 L=0.15 W=2 nf=1 ad=0.58 as=0.58 pd=4.58 ps=4.58 mult=1 m=1
XMP2_st_m20mv ref_st_m20mv rbl_st_m20mv vp_st_m20mv vdd sky130_fd_pr__pfet_01v8 L=0.15 W=2 nf=1 ad=0.58 as=0.58 pd=4.58 ps=4.58 mult=1 m=1
XMNF_st_m20mv vn_st_m20mv en 0 0 sky130_fd_pr__nfet_01v8 L=0.15 W=2 nf=1 ad=0.58 as=0.58 pd=4.58 ps=4.58 mult=1 m=1
XMPH_st_m20mv vp_st_m20mv enb vdd vdd sky130_fd_pr__pfet_01v8 L=0.15 W=4 nf=1 ad=1.16 as=1.16 pd=8.58 ps=8.58 mult=1 m=1
bd_st_m20mv d_st_m20mv 0 v=v(rbl_st_m20mv)-v(ref_st_m20mv)
bdabs_st_m20mv dabs_st_m20mv 0 v=abs(v(rbl_st_m20mv)-v(ref_st_m20mv))

* ---- instance 3: st_m10mv ----
vpa_st_m10mv pa_st_m10mv 0 dc 0.790000
spa_st_m10mv pa_st_m10mv rbl_st_m10mv ctl 0 swpre
crbl_st_m10mv rbl_st_m10mv 0 {C_RBL}
spr_st_m10mv pref_100 ref_st_m10mv ctl 0 swpre
cref_st_m10mv ref_st_m10mv 0 {C_RBL}   $ ASSUMPTION: ideal matched dummy load
XMN1_st_m10mv rbl_st_m10mv ref_st_m10mv vn_st_m10mv 0 sky130_fd_pr__nfet_01v8 L=0.15 W=1 nf=1 ad=0.29 as=0.29 pd=2.58 ps=2.58 mult=1 m=1
XMN2_st_m10mv ref_st_m10mv rbl_st_m10mv vn_st_m10mv 0 sky130_fd_pr__nfet_01v8 L=0.15 W=1 nf=1 ad=0.29 as=0.29 pd=2.58 ps=2.58 mult=1 m=1
XMP1_st_m10mv rbl_st_m10mv ref_st_m10mv vp_st_m10mv vdd sky130_fd_pr__pfet_01v8 L=0.15 W=2 nf=1 ad=0.58 as=0.58 pd=4.58 ps=4.58 mult=1 m=1
XMP2_st_m10mv ref_st_m10mv rbl_st_m10mv vp_st_m10mv vdd sky130_fd_pr__pfet_01v8 L=0.15 W=2 nf=1 ad=0.58 as=0.58 pd=4.58 ps=4.58 mult=1 m=1
XMNF_st_m10mv vn_st_m10mv en 0 0 sky130_fd_pr__nfet_01v8 L=0.15 W=2 nf=1 ad=0.58 as=0.58 pd=4.58 ps=4.58 mult=1 m=1
XMPH_st_m10mv vp_st_m10mv enb vdd vdd sky130_fd_pr__pfet_01v8 L=0.15 W=4 nf=1 ad=1.16 as=1.16 pd=8.58 ps=8.58 mult=1 m=1
bd_st_m10mv d_st_m10mv 0 v=v(rbl_st_m10mv)-v(ref_st_m10mv)
bdabs_st_m10mv dabs_st_m10mv 0 v=abs(v(rbl_st_m10mv)-v(ref_st_m10mv))

* ---- instance 4: st_m5mv ----
vpa_st_m5mv pa_st_m5mv 0 dc 0.795000
spa_st_m5mv pa_st_m5mv rbl_st_m5mv ctl 0 swpre
crbl_st_m5mv rbl_st_m5mv 0 {C_RBL}
spr_st_m5mv pref_100 ref_st_m5mv ctl 0 swpre
cref_st_m5mv ref_st_m5mv 0 {C_RBL}   $ ASSUMPTION: ideal matched dummy load
XMN1_st_m5mv rbl_st_m5mv ref_st_m5mv vn_st_m5mv 0 sky130_fd_pr__nfet_01v8 L=0.15 W=1 nf=1 ad=0.29 as=0.29 pd=2.58 ps=2.58 mult=1 m=1
XMN2_st_m5mv ref_st_m5mv rbl_st_m5mv vn_st_m5mv 0 sky130_fd_pr__nfet_01v8 L=0.15 W=1 nf=1 ad=0.29 as=0.29 pd=2.58 ps=2.58 mult=1 m=1
XMP1_st_m5mv rbl_st_m5mv ref_st_m5mv vp_st_m5mv vdd sky130_fd_pr__pfet_01v8 L=0.15 W=2 nf=1 ad=0.58 as=0.58 pd=4.58 ps=4.58 mult=1 m=1
XMP2_st_m5mv ref_st_m5mv rbl_st_m5mv vp_st_m5mv vdd sky130_fd_pr__pfet_01v8 L=0.15 W=2 nf=1 ad=0.58 as=0.58 pd=4.58 ps=4.58 mult=1 m=1
XMNF_st_m5mv vn_st_m5mv en 0 0 sky130_fd_pr__nfet_01v8 L=0.15 W=2 nf=1 ad=0.58 as=0.58 pd=4.58 ps=4.58 mult=1 m=1
XMPH_st_m5mv vp_st_m5mv enb vdd vdd sky130_fd_pr__pfet_01v8 L=0.15 W=4 nf=1 ad=1.16 as=1.16 pd=8.58 ps=8.58 mult=1 m=1
bd_st_m5mv d_st_m5mv 0 v=v(rbl_st_m5mv)-v(ref_st_m5mv)
bdabs_st_m5mv dabs_st_m5mv 0 v=abs(v(rbl_st_m5mv)-v(ref_st_m5mv))

* ---- instance 5: st_m2mv ----
vpa_st_m2mv pa_st_m2mv 0 dc 0.798000
spa_st_m2mv pa_st_m2mv rbl_st_m2mv ctl 0 swpre
crbl_st_m2mv rbl_st_m2mv 0 {C_RBL}
spr_st_m2mv pref_100 ref_st_m2mv ctl 0 swpre
cref_st_m2mv ref_st_m2mv 0 {C_RBL}   $ ASSUMPTION: ideal matched dummy load
XMN1_st_m2mv rbl_st_m2mv ref_st_m2mv vn_st_m2mv 0 sky130_fd_pr__nfet_01v8 L=0.15 W=1 nf=1 ad=0.29 as=0.29 pd=2.58 ps=2.58 mult=1 m=1
XMN2_st_m2mv ref_st_m2mv rbl_st_m2mv vn_st_m2mv 0 sky130_fd_pr__nfet_01v8 L=0.15 W=1 nf=1 ad=0.29 as=0.29 pd=2.58 ps=2.58 mult=1 m=1
XMP1_st_m2mv rbl_st_m2mv ref_st_m2mv vp_st_m2mv vdd sky130_fd_pr__pfet_01v8 L=0.15 W=2 nf=1 ad=0.58 as=0.58 pd=4.58 ps=4.58 mult=1 m=1
XMP2_st_m2mv ref_st_m2mv rbl_st_m2mv vp_st_m2mv vdd sky130_fd_pr__pfet_01v8 L=0.15 W=2 nf=1 ad=0.58 as=0.58 pd=4.58 ps=4.58 mult=1 m=1
XMNF_st_m2mv vn_st_m2mv en 0 0 sky130_fd_pr__nfet_01v8 L=0.15 W=2 nf=1 ad=0.58 as=0.58 pd=4.58 ps=4.58 mult=1 m=1
XMPH_st_m2mv vp_st_m2mv enb vdd vdd sky130_fd_pr__pfet_01v8 L=0.15 W=4 nf=1 ad=1.16 as=1.16 pd=8.58 ps=8.58 mult=1 m=1
bd_st_m2mv d_st_m2mv 0 v=v(rbl_st_m2mv)-v(ref_st_m2mv)
bdabs_st_m2mv dabs_st_m2mv 0 v=abs(v(rbl_st_m2mv)-v(ref_st_m2mv))

* ---- instance 6: st_m1mv ----
vpa_st_m1mv pa_st_m1mv 0 dc 0.799000
spa_st_m1mv pa_st_m1mv rbl_st_m1mv ctl 0 swpre
crbl_st_m1mv rbl_st_m1mv 0 {C_RBL}
spr_st_m1mv pref_100 ref_st_m1mv ctl 0 swpre
cref_st_m1mv ref_st_m1mv 0 {C_RBL}   $ ASSUMPTION: ideal matched dummy load
XMN1_st_m1mv rbl_st_m1mv ref_st_m1mv vn_st_m1mv 0 sky130_fd_pr__nfet_01v8 L=0.15 W=1 nf=1 ad=0.29 as=0.29 pd=2.58 ps=2.58 mult=1 m=1
XMN2_st_m1mv ref_st_m1mv rbl_st_m1mv vn_st_m1mv 0 sky130_fd_pr__nfet_01v8 L=0.15 W=1 nf=1 ad=0.29 as=0.29 pd=2.58 ps=2.58 mult=1 m=1
XMP1_st_m1mv rbl_st_m1mv ref_st_m1mv vp_st_m1mv vdd sky130_fd_pr__pfet_01v8 L=0.15 W=2 nf=1 ad=0.58 as=0.58 pd=4.58 ps=4.58 mult=1 m=1
XMP2_st_m1mv ref_st_m1mv rbl_st_m1mv vp_st_m1mv vdd sky130_fd_pr__pfet_01v8 L=0.15 W=2 nf=1 ad=0.58 as=0.58 pd=4.58 ps=4.58 mult=1 m=1
XMNF_st_m1mv vn_st_m1mv en 0 0 sky130_fd_pr__nfet_01v8 L=0.15 W=2 nf=1 ad=0.58 as=0.58 pd=4.58 ps=4.58 mult=1 m=1
XMPH_st_m1mv vp_st_m1mv enb vdd vdd sky130_fd_pr__pfet_01v8 L=0.15 W=4 nf=1 ad=1.16 as=1.16 pd=8.58 ps=8.58 mult=1 m=1
bd_st_m1mv d_st_m1mv 0 v=v(rbl_st_m1mv)-v(ref_st_m1mv)
bdabs_st_m1mv dabs_st_m1mv 0 v=abs(v(rbl_st_m1mv)-v(ref_st_m1mv))

* ---- instance 7: st_p1mv ----
vpa_st_p1mv pa_st_p1mv 0 dc 0.801000
spa_st_p1mv pa_st_p1mv rbl_st_p1mv ctl 0 swpre
crbl_st_p1mv rbl_st_p1mv 0 {C_RBL}
spr_st_p1mv pref_100 ref_st_p1mv ctl 0 swpre
cref_st_p1mv ref_st_p1mv 0 {C_RBL}   $ ASSUMPTION: ideal matched dummy load
XMN1_st_p1mv rbl_st_p1mv ref_st_p1mv vn_st_p1mv 0 sky130_fd_pr__nfet_01v8 L=0.15 W=1 nf=1 ad=0.29 as=0.29 pd=2.58 ps=2.58 mult=1 m=1
XMN2_st_p1mv ref_st_p1mv rbl_st_p1mv vn_st_p1mv 0 sky130_fd_pr__nfet_01v8 L=0.15 W=1 nf=1 ad=0.29 as=0.29 pd=2.58 ps=2.58 mult=1 m=1
XMP1_st_p1mv rbl_st_p1mv ref_st_p1mv vp_st_p1mv vdd sky130_fd_pr__pfet_01v8 L=0.15 W=2 nf=1 ad=0.58 as=0.58 pd=4.58 ps=4.58 mult=1 m=1
XMP2_st_p1mv ref_st_p1mv rbl_st_p1mv vp_st_p1mv vdd sky130_fd_pr__pfet_01v8 L=0.15 W=2 nf=1 ad=0.58 as=0.58 pd=4.58 ps=4.58 mult=1 m=1
XMNF_st_p1mv vn_st_p1mv en 0 0 sky130_fd_pr__nfet_01v8 L=0.15 W=2 nf=1 ad=0.58 as=0.58 pd=4.58 ps=4.58 mult=1 m=1
XMPH_st_p1mv vp_st_p1mv enb vdd vdd sky130_fd_pr__pfet_01v8 L=0.15 W=4 nf=1 ad=1.16 as=1.16 pd=8.58 ps=8.58 mult=1 m=1
bd_st_p1mv d_st_p1mv 0 v=v(rbl_st_p1mv)-v(ref_st_p1mv)
bdabs_st_p1mv dabs_st_p1mv 0 v=abs(v(rbl_st_p1mv)-v(ref_st_p1mv))

* ---- instance 8: st_p2mv ----
vpa_st_p2mv pa_st_p2mv 0 dc 0.802000
spa_st_p2mv pa_st_p2mv rbl_st_p2mv ctl 0 swpre
crbl_st_p2mv rbl_st_p2mv 0 {C_RBL}
spr_st_p2mv pref_100 ref_st_p2mv ctl 0 swpre
cref_st_p2mv ref_st_p2mv 0 {C_RBL}   $ ASSUMPTION: ideal matched dummy load
XMN1_st_p2mv rbl_st_p2mv ref_st_p2mv vn_st_p2mv 0 sky130_fd_pr__nfet_01v8 L=0.15 W=1 nf=1 ad=0.29 as=0.29 pd=2.58 ps=2.58 mult=1 m=1
XMN2_st_p2mv ref_st_p2mv rbl_st_p2mv vn_st_p2mv 0 sky130_fd_pr__nfet_01v8 L=0.15 W=1 nf=1 ad=0.29 as=0.29 pd=2.58 ps=2.58 mult=1 m=1
XMP1_st_p2mv rbl_st_p2mv ref_st_p2mv vp_st_p2mv vdd sky130_fd_pr__pfet_01v8 L=0.15 W=2 nf=1 ad=0.58 as=0.58 pd=4.58 ps=4.58 mult=1 m=1
XMP2_st_p2mv ref_st_p2mv rbl_st_p2mv vp_st_p2mv vdd sky130_fd_pr__pfet_01v8 L=0.15 W=2 nf=1 ad=0.58 as=0.58 pd=4.58 ps=4.58 mult=1 m=1
XMNF_st_p2mv vn_st_p2mv en 0 0 sky130_fd_pr__nfet_01v8 L=0.15 W=2 nf=1 ad=0.58 as=0.58 pd=4.58 ps=4.58 mult=1 m=1
XMPH_st_p2mv vp_st_p2mv enb vdd vdd sky130_fd_pr__pfet_01v8 L=0.15 W=4 nf=1 ad=1.16 as=1.16 pd=8.58 ps=8.58 mult=1 m=1
bd_st_p2mv d_st_p2mv 0 v=v(rbl_st_p2mv)-v(ref_st_p2mv)
bdabs_st_p2mv dabs_st_p2mv 0 v=abs(v(rbl_st_p2mv)-v(ref_st_p2mv))

* ---- instance 9: st_p5mv ----
vpa_st_p5mv pa_st_p5mv 0 dc 0.805000
spa_st_p5mv pa_st_p5mv rbl_st_p5mv ctl 0 swpre
crbl_st_p5mv rbl_st_p5mv 0 {C_RBL}
spr_st_p5mv pref_100 ref_st_p5mv ctl 0 swpre
cref_st_p5mv ref_st_p5mv 0 {C_RBL}   $ ASSUMPTION: ideal matched dummy load
XMN1_st_p5mv rbl_st_p5mv ref_st_p5mv vn_st_p5mv 0 sky130_fd_pr__nfet_01v8 L=0.15 W=1 nf=1 ad=0.29 as=0.29 pd=2.58 ps=2.58 mult=1 m=1
XMN2_st_p5mv ref_st_p5mv rbl_st_p5mv vn_st_p5mv 0 sky130_fd_pr__nfet_01v8 L=0.15 W=1 nf=1 ad=0.29 as=0.29 pd=2.58 ps=2.58 mult=1 m=1
XMP1_st_p5mv rbl_st_p5mv ref_st_p5mv vp_st_p5mv vdd sky130_fd_pr__pfet_01v8 L=0.15 W=2 nf=1 ad=0.58 as=0.58 pd=4.58 ps=4.58 mult=1 m=1
XMP2_st_p5mv ref_st_p5mv rbl_st_p5mv vp_st_p5mv vdd sky130_fd_pr__pfet_01v8 L=0.15 W=2 nf=1 ad=0.58 as=0.58 pd=4.58 ps=4.58 mult=1 m=1
XMNF_st_p5mv vn_st_p5mv en 0 0 sky130_fd_pr__nfet_01v8 L=0.15 W=2 nf=1 ad=0.58 as=0.58 pd=4.58 ps=4.58 mult=1 m=1
XMPH_st_p5mv vp_st_p5mv enb vdd vdd sky130_fd_pr__pfet_01v8 L=0.15 W=4 nf=1 ad=1.16 as=1.16 pd=8.58 ps=8.58 mult=1 m=1
bd_st_p5mv d_st_p5mv 0 v=v(rbl_st_p5mv)-v(ref_st_p5mv)
bdabs_st_p5mv dabs_st_p5mv 0 v=abs(v(rbl_st_p5mv)-v(ref_st_p5mv))

* ---- instance 10: st_p10mv ----
vpa_st_p10mv pa_st_p10mv 0 dc 0.810000
spa_st_p10mv pa_st_p10mv rbl_st_p10mv ctl 0 swpre
crbl_st_p10mv rbl_st_p10mv 0 {C_RBL}
spr_st_p10mv pref_100 ref_st_p10mv ctl 0 swpre
cref_st_p10mv ref_st_p10mv 0 {C_RBL}   $ ASSUMPTION: ideal matched dummy load
XMN1_st_p10mv rbl_st_p10mv ref_st_p10mv vn_st_p10mv 0 sky130_fd_pr__nfet_01v8 L=0.15 W=1 nf=1 ad=0.29 as=0.29 pd=2.58 ps=2.58 mult=1 m=1
XMN2_st_p10mv ref_st_p10mv rbl_st_p10mv vn_st_p10mv 0 sky130_fd_pr__nfet_01v8 L=0.15 W=1 nf=1 ad=0.29 as=0.29 pd=2.58 ps=2.58 mult=1 m=1
XMP1_st_p10mv rbl_st_p10mv ref_st_p10mv vp_st_p10mv vdd sky130_fd_pr__pfet_01v8 L=0.15 W=2 nf=1 ad=0.58 as=0.58 pd=4.58 ps=4.58 mult=1 m=1
XMP2_st_p10mv ref_st_p10mv rbl_st_p10mv vp_st_p10mv vdd sky130_fd_pr__pfet_01v8 L=0.15 W=2 nf=1 ad=0.58 as=0.58 pd=4.58 ps=4.58 mult=1 m=1
XMNF_st_p10mv vn_st_p10mv en 0 0 sky130_fd_pr__nfet_01v8 L=0.15 W=2 nf=1 ad=0.58 as=0.58 pd=4.58 ps=4.58 mult=1 m=1
XMPH_st_p10mv vp_st_p10mv enb vdd vdd sky130_fd_pr__pfet_01v8 L=0.15 W=4 nf=1 ad=1.16 as=1.16 pd=8.58 ps=8.58 mult=1 m=1
bd_st_p10mv d_st_p10mv 0 v=v(rbl_st_p10mv)-v(ref_st_p10mv)
bdabs_st_p10mv dabs_st_p10mv 0 v=abs(v(rbl_st_p10mv)-v(ref_st_p10mv))

* ---- instance 11: st_p20mv ----
vpa_st_p20mv pa_st_p20mv 0 dc 0.820000
spa_st_p20mv pa_st_p20mv rbl_st_p20mv ctl 0 swpre
crbl_st_p20mv rbl_st_p20mv 0 {C_RBL}
spr_st_p20mv pref_100 ref_st_p20mv ctl 0 swpre
cref_st_p20mv ref_st_p20mv 0 {C_RBL}   $ ASSUMPTION: ideal matched dummy load
XMN1_st_p20mv rbl_st_p20mv ref_st_p20mv vn_st_p20mv 0 sky130_fd_pr__nfet_01v8 L=0.15 W=1 nf=1 ad=0.29 as=0.29 pd=2.58 ps=2.58 mult=1 m=1
XMN2_st_p20mv ref_st_p20mv rbl_st_p20mv vn_st_p20mv 0 sky130_fd_pr__nfet_01v8 L=0.15 W=1 nf=1 ad=0.29 as=0.29 pd=2.58 ps=2.58 mult=1 m=1
XMP1_st_p20mv rbl_st_p20mv ref_st_p20mv vp_st_p20mv vdd sky130_fd_pr__pfet_01v8 L=0.15 W=2 nf=1 ad=0.58 as=0.58 pd=4.58 ps=4.58 mult=1 m=1
XMP2_st_p20mv ref_st_p20mv rbl_st_p20mv vp_st_p20mv vdd sky130_fd_pr__pfet_01v8 L=0.15 W=2 nf=1 ad=0.58 as=0.58 pd=4.58 ps=4.58 mult=1 m=1
XMNF_st_p20mv vn_st_p20mv en 0 0 sky130_fd_pr__nfet_01v8 L=0.15 W=2 nf=1 ad=0.58 as=0.58 pd=4.58 ps=4.58 mult=1 m=1
XMPH_st_p20mv vp_st_p20mv enb vdd vdd sky130_fd_pr__pfet_01v8 L=0.15 W=4 nf=1 ad=1.16 as=1.16 pd=8.58 ps=8.58 mult=1 m=1
bd_st_p20mv d_st_p20mv 0 v=v(rbl_st_p20mv)-v(ref_st_p20mv)
bdabs_st_p20mv dabs_st_p20mv 0 v=abs(v(rbl_st_p20mv)-v(ref_st_p20mv))

* ---- instance 12: st_p50mv ----
vpa_st_p50mv pa_st_p50mv 0 dc 0.850000
spa_st_p50mv pa_st_p50mv rbl_st_p50mv ctl 0 swpre
crbl_st_p50mv rbl_st_p50mv 0 {C_RBL}
spr_st_p50mv pref_100 ref_st_p50mv ctl 0 swpre
cref_st_p50mv ref_st_p50mv 0 {C_RBL}   $ ASSUMPTION: ideal matched dummy load
XMN1_st_p50mv rbl_st_p50mv ref_st_p50mv vn_st_p50mv 0 sky130_fd_pr__nfet_01v8 L=0.15 W=1 nf=1 ad=0.29 as=0.29 pd=2.58 ps=2.58 mult=1 m=1
XMN2_st_p50mv ref_st_p50mv rbl_st_p50mv vn_st_p50mv 0 sky130_fd_pr__nfet_01v8 L=0.15 W=1 nf=1 ad=0.29 as=0.29 pd=2.58 ps=2.58 mult=1 m=1
XMP1_st_p50mv rbl_st_p50mv ref_st_p50mv vp_st_p50mv vdd sky130_fd_pr__pfet_01v8 L=0.15 W=2 nf=1 ad=0.58 as=0.58 pd=4.58 ps=4.58 mult=1 m=1
XMP2_st_p50mv ref_st_p50mv rbl_st_p50mv vp_st_p50mv vdd sky130_fd_pr__pfet_01v8 L=0.15 W=2 nf=1 ad=0.58 as=0.58 pd=4.58 ps=4.58 mult=1 m=1
XMNF_st_p50mv vn_st_p50mv en 0 0 sky130_fd_pr__nfet_01v8 L=0.15 W=2 nf=1 ad=0.58 as=0.58 pd=4.58 ps=4.58 mult=1 m=1
XMPH_st_p50mv vp_st_p50mv enb vdd vdd sky130_fd_pr__pfet_01v8 L=0.15 W=4 nf=1 ad=1.16 as=1.16 pd=8.58 ps=8.58 mult=1 m=1
bd_st_p50mv d_st_p50mv 0 v=v(rbl_st_p50mv)-v(ref_st_p50mv)
bdabs_st_p50mv dabs_st_p50mv 0 v=abs(v(rbl_st_p50mv)-v(ref_st_p50mv))

* ---- instance 13: st_p100mv ----
vpa_st_p100mv pa_st_p100mv 0 dc 0.900000
spa_st_p100mv pa_st_p100mv rbl_st_p100mv ctl 0 swpre
crbl_st_p100mv rbl_st_p100mv 0 {C_RBL}
spr_st_p100mv pref_100 ref_st_p100mv ctl 0 swpre
cref_st_p100mv ref_st_p100mv 0 {C_RBL}   $ ASSUMPTION: ideal matched dummy load
XMN1_st_p100mv rbl_st_p100mv ref_st_p100mv vn_st_p100mv 0 sky130_fd_pr__nfet_01v8 L=0.15 W=1 nf=1 ad=0.29 as=0.29 pd=2.58 ps=2.58 mult=1 m=1
XMN2_st_p100mv ref_st_p100mv rbl_st_p100mv vn_st_p100mv 0 sky130_fd_pr__nfet_01v8 L=0.15 W=1 nf=1 ad=0.29 as=0.29 pd=2.58 ps=2.58 mult=1 m=1
XMP1_st_p100mv rbl_st_p100mv ref_st_p100mv vp_st_p100mv vdd sky130_fd_pr__pfet_01v8 L=0.15 W=2 nf=1 ad=0.58 as=0.58 pd=4.58 ps=4.58 mult=1 m=1
XMP2_st_p100mv ref_st_p100mv rbl_st_p100mv vp_st_p100mv vdd sky130_fd_pr__pfet_01v8 L=0.15 W=2 nf=1 ad=0.58 as=0.58 pd=4.58 ps=4.58 mult=1 m=1
XMNF_st_p100mv vn_st_p100mv en 0 0 sky130_fd_pr__nfet_01v8 L=0.15 W=2 nf=1 ad=0.58 as=0.58 pd=4.58 ps=4.58 mult=1 m=1
XMPH_st_p100mv vp_st_p100mv enb vdd vdd sky130_fd_pr__pfet_01v8 L=0.15 W=4 nf=1 ad=1.16 as=1.16 pd=8.58 ps=8.58 mult=1 m=1
bd_st_p100mv d_st_p100mv 0 v=v(rbl_st_p100mv)-v(ref_st_p100mv)
bdabs_st_p100mv dabs_st_p100mv 0 v=abs(v(rbl_st_p100mv)-v(ref_st_p100mv))

* ---- instance 14: cell0_r020_n100 ----
spa_cell0_r020_n100 prea rbl_cell0_r020_n100 ctl 0 swpre
XMWR_cell0_r020_n100_0 sn_cell0_r020_n100_0 0 0 0 sky130_fd_pr__nfet_01v8 L=0.15 W=0.42 nf=1 ad=0.1974 as=0.1974 pd=1.78 ps=1.78 nrd=0.69047619047619  nrs=0.69047619047619 sa=0 sb=0 sd=0 mult=1 m=1
XMRD_cell0_r020_n100_0 rbl_cell0_r020_n100 sn_cell0_r020_n100_0 rwl_sel 0 sky130_fd_pr__nfet_01v8 L=0.15 W=0.42 nf=1 ad=0.1974 as=0.1974 pd=1.78 ps=1.78 nrd=0.69047619047619  nrs=0.69047619047619 sa=0 sb=0 sd=0 mult=1 m=1
csn_cell0_r020_n100_0 sn_cell0_r020_n100_0 0 {C_SN}
XMWR_cell0_r020_n100_1 sn_cell0_r020_n100_1 0 0 0 sky130_fd_pr__nfet_01v8 L=0.15 W=0.42 nf=1 ad=0.1974 as=0.1974 pd=1.78 ps=1.78 nrd=0.69047619047619  nrs=0.69047619047619 sa=0 sb=0 sd=0 mult=1 m=1
XMRD_cell0_r020_n100_1 rbl_cell0_r020_n100 sn_cell0_r020_n100_1 rwl_des 0 sky130_fd_pr__nfet_01v8 L=0.15 W=0.42 nf=1 ad=0.1974 as=0.1974 pd=1.78 ps=1.78 nrd=0.69047619047619  nrs=0.69047619047619 sa=0 sb=0 sd=0 mult=1 m=1
csn_cell0_r020_n100_1 sn_cell0_r020_n100_1 0 {C_SN}
XMWR_cell0_r020_n100_2 sn_cell0_r020_n100_2 0 0 0 sky130_fd_pr__nfet_01v8 L=0.15 W=0.42 nf=1 ad=0.1974 as=0.1974 pd=1.78 ps=1.78 nrd=0.69047619047619  nrs=0.69047619047619 sa=0 sb=0 sd=0 mult=1 m=1
XMRD_cell0_r020_n100_2 rbl_cell0_r020_n100 sn_cell0_r020_n100_2 rwl_des 0 sky130_fd_pr__nfet_01v8 L=0.15 W=0.42 nf=1 ad=0.1974 as=0.1974 pd=1.78 ps=1.78 nrd=0.69047619047619  nrs=0.69047619047619 sa=0 sb=0 sd=0 mult=1 m=1
csn_cell0_r020_n100_2 sn_cell0_r020_n100_2 0 {C_SN}
XMWR_cell0_r020_n100_3 sn_cell0_r020_n100_3 0 0 0 sky130_fd_pr__nfet_01v8 L=0.15 W=0.42 nf=1 ad=0.1974 as=0.1974 pd=1.78 ps=1.78 nrd=0.69047619047619  nrs=0.69047619047619 sa=0 sb=0 sd=0 mult=1 m=1
XMRD_cell0_r020_n100_3 rbl_cell0_r020_n100 sn_cell0_r020_n100_3 rwl_des 0 sky130_fd_pr__nfet_01v8 L=0.15 W=0.42 nf=1 ad=0.1974 as=0.1974 pd=1.78 ps=1.78 nrd=0.69047619047619  nrs=0.69047619047619 sa=0 sb=0 sd=0 mult=1 m=1
csn_cell0_r020_n100_3 sn_cell0_r020_n100_3 0 {C_SN}
crbl_cell0_r020_n100 rbl_cell0_r020_n100 0 {C_RBL}
spr_cell0_r020_n100 pref_020 ref_cell0_r020_n100 ctl 0 swpre
cref_cell0_r020_n100 ref_cell0_r020_n100 0 {C_RBL}   $ ASSUMPTION: ideal matched dummy load
XMN1_cell0_r020_n100 rbl_cell0_r020_n100 ref_cell0_r020_n100 vn_cell0_r020_n100 0 sky130_fd_pr__nfet_01v8 L=0.15 W=1 nf=1 ad=0.29 as=0.29 pd=2.58 ps=2.58 mult=1 m=1
XMN2_cell0_r020_n100 ref_cell0_r020_n100 rbl_cell0_r020_n100 vn_cell0_r020_n100 0 sky130_fd_pr__nfet_01v8 L=0.15 W=1 nf=1 ad=0.29 as=0.29 pd=2.58 ps=2.58 mult=1 m=1
XMP1_cell0_r020_n100 rbl_cell0_r020_n100 ref_cell0_r020_n100 vp_cell0_r020_n100 vdd sky130_fd_pr__pfet_01v8 L=0.15 W=2 nf=1 ad=0.58 as=0.58 pd=4.58 ps=4.58 mult=1 m=1
XMP2_cell0_r020_n100 ref_cell0_r020_n100 rbl_cell0_r020_n100 vp_cell0_r020_n100 vdd sky130_fd_pr__pfet_01v8 L=0.15 W=2 nf=1 ad=0.58 as=0.58 pd=4.58 ps=4.58 mult=1 m=1
XMNF_cell0_r020_n100 vn_cell0_r020_n100 en 0 0 sky130_fd_pr__nfet_01v8 L=0.15 W=2 nf=1 ad=0.58 as=0.58 pd=4.58 ps=4.58 mult=1 m=1
XMPH_cell0_r020_n100 vp_cell0_r020_n100 enb vdd vdd sky130_fd_pr__pfet_01v8 L=0.15 W=4 nf=1 ad=1.16 as=1.16 pd=8.58 ps=8.58 mult=1 m=1
bd_cell0_r020_n100 d_cell0_r020_n100 0 v=v(rbl_cell0_r020_n100)-v(ref_cell0_r020_n100)
bdabs_cell0_r020_n100 dabs_cell0_r020_n100 0 v=abs(v(rbl_cell0_r020_n100)-v(ref_cell0_r020_n100))

* ---- instance 15: cell0_r020_0000 ----
spa_cell0_r020_0000 prea rbl_cell0_r020_0000 ctl 0 swpre
XMWR_cell0_r020_0000_0 sn_cell0_r020_0000_0 0 0 0 sky130_fd_pr__nfet_01v8 L=0.15 W=0.42 nf=1 ad=0.1974 as=0.1974 pd=1.78 ps=1.78 nrd=0.69047619047619  nrs=0.69047619047619 sa=0 sb=0 sd=0 mult=1 m=1
XMRD_cell0_r020_0000_0 rbl_cell0_r020_0000 sn_cell0_r020_0000_0 rwl_sel 0 sky130_fd_pr__nfet_01v8 L=0.15 W=0.42 nf=1 ad=0.1974 as=0.1974 pd=1.78 ps=1.78 nrd=0.69047619047619  nrs=0.69047619047619 sa=0 sb=0 sd=0 mult=1 m=1
csn_cell0_r020_0000_0 sn_cell0_r020_0000_0 0 {C_SN}
XMWR_cell0_r020_0000_1 sn_cell0_r020_0000_1 0 0 0 sky130_fd_pr__nfet_01v8 L=0.15 W=0.42 nf=1 ad=0.1974 as=0.1974 pd=1.78 ps=1.78 nrd=0.69047619047619  nrs=0.69047619047619 sa=0 sb=0 sd=0 mult=1 m=1
XMRD_cell0_r020_0000_1 rbl_cell0_r020_0000 sn_cell0_r020_0000_1 rwl_des 0 sky130_fd_pr__nfet_01v8 L=0.15 W=0.42 nf=1 ad=0.1974 as=0.1974 pd=1.78 ps=1.78 nrd=0.69047619047619  nrs=0.69047619047619 sa=0 sb=0 sd=0 mult=1 m=1
csn_cell0_r020_0000_1 sn_cell0_r020_0000_1 0 {C_SN}
XMWR_cell0_r020_0000_2 sn_cell0_r020_0000_2 0 0 0 sky130_fd_pr__nfet_01v8 L=0.15 W=0.42 nf=1 ad=0.1974 as=0.1974 pd=1.78 ps=1.78 nrd=0.69047619047619  nrs=0.69047619047619 sa=0 sb=0 sd=0 mult=1 m=1
XMRD_cell0_r020_0000_2 rbl_cell0_r020_0000 sn_cell0_r020_0000_2 rwl_des 0 sky130_fd_pr__nfet_01v8 L=0.15 W=0.42 nf=1 ad=0.1974 as=0.1974 pd=1.78 ps=1.78 nrd=0.69047619047619  nrs=0.69047619047619 sa=0 sb=0 sd=0 mult=1 m=1
csn_cell0_r020_0000_2 sn_cell0_r020_0000_2 0 {C_SN}
XMWR_cell0_r020_0000_3 sn_cell0_r020_0000_3 0 0 0 sky130_fd_pr__nfet_01v8 L=0.15 W=0.42 nf=1 ad=0.1974 as=0.1974 pd=1.78 ps=1.78 nrd=0.69047619047619  nrs=0.69047619047619 sa=0 sb=0 sd=0 mult=1 m=1
XMRD_cell0_r020_0000_3 rbl_cell0_r020_0000 sn_cell0_r020_0000_3 rwl_des 0 sky130_fd_pr__nfet_01v8 L=0.15 W=0.42 nf=1 ad=0.1974 as=0.1974 pd=1.78 ps=1.78 nrd=0.69047619047619  nrs=0.69047619047619 sa=0 sb=0 sd=0 mult=1 m=1
csn_cell0_r020_0000_3 sn_cell0_r020_0000_3 0 {C_SN}
crbl_cell0_r020_0000 rbl_cell0_r020_0000 0 {C_RBL}
spr_cell0_r020_0000 pref_020 ref_cell0_r020_0000 ctl 0 swpre
cref_cell0_r020_0000 ref_cell0_r020_0000 0 {C_RBL}   $ ASSUMPTION: ideal matched dummy load
XMN1_cell0_r020_0000 rbl_cell0_r020_0000 ref_cell0_r020_0000 vn_cell0_r020_0000 0 sky130_fd_pr__nfet_01v8 L=0.15 W=1 nf=1 ad=0.29 as=0.29 pd=2.58 ps=2.58 mult=1 m=1
XMN2_cell0_r020_0000 ref_cell0_r020_0000 rbl_cell0_r020_0000 vn_cell0_r020_0000 0 sky130_fd_pr__nfet_01v8 L=0.15 W=1 nf=1 ad=0.29 as=0.29 pd=2.58 ps=2.58 mult=1 m=1
XMP1_cell0_r020_0000 rbl_cell0_r020_0000 ref_cell0_r020_0000 vp_cell0_r020_0000 vdd sky130_fd_pr__pfet_01v8 L=0.15 W=2 nf=1 ad=0.58 as=0.58 pd=4.58 ps=4.58 mult=1 m=1
XMP2_cell0_r020_0000 ref_cell0_r020_0000 rbl_cell0_r020_0000 vp_cell0_r020_0000 vdd sky130_fd_pr__pfet_01v8 L=0.15 W=2 nf=1 ad=0.58 as=0.58 pd=4.58 ps=4.58 mult=1 m=1
XMNF_cell0_r020_0000 vn_cell0_r020_0000 en 0 0 sky130_fd_pr__nfet_01v8 L=0.15 W=2 nf=1 ad=0.58 as=0.58 pd=4.58 ps=4.58 mult=1 m=1
XMPH_cell0_r020_0000 vp_cell0_r020_0000 enb vdd vdd sky130_fd_pr__pfet_01v8 L=0.15 W=4 nf=1 ad=1.16 as=1.16 pd=8.58 ps=8.58 mult=1 m=1
bd_cell0_r020_0000 d_cell0_r020_0000 0 v=v(rbl_cell0_r020_0000)-v(ref_cell0_r020_0000)
bdabs_cell0_r020_0000 dabs_cell0_r020_0000 0 v=abs(v(rbl_cell0_r020_0000)-v(ref_cell0_r020_0000))

* ---- instance 16: cell1_r020_0300 ----
spa_cell1_r020_0300 prea rbl_cell1_r020_0300 ctl 0 swpre
XMWR_cell1_r020_0300_0 sn_cell1_r020_0300_0 0 0 0 sky130_fd_pr__nfet_01v8 L=0.15 W=0.42 nf=1 ad=0.1974 as=0.1974 pd=1.78 ps=1.78 nrd=0.69047619047619  nrs=0.69047619047619 sa=0 sb=0 sd=0 mult=1 m=1
XMRD_cell1_r020_0300_0 rbl_cell1_r020_0300 sn_cell1_r020_0300_0 rwl_sel 0 sky130_fd_pr__nfet_01v8 L=0.15 W=0.42 nf=1 ad=0.1974 as=0.1974 pd=1.78 ps=1.78 nrd=0.69047619047619  nrs=0.69047619047619 sa=0 sb=0 sd=0 mult=1 m=1
csn_cell1_r020_0300_0 sn_cell1_r020_0300_0 0 {C_SN}
XMWR_cell1_r020_0300_1 sn_cell1_r020_0300_1 0 0 0 sky130_fd_pr__nfet_01v8 L=0.15 W=0.42 nf=1 ad=0.1974 as=0.1974 pd=1.78 ps=1.78 nrd=0.69047619047619  nrs=0.69047619047619 sa=0 sb=0 sd=0 mult=1 m=1
XMRD_cell1_r020_0300_1 rbl_cell1_r020_0300 sn_cell1_r020_0300_1 rwl_des 0 sky130_fd_pr__nfet_01v8 L=0.15 W=0.42 nf=1 ad=0.1974 as=0.1974 pd=1.78 ps=1.78 nrd=0.69047619047619  nrs=0.69047619047619 sa=0 sb=0 sd=0 mult=1 m=1
csn_cell1_r020_0300_1 sn_cell1_r020_0300_1 0 {C_SN}
XMWR_cell1_r020_0300_2 sn_cell1_r020_0300_2 0 0 0 sky130_fd_pr__nfet_01v8 L=0.15 W=0.42 nf=1 ad=0.1974 as=0.1974 pd=1.78 ps=1.78 nrd=0.69047619047619  nrs=0.69047619047619 sa=0 sb=0 sd=0 mult=1 m=1
XMRD_cell1_r020_0300_2 rbl_cell1_r020_0300 sn_cell1_r020_0300_2 rwl_des 0 sky130_fd_pr__nfet_01v8 L=0.15 W=0.42 nf=1 ad=0.1974 as=0.1974 pd=1.78 ps=1.78 nrd=0.69047619047619  nrs=0.69047619047619 sa=0 sb=0 sd=0 mult=1 m=1
csn_cell1_r020_0300_2 sn_cell1_r020_0300_2 0 {C_SN}
XMWR_cell1_r020_0300_3 sn_cell1_r020_0300_3 0 0 0 sky130_fd_pr__nfet_01v8 L=0.15 W=0.42 nf=1 ad=0.1974 as=0.1974 pd=1.78 ps=1.78 nrd=0.69047619047619  nrs=0.69047619047619 sa=0 sb=0 sd=0 mult=1 m=1
XMRD_cell1_r020_0300_3 rbl_cell1_r020_0300 sn_cell1_r020_0300_3 rwl_des 0 sky130_fd_pr__nfet_01v8 L=0.15 W=0.42 nf=1 ad=0.1974 as=0.1974 pd=1.78 ps=1.78 nrd=0.69047619047619  nrs=0.69047619047619 sa=0 sb=0 sd=0 mult=1 m=1
csn_cell1_r020_0300_3 sn_cell1_r020_0300_3 0 {C_SN}
crbl_cell1_r020_0300 rbl_cell1_r020_0300 0 {C_RBL}
spr_cell1_r020_0300 pref_020 ref_cell1_r020_0300 ctl 0 swpre
cref_cell1_r020_0300 ref_cell1_r020_0300 0 {C_RBL}   $ ASSUMPTION: ideal matched dummy load
XMN1_cell1_r020_0300 rbl_cell1_r020_0300 ref_cell1_r020_0300 vn_cell1_r020_0300 0 sky130_fd_pr__nfet_01v8 L=0.15 W=1 nf=1 ad=0.29 as=0.29 pd=2.58 ps=2.58 mult=1 m=1
XMN2_cell1_r020_0300 ref_cell1_r020_0300 rbl_cell1_r020_0300 vn_cell1_r020_0300 0 sky130_fd_pr__nfet_01v8 L=0.15 W=1 nf=1 ad=0.29 as=0.29 pd=2.58 ps=2.58 mult=1 m=1
XMP1_cell1_r020_0300 rbl_cell1_r020_0300 ref_cell1_r020_0300 vp_cell1_r020_0300 vdd sky130_fd_pr__pfet_01v8 L=0.15 W=2 nf=1 ad=0.58 as=0.58 pd=4.58 ps=4.58 mult=1 m=1
XMP2_cell1_r020_0300 ref_cell1_r020_0300 rbl_cell1_r020_0300 vp_cell1_r020_0300 vdd sky130_fd_pr__pfet_01v8 L=0.15 W=2 nf=1 ad=0.58 as=0.58 pd=4.58 ps=4.58 mult=1 m=1
XMNF_cell1_r020_0300 vn_cell1_r020_0300 en 0 0 sky130_fd_pr__nfet_01v8 L=0.15 W=2 nf=1 ad=0.58 as=0.58 pd=4.58 ps=4.58 mult=1 m=1
XMPH_cell1_r020_0300 vp_cell1_r020_0300 enb vdd vdd sky130_fd_pr__pfet_01v8 L=0.15 W=4 nf=1 ad=1.16 as=1.16 pd=8.58 ps=8.58 mult=1 m=1
bd_cell1_r020_0300 d_cell1_r020_0300 0 v=v(rbl_cell1_r020_0300)-v(ref_cell1_r020_0300)
bdabs_cell1_r020_0300 dabs_cell1_r020_0300 0 v=abs(v(rbl_cell1_r020_0300)-v(ref_cell1_r020_0300))

* ---- instance 17: cell1_r020_0350 ----
spa_cell1_r020_0350 prea rbl_cell1_r020_0350 ctl 0 swpre
XMWR_cell1_r020_0350_0 sn_cell1_r020_0350_0 0 0 0 sky130_fd_pr__nfet_01v8 L=0.15 W=0.42 nf=1 ad=0.1974 as=0.1974 pd=1.78 ps=1.78 nrd=0.69047619047619  nrs=0.69047619047619 sa=0 sb=0 sd=0 mult=1 m=1
XMRD_cell1_r020_0350_0 rbl_cell1_r020_0350 sn_cell1_r020_0350_0 rwl_sel 0 sky130_fd_pr__nfet_01v8 L=0.15 W=0.42 nf=1 ad=0.1974 as=0.1974 pd=1.78 ps=1.78 nrd=0.69047619047619  nrs=0.69047619047619 sa=0 sb=0 sd=0 mult=1 m=1
csn_cell1_r020_0350_0 sn_cell1_r020_0350_0 0 {C_SN}
XMWR_cell1_r020_0350_1 sn_cell1_r020_0350_1 0 0 0 sky130_fd_pr__nfet_01v8 L=0.15 W=0.42 nf=1 ad=0.1974 as=0.1974 pd=1.78 ps=1.78 nrd=0.69047619047619  nrs=0.69047619047619 sa=0 sb=0 sd=0 mult=1 m=1
XMRD_cell1_r020_0350_1 rbl_cell1_r020_0350 sn_cell1_r020_0350_1 rwl_des 0 sky130_fd_pr__nfet_01v8 L=0.15 W=0.42 nf=1 ad=0.1974 as=0.1974 pd=1.78 ps=1.78 nrd=0.69047619047619  nrs=0.69047619047619 sa=0 sb=0 sd=0 mult=1 m=1
csn_cell1_r020_0350_1 sn_cell1_r020_0350_1 0 {C_SN}
XMWR_cell1_r020_0350_2 sn_cell1_r020_0350_2 0 0 0 sky130_fd_pr__nfet_01v8 L=0.15 W=0.42 nf=1 ad=0.1974 as=0.1974 pd=1.78 ps=1.78 nrd=0.69047619047619  nrs=0.69047619047619 sa=0 sb=0 sd=0 mult=1 m=1
XMRD_cell1_r020_0350_2 rbl_cell1_r020_0350 sn_cell1_r020_0350_2 rwl_des 0 sky130_fd_pr__nfet_01v8 L=0.15 W=0.42 nf=1 ad=0.1974 as=0.1974 pd=1.78 ps=1.78 nrd=0.69047619047619  nrs=0.69047619047619 sa=0 sb=0 sd=0 mult=1 m=1
csn_cell1_r020_0350_2 sn_cell1_r020_0350_2 0 {C_SN}
XMWR_cell1_r020_0350_3 sn_cell1_r020_0350_3 0 0 0 sky130_fd_pr__nfet_01v8 L=0.15 W=0.42 nf=1 ad=0.1974 as=0.1974 pd=1.78 ps=1.78 nrd=0.69047619047619  nrs=0.69047619047619 sa=0 sb=0 sd=0 mult=1 m=1
XMRD_cell1_r020_0350_3 rbl_cell1_r020_0350 sn_cell1_r020_0350_3 rwl_des 0 sky130_fd_pr__nfet_01v8 L=0.15 W=0.42 nf=1 ad=0.1974 as=0.1974 pd=1.78 ps=1.78 nrd=0.69047619047619  nrs=0.69047619047619 sa=0 sb=0 sd=0 mult=1 m=1
csn_cell1_r020_0350_3 sn_cell1_r020_0350_3 0 {C_SN}
crbl_cell1_r020_0350 rbl_cell1_r020_0350 0 {C_RBL}
spr_cell1_r020_0350 pref_020 ref_cell1_r020_0350 ctl 0 swpre
cref_cell1_r020_0350 ref_cell1_r020_0350 0 {C_RBL}   $ ASSUMPTION: ideal matched dummy load
XMN1_cell1_r020_0350 rbl_cell1_r020_0350 ref_cell1_r020_0350 vn_cell1_r020_0350 0 sky130_fd_pr__nfet_01v8 L=0.15 W=1 nf=1 ad=0.29 as=0.29 pd=2.58 ps=2.58 mult=1 m=1
XMN2_cell1_r020_0350 ref_cell1_r020_0350 rbl_cell1_r020_0350 vn_cell1_r020_0350 0 sky130_fd_pr__nfet_01v8 L=0.15 W=1 nf=1 ad=0.29 as=0.29 pd=2.58 ps=2.58 mult=1 m=1
XMP1_cell1_r020_0350 rbl_cell1_r020_0350 ref_cell1_r020_0350 vp_cell1_r020_0350 vdd sky130_fd_pr__pfet_01v8 L=0.15 W=2 nf=1 ad=0.58 as=0.58 pd=4.58 ps=4.58 mult=1 m=1
XMP2_cell1_r020_0350 ref_cell1_r020_0350 rbl_cell1_r020_0350 vp_cell1_r020_0350 vdd sky130_fd_pr__pfet_01v8 L=0.15 W=2 nf=1 ad=0.58 as=0.58 pd=4.58 ps=4.58 mult=1 m=1
XMNF_cell1_r020_0350 vn_cell1_r020_0350 en 0 0 sky130_fd_pr__nfet_01v8 L=0.15 W=2 nf=1 ad=0.58 as=0.58 pd=4.58 ps=4.58 mult=1 m=1
XMPH_cell1_r020_0350 vp_cell1_r020_0350 enb vdd vdd sky130_fd_pr__pfet_01v8 L=0.15 W=4 nf=1 ad=1.16 as=1.16 pd=8.58 ps=8.58 mult=1 m=1
bd_cell1_r020_0350 d_cell1_r020_0350 0 v=v(rbl_cell1_r020_0350)-v(ref_cell1_r020_0350)
bdabs_cell1_r020_0350 dabs_cell1_r020_0350 0 v=abs(v(rbl_cell1_r020_0350)-v(ref_cell1_r020_0350))

* ---- instance 18: cell1_r020_0400 ----
spa_cell1_r020_0400 prea rbl_cell1_r020_0400 ctl 0 swpre
XMWR_cell1_r020_0400_0 sn_cell1_r020_0400_0 0 0 0 sky130_fd_pr__nfet_01v8 L=0.15 W=0.42 nf=1 ad=0.1974 as=0.1974 pd=1.78 ps=1.78 nrd=0.69047619047619  nrs=0.69047619047619 sa=0 sb=0 sd=0 mult=1 m=1
XMRD_cell1_r020_0400_0 rbl_cell1_r020_0400 sn_cell1_r020_0400_0 rwl_sel 0 sky130_fd_pr__nfet_01v8 L=0.15 W=0.42 nf=1 ad=0.1974 as=0.1974 pd=1.78 ps=1.78 nrd=0.69047619047619  nrs=0.69047619047619 sa=0 sb=0 sd=0 mult=1 m=1
csn_cell1_r020_0400_0 sn_cell1_r020_0400_0 0 {C_SN}
XMWR_cell1_r020_0400_1 sn_cell1_r020_0400_1 0 0 0 sky130_fd_pr__nfet_01v8 L=0.15 W=0.42 nf=1 ad=0.1974 as=0.1974 pd=1.78 ps=1.78 nrd=0.69047619047619  nrs=0.69047619047619 sa=0 sb=0 sd=0 mult=1 m=1
XMRD_cell1_r020_0400_1 rbl_cell1_r020_0400 sn_cell1_r020_0400_1 rwl_des 0 sky130_fd_pr__nfet_01v8 L=0.15 W=0.42 nf=1 ad=0.1974 as=0.1974 pd=1.78 ps=1.78 nrd=0.69047619047619  nrs=0.69047619047619 sa=0 sb=0 sd=0 mult=1 m=1
csn_cell1_r020_0400_1 sn_cell1_r020_0400_1 0 {C_SN}
XMWR_cell1_r020_0400_2 sn_cell1_r020_0400_2 0 0 0 sky130_fd_pr__nfet_01v8 L=0.15 W=0.42 nf=1 ad=0.1974 as=0.1974 pd=1.78 ps=1.78 nrd=0.69047619047619  nrs=0.69047619047619 sa=0 sb=0 sd=0 mult=1 m=1
XMRD_cell1_r020_0400_2 rbl_cell1_r020_0400 sn_cell1_r020_0400_2 rwl_des 0 sky130_fd_pr__nfet_01v8 L=0.15 W=0.42 nf=1 ad=0.1974 as=0.1974 pd=1.78 ps=1.78 nrd=0.69047619047619  nrs=0.69047619047619 sa=0 sb=0 sd=0 mult=1 m=1
csn_cell1_r020_0400_2 sn_cell1_r020_0400_2 0 {C_SN}
XMWR_cell1_r020_0400_3 sn_cell1_r020_0400_3 0 0 0 sky130_fd_pr__nfet_01v8 L=0.15 W=0.42 nf=1 ad=0.1974 as=0.1974 pd=1.78 ps=1.78 nrd=0.69047619047619  nrs=0.69047619047619 sa=0 sb=0 sd=0 mult=1 m=1
XMRD_cell1_r020_0400_3 rbl_cell1_r020_0400 sn_cell1_r020_0400_3 rwl_des 0 sky130_fd_pr__nfet_01v8 L=0.15 W=0.42 nf=1 ad=0.1974 as=0.1974 pd=1.78 ps=1.78 nrd=0.69047619047619  nrs=0.69047619047619 sa=0 sb=0 sd=0 mult=1 m=1
csn_cell1_r020_0400_3 sn_cell1_r020_0400_3 0 {C_SN}
crbl_cell1_r020_0400 rbl_cell1_r020_0400 0 {C_RBL}
spr_cell1_r020_0400 pref_020 ref_cell1_r020_0400 ctl 0 swpre
cref_cell1_r020_0400 ref_cell1_r020_0400 0 {C_RBL}   $ ASSUMPTION: ideal matched dummy load
XMN1_cell1_r020_0400 rbl_cell1_r020_0400 ref_cell1_r020_0400 vn_cell1_r020_0400 0 sky130_fd_pr__nfet_01v8 L=0.15 W=1 nf=1 ad=0.29 as=0.29 pd=2.58 ps=2.58 mult=1 m=1
XMN2_cell1_r020_0400 ref_cell1_r020_0400 rbl_cell1_r020_0400 vn_cell1_r020_0400 0 sky130_fd_pr__nfet_01v8 L=0.15 W=1 nf=1 ad=0.29 as=0.29 pd=2.58 ps=2.58 mult=1 m=1
XMP1_cell1_r020_0400 rbl_cell1_r020_0400 ref_cell1_r020_0400 vp_cell1_r020_0400 vdd sky130_fd_pr__pfet_01v8 L=0.15 W=2 nf=1 ad=0.58 as=0.58 pd=4.58 ps=4.58 mult=1 m=1
XMP2_cell1_r020_0400 ref_cell1_r020_0400 rbl_cell1_r020_0400 vp_cell1_r020_0400 vdd sky130_fd_pr__pfet_01v8 L=0.15 W=2 nf=1 ad=0.58 as=0.58 pd=4.58 ps=4.58 mult=1 m=1
XMNF_cell1_r020_0400 vn_cell1_r020_0400 en 0 0 sky130_fd_pr__nfet_01v8 L=0.15 W=2 nf=1 ad=0.58 as=0.58 pd=4.58 ps=4.58 mult=1 m=1
XMPH_cell1_r020_0400 vp_cell1_r020_0400 enb vdd vdd sky130_fd_pr__pfet_01v8 L=0.15 W=4 nf=1 ad=1.16 as=1.16 pd=8.58 ps=8.58 mult=1 m=1
bd_cell1_r020_0400 d_cell1_r020_0400 0 v=v(rbl_cell1_r020_0400)-v(ref_cell1_r020_0400)
bdabs_cell1_r020_0400 dabs_cell1_r020_0400 0 v=abs(v(rbl_cell1_r020_0400)-v(ref_cell1_r020_0400))

* ---- instance 19: cell1_r020_0450 ----
spa_cell1_r020_0450 prea rbl_cell1_r020_0450 ctl 0 swpre
XMWR_cell1_r020_0450_0 sn_cell1_r020_0450_0 0 0 0 sky130_fd_pr__nfet_01v8 L=0.15 W=0.42 nf=1 ad=0.1974 as=0.1974 pd=1.78 ps=1.78 nrd=0.69047619047619  nrs=0.69047619047619 sa=0 sb=0 sd=0 mult=1 m=1
XMRD_cell1_r020_0450_0 rbl_cell1_r020_0450 sn_cell1_r020_0450_0 rwl_sel 0 sky130_fd_pr__nfet_01v8 L=0.15 W=0.42 nf=1 ad=0.1974 as=0.1974 pd=1.78 ps=1.78 nrd=0.69047619047619  nrs=0.69047619047619 sa=0 sb=0 sd=0 mult=1 m=1
csn_cell1_r020_0450_0 sn_cell1_r020_0450_0 0 {C_SN}
XMWR_cell1_r020_0450_1 sn_cell1_r020_0450_1 0 0 0 sky130_fd_pr__nfet_01v8 L=0.15 W=0.42 nf=1 ad=0.1974 as=0.1974 pd=1.78 ps=1.78 nrd=0.69047619047619  nrs=0.69047619047619 sa=0 sb=0 sd=0 mult=1 m=1
XMRD_cell1_r020_0450_1 rbl_cell1_r020_0450 sn_cell1_r020_0450_1 rwl_des 0 sky130_fd_pr__nfet_01v8 L=0.15 W=0.42 nf=1 ad=0.1974 as=0.1974 pd=1.78 ps=1.78 nrd=0.69047619047619  nrs=0.69047619047619 sa=0 sb=0 sd=0 mult=1 m=1
csn_cell1_r020_0450_1 sn_cell1_r020_0450_1 0 {C_SN}
XMWR_cell1_r020_0450_2 sn_cell1_r020_0450_2 0 0 0 sky130_fd_pr__nfet_01v8 L=0.15 W=0.42 nf=1 ad=0.1974 as=0.1974 pd=1.78 ps=1.78 nrd=0.69047619047619  nrs=0.69047619047619 sa=0 sb=0 sd=0 mult=1 m=1
XMRD_cell1_r020_0450_2 rbl_cell1_r020_0450 sn_cell1_r020_0450_2 rwl_des 0 sky130_fd_pr__nfet_01v8 L=0.15 W=0.42 nf=1 ad=0.1974 as=0.1974 pd=1.78 ps=1.78 nrd=0.69047619047619  nrs=0.69047619047619 sa=0 sb=0 sd=0 mult=1 m=1
csn_cell1_r020_0450_2 sn_cell1_r020_0450_2 0 {C_SN}
XMWR_cell1_r020_0450_3 sn_cell1_r020_0450_3 0 0 0 sky130_fd_pr__nfet_01v8 L=0.15 W=0.42 nf=1 ad=0.1974 as=0.1974 pd=1.78 ps=1.78 nrd=0.69047619047619  nrs=0.69047619047619 sa=0 sb=0 sd=0 mult=1 m=1
XMRD_cell1_r020_0450_3 rbl_cell1_r020_0450 sn_cell1_r020_0450_3 rwl_des 0 sky130_fd_pr__nfet_01v8 L=0.15 W=0.42 nf=1 ad=0.1974 as=0.1974 pd=1.78 ps=1.78 nrd=0.69047619047619  nrs=0.69047619047619 sa=0 sb=0 sd=0 mult=1 m=1
csn_cell1_r020_0450_3 sn_cell1_r020_0450_3 0 {C_SN}
crbl_cell1_r020_0450 rbl_cell1_r020_0450 0 {C_RBL}
spr_cell1_r020_0450 pref_020 ref_cell1_r020_0450 ctl 0 swpre
cref_cell1_r020_0450 ref_cell1_r020_0450 0 {C_RBL}   $ ASSUMPTION: ideal matched dummy load
XMN1_cell1_r020_0450 rbl_cell1_r020_0450 ref_cell1_r020_0450 vn_cell1_r020_0450 0 sky130_fd_pr__nfet_01v8 L=0.15 W=1 nf=1 ad=0.29 as=0.29 pd=2.58 ps=2.58 mult=1 m=1
XMN2_cell1_r020_0450 ref_cell1_r020_0450 rbl_cell1_r020_0450 vn_cell1_r020_0450 0 sky130_fd_pr__nfet_01v8 L=0.15 W=1 nf=1 ad=0.29 as=0.29 pd=2.58 ps=2.58 mult=1 m=1
XMP1_cell1_r020_0450 rbl_cell1_r020_0450 ref_cell1_r020_0450 vp_cell1_r020_0450 vdd sky130_fd_pr__pfet_01v8 L=0.15 W=2 nf=1 ad=0.58 as=0.58 pd=4.58 ps=4.58 mult=1 m=1
XMP2_cell1_r020_0450 ref_cell1_r020_0450 rbl_cell1_r020_0450 vp_cell1_r020_0450 vdd sky130_fd_pr__pfet_01v8 L=0.15 W=2 nf=1 ad=0.58 as=0.58 pd=4.58 ps=4.58 mult=1 m=1
XMNF_cell1_r020_0450 vn_cell1_r020_0450 en 0 0 sky130_fd_pr__nfet_01v8 L=0.15 W=2 nf=1 ad=0.58 as=0.58 pd=4.58 ps=4.58 mult=1 m=1
XMPH_cell1_r020_0450 vp_cell1_r020_0450 enb vdd vdd sky130_fd_pr__pfet_01v8 L=0.15 W=4 nf=1 ad=1.16 as=1.16 pd=8.58 ps=8.58 mult=1 m=1
bd_cell1_r020_0450 d_cell1_r020_0450 0 v=v(rbl_cell1_r020_0450)-v(ref_cell1_r020_0450)
bdabs_cell1_r020_0450 dabs_cell1_r020_0450 0 v=abs(v(rbl_cell1_r020_0450)-v(ref_cell1_r020_0450))

* ---- instance 20: cell1_r020_0500 ----
spa_cell1_r020_0500 prea rbl_cell1_r020_0500 ctl 0 swpre
XMWR_cell1_r020_0500_0 sn_cell1_r020_0500_0 0 0 0 sky130_fd_pr__nfet_01v8 L=0.15 W=0.42 nf=1 ad=0.1974 as=0.1974 pd=1.78 ps=1.78 nrd=0.69047619047619  nrs=0.69047619047619 sa=0 sb=0 sd=0 mult=1 m=1
XMRD_cell1_r020_0500_0 rbl_cell1_r020_0500 sn_cell1_r020_0500_0 rwl_sel 0 sky130_fd_pr__nfet_01v8 L=0.15 W=0.42 nf=1 ad=0.1974 as=0.1974 pd=1.78 ps=1.78 nrd=0.69047619047619  nrs=0.69047619047619 sa=0 sb=0 sd=0 mult=1 m=1
csn_cell1_r020_0500_0 sn_cell1_r020_0500_0 0 {C_SN}
XMWR_cell1_r020_0500_1 sn_cell1_r020_0500_1 0 0 0 sky130_fd_pr__nfet_01v8 L=0.15 W=0.42 nf=1 ad=0.1974 as=0.1974 pd=1.78 ps=1.78 nrd=0.69047619047619  nrs=0.69047619047619 sa=0 sb=0 sd=0 mult=1 m=1
XMRD_cell1_r020_0500_1 rbl_cell1_r020_0500 sn_cell1_r020_0500_1 rwl_des 0 sky130_fd_pr__nfet_01v8 L=0.15 W=0.42 nf=1 ad=0.1974 as=0.1974 pd=1.78 ps=1.78 nrd=0.69047619047619  nrs=0.69047619047619 sa=0 sb=0 sd=0 mult=1 m=1
csn_cell1_r020_0500_1 sn_cell1_r020_0500_1 0 {C_SN}
XMWR_cell1_r020_0500_2 sn_cell1_r020_0500_2 0 0 0 sky130_fd_pr__nfet_01v8 L=0.15 W=0.42 nf=1 ad=0.1974 as=0.1974 pd=1.78 ps=1.78 nrd=0.69047619047619  nrs=0.69047619047619 sa=0 sb=0 sd=0 mult=1 m=1
XMRD_cell1_r020_0500_2 rbl_cell1_r020_0500 sn_cell1_r020_0500_2 rwl_des 0 sky130_fd_pr__nfet_01v8 L=0.15 W=0.42 nf=1 ad=0.1974 as=0.1974 pd=1.78 ps=1.78 nrd=0.69047619047619  nrs=0.69047619047619 sa=0 sb=0 sd=0 mult=1 m=1
csn_cell1_r020_0500_2 sn_cell1_r020_0500_2 0 {C_SN}
XMWR_cell1_r020_0500_3 sn_cell1_r020_0500_3 0 0 0 sky130_fd_pr__nfet_01v8 L=0.15 W=0.42 nf=1 ad=0.1974 as=0.1974 pd=1.78 ps=1.78 nrd=0.69047619047619  nrs=0.69047619047619 sa=0 sb=0 sd=0 mult=1 m=1
XMRD_cell1_r020_0500_3 rbl_cell1_r020_0500 sn_cell1_r020_0500_3 rwl_des 0 sky130_fd_pr__nfet_01v8 L=0.15 W=0.42 nf=1 ad=0.1974 as=0.1974 pd=1.78 ps=1.78 nrd=0.69047619047619  nrs=0.69047619047619 sa=0 sb=0 sd=0 mult=1 m=1
csn_cell1_r020_0500_3 sn_cell1_r020_0500_3 0 {C_SN}
crbl_cell1_r020_0500 rbl_cell1_r020_0500 0 {C_RBL}
spr_cell1_r020_0500 pref_020 ref_cell1_r020_0500 ctl 0 swpre
cref_cell1_r020_0500 ref_cell1_r020_0500 0 {C_RBL}   $ ASSUMPTION: ideal matched dummy load
XMN1_cell1_r020_0500 rbl_cell1_r020_0500 ref_cell1_r020_0500 vn_cell1_r020_0500 0 sky130_fd_pr__nfet_01v8 L=0.15 W=1 nf=1 ad=0.29 as=0.29 pd=2.58 ps=2.58 mult=1 m=1
XMN2_cell1_r020_0500 ref_cell1_r020_0500 rbl_cell1_r020_0500 vn_cell1_r020_0500 0 sky130_fd_pr__nfet_01v8 L=0.15 W=1 nf=1 ad=0.29 as=0.29 pd=2.58 ps=2.58 mult=1 m=1
XMP1_cell1_r020_0500 rbl_cell1_r020_0500 ref_cell1_r020_0500 vp_cell1_r020_0500 vdd sky130_fd_pr__pfet_01v8 L=0.15 W=2 nf=1 ad=0.58 as=0.58 pd=4.58 ps=4.58 mult=1 m=1
XMP2_cell1_r020_0500 ref_cell1_r020_0500 rbl_cell1_r020_0500 vp_cell1_r020_0500 vdd sky130_fd_pr__pfet_01v8 L=0.15 W=2 nf=1 ad=0.58 as=0.58 pd=4.58 ps=4.58 mult=1 m=1
XMNF_cell1_r020_0500 vn_cell1_r020_0500 en 0 0 sky130_fd_pr__nfet_01v8 L=0.15 W=2 nf=1 ad=0.58 as=0.58 pd=4.58 ps=4.58 mult=1 m=1
XMPH_cell1_r020_0500 vp_cell1_r020_0500 enb vdd vdd sky130_fd_pr__pfet_01v8 L=0.15 W=4 nf=1 ad=1.16 as=1.16 pd=8.58 ps=8.58 mult=1 m=1
bd_cell1_r020_0500 d_cell1_r020_0500 0 v=v(rbl_cell1_r020_0500)-v(ref_cell1_r020_0500)
bdabs_cell1_r020_0500 dabs_cell1_r020_0500 0 v=abs(v(rbl_cell1_r020_0500)-v(ref_cell1_r020_0500))

* ---- instance 21: cell1_r020_0550 ----
spa_cell1_r020_0550 prea rbl_cell1_r020_0550 ctl 0 swpre
XMWR_cell1_r020_0550_0 sn_cell1_r020_0550_0 0 0 0 sky130_fd_pr__nfet_01v8 L=0.15 W=0.42 nf=1 ad=0.1974 as=0.1974 pd=1.78 ps=1.78 nrd=0.69047619047619  nrs=0.69047619047619 sa=0 sb=0 sd=0 mult=1 m=1
XMRD_cell1_r020_0550_0 rbl_cell1_r020_0550 sn_cell1_r020_0550_0 rwl_sel 0 sky130_fd_pr__nfet_01v8 L=0.15 W=0.42 nf=1 ad=0.1974 as=0.1974 pd=1.78 ps=1.78 nrd=0.69047619047619  nrs=0.69047619047619 sa=0 sb=0 sd=0 mult=1 m=1
csn_cell1_r020_0550_0 sn_cell1_r020_0550_0 0 {C_SN}
XMWR_cell1_r020_0550_1 sn_cell1_r020_0550_1 0 0 0 sky130_fd_pr__nfet_01v8 L=0.15 W=0.42 nf=1 ad=0.1974 as=0.1974 pd=1.78 ps=1.78 nrd=0.69047619047619  nrs=0.69047619047619 sa=0 sb=0 sd=0 mult=1 m=1
XMRD_cell1_r020_0550_1 rbl_cell1_r020_0550 sn_cell1_r020_0550_1 rwl_des 0 sky130_fd_pr__nfet_01v8 L=0.15 W=0.42 nf=1 ad=0.1974 as=0.1974 pd=1.78 ps=1.78 nrd=0.69047619047619  nrs=0.69047619047619 sa=0 sb=0 sd=0 mult=1 m=1
csn_cell1_r020_0550_1 sn_cell1_r020_0550_1 0 {C_SN}
XMWR_cell1_r020_0550_2 sn_cell1_r020_0550_2 0 0 0 sky130_fd_pr__nfet_01v8 L=0.15 W=0.42 nf=1 ad=0.1974 as=0.1974 pd=1.78 ps=1.78 nrd=0.69047619047619  nrs=0.69047619047619 sa=0 sb=0 sd=0 mult=1 m=1
XMRD_cell1_r020_0550_2 rbl_cell1_r020_0550 sn_cell1_r020_0550_2 rwl_des 0 sky130_fd_pr__nfet_01v8 L=0.15 W=0.42 nf=1 ad=0.1974 as=0.1974 pd=1.78 ps=1.78 nrd=0.69047619047619  nrs=0.69047619047619 sa=0 sb=0 sd=0 mult=1 m=1
csn_cell1_r020_0550_2 sn_cell1_r020_0550_2 0 {C_SN}
XMWR_cell1_r020_0550_3 sn_cell1_r020_0550_3 0 0 0 sky130_fd_pr__nfet_01v8 L=0.15 W=0.42 nf=1 ad=0.1974 as=0.1974 pd=1.78 ps=1.78 nrd=0.69047619047619  nrs=0.69047619047619 sa=0 sb=0 sd=0 mult=1 m=1
XMRD_cell1_r020_0550_3 rbl_cell1_r020_0550 sn_cell1_r020_0550_3 rwl_des 0 sky130_fd_pr__nfet_01v8 L=0.15 W=0.42 nf=1 ad=0.1974 as=0.1974 pd=1.78 ps=1.78 nrd=0.69047619047619  nrs=0.69047619047619 sa=0 sb=0 sd=0 mult=1 m=1
csn_cell1_r020_0550_3 sn_cell1_r020_0550_3 0 {C_SN}
crbl_cell1_r020_0550 rbl_cell1_r020_0550 0 {C_RBL}
spr_cell1_r020_0550 pref_020 ref_cell1_r020_0550 ctl 0 swpre
cref_cell1_r020_0550 ref_cell1_r020_0550 0 {C_RBL}   $ ASSUMPTION: ideal matched dummy load
XMN1_cell1_r020_0550 rbl_cell1_r020_0550 ref_cell1_r020_0550 vn_cell1_r020_0550 0 sky130_fd_pr__nfet_01v8 L=0.15 W=1 nf=1 ad=0.29 as=0.29 pd=2.58 ps=2.58 mult=1 m=1
XMN2_cell1_r020_0550 ref_cell1_r020_0550 rbl_cell1_r020_0550 vn_cell1_r020_0550 0 sky130_fd_pr__nfet_01v8 L=0.15 W=1 nf=1 ad=0.29 as=0.29 pd=2.58 ps=2.58 mult=1 m=1
XMP1_cell1_r020_0550 rbl_cell1_r020_0550 ref_cell1_r020_0550 vp_cell1_r020_0550 vdd sky130_fd_pr__pfet_01v8 L=0.15 W=2 nf=1 ad=0.58 as=0.58 pd=4.58 ps=4.58 mult=1 m=1
XMP2_cell1_r020_0550 ref_cell1_r020_0550 rbl_cell1_r020_0550 vp_cell1_r020_0550 vdd sky130_fd_pr__pfet_01v8 L=0.15 W=2 nf=1 ad=0.58 as=0.58 pd=4.58 ps=4.58 mult=1 m=1
XMNF_cell1_r020_0550 vn_cell1_r020_0550 en 0 0 sky130_fd_pr__nfet_01v8 L=0.15 W=2 nf=1 ad=0.58 as=0.58 pd=4.58 ps=4.58 mult=1 m=1
XMPH_cell1_r020_0550 vp_cell1_r020_0550 enb vdd vdd sky130_fd_pr__pfet_01v8 L=0.15 W=4 nf=1 ad=1.16 as=1.16 pd=8.58 ps=8.58 mult=1 m=1
bd_cell1_r020_0550 d_cell1_r020_0550 0 v=v(rbl_cell1_r020_0550)-v(ref_cell1_r020_0550)
bdabs_cell1_r020_0550 dabs_cell1_r020_0550 0 v=abs(v(rbl_cell1_r020_0550)-v(ref_cell1_r020_0550))

* ---- instance 22: cell1_r020_0600 ----
spa_cell1_r020_0600 prea rbl_cell1_r020_0600 ctl 0 swpre
XMWR_cell1_r020_0600_0 sn_cell1_r020_0600_0 0 0 0 sky130_fd_pr__nfet_01v8 L=0.15 W=0.42 nf=1 ad=0.1974 as=0.1974 pd=1.78 ps=1.78 nrd=0.69047619047619  nrs=0.69047619047619 sa=0 sb=0 sd=0 mult=1 m=1
XMRD_cell1_r020_0600_0 rbl_cell1_r020_0600 sn_cell1_r020_0600_0 rwl_sel 0 sky130_fd_pr__nfet_01v8 L=0.15 W=0.42 nf=1 ad=0.1974 as=0.1974 pd=1.78 ps=1.78 nrd=0.69047619047619  nrs=0.69047619047619 sa=0 sb=0 sd=0 mult=1 m=1
csn_cell1_r020_0600_0 sn_cell1_r020_0600_0 0 {C_SN}
XMWR_cell1_r020_0600_1 sn_cell1_r020_0600_1 0 0 0 sky130_fd_pr__nfet_01v8 L=0.15 W=0.42 nf=1 ad=0.1974 as=0.1974 pd=1.78 ps=1.78 nrd=0.69047619047619  nrs=0.69047619047619 sa=0 sb=0 sd=0 mult=1 m=1
XMRD_cell1_r020_0600_1 rbl_cell1_r020_0600 sn_cell1_r020_0600_1 rwl_des 0 sky130_fd_pr__nfet_01v8 L=0.15 W=0.42 nf=1 ad=0.1974 as=0.1974 pd=1.78 ps=1.78 nrd=0.69047619047619  nrs=0.69047619047619 sa=0 sb=0 sd=0 mult=1 m=1
csn_cell1_r020_0600_1 sn_cell1_r020_0600_1 0 {C_SN}
XMWR_cell1_r020_0600_2 sn_cell1_r020_0600_2 0 0 0 sky130_fd_pr__nfet_01v8 L=0.15 W=0.42 nf=1 ad=0.1974 as=0.1974 pd=1.78 ps=1.78 nrd=0.69047619047619  nrs=0.69047619047619 sa=0 sb=0 sd=0 mult=1 m=1
XMRD_cell1_r020_0600_2 rbl_cell1_r020_0600 sn_cell1_r020_0600_2 rwl_des 0 sky130_fd_pr__nfet_01v8 L=0.15 W=0.42 nf=1 ad=0.1974 as=0.1974 pd=1.78 ps=1.78 nrd=0.69047619047619  nrs=0.69047619047619 sa=0 sb=0 sd=0 mult=1 m=1
csn_cell1_r020_0600_2 sn_cell1_r020_0600_2 0 {C_SN}
XMWR_cell1_r020_0600_3 sn_cell1_r020_0600_3 0 0 0 sky130_fd_pr__nfet_01v8 L=0.15 W=0.42 nf=1 ad=0.1974 as=0.1974 pd=1.78 ps=1.78 nrd=0.69047619047619  nrs=0.69047619047619 sa=0 sb=0 sd=0 mult=1 m=1
XMRD_cell1_r020_0600_3 rbl_cell1_r020_0600 sn_cell1_r020_0600_3 rwl_des 0 sky130_fd_pr__nfet_01v8 L=0.15 W=0.42 nf=1 ad=0.1974 as=0.1974 pd=1.78 ps=1.78 nrd=0.69047619047619  nrs=0.69047619047619 sa=0 sb=0 sd=0 mult=1 m=1
csn_cell1_r020_0600_3 sn_cell1_r020_0600_3 0 {C_SN}
crbl_cell1_r020_0600 rbl_cell1_r020_0600 0 {C_RBL}
spr_cell1_r020_0600 pref_020 ref_cell1_r020_0600 ctl 0 swpre
cref_cell1_r020_0600 ref_cell1_r020_0600 0 {C_RBL}   $ ASSUMPTION: ideal matched dummy load
XMN1_cell1_r020_0600 rbl_cell1_r020_0600 ref_cell1_r020_0600 vn_cell1_r020_0600 0 sky130_fd_pr__nfet_01v8 L=0.15 W=1 nf=1 ad=0.29 as=0.29 pd=2.58 ps=2.58 mult=1 m=1
XMN2_cell1_r020_0600 ref_cell1_r020_0600 rbl_cell1_r020_0600 vn_cell1_r020_0600 0 sky130_fd_pr__nfet_01v8 L=0.15 W=1 nf=1 ad=0.29 as=0.29 pd=2.58 ps=2.58 mult=1 m=1
XMP1_cell1_r020_0600 rbl_cell1_r020_0600 ref_cell1_r020_0600 vp_cell1_r020_0600 vdd sky130_fd_pr__pfet_01v8 L=0.15 W=2 nf=1 ad=0.58 as=0.58 pd=4.58 ps=4.58 mult=1 m=1
XMP2_cell1_r020_0600 ref_cell1_r020_0600 rbl_cell1_r020_0600 vp_cell1_r020_0600 vdd sky130_fd_pr__pfet_01v8 L=0.15 W=2 nf=1 ad=0.58 as=0.58 pd=4.58 ps=4.58 mult=1 m=1
XMNF_cell1_r020_0600 vn_cell1_r020_0600 en 0 0 sky130_fd_pr__nfet_01v8 L=0.15 W=2 nf=1 ad=0.58 as=0.58 pd=4.58 ps=4.58 mult=1 m=1
XMPH_cell1_r020_0600 vp_cell1_r020_0600 enb vdd vdd sky130_fd_pr__pfet_01v8 L=0.15 W=4 nf=1 ad=1.16 as=1.16 pd=8.58 ps=8.58 mult=1 m=1
bd_cell1_r020_0600 d_cell1_r020_0600 0 v=v(rbl_cell1_r020_0600)-v(ref_cell1_r020_0600)
bdabs_cell1_r020_0600 dabs_cell1_r020_0600 0 v=abs(v(rbl_cell1_r020_0600)-v(ref_cell1_r020_0600))

* ---- instance 23: cell1_r020_0650 ----
spa_cell1_r020_0650 prea rbl_cell1_r020_0650 ctl 0 swpre
XMWR_cell1_r020_0650_0 sn_cell1_r020_0650_0 0 0 0 sky130_fd_pr__nfet_01v8 L=0.15 W=0.42 nf=1 ad=0.1974 as=0.1974 pd=1.78 ps=1.78 nrd=0.69047619047619  nrs=0.69047619047619 sa=0 sb=0 sd=0 mult=1 m=1
XMRD_cell1_r020_0650_0 rbl_cell1_r020_0650 sn_cell1_r020_0650_0 rwl_sel 0 sky130_fd_pr__nfet_01v8 L=0.15 W=0.42 nf=1 ad=0.1974 as=0.1974 pd=1.78 ps=1.78 nrd=0.69047619047619  nrs=0.69047619047619 sa=0 sb=0 sd=0 mult=1 m=1
csn_cell1_r020_0650_0 sn_cell1_r020_0650_0 0 {C_SN}
XMWR_cell1_r020_0650_1 sn_cell1_r020_0650_1 0 0 0 sky130_fd_pr__nfet_01v8 L=0.15 W=0.42 nf=1 ad=0.1974 as=0.1974 pd=1.78 ps=1.78 nrd=0.69047619047619  nrs=0.69047619047619 sa=0 sb=0 sd=0 mult=1 m=1
XMRD_cell1_r020_0650_1 rbl_cell1_r020_0650 sn_cell1_r020_0650_1 rwl_des 0 sky130_fd_pr__nfet_01v8 L=0.15 W=0.42 nf=1 ad=0.1974 as=0.1974 pd=1.78 ps=1.78 nrd=0.69047619047619  nrs=0.69047619047619 sa=0 sb=0 sd=0 mult=1 m=1
csn_cell1_r020_0650_1 sn_cell1_r020_0650_1 0 {C_SN}
XMWR_cell1_r020_0650_2 sn_cell1_r020_0650_2 0 0 0 sky130_fd_pr__nfet_01v8 L=0.15 W=0.42 nf=1 ad=0.1974 as=0.1974 pd=1.78 ps=1.78 nrd=0.69047619047619  nrs=0.69047619047619 sa=0 sb=0 sd=0 mult=1 m=1
XMRD_cell1_r020_0650_2 rbl_cell1_r020_0650 sn_cell1_r020_0650_2 rwl_des 0 sky130_fd_pr__nfet_01v8 L=0.15 W=0.42 nf=1 ad=0.1974 as=0.1974 pd=1.78 ps=1.78 nrd=0.69047619047619  nrs=0.69047619047619 sa=0 sb=0 sd=0 mult=1 m=1
csn_cell1_r020_0650_2 sn_cell1_r020_0650_2 0 {C_SN}
XMWR_cell1_r020_0650_3 sn_cell1_r020_0650_3 0 0 0 sky130_fd_pr__nfet_01v8 L=0.15 W=0.42 nf=1 ad=0.1974 as=0.1974 pd=1.78 ps=1.78 nrd=0.69047619047619  nrs=0.69047619047619 sa=0 sb=0 sd=0 mult=1 m=1
XMRD_cell1_r020_0650_3 rbl_cell1_r020_0650 sn_cell1_r020_0650_3 rwl_des 0 sky130_fd_pr__nfet_01v8 L=0.15 W=0.42 nf=1 ad=0.1974 as=0.1974 pd=1.78 ps=1.78 nrd=0.69047619047619  nrs=0.69047619047619 sa=0 sb=0 sd=0 mult=1 m=1
csn_cell1_r020_0650_3 sn_cell1_r020_0650_3 0 {C_SN}
crbl_cell1_r020_0650 rbl_cell1_r020_0650 0 {C_RBL}
spr_cell1_r020_0650 pref_020 ref_cell1_r020_0650 ctl 0 swpre
cref_cell1_r020_0650 ref_cell1_r020_0650 0 {C_RBL}   $ ASSUMPTION: ideal matched dummy load
XMN1_cell1_r020_0650 rbl_cell1_r020_0650 ref_cell1_r020_0650 vn_cell1_r020_0650 0 sky130_fd_pr__nfet_01v8 L=0.15 W=1 nf=1 ad=0.29 as=0.29 pd=2.58 ps=2.58 mult=1 m=1
XMN2_cell1_r020_0650 ref_cell1_r020_0650 rbl_cell1_r020_0650 vn_cell1_r020_0650 0 sky130_fd_pr__nfet_01v8 L=0.15 W=1 nf=1 ad=0.29 as=0.29 pd=2.58 ps=2.58 mult=1 m=1
XMP1_cell1_r020_0650 rbl_cell1_r020_0650 ref_cell1_r020_0650 vp_cell1_r020_0650 vdd sky130_fd_pr__pfet_01v8 L=0.15 W=2 nf=1 ad=0.58 as=0.58 pd=4.58 ps=4.58 mult=1 m=1
XMP2_cell1_r020_0650 ref_cell1_r020_0650 rbl_cell1_r020_0650 vp_cell1_r020_0650 vdd sky130_fd_pr__pfet_01v8 L=0.15 W=2 nf=1 ad=0.58 as=0.58 pd=4.58 ps=4.58 mult=1 m=1
XMNF_cell1_r020_0650 vn_cell1_r020_0650 en 0 0 sky130_fd_pr__nfet_01v8 L=0.15 W=2 nf=1 ad=0.58 as=0.58 pd=4.58 ps=4.58 mult=1 m=1
XMPH_cell1_r020_0650 vp_cell1_r020_0650 enb vdd vdd sky130_fd_pr__pfet_01v8 L=0.15 W=4 nf=1 ad=1.16 as=1.16 pd=8.58 ps=8.58 mult=1 m=1
bd_cell1_r020_0650 d_cell1_r020_0650 0 v=v(rbl_cell1_r020_0650)-v(ref_cell1_r020_0650)
bdabs_cell1_r020_0650 dabs_cell1_r020_0650 0 v=abs(v(rbl_cell1_r020_0650)-v(ref_cell1_r020_0650))

* ---- instance 24: cell1_r020_0700 ----
spa_cell1_r020_0700 prea rbl_cell1_r020_0700 ctl 0 swpre
XMWR_cell1_r020_0700_0 sn_cell1_r020_0700_0 0 0 0 sky130_fd_pr__nfet_01v8 L=0.15 W=0.42 nf=1 ad=0.1974 as=0.1974 pd=1.78 ps=1.78 nrd=0.69047619047619  nrs=0.69047619047619 sa=0 sb=0 sd=0 mult=1 m=1
XMRD_cell1_r020_0700_0 rbl_cell1_r020_0700 sn_cell1_r020_0700_0 rwl_sel 0 sky130_fd_pr__nfet_01v8 L=0.15 W=0.42 nf=1 ad=0.1974 as=0.1974 pd=1.78 ps=1.78 nrd=0.69047619047619  nrs=0.69047619047619 sa=0 sb=0 sd=0 mult=1 m=1
csn_cell1_r020_0700_0 sn_cell1_r020_0700_0 0 {C_SN}
XMWR_cell1_r020_0700_1 sn_cell1_r020_0700_1 0 0 0 sky130_fd_pr__nfet_01v8 L=0.15 W=0.42 nf=1 ad=0.1974 as=0.1974 pd=1.78 ps=1.78 nrd=0.69047619047619  nrs=0.69047619047619 sa=0 sb=0 sd=0 mult=1 m=1
XMRD_cell1_r020_0700_1 rbl_cell1_r020_0700 sn_cell1_r020_0700_1 rwl_des 0 sky130_fd_pr__nfet_01v8 L=0.15 W=0.42 nf=1 ad=0.1974 as=0.1974 pd=1.78 ps=1.78 nrd=0.69047619047619  nrs=0.69047619047619 sa=0 sb=0 sd=0 mult=1 m=1
csn_cell1_r020_0700_1 sn_cell1_r020_0700_1 0 {C_SN}
XMWR_cell1_r020_0700_2 sn_cell1_r020_0700_2 0 0 0 sky130_fd_pr__nfet_01v8 L=0.15 W=0.42 nf=1 ad=0.1974 as=0.1974 pd=1.78 ps=1.78 nrd=0.69047619047619  nrs=0.69047619047619 sa=0 sb=0 sd=0 mult=1 m=1
XMRD_cell1_r020_0700_2 rbl_cell1_r020_0700 sn_cell1_r020_0700_2 rwl_des 0 sky130_fd_pr__nfet_01v8 L=0.15 W=0.42 nf=1 ad=0.1974 as=0.1974 pd=1.78 ps=1.78 nrd=0.69047619047619  nrs=0.69047619047619 sa=0 sb=0 sd=0 mult=1 m=1
csn_cell1_r020_0700_2 sn_cell1_r020_0700_2 0 {C_SN}
XMWR_cell1_r020_0700_3 sn_cell1_r020_0700_3 0 0 0 sky130_fd_pr__nfet_01v8 L=0.15 W=0.42 nf=1 ad=0.1974 as=0.1974 pd=1.78 ps=1.78 nrd=0.69047619047619  nrs=0.69047619047619 sa=0 sb=0 sd=0 mult=1 m=1
XMRD_cell1_r020_0700_3 rbl_cell1_r020_0700 sn_cell1_r020_0700_3 rwl_des 0 sky130_fd_pr__nfet_01v8 L=0.15 W=0.42 nf=1 ad=0.1974 as=0.1974 pd=1.78 ps=1.78 nrd=0.69047619047619  nrs=0.69047619047619 sa=0 sb=0 sd=0 mult=1 m=1
csn_cell1_r020_0700_3 sn_cell1_r020_0700_3 0 {C_SN}
crbl_cell1_r020_0700 rbl_cell1_r020_0700 0 {C_RBL}
spr_cell1_r020_0700 pref_020 ref_cell1_r020_0700 ctl 0 swpre
cref_cell1_r020_0700 ref_cell1_r020_0700 0 {C_RBL}   $ ASSUMPTION: ideal matched dummy load
XMN1_cell1_r020_0700 rbl_cell1_r020_0700 ref_cell1_r020_0700 vn_cell1_r020_0700 0 sky130_fd_pr__nfet_01v8 L=0.15 W=1 nf=1 ad=0.29 as=0.29 pd=2.58 ps=2.58 mult=1 m=1
XMN2_cell1_r020_0700 ref_cell1_r020_0700 rbl_cell1_r020_0700 vn_cell1_r020_0700 0 sky130_fd_pr__nfet_01v8 L=0.15 W=1 nf=1 ad=0.29 as=0.29 pd=2.58 ps=2.58 mult=1 m=1
XMP1_cell1_r020_0700 rbl_cell1_r020_0700 ref_cell1_r020_0700 vp_cell1_r020_0700 vdd sky130_fd_pr__pfet_01v8 L=0.15 W=2 nf=1 ad=0.58 as=0.58 pd=4.58 ps=4.58 mult=1 m=1
XMP2_cell1_r020_0700 ref_cell1_r020_0700 rbl_cell1_r020_0700 vp_cell1_r020_0700 vdd sky130_fd_pr__pfet_01v8 L=0.15 W=2 nf=1 ad=0.58 as=0.58 pd=4.58 ps=4.58 mult=1 m=1
XMNF_cell1_r020_0700 vn_cell1_r020_0700 en 0 0 sky130_fd_pr__nfet_01v8 L=0.15 W=2 nf=1 ad=0.58 as=0.58 pd=4.58 ps=4.58 mult=1 m=1
XMPH_cell1_r020_0700 vp_cell1_r020_0700 enb vdd vdd sky130_fd_pr__pfet_01v8 L=0.15 W=4 nf=1 ad=1.16 as=1.16 pd=8.58 ps=8.58 mult=1 m=1
bd_cell1_r020_0700 d_cell1_r020_0700 0 v=v(rbl_cell1_r020_0700)-v(ref_cell1_r020_0700)
bdabs_cell1_r020_0700 dabs_cell1_r020_0700 0 v=abs(v(rbl_cell1_r020_0700)-v(ref_cell1_r020_0700))

* ---- instance 25: cell1_r020_0750 ----
spa_cell1_r020_0750 prea rbl_cell1_r020_0750 ctl 0 swpre
XMWR_cell1_r020_0750_0 sn_cell1_r020_0750_0 0 0 0 sky130_fd_pr__nfet_01v8 L=0.15 W=0.42 nf=1 ad=0.1974 as=0.1974 pd=1.78 ps=1.78 nrd=0.69047619047619  nrs=0.69047619047619 sa=0 sb=0 sd=0 mult=1 m=1
XMRD_cell1_r020_0750_0 rbl_cell1_r020_0750 sn_cell1_r020_0750_0 rwl_sel 0 sky130_fd_pr__nfet_01v8 L=0.15 W=0.42 nf=1 ad=0.1974 as=0.1974 pd=1.78 ps=1.78 nrd=0.69047619047619  nrs=0.69047619047619 sa=0 sb=0 sd=0 mult=1 m=1
csn_cell1_r020_0750_0 sn_cell1_r020_0750_0 0 {C_SN}
XMWR_cell1_r020_0750_1 sn_cell1_r020_0750_1 0 0 0 sky130_fd_pr__nfet_01v8 L=0.15 W=0.42 nf=1 ad=0.1974 as=0.1974 pd=1.78 ps=1.78 nrd=0.69047619047619  nrs=0.69047619047619 sa=0 sb=0 sd=0 mult=1 m=1
XMRD_cell1_r020_0750_1 rbl_cell1_r020_0750 sn_cell1_r020_0750_1 rwl_des 0 sky130_fd_pr__nfet_01v8 L=0.15 W=0.42 nf=1 ad=0.1974 as=0.1974 pd=1.78 ps=1.78 nrd=0.69047619047619  nrs=0.69047619047619 sa=0 sb=0 sd=0 mult=1 m=1
csn_cell1_r020_0750_1 sn_cell1_r020_0750_1 0 {C_SN}
XMWR_cell1_r020_0750_2 sn_cell1_r020_0750_2 0 0 0 sky130_fd_pr__nfet_01v8 L=0.15 W=0.42 nf=1 ad=0.1974 as=0.1974 pd=1.78 ps=1.78 nrd=0.69047619047619  nrs=0.69047619047619 sa=0 sb=0 sd=0 mult=1 m=1
XMRD_cell1_r020_0750_2 rbl_cell1_r020_0750 sn_cell1_r020_0750_2 rwl_des 0 sky130_fd_pr__nfet_01v8 L=0.15 W=0.42 nf=1 ad=0.1974 as=0.1974 pd=1.78 ps=1.78 nrd=0.69047619047619  nrs=0.69047619047619 sa=0 sb=0 sd=0 mult=1 m=1
csn_cell1_r020_0750_2 sn_cell1_r020_0750_2 0 {C_SN}
XMWR_cell1_r020_0750_3 sn_cell1_r020_0750_3 0 0 0 sky130_fd_pr__nfet_01v8 L=0.15 W=0.42 nf=1 ad=0.1974 as=0.1974 pd=1.78 ps=1.78 nrd=0.69047619047619  nrs=0.69047619047619 sa=0 sb=0 sd=0 mult=1 m=1
XMRD_cell1_r020_0750_3 rbl_cell1_r020_0750 sn_cell1_r020_0750_3 rwl_des 0 sky130_fd_pr__nfet_01v8 L=0.15 W=0.42 nf=1 ad=0.1974 as=0.1974 pd=1.78 ps=1.78 nrd=0.69047619047619  nrs=0.69047619047619 sa=0 sb=0 sd=0 mult=1 m=1
csn_cell1_r020_0750_3 sn_cell1_r020_0750_3 0 {C_SN}
crbl_cell1_r020_0750 rbl_cell1_r020_0750 0 {C_RBL}
spr_cell1_r020_0750 pref_020 ref_cell1_r020_0750 ctl 0 swpre
cref_cell1_r020_0750 ref_cell1_r020_0750 0 {C_RBL}   $ ASSUMPTION: ideal matched dummy load
XMN1_cell1_r020_0750 rbl_cell1_r020_0750 ref_cell1_r020_0750 vn_cell1_r020_0750 0 sky130_fd_pr__nfet_01v8 L=0.15 W=1 nf=1 ad=0.29 as=0.29 pd=2.58 ps=2.58 mult=1 m=1
XMN2_cell1_r020_0750 ref_cell1_r020_0750 rbl_cell1_r020_0750 vn_cell1_r020_0750 0 sky130_fd_pr__nfet_01v8 L=0.15 W=1 nf=1 ad=0.29 as=0.29 pd=2.58 ps=2.58 mult=1 m=1
XMP1_cell1_r020_0750 rbl_cell1_r020_0750 ref_cell1_r020_0750 vp_cell1_r020_0750 vdd sky130_fd_pr__pfet_01v8 L=0.15 W=2 nf=1 ad=0.58 as=0.58 pd=4.58 ps=4.58 mult=1 m=1
XMP2_cell1_r020_0750 ref_cell1_r020_0750 rbl_cell1_r020_0750 vp_cell1_r020_0750 vdd sky130_fd_pr__pfet_01v8 L=0.15 W=2 nf=1 ad=0.58 as=0.58 pd=4.58 ps=4.58 mult=1 m=1
XMNF_cell1_r020_0750 vn_cell1_r020_0750 en 0 0 sky130_fd_pr__nfet_01v8 L=0.15 W=2 nf=1 ad=0.58 as=0.58 pd=4.58 ps=4.58 mult=1 m=1
XMPH_cell1_r020_0750 vp_cell1_r020_0750 enb vdd vdd sky130_fd_pr__pfet_01v8 L=0.15 W=4 nf=1 ad=1.16 as=1.16 pd=8.58 ps=8.58 mult=1 m=1
bd_cell1_r020_0750 d_cell1_r020_0750 0 v=v(rbl_cell1_r020_0750)-v(ref_cell1_r020_0750)
bdabs_cell1_r020_0750 dabs_cell1_r020_0750 0 v=abs(v(rbl_cell1_r020_0750)-v(ref_cell1_r020_0750))

* ---- instance 26: cell1_r020_0800 ----
spa_cell1_r020_0800 prea rbl_cell1_r020_0800 ctl 0 swpre
XMWR_cell1_r020_0800_0 sn_cell1_r020_0800_0 0 0 0 sky130_fd_pr__nfet_01v8 L=0.15 W=0.42 nf=1 ad=0.1974 as=0.1974 pd=1.78 ps=1.78 nrd=0.69047619047619  nrs=0.69047619047619 sa=0 sb=0 sd=0 mult=1 m=1
XMRD_cell1_r020_0800_0 rbl_cell1_r020_0800 sn_cell1_r020_0800_0 rwl_sel 0 sky130_fd_pr__nfet_01v8 L=0.15 W=0.42 nf=1 ad=0.1974 as=0.1974 pd=1.78 ps=1.78 nrd=0.69047619047619  nrs=0.69047619047619 sa=0 sb=0 sd=0 mult=1 m=1
csn_cell1_r020_0800_0 sn_cell1_r020_0800_0 0 {C_SN}
XMWR_cell1_r020_0800_1 sn_cell1_r020_0800_1 0 0 0 sky130_fd_pr__nfet_01v8 L=0.15 W=0.42 nf=1 ad=0.1974 as=0.1974 pd=1.78 ps=1.78 nrd=0.69047619047619  nrs=0.69047619047619 sa=0 sb=0 sd=0 mult=1 m=1
XMRD_cell1_r020_0800_1 rbl_cell1_r020_0800 sn_cell1_r020_0800_1 rwl_des 0 sky130_fd_pr__nfet_01v8 L=0.15 W=0.42 nf=1 ad=0.1974 as=0.1974 pd=1.78 ps=1.78 nrd=0.69047619047619  nrs=0.69047619047619 sa=0 sb=0 sd=0 mult=1 m=1
csn_cell1_r020_0800_1 sn_cell1_r020_0800_1 0 {C_SN}
XMWR_cell1_r020_0800_2 sn_cell1_r020_0800_2 0 0 0 sky130_fd_pr__nfet_01v8 L=0.15 W=0.42 nf=1 ad=0.1974 as=0.1974 pd=1.78 ps=1.78 nrd=0.69047619047619  nrs=0.69047619047619 sa=0 sb=0 sd=0 mult=1 m=1
XMRD_cell1_r020_0800_2 rbl_cell1_r020_0800 sn_cell1_r020_0800_2 rwl_des 0 sky130_fd_pr__nfet_01v8 L=0.15 W=0.42 nf=1 ad=0.1974 as=0.1974 pd=1.78 ps=1.78 nrd=0.69047619047619  nrs=0.69047619047619 sa=0 sb=0 sd=0 mult=1 m=1
csn_cell1_r020_0800_2 sn_cell1_r020_0800_2 0 {C_SN}
XMWR_cell1_r020_0800_3 sn_cell1_r020_0800_3 0 0 0 sky130_fd_pr__nfet_01v8 L=0.15 W=0.42 nf=1 ad=0.1974 as=0.1974 pd=1.78 ps=1.78 nrd=0.69047619047619  nrs=0.69047619047619 sa=0 sb=0 sd=0 mult=1 m=1
XMRD_cell1_r020_0800_3 rbl_cell1_r020_0800 sn_cell1_r020_0800_3 rwl_des 0 sky130_fd_pr__nfet_01v8 L=0.15 W=0.42 nf=1 ad=0.1974 as=0.1974 pd=1.78 ps=1.78 nrd=0.69047619047619  nrs=0.69047619047619 sa=0 sb=0 sd=0 mult=1 m=1
csn_cell1_r020_0800_3 sn_cell1_r020_0800_3 0 {C_SN}
crbl_cell1_r020_0800 rbl_cell1_r020_0800 0 {C_RBL}
spr_cell1_r020_0800 pref_020 ref_cell1_r020_0800 ctl 0 swpre
cref_cell1_r020_0800 ref_cell1_r020_0800 0 {C_RBL}   $ ASSUMPTION: ideal matched dummy load
XMN1_cell1_r020_0800 rbl_cell1_r020_0800 ref_cell1_r020_0800 vn_cell1_r020_0800 0 sky130_fd_pr__nfet_01v8 L=0.15 W=1 nf=1 ad=0.29 as=0.29 pd=2.58 ps=2.58 mult=1 m=1
XMN2_cell1_r020_0800 ref_cell1_r020_0800 rbl_cell1_r020_0800 vn_cell1_r020_0800 0 sky130_fd_pr__nfet_01v8 L=0.15 W=1 nf=1 ad=0.29 as=0.29 pd=2.58 ps=2.58 mult=1 m=1
XMP1_cell1_r020_0800 rbl_cell1_r020_0800 ref_cell1_r020_0800 vp_cell1_r020_0800 vdd sky130_fd_pr__pfet_01v8 L=0.15 W=2 nf=1 ad=0.58 as=0.58 pd=4.58 ps=4.58 mult=1 m=1
XMP2_cell1_r020_0800 ref_cell1_r020_0800 rbl_cell1_r020_0800 vp_cell1_r020_0800 vdd sky130_fd_pr__pfet_01v8 L=0.15 W=2 nf=1 ad=0.58 as=0.58 pd=4.58 ps=4.58 mult=1 m=1
XMNF_cell1_r020_0800 vn_cell1_r020_0800 en 0 0 sky130_fd_pr__nfet_01v8 L=0.15 W=2 nf=1 ad=0.58 as=0.58 pd=4.58 ps=4.58 mult=1 m=1
XMPH_cell1_r020_0800 vp_cell1_r020_0800 enb vdd vdd sky130_fd_pr__pfet_01v8 L=0.15 W=4 nf=1 ad=1.16 as=1.16 pd=8.58 ps=8.58 mult=1 m=1
bd_cell1_r020_0800 d_cell1_r020_0800 0 v=v(rbl_cell1_r020_0800)-v(ref_cell1_r020_0800)
bdabs_cell1_r020_0800 dabs_cell1_r020_0800 0 v=abs(v(rbl_cell1_r020_0800)-v(ref_cell1_r020_0800))

* ---- instance 27: cell1_r020_0850 ----
spa_cell1_r020_0850 prea rbl_cell1_r020_0850 ctl 0 swpre
XMWR_cell1_r020_0850_0 sn_cell1_r020_0850_0 0 0 0 sky130_fd_pr__nfet_01v8 L=0.15 W=0.42 nf=1 ad=0.1974 as=0.1974 pd=1.78 ps=1.78 nrd=0.69047619047619  nrs=0.69047619047619 sa=0 sb=0 sd=0 mult=1 m=1
XMRD_cell1_r020_0850_0 rbl_cell1_r020_0850 sn_cell1_r020_0850_0 rwl_sel 0 sky130_fd_pr__nfet_01v8 L=0.15 W=0.42 nf=1 ad=0.1974 as=0.1974 pd=1.78 ps=1.78 nrd=0.69047619047619  nrs=0.69047619047619 sa=0 sb=0 sd=0 mult=1 m=1
csn_cell1_r020_0850_0 sn_cell1_r020_0850_0 0 {C_SN}
XMWR_cell1_r020_0850_1 sn_cell1_r020_0850_1 0 0 0 sky130_fd_pr__nfet_01v8 L=0.15 W=0.42 nf=1 ad=0.1974 as=0.1974 pd=1.78 ps=1.78 nrd=0.69047619047619  nrs=0.69047619047619 sa=0 sb=0 sd=0 mult=1 m=1
XMRD_cell1_r020_0850_1 rbl_cell1_r020_0850 sn_cell1_r020_0850_1 rwl_des 0 sky130_fd_pr__nfet_01v8 L=0.15 W=0.42 nf=1 ad=0.1974 as=0.1974 pd=1.78 ps=1.78 nrd=0.69047619047619  nrs=0.69047619047619 sa=0 sb=0 sd=0 mult=1 m=1
csn_cell1_r020_0850_1 sn_cell1_r020_0850_1 0 {C_SN}
XMWR_cell1_r020_0850_2 sn_cell1_r020_0850_2 0 0 0 sky130_fd_pr__nfet_01v8 L=0.15 W=0.42 nf=1 ad=0.1974 as=0.1974 pd=1.78 ps=1.78 nrd=0.69047619047619  nrs=0.69047619047619 sa=0 sb=0 sd=0 mult=1 m=1
XMRD_cell1_r020_0850_2 rbl_cell1_r020_0850 sn_cell1_r020_0850_2 rwl_des 0 sky130_fd_pr__nfet_01v8 L=0.15 W=0.42 nf=1 ad=0.1974 as=0.1974 pd=1.78 ps=1.78 nrd=0.69047619047619  nrs=0.69047619047619 sa=0 sb=0 sd=0 mult=1 m=1
csn_cell1_r020_0850_2 sn_cell1_r020_0850_2 0 {C_SN}
XMWR_cell1_r020_0850_3 sn_cell1_r020_0850_3 0 0 0 sky130_fd_pr__nfet_01v8 L=0.15 W=0.42 nf=1 ad=0.1974 as=0.1974 pd=1.78 ps=1.78 nrd=0.69047619047619  nrs=0.69047619047619 sa=0 sb=0 sd=0 mult=1 m=1
XMRD_cell1_r020_0850_3 rbl_cell1_r020_0850 sn_cell1_r020_0850_3 rwl_des 0 sky130_fd_pr__nfet_01v8 L=0.15 W=0.42 nf=1 ad=0.1974 as=0.1974 pd=1.78 ps=1.78 nrd=0.69047619047619  nrs=0.69047619047619 sa=0 sb=0 sd=0 mult=1 m=1
csn_cell1_r020_0850_3 sn_cell1_r020_0850_3 0 {C_SN}
crbl_cell1_r020_0850 rbl_cell1_r020_0850 0 {C_RBL}
spr_cell1_r020_0850 pref_020 ref_cell1_r020_0850 ctl 0 swpre
cref_cell1_r020_0850 ref_cell1_r020_0850 0 {C_RBL}   $ ASSUMPTION: ideal matched dummy load
XMN1_cell1_r020_0850 rbl_cell1_r020_0850 ref_cell1_r020_0850 vn_cell1_r020_0850 0 sky130_fd_pr__nfet_01v8 L=0.15 W=1 nf=1 ad=0.29 as=0.29 pd=2.58 ps=2.58 mult=1 m=1
XMN2_cell1_r020_0850 ref_cell1_r020_0850 rbl_cell1_r020_0850 vn_cell1_r020_0850 0 sky130_fd_pr__nfet_01v8 L=0.15 W=1 nf=1 ad=0.29 as=0.29 pd=2.58 ps=2.58 mult=1 m=1
XMP1_cell1_r020_0850 rbl_cell1_r020_0850 ref_cell1_r020_0850 vp_cell1_r020_0850 vdd sky130_fd_pr__pfet_01v8 L=0.15 W=2 nf=1 ad=0.58 as=0.58 pd=4.58 ps=4.58 mult=1 m=1
XMP2_cell1_r020_0850 ref_cell1_r020_0850 rbl_cell1_r020_0850 vp_cell1_r020_0850 vdd sky130_fd_pr__pfet_01v8 L=0.15 W=2 nf=1 ad=0.58 as=0.58 pd=4.58 ps=4.58 mult=1 m=1
XMNF_cell1_r020_0850 vn_cell1_r020_0850 en 0 0 sky130_fd_pr__nfet_01v8 L=0.15 W=2 nf=1 ad=0.58 as=0.58 pd=4.58 ps=4.58 mult=1 m=1
XMPH_cell1_r020_0850 vp_cell1_r020_0850 enb vdd vdd sky130_fd_pr__pfet_01v8 L=0.15 W=4 nf=1 ad=1.16 as=1.16 pd=8.58 ps=8.58 mult=1 m=1
bd_cell1_r020_0850 d_cell1_r020_0850 0 v=v(rbl_cell1_r020_0850)-v(ref_cell1_r020_0850)
bdabs_cell1_r020_0850 dabs_cell1_r020_0850 0 v=abs(v(rbl_cell1_r020_0850)-v(ref_cell1_r020_0850))

* ---- instance 28: cell1_r020_0900 ----
spa_cell1_r020_0900 prea rbl_cell1_r020_0900 ctl 0 swpre
XMWR_cell1_r020_0900_0 sn_cell1_r020_0900_0 0 0 0 sky130_fd_pr__nfet_01v8 L=0.15 W=0.42 nf=1 ad=0.1974 as=0.1974 pd=1.78 ps=1.78 nrd=0.69047619047619  nrs=0.69047619047619 sa=0 sb=0 sd=0 mult=1 m=1
XMRD_cell1_r020_0900_0 rbl_cell1_r020_0900 sn_cell1_r020_0900_0 rwl_sel 0 sky130_fd_pr__nfet_01v8 L=0.15 W=0.42 nf=1 ad=0.1974 as=0.1974 pd=1.78 ps=1.78 nrd=0.69047619047619  nrs=0.69047619047619 sa=0 sb=0 sd=0 mult=1 m=1
csn_cell1_r020_0900_0 sn_cell1_r020_0900_0 0 {C_SN}
XMWR_cell1_r020_0900_1 sn_cell1_r020_0900_1 0 0 0 sky130_fd_pr__nfet_01v8 L=0.15 W=0.42 nf=1 ad=0.1974 as=0.1974 pd=1.78 ps=1.78 nrd=0.69047619047619  nrs=0.69047619047619 sa=0 sb=0 sd=0 mult=1 m=1
XMRD_cell1_r020_0900_1 rbl_cell1_r020_0900 sn_cell1_r020_0900_1 rwl_des 0 sky130_fd_pr__nfet_01v8 L=0.15 W=0.42 nf=1 ad=0.1974 as=0.1974 pd=1.78 ps=1.78 nrd=0.69047619047619  nrs=0.69047619047619 sa=0 sb=0 sd=0 mult=1 m=1
csn_cell1_r020_0900_1 sn_cell1_r020_0900_1 0 {C_SN}
XMWR_cell1_r020_0900_2 sn_cell1_r020_0900_2 0 0 0 sky130_fd_pr__nfet_01v8 L=0.15 W=0.42 nf=1 ad=0.1974 as=0.1974 pd=1.78 ps=1.78 nrd=0.69047619047619  nrs=0.69047619047619 sa=0 sb=0 sd=0 mult=1 m=1
XMRD_cell1_r020_0900_2 rbl_cell1_r020_0900 sn_cell1_r020_0900_2 rwl_des 0 sky130_fd_pr__nfet_01v8 L=0.15 W=0.42 nf=1 ad=0.1974 as=0.1974 pd=1.78 ps=1.78 nrd=0.69047619047619  nrs=0.69047619047619 sa=0 sb=0 sd=0 mult=1 m=1
csn_cell1_r020_0900_2 sn_cell1_r020_0900_2 0 {C_SN}
XMWR_cell1_r020_0900_3 sn_cell1_r020_0900_3 0 0 0 sky130_fd_pr__nfet_01v8 L=0.15 W=0.42 nf=1 ad=0.1974 as=0.1974 pd=1.78 ps=1.78 nrd=0.69047619047619  nrs=0.69047619047619 sa=0 sb=0 sd=0 mult=1 m=1
XMRD_cell1_r020_0900_3 rbl_cell1_r020_0900 sn_cell1_r020_0900_3 rwl_des 0 sky130_fd_pr__nfet_01v8 L=0.15 W=0.42 nf=1 ad=0.1974 as=0.1974 pd=1.78 ps=1.78 nrd=0.69047619047619  nrs=0.69047619047619 sa=0 sb=0 sd=0 mult=1 m=1
csn_cell1_r020_0900_3 sn_cell1_r020_0900_3 0 {C_SN}
crbl_cell1_r020_0900 rbl_cell1_r020_0900 0 {C_RBL}
spr_cell1_r020_0900 pref_020 ref_cell1_r020_0900 ctl 0 swpre
cref_cell1_r020_0900 ref_cell1_r020_0900 0 {C_RBL}   $ ASSUMPTION: ideal matched dummy load
XMN1_cell1_r020_0900 rbl_cell1_r020_0900 ref_cell1_r020_0900 vn_cell1_r020_0900 0 sky130_fd_pr__nfet_01v8 L=0.15 W=1 nf=1 ad=0.29 as=0.29 pd=2.58 ps=2.58 mult=1 m=1
XMN2_cell1_r020_0900 ref_cell1_r020_0900 rbl_cell1_r020_0900 vn_cell1_r020_0900 0 sky130_fd_pr__nfet_01v8 L=0.15 W=1 nf=1 ad=0.29 as=0.29 pd=2.58 ps=2.58 mult=1 m=1
XMP1_cell1_r020_0900 rbl_cell1_r020_0900 ref_cell1_r020_0900 vp_cell1_r020_0900 vdd sky130_fd_pr__pfet_01v8 L=0.15 W=2 nf=1 ad=0.58 as=0.58 pd=4.58 ps=4.58 mult=1 m=1
XMP2_cell1_r020_0900 ref_cell1_r020_0900 rbl_cell1_r020_0900 vp_cell1_r020_0900 vdd sky130_fd_pr__pfet_01v8 L=0.15 W=2 nf=1 ad=0.58 as=0.58 pd=4.58 ps=4.58 mult=1 m=1
XMNF_cell1_r020_0900 vn_cell1_r020_0900 en 0 0 sky130_fd_pr__nfet_01v8 L=0.15 W=2 nf=1 ad=0.58 as=0.58 pd=4.58 ps=4.58 mult=1 m=1
XMPH_cell1_r020_0900 vp_cell1_r020_0900 enb vdd vdd sky130_fd_pr__pfet_01v8 L=0.15 W=4 nf=1 ad=1.16 as=1.16 pd=8.58 ps=8.58 mult=1 m=1
bd_cell1_r020_0900 d_cell1_r020_0900 0 v=v(rbl_cell1_r020_0900)-v(ref_cell1_r020_0900)
bdabs_cell1_r020_0900 dabs_cell1_r020_0900 0 v=abs(v(rbl_cell1_r020_0900)-v(ref_cell1_r020_0900))

* ---- instance 29: cell1_r020_0950 ----
spa_cell1_r020_0950 prea rbl_cell1_r020_0950 ctl 0 swpre
XMWR_cell1_r020_0950_0 sn_cell1_r020_0950_0 0 0 0 sky130_fd_pr__nfet_01v8 L=0.15 W=0.42 nf=1 ad=0.1974 as=0.1974 pd=1.78 ps=1.78 nrd=0.69047619047619  nrs=0.69047619047619 sa=0 sb=0 sd=0 mult=1 m=1
XMRD_cell1_r020_0950_0 rbl_cell1_r020_0950 sn_cell1_r020_0950_0 rwl_sel 0 sky130_fd_pr__nfet_01v8 L=0.15 W=0.42 nf=1 ad=0.1974 as=0.1974 pd=1.78 ps=1.78 nrd=0.69047619047619  nrs=0.69047619047619 sa=0 sb=0 sd=0 mult=1 m=1
csn_cell1_r020_0950_0 sn_cell1_r020_0950_0 0 {C_SN}
XMWR_cell1_r020_0950_1 sn_cell1_r020_0950_1 0 0 0 sky130_fd_pr__nfet_01v8 L=0.15 W=0.42 nf=1 ad=0.1974 as=0.1974 pd=1.78 ps=1.78 nrd=0.69047619047619  nrs=0.69047619047619 sa=0 sb=0 sd=0 mult=1 m=1
XMRD_cell1_r020_0950_1 rbl_cell1_r020_0950 sn_cell1_r020_0950_1 rwl_des 0 sky130_fd_pr__nfet_01v8 L=0.15 W=0.42 nf=1 ad=0.1974 as=0.1974 pd=1.78 ps=1.78 nrd=0.69047619047619  nrs=0.69047619047619 sa=0 sb=0 sd=0 mult=1 m=1
csn_cell1_r020_0950_1 sn_cell1_r020_0950_1 0 {C_SN}
XMWR_cell1_r020_0950_2 sn_cell1_r020_0950_2 0 0 0 sky130_fd_pr__nfet_01v8 L=0.15 W=0.42 nf=1 ad=0.1974 as=0.1974 pd=1.78 ps=1.78 nrd=0.69047619047619  nrs=0.69047619047619 sa=0 sb=0 sd=0 mult=1 m=1
XMRD_cell1_r020_0950_2 rbl_cell1_r020_0950 sn_cell1_r020_0950_2 rwl_des 0 sky130_fd_pr__nfet_01v8 L=0.15 W=0.42 nf=1 ad=0.1974 as=0.1974 pd=1.78 ps=1.78 nrd=0.69047619047619  nrs=0.69047619047619 sa=0 sb=0 sd=0 mult=1 m=1
csn_cell1_r020_0950_2 sn_cell1_r020_0950_2 0 {C_SN}
XMWR_cell1_r020_0950_3 sn_cell1_r020_0950_3 0 0 0 sky130_fd_pr__nfet_01v8 L=0.15 W=0.42 nf=1 ad=0.1974 as=0.1974 pd=1.78 ps=1.78 nrd=0.69047619047619  nrs=0.69047619047619 sa=0 sb=0 sd=0 mult=1 m=1
XMRD_cell1_r020_0950_3 rbl_cell1_r020_0950 sn_cell1_r020_0950_3 rwl_des 0 sky130_fd_pr__nfet_01v8 L=0.15 W=0.42 nf=1 ad=0.1974 as=0.1974 pd=1.78 ps=1.78 nrd=0.69047619047619  nrs=0.69047619047619 sa=0 sb=0 sd=0 mult=1 m=1
csn_cell1_r020_0950_3 sn_cell1_r020_0950_3 0 {C_SN}
crbl_cell1_r020_0950 rbl_cell1_r020_0950 0 {C_RBL}
spr_cell1_r020_0950 pref_020 ref_cell1_r020_0950 ctl 0 swpre
cref_cell1_r020_0950 ref_cell1_r020_0950 0 {C_RBL}   $ ASSUMPTION: ideal matched dummy load
XMN1_cell1_r020_0950 rbl_cell1_r020_0950 ref_cell1_r020_0950 vn_cell1_r020_0950 0 sky130_fd_pr__nfet_01v8 L=0.15 W=1 nf=1 ad=0.29 as=0.29 pd=2.58 ps=2.58 mult=1 m=1
XMN2_cell1_r020_0950 ref_cell1_r020_0950 rbl_cell1_r020_0950 vn_cell1_r020_0950 0 sky130_fd_pr__nfet_01v8 L=0.15 W=1 nf=1 ad=0.29 as=0.29 pd=2.58 ps=2.58 mult=1 m=1
XMP1_cell1_r020_0950 rbl_cell1_r020_0950 ref_cell1_r020_0950 vp_cell1_r020_0950 vdd sky130_fd_pr__pfet_01v8 L=0.15 W=2 nf=1 ad=0.58 as=0.58 pd=4.58 ps=4.58 mult=1 m=1
XMP2_cell1_r020_0950 ref_cell1_r020_0950 rbl_cell1_r020_0950 vp_cell1_r020_0950 vdd sky130_fd_pr__pfet_01v8 L=0.15 W=2 nf=1 ad=0.58 as=0.58 pd=4.58 ps=4.58 mult=1 m=1
XMNF_cell1_r020_0950 vn_cell1_r020_0950 en 0 0 sky130_fd_pr__nfet_01v8 L=0.15 W=2 nf=1 ad=0.58 as=0.58 pd=4.58 ps=4.58 mult=1 m=1
XMPH_cell1_r020_0950 vp_cell1_r020_0950 enb vdd vdd sky130_fd_pr__pfet_01v8 L=0.15 W=4 nf=1 ad=1.16 as=1.16 pd=8.58 ps=8.58 mult=1 m=1
bd_cell1_r020_0950 d_cell1_r020_0950 0 v=v(rbl_cell1_r020_0950)-v(ref_cell1_r020_0950)
bdabs_cell1_r020_0950 dabs_cell1_r020_0950 0 v=abs(v(rbl_cell1_r020_0950)-v(ref_cell1_r020_0950))

* ---- instance 30: cell1_r020_1000 ----
spa_cell1_r020_1000 prea rbl_cell1_r020_1000 ctl 0 swpre
XMWR_cell1_r020_1000_0 sn_cell1_r020_1000_0 0 0 0 sky130_fd_pr__nfet_01v8 L=0.15 W=0.42 nf=1 ad=0.1974 as=0.1974 pd=1.78 ps=1.78 nrd=0.69047619047619  nrs=0.69047619047619 sa=0 sb=0 sd=0 mult=1 m=1
XMRD_cell1_r020_1000_0 rbl_cell1_r020_1000 sn_cell1_r020_1000_0 rwl_sel 0 sky130_fd_pr__nfet_01v8 L=0.15 W=0.42 nf=1 ad=0.1974 as=0.1974 pd=1.78 ps=1.78 nrd=0.69047619047619  nrs=0.69047619047619 sa=0 sb=0 sd=0 mult=1 m=1
csn_cell1_r020_1000_0 sn_cell1_r020_1000_0 0 {C_SN}
XMWR_cell1_r020_1000_1 sn_cell1_r020_1000_1 0 0 0 sky130_fd_pr__nfet_01v8 L=0.15 W=0.42 nf=1 ad=0.1974 as=0.1974 pd=1.78 ps=1.78 nrd=0.69047619047619  nrs=0.69047619047619 sa=0 sb=0 sd=0 mult=1 m=1
XMRD_cell1_r020_1000_1 rbl_cell1_r020_1000 sn_cell1_r020_1000_1 rwl_des 0 sky130_fd_pr__nfet_01v8 L=0.15 W=0.42 nf=1 ad=0.1974 as=0.1974 pd=1.78 ps=1.78 nrd=0.69047619047619  nrs=0.69047619047619 sa=0 sb=0 sd=0 mult=1 m=1
csn_cell1_r020_1000_1 sn_cell1_r020_1000_1 0 {C_SN}
XMWR_cell1_r020_1000_2 sn_cell1_r020_1000_2 0 0 0 sky130_fd_pr__nfet_01v8 L=0.15 W=0.42 nf=1 ad=0.1974 as=0.1974 pd=1.78 ps=1.78 nrd=0.69047619047619  nrs=0.69047619047619 sa=0 sb=0 sd=0 mult=1 m=1
XMRD_cell1_r020_1000_2 rbl_cell1_r020_1000 sn_cell1_r020_1000_2 rwl_des 0 sky130_fd_pr__nfet_01v8 L=0.15 W=0.42 nf=1 ad=0.1974 as=0.1974 pd=1.78 ps=1.78 nrd=0.69047619047619  nrs=0.69047619047619 sa=0 sb=0 sd=0 mult=1 m=1
csn_cell1_r020_1000_2 sn_cell1_r020_1000_2 0 {C_SN}
XMWR_cell1_r020_1000_3 sn_cell1_r020_1000_3 0 0 0 sky130_fd_pr__nfet_01v8 L=0.15 W=0.42 nf=1 ad=0.1974 as=0.1974 pd=1.78 ps=1.78 nrd=0.69047619047619  nrs=0.69047619047619 sa=0 sb=0 sd=0 mult=1 m=1
XMRD_cell1_r020_1000_3 rbl_cell1_r020_1000 sn_cell1_r020_1000_3 rwl_des 0 sky130_fd_pr__nfet_01v8 L=0.15 W=0.42 nf=1 ad=0.1974 as=0.1974 pd=1.78 ps=1.78 nrd=0.69047619047619  nrs=0.69047619047619 sa=0 sb=0 sd=0 mult=1 m=1
csn_cell1_r020_1000_3 sn_cell1_r020_1000_3 0 {C_SN}
crbl_cell1_r020_1000 rbl_cell1_r020_1000 0 {C_RBL}
spr_cell1_r020_1000 pref_020 ref_cell1_r020_1000 ctl 0 swpre
cref_cell1_r020_1000 ref_cell1_r020_1000 0 {C_RBL}   $ ASSUMPTION: ideal matched dummy load
XMN1_cell1_r020_1000 rbl_cell1_r020_1000 ref_cell1_r020_1000 vn_cell1_r020_1000 0 sky130_fd_pr__nfet_01v8 L=0.15 W=1 nf=1 ad=0.29 as=0.29 pd=2.58 ps=2.58 mult=1 m=1
XMN2_cell1_r020_1000 ref_cell1_r020_1000 rbl_cell1_r020_1000 vn_cell1_r020_1000 0 sky130_fd_pr__nfet_01v8 L=0.15 W=1 nf=1 ad=0.29 as=0.29 pd=2.58 ps=2.58 mult=1 m=1
XMP1_cell1_r020_1000 rbl_cell1_r020_1000 ref_cell1_r020_1000 vp_cell1_r020_1000 vdd sky130_fd_pr__pfet_01v8 L=0.15 W=2 nf=1 ad=0.58 as=0.58 pd=4.58 ps=4.58 mult=1 m=1
XMP2_cell1_r020_1000 ref_cell1_r020_1000 rbl_cell1_r020_1000 vp_cell1_r020_1000 vdd sky130_fd_pr__pfet_01v8 L=0.15 W=2 nf=1 ad=0.58 as=0.58 pd=4.58 ps=4.58 mult=1 m=1
XMNF_cell1_r020_1000 vn_cell1_r020_1000 en 0 0 sky130_fd_pr__nfet_01v8 L=0.15 W=2 nf=1 ad=0.58 as=0.58 pd=4.58 ps=4.58 mult=1 m=1
XMPH_cell1_r020_1000 vp_cell1_r020_1000 enb vdd vdd sky130_fd_pr__pfet_01v8 L=0.15 W=4 nf=1 ad=1.16 as=1.16 pd=8.58 ps=8.58 mult=1 m=1
bd_cell1_r020_1000 d_cell1_r020_1000 0 v=v(rbl_cell1_r020_1000)-v(ref_cell1_r020_1000)
bdabs_cell1_r020_1000 dabs_cell1_r020_1000 0 v=abs(v(rbl_cell1_r020_1000)-v(ref_cell1_r020_1000))

* ---- instance 31: cell1_r020_1050 ----
spa_cell1_r020_1050 prea rbl_cell1_r020_1050 ctl 0 swpre
XMWR_cell1_r020_1050_0 sn_cell1_r020_1050_0 0 0 0 sky130_fd_pr__nfet_01v8 L=0.15 W=0.42 nf=1 ad=0.1974 as=0.1974 pd=1.78 ps=1.78 nrd=0.69047619047619  nrs=0.69047619047619 sa=0 sb=0 sd=0 mult=1 m=1
XMRD_cell1_r020_1050_0 rbl_cell1_r020_1050 sn_cell1_r020_1050_0 rwl_sel 0 sky130_fd_pr__nfet_01v8 L=0.15 W=0.42 nf=1 ad=0.1974 as=0.1974 pd=1.78 ps=1.78 nrd=0.69047619047619  nrs=0.69047619047619 sa=0 sb=0 sd=0 mult=1 m=1
csn_cell1_r020_1050_0 sn_cell1_r020_1050_0 0 {C_SN}
XMWR_cell1_r020_1050_1 sn_cell1_r020_1050_1 0 0 0 sky130_fd_pr__nfet_01v8 L=0.15 W=0.42 nf=1 ad=0.1974 as=0.1974 pd=1.78 ps=1.78 nrd=0.69047619047619  nrs=0.69047619047619 sa=0 sb=0 sd=0 mult=1 m=1
XMRD_cell1_r020_1050_1 rbl_cell1_r020_1050 sn_cell1_r020_1050_1 rwl_des 0 sky130_fd_pr__nfet_01v8 L=0.15 W=0.42 nf=1 ad=0.1974 as=0.1974 pd=1.78 ps=1.78 nrd=0.69047619047619  nrs=0.69047619047619 sa=0 sb=0 sd=0 mult=1 m=1
csn_cell1_r020_1050_1 sn_cell1_r020_1050_1 0 {C_SN}
XMWR_cell1_r020_1050_2 sn_cell1_r020_1050_2 0 0 0 sky130_fd_pr__nfet_01v8 L=0.15 W=0.42 nf=1 ad=0.1974 as=0.1974 pd=1.78 ps=1.78 nrd=0.69047619047619  nrs=0.69047619047619 sa=0 sb=0 sd=0 mult=1 m=1
XMRD_cell1_r020_1050_2 rbl_cell1_r020_1050 sn_cell1_r020_1050_2 rwl_des 0 sky130_fd_pr__nfet_01v8 L=0.15 W=0.42 nf=1 ad=0.1974 as=0.1974 pd=1.78 ps=1.78 nrd=0.69047619047619  nrs=0.69047619047619 sa=0 sb=0 sd=0 mult=1 m=1
csn_cell1_r020_1050_2 sn_cell1_r020_1050_2 0 {C_SN}
XMWR_cell1_r020_1050_3 sn_cell1_r020_1050_3 0 0 0 sky130_fd_pr__nfet_01v8 L=0.15 W=0.42 nf=1 ad=0.1974 as=0.1974 pd=1.78 ps=1.78 nrd=0.69047619047619  nrs=0.69047619047619 sa=0 sb=0 sd=0 mult=1 m=1
XMRD_cell1_r020_1050_3 rbl_cell1_r020_1050 sn_cell1_r020_1050_3 rwl_des 0 sky130_fd_pr__nfet_01v8 L=0.15 W=0.42 nf=1 ad=0.1974 as=0.1974 pd=1.78 ps=1.78 nrd=0.69047619047619  nrs=0.69047619047619 sa=0 sb=0 sd=0 mult=1 m=1
csn_cell1_r020_1050_3 sn_cell1_r020_1050_3 0 {C_SN}
crbl_cell1_r020_1050 rbl_cell1_r020_1050 0 {C_RBL}
spr_cell1_r020_1050 pref_020 ref_cell1_r020_1050 ctl 0 swpre
cref_cell1_r020_1050 ref_cell1_r020_1050 0 {C_RBL}   $ ASSUMPTION: ideal matched dummy load
XMN1_cell1_r020_1050 rbl_cell1_r020_1050 ref_cell1_r020_1050 vn_cell1_r020_1050 0 sky130_fd_pr__nfet_01v8 L=0.15 W=1 nf=1 ad=0.29 as=0.29 pd=2.58 ps=2.58 mult=1 m=1
XMN2_cell1_r020_1050 ref_cell1_r020_1050 rbl_cell1_r020_1050 vn_cell1_r020_1050 0 sky130_fd_pr__nfet_01v8 L=0.15 W=1 nf=1 ad=0.29 as=0.29 pd=2.58 ps=2.58 mult=1 m=1
XMP1_cell1_r020_1050 rbl_cell1_r020_1050 ref_cell1_r020_1050 vp_cell1_r020_1050 vdd sky130_fd_pr__pfet_01v8 L=0.15 W=2 nf=1 ad=0.58 as=0.58 pd=4.58 ps=4.58 mult=1 m=1
XMP2_cell1_r020_1050 ref_cell1_r020_1050 rbl_cell1_r020_1050 vp_cell1_r020_1050 vdd sky130_fd_pr__pfet_01v8 L=0.15 W=2 nf=1 ad=0.58 as=0.58 pd=4.58 ps=4.58 mult=1 m=1
XMNF_cell1_r020_1050 vn_cell1_r020_1050 en 0 0 sky130_fd_pr__nfet_01v8 L=0.15 W=2 nf=1 ad=0.58 as=0.58 pd=4.58 ps=4.58 mult=1 m=1
XMPH_cell1_r020_1050 vp_cell1_r020_1050 enb vdd vdd sky130_fd_pr__pfet_01v8 L=0.15 W=4 nf=1 ad=1.16 as=1.16 pd=8.58 ps=8.58 mult=1 m=1
bd_cell1_r020_1050 d_cell1_r020_1050 0 v=v(rbl_cell1_r020_1050)-v(ref_cell1_r020_1050)
bdabs_cell1_r020_1050 dabs_cell1_r020_1050 0 v=abs(v(rbl_cell1_r020_1050)-v(ref_cell1_r020_1050))

* ---- instance 32: cell1_r020_1100 ----
spa_cell1_r020_1100 prea rbl_cell1_r020_1100 ctl 0 swpre
XMWR_cell1_r020_1100_0 sn_cell1_r020_1100_0 0 0 0 sky130_fd_pr__nfet_01v8 L=0.15 W=0.42 nf=1 ad=0.1974 as=0.1974 pd=1.78 ps=1.78 nrd=0.69047619047619  nrs=0.69047619047619 sa=0 sb=0 sd=0 mult=1 m=1
XMRD_cell1_r020_1100_0 rbl_cell1_r020_1100 sn_cell1_r020_1100_0 rwl_sel 0 sky130_fd_pr__nfet_01v8 L=0.15 W=0.42 nf=1 ad=0.1974 as=0.1974 pd=1.78 ps=1.78 nrd=0.69047619047619  nrs=0.69047619047619 sa=0 sb=0 sd=0 mult=1 m=1
csn_cell1_r020_1100_0 sn_cell1_r020_1100_0 0 {C_SN}
XMWR_cell1_r020_1100_1 sn_cell1_r020_1100_1 0 0 0 sky130_fd_pr__nfet_01v8 L=0.15 W=0.42 nf=1 ad=0.1974 as=0.1974 pd=1.78 ps=1.78 nrd=0.69047619047619  nrs=0.69047619047619 sa=0 sb=0 sd=0 mult=1 m=1
XMRD_cell1_r020_1100_1 rbl_cell1_r020_1100 sn_cell1_r020_1100_1 rwl_des 0 sky130_fd_pr__nfet_01v8 L=0.15 W=0.42 nf=1 ad=0.1974 as=0.1974 pd=1.78 ps=1.78 nrd=0.69047619047619  nrs=0.69047619047619 sa=0 sb=0 sd=0 mult=1 m=1
csn_cell1_r020_1100_1 sn_cell1_r020_1100_1 0 {C_SN}
XMWR_cell1_r020_1100_2 sn_cell1_r020_1100_2 0 0 0 sky130_fd_pr__nfet_01v8 L=0.15 W=0.42 nf=1 ad=0.1974 as=0.1974 pd=1.78 ps=1.78 nrd=0.69047619047619  nrs=0.69047619047619 sa=0 sb=0 sd=0 mult=1 m=1
XMRD_cell1_r020_1100_2 rbl_cell1_r020_1100 sn_cell1_r020_1100_2 rwl_des 0 sky130_fd_pr__nfet_01v8 L=0.15 W=0.42 nf=1 ad=0.1974 as=0.1974 pd=1.78 ps=1.78 nrd=0.69047619047619  nrs=0.69047619047619 sa=0 sb=0 sd=0 mult=1 m=1
csn_cell1_r020_1100_2 sn_cell1_r020_1100_2 0 {C_SN}
XMWR_cell1_r020_1100_3 sn_cell1_r020_1100_3 0 0 0 sky130_fd_pr__nfet_01v8 L=0.15 W=0.42 nf=1 ad=0.1974 as=0.1974 pd=1.78 ps=1.78 nrd=0.69047619047619  nrs=0.69047619047619 sa=0 sb=0 sd=0 mult=1 m=1
XMRD_cell1_r020_1100_3 rbl_cell1_r020_1100 sn_cell1_r020_1100_3 rwl_des 0 sky130_fd_pr__nfet_01v8 L=0.15 W=0.42 nf=1 ad=0.1974 as=0.1974 pd=1.78 ps=1.78 nrd=0.69047619047619  nrs=0.69047619047619 sa=0 sb=0 sd=0 mult=1 m=1
csn_cell1_r020_1100_3 sn_cell1_r020_1100_3 0 {C_SN}
crbl_cell1_r020_1100 rbl_cell1_r020_1100 0 {C_RBL}
spr_cell1_r020_1100 pref_020 ref_cell1_r020_1100 ctl 0 swpre
cref_cell1_r020_1100 ref_cell1_r020_1100 0 {C_RBL}   $ ASSUMPTION: ideal matched dummy load
XMN1_cell1_r020_1100 rbl_cell1_r020_1100 ref_cell1_r020_1100 vn_cell1_r020_1100 0 sky130_fd_pr__nfet_01v8 L=0.15 W=1 nf=1 ad=0.29 as=0.29 pd=2.58 ps=2.58 mult=1 m=1
XMN2_cell1_r020_1100 ref_cell1_r020_1100 rbl_cell1_r020_1100 vn_cell1_r020_1100 0 sky130_fd_pr__nfet_01v8 L=0.15 W=1 nf=1 ad=0.29 as=0.29 pd=2.58 ps=2.58 mult=1 m=1
XMP1_cell1_r020_1100 rbl_cell1_r020_1100 ref_cell1_r020_1100 vp_cell1_r020_1100 vdd sky130_fd_pr__pfet_01v8 L=0.15 W=2 nf=1 ad=0.58 as=0.58 pd=4.58 ps=4.58 mult=1 m=1
XMP2_cell1_r020_1100 ref_cell1_r020_1100 rbl_cell1_r020_1100 vp_cell1_r020_1100 vdd sky130_fd_pr__pfet_01v8 L=0.15 W=2 nf=1 ad=0.58 as=0.58 pd=4.58 ps=4.58 mult=1 m=1
XMNF_cell1_r020_1100 vn_cell1_r020_1100 en 0 0 sky130_fd_pr__nfet_01v8 L=0.15 W=2 nf=1 ad=0.58 as=0.58 pd=4.58 ps=4.58 mult=1 m=1
XMPH_cell1_r020_1100 vp_cell1_r020_1100 enb vdd vdd sky130_fd_pr__pfet_01v8 L=0.15 W=4 nf=1 ad=1.16 as=1.16 pd=8.58 ps=8.58 mult=1 m=1
bd_cell1_r020_1100 d_cell1_r020_1100 0 v=v(rbl_cell1_r020_1100)-v(ref_cell1_r020_1100)
bdabs_cell1_r020_1100 dabs_cell1_r020_1100 0 v=abs(v(rbl_cell1_r020_1100)-v(ref_cell1_r020_1100))

* ---- instance 33: cell1_r020_1150 ----
spa_cell1_r020_1150 prea rbl_cell1_r020_1150 ctl 0 swpre
XMWR_cell1_r020_1150_0 sn_cell1_r020_1150_0 0 0 0 sky130_fd_pr__nfet_01v8 L=0.15 W=0.42 nf=1 ad=0.1974 as=0.1974 pd=1.78 ps=1.78 nrd=0.69047619047619  nrs=0.69047619047619 sa=0 sb=0 sd=0 mult=1 m=1
XMRD_cell1_r020_1150_0 rbl_cell1_r020_1150 sn_cell1_r020_1150_0 rwl_sel 0 sky130_fd_pr__nfet_01v8 L=0.15 W=0.42 nf=1 ad=0.1974 as=0.1974 pd=1.78 ps=1.78 nrd=0.69047619047619  nrs=0.69047619047619 sa=0 sb=0 sd=0 mult=1 m=1
csn_cell1_r020_1150_0 sn_cell1_r020_1150_0 0 {C_SN}
XMWR_cell1_r020_1150_1 sn_cell1_r020_1150_1 0 0 0 sky130_fd_pr__nfet_01v8 L=0.15 W=0.42 nf=1 ad=0.1974 as=0.1974 pd=1.78 ps=1.78 nrd=0.69047619047619  nrs=0.69047619047619 sa=0 sb=0 sd=0 mult=1 m=1
XMRD_cell1_r020_1150_1 rbl_cell1_r020_1150 sn_cell1_r020_1150_1 rwl_des 0 sky130_fd_pr__nfet_01v8 L=0.15 W=0.42 nf=1 ad=0.1974 as=0.1974 pd=1.78 ps=1.78 nrd=0.69047619047619  nrs=0.69047619047619 sa=0 sb=0 sd=0 mult=1 m=1
csn_cell1_r020_1150_1 sn_cell1_r020_1150_1 0 {C_SN}
XMWR_cell1_r020_1150_2 sn_cell1_r020_1150_2 0 0 0 sky130_fd_pr__nfet_01v8 L=0.15 W=0.42 nf=1 ad=0.1974 as=0.1974 pd=1.78 ps=1.78 nrd=0.69047619047619  nrs=0.69047619047619 sa=0 sb=0 sd=0 mult=1 m=1
XMRD_cell1_r020_1150_2 rbl_cell1_r020_1150 sn_cell1_r020_1150_2 rwl_des 0 sky130_fd_pr__nfet_01v8 L=0.15 W=0.42 nf=1 ad=0.1974 as=0.1974 pd=1.78 ps=1.78 nrd=0.69047619047619  nrs=0.69047619047619 sa=0 sb=0 sd=0 mult=1 m=1
csn_cell1_r020_1150_2 sn_cell1_r020_1150_2 0 {C_SN}
XMWR_cell1_r020_1150_3 sn_cell1_r020_1150_3 0 0 0 sky130_fd_pr__nfet_01v8 L=0.15 W=0.42 nf=1 ad=0.1974 as=0.1974 pd=1.78 ps=1.78 nrd=0.69047619047619  nrs=0.69047619047619 sa=0 sb=0 sd=0 mult=1 m=1
XMRD_cell1_r020_1150_3 rbl_cell1_r020_1150 sn_cell1_r020_1150_3 rwl_des 0 sky130_fd_pr__nfet_01v8 L=0.15 W=0.42 nf=1 ad=0.1974 as=0.1974 pd=1.78 ps=1.78 nrd=0.69047619047619  nrs=0.69047619047619 sa=0 sb=0 sd=0 mult=1 m=1
csn_cell1_r020_1150_3 sn_cell1_r020_1150_3 0 {C_SN}
crbl_cell1_r020_1150 rbl_cell1_r020_1150 0 {C_RBL}
spr_cell1_r020_1150 pref_020 ref_cell1_r020_1150 ctl 0 swpre
cref_cell1_r020_1150 ref_cell1_r020_1150 0 {C_RBL}   $ ASSUMPTION: ideal matched dummy load
XMN1_cell1_r020_1150 rbl_cell1_r020_1150 ref_cell1_r020_1150 vn_cell1_r020_1150 0 sky130_fd_pr__nfet_01v8 L=0.15 W=1 nf=1 ad=0.29 as=0.29 pd=2.58 ps=2.58 mult=1 m=1
XMN2_cell1_r020_1150 ref_cell1_r020_1150 rbl_cell1_r020_1150 vn_cell1_r020_1150 0 sky130_fd_pr__nfet_01v8 L=0.15 W=1 nf=1 ad=0.29 as=0.29 pd=2.58 ps=2.58 mult=1 m=1
XMP1_cell1_r020_1150 rbl_cell1_r020_1150 ref_cell1_r020_1150 vp_cell1_r020_1150 vdd sky130_fd_pr__pfet_01v8 L=0.15 W=2 nf=1 ad=0.58 as=0.58 pd=4.58 ps=4.58 mult=1 m=1
XMP2_cell1_r020_1150 ref_cell1_r020_1150 rbl_cell1_r020_1150 vp_cell1_r020_1150 vdd sky130_fd_pr__pfet_01v8 L=0.15 W=2 nf=1 ad=0.58 as=0.58 pd=4.58 ps=4.58 mult=1 m=1
XMNF_cell1_r020_1150 vn_cell1_r020_1150 en 0 0 sky130_fd_pr__nfet_01v8 L=0.15 W=2 nf=1 ad=0.58 as=0.58 pd=4.58 ps=4.58 mult=1 m=1
XMPH_cell1_r020_1150 vp_cell1_r020_1150 enb vdd vdd sky130_fd_pr__pfet_01v8 L=0.15 W=4 nf=1 ad=1.16 as=1.16 pd=8.58 ps=8.58 mult=1 m=1
bd_cell1_r020_1150 d_cell1_r020_1150 0 v=v(rbl_cell1_r020_1150)-v(ref_cell1_r020_1150)
bdabs_cell1_r020_1150 dabs_cell1_r020_1150 0 v=abs(v(rbl_cell1_r020_1150)-v(ref_cell1_r020_1150))

* ---- instance 34: cell1_r020_1200 ----
spa_cell1_r020_1200 prea rbl_cell1_r020_1200 ctl 0 swpre
XMWR_cell1_r020_1200_0 sn_cell1_r020_1200_0 0 0 0 sky130_fd_pr__nfet_01v8 L=0.15 W=0.42 nf=1 ad=0.1974 as=0.1974 pd=1.78 ps=1.78 nrd=0.69047619047619  nrs=0.69047619047619 sa=0 sb=0 sd=0 mult=1 m=1
XMRD_cell1_r020_1200_0 rbl_cell1_r020_1200 sn_cell1_r020_1200_0 rwl_sel 0 sky130_fd_pr__nfet_01v8 L=0.15 W=0.42 nf=1 ad=0.1974 as=0.1974 pd=1.78 ps=1.78 nrd=0.69047619047619  nrs=0.69047619047619 sa=0 sb=0 sd=0 mult=1 m=1
csn_cell1_r020_1200_0 sn_cell1_r020_1200_0 0 {C_SN}
XMWR_cell1_r020_1200_1 sn_cell1_r020_1200_1 0 0 0 sky130_fd_pr__nfet_01v8 L=0.15 W=0.42 nf=1 ad=0.1974 as=0.1974 pd=1.78 ps=1.78 nrd=0.69047619047619  nrs=0.69047619047619 sa=0 sb=0 sd=0 mult=1 m=1
XMRD_cell1_r020_1200_1 rbl_cell1_r020_1200 sn_cell1_r020_1200_1 rwl_des 0 sky130_fd_pr__nfet_01v8 L=0.15 W=0.42 nf=1 ad=0.1974 as=0.1974 pd=1.78 ps=1.78 nrd=0.69047619047619  nrs=0.69047619047619 sa=0 sb=0 sd=0 mult=1 m=1
csn_cell1_r020_1200_1 sn_cell1_r020_1200_1 0 {C_SN}
XMWR_cell1_r020_1200_2 sn_cell1_r020_1200_2 0 0 0 sky130_fd_pr__nfet_01v8 L=0.15 W=0.42 nf=1 ad=0.1974 as=0.1974 pd=1.78 ps=1.78 nrd=0.69047619047619  nrs=0.69047619047619 sa=0 sb=0 sd=0 mult=1 m=1
XMRD_cell1_r020_1200_2 rbl_cell1_r020_1200 sn_cell1_r020_1200_2 rwl_des 0 sky130_fd_pr__nfet_01v8 L=0.15 W=0.42 nf=1 ad=0.1974 as=0.1974 pd=1.78 ps=1.78 nrd=0.69047619047619  nrs=0.69047619047619 sa=0 sb=0 sd=0 mult=1 m=1
csn_cell1_r020_1200_2 sn_cell1_r020_1200_2 0 {C_SN}
XMWR_cell1_r020_1200_3 sn_cell1_r020_1200_3 0 0 0 sky130_fd_pr__nfet_01v8 L=0.15 W=0.42 nf=1 ad=0.1974 as=0.1974 pd=1.78 ps=1.78 nrd=0.69047619047619  nrs=0.69047619047619 sa=0 sb=0 sd=0 mult=1 m=1
XMRD_cell1_r020_1200_3 rbl_cell1_r020_1200 sn_cell1_r020_1200_3 rwl_des 0 sky130_fd_pr__nfet_01v8 L=0.15 W=0.42 nf=1 ad=0.1974 as=0.1974 pd=1.78 ps=1.78 nrd=0.69047619047619  nrs=0.69047619047619 sa=0 sb=0 sd=0 mult=1 m=1
csn_cell1_r020_1200_3 sn_cell1_r020_1200_3 0 {C_SN}
crbl_cell1_r020_1200 rbl_cell1_r020_1200 0 {C_RBL}
spr_cell1_r020_1200 pref_020 ref_cell1_r020_1200 ctl 0 swpre
cref_cell1_r020_1200 ref_cell1_r020_1200 0 {C_RBL}   $ ASSUMPTION: ideal matched dummy load
XMN1_cell1_r020_1200 rbl_cell1_r020_1200 ref_cell1_r020_1200 vn_cell1_r020_1200 0 sky130_fd_pr__nfet_01v8 L=0.15 W=1 nf=1 ad=0.29 as=0.29 pd=2.58 ps=2.58 mult=1 m=1
XMN2_cell1_r020_1200 ref_cell1_r020_1200 rbl_cell1_r020_1200 vn_cell1_r020_1200 0 sky130_fd_pr__nfet_01v8 L=0.15 W=1 nf=1 ad=0.29 as=0.29 pd=2.58 ps=2.58 mult=1 m=1
XMP1_cell1_r020_1200 rbl_cell1_r020_1200 ref_cell1_r020_1200 vp_cell1_r020_1200 vdd sky130_fd_pr__pfet_01v8 L=0.15 W=2 nf=1 ad=0.58 as=0.58 pd=4.58 ps=4.58 mult=1 m=1
XMP2_cell1_r020_1200 ref_cell1_r020_1200 rbl_cell1_r020_1200 vp_cell1_r020_1200 vdd sky130_fd_pr__pfet_01v8 L=0.15 W=2 nf=1 ad=0.58 as=0.58 pd=4.58 ps=4.58 mult=1 m=1
XMNF_cell1_r020_1200 vn_cell1_r020_1200 en 0 0 sky130_fd_pr__nfet_01v8 L=0.15 W=2 nf=1 ad=0.58 as=0.58 pd=4.58 ps=4.58 mult=1 m=1
XMPH_cell1_r020_1200 vp_cell1_r020_1200 enb vdd vdd sky130_fd_pr__pfet_01v8 L=0.15 W=4 nf=1 ad=1.16 as=1.16 pd=8.58 ps=8.58 mult=1 m=1
bd_cell1_r020_1200 d_cell1_r020_1200 0 v=v(rbl_cell1_r020_1200)-v(ref_cell1_r020_1200)
bdabs_cell1_r020_1200 dabs_cell1_r020_1200 0 v=abs(v(rbl_cell1_r020_1200)-v(ref_cell1_r020_1200))

* ---- instance 35: cell0_r050_n100 ----
spa_cell0_r050_n100 prea rbl_cell0_r050_n100 ctl 0 swpre
XMWR_cell0_r050_n100_0 sn_cell0_r050_n100_0 0 0 0 sky130_fd_pr__nfet_01v8 L=0.15 W=0.42 nf=1 ad=0.1974 as=0.1974 pd=1.78 ps=1.78 nrd=0.69047619047619  nrs=0.69047619047619 sa=0 sb=0 sd=0 mult=1 m=1
XMRD_cell0_r050_n100_0 rbl_cell0_r050_n100 sn_cell0_r050_n100_0 rwl_sel 0 sky130_fd_pr__nfet_01v8 L=0.15 W=0.42 nf=1 ad=0.1974 as=0.1974 pd=1.78 ps=1.78 nrd=0.69047619047619  nrs=0.69047619047619 sa=0 sb=0 sd=0 mult=1 m=1
csn_cell0_r050_n100_0 sn_cell0_r050_n100_0 0 {C_SN}
XMWR_cell0_r050_n100_1 sn_cell0_r050_n100_1 0 0 0 sky130_fd_pr__nfet_01v8 L=0.15 W=0.42 nf=1 ad=0.1974 as=0.1974 pd=1.78 ps=1.78 nrd=0.69047619047619  nrs=0.69047619047619 sa=0 sb=0 sd=0 mult=1 m=1
XMRD_cell0_r050_n100_1 rbl_cell0_r050_n100 sn_cell0_r050_n100_1 rwl_des 0 sky130_fd_pr__nfet_01v8 L=0.15 W=0.42 nf=1 ad=0.1974 as=0.1974 pd=1.78 ps=1.78 nrd=0.69047619047619  nrs=0.69047619047619 sa=0 sb=0 sd=0 mult=1 m=1
csn_cell0_r050_n100_1 sn_cell0_r050_n100_1 0 {C_SN}
XMWR_cell0_r050_n100_2 sn_cell0_r050_n100_2 0 0 0 sky130_fd_pr__nfet_01v8 L=0.15 W=0.42 nf=1 ad=0.1974 as=0.1974 pd=1.78 ps=1.78 nrd=0.69047619047619  nrs=0.69047619047619 sa=0 sb=0 sd=0 mult=1 m=1
XMRD_cell0_r050_n100_2 rbl_cell0_r050_n100 sn_cell0_r050_n100_2 rwl_des 0 sky130_fd_pr__nfet_01v8 L=0.15 W=0.42 nf=1 ad=0.1974 as=0.1974 pd=1.78 ps=1.78 nrd=0.69047619047619  nrs=0.69047619047619 sa=0 sb=0 sd=0 mult=1 m=1
csn_cell0_r050_n100_2 sn_cell0_r050_n100_2 0 {C_SN}
XMWR_cell0_r050_n100_3 sn_cell0_r050_n100_3 0 0 0 sky130_fd_pr__nfet_01v8 L=0.15 W=0.42 nf=1 ad=0.1974 as=0.1974 pd=1.78 ps=1.78 nrd=0.69047619047619  nrs=0.69047619047619 sa=0 sb=0 sd=0 mult=1 m=1
XMRD_cell0_r050_n100_3 rbl_cell0_r050_n100 sn_cell0_r050_n100_3 rwl_des 0 sky130_fd_pr__nfet_01v8 L=0.15 W=0.42 nf=1 ad=0.1974 as=0.1974 pd=1.78 ps=1.78 nrd=0.69047619047619  nrs=0.69047619047619 sa=0 sb=0 sd=0 mult=1 m=1
csn_cell0_r050_n100_3 sn_cell0_r050_n100_3 0 {C_SN}
crbl_cell0_r050_n100 rbl_cell0_r050_n100 0 {C_RBL}
spr_cell0_r050_n100 pref_050 ref_cell0_r050_n100 ctl 0 swpre
cref_cell0_r050_n100 ref_cell0_r050_n100 0 {C_RBL}   $ ASSUMPTION: ideal matched dummy load
XMN1_cell0_r050_n100 rbl_cell0_r050_n100 ref_cell0_r050_n100 vn_cell0_r050_n100 0 sky130_fd_pr__nfet_01v8 L=0.15 W=1 nf=1 ad=0.29 as=0.29 pd=2.58 ps=2.58 mult=1 m=1
XMN2_cell0_r050_n100 ref_cell0_r050_n100 rbl_cell0_r050_n100 vn_cell0_r050_n100 0 sky130_fd_pr__nfet_01v8 L=0.15 W=1 nf=1 ad=0.29 as=0.29 pd=2.58 ps=2.58 mult=1 m=1
XMP1_cell0_r050_n100 rbl_cell0_r050_n100 ref_cell0_r050_n100 vp_cell0_r050_n100 vdd sky130_fd_pr__pfet_01v8 L=0.15 W=2 nf=1 ad=0.58 as=0.58 pd=4.58 ps=4.58 mult=1 m=1
XMP2_cell0_r050_n100 ref_cell0_r050_n100 rbl_cell0_r050_n100 vp_cell0_r050_n100 vdd sky130_fd_pr__pfet_01v8 L=0.15 W=2 nf=1 ad=0.58 as=0.58 pd=4.58 ps=4.58 mult=1 m=1
XMNF_cell0_r050_n100 vn_cell0_r050_n100 en 0 0 sky130_fd_pr__nfet_01v8 L=0.15 W=2 nf=1 ad=0.58 as=0.58 pd=4.58 ps=4.58 mult=1 m=1
XMPH_cell0_r050_n100 vp_cell0_r050_n100 enb vdd vdd sky130_fd_pr__pfet_01v8 L=0.15 W=4 nf=1 ad=1.16 as=1.16 pd=8.58 ps=8.58 mult=1 m=1
bd_cell0_r050_n100 d_cell0_r050_n100 0 v=v(rbl_cell0_r050_n100)-v(ref_cell0_r050_n100)
bdabs_cell0_r050_n100 dabs_cell0_r050_n100 0 v=abs(v(rbl_cell0_r050_n100)-v(ref_cell0_r050_n100))

* ---- instance 36: cell0_r050_0000 ----
spa_cell0_r050_0000 prea rbl_cell0_r050_0000 ctl 0 swpre
XMWR_cell0_r050_0000_0 sn_cell0_r050_0000_0 0 0 0 sky130_fd_pr__nfet_01v8 L=0.15 W=0.42 nf=1 ad=0.1974 as=0.1974 pd=1.78 ps=1.78 nrd=0.69047619047619  nrs=0.69047619047619 sa=0 sb=0 sd=0 mult=1 m=1
XMRD_cell0_r050_0000_0 rbl_cell0_r050_0000 sn_cell0_r050_0000_0 rwl_sel 0 sky130_fd_pr__nfet_01v8 L=0.15 W=0.42 nf=1 ad=0.1974 as=0.1974 pd=1.78 ps=1.78 nrd=0.69047619047619  nrs=0.69047619047619 sa=0 sb=0 sd=0 mult=1 m=1
csn_cell0_r050_0000_0 sn_cell0_r050_0000_0 0 {C_SN}
XMWR_cell0_r050_0000_1 sn_cell0_r050_0000_1 0 0 0 sky130_fd_pr__nfet_01v8 L=0.15 W=0.42 nf=1 ad=0.1974 as=0.1974 pd=1.78 ps=1.78 nrd=0.69047619047619  nrs=0.69047619047619 sa=0 sb=0 sd=0 mult=1 m=1
XMRD_cell0_r050_0000_1 rbl_cell0_r050_0000 sn_cell0_r050_0000_1 rwl_des 0 sky130_fd_pr__nfet_01v8 L=0.15 W=0.42 nf=1 ad=0.1974 as=0.1974 pd=1.78 ps=1.78 nrd=0.69047619047619  nrs=0.69047619047619 sa=0 sb=0 sd=0 mult=1 m=1
csn_cell0_r050_0000_1 sn_cell0_r050_0000_1 0 {C_SN}
XMWR_cell0_r050_0000_2 sn_cell0_r050_0000_2 0 0 0 sky130_fd_pr__nfet_01v8 L=0.15 W=0.42 nf=1 ad=0.1974 as=0.1974 pd=1.78 ps=1.78 nrd=0.69047619047619  nrs=0.69047619047619 sa=0 sb=0 sd=0 mult=1 m=1
XMRD_cell0_r050_0000_2 rbl_cell0_r050_0000 sn_cell0_r050_0000_2 rwl_des 0 sky130_fd_pr__nfet_01v8 L=0.15 W=0.42 nf=1 ad=0.1974 as=0.1974 pd=1.78 ps=1.78 nrd=0.69047619047619  nrs=0.69047619047619 sa=0 sb=0 sd=0 mult=1 m=1
csn_cell0_r050_0000_2 sn_cell0_r050_0000_2 0 {C_SN}
XMWR_cell0_r050_0000_3 sn_cell0_r050_0000_3 0 0 0 sky130_fd_pr__nfet_01v8 L=0.15 W=0.42 nf=1 ad=0.1974 as=0.1974 pd=1.78 ps=1.78 nrd=0.69047619047619  nrs=0.69047619047619 sa=0 sb=0 sd=0 mult=1 m=1
XMRD_cell0_r050_0000_3 rbl_cell0_r050_0000 sn_cell0_r050_0000_3 rwl_des 0 sky130_fd_pr__nfet_01v8 L=0.15 W=0.42 nf=1 ad=0.1974 as=0.1974 pd=1.78 ps=1.78 nrd=0.69047619047619  nrs=0.69047619047619 sa=0 sb=0 sd=0 mult=1 m=1
csn_cell0_r050_0000_3 sn_cell0_r050_0000_3 0 {C_SN}
crbl_cell0_r050_0000 rbl_cell0_r050_0000 0 {C_RBL}
spr_cell0_r050_0000 pref_050 ref_cell0_r050_0000 ctl 0 swpre
cref_cell0_r050_0000 ref_cell0_r050_0000 0 {C_RBL}   $ ASSUMPTION: ideal matched dummy load
XMN1_cell0_r050_0000 rbl_cell0_r050_0000 ref_cell0_r050_0000 vn_cell0_r050_0000 0 sky130_fd_pr__nfet_01v8 L=0.15 W=1 nf=1 ad=0.29 as=0.29 pd=2.58 ps=2.58 mult=1 m=1
XMN2_cell0_r050_0000 ref_cell0_r050_0000 rbl_cell0_r050_0000 vn_cell0_r050_0000 0 sky130_fd_pr__nfet_01v8 L=0.15 W=1 nf=1 ad=0.29 as=0.29 pd=2.58 ps=2.58 mult=1 m=1
XMP1_cell0_r050_0000 rbl_cell0_r050_0000 ref_cell0_r050_0000 vp_cell0_r050_0000 vdd sky130_fd_pr__pfet_01v8 L=0.15 W=2 nf=1 ad=0.58 as=0.58 pd=4.58 ps=4.58 mult=1 m=1
XMP2_cell0_r050_0000 ref_cell0_r050_0000 rbl_cell0_r050_0000 vp_cell0_r050_0000 vdd sky130_fd_pr__pfet_01v8 L=0.15 W=2 nf=1 ad=0.58 as=0.58 pd=4.58 ps=4.58 mult=1 m=1
XMNF_cell0_r050_0000 vn_cell0_r050_0000 en 0 0 sky130_fd_pr__nfet_01v8 L=0.15 W=2 nf=1 ad=0.58 as=0.58 pd=4.58 ps=4.58 mult=1 m=1
XMPH_cell0_r050_0000 vp_cell0_r050_0000 enb vdd vdd sky130_fd_pr__pfet_01v8 L=0.15 W=4 nf=1 ad=1.16 as=1.16 pd=8.58 ps=8.58 mult=1 m=1
bd_cell0_r050_0000 d_cell0_r050_0000 0 v=v(rbl_cell0_r050_0000)-v(ref_cell0_r050_0000)
bdabs_cell0_r050_0000 dabs_cell0_r050_0000 0 v=abs(v(rbl_cell0_r050_0000)-v(ref_cell0_r050_0000))

* ---- instance 37: cell1_r050_0300 ----
spa_cell1_r050_0300 prea rbl_cell1_r050_0300 ctl 0 swpre
XMWR_cell1_r050_0300_0 sn_cell1_r050_0300_0 0 0 0 sky130_fd_pr__nfet_01v8 L=0.15 W=0.42 nf=1 ad=0.1974 as=0.1974 pd=1.78 ps=1.78 nrd=0.69047619047619  nrs=0.69047619047619 sa=0 sb=0 sd=0 mult=1 m=1
XMRD_cell1_r050_0300_0 rbl_cell1_r050_0300 sn_cell1_r050_0300_0 rwl_sel 0 sky130_fd_pr__nfet_01v8 L=0.15 W=0.42 nf=1 ad=0.1974 as=0.1974 pd=1.78 ps=1.78 nrd=0.69047619047619  nrs=0.69047619047619 sa=0 sb=0 sd=0 mult=1 m=1
csn_cell1_r050_0300_0 sn_cell1_r050_0300_0 0 {C_SN}
XMWR_cell1_r050_0300_1 sn_cell1_r050_0300_1 0 0 0 sky130_fd_pr__nfet_01v8 L=0.15 W=0.42 nf=1 ad=0.1974 as=0.1974 pd=1.78 ps=1.78 nrd=0.69047619047619  nrs=0.69047619047619 sa=0 sb=0 sd=0 mult=1 m=1
XMRD_cell1_r050_0300_1 rbl_cell1_r050_0300 sn_cell1_r050_0300_1 rwl_des 0 sky130_fd_pr__nfet_01v8 L=0.15 W=0.42 nf=1 ad=0.1974 as=0.1974 pd=1.78 ps=1.78 nrd=0.69047619047619  nrs=0.69047619047619 sa=0 sb=0 sd=0 mult=1 m=1
csn_cell1_r050_0300_1 sn_cell1_r050_0300_1 0 {C_SN}
XMWR_cell1_r050_0300_2 sn_cell1_r050_0300_2 0 0 0 sky130_fd_pr__nfet_01v8 L=0.15 W=0.42 nf=1 ad=0.1974 as=0.1974 pd=1.78 ps=1.78 nrd=0.69047619047619  nrs=0.69047619047619 sa=0 sb=0 sd=0 mult=1 m=1
XMRD_cell1_r050_0300_2 rbl_cell1_r050_0300 sn_cell1_r050_0300_2 rwl_des 0 sky130_fd_pr__nfet_01v8 L=0.15 W=0.42 nf=1 ad=0.1974 as=0.1974 pd=1.78 ps=1.78 nrd=0.69047619047619  nrs=0.69047619047619 sa=0 sb=0 sd=0 mult=1 m=1
csn_cell1_r050_0300_2 sn_cell1_r050_0300_2 0 {C_SN}
XMWR_cell1_r050_0300_3 sn_cell1_r050_0300_3 0 0 0 sky130_fd_pr__nfet_01v8 L=0.15 W=0.42 nf=1 ad=0.1974 as=0.1974 pd=1.78 ps=1.78 nrd=0.69047619047619  nrs=0.69047619047619 sa=0 sb=0 sd=0 mult=1 m=1
XMRD_cell1_r050_0300_3 rbl_cell1_r050_0300 sn_cell1_r050_0300_3 rwl_des 0 sky130_fd_pr__nfet_01v8 L=0.15 W=0.42 nf=1 ad=0.1974 as=0.1974 pd=1.78 ps=1.78 nrd=0.69047619047619  nrs=0.69047619047619 sa=0 sb=0 sd=0 mult=1 m=1
csn_cell1_r050_0300_3 sn_cell1_r050_0300_3 0 {C_SN}
crbl_cell1_r050_0300 rbl_cell1_r050_0300 0 {C_RBL}
spr_cell1_r050_0300 pref_050 ref_cell1_r050_0300 ctl 0 swpre
cref_cell1_r050_0300 ref_cell1_r050_0300 0 {C_RBL}   $ ASSUMPTION: ideal matched dummy load
XMN1_cell1_r050_0300 rbl_cell1_r050_0300 ref_cell1_r050_0300 vn_cell1_r050_0300 0 sky130_fd_pr__nfet_01v8 L=0.15 W=1 nf=1 ad=0.29 as=0.29 pd=2.58 ps=2.58 mult=1 m=1
XMN2_cell1_r050_0300 ref_cell1_r050_0300 rbl_cell1_r050_0300 vn_cell1_r050_0300 0 sky130_fd_pr__nfet_01v8 L=0.15 W=1 nf=1 ad=0.29 as=0.29 pd=2.58 ps=2.58 mult=1 m=1
XMP1_cell1_r050_0300 rbl_cell1_r050_0300 ref_cell1_r050_0300 vp_cell1_r050_0300 vdd sky130_fd_pr__pfet_01v8 L=0.15 W=2 nf=1 ad=0.58 as=0.58 pd=4.58 ps=4.58 mult=1 m=1
XMP2_cell1_r050_0300 ref_cell1_r050_0300 rbl_cell1_r050_0300 vp_cell1_r050_0300 vdd sky130_fd_pr__pfet_01v8 L=0.15 W=2 nf=1 ad=0.58 as=0.58 pd=4.58 ps=4.58 mult=1 m=1
XMNF_cell1_r050_0300 vn_cell1_r050_0300 en 0 0 sky130_fd_pr__nfet_01v8 L=0.15 W=2 nf=1 ad=0.58 as=0.58 pd=4.58 ps=4.58 mult=1 m=1
XMPH_cell1_r050_0300 vp_cell1_r050_0300 enb vdd vdd sky130_fd_pr__pfet_01v8 L=0.15 W=4 nf=1 ad=1.16 as=1.16 pd=8.58 ps=8.58 mult=1 m=1
bd_cell1_r050_0300 d_cell1_r050_0300 0 v=v(rbl_cell1_r050_0300)-v(ref_cell1_r050_0300)
bdabs_cell1_r050_0300 dabs_cell1_r050_0300 0 v=abs(v(rbl_cell1_r050_0300)-v(ref_cell1_r050_0300))

* ---- instance 38: cell1_r050_0350 ----
spa_cell1_r050_0350 prea rbl_cell1_r050_0350 ctl 0 swpre
XMWR_cell1_r050_0350_0 sn_cell1_r050_0350_0 0 0 0 sky130_fd_pr__nfet_01v8 L=0.15 W=0.42 nf=1 ad=0.1974 as=0.1974 pd=1.78 ps=1.78 nrd=0.69047619047619  nrs=0.69047619047619 sa=0 sb=0 sd=0 mult=1 m=1
XMRD_cell1_r050_0350_0 rbl_cell1_r050_0350 sn_cell1_r050_0350_0 rwl_sel 0 sky130_fd_pr__nfet_01v8 L=0.15 W=0.42 nf=1 ad=0.1974 as=0.1974 pd=1.78 ps=1.78 nrd=0.69047619047619  nrs=0.69047619047619 sa=0 sb=0 sd=0 mult=1 m=1
csn_cell1_r050_0350_0 sn_cell1_r050_0350_0 0 {C_SN}
XMWR_cell1_r050_0350_1 sn_cell1_r050_0350_1 0 0 0 sky130_fd_pr__nfet_01v8 L=0.15 W=0.42 nf=1 ad=0.1974 as=0.1974 pd=1.78 ps=1.78 nrd=0.69047619047619  nrs=0.69047619047619 sa=0 sb=0 sd=0 mult=1 m=1
XMRD_cell1_r050_0350_1 rbl_cell1_r050_0350 sn_cell1_r050_0350_1 rwl_des 0 sky130_fd_pr__nfet_01v8 L=0.15 W=0.42 nf=1 ad=0.1974 as=0.1974 pd=1.78 ps=1.78 nrd=0.69047619047619  nrs=0.69047619047619 sa=0 sb=0 sd=0 mult=1 m=1
csn_cell1_r050_0350_1 sn_cell1_r050_0350_1 0 {C_SN}
XMWR_cell1_r050_0350_2 sn_cell1_r050_0350_2 0 0 0 sky130_fd_pr__nfet_01v8 L=0.15 W=0.42 nf=1 ad=0.1974 as=0.1974 pd=1.78 ps=1.78 nrd=0.69047619047619  nrs=0.69047619047619 sa=0 sb=0 sd=0 mult=1 m=1
XMRD_cell1_r050_0350_2 rbl_cell1_r050_0350 sn_cell1_r050_0350_2 rwl_des 0 sky130_fd_pr__nfet_01v8 L=0.15 W=0.42 nf=1 ad=0.1974 as=0.1974 pd=1.78 ps=1.78 nrd=0.69047619047619  nrs=0.69047619047619 sa=0 sb=0 sd=0 mult=1 m=1
csn_cell1_r050_0350_2 sn_cell1_r050_0350_2 0 {C_SN}
XMWR_cell1_r050_0350_3 sn_cell1_r050_0350_3 0 0 0 sky130_fd_pr__nfet_01v8 L=0.15 W=0.42 nf=1 ad=0.1974 as=0.1974 pd=1.78 ps=1.78 nrd=0.69047619047619  nrs=0.69047619047619 sa=0 sb=0 sd=0 mult=1 m=1
XMRD_cell1_r050_0350_3 rbl_cell1_r050_0350 sn_cell1_r050_0350_3 rwl_des 0 sky130_fd_pr__nfet_01v8 L=0.15 W=0.42 nf=1 ad=0.1974 as=0.1974 pd=1.78 ps=1.78 nrd=0.69047619047619  nrs=0.69047619047619 sa=0 sb=0 sd=0 mult=1 m=1
csn_cell1_r050_0350_3 sn_cell1_r050_0350_3 0 {C_SN}
crbl_cell1_r050_0350 rbl_cell1_r050_0350 0 {C_RBL}
spr_cell1_r050_0350 pref_050 ref_cell1_r050_0350 ctl 0 swpre
cref_cell1_r050_0350 ref_cell1_r050_0350 0 {C_RBL}   $ ASSUMPTION: ideal matched dummy load
XMN1_cell1_r050_0350 rbl_cell1_r050_0350 ref_cell1_r050_0350 vn_cell1_r050_0350 0 sky130_fd_pr__nfet_01v8 L=0.15 W=1 nf=1 ad=0.29 as=0.29 pd=2.58 ps=2.58 mult=1 m=1
XMN2_cell1_r050_0350 ref_cell1_r050_0350 rbl_cell1_r050_0350 vn_cell1_r050_0350 0 sky130_fd_pr__nfet_01v8 L=0.15 W=1 nf=1 ad=0.29 as=0.29 pd=2.58 ps=2.58 mult=1 m=1
XMP1_cell1_r050_0350 rbl_cell1_r050_0350 ref_cell1_r050_0350 vp_cell1_r050_0350 vdd sky130_fd_pr__pfet_01v8 L=0.15 W=2 nf=1 ad=0.58 as=0.58 pd=4.58 ps=4.58 mult=1 m=1
XMP2_cell1_r050_0350 ref_cell1_r050_0350 rbl_cell1_r050_0350 vp_cell1_r050_0350 vdd sky130_fd_pr__pfet_01v8 L=0.15 W=2 nf=1 ad=0.58 as=0.58 pd=4.58 ps=4.58 mult=1 m=1
XMNF_cell1_r050_0350 vn_cell1_r050_0350 en 0 0 sky130_fd_pr__nfet_01v8 L=0.15 W=2 nf=1 ad=0.58 as=0.58 pd=4.58 ps=4.58 mult=1 m=1
XMPH_cell1_r050_0350 vp_cell1_r050_0350 enb vdd vdd sky130_fd_pr__pfet_01v8 L=0.15 W=4 nf=1 ad=1.16 as=1.16 pd=8.58 ps=8.58 mult=1 m=1
bd_cell1_r050_0350 d_cell1_r050_0350 0 v=v(rbl_cell1_r050_0350)-v(ref_cell1_r050_0350)
bdabs_cell1_r050_0350 dabs_cell1_r050_0350 0 v=abs(v(rbl_cell1_r050_0350)-v(ref_cell1_r050_0350))

* ---- instance 39: cell1_r050_0400 ----
spa_cell1_r050_0400 prea rbl_cell1_r050_0400 ctl 0 swpre
XMWR_cell1_r050_0400_0 sn_cell1_r050_0400_0 0 0 0 sky130_fd_pr__nfet_01v8 L=0.15 W=0.42 nf=1 ad=0.1974 as=0.1974 pd=1.78 ps=1.78 nrd=0.69047619047619  nrs=0.69047619047619 sa=0 sb=0 sd=0 mult=1 m=1
XMRD_cell1_r050_0400_0 rbl_cell1_r050_0400 sn_cell1_r050_0400_0 rwl_sel 0 sky130_fd_pr__nfet_01v8 L=0.15 W=0.42 nf=1 ad=0.1974 as=0.1974 pd=1.78 ps=1.78 nrd=0.69047619047619  nrs=0.69047619047619 sa=0 sb=0 sd=0 mult=1 m=1
csn_cell1_r050_0400_0 sn_cell1_r050_0400_0 0 {C_SN}
XMWR_cell1_r050_0400_1 sn_cell1_r050_0400_1 0 0 0 sky130_fd_pr__nfet_01v8 L=0.15 W=0.42 nf=1 ad=0.1974 as=0.1974 pd=1.78 ps=1.78 nrd=0.69047619047619  nrs=0.69047619047619 sa=0 sb=0 sd=0 mult=1 m=1
XMRD_cell1_r050_0400_1 rbl_cell1_r050_0400 sn_cell1_r050_0400_1 rwl_des 0 sky130_fd_pr__nfet_01v8 L=0.15 W=0.42 nf=1 ad=0.1974 as=0.1974 pd=1.78 ps=1.78 nrd=0.69047619047619  nrs=0.69047619047619 sa=0 sb=0 sd=0 mult=1 m=1
csn_cell1_r050_0400_1 sn_cell1_r050_0400_1 0 {C_SN}
XMWR_cell1_r050_0400_2 sn_cell1_r050_0400_2 0 0 0 sky130_fd_pr__nfet_01v8 L=0.15 W=0.42 nf=1 ad=0.1974 as=0.1974 pd=1.78 ps=1.78 nrd=0.69047619047619  nrs=0.69047619047619 sa=0 sb=0 sd=0 mult=1 m=1
XMRD_cell1_r050_0400_2 rbl_cell1_r050_0400 sn_cell1_r050_0400_2 rwl_des 0 sky130_fd_pr__nfet_01v8 L=0.15 W=0.42 nf=1 ad=0.1974 as=0.1974 pd=1.78 ps=1.78 nrd=0.69047619047619  nrs=0.69047619047619 sa=0 sb=0 sd=0 mult=1 m=1
csn_cell1_r050_0400_2 sn_cell1_r050_0400_2 0 {C_SN}
XMWR_cell1_r050_0400_3 sn_cell1_r050_0400_3 0 0 0 sky130_fd_pr__nfet_01v8 L=0.15 W=0.42 nf=1 ad=0.1974 as=0.1974 pd=1.78 ps=1.78 nrd=0.69047619047619  nrs=0.69047619047619 sa=0 sb=0 sd=0 mult=1 m=1
XMRD_cell1_r050_0400_3 rbl_cell1_r050_0400 sn_cell1_r050_0400_3 rwl_des 0 sky130_fd_pr__nfet_01v8 L=0.15 W=0.42 nf=1 ad=0.1974 as=0.1974 pd=1.78 ps=1.78 nrd=0.69047619047619  nrs=0.69047619047619 sa=0 sb=0 sd=0 mult=1 m=1
csn_cell1_r050_0400_3 sn_cell1_r050_0400_3 0 {C_SN}
crbl_cell1_r050_0400 rbl_cell1_r050_0400 0 {C_RBL}
spr_cell1_r050_0400 pref_050 ref_cell1_r050_0400 ctl 0 swpre
cref_cell1_r050_0400 ref_cell1_r050_0400 0 {C_RBL}   $ ASSUMPTION: ideal matched dummy load
XMN1_cell1_r050_0400 rbl_cell1_r050_0400 ref_cell1_r050_0400 vn_cell1_r050_0400 0 sky130_fd_pr__nfet_01v8 L=0.15 W=1 nf=1 ad=0.29 as=0.29 pd=2.58 ps=2.58 mult=1 m=1
XMN2_cell1_r050_0400 ref_cell1_r050_0400 rbl_cell1_r050_0400 vn_cell1_r050_0400 0 sky130_fd_pr__nfet_01v8 L=0.15 W=1 nf=1 ad=0.29 as=0.29 pd=2.58 ps=2.58 mult=1 m=1
XMP1_cell1_r050_0400 rbl_cell1_r050_0400 ref_cell1_r050_0400 vp_cell1_r050_0400 vdd sky130_fd_pr__pfet_01v8 L=0.15 W=2 nf=1 ad=0.58 as=0.58 pd=4.58 ps=4.58 mult=1 m=1
XMP2_cell1_r050_0400 ref_cell1_r050_0400 rbl_cell1_r050_0400 vp_cell1_r050_0400 vdd sky130_fd_pr__pfet_01v8 L=0.15 W=2 nf=1 ad=0.58 as=0.58 pd=4.58 ps=4.58 mult=1 m=1
XMNF_cell1_r050_0400 vn_cell1_r050_0400 en 0 0 sky130_fd_pr__nfet_01v8 L=0.15 W=2 nf=1 ad=0.58 as=0.58 pd=4.58 ps=4.58 mult=1 m=1
XMPH_cell1_r050_0400 vp_cell1_r050_0400 enb vdd vdd sky130_fd_pr__pfet_01v8 L=0.15 W=4 nf=1 ad=1.16 as=1.16 pd=8.58 ps=8.58 mult=1 m=1
bd_cell1_r050_0400 d_cell1_r050_0400 0 v=v(rbl_cell1_r050_0400)-v(ref_cell1_r050_0400)
bdabs_cell1_r050_0400 dabs_cell1_r050_0400 0 v=abs(v(rbl_cell1_r050_0400)-v(ref_cell1_r050_0400))

* ---- instance 40: cell1_r050_0450 ----
spa_cell1_r050_0450 prea rbl_cell1_r050_0450 ctl 0 swpre
XMWR_cell1_r050_0450_0 sn_cell1_r050_0450_0 0 0 0 sky130_fd_pr__nfet_01v8 L=0.15 W=0.42 nf=1 ad=0.1974 as=0.1974 pd=1.78 ps=1.78 nrd=0.69047619047619  nrs=0.69047619047619 sa=0 sb=0 sd=0 mult=1 m=1
XMRD_cell1_r050_0450_0 rbl_cell1_r050_0450 sn_cell1_r050_0450_0 rwl_sel 0 sky130_fd_pr__nfet_01v8 L=0.15 W=0.42 nf=1 ad=0.1974 as=0.1974 pd=1.78 ps=1.78 nrd=0.69047619047619  nrs=0.69047619047619 sa=0 sb=0 sd=0 mult=1 m=1
csn_cell1_r050_0450_0 sn_cell1_r050_0450_0 0 {C_SN}
XMWR_cell1_r050_0450_1 sn_cell1_r050_0450_1 0 0 0 sky130_fd_pr__nfet_01v8 L=0.15 W=0.42 nf=1 ad=0.1974 as=0.1974 pd=1.78 ps=1.78 nrd=0.69047619047619  nrs=0.69047619047619 sa=0 sb=0 sd=0 mult=1 m=1
XMRD_cell1_r050_0450_1 rbl_cell1_r050_0450 sn_cell1_r050_0450_1 rwl_des 0 sky130_fd_pr__nfet_01v8 L=0.15 W=0.42 nf=1 ad=0.1974 as=0.1974 pd=1.78 ps=1.78 nrd=0.69047619047619  nrs=0.69047619047619 sa=0 sb=0 sd=0 mult=1 m=1
csn_cell1_r050_0450_1 sn_cell1_r050_0450_1 0 {C_SN}
XMWR_cell1_r050_0450_2 sn_cell1_r050_0450_2 0 0 0 sky130_fd_pr__nfet_01v8 L=0.15 W=0.42 nf=1 ad=0.1974 as=0.1974 pd=1.78 ps=1.78 nrd=0.69047619047619  nrs=0.69047619047619 sa=0 sb=0 sd=0 mult=1 m=1
XMRD_cell1_r050_0450_2 rbl_cell1_r050_0450 sn_cell1_r050_0450_2 rwl_des 0 sky130_fd_pr__nfet_01v8 L=0.15 W=0.42 nf=1 ad=0.1974 as=0.1974 pd=1.78 ps=1.78 nrd=0.69047619047619  nrs=0.69047619047619 sa=0 sb=0 sd=0 mult=1 m=1
csn_cell1_r050_0450_2 sn_cell1_r050_0450_2 0 {C_SN}
XMWR_cell1_r050_0450_3 sn_cell1_r050_0450_3 0 0 0 sky130_fd_pr__nfet_01v8 L=0.15 W=0.42 nf=1 ad=0.1974 as=0.1974 pd=1.78 ps=1.78 nrd=0.69047619047619  nrs=0.69047619047619 sa=0 sb=0 sd=0 mult=1 m=1
XMRD_cell1_r050_0450_3 rbl_cell1_r050_0450 sn_cell1_r050_0450_3 rwl_des 0 sky130_fd_pr__nfet_01v8 L=0.15 W=0.42 nf=1 ad=0.1974 as=0.1974 pd=1.78 ps=1.78 nrd=0.69047619047619  nrs=0.69047619047619 sa=0 sb=0 sd=0 mult=1 m=1
csn_cell1_r050_0450_3 sn_cell1_r050_0450_3 0 {C_SN}
crbl_cell1_r050_0450 rbl_cell1_r050_0450 0 {C_RBL}
spr_cell1_r050_0450 pref_050 ref_cell1_r050_0450 ctl 0 swpre
cref_cell1_r050_0450 ref_cell1_r050_0450 0 {C_RBL}   $ ASSUMPTION: ideal matched dummy load
XMN1_cell1_r050_0450 rbl_cell1_r050_0450 ref_cell1_r050_0450 vn_cell1_r050_0450 0 sky130_fd_pr__nfet_01v8 L=0.15 W=1 nf=1 ad=0.29 as=0.29 pd=2.58 ps=2.58 mult=1 m=1
XMN2_cell1_r050_0450 ref_cell1_r050_0450 rbl_cell1_r050_0450 vn_cell1_r050_0450 0 sky130_fd_pr__nfet_01v8 L=0.15 W=1 nf=1 ad=0.29 as=0.29 pd=2.58 ps=2.58 mult=1 m=1
XMP1_cell1_r050_0450 rbl_cell1_r050_0450 ref_cell1_r050_0450 vp_cell1_r050_0450 vdd sky130_fd_pr__pfet_01v8 L=0.15 W=2 nf=1 ad=0.58 as=0.58 pd=4.58 ps=4.58 mult=1 m=1
XMP2_cell1_r050_0450 ref_cell1_r050_0450 rbl_cell1_r050_0450 vp_cell1_r050_0450 vdd sky130_fd_pr__pfet_01v8 L=0.15 W=2 nf=1 ad=0.58 as=0.58 pd=4.58 ps=4.58 mult=1 m=1
XMNF_cell1_r050_0450 vn_cell1_r050_0450 en 0 0 sky130_fd_pr__nfet_01v8 L=0.15 W=2 nf=1 ad=0.58 as=0.58 pd=4.58 ps=4.58 mult=1 m=1
XMPH_cell1_r050_0450 vp_cell1_r050_0450 enb vdd vdd sky130_fd_pr__pfet_01v8 L=0.15 W=4 nf=1 ad=1.16 as=1.16 pd=8.58 ps=8.58 mult=1 m=1
bd_cell1_r050_0450 d_cell1_r050_0450 0 v=v(rbl_cell1_r050_0450)-v(ref_cell1_r050_0450)
bdabs_cell1_r050_0450 dabs_cell1_r050_0450 0 v=abs(v(rbl_cell1_r050_0450)-v(ref_cell1_r050_0450))

* ---- instance 41: cell1_r050_0500 ----
spa_cell1_r050_0500 prea rbl_cell1_r050_0500 ctl 0 swpre
XMWR_cell1_r050_0500_0 sn_cell1_r050_0500_0 0 0 0 sky130_fd_pr__nfet_01v8 L=0.15 W=0.42 nf=1 ad=0.1974 as=0.1974 pd=1.78 ps=1.78 nrd=0.69047619047619  nrs=0.69047619047619 sa=0 sb=0 sd=0 mult=1 m=1
XMRD_cell1_r050_0500_0 rbl_cell1_r050_0500 sn_cell1_r050_0500_0 rwl_sel 0 sky130_fd_pr__nfet_01v8 L=0.15 W=0.42 nf=1 ad=0.1974 as=0.1974 pd=1.78 ps=1.78 nrd=0.69047619047619  nrs=0.69047619047619 sa=0 sb=0 sd=0 mult=1 m=1
csn_cell1_r050_0500_0 sn_cell1_r050_0500_0 0 {C_SN}
XMWR_cell1_r050_0500_1 sn_cell1_r050_0500_1 0 0 0 sky130_fd_pr__nfet_01v8 L=0.15 W=0.42 nf=1 ad=0.1974 as=0.1974 pd=1.78 ps=1.78 nrd=0.69047619047619  nrs=0.69047619047619 sa=0 sb=0 sd=0 mult=1 m=1
XMRD_cell1_r050_0500_1 rbl_cell1_r050_0500 sn_cell1_r050_0500_1 rwl_des 0 sky130_fd_pr__nfet_01v8 L=0.15 W=0.42 nf=1 ad=0.1974 as=0.1974 pd=1.78 ps=1.78 nrd=0.69047619047619  nrs=0.69047619047619 sa=0 sb=0 sd=0 mult=1 m=1
csn_cell1_r050_0500_1 sn_cell1_r050_0500_1 0 {C_SN}
XMWR_cell1_r050_0500_2 sn_cell1_r050_0500_2 0 0 0 sky130_fd_pr__nfet_01v8 L=0.15 W=0.42 nf=1 ad=0.1974 as=0.1974 pd=1.78 ps=1.78 nrd=0.69047619047619  nrs=0.69047619047619 sa=0 sb=0 sd=0 mult=1 m=1
XMRD_cell1_r050_0500_2 rbl_cell1_r050_0500 sn_cell1_r050_0500_2 rwl_des 0 sky130_fd_pr__nfet_01v8 L=0.15 W=0.42 nf=1 ad=0.1974 as=0.1974 pd=1.78 ps=1.78 nrd=0.69047619047619  nrs=0.69047619047619 sa=0 sb=0 sd=0 mult=1 m=1
csn_cell1_r050_0500_2 sn_cell1_r050_0500_2 0 {C_SN}
XMWR_cell1_r050_0500_3 sn_cell1_r050_0500_3 0 0 0 sky130_fd_pr__nfet_01v8 L=0.15 W=0.42 nf=1 ad=0.1974 as=0.1974 pd=1.78 ps=1.78 nrd=0.69047619047619  nrs=0.69047619047619 sa=0 sb=0 sd=0 mult=1 m=1
XMRD_cell1_r050_0500_3 rbl_cell1_r050_0500 sn_cell1_r050_0500_3 rwl_des 0 sky130_fd_pr__nfet_01v8 L=0.15 W=0.42 nf=1 ad=0.1974 as=0.1974 pd=1.78 ps=1.78 nrd=0.69047619047619  nrs=0.69047619047619 sa=0 sb=0 sd=0 mult=1 m=1
csn_cell1_r050_0500_3 sn_cell1_r050_0500_3 0 {C_SN}
crbl_cell1_r050_0500 rbl_cell1_r050_0500 0 {C_RBL}
spr_cell1_r050_0500 pref_050 ref_cell1_r050_0500 ctl 0 swpre
cref_cell1_r050_0500 ref_cell1_r050_0500 0 {C_RBL}   $ ASSUMPTION: ideal matched dummy load
XMN1_cell1_r050_0500 rbl_cell1_r050_0500 ref_cell1_r050_0500 vn_cell1_r050_0500 0 sky130_fd_pr__nfet_01v8 L=0.15 W=1 nf=1 ad=0.29 as=0.29 pd=2.58 ps=2.58 mult=1 m=1
XMN2_cell1_r050_0500 ref_cell1_r050_0500 rbl_cell1_r050_0500 vn_cell1_r050_0500 0 sky130_fd_pr__nfet_01v8 L=0.15 W=1 nf=1 ad=0.29 as=0.29 pd=2.58 ps=2.58 mult=1 m=1
XMP1_cell1_r050_0500 rbl_cell1_r050_0500 ref_cell1_r050_0500 vp_cell1_r050_0500 vdd sky130_fd_pr__pfet_01v8 L=0.15 W=2 nf=1 ad=0.58 as=0.58 pd=4.58 ps=4.58 mult=1 m=1
XMP2_cell1_r050_0500 ref_cell1_r050_0500 rbl_cell1_r050_0500 vp_cell1_r050_0500 vdd sky130_fd_pr__pfet_01v8 L=0.15 W=2 nf=1 ad=0.58 as=0.58 pd=4.58 ps=4.58 mult=1 m=1
XMNF_cell1_r050_0500 vn_cell1_r050_0500 en 0 0 sky130_fd_pr__nfet_01v8 L=0.15 W=2 nf=1 ad=0.58 as=0.58 pd=4.58 ps=4.58 mult=1 m=1
XMPH_cell1_r050_0500 vp_cell1_r050_0500 enb vdd vdd sky130_fd_pr__pfet_01v8 L=0.15 W=4 nf=1 ad=1.16 as=1.16 pd=8.58 ps=8.58 mult=1 m=1
bd_cell1_r050_0500 d_cell1_r050_0500 0 v=v(rbl_cell1_r050_0500)-v(ref_cell1_r050_0500)
bdabs_cell1_r050_0500 dabs_cell1_r050_0500 0 v=abs(v(rbl_cell1_r050_0500)-v(ref_cell1_r050_0500))

* ---- instance 42: cell1_r050_0550 ----
spa_cell1_r050_0550 prea rbl_cell1_r050_0550 ctl 0 swpre
XMWR_cell1_r050_0550_0 sn_cell1_r050_0550_0 0 0 0 sky130_fd_pr__nfet_01v8 L=0.15 W=0.42 nf=1 ad=0.1974 as=0.1974 pd=1.78 ps=1.78 nrd=0.69047619047619  nrs=0.69047619047619 sa=0 sb=0 sd=0 mult=1 m=1
XMRD_cell1_r050_0550_0 rbl_cell1_r050_0550 sn_cell1_r050_0550_0 rwl_sel 0 sky130_fd_pr__nfet_01v8 L=0.15 W=0.42 nf=1 ad=0.1974 as=0.1974 pd=1.78 ps=1.78 nrd=0.69047619047619  nrs=0.69047619047619 sa=0 sb=0 sd=0 mult=1 m=1
csn_cell1_r050_0550_0 sn_cell1_r050_0550_0 0 {C_SN}
XMWR_cell1_r050_0550_1 sn_cell1_r050_0550_1 0 0 0 sky130_fd_pr__nfet_01v8 L=0.15 W=0.42 nf=1 ad=0.1974 as=0.1974 pd=1.78 ps=1.78 nrd=0.69047619047619  nrs=0.69047619047619 sa=0 sb=0 sd=0 mult=1 m=1
XMRD_cell1_r050_0550_1 rbl_cell1_r050_0550 sn_cell1_r050_0550_1 rwl_des 0 sky130_fd_pr__nfet_01v8 L=0.15 W=0.42 nf=1 ad=0.1974 as=0.1974 pd=1.78 ps=1.78 nrd=0.69047619047619  nrs=0.69047619047619 sa=0 sb=0 sd=0 mult=1 m=1
csn_cell1_r050_0550_1 sn_cell1_r050_0550_1 0 {C_SN}
XMWR_cell1_r050_0550_2 sn_cell1_r050_0550_2 0 0 0 sky130_fd_pr__nfet_01v8 L=0.15 W=0.42 nf=1 ad=0.1974 as=0.1974 pd=1.78 ps=1.78 nrd=0.69047619047619  nrs=0.69047619047619 sa=0 sb=0 sd=0 mult=1 m=1
XMRD_cell1_r050_0550_2 rbl_cell1_r050_0550 sn_cell1_r050_0550_2 rwl_des 0 sky130_fd_pr__nfet_01v8 L=0.15 W=0.42 nf=1 ad=0.1974 as=0.1974 pd=1.78 ps=1.78 nrd=0.69047619047619  nrs=0.69047619047619 sa=0 sb=0 sd=0 mult=1 m=1
csn_cell1_r050_0550_2 sn_cell1_r050_0550_2 0 {C_SN}
XMWR_cell1_r050_0550_3 sn_cell1_r050_0550_3 0 0 0 sky130_fd_pr__nfet_01v8 L=0.15 W=0.42 nf=1 ad=0.1974 as=0.1974 pd=1.78 ps=1.78 nrd=0.69047619047619  nrs=0.69047619047619 sa=0 sb=0 sd=0 mult=1 m=1
XMRD_cell1_r050_0550_3 rbl_cell1_r050_0550 sn_cell1_r050_0550_3 rwl_des 0 sky130_fd_pr__nfet_01v8 L=0.15 W=0.42 nf=1 ad=0.1974 as=0.1974 pd=1.78 ps=1.78 nrd=0.69047619047619  nrs=0.69047619047619 sa=0 sb=0 sd=0 mult=1 m=1
csn_cell1_r050_0550_3 sn_cell1_r050_0550_3 0 {C_SN}
crbl_cell1_r050_0550 rbl_cell1_r050_0550 0 {C_RBL}
spr_cell1_r050_0550 pref_050 ref_cell1_r050_0550 ctl 0 swpre
cref_cell1_r050_0550 ref_cell1_r050_0550 0 {C_RBL}   $ ASSUMPTION: ideal matched dummy load
XMN1_cell1_r050_0550 rbl_cell1_r050_0550 ref_cell1_r050_0550 vn_cell1_r050_0550 0 sky130_fd_pr__nfet_01v8 L=0.15 W=1 nf=1 ad=0.29 as=0.29 pd=2.58 ps=2.58 mult=1 m=1
XMN2_cell1_r050_0550 ref_cell1_r050_0550 rbl_cell1_r050_0550 vn_cell1_r050_0550 0 sky130_fd_pr__nfet_01v8 L=0.15 W=1 nf=1 ad=0.29 as=0.29 pd=2.58 ps=2.58 mult=1 m=1
XMP1_cell1_r050_0550 rbl_cell1_r050_0550 ref_cell1_r050_0550 vp_cell1_r050_0550 vdd sky130_fd_pr__pfet_01v8 L=0.15 W=2 nf=1 ad=0.58 as=0.58 pd=4.58 ps=4.58 mult=1 m=1
XMP2_cell1_r050_0550 ref_cell1_r050_0550 rbl_cell1_r050_0550 vp_cell1_r050_0550 vdd sky130_fd_pr__pfet_01v8 L=0.15 W=2 nf=1 ad=0.58 as=0.58 pd=4.58 ps=4.58 mult=1 m=1
XMNF_cell1_r050_0550 vn_cell1_r050_0550 en 0 0 sky130_fd_pr__nfet_01v8 L=0.15 W=2 nf=1 ad=0.58 as=0.58 pd=4.58 ps=4.58 mult=1 m=1
XMPH_cell1_r050_0550 vp_cell1_r050_0550 enb vdd vdd sky130_fd_pr__pfet_01v8 L=0.15 W=4 nf=1 ad=1.16 as=1.16 pd=8.58 ps=8.58 mult=1 m=1
bd_cell1_r050_0550 d_cell1_r050_0550 0 v=v(rbl_cell1_r050_0550)-v(ref_cell1_r050_0550)
bdabs_cell1_r050_0550 dabs_cell1_r050_0550 0 v=abs(v(rbl_cell1_r050_0550)-v(ref_cell1_r050_0550))

* ---- instance 43: cell1_r050_0600 ----
spa_cell1_r050_0600 prea rbl_cell1_r050_0600 ctl 0 swpre
XMWR_cell1_r050_0600_0 sn_cell1_r050_0600_0 0 0 0 sky130_fd_pr__nfet_01v8 L=0.15 W=0.42 nf=1 ad=0.1974 as=0.1974 pd=1.78 ps=1.78 nrd=0.69047619047619  nrs=0.69047619047619 sa=0 sb=0 sd=0 mult=1 m=1
XMRD_cell1_r050_0600_0 rbl_cell1_r050_0600 sn_cell1_r050_0600_0 rwl_sel 0 sky130_fd_pr__nfet_01v8 L=0.15 W=0.42 nf=1 ad=0.1974 as=0.1974 pd=1.78 ps=1.78 nrd=0.69047619047619  nrs=0.69047619047619 sa=0 sb=0 sd=0 mult=1 m=1
csn_cell1_r050_0600_0 sn_cell1_r050_0600_0 0 {C_SN}
XMWR_cell1_r050_0600_1 sn_cell1_r050_0600_1 0 0 0 sky130_fd_pr__nfet_01v8 L=0.15 W=0.42 nf=1 ad=0.1974 as=0.1974 pd=1.78 ps=1.78 nrd=0.69047619047619  nrs=0.69047619047619 sa=0 sb=0 sd=0 mult=1 m=1
XMRD_cell1_r050_0600_1 rbl_cell1_r050_0600 sn_cell1_r050_0600_1 rwl_des 0 sky130_fd_pr__nfet_01v8 L=0.15 W=0.42 nf=1 ad=0.1974 as=0.1974 pd=1.78 ps=1.78 nrd=0.69047619047619  nrs=0.69047619047619 sa=0 sb=0 sd=0 mult=1 m=1
csn_cell1_r050_0600_1 sn_cell1_r050_0600_1 0 {C_SN}
XMWR_cell1_r050_0600_2 sn_cell1_r050_0600_2 0 0 0 sky130_fd_pr__nfet_01v8 L=0.15 W=0.42 nf=1 ad=0.1974 as=0.1974 pd=1.78 ps=1.78 nrd=0.69047619047619  nrs=0.69047619047619 sa=0 sb=0 sd=0 mult=1 m=1
XMRD_cell1_r050_0600_2 rbl_cell1_r050_0600 sn_cell1_r050_0600_2 rwl_des 0 sky130_fd_pr__nfet_01v8 L=0.15 W=0.42 nf=1 ad=0.1974 as=0.1974 pd=1.78 ps=1.78 nrd=0.69047619047619  nrs=0.69047619047619 sa=0 sb=0 sd=0 mult=1 m=1
csn_cell1_r050_0600_2 sn_cell1_r050_0600_2 0 {C_SN}
XMWR_cell1_r050_0600_3 sn_cell1_r050_0600_3 0 0 0 sky130_fd_pr__nfet_01v8 L=0.15 W=0.42 nf=1 ad=0.1974 as=0.1974 pd=1.78 ps=1.78 nrd=0.69047619047619  nrs=0.69047619047619 sa=0 sb=0 sd=0 mult=1 m=1
XMRD_cell1_r050_0600_3 rbl_cell1_r050_0600 sn_cell1_r050_0600_3 rwl_des 0 sky130_fd_pr__nfet_01v8 L=0.15 W=0.42 nf=1 ad=0.1974 as=0.1974 pd=1.78 ps=1.78 nrd=0.69047619047619  nrs=0.69047619047619 sa=0 sb=0 sd=0 mult=1 m=1
csn_cell1_r050_0600_3 sn_cell1_r050_0600_3 0 {C_SN}
crbl_cell1_r050_0600 rbl_cell1_r050_0600 0 {C_RBL}
spr_cell1_r050_0600 pref_050 ref_cell1_r050_0600 ctl 0 swpre
cref_cell1_r050_0600 ref_cell1_r050_0600 0 {C_RBL}   $ ASSUMPTION: ideal matched dummy load
XMN1_cell1_r050_0600 rbl_cell1_r050_0600 ref_cell1_r050_0600 vn_cell1_r050_0600 0 sky130_fd_pr__nfet_01v8 L=0.15 W=1 nf=1 ad=0.29 as=0.29 pd=2.58 ps=2.58 mult=1 m=1
XMN2_cell1_r050_0600 ref_cell1_r050_0600 rbl_cell1_r050_0600 vn_cell1_r050_0600 0 sky130_fd_pr__nfet_01v8 L=0.15 W=1 nf=1 ad=0.29 as=0.29 pd=2.58 ps=2.58 mult=1 m=1
XMP1_cell1_r050_0600 rbl_cell1_r050_0600 ref_cell1_r050_0600 vp_cell1_r050_0600 vdd sky130_fd_pr__pfet_01v8 L=0.15 W=2 nf=1 ad=0.58 as=0.58 pd=4.58 ps=4.58 mult=1 m=1
XMP2_cell1_r050_0600 ref_cell1_r050_0600 rbl_cell1_r050_0600 vp_cell1_r050_0600 vdd sky130_fd_pr__pfet_01v8 L=0.15 W=2 nf=1 ad=0.58 as=0.58 pd=4.58 ps=4.58 mult=1 m=1
XMNF_cell1_r050_0600 vn_cell1_r050_0600 en 0 0 sky130_fd_pr__nfet_01v8 L=0.15 W=2 nf=1 ad=0.58 as=0.58 pd=4.58 ps=4.58 mult=1 m=1
XMPH_cell1_r050_0600 vp_cell1_r050_0600 enb vdd vdd sky130_fd_pr__pfet_01v8 L=0.15 W=4 nf=1 ad=1.16 as=1.16 pd=8.58 ps=8.58 mult=1 m=1
bd_cell1_r050_0600 d_cell1_r050_0600 0 v=v(rbl_cell1_r050_0600)-v(ref_cell1_r050_0600)
bdabs_cell1_r050_0600 dabs_cell1_r050_0600 0 v=abs(v(rbl_cell1_r050_0600)-v(ref_cell1_r050_0600))

* ---- instance 44: cell1_r050_0650 ----
spa_cell1_r050_0650 prea rbl_cell1_r050_0650 ctl 0 swpre
XMWR_cell1_r050_0650_0 sn_cell1_r050_0650_0 0 0 0 sky130_fd_pr__nfet_01v8 L=0.15 W=0.42 nf=1 ad=0.1974 as=0.1974 pd=1.78 ps=1.78 nrd=0.69047619047619  nrs=0.69047619047619 sa=0 sb=0 sd=0 mult=1 m=1
XMRD_cell1_r050_0650_0 rbl_cell1_r050_0650 sn_cell1_r050_0650_0 rwl_sel 0 sky130_fd_pr__nfet_01v8 L=0.15 W=0.42 nf=1 ad=0.1974 as=0.1974 pd=1.78 ps=1.78 nrd=0.69047619047619  nrs=0.69047619047619 sa=0 sb=0 sd=0 mult=1 m=1
csn_cell1_r050_0650_0 sn_cell1_r050_0650_0 0 {C_SN}
XMWR_cell1_r050_0650_1 sn_cell1_r050_0650_1 0 0 0 sky130_fd_pr__nfet_01v8 L=0.15 W=0.42 nf=1 ad=0.1974 as=0.1974 pd=1.78 ps=1.78 nrd=0.69047619047619  nrs=0.69047619047619 sa=0 sb=0 sd=0 mult=1 m=1
XMRD_cell1_r050_0650_1 rbl_cell1_r050_0650 sn_cell1_r050_0650_1 rwl_des 0 sky130_fd_pr__nfet_01v8 L=0.15 W=0.42 nf=1 ad=0.1974 as=0.1974 pd=1.78 ps=1.78 nrd=0.69047619047619  nrs=0.69047619047619 sa=0 sb=0 sd=0 mult=1 m=1
csn_cell1_r050_0650_1 sn_cell1_r050_0650_1 0 {C_SN}
XMWR_cell1_r050_0650_2 sn_cell1_r050_0650_2 0 0 0 sky130_fd_pr__nfet_01v8 L=0.15 W=0.42 nf=1 ad=0.1974 as=0.1974 pd=1.78 ps=1.78 nrd=0.69047619047619  nrs=0.69047619047619 sa=0 sb=0 sd=0 mult=1 m=1
XMRD_cell1_r050_0650_2 rbl_cell1_r050_0650 sn_cell1_r050_0650_2 rwl_des 0 sky130_fd_pr__nfet_01v8 L=0.15 W=0.42 nf=1 ad=0.1974 as=0.1974 pd=1.78 ps=1.78 nrd=0.69047619047619  nrs=0.69047619047619 sa=0 sb=0 sd=0 mult=1 m=1
csn_cell1_r050_0650_2 sn_cell1_r050_0650_2 0 {C_SN}
XMWR_cell1_r050_0650_3 sn_cell1_r050_0650_3 0 0 0 sky130_fd_pr__nfet_01v8 L=0.15 W=0.42 nf=1 ad=0.1974 as=0.1974 pd=1.78 ps=1.78 nrd=0.69047619047619  nrs=0.69047619047619 sa=0 sb=0 sd=0 mult=1 m=1
XMRD_cell1_r050_0650_3 rbl_cell1_r050_0650 sn_cell1_r050_0650_3 rwl_des 0 sky130_fd_pr__nfet_01v8 L=0.15 W=0.42 nf=1 ad=0.1974 as=0.1974 pd=1.78 ps=1.78 nrd=0.69047619047619  nrs=0.69047619047619 sa=0 sb=0 sd=0 mult=1 m=1
csn_cell1_r050_0650_3 sn_cell1_r050_0650_3 0 {C_SN}
crbl_cell1_r050_0650 rbl_cell1_r050_0650 0 {C_RBL}
spr_cell1_r050_0650 pref_050 ref_cell1_r050_0650 ctl 0 swpre
cref_cell1_r050_0650 ref_cell1_r050_0650 0 {C_RBL}   $ ASSUMPTION: ideal matched dummy load
XMN1_cell1_r050_0650 rbl_cell1_r050_0650 ref_cell1_r050_0650 vn_cell1_r050_0650 0 sky130_fd_pr__nfet_01v8 L=0.15 W=1 nf=1 ad=0.29 as=0.29 pd=2.58 ps=2.58 mult=1 m=1
XMN2_cell1_r050_0650 ref_cell1_r050_0650 rbl_cell1_r050_0650 vn_cell1_r050_0650 0 sky130_fd_pr__nfet_01v8 L=0.15 W=1 nf=1 ad=0.29 as=0.29 pd=2.58 ps=2.58 mult=1 m=1
XMP1_cell1_r050_0650 rbl_cell1_r050_0650 ref_cell1_r050_0650 vp_cell1_r050_0650 vdd sky130_fd_pr__pfet_01v8 L=0.15 W=2 nf=1 ad=0.58 as=0.58 pd=4.58 ps=4.58 mult=1 m=1
XMP2_cell1_r050_0650 ref_cell1_r050_0650 rbl_cell1_r050_0650 vp_cell1_r050_0650 vdd sky130_fd_pr__pfet_01v8 L=0.15 W=2 nf=1 ad=0.58 as=0.58 pd=4.58 ps=4.58 mult=1 m=1
XMNF_cell1_r050_0650 vn_cell1_r050_0650 en 0 0 sky130_fd_pr__nfet_01v8 L=0.15 W=2 nf=1 ad=0.58 as=0.58 pd=4.58 ps=4.58 mult=1 m=1
XMPH_cell1_r050_0650 vp_cell1_r050_0650 enb vdd vdd sky130_fd_pr__pfet_01v8 L=0.15 W=4 nf=1 ad=1.16 as=1.16 pd=8.58 ps=8.58 mult=1 m=1
bd_cell1_r050_0650 d_cell1_r050_0650 0 v=v(rbl_cell1_r050_0650)-v(ref_cell1_r050_0650)
bdabs_cell1_r050_0650 dabs_cell1_r050_0650 0 v=abs(v(rbl_cell1_r050_0650)-v(ref_cell1_r050_0650))

* ---- instance 45: cell1_r050_0700 ----
spa_cell1_r050_0700 prea rbl_cell1_r050_0700 ctl 0 swpre
XMWR_cell1_r050_0700_0 sn_cell1_r050_0700_0 0 0 0 sky130_fd_pr__nfet_01v8 L=0.15 W=0.42 nf=1 ad=0.1974 as=0.1974 pd=1.78 ps=1.78 nrd=0.69047619047619  nrs=0.69047619047619 sa=0 sb=0 sd=0 mult=1 m=1
XMRD_cell1_r050_0700_0 rbl_cell1_r050_0700 sn_cell1_r050_0700_0 rwl_sel 0 sky130_fd_pr__nfet_01v8 L=0.15 W=0.42 nf=1 ad=0.1974 as=0.1974 pd=1.78 ps=1.78 nrd=0.69047619047619  nrs=0.69047619047619 sa=0 sb=0 sd=0 mult=1 m=1
csn_cell1_r050_0700_0 sn_cell1_r050_0700_0 0 {C_SN}
XMWR_cell1_r050_0700_1 sn_cell1_r050_0700_1 0 0 0 sky130_fd_pr__nfet_01v8 L=0.15 W=0.42 nf=1 ad=0.1974 as=0.1974 pd=1.78 ps=1.78 nrd=0.69047619047619  nrs=0.69047619047619 sa=0 sb=0 sd=0 mult=1 m=1
XMRD_cell1_r050_0700_1 rbl_cell1_r050_0700 sn_cell1_r050_0700_1 rwl_des 0 sky130_fd_pr__nfet_01v8 L=0.15 W=0.42 nf=1 ad=0.1974 as=0.1974 pd=1.78 ps=1.78 nrd=0.69047619047619  nrs=0.69047619047619 sa=0 sb=0 sd=0 mult=1 m=1
csn_cell1_r050_0700_1 sn_cell1_r050_0700_1 0 {C_SN}
XMWR_cell1_r050_0700_2 sn_cell1_r050_0700_2 0 0 0 sky130_fd_pr__nfet_01v8 L=0.15 W=0.42 nf=1 ad=0.1974 as=0.1974 pd=1.78 ps=1.78 nrd=0.69047619047619  nrs=0.69047619047619 sa=0 sb=0 sd=0 mult=1 m=1
XMRD_cell1_r050_0700_2 rbl_cell1_r050_0700 sn_cell1_r050_0700_2 rwl_des 0 sky130_fd_pr__nfet_01v8 L=0.15 W=0.42 nf=1 ad=0.1974 as=0.1974 pd=1.78 ps=1.78 nrd=0.69047619047619  nrs=0.69047619047619 sa=0 sb=0 sd=0 mult=1 m=1
csn_cell1_r050_0700_2 sn_cell1_r050_0700_2 0 {C_SN}
XMWR_cell1_r050_0700_3 sn_cell1_r050_0700_3 0 0 0 sky130_fd_pr__nfet_01v8 L=0.15 W=0.42 nf=1 ad=0.1974 as=0.1974 pd=1.78 ps=1.78 nrd=0.69047619047619  nrs=0.69047619047619 sa=0 sb=0 sd=0 mult=1 m=1
XMRD_cell1_r050_0700_3 rbl_cell1_r050_0700 sn_cell1_r050_0700_3 rwl_des 0 sky130_fd_pr__nfet_01v8 L=0.15 W=0.42 nf=1 ad=0.1974 as=0.1974 pd=1.78 ps=1.78 nrd=0.69047619047619  nrs=0.69047619047619 sa=0 sb=0 sd=0 mult=1 m=1
csn_cell1_r050_0700_3 sn_cell1_r050_0700_3 0 {C_SN}
crbl_cell1_r050_0700 rbl_cell1_r050_0700 0 {C_RBL}
spr_cell1_r050_0700 pref_050 ref_cell1_r050_0700 ctl 0 swpre
cref_cell1_r050_0700 ref_cell1_r050_0700 0 {C_RBL}   $ ASSUMPTION: ideal matched dummy load
XMN1_cell1_r050_0700 rbl_cell1_r050_0700 ref_cell1_r050_0700 vn_cell1_r050_0700 0 sky130_fd_pr__nfet_01v8 L=0.15 W=1 nf=1 ad=0.29 as=0.29 pd=2.58 ps=2.58 mult=1 m=1
XMN2_cell1_r050_0700 ref_cell1_r050_0700 rbl_cell1_r050_0700 vn_cell1_r050_0700 0 sky130_fd_pr__nfet_01v8 L=0.15 W=1 nf=1 ad=0.29 as=0.29 pd=2.58 ps=2.58 mult=1 m=1
XMP1_cell1_r050_0700 rbl_cell1_r050_0700 ref_cell1_r050_0700 vp_cell1_r050_0700 vdd sky130_fd_pr__pfet_01v8 L=0.15 W=2 nf=1 ad=0.58 as=0.58 pd=4.58 ps=4.58 mult=1 m=1
XMP2_cell1_r050_0700 ref_cell1_r050_0700 rbl_cell1_r050_0700 vp_cell1_r050_0700 vdd sky130_fd_pr__pfet_01v8 L=0.15 W=2 nf=1 ad=0.58 as=0.58 pd=4.58 ps=4.58 mult=1 m=1
XMNF_cell1_r050_0700 vn_cell1_r050_0700 en 0 0 sky130_fd_pr__nfet_01v8 L=0.15 W=2 nf=1 ad=0.58 as=0.58 pd=4.58 ps=4.58 mult=1 m=1
XMPH_cell1_r050_0700 vp_cell1_r050_0700 enb vdd vdd sky130_fd_pr__pfet_01v8 L=0.15 W=4 nf=1 ad=1.16 as=1.16 pd=8.58 ps=8.58 mult=1 m=1
bd_cell1_r050_0700 d_cell1_r050_0700 0 v=v(rbl_cell1_r050_0700)-v(ref_cell1_r050_0700)
bdabs_cell1_r050_0700 dabs_cell1_r050_0700 0 v=abs(v(rbl_cell1_r050_0700)-v(ref_cell1_r050_0700))

* ---- instance 46: cell1_r050_0750 ----
spa_cell1_r050_0750 prea rbl_cell1_r050_0750 ctl 0 swpre
XMWR_cell1_r050_0750_0 sn_cell1_r050_0750_0 0 0 0 sky130_fd_pr__nfet_01v8 L=0.15 W=0.42 nf=1 ad=0.1974 as=0.1974 pd=1.78 ps=1.78 nrd=0.69047619047619  nrs=0.69047619047619 sa=0 sb=0 sd=0 mult=1 m=1
XMRD_cell1_r050_0750_0 rbl_cell1_r050_0750 sn_cell1_r050_0750_0 rwl_sel 0 sky130_fd_pr__nfet_01v8 L=0.15 W=0.42 nf=1 ad=0.1974 as=0.1974 pd=1.78 ps=1.78 nrd=0.69047619047619  nrs=0.69047619047619 sa=0 sb=0 sd=0 mult=1 m=1
csn_cell1_r050_0750_0 sn_cell1_r050_0750_0 0 {C_SN}
XMWR_cell1_r050_0750_1 sn_cell1_r050_0750_1 0 0 0 sky130_fd_pr__nfet_01v8 L=0.15 W=0.42 nf=1 ad=0.1974 as=0.1974 pd=1.78 ps=1.78 nrd=0.69047619047619  nrs=0.69047619047619 sa=0 sb=0 sd=0 mult=1 m=1
XMRD_cell1_r050_0750_1 rbl_cell1_r050_0750 sn_cell1_r050_0750_1 rwl_des 0 sky130_fd_pr__nfet_01v8 L=0.15 W=0.42 nf=1 ad=0.1974 as=0.1974 pd=1.78 ps=1.78 nrd=0.69047619047619  nrs=0.69047619047619 sa=0 sb=0 sd=0 mult=1 m=1
csn_cell1_r050_0750_1 sn_cell1_r050_0750_1 0 {C_SN}
XMWR_cell1_r050_0750_2 sn_cell1_r050_0750_2 0 0 0 sky130_fd_pr__nfet_01v8 L=0.15 W=0.42 nf=1 ad=0.1974 as=0.1974 pd=1.78 ps=1.78 nrd=0.69047619047619  nrs=0.69047619047619 sa=0 sb=0 sd=0 mult=1 m=1
XMRD_cell1_r050_0750_2 rbl_cell1_r050_0750 sn_cell1_r050_0750_2 rwl_des 0 sky130_fd_pr__nfet_01v8 L=0.15 W=0.42 nf=1 ad=0.1974 as=0.1974 pd=1.78 ps=1.78 nrd=0.69047619047619  nrs=0.69047619047619 sa=0 sb=0 sd=0 mult=1 m=1
csn_cell1_r050_0750_2 sn_cell1_r050_0750_2 0 {C_SN}
XMWR_cell1_r050_0750_3 sn_cell1_r050_0750_3 0 0 0 sky130_fd_pr__nfet_01v8 L=0.15 W=0.42 nf=1 ad=0.1974 as=0.1974 pd=1.78 ps=1.78 nrd=0.69047619047619  nrs=0.69047619047619 sa=0 sb=0 sd=0 mult=1 m=1
XMRD_cell1_r050_0750_3 rbl_cell1_r050_0750 sn_cell1_r050_0750_3 rwl_des 0 sky130_fd_pr__nfet_01v8 L=0.15 W=0.42 nf=1 ad=0.1974 as=0.1974 pd=1.78 ps=1.78 nrd=0.69047619047619  nrs=0.69047619047619 sa=0 sb=0 sd=0 mult=1 m=1
csn_cell1_r050_0750_3 sn_cell1_r050_0750_3 0 {C_SN}
crbl_cell1_r050_0750 rbl_cell1_r050_0750 0 {C_RBL}
spr_cell1_r050_0750 pref_050 ref_cell1_r050_0750 ctl 0 swpre
cref_cell1_r050_0750 ref_cell1_r050_0750 0 {C_RBL}   $ ASSUMPTION: ideal matched dummy load
XMN1_cell1_r050_0750 rbl_cell1_r050_0750 ref_cell1_r050_0750 vn_cell1_r050_0750 0 sky130_fd_pr__nfet_01v8 L=0.15 W=1 nf=1 ad=0.29 as=0.29 pd=2.58 ps=2.58 mult=1 m=1
XMN2_cell1_r050_0750 ref_cell1_r050_0750 rbl_cell1_r050_0750 vn_cell1_r050_0750 0 sky130_fd_pr__nfet_01v8 L=0.15 W=1 nf=1 ad=0.29 as=0.29 pd=2.58 ps=2.58 mult=1 m=1
XMP1_cell1_r050_0750 rbl_cell1_r050_0750 ref_cell1_r050_0750 vp_cell1_r050_0750 vdd sky130_fd_pr__pfet_01v8 L=0.15 W=2 nf=1 ad=0.58 as=0.58 pd=4.58 ps=4.58 mult=1 m=1
XMP2_cell1_r050_0750 ref_cell1_r050_0750 rbl_cell1_r050_0750 vp_cell1_r050_0750 vdd sky130_fd_pr__pfet_01v8 L=0.15 W=2 nf=1 ad=0.58 as=0.58 pd=4.58 ps=4.58 mult=1 m=1
XMNF_cell1_r050_0750 vn_cell1_r050_0750 en 0 0 sky130_fd_pr__nfet_01v8 L=0.15 W=2 nf=1 ad=0.58 as=0.58 pd=4.58 ps=4.58 mult=1 m=1
XMPH_cell1_r050_0750 vp_cell1_r050_0750 enb vdd vdd sky130_fd_pr__pfet_01v8 L=0.15 W=4 nf=1 ad=1.16 as=1.16 pd=8.58 ps=8.58 mult=1 m=1
bd_cell1_r050_0750 d_cell1_r050_0750 0 v=v(rbl_cell1_r050_0750)-v(ref_cell1_r050_0750)
bdabs_cell1_r050_0750 dabs_cell1_r050_0750 0 v=abs(v(rbl_cell1_r050_0750)-v(ref_cell1_r050_0750))

* ---- instance 47: cell1_r050_0800 ----
spa_cell1_r050_0800 prea rbl_cell1_r050_0800 ctl 0 swpre
XMWR_cell1_r050_0800_0 sn_cell1_r050_0800_0 0 0 0 sky130_fd_pr__nfet_01v8 L=0.15 W=0.42 nf=1 ad=0.1974 as=0.1974 pd=1.78 ps=1.78 nrd=0.69047619047619  nrs=0.69047619047619 sa=0 sb=0 sd=0 mult=1 m=1
XMRD_cell1_r050_0800_0 rbl_cell1_r050_0800 sn_cell1_r050_0800_0 rwl_sel 0 sky130_fd_pr__nfet_01v8 L=0.15 W=0.42 nf=1 ad=0.1974 as=0.1974 pd=1.78 ps=1.78 nrd=0.69047619047619  nrs=0.69047619047619 sa=0 sb=0 sd=0 mult=1 m=1
csn_cell1_r050_0800_0 sn_cell1_r050_0800_0 0 {C_SN}
XMWR_cell1_r050_0800_1 sn_cell1_r050_0800_1 0 0 0 sky130_fd_pr__nfet_01v8 L=0.15 W=0.42 nf=1 ad=0.1974 as=0.1974 pd=1.78 ps=1.78 nrd=0.69047619047619  nrs=0.69047619047619 sa=0 sb=0 sd=0 mult=1 m=1
XMRD_cell1_r050_0800_1 rbl_cell1_r050_0800 sn_cell1_r050_0800_1 rwl_des 0 sky130_fd_pr__nfet_01v8 L=0.15 W=0.42 nf=1 ad=0.1974 as=0.1974 pd=1.78 ps=1.78 nrd=0.69047619047619  nrs=0.69047619047619 sa=0 sb=0 sd=0 mult=1 m=1
csn_cell1_r050_0800_1 sn_cell1_r050_0800_1 0 {C_SN}
XMWR_cell1_r050_0800_2 sn_cell1_r050_0800_2 0 0 0 sky130_fd_pr__nfet_01v8 L=0.15 W=0.42 nf=1 ad=0.1974 as=0.1974 pd=1.78 ps=1.78 nrd=0.69047619047619  nrs=0.69047619047619 sa=0 sb=0 sd=0 mult=1 m=1
XMRD_cell1_r050_0800_2 rbl_cell1_r050_0800 sn_cell1_r050_0800_2 rwl_des 0 sky130_fd_pr__nfet_01v8 L=0.15 W=0.42 nf=1 ad=0.1974 as=0.1974 pd=1.78 ps=1.78 nrd=0.69047619047619  nrs=0.69047619047619 sa=0 sb=0 sd=0 mult=1 m=1
csn_cell1_r050_0800_2 sn_cell1_r050_0800_2 0 {C_SN}
XMWR_cell1_r050_0800_3 sn_cell1_r050_0800_3 0 0 0 sky130_fd_pr__nfet_01v8 L=0.15 W=0.42 nf=1 ad=0.1974 as=0.1974 pd=1.78 ps=1.78 nrd=0.69047619047619  nrs=0.69047619047619 sa=0 sb=0 sd=0 mult=1 m=1
XMRD_cell1_r050_0800_3 rbl_cell1_r050_0800 sn_cell1_r050_0800_3 rwl_des 0 sky130_fd_pr__nfet_01v8 L=0.15 W=0.42 nf=1 ad=0.1974 as=0.1974 pd=1.78 ps=1.78 nrd=0.69047619047619  nrs=0.69047619047619 sa=0 sb=0 sd=0 mult=1 m=1
csn_cell1_r050_0800_3 sn_cell1_r050_0800_3 0 {C_SN}
crbl_cell1_r050_0800 rbl_cell1_r050_0800 0 {C_RBL}
spr_cell1_r050_0800 pref_050 ref_cell1_r050_0800 ctl 0 swpre
cref_cell1_r050_0800 ref_cell1_r050_0800 0 {C_RBL}   $ ASSUMPTION: ideal matched dummy load
XMN1_cell1_r050_0800 rbl_cell1_r050_0800 ref_cell1_r050_0800 vn_cell1_r050_0800 0 sky130_fd_pr__nfet_01v8 L=0.15 W=1 nf=1 ad=0.29 as=0.29 pd=2.58 ps=2.58 mult=1 m=1
XMN2_cell1_r050_0800 ref_cell1_r050_0800 rbl_cell1_r050_0800 vn_cell1_r050_0800 0 sky130_fd_pr__nfet_01v8 L=0.15 W=1 nf=1 ad=0.29 as=0.29 pd=2.58 ps=2.58 mult=1 m=1
XMP1_cell1_r050_0800 rbl_cell1_r050_0800 ref_cell1_r050_0800 vp_cell1_r050_0800 vdd sky130_fd_pr__pfet_01v8 L=0.15 W=2 nf=1 ad=0.58 as=0.58 pd=4.58 ps=4.58 mult=1 m=1
XMP2_cell1_r050_0800 ref_cell1_r050_0800 rbl_cell1_r050_0800 vp_cell1_r050_0800 vdd sky130_fd_pr__pfet_01v8 L=0.15 W=2 nf=1 ad=0.58 as=0.58 pd=4.58 ps=4.58 mult=1 m=1
XMNF_cell1_r050_0800 vn_cell1_r050_0800 en 0 0 sky130_fd_pr__nfet_01v8 L=0.15 W=2 nf=1 ad=0.58 as=0.58 pd=4.58 ps=4.58 mult=1 m=1
XMPH_cell1_r050_0800 vp_cell1_r050_0800 enb vdd vdd sky130_fd_pr__pfet_01v8 L=0.15 W=4 nf=1 ad=1.16 as=1.16 pd=8.58 ps=8.58 mult=1 m=1
bd_cell1_r050_0800 d_cell1_r050_0800 0 v=v(rbl_cell1_r050_0800)-v(ref_cell1_r050_0800)
bdabs_cell1_r050_0800 dabs_cell1_r050_0800 0 v=abs(v(rbl_cell1_r050_0800)-v(ref_cell1_r050_0800))

* ---- instance 48: cell1_r050_0850 ----
spa_cell1_r050_0850 prea rbl_cell1_r050_0850 ctl 0 swpre
XMWR_cell1_r050_0850_0 sn_cell1_r050_0850_0 0 0 0 sky130_fd_pr__nfet_01v8 L=0.15 W=0.42 nf=1 ad=0.1974 as=0.1974 pd=1.78 ps=1.78 nrd=0.69047619047619  nrs=0.69047619047619 sa=0 sb=0 sd=0 mult=1 m=1
XMRD_cell1_r050_0850_0 rbl_cell1_r050_0850 sn_cell1_r050_0850_0 rwl_sel 0 sky130_fd_pr__nfet_01v8 L=0.15 W=0.42 nf=1 ad=0.1974 as=0.1974 pd=1.78 ps=1.78 nrd=0.69047619047619  nrs=0.69047619047619 sa=0 sb=0 sd=0 mult=1 m=1
csn_cell1_r050_0850_0 sn_cell1_r050_0850_0 0 {C_SN}
XMWR_cell1_r050_0850_1 sn_cell1_r050_0850_1 0 0 0 sky130_fd_pr__nfet_01v8 L=0.15 W=0.42 nf=1 ad=0.1974 as=0.1974 pd=1.78 ps=1.78 nrd=0.69047619047619  nrs=0.69047619047619 sa=0 sb=0 sd=0 mult=1 m=1
XMRD_cell1_r050_0850_1 rbl_cell1_r050_0850 sn_cell1_r050_0850_1 rwl_des 0 sky130_fd_pr__nfet_01v8 L=0.15 W=0.42 nf=1 ad=0.1974 as=0.1974 pd=1.78 ps=1.78 nrd=0.69047619047619  nrs=0.69047619047619 sa=0 sb=0 sd=0 mult=1 m=1
csn_cell1_r050_0850_1 sn_cell1_r050_0850_1 0 {C_SN}
XMWR_cell1_r050_0850_2 sn_cell1_r050_0850_2 0 0 0 sky130_fd_pr__nfet_01v8 L=0.15 W=0.42 nf=1 ad=0.1974 as=0.1974 pd=1.78 ps=1.78 nrd=0.69047619047619  nrs=0.69047619047619 sa=0 sb=0 sd=0 mult=1 m=1
XMRD_cell1_r050_0850_2 rbl_cell1_r050_0850 sn_cell1_r050_0850_2 rwl_des 0 sky130_fd_pr__nfet_01v8 L=0.15 W=0.42 nf=1 ad=0.1974 as=0.1974 pd=1.78 ps=1.78 nrd=0.69047619047619  nrs=0.69047619047619 sa=0 sb=0 sd=0 mult=1 m=1
csn_cell1_r050_0850_2 sn_cell1_r050_0850_2 0 {C_SN}
XMWR_cell1_r050_0850_3 sn_cell1_r050_0850_3 0 0 0 sky130_fd_pr__nfet_01v8 L=0.15 W=0.42 nf=1 ad=0.1974 as=0.1974 pd=1.78 ps=1.78 nrd=0.69047619047619  nrs=0.69047619047619 sa=0 sb=0 sd=0 mult=1 m=1
XMRD_cell1_r050_0850_3 rbl_cell1_r050_0850 sn_cell1_r050_0850_3 rwl_des 0 sky130_fd_pr__nfet_01v8 L=0.15 W=0.42 nf=1 ad=0.1974 as=0.1974 pd=1.78 ps=1.78 nrd=0.69047619047619  nrs=0.69047619047619 sa=0 sb=0 sd=0 mult=1 m=1
csn_cell1_r050_0850_3 sn_cell1_r050_0850_3 0 {C_SN}
crbl_cell1_r050_0850 rbl_cell1_r050_0850 0 {C_RBL}
spr_cell1_r050_0850 pref_050 ref_cell1_r050_0850 ctl 0 swpre
cref_cell1_r050_0850 ref_cell1_r050_0850 0 {C_RBL}   $ ASSUMPTION: ideal matched dummy load
XMN1_cell1_r050_0850 rbl_cell1_r050_0850 ref_cell1_r050_0850 vn_cell1_r050_0850 0 sky130_fd_pr__nfet_01v8 L=0.15 W=1 nf=1 ad=0.29 as=0.29 pd=2.58 ps=2.58 mult=1 m=1
XMN2_cell1_r050_0850 ref_cell1_r050_0850 rbl_cell1_r050_0850 vn_cell1_r050_0850 0 sky130_fd_pr__nfet_01v8 L=0.15 W=1 nf=1 ad=0.29 as=0.29 pd=2.58 ps=2.58 mult=1 m=1
XMP1_cell1_r050_0850 rbl_cell1_r050_0850 ref_cell1_r050_0850 vp_cell1_r050_0850 vdd sky130_fd_pr__pfet_01v8 L=0.15 W=2 nf=1 ad=0.58 as=0.58 pd=4.58 ps=4.58 mult=1 m=1
XMP2_cell1_r050_0850 ref_cell1_r050_0850 rbl_cell1_r050_0850 vp_cell1_r050_0850 vdd sky130_fd_pr__pfet_01v8 L=0.15 W=2 nf=1 ad=0.58 as=0.58 pd=4.58 ps=4.58 mult=1 m=1
XMNF_cell1_r050_0850 vn_cell1_r050_0850 en 0 0 sky130_fd_pr__nfet_01v8 L=0.15 W=2 nf=1 ad=0.58 as=0.58 pd=4.58 ps=4.58 mult=1 m=1
XMPH_cell1_r050_0850 vp_cell1_r050_0850 enb vdd vdd sky130_fd_pr__pfet_01v8 L=0.15 W=4 nf=1 ad=1.16 as=1.16 pd=8.58 ps=8.58 mult=1 m=1
bd_cell1_r050_0850 d_cell1_r050_0850 0 v=v(rbl_cell1_r050_0850)-v(ref_cell1_r050_0850)
bdabs_cell1_r050_0850 dabs_cell1_r050_0850 0 v=abs(v(rbl_cell1_r050_0850)-v(ref_cell1_r050_0850))

* ---- instance 49: cell1_r050_0900 ----
spa_cell1_r050_0900 prea rbl_cell1_r050_0900 ctl 0 swpre
XMWR_cell1_r050_0900_0 sn_cell1_r050_0900_0 0 0 0 sky130_fd_pr__nfet_01v8 L=0.15 W=0.42 nf=1 ad=0.1974 as=0.1974 pd=1.78 ps=1.78 nrd=0.69047619047619  nrs=0.69047619047619 sa=0 sb=0 sd=0 mult=1 m=1
XMRD_cell1_r050_0900_0 rbl_cell1_r050_0900 sn_cell1_r050_0900_0 rwl_sel 0 sky130_fd_pr__nfet_01v8 L=0.15 W=0.42 nf=1 ad=0.1974 as=0.1974 pd=1.78 ps=1.78 nrd=0.69047619047619  nrs=0.69047619047619 sa=0 sb=0 sd=0 mult=1 m=1
csn_cell1_r050_0900_0 sn_cell1_r050_0900_0 0 {C_SN}
XMWR_cell1_r050_0900_1 sn_cell1_r050_0900_1 0 0 0 sky130_fd_pr__nfet_01v8 L=0.15 W=0.42 nf=1 ad=0.1974 as=0.1974 pd=1.78 ps=1.78 nrd=0.69047619047619  nrs=0.69047619047619 sa=0 sb=0 sd=0 mult=1 m=1
XMRD_cell1_r050_0900_1 rbl_cell1_r050_0900 sn_cell1_r050_0900_1 rwl_des 0 sky130_fd_pr__nfet_01v8 L=0.15 W=0.42 nf=1 ad=0.1974 as=0.1974 pd=1.78 ps=1.78 nrd=0.69047619047619  nrs=0.69047619047619 sa=0 sb=0 sd=0 mult=1 m=1
csn_cell1_r050_0900_1 sn_cell1_r050_0900_1 0 {C_SN}
XMWR_cell1_r050_0900_2 sn_cell1_r050_0900_2 0 0 0 sky130_fd_pr__nfet_01v8 L=0.15 W=0.42 nf=1 ad=0.1974 as=0.1974 pd=1.78 ps=1.78 nrd=0.69047619047619  nrs=0.69047619047619 sa=0 sb=0 sd=0 mult=1 m=1
XMRD_cell1_r050_0900_2 rbl_cell1_r050_0900 sn_cell1_r050_0900_2 rwl_des 0 sky130_fd_pr__nfet_01v8 L=0.15 W=0.42 nf=1 ad=0.1974 as=0.1974 pd=1.78 ps=1.78 nrd=0.69047619047619  nrs=0.69047619047619 sa=0 sb=0 sd=0 mult=1 m=1
csn_cell1_r050_0900_2 sn_cell1_r050_0900_2 0 {C_SN}
XMWR_cell1_r050_0900_3 sn_cell1_r050_0900_3 0 0 0 sky130_fd_pr__nfet_01v8 L=0.15 W=0.42 nf=1 ad=0.1974 as=0.1974 pd=1.78 ps=1.78 nrd=0.69047619047619  nrs=0.69047619047619 sa=0 sb=0 sd=0 mult=1 m=1
XMRD_cell1_r050_0900_3 rbl_cell1_r050_0900 sn_cell1_r050_0900_3 rwl_des 0 sky130_fd_pr__nfet_01v8 L=0.15 W=0.42 nf=1 ad=0.1974 as=0.1974 pd=1.78 ps=1.78 nrd=0.69047619047619  nrs=0.69047619047619 sa=0 sb=0 sd=0 mult=1 m=1
csn_cell1_r050_0900_3 sn_cell1_r050_0900_3 0 {C_SN}
crbl_cell1_r050_0900 rbl_cell1_r050_0900 0 {C_RBL}
spr_cell1_r050_0900 pref_050 ref_cell1_r050_0900 ctl 0 swpre
cref_cell1_r050_0900 ref_cell1_r050_0900 0 {C_RBL}   $ ASSUMPTION: ideal matched dummy load
XMN1_cell1_r050_0900 rbl_cell1_r050_0900 ref_cell1_r050_0900 vn_cell1_r050_0900 0 sky130_fd_pr__nfet_01v8 L=0.15 W=1 nf=1 ad=0.29 as=0.29 pd=2.58 ps=2.58 mult=1 m=1
XMN2_cell1_r050_0900 ref_cell1_r050_0900 rbl_cell1_r050_0900 vn_cell1_r050_0900 0 sky130_fd_pr__nfet_01v8 L=0.15 W=1 nf=1 ad=0.29 as=0.29 pd=2.58 ps=2.58 mult=1 m=1
XMP1_cell1_r050_0900 rbl_cell1_r050_0900 ref_cell1_r050_0900 vp_cell1_r050_0900 vdd sky130_fd_pr__pfet_01v8 L=0.15 W=2 nf=1 ad=0.58 as=0.58 pd=4.58 ps=4.58 mult=1 m=1
XMP2_cell1_r050_0900 ref_cell1_r050_0900 rbl_cell1_r050_0900 vp_cell1_r050_0900 vdd sky130_fd_pr__pfet_01v8 L=0.15 W=2 nf=1 ad=0.58 as=0.58 pd=4.58 ps=4.58 mult=1 m=1
XMNF_cell1_r050_0900 vn_cell1_r050_0900 en 0 0 sky130_fd_pr__nfet_01v8 L=0.15 W=2 nf=1 ad=0.58 as=0.58 pd=4.58 ps=4.58 mult=1 m=1
XMPH_cell1_r050_0900 vp_cell1_r050_0900 enb vdd vdd sky130_fd_pr__pfet_01v8 L=0.15 W=4 nf=1 ad=1.16 as=1.16 pd=8.58 ps=8.58 mult=1 m=1
bd_cell1_r050_0900 d_cell1_r050_0900 0 v=v(rbl_cell1_r050_0900)-v(ref_cell1_r050_0900)
bdabs_cell1_r050_0900 dabs_cell1_r050_0900 0 v=abs(v(rbl_cell1_r050_0900)-v(ref_cell1_r050_0900))

* ---- instance 50: cell1_r050_0950 ----
spa_cell1_r050_0950 prea rbl_cell1_r050_0950 ctl 0 swpre
XMWR_cell1_r050_0950_0 sn_cell1_r050_0950_0 0 0 0 sky130_fd_pr__nfet_01v8 L=0.15 W=0.42 nf=1 ad=0.1974 as=0.1974 pd=1.78 ps=1.78 nrd=0.69047619047619  nrs=0.69047619047619 sa=0 sb=0 sd=0 mult=1 m=1
XMRD_cell1_r050_0950_0 rbl_cell1_r050_0950 sn_cell1_r050_0950_0 rwl_sel 0 sky130_fd_pr__nfet_01v8 L=0.15 W=0.42 nf=1 ad=0.1974 as=0.1974 pd=1.78 ps=1.78 nrd=0.69047619047619  nrs=0.69047619047619 sa=0 sb=0 sd=0 mult=1 m=1
csn_cell1_r050_0950_0 sn_cell1_r050_0950_0 0 {C_SN}
XMWR_cell1_r050_0950_1 sn_cell1_r050_0950_1 0 0 0 sky130_fd_pr__nfet_01v8 L=0.15 W=0.42 nf=1 ad=0.1974 as=0.1974 pd=1.78 ps=1.78 nrd=0.69047619047619  nrs=0.69047619047619 sa=0 sb=0 sd=0 mult=1 m=1
XMRD_cell1_r050_0950_1 rbl_cell1_r050_0950 sn_cell1_r050_0950_1 rwl_des 0 sky130_fd_pr__nfet_01v8 L=0.15 W=0.42 nf=1 ad=0.1974 as=0.1974 pd=1.78 ps=1.78 nrd=0.69047619047619  nrs=0.69047619047619 sa=0 sb=0 sd=0 mult=1 m=1
csn_cell1_r050_0950_1 sn_cell1_r050_0950_1 0 {C_SN}
XMWR_cell1_r050_0950_2 sn_cell1_r050_0950_2 0 0 0 sky130_fd_pr__nfet_01v8 L=0.15 W=0.42 nf=1 ad=0.1974 as=0.1974 pd=1.78 ps=1.78 nrd=0.69047619047619  nrs=0.69047619047619 sa=0 sb=0 sd=0 mult=1 m=1
XMRD_cell1_r050_0950_2 rbl_cell1_r050_0950 sn_cell1_r050_0950_2 rwl_des 0 sky130_fd_pr__nfet_01v8 L=0.15 W=0.42 nf=1 ad=0.1974 as=0.1974 pd=1.78 ps=1.78 nrd=0.69047619047619  nrs=0.69047619047619 sa=0 sb=0 sd=0 mult=1 m=1
csn_cell1_r050_0950_2 sn_cell1_r050_0950_2 0 {C_SN}
XMWR_cell1_r050_0950_3 sn_cell1_r050_0950_3 0 0 0 sky130_fd_pr__nfet_01v8 L=0.15 W=0.42 nf=1 ad=0.1974 as=0.1974 pd=1.78 ps=1.78 nrd=0.69047619047619  nrs=0.69047619047619 sa=0 sb=0 sd=0 mult=1 m=1
XMRD_cell1_r050_0950_3 rbl_cell1_r050_0950 sn_cell1_r050_0950_3 rwl_des 0 sky130_fd_pr__nfet_01v8 L=0.15 W=0.42 nf=1 ad=0.1974 as=0.1974 pd=1.78 ps=1.78 nrd=0.69047619047619  nrs=0.69047619047619 sa=0 sb=0 sd=0 mult=1 m=1
csn_cell1_r050_0950_3 sn_cell1_r050_0950_3 0 {C_SN}
crbl_cell1_r050_0950 rbl_cell1_r050_0950 0 {C_RBL}
spr_cell1_r050_0950 pref_050 ref_cell1_r050_0950 ctl 0 swpre
cref_cell1_r050_0950 ref_cell1_r050_0950 0 {C_RBL}   $ ASSUMPTION: ideal matched dummy load
XMN1_cell1_r050_0950 rbl_cell1_r050_0950 ref_cell1_r050_0950 vn_cell1_r050_0950 0 sky130_fd_pr__nfet_01v8 L=0.15 W=1 nf=1 ad=0.29 as=0.29 pd=2.58 ps=2.58 mult=1 m=1
XMN2_cell1_r050_0950 ref_cell1_r050_0950 rbl_cell1_r050_0950 vn_cell1_r050_0950 0 sky130_fd_pr__nfet_01v8 L=0.15 W=1 nf=1 ad=0.29 as=0.29 pd=2.58 ps=2.58 mult=1 m=1
XMP1_cell1_r050_0950 rbl_cell1_r050_0950 ref_cell1_r050_0950 vp_cell1_r050_0950 vdd sky130_fd_pr__pfet_01v8 L=0.15 W=2 nf=1 ad=0.58 as=0.58 pd=4.58 ps=4.58 mult=1 m=1
XMP2_cell1_r050_0950 ref_cell1_r050_0950 rbl_cell1_r050_0950 vp_cell1_r050_0950 vdd sky130_fd_pr__pfet_01v8 L=0.15 W=2 nf=1 ad=0.58 as=0.58 pd=4.58 ps=4.58 mult=1 m=1
XMNF_cell1_r050_0950 vn_cell1_r050_0950 en 0 0 sky130_fd_pr__nfet_01v8 L=0.15 W=2 nf=1 ad=0.58 as=0.58 pd=4.58 ps=4.58 mult=1 m=1
XMPH_cell1_r050_0950 vp_cell1_r050_0950 enb vdd vdd sky130_fd_pr__pfet_01v8 L=0.15 W=4 nf=1 ad=1.16 as=1.16 pd=8.58 ps=8.58 mult=1 m=1
bd_cell1_r050_0950 d_cell1_r050_0950 0 v=v(rbl_cell1_r050_0950)-v(ref_cell1_r050_0950)
bdabs_cell1_r050_0950 dabs_cell1_r050_0950 0 v=abs(v(rbl_cell1_r050_0950)-v(ref_cell1_r050_0950))

* ---- instance 51: cell1_r050_1000 ----
spa_cell1_r050_1000 prea rbl_cell1_r050_1000 ctl 0 swpre
XMWR_cell1_r050_1000_0 sn_cell1_r050_1000_0 0 0 0 sky130_fd_pr__nfet_01v8 L=0.15 W=0.42 nf=1 ad=0.1974 as=0.1974 pd=1.78 ps=1.78 nrd=0.69047619047619  nrs=0.69047619047619 sa=0 sb=0 sd=0 mult=1 m=1
XMRD_cell1_r050_1000_0 rbl_cell1_r050_1000 sn_cell1_r050_1000_0 rwl_sel 0 sky130_fd_pr__nfet_01v8 L=0.15 W=0.42 nf=1 ad=0.1974 as=0.1974 pd=1.78 ps=1.78 nrd=0.69047619047619  nrs=0.69047619047619 sa=0 sb=0 sd=0 mult=1 m=1
csn_cell1_r050_1000_0 sn_cell1_r050_1000_0 0 {C_SN}
XMWR_cell1_r050_1000_1 sn_cell1_r050_1000_1 0 0 0 sky130_fd_pr__nfet_01v8 L=0.15 W=0.42 nf=1 ad=0.1974 as=0.1974 pd=1.78 ps=1.78 nrd=0.69047619047619  nrs=0.69047619047619 sa=0 sb=0 sd=0 mult=1 m=1
XMRD_cell1_r050_1000_1 rbl_cell1_r050_1000 sn_cell1_r050_1000_1 rwl_des 0 sky130_fd_pr__nfet_01v8 L=0.15 W=0.42 nf=1 ad=0.1974 as=0.1974 pd=1.78 ps=1.78 nrd=0.69047619047619  nrs=0.69047619047619 sa=0 sb=0 sd=0 mult=1 m=1
csn_cell1_r050_1000_1 sn_cell1_r050_1000_1 0 {C_SN}
XMWR_cell1_r050_1000_2 sn_cell1_r050_1000_2 0 0 0 sky130_fd_pr__nfet_01v8 L=0.15 W=0.42 nf=1 ad=0.1974 as=0.1974 pd=1.78 ps=1.78 nrd=0.69047619047619  nrs=0.69047619047619 sa=0 sb=0 sd=0 mult=1 m=1
XMRD_cell1_r050_1000_2 rbl_cell1_r050_1000 sn_cell1_r050_1000_2 rwl_des 0 sky130_fd_pr__nfet_01v8 L=0.15 W=0.42 nf=1 ad=0.1974 as=0.1974 pd=1.78 ps=1.78 nrd=0.69047619047619  nrs=0.69047619047619 sa=0 sb=0 sd=0 mult=1 m=1
csn_cell1_r050_1000_2 sn_cell1_r050_1000_2 0 {C_SN}
XMWR_cell1_r050_1000_3 sn_cell1_r050_1000_3 0 0 0 sky130_fd_pr__nfet_01v8 L=0.15 W=0.42 nf=1 ad=0.1974 as=0.1974 pd=1.78 ps=1.78 nrd=0.69047619047619  nrs=0.69047619047619 sa=0 sb=0 sd=0 mult=1 m=1
XMRD_cell1_r050_1000_3 rbl_cell1_r050_1000 sn_cell1_r050_1000_3 rwl_des 0 sky130_fd_pr__nfet_01v8 L=0.15 W=0.42 nf=1 ad=0.1974 as=0.1974 pd=1.78 ps=1.78 nrd=0.69047619047619  nrs=0.69047619047619 sa=0 sb=0 sd=0 mult=1 m=1
csn_cell1_r050_1000_3 sn_cell1_r050_1000_3 0 {C_SN}
crbl_cell1_r050_1000 rbl_cell1_r050_1000 0 {C_RBL}
spr_cell1_r050_1000 pref_050 ref_cell1_r050_1000 ctl 0 swpre
cref_cell1_r050_1000 ref_cell1_r050_1000 0 {C_RBL}   $ ASSUMPTION: ideal matched dummy load
XMN1_cell1_r050_1000 rbl_cell1_r050_1000 ref_cell1_r050_1000 vn_cell1_r050_1000 0 sky130_fd_pr__nfet_01v8 L=0.15 W=1 nf=1 ad=0.29 as=0.29 pd=2.58 ps=2.58 mult=1 m=1
XMN2_cell1_r050_1000 ref_cell1_r050_1000 rbl_cell1_r050_1000 vn_cell1_r050_1000 0 sky130_fd_pr__nfet_01v8 L=0.15 W=1 nf=1 ad=0.29 as=0.29 pd=2.58 ps=2.58 mult=1 m=1
XMP1_cell1_r050_1000 rbl_cell1_r050_1000 ref_cell1_r050_1000 vp_cell1_r050_1000 vdd sky130_fd_pr__pfet_01v8 L=0.15 W=2 nf=1 ad=0.58 as=0.58 pd=4.58 ps=4.58 mult=1 m=1
XMP2_cell1_r050_1000 ref_cell1_r050_1000 rbl_cell1_r050_1000 vp_cell1_r050_1000 vdd sky130_fd_pr__pfet_01v8 L=0.15 W=2 nf=1 ad=0.58 as=0.58 pd=4.58 ps=4.58 mult=1 m=1
XMNF_cell1_r050_1000 vn_cell1_r050_1000 en 0 0 sky130_fd_pr__nfet_01v8 L=0.15 W=2 nf=1 ad=0.58 as=0.58 pd=4.58 ps=4.58 mult=1 m=1
XMPH_cell1_r050_1000 vp_cell1_r050_1000 enb vdd vdd sky130_fd_pr__pfet_01v8 L=0.15 W=4 nf=1 ad=1.16 as=1.16 pd=8.58 ps=8.58 mult=1 m=1
bd_cell1_r050_1000 d_cell1_r050_1000 0 v=v(rbl_cell1_r050_1000)-v(ref_cell1_r050_1000)
bdabs_cell1_r050_1000 dabs_cell1_r050_1000 0 v=abs(v(rbl_cell1_r050_1000)-v(ref_cell1_r050_1000))

* ---- instance 52: cell1_r050_1050 ----
spa_cell1_r050_1050 prea rbl_cell1_r050_1050 ctl 0 swpre
XMWR_cell1_r050_1050_0 sn_cell1_r050_1050_0 0 0 0 sky130_fd_pr__nfet_01v8 L=0.15 W=0.42 nf=1 ad=0.1974 as=0.1974 pd=1.78 ps=1.78 nrd=0.69047619047619  nrs=0.69047619047619 sa=0 sb=0 sd=0 mult=1 m=1
XMRD_cell1_r050_1050_0 rbl_cell1_r050_1050 sn_cell1_r050_1050_0 rwl_sel 0 sky130_fd_pr__nfet_01v8 L=0.15 W=0.42 nf=1 ad=0.1974 as=0.1974 pd=1.78 ps=1.78 nrd=0.69047619047619  nrs=0.69047619047619 sa=0 sb=0 sd=0 mult=1 m=1
csn_cell1_r050_1050_0 sn_cell1_r050_1050_0 0 {C_SN}
XMWR_cell1_r050_1050_1 sn_cell1_r050_1050_1 0 0 0 sky130_fd_pr__nfet_01v8 L=0.15 W=0.42 nf=1 ad=0.1974 as=0.1974 pd=1.78 ps=1.78 nrd=0.69047619047619  nrs=0.69047619047619 sa=0 sb=0 sd=0 mult=1 m=1
XMRD_cell1_r050_1050_1 rbl_cell1_r050_1050 sn_cell1_r050_1050_1 rwl_des 0 sky130_fd_pr__nfet_01v8 L=0.15 W=0.42 nf=1 ad=0.1974 as=0.1974 pd=1.78 ps=1.78 nrd=0.69047619047619  nrs=0.69047619047619 sa=0 sb=0 sd=0 mult=1 m=1
csn_cell1_r050_1050_1 sn_cell1_r050_1050_1 0 {C_SN}
XMWR_cell1_r050_1050_2 sn_cell1_r050_1050_2 0 0 0 sky130_fd_pr__nfet_01v8 L=0.15 W=0.42 nf=1 ad=0.1974 as=0.1974 pd=1.78 ps=1.78 nrd=0.69047619047619  nrs=0.69047619047619 sa=0 sb=0 sd=0 mult=1 m=1
XMRD_cell1_r050_1050_2 rbl_cell1_r050_1050 sn_cell1_r050_1050_2 rwl_des 0 sky130_fd_pr__nfet_01v8 L=0.15 W=0.42 nf=1 ad=0.1974 as=0.1974 pd=1.78 ps=1.78 nrd=0.69047619047619  nrs=0.69047619047619 sa=0 sb=0 sd=0 mult=1 m=1
csn_cell1_r050_1050_2 sn_cell1_r050_1050_2 0 {C_SN}
XMWR_cell1_r050_1050_3 sn_cell1_r050_1050_3 0 0 0 sky130_fd_pr__nfet_01v8 L=0.15 W=0.42 nf=1 ad=0.1974 as=0.1974 pd=1.78 ps=1.78 nrd=0.69047619047619  nrs=0.69047619047619 sa=0 sb=0 sd=0 mult=1 m=1
XMRD_cell1_r050_1050_3 rbl_cell1_r050_1050 sn_cell1_r050_1050_3 rwl_des 0 sky130_fd_pr__nfet_01v8 L=0.15 W=0.42 nf=1 ad=0.1974 as=0.1974 pd=1.78 ps=1.78 nrd=0.69047619047619  nrs=0.69047619047619 sa=0 sb=0 sd=0 mult=1 m=1
csn_cell1_r050_1050_3 sn_cell1_r050_1050_3 0 {C_SN}
crbl_cell1_r050_1050 rbl_cell1_r050_1050 0 {C_RBL}
spr_cell1_r050_1050 pref_050 ref_cell1_r050_1050 ctl 0 swpre
cref_cell1_r050_1050 ref_cell1_r050_1050 0 {C_RBL}   $ ASSUMPTION: ideal matched dummy load
XMN1_cell1_r050_1050 rbl_cell1_r050_1050 ref_cell1_r050_1050 vn_cell1_r050_1050 0 sky130_fd_pr__nfet_01v8 L=0.15 W=1 nf=1 ad=0.29 as=0.29 pd=2.58 ps=2.58 mult=1 m=1
XMN2_cell1_r050_1050 ref_cell1_r050_1050 rbl_cell1_r050_1050 vn_cell1_r050_1050 0 sky130_fd_pr__nfet_01v8 L=0.15 W=1 nf=1 ad=0.29 as=0.29 pd=2.58 ps=2.58 mult=1 m=1
XMP1_cell1_r050_1050 rbl_cell1_r050_1050 ref_cell1_r050_1050 vp_cell1_r050_1050 vdd sky130_fd_pr__pfet_01v8 L=0.15 W=2 nf=1 ad=0.58 as=0.58 pd=4.58 ps=4.58 mult=1 m=1
XMP2_cell1_r050_1050 ref_cell1_r050_1050 rbl_cell1_r050_1050 vp_cell1_r050_1050 vdd sky130_fd_pr__pfet_01v8 L=0.15 W=2 nf=1 ad=0.58 as=0.58 pd=4.58 ps=4.58 mult=1 m=1
XMNF_cell1_r050_1050 vn_cell1_r050_1050 en 0 0 sky130_fd_pr__nfet_01v8 L=0.15 W=2 nf=1 ad=0.58 as=0.58 pd=4.58 ps=4.58 mult=1 m=1
XMPH_cell1_r050_1050 vp_cell1_r050_1050 enb vdd vdd sky130_fd_pr__pfet_01v8 L=0.15 W=4 nf=1 ad=1.16 as=1.16 pd=8.58 ps=8.58 mult=1 m=1
bd_cell1_r050_1050 d_cell1_r050_1050 0 v=v(rbl_cell1_r050_1050)-v(ref_cell1_r050_1050)
bdabs_cell1_r050_1050 dabs_cell1_r050_1050 0 v=abs(v(rbl_cell1_r050_1050)-v(ref_cell1_r050_1050))

* ---- instance 53: cell1_r050_1100 ----
spa_cell1_r050_1100 prea rbl_cell1_r050_1100 ctl 0 swpre
XMWR_cell1_r050_1100_0 sn_cell1_r050_1100_0 0 0 0 sky130_fd_pr__nfet_01v8 L=0.15 W=0.42 nf=1 ad=0.1974 as=0.1974 pd=1.78 ps=1.78 nrd=0.69047619047619  nrs=0.69047619047619 sa=0 sb=0 sd=0 mult=1 m=1
XMRD_cell1_r050_1100_0 rbl_cell1_r050_1100 sn_cell1_r050_1100_0 rwl_sel 0 sky130_fd_pr__nfet_01v8 L=0.15 W=0.42 nf=1 ad=0.1974 as=0.1974 pd=1.78 ps=1.78 nrd=0.69047619047619  nrs=0.69047619047619 sa=0 sb=0 sd=0 mult=1 m=1
csn_cell1_r050_1100_0 sn_cell1_r050_1100_0 0 {C_SN}
XMWR_cell1_r050_1100_1 sn_cell1_r050_1100_1 0 0 0 sky130_fd_pr__nfet_01v8 L=0.15 W=0.42 nf=1 ad=0.1974 as=0.1974 pd=1.78 ps=1.78 nrd=0.69047619047619  nrs=0.69047619047619 sa=0 sb=0 sd=0 mult=1 m=1
XMRD_cell1_r050_1100_1 rbl_cell1_r050_1100 sn_cell1_r050_1100_1 rwl_des 0 sky130_fd_pr__nfet_01v8 L=0.15 W=0.42 nf=1 ad=0.1974 as=0.1974 pd=1.78 ps=1.78 nrd=0.69047619047619  nrs=0.69047619047619 sa=0 sb=0 sd=0 mult=1 m=1
csn_cell1_r050_1100_1 sn_cell1_r050_1100_1 0 {C_SN}
XMWR_cell1_r050_1100_2 sn_cell1_r050_1100_2 0 0 0 sky130_fd_pr__nfet_01v8 L=0.15 W=0.42 nf=1 ad=0.1974 as=0.1974 pd=1.78 ps=1.78 nrd=0.69047619047619  nrs=0.69047619047619 sa=0 sb=0 sd=0 mult=1 m=1
XMRD_cell1_r050_1100_2 rbl_cell1_r050_1100 sn_cell1_r050_1100_2 rwl_des 0 sky130_fd_pr__nfet_01v8 L=0.15 W=0.42 nf=1 ad=0.1974 as=0.1974 pd=1.78 ps=1.78 nrd=0.69047619047619  nrs=0.69047619047619 sa=0 sb=0 sd=0 mult=1 m=1
csn_cell1_r050_1100_2 sn_cell1_r050_1100_2 0 {C_SN}
XMWR_cell1_r050_1100_3 sn_cell1_r050_1100_3 0 0 0 sky130_fd_pr__nfet_01v8 L=0.15 W=0.42 nf=1 ad=0.1974 as=0.1974 pd=1.78 ps=1.78 nrd=0.69047619047619  nrs=0.69047619047619 sa=0 sb=0 sd=0 mult=1 m=1
XMRD_cell1_r050_1100_3 rbl_cell1_r050_1100 sn_cell1_r050_1100_3 rwl_des 0 sky130_fd_pr__nfet_01v8 L=0.15 W=0.42 nf=1 ad=0.1974 as=0.1974 pd=1.78 ps=1.78 nrd=0.69047619047619  nrs=0.69047619047619 sa=0 sb=0 sd=0 mult=1 m=1
csn_cell1_r050_1100_3 sn_cell1_r050_1100_3 0 {C_SN}
crbl_cell1_r050_1100 rbl_cell1_r050_1100 0 {C_RBL}
spr_cell1_r050_1100 pref_050 ref_cell1_r050_1100 ctl 0 swpre
cref_cell1_r050_1100 ref_cell1_r050_1100 0 {C_RBL}   $ ASSUMPTION: ideal matched dummy load
XMN1_cell1_r050_1100 rbl_cell1_r050_1100 ref_cell1_r050_1100 vn_cell1_r050_1100 0 sky130_fd_pr__nfet_01v8 L=0.15 W=1 nf=1 ad=0.29 as=0.29 pd=2.58 ps=2.58 mult=1 m=1
XMN2_cell1_r050_1100 ref_cell1_r050_1100 rbl_cell1_r050_1100 vn_cell1_r050_1100 0 sky130_fd_pr__nfet_01v8 L=0.15 W=1 nf=1 ad=0.29 as=0.29 pd=2.58 ps=2.58 mult=1 m=1
XMP1_cell1_r050_1100 rbl_cell1_r050_1100 ref_cell1_r050_1100 vp_cell1_r050_1100 vdd sky130_fd_pr__pfet_01v8 L=0.15 W=2 nf=1 ad=0.58 as=0.58 pd=4.58 ps=4.58 mult=1 m=1
XMP2_cell1_r050_1100 ref_cell1_r050_1100 rbl_cell1_r050_1100 vp_cell1_r050_1100 vdd sky130_fd_pr__pfet_01v8 L=0.15 W=2 nf=1 ad=0.58 as=0.58 pd=4.58 ps=4.58 mult=1 m=1
XMNF_cell1_r050_1100 vn_cell1_r050_1100 en 0 0 sky130_fd_pr__nfet_01v8 L=0.15 W=2 nf=1 ad=0.58 as=0.58 pd=4.58 ps=4.58 mult=1 m=1
XMPH_cell1_r050_1100 vp_cell1_r050_1100 enb vdd vdd sky130_fd_pr__pfet_01v8 L=0.15 W=4 nf=1 ad=1.16 as=1.16 pd=8.58 ps=8.58 mult=1 m=1
bd_cell1_r050_1100 d_cell1_r050_1100 0 v=v(rbl_cell1_r050_1100)-v(ref_cell1_r050_1100)
bdabs_cell1_r050_1100 dabs_cell1_r050_1100 0 v=abs(v(rbl_cell1_r050_1100)-v(ref_cell1_r050_1100))

* ---- instance 54: cell1_r050_1150 ----
spa_cell1_r050_1150 prea rbl_cell1_r050_1150 ctl 0 swpre
XMWR_cell1_r050_1150_0 sn_cell1_r050_1150_0 0 0 0 sky130_fd_pr__nfet_01v8 L=0.15 W=0.42 nf=1 ad=0.1974 as=0.1974 pd=1.78 ps=1.78 nrd=0.69047619047619  nrs=0.69047619047619 sa=0 sb=0 sd=0 mult=1 m=1
XMRD_cell1_r050_1150_0 rbl_cell1_r050_1150 sn_cell1_r050_1150_0 rwl_sel 0 sky130_fd_pr__nfet_01v8 L=0.15 W=0.42 nf=1 ad=0.1974 as=0.1974 pd=1.78 ps=1.78 nrd=0.69047619047619  nrs=0.69047619047619 sa=0 sb=0 sd=0 mult=1 m=1
csn_cell1_r050_1150_0 sn_cell1_r050_1150_0 0 {C_SN}
XMWR_cell1_r050_1150_1 sn_cell1_r050_1150_1 0 0 0 sky130_fd_pr__nfet_01v8 L=0.15 W=0.42 nf=1 ad=0.1974 as=0.1974 pd=1.78 ps=1.78 nrd=0.69047619047619  nrs=0.69047619047619 sa=0 sb=0 sd=0 mult=1 m=1
XMRD_cell1_r050_1150_1 rbl_cell1_r050_1150 sn_cell1_r050_1150_1 rwl_des 0 sky130_fd_pr__nfet_01v8 L=0.15 W=0.42 nf=1 ad=0.1974 as=0.1974 pd=1.78 ps=1.78 nrd=0.69047619047619  nrs=0.69047619047619 sa=0 sb=0 sd=0 mult=1 m=1
csn_cell1_r050_1150_1 sn_cell1_r050_1150_1 0 {C_SN}
XMWR_cell1_r050_1150_2 sn_cell1_r050_1150_2 0 0 0 sky130_fd_pr__nfet_01v8 L=0.15 W=0.42 nf=1 ad=0.1974 as=0.1974 pd=1.78 ps=1.78 nrd=0.69047619047619  nrs=0.69047619047619 sa=0 sb=0 sd=0 mult=1 m=1
XMRD_cell1_r050_1150_2 rbl_cell1_r050_1150 sn_cell1_r050_1150_2 rwl_des 0 sky130_fd_pr__nfet_01v8 L=0.15 W=0.42 nf=1 ad=0.1974 as=0.1974 pd=1.78 ps=1.78 nrd=0.69047619047619  nrs=0.69047619047619 sa=0 sb=0 sd=0 mult=1 m=1
csn_cell1_r050_1150_2 sn_cell1_r050_1150_2 0 {C_SN}
XMWR_cell1_r050_1150_3 sn_cell1_r050_1150_3 0 0 0 sky130_fd_pr__nfet_01v8 L=0.15 W=0.42 nf=1 ad=0.1974 as=0.1974 pd=1.78 ps=1.78 nrd=0.69047619047619  nrs=0.69047619047619 sa=0 sb=0 sd=0 mult=1 m=1
XMRD_cell1_r050_1150_3 rbl_cell1_r050_1150 sn_cell1_r050_1150_3 rwl_des 0 sky130_fd_pr__nfet_01v8 L=0.15 W=0.42 nf=1 ad=0.1974 as=0.1974 pd=1.78 ps=1.78 nrd=0.69047619047619  nrs=0.69047619047619 sa=0 sb=0 sd=0 mult=1 m=1
csn_cell1_r050_1150_3 sn_cell1_r050_1150_3 0 {C_SN}
crbl_cell1_r050_1150 rbl_cell1_r050_1150 0 {C_RBL}
spr_cell1_r050_1150 pref_050 ref_cell1_r050_1150 ctl 0 swpre
cref_cell1_r050_1150 ref_cell1_r050_1150 0 {C_RBL}   $ ASSUMPTION: ideal matched dummy load
XMN1_cell1_r050_1150 rbl_cell1_r050_1150 ref_cell1_r050_1150 vn_cell1_r050_1150 0 sky130_fd_pr__nfet_01v8 L=0.15 W=1 nf=1 ad=0.29 as=0.29 pd=2.58 ps=2.58 mult=1 m=1
XMN2_cell1_r050_1150 ref_cell1_r050_1150 rbl_cell1_r050_1150 vn_cell1_r050_1150 0 sky130_fd_pr__nfet_01v8 L=0.15 W=1 nf=1 ad=0.29 as=0.29 pd=2.58 ps=2.58 mult=1 m=1
XMP1_cell1_r050_1150 rbl_cell1_r050_1150 ref_cell1_r050_1150 vp_cell1_r050_1150 vdd sky130_fd_pr__pfet_01v8 L=0.15 W=2 nf=1 ad=0.58 as=0.58 pd=4.58 ps=4.58 mult=1 m=1
XMP2_cell1_r050_1150 ref_cell1_r050_1150 rbl_cell1_r050_1150 vp_cell1_r050_1150 vdd sky130_fd_pr__pfet_01v8 L=0.15 W=2 nf=1 ad=0.58 as=0.58 pd=4.58 ps=4.58 mult=1 m=1
XMNF_cell1_r050_1150 vn_cell1_r050_1150 en 0 0 sky130_fd_pr__nfet_01v8 L=0.15 W=2 nf=1 ad=0.58 as=0.58 pd=4.58 ps=4.58 mult=1 m=1
XMPH_cell1_r050_1150 vp_cell1_r050_1150 enb vdd vdd sky130_fd_pr__pfet_01v8 L=0.15 W=4 nf=1 ad=1.16 as=1.16 pd=8.58 ps=8.58 mult=1 m=1
bd_cell1_r050_1150 d_cell1_r050_1150 0 v=v(rbl_cell1_r050_1150)-v(ref_cell1_r050_1150)
bdabs_cell1_r050_1150 dabs_cell1_r050_1150 0 v=abs(v(rbl_cell1_r050_1150)-v(ref_cell1_r050_1150))

* ---- instance 55: cell1_r050_1200 ----
spa_cell1_r050_1200 prea rbl_cell1_r050_1200 ctl 0 swpre
XMWR_cell1_r050_1200_0 sn_cell1_r050_1200_0 0 0 0 sky130_fd_pr__nfet_01v8 L=0.15 W=0.42 nf=1 ad=0.1974 as=0.1974 pd=1.78 ps=1.78 nrd=0.69047619047619  nrs=0.69047619047619 sa=0 sb=0 sd=0 mult=1 m=1
XMRD_cell1_r050_1200_0 rbl_cell1_r050_1200 sn_cell1_r050_1200_0 rwl_sel 0 sky130_fd_pr__nfet_01v8 L=0.15 W=0.42 nf=1 ad=0.1974 as=0.1974 pd=1.78 ps=1.78 nrd=0.69047619047619  nrs=0.69047619047619 sa=0 sb=0 sd=0 mult=1 m=1
csn_cell1_r050_1200_0 sn_cell1_r050_1200_0 0 {C_SN}
XMWR_cell1_r050_1200_1 sn_cell1_r050_1200_1 0 0 0 sky130_fd_pr__nfet_01v8 L=0.15 W=0.42 nf=1 ad=0.1974 as=0.1974 pd=1.78 ps=1.78 nrd=0.69047619047619  nrs=0.69047619047619 sa=0 sb=0 sd=0 mult=1 m=1
XMRD_cell1_r050_1200_1 rbl_cell1_r050_1200 sn_cell1_r050_1200_1 rwl_des 0 sky130_fd_pr__nfet_01v8 L=0.15 W=0.42 nf=1 ad=0.1974 as=0.1974 pd=1.78 ps=1.78 nrd=0.69047619047619  nrs=0.69047619047619 sa=0 sb=0 sd=0 mult=1 m=1
csn_cell1_r050_1200_1 sn_cell1_r050_1200_1 0 {C_SN}
XMWR_cell1_r050_1200_2 sn_cell1_r050_1200_2 0 0 0 sky130_fd_pr__nfet_01v8 L=0.15 W=0.42 nf=1 ad=0.1974 as=0.1974 pd=1.78 ps=1.78 nrd=0.69047619047619  nrs=0.69047619047619 sa=0 sb=0 sd=0 mult=1 m=1
XMRD_cell1_r050_1200_2 rbl_cell1_r050_1200 sn_cell1_r050_1200_2 rwl_des 0 sky130_fd_pr__nfet_01v8 L=0.15 W=0.42 nf=1 ad=0.1974 as=0.1974 pd=1.78 ps=1.78 nrd=0.69047619047619  nrs=0.69047619047619 sa=0 sb=0 sd=0 mult=1 m=1
csn_cell1_r050_1200_2 sn_cell1_r050_1200_2 0 {C_SN}
XMWR_cell1_r050_1200_3 sn_cell1_r050_1200_3 0 0 0 sky130_fd_pr__nfet_01v8 L=0.15 W=0.42 nf=1 ad=0.1974 as=0.1974 pd=1.78 ps=1.78 nrd=0.69047619047619  nrs=0.69047619047619 sa=0 sb=0 sd=0 mult=1 m=1
XMRD_cell1_r050_1200_3 rbl_cell1_r050_1200 sn_cell1_r050_1200_3 rwl_des 0 sky130_fd_pr__nfet_01v8 L=0.15 W=0.42 nf=1 ad=0.1974 as=0.1974 pd=1.78 ps=1.78 nrd=0.69047619047619  nrs=0.69047619047619 sa=0 sb=0 sd=0 mult=1 m=1
csn_cell1_r050_1200_3 sn_cell1_r050_1200_3 0 {C_SN}
crbl_cell1_r050_1200 rbl_cell1_r050_1200 0 {C_RBL}
spr_cell1_r050_1200 pref_050 ref_cell1_r050_1200 ctl 0 swpre
cref_cell1_r050_1200 ref_cell1_r050_1200 0 {C_RBL}   $ ASSUMPTION: ideal matched dummy load
XMN1_cell1_r050_1200 rbl_cell1_r050_1200 ref_cell1_r050_1200 vn_cell1_r050_1200 0 sky130_fd_pr__nfet_01v8 L=0.15 W=1 nf=1 ad=0.29 as=0.29 pd=2.58 ps=2.58 mult=1 m=1
XMN2_cell1_r050_1200 ref_cell1_r050_1200 rbl_cell1_r050_1200 vn_cell1_r050_1200 0 sky130_fd_pr__nfet_01v8 L=0.15 W=1 nf=1 ad=0.29 as=0.29 pd=2.58 ps=2.58 mult=1 m=1
XMP1_cell1_r050_1200 rbl_cell1_r050_1200 ref_cell1_r050_1200 vp_cell1_r050_1200 vdd sky130_fd_pr__pfet_01v8 L=0.15 W=2 nf=1 ad=0.58 as=0.58 pd=4.58 ps=4.58 mult=1 m=1
XMP2_cell1_r050_1200 ref_cell1_r050_1200 rbl_cell1_r050_1200 vp_cell1_r050_1200 vdd sky130_fd_pr__pfet_01v8 L=0.15 W=2 nf=1 ad=0.58 as=0.58 pd=4.58 ps=4.58 mult=1 m=1
XMNF_cell1_r050_1200 vn_cell1_r050_1200 en 0 0 sky130_fd_pr__nfet_01v8 L=0.15 W=2 nf=1 ad=0.58 as=0.58 pd=4.58 ps=4.58 mult=1 m=1
XMPH_cell1_r050_1200 vp_cell1_r050_1200 enb vdd vdd sky130_fd_pr__pfet_01v8 L=0.15 W=4 nf=1 ad=1.16 as=1.16 pd=8.58 ps=8.58 mult=1 m=1
bd_cell1_r050_1200 d_cell1_r050_1200 0 v=v(rbl_cell1_r050_1200)-v(ref_cell1_r050_1200)
bdabs_cell1_r050_1200 dabs_cell1_r050_1200 0 v=abs(v(rbl_cell1_r050_1200)-v(ref_cell1_r050_1200))

* ---- instance 56: cell0_r100_n100 ----
spa_cell0_r100_n100 prea rbl_cell0_r100_n100 ctl 0 swpre
XMWR_cell0_r100_n100_0 sn_cell0_r100_n100_0 0 0 0 sky130_fd_pr__nfet_01v8 L=0.15 W=0.42 nf=1 ad=0.1974 as=0.1974 pd=1.78 ps=1.78 nrd=0.69047619047619  nrs=0.69047619047619 sa=0 sb=0 sd=0 mult=1 m=1
XMRD_cell0_r100_n100_0 rbl_cell0_r100_n100 sn_cell0_r100_n100_0 rwl_sel 0 sky130_fd_pr__nfet_01v8 L=0.15 W=0.42 nf=1 ad=0.1974 as=0.1974 pd=1.78 ps=1.78 nrd=0.69047619047619  nrs=0.69047619047619 sa=0 sb=0 sd=0 mult=1 m=1
csn_cell0_r100_n100_0 sn_cell0_r100_n100_0 0 {C_SN}
XMWR_cell0_r100_n100_1 sn_cell0_r100_n100_1 0 0 0 sky130_fd_pr__nfet_01v8 L=0.15 W=0.42 nf=1 ad=0.1974 as=0.1974 pd=1.78 ps=1.78 nrd=0.69047619047619  nrs=0.69047619047619 sa=0 sb=0 sd=0 mult=1 m=1
XMRD_cell0_r100_n100_1 rbl_cell0_r100_n100 sn_cell0_r100_n100_1 rwl_des 0 sky130_fd_pr__nfet_01v8 L=0.15 W=0.42 nf=1 ad=0.1974 as=0.1974 pd=1.78 ps=1.78 nrd=0.69047619047619  nrs=0.69047619047619 sa=0 sb=0 sd=0 mult=1 m=1
csn_cell0_r100_n100_1 sn_cell0_r100_n100_1 0 {C_SN}
XMWR_cell0_r100_n100_2 sn_cell0_r100_n100_2 0 0 0 sky130_fd_pr__nfet_01v8 L=0.15 W=0.42 nf=1 ad=0.1974 as=0.1974 pd=1.78 ps=1.78 nrd=0.69047619047619  nrs=0.69047619047619 sa=0 sb=0 sd=0 mult=1 m=1
XMRD_cell0_r100_n100_2 rbl_cell0_r100_n100 sn_cell0_r100_n100_2 rwl_des 0 sky130_fd_pr__nfet_01v8 L=0.15 W=0.42 nf=1 ad=0.1974 as=0.1974 pd=1.78 ps=1.78 nrd=0.69047619047619  nrs=0.69047619047619 sa=0 sb=0 sd=0 mult=1 m=1
csn_cell0_r100_n100_2 sn_cell0_r100_n100_2 0 {C_SN}
XMWR_cell0_r100_n100_3 sn_cell0_r100_n100_3 0 0 0 sky130_fd_pr__nfet_01v8 L=0.15 W=0.42 nf=1 ad=0.1974 as=0.1974 pd=1.78 ps=1.78 nrd=0.69047619047619  nrs=0.69047619047619 sa=0 sb=0 sd=0 mult=1 m=1
XMRD_cell0_r100_n100_3 rbl_cell0_r100_n100 sn_cell0_r100_n100_3 rwl_des 0 sky130_fd_pr__nfet_01v8 L=0.15 W=0.42 nf=1 ad=0.1974 as=0.1974 pd=1.78 ps=1.78 nrd=0.69047619047619  nrs=0.69047619047619 sa=0 sb=0 sd=0 mult=1 m=1
csn_cell0_r100_n100_3 sn_cell0_r100_n100_3 0 {C_SN}
crbl_cell0_r100_n100 rbl_cell0_r100_n100 0 {C_RBL}
spr_cell0_r100_n100 pref_100 ref_cell0_r100_n100 ctl 0 swpre
cref_cell0_r100_n100 ref_cell0_r100_n100 0 {C_RBL}   $ ASSUMPTION: ideal matched dummy load
XMN1_cell0_r100_n100 rbl_cell0_r100_n100 ref_cell0_r100_n100 vn_cell0_r100_n100 0 sky130_fd_pr__nfet_01v8 L=0.15 W=1 nf=1 ad=0.29 as=0.29 pd=2.58 ps=2.58 mult=1 m=1
XMN2_cell0_r100_n100 ref_cell0_r100_n100 rbl_cell0_r100_n100 vn_cell0_r100_n100 0 sky130_fd_pr__nfet_01v8 L=0.15 W=1 nf=1 ad=0.29 as=0.29 pd=2.58 ps=2.58 mult=1 m=1
XMP1_cell0_r100_n100 rbl_cell0_r100_n100 ref_cell0_r100_n100 vp_cell0_r100_n100 vdd sky130_fd_pr__pfet_01v8 L=0.15 W=2 nf=1 ad=0.58 as=0.58 pd=4.58 ps=4.58 mult=1 m=1
XMP2_cell0_r100_n100 ref_cell0_r100_n100 rbl_cell0_r100_n100 vp_cell0_r100_n100 vdd sky130_fd_pr__pfet_01v8 L=0.15 W=2 nf=1 ad=0.58 as=0.58 pd=4.58 ps=4.58 mult=1 m=1
XMNF_cell0_r100_n100 vn_cell0_r100_n100 en 0 0 sky130_fd_pr__nfet_01v8 L=0.15 W=2 nf=1 ad=0.58 as=0.58 pd=4.58 ps=4.58 mult=1 m=1
XMPH_cell0_r100_n100 vp_cell0_r100_n100 enb vdd vdd sky130_fd_pr__pfet_01v8 L=0.15 W=4 nf=1 ad=1.16 as=1.16 pd=8.58 ps=8.58 mult=1 m=1
bd_cell0_r100_n100 d_cell0_r100_n100 0 v=v(rbl_cell0_r100_n100)-v(ref_cell0_r100_n100)
bdabs_cell0_r100_n100 dabs_cell0_r100_n100 0 v=abs(v(rbl_cell0_r100_n100)-v(ref_cell0_r100_n100))

* ---- instance 57: cell0_r100_0000 ----
spa_cell0_r100_0000 prea rbl_cell0_r100_0000 ctl 0 swpre
XMWR_cell0_r100_0000_0 sn_cell0_r100_0000_0 0 0 0 sky130_fd_pr__nfet_01v8 L=0.15 W=0.42 nf=1 ad=0.1974 as=0.1974 pd=1.78 ps=1.78 nrd=0.69047619047619  nrs=0.69047619047619 sa=0 sb=0 sd=0 mult=1 m=1
XMRD_cell0_r100_0000_0 rbl_cell0_r100_0000 sn_cell0_r100_0000_0 rwl_sel 0 sky130_fd_pr__nfet_01v8 L=0.15 W=0.42 nf=1 ad=0.1974 as=0.1974 pd=1.78 ps=1.78 nrd=0.69047619047619  nrs=0.69047619047619 sa=0 sb=0 sd=0 mult=1 m=1
csn_cell0_r100_0000_0 sn_cell0_r100_0000_0 0 {C_SN}
XMWR_cell0_r100_0000_1 sn_cell0_r100_0000_1 0 0 0 sky130_fd_pr__nfet_01v8 L=0.15 W=0.42 nf=1 ad=0.1974 as=0.1974 pd=1.78 ps=1.78 nrd=0.69047619047619  nrs=0.69047619047619 sa=0 sb=0 sd=0 mult=1 m=1
XMRD_cell0_r100_0000_1 rbl_cell0_r100_0000 sn_cell0_r100_0000_1 rwl_des 0 sky130_fd_pr__nfet_01v8 L=0.15 W=0.42 nf=1 ad=0.1974 as=0.1974 pd=1.78 ps=1.78 nrd=0.69047619047619  nrs=0.69047619047619 sa=0 sb=0 sd=0 mult=1 m=1
csn_cell0_r100_0000_1 sn_cell0_r100_0000_1 0 {C_SN}
XMWR_cell0_r100_0000_2 sn_cell0_r100_0000_2 0 0 0 sky130_fd_pr__nfet_01v8 L=0.15 W=0.42 nf=1 ad=0.1974 as=0.1974 pd=1.78 ps=1.78 nrd=0.69047619047619  nrs=0.69047619047619 sa=0 sb=0 sd=0 mult=1 m=1
XMRD_cell0_r100_0000_2 rbl_cell0_r100_0000 sn_cell0_r100_0000_2 rwl_des 0 sky130_fd_pr__nfet_01v8 L=0.15 W=0.42 nf=1 ad=0.1974 as=0.1974 pd=1.78 ps=1.78 nrd=0.69047619047619  nrs=0.69047619047619 sa=0 sb=0 sd=0 mult=1 m=1
csn_cell0_r100_0000_2 sn_cell0_r100_0000_2 0 {C_SN}
XMWR_cell0_r100_0000_3 sn_cell0_r100_0000_3 0 0 0 sky130_fd_pr__nfet_01v8 L=0.15 W=0.42 nf=1 ad=0.1974 as=0.1974 pd=1.78 ps=1.78 nrd=0.69047619047619  nrs=0.69047619047619 sa=0 sb=0 sd=0 mult=1 m=1
XMRD_cell0_r100_0000_3 rbl_cell0_r100_0000 sn_cell0_r100_0000_3 rwl_des 0 sky130_fd_pr__nfet_01v8 L=0.15 W=0.42 nf=1 ad=0.1974 as=0.1974 pd=1.78 ps=1.78 nrd=0.69047619047619  nrs=0.69047619047619 sa=0 sb=0 sd=0 mult=1 m=1
csn_cell0_r100_0000_3 sn_cell0_r100_0000_3 0 {C_SN}
crbl_cell0_r100_0000 rbl_cell0_r100_0000 0 {C_RBL}
spr_cell0_r100_0000 pref_100 ref_cell0_r100_0000 ctl 0 swpre
cref_cell0_r100_0000 ref_cell0_r100_0000 0 {C_RBL}   $ ASSUMPTION: ideal matched dummy load
XMN1_cell0_r100_0000 rbl_cell0_r100_0000 ref_cell0_r100_0000 vn_cell0_r100_0000 0 sky130_fd_pr__nfet_01v8 L=0.15 W=1 nf=1 ad=0.29 as=0.29 pd=2.58 ps=2.58 mult=1 m=1
XMN2_cell0_r100_0000 ref_cell0_r100_0000 rbl_cell0_r100_0000 vn_cell0_r100_0000 0 sky130_fd_pr__nfet_01v8 L=0.15 W=1 nf=1 ad=0.29 as=0.29 pd=2.58 ps=2.58 mult=1 m=1
XMP1_cell0_r100_0000 rbl_cell0_r100_0000 ref_cell0_r100_0000 vp_cell0_r100_0000 vdd sky130_fd_pr__pfet_01v8 L=0.15 W=2 nf=1 ad=0.58 as=0.58 pd=4.58 ps=4.58 mult=1 m=1
XMP2_cell0_r100_0000 ref_cell0_r100_0000 rbl_cell0_r100_0000 vp_cell0_r100_0000 vdd sky130_fd_pr__pfet_01v8 L=0.15 W=2 nf=1 ad=0.58 as=0.58 pd=4.58 ps=4.58 mult=1 m=1
XMNF_cell0_r100_0000 vn_cell0_r100_0000 en 0 0 sky130_fd_pr__nfet_01v8 L=0.15 W=2 nf=1 ad=0.58 as=0.58 pd=4.58 ps=4.58 mult=1 m=1
XMPH_cell0_r100_0000 vp_cell0_r100_0000 enb vdd vdd sky130_fd_pr__pfet_01v8 L=0.15 W=4 nf=1 ad=1.16 as=1.16 pd=8.58 ps=8.58 mult=1 m=1
bd_cell0_r100_0000 d_cell0_r100_0000 0 v=v(rbl_cell0_r100_0000)-v(ref_cell0_r100_0000)
bdabs_cell0_r100_0000 dabs_cell0_r100_0000 0 v=abs(v(rbl_cell0_r100_0000)-v(ref_cell0_r100_0000))

* ---- instance 58: cell1_r100_0300 ----
spa_cell1_r100_0300 prea rbl_cell1_r100_0300 ctl 0 swpre
XMWR_cell1_r100_0300_0 sn_cell1_r100_0300_0 0 0 0 sky130_fd_pr__nfet_01v8 L=0.15 W=0.42 nf=1 ad=0.1974 as=0.1974 pd=1.78 ps=1.78 nrd=0.69047619047619  nrs=0.69047619047619 sa=0 sb=0 sd=0 mult=1 m=1
XMRD_cell1_r100_0300_0 rbl_cell1_r100_0300 sn_cell1_r100_0300_0 rwl_sel 0 sky130_fd_pr__nfet_01v8 L=0.15 W=0.42 nf=1 ad=0.1974 as=0.1974 pd=1.78 ps=1.78 nrd=0.69047619047619  nrs=0.69047619047619 sa=0 sb=0 sd=0 mult=1 m=1
csn_cell1_r100_0300_0 sn_cell1_r100_0300_0 0 {C_SN}
XMWR_cell1_r100_0300_1 sn_cell1_r100_0300_1 0 0 0 sky130_fd_pr__nfet_01v8 L=0.15 W=0.42 nf=1 ad=0.1974 as=0.1974 pd=1.78 ps=1.78 nrd=0.69047619047619  nrs=0.69047619047619 sa=0 sb=0 sd=0 mult=1 m=1
XMRD_cell1_r100_0300_1 rbl_cell1_r100_0300 sn_cell1_r100_0300_1 rwl_des 0 sky130_fd_pr__nfet_01v8 L=0.15 W=0.42 nf=1 ad=0.1974 as=0.1974 pd=1.78 ps=1.78 nrd=0.69047619047619  nrs=0.69047619047619 sa=0 sb=0 sd=0 mult=1 m=1
csn_cell1_r100_0300_1 sn_cell1_r100_0300_1 0 {C_SN}
XMWR_cell1_r100_0300_2 sn_cell1_r100_0300_2 0 0 0 sky130_fd_pr__nfet_01v8 L=0.15 W=0.42 nf=1 ad=0.1974 as=0.1974 pd=1.78 ps=1.78 nrd=0.69047619047619  nrs=0.69047619047619 sa=0 sb=0 sd=0 mult=1 m=1
XMRD_cell1_r100_0300_2 rbl_cell1_r100_0300 sn_cell1_r100_0300_2 rwl_des 0 sky130_fd_pr__nfet_01v8 L=0.15 W=0.42 nf=1 ad=0.1974 as=0.1974 pd=1.78 ps=1.78 nrd=0.69047619047619  nrs=0.69047619047619 sa=0 sb=0 sd=0 mult=1 m=1
csn_cell1_r100_0300_2 sn_cell1_r100_0300_2 0 {C_SN}
XMWR_cell1_r100_0300_3 sn_cell1_r100_0300_3 0 0 0 sky130_fd_pr__nfet_01v8 L=0.15 W=0.42 nf=1 ad=0.1974 as=0.1974 pd=1.78 ps=1.78 nrd=0.69047619047619  nrs=0.69047619047619 sa=0 sb=0 sd=0 mult=1 m=1
XMRD_cell1_r100_0300_3 rbl_cell1_r100_0300 sn_cell1_r100_0300_3 rwl_des 0 sky130_fd_pr__nfet_01v8 L=0.15 W=0.42 nf=1 ad=0.1974 as=0.1974 pd=1.78 ps=1.78 nrd=0.69047619047619  nrs=0.69047619047619 sa=0 sb=0 sd=0 mult=1 m=1
csn_cell1_r100_0300_3 sn_cell1_r100_0300_3 0 {C_SN}
crbl_cell1_r100_0300 rbl_cell1_r100_0300 0 {C_RBL}
spr_cell1_r100_0300 pref_100 ref_cell1_r100_0300 ctl 0 swpre
cref_cell1_r100_0300 ref_cell1_r100_0300 0 {C_RBL}   $ ASSUMPTION: ideal matched dummy load
XMN1_cell1_r100_0300 rbl_cell1_r100_0300 ref_cell1_r100_0300 vn_cell1_r100_0300 0 sky130_fd_pr__nfet_01v8 L=0.15 W=1 nf=1 ad=0.29 as=0.29 pd=2.58 ps=2.58 mult=1 m=1
XMN2_cell1_r100_0300 ref_cell1_r100_0300 rbl_cell1_r100_0300 vn_cell1_r100_0300 0 sky130_fd_pr__nfet_01v8 L=0.15 W=1 nf=1 ad=0.29 as=0.29 pd=2.58 ps=2.58 mult=1 m=1
XMP1_cell1_r100_0300 rbl_cell1_r100_0300 ref_cell1_r100_0300 vp_cell1_r100_0300 vdd sky130_fd_pr__pfet_01v8 L=0.15 W=2 nf=1 ad=0.58 as=0.58 pd=4.58 ps=4.58 mult=1 m=1
XMP2_cell1_r100_0300 ref_cell1_r100_0300 rbl_cell1_r100_0300 vp_cell1_r100_0300 vdd sky130_fd_pr__pfet_01v8 L=0.15 W=2 nf=1 ad=0.58 as=0.58 pd=4.58 ps=4.58 mult=1 m=1
XMNF_cell1_r100_0300 vn_cell1_r100_0300 en 0 0 sky130_fd_pr__nfet_01v8 L=0.15 W=2 nf=1 ad=0.58 as=0.58 pd=4.58 ps=4.58 mult=1 m=1
XMPH_cell1_r100_0300 vp_cell1_r100_0300 enb vdd vdd sky130_fd_pr__pfet_01v8 L=0.15 W=4 nf=1 ad=1.16 as=1.16 pd=8.58 ps=8.58 mult=1 m=1
bd_cell1_r100_0300 d_cell1_r100_0300 0 v=v(rbl_cell1_r100_0300)-v(ref_cell1_r100_0300)
bdabs_cell1_r100_0300 dabs_cell1_r100_0300 0 v=abs(v(rbl_cell1_r100_0300)-v(ref_cell1_r100_0300))

* ---- instance 59: cell1_r100_0350 ----
spa_cell1_r100_0350 prea rbl_cell1_r100_0350 ctl 0 swpre
XMWR_cell1_r100_0350_0 sn_cell1_r100_0350_0 0 0 0 sky130_fd_pr__nfet_01v8 L=0.15 W=0.42 nf=1 ad=0.1974 as=0.1974 pd=1.78 ps=1.78 nrd=0.69047619047619  nrs=0.69047619047619 sa=0 sb=0 sd=0 mult=1 m=1
XMRD_cell1_r100_0350_0 rbl_cell1_r100_0350 sn_cell1_r100_0350_0 rwl_sel 0 sky130_fd_pr__nfet_01v8 L=0.15 W=0.42 nf=1 ad=0.1974 as=0.1974 pd=1.78 ps=1.78 nrd=0.69047619047619  nrs=0.69047619047619 sa=0 sb=0 sd=0 mult=1 m=1
csn_cell1_r100_0350_0 sn_cell1_r100_0350_0 0 {C_SN}
XMWR_cell1_r100_0350_1 sn_cell1_r100_0350_1 0 0 0 sky130_fd_pr__nfet_01v8 L=0.15 W=0.42 nf=1 ad=0.1974 as=0.1974 pd=1.78 ps=1.78 nrd=0.69047619047619  nrs=0.69047619047619 sa=0 sb=0 sd=0 mult=1 m=1
XMRD_cell1_r100_0350_1 rbl_cell1_r100_0350 sn_cell1_r100_0350_1 rwl_des 0 sky130_fd_pr__nfet_01v8 L=0.15 W=0.42 nf=1 ad=0.1974 as=0.1974 pd=1.78 ps=1.78 nrd=0.69047619047619  nrs=0.69047619047619 sa=0 sb=0 sd=0 mult=1 m=1
csn_cell1_r100_0350_1 sn_cell1_r100_0350_1 0 {C_SN}
XMWR_cell1_r100_0350_2 sn_cell1_r100_0350_2 0 0 0 sky130_fd_pr__nfet_01v8 L=0.15 W=0.42 nf=1 ad=0.1974 as=0.1974 pd=1.78 ps=1.78 nrd=0.69047619047619  nrs=0.69047619047619 sa=0 sb=0 sd=0 mult=1 m=1
XMRD_cell1_r100_0350_2 rbl_cell1_r100_0350 sn_cell1_r100_0350_2 rwl_des 0 sky130_fd_pr__nfet_01v8 L=0.15 W=0.42 nf=1 ad=0.1974 as=0.1974 pd=1.78 ps=1.78 nrd=0.69047619047619  nrs=0.69047619047619 sa=0 sb=0 sd=0 mult=1 m=1
csn_cell1_r100_0350_2 sn_cell1_r100_0350_2 0 {C_SN}
XMWR_cell1_r100_0350_3 sn_cell1_r100_0350_3 0 0 0 sky130_fd_pr__nfet_01v8 L=0.15 W=0.42 nf=1 ad=0.1974 as=0.1974 pd=1.78 ps=1.78 nrd=0.69047619047619  nrs=0.69047619047619 sa=0 sb=0 sd=0 mult=1 m=1
XMRD_cell1_r100_0350_3 rbl_cell1_r100_0350 sn_cell1_r100_0350_3 rwl_des 0 sky130_fd_pr__nfet_01v8 L=0.15 W=0.42 nf=1 ad=0.1974 as=0.1974 pd=1.78 ps=1.78 nrd=0.69047619047619  nrs=0.69047619047619 sa=0 sb=0 sd=0 mult=1 m=1
csn_cell1_r100_0350_3 sn_cell1_r100_0350_3 0 {C_SN}
crbl_cell1_r100_0350 rbl_cell1_r100_0350 0 {C_RBL}
spr_cell1_r100_0350 pref_100 ref_cell1_r100_0350 ctl 0 swpre
cref_cell1_r100_0350 ref_cell1_r100_0350 0 {C_RBL}   $ ASSUMPTION: ideal matched dummy load
XMN1_cell1_r100_0350 rbl_cell1_r100_0350 ref_cell1_r100_0350 vn_cell1_r100_0350 0 sky130_fd_pr__nfet_01v8 L=0.15 W=1 nf=1 ad=0.29 as=0.29 pd=2.58 ps=2.58 mult=1 m=1
XMN2_cell1_r100_0350 ref_cell1_r100_0350 rbl_cell1_r100_0350 vn_cell1_r100_0350 0 sky130_fd_pr__nfet_01v8 L=0.15 W=1 nf=1 ad=0.29 as=0.29 pd=2.58 ps=2.58 mult=1 m=1
XMP1_cell1_r100_0350 rbl_cell1_r100_0350 ref_cell1_r100_0350 vp_cell1_r100_0350 vdd sky130_fd_pr__pfet_01v8 L=0.15 W=2 nf=1 ad=0.58 as=0.58 pd=4.58 ps=4.58 mult=1 m=1
XMP2_cell1_r100_0350 ref_cell1_r100_0350 rbl_cell1_r100_0350 vp_cell1_r100_0350 vdd sky130_fd_pr__pfet_01v8 L=0.15 W=2 nf=1 ad=0.58 as=0.58 pd=4.58 ps=4.58 mult=1 m=1
XMNF_cell1_r100_0350 vn_cell1_r100_0350 en 0 0 sky130_fd_pr__nfet_01v8 L=0.15 W=2 nf=1 ad=0.58 as=0.58 pd=4.58 ps=4.58 mult=1 m=1
XMPH_cell1_r100_0350 vp_cell1_r100_0350 enb vdd vdd sky130_fd_pr__pfet_01v8 L=0.15 W=4 nf=1 ad=1.16 as=1.16 pd=8.58 ps=8.58 mult=1 m=1
bd_cell1_r100_0350 d_cell1_r100_0350 0 v=v(rbl_cell1_r100_0350)-v(ref_cell1_r100_0350)
bdabs_cell1_r100_0350 dabs_cell1_r100_0350 0 v=abs(v(rbl_cell1_r100_0350)-v(ref_cell1_r100_0350))

* ---- instance 60: cell1_r100_0400 ----
spa_cell1_r100_0400 prea rbl_cell1_r100_0400 ctl 0 swpre
XMWR_cell1_r100_0400_0 sn_cell1_r100_0400_0 0 0 0 sky130_fd_pr__nfet_01v8 L=0.15 W=0.42 nf=1 ad=0.1974 as=0.1974 pd=1.78 ps=1.78 nrd=0.69047619047619  nrs=0.69047619047619 sa=0 sb=0 sd=0 mult=1 m=1
XMRD_cell1_r100_0400_0 rbl_cell1_r100_0400 sn_cell1_r100_0400_0 rwl_sel 0 sky130_fd_pr__nfet_01v8 L=0.15 W=0.42 nf=1 ad=0.1974 as=0.1974 pd=1.78 ps=1.78 nrd=0.69047619047619  nrs=0.69047619047619 sa=0 sb=0 sd=0 mult=1 m=1
csn_cell1_r100_0400_0 sn_cell1_r100_0400_0 0 {C_SN}
XMWR_cell1_r100_0400_1 sn_cell1_r100_0400_1 0 0 0 sky130_fd_pr__nfet_01v8 L=0.15 W=0.42 nf=1 ad=0.1974 as=0.1974 pd=1.78 ps=1.78 nrd=0.69047619047619  nrs=0.69047619047619 sa=0 sb=0 sd=0 mult=1 m=1
XMRD_cell1_r100_0400_1 rbl_cell1_r100_0400 sn_cell1_r100_0400_1 rwl_des 0 sky130_fd_pr__nfet_01v8 L=0.15 W=0.42 nf=1 ad=0.1974 as=0.1974 pd=1.78 ps=1.78 nrd=0.69047619047619  nrs=0.69047619047619 sa=0 sb=0 sd=0 mult=1 m=1
csn_cell1_r100_0400_1 sn_cell1_r100_0400_1 0 {C_SN}
XMWR_cell1_r100_0400_2 sn_cell1_r100_0400_2 0 0 0 sky130_fd_pr__nfet_01v8 L=0.15 W=0.42 nf=1 ad=0.1974 as=0.1974 pd=1.78 ps=1.78 nrd=0.69047619047619  nrs=0.69047619047619 sa=0 sb=0 sd=0 mult=1 m=1
XMRD_cell1_r100_0400_2 rbl_cell1_r100_0400 sn_cell1_r100_0400_2 rwl_des 0 sky130_fd_pr__nfet_01v8 L=0.15 W=0.42 nf=1 ad=0.1974 as=0.1974 pd=1.78 ps=1.78 nrd=0.69047619047619  nrs=0.69047619047619 sa=0 sb=0 sd=0 mult=1 m=1
csn_cell1_r100_0400_2 sn_cell1_r100_0400_2 0 {C_SN}
XMWR_cell1_r100_0400_3 sn_cell1_r100_0400_3 0 0 0 sky130_fd_pr__nfet_01v8 L=0.15 W=0.42 nf=1 ad=0.1974 as=0.1974 pd=1.78 ps=1.78 nrd=0.69047619047619  nrs=0.69047619047619 sa=0 sb=0 sd=0 mult=1 m=1
XMRD_cell1_r100_0400_3 rbl_cell1_r100_0400 sn_cell1_r100_0400_3 rwl_des 0 sky130_fd_pr__nfet_01v8 L=0.15 W=0.42 nf=1 ad=0.1974 as=0.1974 pd=1.78 ps=1.78 nrd=0.69047619047619  nrs=0.69047619047619 sa=0 sb=0 sd=0 mult=1 m=1
csn_cell1_r100_0400_3 sn_cell1_r100_0400_3 0 {C_SN}
crbl_cell1_r100_0400 rbl_cell1_r100_0400 0 {C_RBL}
spr_cell1_r100_0400 pref_100 ref_cell1_r100_0400 ctl 0 swpre
cref_cell1_r100_0400 ref_cell1_r100_0400 0 {C_RBL}   $ ASSUMPTION: ideal matched dummy load
XMN1_cell1_r100_0400 rbl_cell1_r100_0400 ref_cell1_r100_0400 vn_cell1_r100_0400 0 sky130_fd_pr__nfet_01v8 L=0.15 W=1 nf=1 ad=0.29 as=0.29 pd=2.58 ps=2.58 mult=1 m=1
XMN2_cell1_r100_0400 ref_cell1_r100_0400 rbl_cell1_r100_0400 vn_cell1_r100_0400 0 sky130_fd_pr__nfet_01v8 L=0.15 W=1 nf=1 ad=0.29 as=0.29 pd=2.58 ps=2.58 mult=1 m=1
XMP1_cell1_r100_0400 rbl_cell1_r100_0400 ref_cell1_r100_0400 vp_cell1_r100_0400 vdd sky130_fd_pr__pfet_01v8 L=0.15 W=2 nf=1 ad=0.58 as=0.58 pd=4.58 ps=4.58 mult=1 m=1
XMP2_cell1_r100_0400 ref_cell1_r100_0400 rbl_cell1_r100_0400 vp_cell1_r100_0400 vdd sky130_fd_pr__pfet_01v8 L=0.15 W=2 nf=1 ad=0.58 as=0.58 pd=4.58 ps=4.58 mult=1 m=1
XMNF_cell1_r100_0400 vn_cell1_r100_0400 en 0 0 sky130_fd_pr__nfet_01v8 L=0.15 W=2 nf=1 ad=0.58 as=0.58 pd=4.58 ps=4.58 mult=1 m=1
XMPH_cell1_r100_0400 vp_cell1_r100_0400 enb vdd vdd sky130_fd_pr__pfet_01v8 L=0.15 W=4 nf=1 ad=1.16 as=1.16 pd=8.58 ps=8.58 mult=1 m=1
bd_cell1_r100_0400 d_cell1_r100_0400 0 v=v(rbl_cell1_r100_0400)-v(ref_cell1_r100_0400)
bdabs_cell1_r100_0400 dabs_cell1_r100_0400 0 v=abs(v(rbl_cell1_r100_0400)-v(ref_cell1_r100_0400))

* ---- instance 61: cell1_r100_0450 ----
spa_cell1_r100_0450 prea rbl_cell1_r100_0450 ctl 0 swpre
XMWR_cell1_r100_0450_0 sn_cell1_r100_0450_0 0 0 0 sky130_fd_pr__nfet_01v8 L=0.15 W=0.42 nf=1 ad=0.1974 as=0.1974 pd=1.78 ps=1.78 nrd=0.69047619047619  nrs=0.69047619047619 sa=0 sb=0 sd=0 mult=1 m=1
XMRD_cell1_r100_0450_0 rbl_cell1_r100_0450 sn_cell1_r100_0450_0 rwl_sel 0 sky130_fd_pr__nfet_01v8 L=0.15 W=0.42 nf=1 ad=0.1974 as=0.1974 pd=1.78 ps=1.78 nrd=0.69047619047619  nrs=0.69047619047619 sa=0 sb=0 sd=0 mult=1 m=1
csn_cell1_r100_0450_0 sn_cell1_r100_0450_0 0 {C_SN}
XMWR_cell1_r100_0450_1 sn_cell1_r100_0450_1 0 0 0 sky130_fd_pr__nfet_01v8 L=0.15 W=0.42 nf=1 ad=0.1974 as=0.1974 pd=1.78 ps=1.78 nrd=0.69047619047619  nrs=0.69047619047619 sa=0 sb=0 sd=0 mult=1 m=1
XMRD_cell1_r100_0450_1 rbl_cell1_r100_0450 sn_cell1_r100_0450_1 rwl_des 0 sky130_fd_pr__nfet_01v8 L=0.15 W=0.42 nf=1 ad=0.1974 as=0.1974 pd=1.78 ps=1.78 nrd=0.69047619047619  nrs=0.69047619047619 sa=0 sb=0 sd=0 mult=1 m=1
csn_cell1_r100_0450_1 sn_cell1_r100_0450_1 0 {C_SN}
XMWR_cell1_r100_0450_2 sn_cell1_r100_0450_2 0 0 0 sky130_fd_pr__nfet_01v8 L=0.15 W=0.42 nf=1 ad=0.1974 as=0.1974 pd=1.78 ps=1.78 nrd=0.69047619047619  nrs=0.69047619047619 sa=0 sb=0 sd=0 mult=1 m=1
XMRD_cell1_r100_0450_2 rbl_cell1_r100_0450 sn_cell1_r100_0450_2 rwl_des 0 sky130_fd_pr__nfet_01v8 L=0.15 W=0.42 nf=1 ad=0.1974 as=0.1974 pd=1.78 ps=1.78 nrd=0.69047619047619  nrs=0.69047619047619 sa=0 sb=0 sd=0 mult=1 m=1
csn_cell1_r100_0450_2 sn_cell1_r100_0450_2 0 {C_SN}
XMWR_cell1_r100_0450_3 sn_cell1_r100_0450_3 0 0 0 sky130_fd_pr__nfet_01v8 L=0.15 W=0.42 nf=1 ad=0.1974 as=0.1974 pd=1.78 ps=1.78 nrd=0.69047619047619  nrs=0.69047619047619 sa=0 sb=0 sd=0 mult=1 m=1
XMRD_cell1_r100_0450_3 rbl_cell1_r100_0450 sn_cell1_r100_0450_3 rwl_des 0 sky130_fd_pr__nfet_01v8 L=0.15 W=0.42 nf=1 ad=0.1974 as=0.1974 pd=1.78 ps=1.78 nrd=0.69047619047619  nrs=0.69047619047619 sa=0 sb=0 sd=0 mult=1 m=1
csn_cell1_r100_0450_3 sn_cell1_r100_0450_3 0 {C_SN}
crbl_cell1_r100_0450 rbl_cell1_r100_0450 0 {C_RBL}
spr_cell1_r100_0450 pref_100 ref_cell1_r100_0450 ctl 0 swpre
cref_cell1_r100_0450 ref_cell1_r100_0450 0 {C_RBL}   $ ASSUMPTION: ideal matched dummy load
XMN1_cell1_r100_0450 rbl_cell1_r100_0450 ref_cell1_r100_0450 vn_cell1_r100_0450 0 sky130_fd_pr__nfet_01v8 L=0.15 W=1 nf=1 ad=0.29 as=0.29 pd=2.58 ps=2.58 mult=1 m=1
XMN2_cell1_r100_0450 ref_cell1_r100_0450 rbl_cell1_r100_0450 vn_cell1_r100_0450 0 sky130_fd_pr__nfet_01v8 L=0.15 W=1 nf=1 ad=0.29 as=0.29 pd=2.58 ps=2.58 mult=1 m=1
XMP1_cell1_r100_0450 rbl_cell1_r100_0450 ref_cell1_r100_0450 vp_cell1_r100_0450 vdd sky130_fd_pr__pfet_01v8 L=0.15 W=2 nf=1 ad=0.58 as=0.58 pd=4.58 ps=4.58 mult=1 m=1
XMP2_cell1_r100_0450 ref_cell1_r100_0450 rbl_cell1_r100_0450 vp_cell1_r100_0450 vdd sky130_fd_pr__pfet_01v8 L=0.15 W=2 nf=1 ad=0.58 as=0.58 pd=4.58 ps=4.58 mult=1 m=1
XMNF_cell1_r100_0450 vn_cell1_r100_0450 en 0 0 sky130_fd_pr__nfet_01v8 L=0.15 W=2 nf=1 ad=0.58 as=0.58 pd=4.58 ps=4.58 mult=1 m=1
XMPH_cell1_r100_0450 vp_cell1_r100_0450 enb vdd vdd sky130_fd_pr__pfet_01v8 L=0.15 W=4 nf=1 ad=1.16 as=1.16 pd=8.58 ps=8.58 mult=1 m=1
bd_cell1_r100_0450 d_cell1_r100_0450 0 v=v(rbl_cell1_r100_0450)-v(ref_cell1_r100_0450)
bdabs_cell1_r100_0450 dabs_cell1_r100_0450 0 v=abs(v(rbl_cell1_r100_0450)-v(ref_cell1_r100_0450))

* ---- instance 62: cell1_r100_0500 ----
spa_cell1_r100_0500 prea rbl_cell1_r100_0500 ctl 0 swpre
XMWR_cell1_r100_0500_0 sn_cell1_r100_0500_0 0 0 0 sky130_fd_pr__nfet_01v8 L=0.15 W=0.42 nf=1 ad=0.1974 as=0.1974 pd=1.78 ps=1.78 nrd=0.69047619047619  nrs=0.69047619047619 sa=0 sb=0 sd=0 mult=1 m=1
XMRD_cell1_r100_0500_0 rbl_cell1_r100_0500 sn_cell1_r100_0500_0 rwl_sel 0 sky130_fd_pr__nfet_01v8 L=0.15 W=0.42 nf=1 ad=0.1974 as=0.1974 pd=1.78 ps=1.78 nrd=0.69047619047619  nrs=0.69047619047619 sa=0 sb=0 sd=0 mult=1 m=1
csn_cell1_r100_0500_0 sn_cell1_r100_0500_0 0 {C_SN}
XMWR_cell1_r100_0500_1 sn_cell1_r100_0500_1 0 0 0 sky130_fd_pr__nfet_01v8 L=0.15 W=0.42 nf=1 ad=0.1974 as=0.1974 pd=1.78 ps=1.78 nrd=0.69047619047619  nrs=0.69047619047619 sa=0 sb=0 sd=0 mult=1 m=1
XMRD_cell1_r100_0500_1 rbl_cell1_r100_0500 sn_cell1_r100_0500_1 rwl_des 0 sky130_fd_pr__nfet_01v8 L=0.15 W=0.42 nf=1 ad=0.1974 as=0.1974 pd=1.78 ps=1.78 nrd=0.69047619047619  nrs=0.69047619047619 sa=0 sb=0 sd=0 mult=1 m=1
csn_cell1_r100_0500_1 sn_cell1_r100_0500_1 0 {C_SN}
XMWR_cell1_r100_0500_2 sn_cell1_r100_0500_2 0 0 0 sky130_fd_pr__nfet_01v8 L=0.15 W=0.42 nf=1 ad=0.1974 as=0.1974 pd=1.78 ps=1.78 nrd=0.69047619047619  nrs=0.69047619047619 sa=0 sb=0 sd=0 mult=1 m=1
XMRD_cell1_r100_0500_2 rbl_cell1_r100_0500 sn_cell1_r100_0500_2 rwl_des 0 sky130_fd_pr__nfet_01v8 L=0.15 W=0.42 nf=1 ad=0.1974 as=0.1974 pd=1.78 ps=1.78 nrd=0.69047619047619  nrs=0.69047619047619 sa=0 sb=0 sd=0 mult=1 m=1
csn_cell1_r100_0500_2 sn_cell1_r100_0500_2 0 {C_SN}
XMWR_cell1_r100_0500_3 sn_cell1_r100_0500_3 0 0 0 sky130_fd_pr__nfet_01v8 L=0.15 W=0.42 nf=1 ad=0.1974 as=0.1974 pd=1.78 ps=1.78 nrd=0.69047619047619  nrs=0.69047619047619 sa=0 sb=0 sd=0 mult=1 m=1
XMRD_cell1_r100_0500_3 rbl_cell1_r100_0500 sn_cell1_r100_0500_3 rwl_des 0 sky130_fd_pr__nfet_01v8 L=0.15 W=0.42 nf=1 ad=0.1974 as=0.1974 pd=1.78 ps=1.78 nrd=0.69047619047619  nrs=0.69047619047619 sa=0 sb=0 sd=0 mult=1 m=1
csn_cell1_r100_0500_3 sn_cell1_r100_0500_3 0 {C_SN}
crbl_cell1_r100_0500 rbl_cell1_r100_0500 0 {C_RBL}
spr_cell1_r100_0500 pref_100 ref_cell1_r100_0500 ctl 0 swpre
cref_cell1_r100_0500 ref_cell1_r100_0500 0 {C_RBL}   $ ASSUMPTION: ideal matched dummy load
XMN1_cell1_r100_0500 rbl_cell1_r100_0500 ref_cell1_r100_0500 vn_cell1_r100_0500 0 sky130_fd_pr__nfet_01v8 L=0.15 W=1 nf=1 ad=0.29 as=0.29 pd=2.58 ps=2.58 mult=1 m=1
XMN2_cell1_r100_0500 ref_cell1_r100_0500 rbl_cell1_r100_0500 vn_cell1_r100_0500 0 sky130_fd_pr__nfet_01v8 L=0.15 W=1 nf=1 ad=0.29 as=0.29 pd=2.58 ps=2.58 mult=1 m=1
XMP1_cell1_r100_0500 rbl_cell1_r100_0500 ref_cell1_r100_0500 vp_cell1_r100_0500 vdd sky130_fd_pr__pfet_01v8 L=0.15 W=2 nf=1 ad=0.58 as=0.58 pd=4.58 ps=4.58 mult=1 m=1
XMP2_cell1_r100_0500 ref_cell1_r100_0500 rbl_cell1_r100_0500 vp_cell1_r100_0500 vdd sky130_fd_pr__pfet_01v8 L=0.15 W=2 nf=1 ad=0.58 as=0.58 pd=4.58 ps=4.58 mult=1 m=1
XMNF_cell1_r100_0500 vn_cell1_r100_0500 en 0 0 sky130_fd_pr__nfet_01v8 L=0.15 W=2 nf=1 ad=0.58 as=0.58 pd=4.58 ps=4.58 mult=1 m=1
XMPH_cell1_r100_0500 vp_cell1_r100_0500 enb vdd vdd sky130_fd_pr__pfet_01v8 L=0.15 W=4 nf=1 ad=1.16 as=1.16 pd=8.58 ps=8.58 mult=1 m=1
bd_cell1_r100_0500 d_cell1_r100_0500 0 v=v(rbl_cell1_r100_0500)-v(ref_cell1_r100_0500)
bdabs_cell1_r100_0500 dabs_cell1_r100_0500 0 v=abs(v(rbl_cell1_r100_0500)-v(ref_cell1_r100_0500))

* ---- instance 63: cell1_r100_0550 ----
spa_cell1_r100_0550 prea rbl_cell1_r100_0550 ctl 0 swpre
XMWR_cell1_r100_0550_0 sn_cell1_r100_0550_0 0 0 0 sky130_fd_pr__nfet_01v8 L=0.15 W=0.42 nf=1 ad=0.1974 as=0.1974 pd=1.78 ps=1.78 nrd=0.69047619047619  nrs=0.69047619047619 sa=0 sb=0 sd=0 mult=1 m=1
XMRD_cell1_r100_0550_0 rbl_cell1_r100_0550 sn_cell1_r100_0550_0 rwl_sel 0 sky130_fd_pr__nfet_01v8 L=0.15 W=0.42 nf=1 ad=0.1974 as=0.1974 pd=1.78 ps=1.78 nrd=0.69047619047619  nrs=0.69047619047619 sa=0 sb=0 sd=0 mult=1 m=1
csn_cell1_r100_0550_0 sn_cell1_r100_0550_0 0 {C_SN}
XMWR_cell1_r100_0550_1 sn_cell1_r100_0550_1 0 0 0 sky130_fd_pr__nfet_01v8 L=0.15 W=0.42 nf=1 ad=0.1974 as=0.1974 pd=1.78 ps=1.78 nrd=0.69047619047619  nrs=0.69047619047619 sa=0 sb=0 sd=0 mult=1 m=1
XMRD_cell1_r100_0550_1 rbl_cell1_r100_0550 sn_cell1_r100_0550_1 rwl_des 0 sky130_fd_pr__nfet_01v8 L=0.15 W=0.42 nf=1 ad=0.1974 as=0.1974 pd=1.78 ps=1.78 nrd=0.69047619047619  nrs=0.69047619047619 sa=0 sb=0 sd=0 mult=1 m=1
csn_cell1_r100_0550_1 sn_cell1_r100_0550_1 0 {C_SN}
XMWR_cell1_r100_0550_2 sn_cell1_r100_0550_2 0 0 0 sky130_fd_pr__nfet_01v8 L=0.15 W=0.42 nf=1 ad=0.1974 as=0.1974 pd=1.78 ps=1.78 nrd=0.69047619047619  nrs=0.69047619047619 sa=0 sb=0 sd=0 mult=1 m=1
XMRD_cell1_r100_0550_2 rbl_cell1_r100_0550 sn_cell1_r100_0550_2 rwl_des 0 sky130_fd_pr__nfet_01v8 L=0.15 W=0.42 nf=1 ad=0.1974 as=0.1974 pd=1.78 ps=1.78 nrd=0.69047619047619  nrs=0.69047619047619 sa=0 sb=0 sd=0 mult=1 m=1
csn_cell1_r100_0550_2 sn_cell1_r100_0550_2 0 {C_SN}
XMWR_cell1_r100_0550_3 sn_cell1_r100_0550_3 0 0 0 sky130_fd_pr__nfet_01v8 L=0.15 W=0.42 nf=1 ad=0.1974 as=0.1974 pd=1.78 ps=1.78 nrd=0.69047619047619  nrs=0.69047619047619 sa=0 sb=0 sd=0 mult=1 m=1
XMRD_cell1_r100_0550_3 rbl_cell1_r100_0550 sn_cell1_r100_0550_3 rwl_des 0 sky130_fd_pr__nfet_01v8 L=0.15 W=0.42 nf=1 ad=0.1974 as=0.1974 pd=1.78 ps=1.78 nrd=0.69047619047619  nrs=0.69047619047619 sa=0 sb=0 sd=0 mult=1 m=1
csn_cell1_r100_0550_3 sn_cell1_r100_0550_3 0 {C_SN}
crbl_cell1_r100_0550 rbl_cell1_r100_0550 0 {C_RBL}
spr_cell1_r100_0550 pref_100 ref_cell1_r100_0550 ctl 0 swpre
cref_cell1_r100_0550 ref_cell1_r100_0550 0 {C_RBL}   $ ASSUMPTION: ideal matched dummy load
XMN1_cell1_r100_0550 rbl_cell1_r100_0550 ref_cell1_r100_0550 vn_cell1_r100_0550 0 sky130_fd_pr__nfet_01v8 L=0.15 W=1 nf=1 ad=0.29 as=0.29 pd=2.58 ps=2.58 mult=1 m=1
XMN2_cell1_r100_0550 ref_cell1_r100_0550 rbl_cell1_r100_0550 vn_cell1_r100_0550 0 sky130_fd_pr__nfet_01v8 L=0.15 W=1 nf=1 ad=0.29 as=0.29 pd=2.58 ps=2.58 mult=1 m=1
XMP1_cell1_r100_0550 rbl_cell1_r100_0550 ref_cell1_r100_0550 vp_cell1_r100_0550 vdd sky130_fd_pr__pfet_01v8 L=0.15 W=2 nf=1 ad=0.58 as=0.58 pd=4.58 ps=4.58 mult=1 m=1
XMP2_cell1_r100_0550 ref_cell1_r100_0550 rbl_cell1_r100_0550 vp_cell1_r100_0550 vdd sky130_fd_pr__pfet_01v8 L=0.15 W=2 nf=1 ad=0.58 as=0.58 pd=4.58 ps=4.58 mult=1 m=1
XMNF_cell1_r100_0550 vn_cell1_r100_0550 en 0 0 sky130_fd_pr__nfet_01v8 L=0.15 W=2 nf=1 ad=0.58 as=0.58 pd=4.58 ps=4.58 mult=1 m=1
XMPH_cell1_r100_0550 vp_cell1_r100_0550 enb vdd vdd sky130_fd_pr__pfet_01v8 L=0.15 W=4 nf=1 ad=1.16 as=1.16 pd=8.58 ps=8.58 mult=1 m=1
bd_cell1_r100_0550 d_cell1_r100_0550 0 v=v(rbl_cell1_r100_0550)-v(ref_cell1_r100_0550)
bdabs_cell1_r100_0550 dabs_cell1_r100_0550 0 v=abs(v(rbl_cell1_r100_0550)-v(ref_cell1_r100_0550))

* ---- instance 64: cell1_r100_0600 ----
spa_cell1_r100_0600 prea rbl_cell1_r100_0600 ctl 0 swpre
XMWR_cell1_r100_0600_0 sn_cell1_r100_0600_0 0 0 0 sky130_fd_pr__nfet_01v8 L=0.15 W=0.42 nf=1 ad=0.1974 as=0.1974 pd=1.78 ps=1.78 nrd=0.69047619047619  nrs=0.69047619047619 sa=0 sb=0 sd=0 mult=1 m=1
XMRD_cell1_r100_0600_0 rbl_cell1_r100_0600 sn_cell1_r100_0600_0 rwl_sel 0 sky130_fd_pr__nfet_01v8 L=0.15 W=0.42 nf=1 ad=0.1974 as=0.1974 pd=1.78 ps=1.78 nrd=0.69047619047619  nrs=0.69047619047619 sa=0 sb=0 sd=0 mult=1 m=1
csn_cell1_r100_0600_0 sn_cell1_r100_0600_0 0 {C_SN}
XMWR_cell1_r100_0600_1 sn_cell1_r100_0600_1 0 0 0 sky130_fd_pr__nfet_01v8 L=0.15 W=0.42 nf=1 ad=0.1974 as=0.1974 pd=1.78 ps=1.78 nrd=0.69047619047619  nrs=0.69047619047619 sa=0 sb=0 sd=0 mult=1 m=1
XMRD_cell1_r100_0600_1 rbl_cell1_r100_0600 sn_cell1_r100_0600_1 rwl_des 0 sky130_fd_pr__nfet_01v8 L=0.15 W=0.42 nf=1 ad=0.1974 as=0.1974 pd=1.78 ps=1.78 nrd=0.69047619047619  nrs=0.69047619047619 sa=0 sb=0 sd=0 mult=1 m=1
csn_cell1_r100_0600_1 sn_cell1_r100_0600_1 0 {C_SN}
XMWR_cell1_r100_0600_2 sn_cell1_r100_0600_2 0 0 0 sky130_fd_pr__nfet_01v8 L=0.15 W=0.42 nf=1 ad=0.1974 as=0.1974 pd=1.78 ps=1.78 nrd=0.69047619047619  nrs=0.69047619047619 sa=0 sb=0 sd=0 mult=1 m=1
XMRD_cell1_r100_0600_2 rbl_cell1_r100_0600 sn_cell1_r100_0600_2 rwl_des 0 sky130_fd_pr__nfet_01v8 L=0.15 W=0.42 nf=1 ad=0.1974 as=0.1974 pd=1.78 ps=1.78 nrd=0.69047619047619  nrs=0.69047619047619 sa=0 sb=0 sd=0 mult=1 m=1
csn_cell1_r100_0600_2 sn_cell1_r100_0600_2 0 {C_SN}
XMWR_cell1_r100_0600_3 sn_cell1_r100_0600_3 0 0 0 sky130_fd_pr__nfet_01v8 L=0.15 W=0.42 nf=1 ad=0.1974 as=0.1974 pd=1.78 ps=1.78 nrd=0.69047619047619  nrs=0.69047619047619 sa=0 sb=0 sd=0 mult=1 m=1
XMRD_cell1_r100_0600_3 rbl_cell1_r100_0600 sn_cell1_r100_0600_3 rwl_des 0 sky130_fd_pr__nfet_01v8 L=0.15 W=0.42 nf=1 ad=0.1974 as=0.1974 pd=1.78 ps=1.78 nrd=0.69047619047619  nrs=0.69047619047619 sa=0 sb=0 sd=0 mult=1 m=1
csn_cell1_r100_0600_3 sn_cell1_r100_0600_3 0 {C_SN}
crbl_cell1_r100_0600 rbl_cell1_r100_0600 0 {C_RBL}
spr_cell1_r100_0600 pref_100 ref_cell1_r100_0600 ctl 0 swpre
cref_cell1_r100_0600 ref_cell1_r100_0600 0 {C_RBL}   $ ASSUMPTION: ideal matched dummy load
XMN1_cell1_r100_0600 rbl_cell1_r100_0600 ref_cell1_r100_0600 vn_cell1_r100_0600 0 sky130_fd_pr__nfet_01v8 L=0.15 W=1 nf=1 ad=0.29 as=0.29 pd=2.58 ps=2.58 mult=1 m=1
XMN2_cell1_r100_0600 ref_cell1_r100_0600 rbl_cell1_r100_0600 vn_cell1_r100_0600 0 sky130_fd_pr__nfet_01v8 L=0.15 W=1 nf=1 ad=0.29 as=0.29 pd=2.58 ps=2.58 mult=1 m=1
XMP1_cell1_r100_0600 rbl_cell1_r100_0600 ref_cell1_r100_0600 vp_cell1_r100_0600 vdd sky130_fd_pr__pfet_01v8 L=0.15 W=2 nf=1 ad=0.58 as=0.58 pd=4.58 ps=4.58 mult=1 m=1
XMP2_cell1_r100_0600 ref_cell1_r100_0600 rbl_cell1_r100_0600 vp_cell1_r100_0600 vdd sky130_fd_pr__pfet_01v8 L=0.15 W=2 nf=1 ad=0.58 as=0.58 pd=4.58 ps=4.58 mult=1 m=1
XMNF_cell1_r100_0600 vn_cell1_r100_0600 en 0 0 sky130_fd_pr__nfet_01v8 L=0.15 W=2 nf=1 ad=0.58 as=0.58 pd=4.58 ps=4.58 mult=1 m=1
XMPH_cell1_r100_0600 vp_cell1_r100_0600 enb vdd vdd sky130_fd_pr__pfet_01v8 L=0.15 W=4 nf=1 ad=1.16 as=1.16 pd=8.58 ps=8.58 mult=1 m=1
bd_cell1_r100_0600 d_cell1_r100_0600 0 v=v(rbl_cell1_r100_0600)-v(ref_cell1_r100_0600)
bdabs_cell1_r100_0600 dabs_cell1_r100_0600 0 v=abs(v(rbl_cell1_r100_0600)-v(ref_cell1_r100_0600))

* ---- instance 65: cell1_r100_0650 ----
spa_cell1_r100_0650 prea rbl_cell1_r100_0650 ctl 0 swpre
XMWR_cell1_r100_0650_0 sn_cell1_r100_0650_0 0 0 0 sky130_fd_pr__nfet_01v8 L=0.15 W=0.42 nf=1 ad=0.1974 as=0.1974 pd=1.78 ps=1.78 nrd=0.69047619047619  nrs=0.69047619047619 sa=0 sb=0 sd=0 mult=1 m=1
XMRD_cell1_r100_0650_0 rbl_cell1_r100_0650 sn_cell1_r100_0650_0 rwl_sel 0 sky130_fd_pr__nfet_01v8 L=0.15 W=0.42 nf=1 ad=0.1974 as=0.1974 pd=1.78 ps=1.78 nrd=0.69047619047619  nrs=0.69047619047619 sa=0 sb=0 sd=0 mult=1 m=1
csn_cell1_r100_0650_0 sn_cell1_r100_0650_0 0 {C_SN}
XMWR_cell1_r100_0650_1 sn_cell1_r100_0650_1 0 0 0 sky130_fd_pr__nfet_01v8 L=0.15 W=0.42 nf=1 ad=0.1974 as=0.1974 pd=1.78 ps=1.78 nrd=0.69047619047619  nrs=0.69047619047619 sa=0 sb=0 sd=0 mult=1 m=1
XMRD_cell1_r100_0650_1 rbl_cell1_r100_0650 sn_cell1_r100_0650_1 rwl_des 0 sky130_fd_pr__nfet_01v8 L=0.15 W=0.42 nf=1 ad=0.1974 as=0.1974 pd=1.78 ps=1.78 nrd=0.69047619047619  nrs=0.69047619047619 sa=0 sb=0 sd=0 mult=1 m=1
csn_cell1_r100_0650_1 sn_cell1_r100_0650_1 0 {C_SN}
XMWR_cell1_r100_0650_2 sn_cell1_r100_0650_2 0 0 0 sky130_fd_pr__nfet_01v8 L=0.15 W=0.42 nf=1 ad=0.1974 as=0.1974 pd=1.78 ps=1.78 nrd=0.69047619047619  nrs=0.69047619047619 sa=0 sb=0 sd=0 mult=1 m=1
XMRD_cell1_r100_0650_2 rbl_cell1_r100_0650 sn_cell1_r100_0650_2 rwl_des 0 sky130_fd_pr__nfet_01v8 L=0.15 W=0.42 nf=1 ad=0.1974 as=0.1974 pd=1.78 ps=1.78 nrd=0.69047619047619  nrs=0.69047619047619 sa=0 sb=0 sd=0 mult=1 m=1
csn_cell1_r100_0650_2 sn_cell1_r100_0650_2 0 {C_SN}
XMWR_cell1_r100_0650_3 sn_cell1_r100_0650_3 0 0 0 sky130_fd_pr__nfet_01v8 L=0.15 W=0.42 nf=1 ad=0.1974 as=0.1974 pd=1.78 ps=1.78 nrd=0.69047619047619  nrs=0.69047619047619 sa=0 sb=0 sd=0 mult=1 m=1
XMRD_cell1_r100_0650_3 rbl_cell1_r100_0650 sn_cell1_r100_0650_3 rwl_des 0 sky130_fd_pr__nfet_01v8 L=0.15 W=0.42 nf=1 ad=0.1974 as=0.1974 pd=1.78 ps=1.78 nrd=0.69047619047619  nrs=0.69047619047619 sa=0 sb=0 sd=0 mult=1 m=1
csn_cell1_r100_0650_3 sn_cell1_r100_0650_3 0 {C_SN}
crbl_cell1_r100_0650 rbl_cell1_r100_0650 0 {C_RBL}
spr_cell1_r100_0650 pref_100 ref_cell1_r100_0650 ctl 0 swpre
cref_cell1_r100_0650 ref_cell1_r100_0650 0 {C_RBL}   $ ASSUMPTION: ideal matched dummy load
XMN1_cell1_r100_0650 rbl_cell1_r100_0650 ref_cell1_r100_0650 vn_cell1_r100_0650 0 sky130_fd_pr__nfet_01v8 L=0.15 W=1 nf=1 ad=0.29 as=0.29 pd=2.58 ps=2.58 mult=1 m=1
XMN2_cell1_r100_0650 ref_cell1_r100_0650 rbl_cell1_r100_0650 vn_cell1_r100_0650 0 sky130_fd_pr__nfet_01v8 L=0.15 W=1 nf=1 ad=0.29 as=0.29 pd=2.58 ps=2.58 mult=1 m=1
XMP1_cell1_r100_0650 rbl_cell1_r100_0650 ref_cell1_r100_0650 vp_cell1_r100_0650 vdd sky130_fd_pr__pfet_01v8 L=0.15 W=2 nf=1 ad=0.58 as=0.58 pd=4.58 ps=4.58 mult=1 m=1
XMP2_cell1_r100_0650 ref_cell1_r100_0650 rbl_cell1_r100_0650 vp_cell1_r100_0650 vdd sky130_fd_pr__pfet_01v8 L=0.15 W=2 nf=1 ad=0.58 as=0.58 pd=4.58 ps=4.58 mult=1 m=1
XMNF_cell1_r100_0650 vn_cell1_r100_0650 en 0 0 sky130_fd_pr__nfet_01v8 L=0.15 W=2 nf=1 ad=0.58 as=0.58 pd=4.58 ps=4.58 mult=1 m=1
XMPH_cell1_r100_0650 vp_cell1_r100_0650 enb vdd vdd sky130_fd_pr__pfet_01v8 L=0.15 W=4 nf=1 ad=1.16 as=1.16 pd=8.58 ps=8.58 mult=1 m=1
bd_cell1_r100_0650 d_cell1_r100_0650 0 v=v(rbl_cell1_r100_0650)-v(ref_cell1_r100_0650)
bdabs_cell1_r100_0650 dabs_cell1_r100_0650 0 v=abs(v(rbl_cell1_r100_0650)-v(ref_cell1_r100_0650))

* ---- instance 66: cell1_r100_0700 ----
spa_cell1_r100_0700 prea rbl_cell1_r100_0700 ctl 0 swpre
XMWR_cell1_r100_0700_0 sn_cell1_r100_0700_0 0 0 0 sky130_fd_pr__nfet_01v8 L=0.15 W=0.42 nf=1 ad=0.1974 as=0.1974 pd=1.78 ps=1.78 nrd=0.69047619047619  nrs=0.69047619047619 sa=0 sb=0 sd=0 mult=1 m=1
XMRD_cell1_r100_0700_0 rbl_cell1_r100_0700 sn_cell1_r100_0700_0 rwl_sel 0 sky130_fd_pr__nfet_01v8 L=0.15 W=0.42 nf=1 ad=0.1974 as=0.1974 pd=1.78 ps=1.78 nrd=0.69047619047619  nrs=0.69047619047619 sa=0 sb=0 sd=0 mult=1 m=1
csn_cell1_r100_0700_0 sn_cell1_r100_0700_0 0 {C_SN}
XMWR_cell1_r100_0700_1 sn_cell1_r100_0700_1 0 0 0 sky130_fd_pr__nfet_01v8 L=0.15 W=0.42 nf=1 ad=0.1974 as=0.1974 pd=1.78 ps=1.78 nrd=0.69047619047619  nrs=0.69047619047619 sa=0 sb=0 sd=0 mult=1 m=1
XMRD_cell1_r100_0700_1 rbl_cell1_r100_0700 sn_cell1_r100_0700_1 rwl_des 0 sky130_fd_pr__nfet_01v8 L=0.15 W=0.42 nf=1 ad=0.1974 as=0.1974 pd=1.78 ps=1.78 nrd=0.69047619047619  nrs=0.69047619047619 sa=0 sb=0 sd=0 mult=1 m=1
csn_cell1_r100_0700_1 sn_cell1_r100_0700_1 0 {C_SN}
XMWR_cell1_r100_0700_2 sn_cell1_r100_0700_2 0 0 0 sky130_fd_pr__nfet_01v8 L=0.15 W=0.42 nf=1 ad=0.1974 as=0.1974 pd=1.78 ps=1.78 nrd=0.69047619047619  nrs=0.69047619047619 sa=0 sb=0 sd=0 mult=1 m=1
XMRD_cell1_r100_0700_2 rbl_cell1_r100_0700 sn_cell1_r100_0700_2 rwl_des 0 sky130_fd_pr__nfet_01v8 L=0.15 W=0.42 nf=1 ad=0.1974 as=0.1974 pd=1.78 ps=1.78 nrd=0.69047619047619  nrs=0.69047619047619 sa=0 sb=0 sd=0 mult=1 m=1
csn_cell1_r100_0700_2 sn_cell1_r100_0700_2 0 {C_SN}
XMWR_cell1_r100_0700_3 sn_cell1_r100_0700_3 0 0 0 sky130_fd_pr__nfet_01v8 L=0.15 W=0.42 nf=1 ad=0.1974 as=0.1974 pd=1.78 ps=1.78 nrd=0.69047619047619  nrs=0.69047619047619 sa=0 sb=0 sd=0 mult=1 m=1
XMRD_cell1_r100_0700_3 rbl_cell1_r100_0700 sn_cell1_r100_0700_3 rwl_des 0 sky130_fd_pr__nfet_01v8 L=0.15 W=0.42 nf=1 ad=0.1974 as=0.1974 pd=1.78 ps=1.78 nrd=0.69047619047619  nrs=0.69047619047619 sa=0 sb=0 sd=0 mult=1 m=1
csn_cell1_r100_0700_3 sn_cell1_r100_0700_3 0 {C_SN}
crbl_cell1_r100_0700 rbl_cell1_r100_0700 0 {C_RBL}
spr_cell1_r100_0700 pref_100 ref_cell1_r100_0700 ctl 0 swpre
cref_cell1_r100_0700 ref_cell1_r100_0700 0 {C_RBL}   $ ASSUMPTION: ideal matched dummy load
XMN1_cell1_r100_0700 rbl_cell1_r100_0700 ref_cell1_r100_0700 vn_cell1_r100_0700 0 sky130_fd_pr__nfet_01v8 L=0.15 W=1 nf=1 ad=0.29 as=0.29 pd=2.58 ps=2.58 mult=1 m=1
XMN2_cell1_r100_0700 ref_cell1_r100_0700 rbl_cell1_r100_0700 vn_cell1_r100_0700 0 sky130_fd_pr__nfet_01v8 L=0.15 W=1 nf=1 ad=0.29 as=0.29 pd=2.58 ps=2.58 mult=1 m=1
XMP1_cell1_r100_0700 rbl_cell1_r100_0700 ref_cell1_r100_0700 vp_cell1_r100_0700 vdd sky130_fd_pr__pfet_01v8 L=0.15 W=2 nf=1 ad=0.58 as=0.58 pd=4.58 ps=4.58 mult=1 m=1
XMP2_cell1_r100_0700 ref_cell1_r100_0700 rbl_cell1_r100_0700 vp_cell1_r100_0700 vdd sky130_fd_pr__pfet_01v8 L=0.15 W=2 nf=1 ad=0.58 as=0.58 pd=4.58 ps=4.58 mult=1 m=1
XMNF_cell1_r100_0700 vn_cell1_r100_0700 en 0 0 sky130_fd_pr__nfet_01v8 L=0.15 W=2 nf=1 ad=0.58 as=0.58 pd=4.58 ps=4.58 mult=1 m=1
XMPH_cell1_r100_0700 vp_cell1_r100_0700 enb vdd vdd sky130_fd_pr__pfet_01v8 L=0.15 W=4 nf=1 ad=1.16 as=1.16 pd=8.58 ps=8.58 mult=1 m=1
bd_cell1_r100_0700 d_cell1_r100_0700 0 v=v(rbl_cell1_r100_0700)-v(ref_cell1_r100_0700)
bdabs_cell1_r100_0700 dabs_cell1_r100_0700 0 v=abs(v(rbl_cell1_r100_0700)-v(ref_cell1_r100_0700))

* ---- instance 67: cell1_r100_0750 ----
spa_cell1_r100_0750 prea rbl_cell1_r100_0750 ctl 0 swpre
XMWR_cell1_r100_0750_0 sn_cell1_r100_0750_0 0 0 0 sky130_fd_pr__nfet_01v8 L=0.15 W=0.42 nf=1 ad=0.1974 as=0.1974 pd=1.78 ps=1.78 nrd=0.69047619047619  nrs=0.69047619047619 sa=0 sb=0 sd=0 mult=1 m=1
XMRD_cell1_r100_0750_0 rbl_cell1_r100_0750 sn_cell1_r100_0750_0 rwl_sel 0 sky130_fd_pr__nfet_01v8 L=0.15 W=0.42 nf=1 ad=0.1974 as=0.1974 pd=1.78 ps=1.78 nrd=0.69047619047619  nrs=0.69047619047619 sa=0 sb=0 sd=0 mult=1 m=1
csn_cell1_r100_0750_0 sn_cell1_r100_0750_0 0 {C_SN}
XMWR_cell1_r100_0750_1 sn_cell1_r100_0750_1 0 0 0 sky130_fd_pr__nfet_01v8 L=0.15 W=0.42 nf=1 ad=0.1974 as=0.1974 pd=1.78 ps=1.78 nrd=0.69047619047619  nrs=0.69047619047619 sa=0 sb=0 sd=0 mult=1 m=1
XMRD_cell1_r100_0750_1 rbl_cell1_r100_0750 sn_cell1_r100_0750_1 rwl_des 0 sky130_fd_pr__nfet_01v8 L=0.15 W=0.42 nf=1 ad=0.1974 as=0.1974 pd=1.78 ps=1.78 nrd=0.69047619047619  nrs=0.69047619047619 sa=0 sb=0 sd=0 mult=1 m=1
csn_cell1_r100_0750_1 sn_cell1_r100_0750_1 0 {C_SN}
XMWR_cell1_r100_0750_2 sn_cell1_r100_0750_2 0 0 0 sky130_fd_pr__nfet_01v8 L=0.15 W=0.42 nf=1 ad=0.1974 as=0.1974 pd=1.78 ps=1.78 nrd=0.69047619047619  nrs=0.69047619047619 sa=0 sb=0 sd=0 mult=1 m=1
XMRD_cell1_r100_0750_2 rbl_cell1_r100_0750 sn_cell1_r100_0750_2 rwl_des 0 sky130_fd_pr__nfet_01v8 L=0.15 W=0.42 nf=1 ad=0.1974 as=0.1974 pd=1.78 ps=1.78 nrd=0.69047619047619  nrs=0.69047619047619 sa=0 sb=0 sd=0 mult=1 m=1
csn_cell1_r100_0750_2 sn_cell1_r100_0750_2 0 {C_SN}
XMWR_cell1_r100_0750_3 sn_cell1_r100_0750_3 0 0 0 sky130_fd_pr__nfet_01v8 L=0.15 W=0.42 nf=1 ad=0.1974 as=0.1974 pd=1.78 ps=1.78 nrd=0.69047619047619  nrs=0.69047619047619 sa=0 sb=0 sd=0 mult=1 m=1
XMRD_cell1_r100_0750_3 rbl_cell1_r100_0750 sn_cell1_r100_0750_3 rwl_des 0 sky130_fd_pr__nfet_01v8 L=0.15 W=0.42 nf=1 ad=0.1974 as=0.1974 pd=1.78 ps=1.78 nrd=0.69047619047619  nrs=0.69047619047619 sa=0 sb=0 sd=0 mult=1 m=1
csn_cell1_r100_0750_3 sn_cell1_r100_0750_3 0 {C_SN}
crbl_cell1_r100_0750 rbl_cell1_r100_0750 0 {C_RBL}
spr_cell1_r100_0750 pref_100 ref_cell1_r100_0750 ctl 0 swpre
cref_cell1_r100_0750 ref_cell1_r100_0750 0 {C_RBL}   $ ASSUMPTION: ideal matched dummy load
XMN1_cell1_r100_0750 rbl_cell1_r100_0750 ref_cell1_r100_0750 vn_cell1_r100_0750 0 sky130_fd_pr__nfet_01v8 L=0.15 W=1 nf=1 ad=0.29 as=0.29 pd=2.58 ps=2.58 mult=1 m=1
XMN2_cell1_r100_0750 ref_cell1_r100_0750 rbl_cell1_r100_0750 vn_cell1_r100_0750 0 sky130_fd_pr__nfet_01v8 L=0.15 W=1 nf=1 ad=0.29 as=0.29 pd=2.58 ps=2.58 mult=1 m=1
XMP1_cell1_r100_0750 rbl_cell1_r100_0750 ref_cell1_r100_0750 vp_cell1_r100_0750 vdd sky130_fd_pr__pfet_01v8 L=0.15 W=2 nf=1 ad=0.58 as=0.58 pd=4.58 ps=4.58 mult=1 m=1
XMP2_cell1_r100_0750 ref_cell1_r100_0750 rbl_cell1_r100_0750 vp_cell1_r100_0750 vdd sky130_fd_pr__pfet_01v8 L=0.15 W=2 nf=1 ad=0.58 as=0.58 pd=4.58 ps=4.58 mult=1 m=1
XMNF_cell1_r100_0750 vn_cell1_r100_0750 en 0 0 sky130_fd_pr__nfet_01v8 L=0.15 W=2 nf=1 ad=0.58 as=0.58 pd=4.58 ps=4.58 mult=1 m=1
XMPH_cell1_r100_0750 vp_cell1_r100_0750 enb vdd vdd sky130_fd_pr__pfet_01v8 L=0.15 W=4 nf=1 ad=1.16 as=1.16 pd=8.58 ps=8.58 mult=1 m=1
bd_cell1_r100_0750 d_cell1_r100_0750 0 v=v(rbl_cell1_r100_0750)-v(ref_cell1_r100_0750)
bdabs_cell1_r100_0750 dabs_cell1_r100_0750 0 v=abs(v(rbl_cell1_r100_0750)-v(ref_cell1_r100_0750))

* ---- instance 68: cell1_r100_0800 ----
spa_cell1_r100_0800 prea rbl_cell1_r100_0800 ctl 0 swpre
XMWR_cell1_r100_0800_0 sn_cell1_r100_0800_0 0 0 0 sky130_fd_pr__nfet_01v8 L=0.15 W=0.42 nf=1 ad=0.1974 as=0.1974 pd=1.78 ps=1.78 nrd=0.69047619047619  nrs=0.69047619047619 sa=0 sb=0 sd=0 mult=1 m=1
XMRD_cell1_r100_0800_0 rbl_cell1_r100_0800 sn_cell1_r100_0800_0 rwl_sel 0 sky130_fd_pr__nfet_01v8 L=0.15 W=0.42 nf=1 ad=0.1974 as=0.1974 pd=1.78 ps=1.78 nrd=0.69047619047619  nrs=0.69047619047619 sa=0 sb=0 sd=0 mult=1 m=1
csn_cell1_r100_0800_0 sn_cell1_r100_0800_0 0 {C_SN}
XMWR_cell1_r100_0800_1 sn_cell1_r100_0800_1 0 0 0 sky130_fd_pr__nfet_01v8 L=0.15 W=0.42 nf=1 ad=0.1974 as=0.1974 pd=1.78 ps=1.78 nrd=0.69047619047619  nrs=0.69047619047619 sa=0 sb=0 sd=0 mult=1 m=1
XMRD_cell1_r100_0800_1 rbl_cell1_r100_0800 sn_cell1_r100_0800_1 rwl_des 0 sky130_fd_pr__nfet_01v8 L=0.15 W=0.42 nf=1 ad=0.1974 as=0.1974 pd=1.78 ps=1.78 nrd=0.69047619047619  nrs=0.69047619047619 sa=0 sb=0 sd=0 mult=1 m=1
csn_cell1_r100_0800_1 sn_cell1_r100_0800_1 0 {C_SN}
XMWR_cell1_r100_0800_2 sn_cell1_r100_0800_2 0 0 0 sky130_fd_pr__nfet_01v8 L=0.15 W=0.42 nf=1 ad=0.1974 as=0.1974 pd=1.78 ps=1.78 nrd=0.69047619047619  nrs=0.69047619047619 sa=0 sb=0 sd=0 mult=1 m=1
XMRD_cell1_r100_0800_2 rbl_cell1_r100_0800 sn_cell1_r100_0800_2 rwl_des 0 sky130_fd_pr__nfet_01v8 L=0.15 W=0.42 nf=1 ad=0.1974 as=0.1974 pd=1.78 ps=1.78 nrd=0.69047619047619  nrs=0.69047619047619 sa=0 sb=0 sd=0 mult=1 m=1
csn_cell1_r100_0800_2 sn_cell1_r100_0800_2 0 {C_SN}
XMWR_cell1_r100_0800_3 sn_cell1_r100_0800_3 0 0 0 sky130_fd_pr__nfet_01v8 L=0.15 W=0.42 nf=1 ad=0.1974 as=0.1974 pd=1.78 ps=1.78 nrd=0.69047619047619  nrs=0.69047619047619 sa=0 sb=0 sd=0 mult=1 m=1
XMRD_cell1_r100_0800_3 rbl_cell1_r100_0800 sn_cell1_r100_0800_3 rwl_des 0 sky130_fd_pr__nfet_01v8 L=0.15 W=0.42 nf=1 ad=0.1974 as=0.1974 pd=1.78 ps=1.78 nrd=0.69047619047619  nrs=0.69047619047619 sa=0 sb=0 sd=0 mult=1 m=1
csn_cell1_r100_0800_3 sn_cell1_r100_0800_3 0 {C_SN}
crbl_cell1_r100_0800 rbl_cell1_r100_0800 0 {C_RBL}
spr_cell1_r100_0800 pref_100 ref_cell1_r100_0800 ctl 0 swpre
cref_cell1_r100_0800 ref_cell1_r100_0800 0 {C_RBL}   $ ASSUMPTION: ideal matched dummy load
XMN1_cell1_r100_0800 rbl_cell1_r100_0800 ref_cell1_r100_0800 vn_cell1_r100_0800 0 sky130_fd_pr__nfet_01v8 L=0.15 W=1 nf=1 ad=0.29 as=0.29 pd=2.58 ps=2.58 mult=1 m=1
XMN2_cell1_r100_0800 ref_cell1_r100_0800 rbl_cell1_r100_0800 vn_cell1_r100_0800 0 sky130_fd_pr__nfet_01v8 L=0.15 W=1 nf=1 ad=0.29 as=0.29 pd=2.58 ps=2.58 mult=1 m=1
XMP1_cell1_r100_0800 rbl_cell1_r100_0800 ref_cell1_r100_0800 vp_cell1_r100_0800 vdd sky130_fd_pr__pfet_01v8 L=0.15 W=2 nf=1 ad=0.58 as=0.58 pd=4.58 ps=4.58 mult=1 m=1
XMP2_cell1_r100_0800 ref_cell1_r100_0800 rbl_cell1_r100_0800 vp_cell1_r100_0800 vdd sky130_fd_pr__pfet_01v8 L=0.15 W=2 nf=1 ad=0.58 as=0.58 pd=4.58 ps=4.58 mult=1 m=1
XMNF_cell1_r100_0800 vn_cell1_r100_0800 en 0 0 sky130_fd_pr__nfet_01v8 L=0.15 W=2 nf=1 ad=0.58 as=0.58 pd=4.58 ps=4.58 mult=1 m=1
XMPH_cell1_r100_0800 vp_cell1_r100_0800 enb vdd vdd sky130_fd_pr__pfet_01v8 L=0.15 W=4 nf=1 ad=1.16 as=1.16 pd=8.58 ps=8.58 mult=1 m=1
bd_cell1_r100_0800 d_cell1_r100_0800 0 v=v(rbl_cell1_r100_0800)-v(ref_cell1_r100_0800)
bdabs_cell1_r100_0800 dabs_cell1_r100_0800 0 v=abs(v(rbl_cell1_r100_0800)-v(ref_cell1_r100_0800))

* ---- instance 69: cell1_r100_0850 ----
spa_cell1_r100_0850 prea rbl_cell1_r100_0850 ctl 0 swpre
XMWR_cell1_r100_0850_0 sn_cell1_r100_0850_0 0 0 0 sky130_fd_pr__nfet_01v8 L=0.15 W=0.42 nf=1 ad=0.1974 as=0.1974 pd=1.78 ps=1.78 nrd=0.69047619047619  nrs=0.69047619047619 sa=0 sb=0 sd=0 mult=1 m=1
XMRD_cell1_r100_0850_0 rbl_cell1_r100_0850 sn_cell1_r100_0850_0 rwl_sel 0 sky130_fd_pr__nfet_01v8 L=0.15 W=0.42 nf=1 ad=0.1974 as=0.1974 pd=1.78 ps=1.78 nrd=0.69047619047619  nrs=0.69047619047619 sa=0 sb=0 sd=0 mult=1 m=1
csn_cell1_r100_0850_0 sn_cell1_r100_0850_0 0 {C_SN}
XMWR_cell1_r100_0850_1 sn_cell1_r100_0850_1 0 0 0 sky130_fd_pr__nfet_01v8 L=0.15 W=0.42 nf=1 ad=0.1974 as=0.1974 pd=1.78 ps=1.78 nrd=0.69047619047619  nrs=0.69047619047619 sa=0 sb=0 sd=0 mult=1 m=1
XMRD_cell1_r100_0850_1 rbl_cell1_r100_0850 sn_cell1_r100_0850_1 rwl_des 0 sky130_fd_pr__nfet_01v8 L=0.15 W=0.42 nf=1 ad=0.1974 as=0.1974 pd=1.78 ps=1.78 nrd=0.69047619047619  nrs=0.69047619047619 sa=0 sb=0 sd=0 mult=1 m=1
csn_cell1_r100_0850_1 sn_cell1_r100_0850_1 0 {C_SN}
XMWR_cell1_r100_0850_2 sn_cell1_r100_0850_2 0 0 0 sky130_fd_pr__nfet_01v8 L=0.15 W=0.42 nf=1 ad=0.1974 as=0.1974 pd=1.78 ps=1.78 nrd=0.69047619047619  nrs=0.69047619047619 sa=0 sb=0 sd=0 mult=1 m=1
XMRD_cell1_r100_0850_2 rbl_cell1_r100_0850 sn_cell1_r100_0850_2 rwl_des 0 sky130_fd_pr__nfet_01v8 L=0.15 W=0.42 nf=1 ad=0.1974 as=0.1974 pd=1.78 ps=1.78 nrd=0.69047619047619  nrs=0.69047619047619 sa=0 sb=0 sd=0 mult=1 m=1
csn_cell1_r100_0850_2 sn_cell1_r100_0850_2 0 {C_SN}
XMWR_cell1_r100_0850_3 sn_cell1_r100_0850_3 0 0 0 sky130_fd_pr__nfet_01v8 L=0.15 W=0.42 nf=1 ad=0.1974 as=0.1974 pd=1.78 ps=1.78 nrd=0.69047619047619  nrs=0.69047619047619 sa=0 sb=0 sd=0 mult=1 m=1
XMRD_cell1_r100_0850_3 rbl_cell1_r100_0850 sn_cell1_r100_0850_3 rwl_des 0 sky130_fd_pr__nfet_01v8 L=0.15 W=0.42 nf=1 ad=0.1974 as=0.1974 pd=1.78 ps=1.78 nrd=0.69047619047619  nrs=0.69047619047619 sa=0 sb=0 sd=0 mult=1 m=1
csn_cell1_r100_0850_3 sn_cell1_r100_0850_3 0 {C_SN}
crbl_cell1_r100_0850 rbl_cell1_r100_0850 0 {C_RBL}
spr_cell1_r100_0850 pref_100 ref_cell1_r100_0850 ctl 0 swpre
cref_cell1_r100_0850 ref_cell1_r100_0850 0 {C_RBL}   $ ASSUMPTION: ideal matched dummy load
XMN1_cell1_r100_0850 rbl_cell1_r100_0850 ref_cell1_r100_0850 vn_cell1_r100_0850 0 sky130_fd_pr__nfet_01v8 L=0.15 W=1 nf=1 ad=0.29 as=0.29 pd=2.58 ps=2.58 mult=1 m=1
XMN2_cell1_r100_0850 ref_cell1_r100_0850 rbl_cell1_r100_0850 vn_cell1_r100_0850 0 sky130_fd_pr__nfet_01v8 L=0.15 W=1 nf=1 ad=0.29 as=0.29 pd=2.58 ps=2.58 mult=1 m=1
XMP1_cell1_r100_0850 rbl_cell1_r100_0850 ref_cell1_r100_0850 vp_cell1_r100_0850 vdd sky130_fd_pr__pfet_01v8 L=0.15 W=2 nf=1 ad=0.58 as=0.58 pd=4.58 ps=4.58 mult=1 m=1
XMP2_cell1_r100_0850 ref_cell1_r100_0850 rbl_cell1_r100_0850 vp_cell1_r100_0850 vdd sky130_fd_pr__pfet_01v8 L=0.15 W=2 nf=1 ad=0.58 as=0.58 pd=4.58 ps=4.58 mult=1 m=1
XMNF_cell1_r100_0850 vn_cell1_r100_0850 en 0 0 sky130_fd_pr__nfet_01v8 L=0.15 W=2 nf=1 ad=0.58 as=0.58 pd=4.58 ps=4.58 mult=1 m=1
XMPH_cell1_r100_0850 vp_cell1_r100_0850 enb vdd vdd sky130_fd_pr__pfet_01v8 L=0.15 W=4 nf=1 ad=1.16 as=1.16 pd=8.58 ps=8.58 mult=1 m=1
bd_cell1_r100_0850 d_cell1_r100_0850 0 v=v(rbl_cell1_r100_0850)-v(ref_cell1_r100_0850)
bdabs_cell1_r100_0850 dabs_cell1_r100_0850 0 v=abs(v(rbl_cell1_r100_0850)-v(ref_cell1_r100_0850))

* ---- instance 70: cell1_r100_0900 ----
spa_cell1_r100_0900 prea rbl_cell1_r100_0900 ctl 0 swpre
XMWR_cell1_r100_0900_0 sn_cell1_r100_0900_0 0 0 0 sky130_fd_pr__nfet_01v8 L=0.15 W=0.42 nf=1 ad=0.1974 as=0.1974 pd=1.78 ps=1.78 nrd=0.69047619047619  nrs=0.69047619047619 sa=0 sb=0 sd=0 mult=1 m=1
XMRD_cell1_r100_0900_0 rbl_cell1_r100_0900 sn_cell1_r100_0900_0 rwl_sel 0 sky130_fd_pr__nfet_01v8 L=0.15 W=0.42 nf=1 ad=0.1974 as=0.1974 pd=1.78 ps=1.78 nrd=0.69047619047619  nrs=0.69047619047619 sa=0 sb=0 sd=0 mult=1 m=1
csn_cell1_r100_0900_0 sn_cell1_r100_0900_0 0 {C_SN}
XMWR_cell1_r100_0900_1 sn_cell1_r100_0900_1 0 0 0 sky130_fd_pr__nfet_01v8 L=0.15 W=0.42 nf=1 ad=0.1974 as=0.1974 pd=1.78 ps=1.78 nrd=0.69047619047619  nrs=0.69047619047619 sa=0 sb=0 sd=0 mult=1 m=1
XMRD_cell1_r100_0900_1 rbl_cell1_r100_0900 sn_cell1_r100_0900_1 rwl_des 0 sky130_fd_pr__nfet_01v8 L=0.15 W=0.42 nf=1 ad=0.1974 as=0.1974 pd=1.78 ps=1.78 nrd=0.69047619047619  nrs=0.69047619047619 sa=0 sb=0 sd=0 mult=1 m=1
csn_cell1_r100_0900_1 sn_cell1_r100_0900_1 0 {C_SN}
XMWR_cell1_r100_0900_2 sn_cell1_r100_0900_2 0 0 0 sky130_fd_pr__nfet_01v8 L=0.15 W=0.42 nf=1 ad=0.1974 as=0.1974 pd=1.78 ps=1.78 nrd=0.69047619047619  nrs=0.69047619047619 sa=0 sb=0 sd=0 mult=1 m=1
XMRD_cell1_r100_0900_2 rbl_cell1_r100_0900 sn_cell1_r100_0900_2 rwl_des 0 sky130_fd_pr__nfet_01v8 L=0.15 W=0.42 nf=1 ad=0.1974 as=0.1974 pd=1.78 ps=1.78 nrd=0.69047619047619  nrs=0.69047619047619 sa=0 sb=0 sd=0 mult=1 m=1
csn_cell1_r100_0900_2 sn_cell1_r100_0900_2 0 {C_SN}
XMWR_cell1_r100_0900_3 sn_cell1_r100_0900_3 0 0 0 sky130_fd_pr__nfet_01v8 L=0.15 W=0.42 nf=1 ad=0.1974 as=0.1974 pd=1.78 ps=1.78 nrd=0.69047619047619  nrs=0.69047619047619 sa=0 sb=0 sd=0 mult=1 m=1
XMRD_cell1_r100_0900_3 rbl_cell1_r100_0900 sn_cell1_r100_0900_3 rwl_des 0 sky130_fd_pr__nfet_01v8 L=0.15 W=0.42 nf=1 ad=0.1974 as=0.1974 pd=1.78 ps=1.78 nrd=0.69047619047619  nrs=0.69047619047619 sa=0 sb=0 sd=0 mult=1 m=1
csn_cell1_r100_0900_3 sn_cell1_r100_0900_3 0 {C_SN}
crbl_cell1_r100_0900 rbl_cell1_r100_0900 0 {C_RBL}
spr_cell1_r100_0900 pref_100 ref_cell1_r100_0900 ctl 0 swpre
cref_cell1_r100_0900 ref_cell1_r100_0900 0 {C_RBL}   $ ASSUMPTION: ideal matched dummy load
XMN1_cell1_r100_0900 rbl_cell1_r100_0900 ref_cell1_r100_0900 vn_cell1_r100_0900 0 sky130_fd_pr__nfet_01v8 L=0.15 W=1 nf=1 ad=0.29 as=0.29 pd=2.58 ps=2.58 mult=1 m=1
XMN2_cell1_r100_0900 ref_cell1_r100_0900 rbl_cell1_r100_0900 vn_cell1_r100_0900 0 sky130_fd_pr__nfet_01v8 L=0.15 W=1 nf=1 ad=0.29 as=0.29 pd=2.58 ps=2.58 mult=1 m=1
XMP1_cell1_r100_0900 rbl_cell1_r100_0900 ref_cell1_r100_0900 vp_cell1_r100_0900 vdd sky130_fd_pr__pfet_01v8 L=0.15 W=2 nf=1 ad=0.58 as=0.58 pd=4.58 ps=4.58 mult=1 m=1
XMP2_cell1_r100_0900 ref_cell1_r100_0900 rbl_cell1_r100_0900 vp_cell1_r100_0900 vdd sky130_fd_pr__pfet_01v8 L=0.15 W=2 nf=1 ad=0.58 as=0.58 pd=4.58 ps=4.58 mult=1 m=1
XMNF_cell1_r100_0900 vn_cell1_r100_0900 en 0 0 sky130_fd_pr__nfet_01v8 L=0.15 W=2 nf=1 ad=0.58 as=0.58 pd=4.58 ps=4.58 mult=1 m=1
XMPH_cell1_r100_0900 vp_cell1_r100_0900 enb vdd vdd sky130_fd_pr__pfet_01v8 L=0.15 W=4 nf=1 ad=1.16 as=1.16 pd=8.58 ps=8.58 mult=1 m=1
bd_cell1_r100_0900 d_cell1_r100_0900 0 v=v(rbl_cell1_r100_0900)-v(ref_cell1_r100_0900)
bdabs_cell1_r100_0900 dabs_cell1_r100_0900 0 v=abs(v(rbl_cell1_r100_0900)-v(ref_cell1_r100_0900))

* ---- instance 71: cell1_r100_0950 ----
spa_cell1_r100_0950 prea rbl_cell1_r100_0950 ctl 0 swpre
XMWR_cell1_r100_0950_0 sn_cell1_r100_0950_0 0 0 0 sky130_fd_pr__nfet_01v8 L=0.15 W=0.42 nf=1 ad=0.1974 as=0.1974 pd=1.78 ps=1.78 nrd=0.69047619047619  nrs=0.69047619047619 sa=0 sb=0 sd=0 mult=1 m=1
XMRD_cell1_r100_0950_0 rbl_cell1_r100_0950 sn_cell1_r100_0950_0 rwl_sel 0 sky130_fd_pr__nfet_01v8 L=0.15 W=0.42 nf=1 ad=0.1974 as=0.1974 pd=1.78 ps=1.78 nrd=0.69047619047619  nrs=0.69047619047619 sa=0 sb=0 sd=0 mult=1 m=1
csn_cell1_r100_0950_0 sn_cell1_r100_0950_0 0 {C_SN}
XMWR_cell1_r100_0950_1 sn_cell1_r100_0950_1 0 0 0 sky130_fd_pr__nfet_01v8 L=0.15 W=0.42 nf=1 ad=0.1974 as=0.1974 pd=1.78 ps=1.78 nrd=0.69047619047619  nrs=0.69047619047619 sa=0 sb=0 sd=0 mult=1 m=1
XMRD_cell1_r100_0950_1 rbl_cell1_r100_0950 sn_cell1_r100_0950_1 rwl_des 0 sky130_fd_pr__nfet_01v8 L=0.15 W=0.42 nf=1 ad=0.1974 as=0.1974 pd=1.78 ps=1.78 nrd=0.69047619047619  nrs=0.69047619047619 sa=0 sb=0 sd=0 mult=1 m=1
csn_cell1_r100_0950_1 sn_cell1_r100_0950_1 0 {C_SN}
XMWR_cell1_r100_0950_2 sn_cell1_r100_0950_2 0 0 0 sky130_fd_pr__nfet_01v8 L=0.15 W=0.42 nf=1 ad=0.1974 as=0.1974 pd=1.78 ps=1.78 nrd=0.69047619047619  nrs=0.69047619047619 sa=0 sb=0 sd=0 mult=1 m=1
XMRD_cell1_r100_0950_2 rbl_cell1_r100_0950 sn_cell1_r100_0950_2 rwl_des 0 sky130_fd_pr__nfet_01v8 L=0.15 W=0.42 nf=1 ad=0.1974 as=0.1974 pd=1.78 ps=1.78 nrd=0.69047619047619  nrs=0.69047619047619 sa=0 sb=0 sd=0 mult=1 m=1
csn_cell1_r100_0950_2 sn_cell1_r100_0950_2 0 {C_SN}
XMWR_cell1_r100_0950_3 sn_cell1_r100_0950_3 0 0 0 sky130_fd_pr__nfet_01v8 L=0.15 W=0.42 nf=1 ad=0.1974 as=0.1974 pd=1.78 ps=1.78 nrd=0.69047619047619  nrs=0.69047619047619 sa=0 sb=0 sd=0 mult=1 m=1
XMRD_cell1_r100_0950_3 rbl_cell1_r100_0950 sn_cell1_r100_0950_3 rwl_des 0 sky130_fd_pr__nfet_01v8 L=0.15 W=0.42 nf=1 ad=0.1974 as=0.1974 pd=1.78 ps=1.78 nrd=0.69047619047619  nrs=0.69047619047619 sa=0 sb=0 sd=0 mult=1 m=1
csn_cell1_r100_0950_3 sn_cell1_r100_0950_3 0 {C_SN}
crbl_cell1_r100_0950 rbl_cell1_r100_0950 0 {C_RBL}
spr_cell1_r100_0950 pref_100 ref_cell1_r100_0950 ctl 0 swpre
cref_cell1_r100_0950 ref_cell1_r100_0950 0 {C_RBL}   $ ASSUMPTION: ideal matched dummy load
XMN1_cell1_r100_0950 rbl_cell1_r100_0950 ref_cell1_r100_0950 vn_cell1_r100_0950 0 sky130_fd_pr__nfet_01v8 L=0.15 W=1 nf=1 ad=0.29 as=0.29 pd=2.58 ps=2.58 mult=1 m=1
XMN2_cell1_r100_0950 ref_cell1_r100_0950 rbl_cell1_r100_0950 vn_cell1_r100_0950 0 sky130_fd_pr__nfet_01v8 L=0.15 W=1 nf=1 ad=0.29 as=0.29 pd=2.58 ps=2.58 mult=1 m=1
XMP1_cell1_r100_0950 rbl_cell1_r100_0950 ref_cell1_r100_0950 vp_cell1_r100_0950 vdd sky130_fd_pr__pfet_01v8 L=0.15 W=2 nf=1 ad=0.58 as=0.58 pd=4.58 ps=4.58 mult=1 m=1
XMP2_cell1_r100_0950 ref_cell1_r100_0950 rbl_cell1_r100_0950 vp_cell1_r100_0950 vdd sky130_fd_pr__pfet_01v8 L=0.15 W=2 nf=1 ad=0.58 as=0.58 pd=4.58 ps=4.58 mult=1 m=1
XMNF_cell1_r100_0950 vn_cell1_r100_0950 en 0 0 sky130_fd_pr__nfet_01v8 L=0.15 W=2 nf=1 ad=0.58 as=0.58 pd=4.58 ps=4.58 mult=1 m=1
XMPH_cell1_r100_0950 vp_cell1_r100_0950 enb vdd vdd sky130_fd_pr__pfet_01v8 L=0.15 W=4 nf=1 ad=1.16 as=1.16 pd=8.58 ps=8.58 mult=1 m=1
bd_cell1_r100_0950 d_cell1_r100_0950 0 v=v(rbl_cell1_r100_0950)-v(ref_cell1_r100_0950)
bdabs_cell1_r100_0950 dabs_cell1_r100_0950 0 v=abs(v(rbl_cell1_r100_0950)-v(ref_cell1_r100_0950))

* ---- instance 72: cell1_r100_1000 ----
spa_cell1_r100_1000 prea rbl_cell1_r100_1000 ctl 0 swpre
XMWR_cell1_r100_1000_0 sn_cell1_r100_1000_0 0 0 0 sky130_fd_pr__nfet_01v8 L=0.15 W=0.42 nf=1 ad=0.1974 as=0.1974 pd=1.78 ps=1.78 nrd=0.69047619047619  nrs=0.69047619047619 sa=0 sb=0 sd=0 mult=1 m=1
XMRD_cell1_r100_1000_0 rbl_cell1_r100_1000 sn_cell1_r100_1000_0 rwl_sel 0 sky130_fd_pr__nfet_01v8 L=0.15 W=0.42 nf=1 ad=0.1974 as=0.1974 pd=1.78 ps=1.78 nrd=0.69047619047619  nrs=0.69047619047619 sa=0 sb=0 sd=0 mult=1 m=1
csn_cell1_r100_1000_0 sn_cell1_r100_1000_0 0 {C_SN}
XMWR_cell1_r100_1000_1 sn_cell1_r100_1000_1 0 0 0 sky130_fd_pr__nfet_01v8 L=0.15 W=0.42 nf=1 ad=0.1974 as=0.1974 pd=1.78 ps=1.78 nrd=0.69047619047619  nrs=0.69047619047619 sa=0 sb=0 sd=0 mult=1 m=1
XMRD_cell1_r100_1000_1 rbl_cell1_r100_1000 sn_cell1_r100_1000_1 rwl_des 0 sky130_fd_pr__nfet_01v8 L=0.15 W=0.42 nf=1 ad=0.1974 as=0.1974 pd=1.78 ps=1.78 nrd=0.69047619047619  nrs=0.69047619047619 sa=0 sb=0 sd=0 mult=1 m=1
csn_cell1_r100_1000_1 sn_cell1_r100_1000_1 0 {C_SN}
XMWR_cell1_r100_1000_2 sn_cell1_r100_1000_2 0 0 0 sky130_fd_pr__nfet_01v8 L=0.15 W=0.42 nf=1 ad=0.1974 as=0.1974 pd=1.78 ps=1.78 nrd=0.69047619047619  nrs=0.69047619047619 sa=0 sb=0 sd=0 mult=1 m=1
XMRD_cell1_r100_1000_2 rbl_cell1_r100_1000 sn_cell1_r100_1000_2 rwl_des 0 sky130_fd_pr__nfet_01v8 L=0.15 W=0.42 nf=1 ad=0.1974 as=0.1974 pd=1.78 ps=1.78 nrd=0.69047619047619  nrs=0.69047619047619 sa=0 sb=0 sd=0 mult=1 m=1
csn_cell1_r100_1000_2 sn_cell1_r100_1000_2 0 {C_SN}
XMWR_cell1_r100_1000_3 sn_cell1_r100_1000_3 0 0 0 sky130_fd_pr__nfet_01v8 L=0.15 W=0.42 nf=1 ad=0.1974 as=0.1974 pd=1.78 ps=1.78 nrd=0.69047619047619  nrs=0.69047619047619 sa=0 sb=0 sd=0 mult=1 m=1
XMRD_cell1_r100_1000_3 rbl_cell1_r100_1000 sn_cell1_r100_1000_3 rwl_des 0 sky130_fd_pr__nfet_01v8 L=0.15 W=0.42 nf=1 ad=0.1974 as=0.1974 pd=1.78 ps=1.78 nrd=0.69047619047619  nrs=0.69047619047619 sa=0 sb=0 sd=0 mult=1 m=1
csn_cell1_r100_1000_3 sn_cell1_r100_1000_3 0 {C_SN}
crbl_cell1_r100_1000 rbl_cell1_r100_1000 0 {C_RBL}
spr_cell1_r100_1000 pref_100 ref_cell1_r100_1000 ctl 0 swpre
cref_cell1_r100_1000 ref_cell1_r100_1000 0 {C_RBL}   $ ASSUMPTION: ideal matched dummy load
XMN1_cell1_r100_1000 rbl_cell1_r100_1000 ref_cell1_r100_1000 vn_cell1_r100_1000 0 sky130_fd_pr__nfet_01v8 L=0.15 W=1 nf=1 ad=0.29 as=0.29 pd=2.58 ps=2.58 mult=1 m=1
XMN2_cell1_r100_1000 ref_cell1_r100_1000 rbl_cell1_r100_1000 vn_cell1_r100_1000 0 sky130_fd_pr__nfet_01v8 L=0.15 W=1 nf=1 ad=0.29 as=0.29 pd=2.58 ps=2.58 mult=1 m=1
XMP1_cell1_r100_1000 rbl_cell1_r100_1000 ref_cell1_r100_1000 vp_cell1_r100_1000 vdd sky130_fd_pr__pfet_01v8 L=0.15 W=2 nf=1 ad=0.58 as=0.58 pd=4.58 ps=4.58 mult=1 m=1
XMP2_cell1_r100_1000 ref_cell1_r100_1000 rbl_cell1_r100_1000 vp_cell1_r100_1000 vdd sky130_fd_pr__pfet_01v8 L=0.15 W=2 nf=1 ad=0.58 as=0.58 pd=4.58 ps=4.58 mult=1 m=1
XMNF_cell1_r100_1000 vn_cell1_r100_1000 en 0 0 sky130_fd_pr__nfet_01v8 L=0.15 W=2 nf=1 ad=0.58 as=0.58 pd=4.58 ps=4.58 mult=1 m=1
XMPH_cell1_r100_1000 vp_cell1_r100_1000 enb vdd vdd sky130_fd_pr__pfet_01v8 L=0.15 W=4 nf=1 ad=1.16 as=1.16 pd=8.58 ps=8.58 mult=1 m=1
bd_cell1_r100_1000 d_cell1_r100_1000 0 v=v(rbl_cell1_r100_1000)-v(ref_cell1_r100_1000)
bdabs_cell1_r100_1000 dabs_cell1_r100_1000 0 v=abs(v(rbl_cell1_r100_1000)-v(ref_cell1_r100_1000))

* ---- instance 73: cell1_r100_1050 ----
spa_cell1_r100_1050 prea rbl_cell1_r100_1050 ctl 0 swpre
XMWR_cell1_r100_1050_0 sn_cell1_r100_1050_0 0 0 0 sky130_fd_pr__nfet_01v8 L=0.15 W=0.42 nf=1 ad=0.1974 as=0.1974 pd=1.78 ps=1.78 nrd=0.69047619047619  nrs=0.69047619047619 sa=0 sb=0 sd=0 mult=1 m=1
XMRD_cell1_r100_1050_0 rbl_cell1_r100_1050 sn_cell1_r100_1050_0 rwl_sel 0 sky130_fd_pr__nfet_01v8 L=0.15 W=0.42 nf=1 ad=0.1974 as=0.1974 pd=1.78 ps=1.78 nrd=0.69047619047619  nrs=0.69047619047619 sa=0 sb=0 sd=0 mult=1 m=1
csn_cell1_r100_1050_0 sn_cell1_r100_1050_0 0 {C_SN}
XMWR_cell1_r100_1050_1 sn_cell1_r100_1050_1 0 0 0 sky130_fd_pr__nfet_01v8 L=0.15 W=0.42 nf=1 ad=0.1974 as=0.1974 pd=1.78 ps=1.78 nrd=0.69047619047619  nrs=0.69047619047619 sa=0 sb=0 sd=0 mult=1 m=1
XMRD_cell1_r100_1050_1 rbl_cell1_r100_1050 sn_cell1_r100_1050_1 rwl_des 0 sky130_fd_pr__nfet_01v8 L=0.15 W=0.42 nf=1 ad=0.1974 as=0.1974 pd=1.78 ps=1.78 nrd=0.69047619047619  nrs=0.69047619047619 sa=0 sb=0 sd=0 mult=1 m=1
csn_cell1_r100_1050_1 sn_cell1_r100_1050_1 0 {C_SN}
XMWR_cell1_r100_1050_2 sn_cell1_r100_1050_2 0 0 0 sky130_fd_pr__nfet_01v8 L=0.15 W=0.42 nf=1 ad=0.1974 as=0.1974 pd=1.78 ps=1.78 nrd=0.69047619047619  nrs=0.69047619047619 sa=0 sb=0 sd=0 mult=1 m=1
XMRD_cell1_r100_1050_2 rbl_cell1_r100_1050 sn_cell1_r100_1050_2 rwl_des 0 sky130_fd_pr__nfet_01v8 L=0.15 W=0.42 nf=1 ad=0.1974 as=0.1974 pd=1.78 ps=1.78 nrd=0.69047619047619  nrs=0.69047619047619 sa=0 sb=0 sd=0 mult=1 m=1
csn_cell1_r100_1050_2 sn_cell1_r100_1050_2 0 {C_SN}
XMWR_cell1_r100_1050_3 sn_cell1_r100_1050_3 0 0 0 sky130_fd_pr__nfet_01v8 L=0.15 W=0.42 nf=1 ad=0.1974 as=0.1974 pd=1.78 ps=1.78 nrd=0.69047619047619  nrs=0.69047619047619 sa=0 sb=0 sd=0 mult=1 m=1
XMRD_cell1_r100_1050_3 rbl_cell1_r100_1050 sn_cell1_r100_1050_3 rwl_des 0 sky130_fd_pr__nfet_01v8 L=0.15 W=0.42 nf=1 ad=0.1974 as=0.1974 pd=1.78 ps=1.78 nrd=0.69047619047619  nrs=0.69047619047619 sa=0 sb=0 sd=0 mult=1 m=1
csn_cell1_r100_1050_3 sn_cell1_r100_1050_3 0 {C_SN}
crbl_cell1_r100_1050 rbl_cell1_r100_1050 0 {C_RBL}
spr_cell1_r100_1050 pref_100 ref_cell1_r100_1050 ctl 0 swpre
cref_cell1_r100_1050 ref_cell1_r100_1050 0 {C_RBL}   $ ASSUMPTION: ideal matched dummy load
XMN1_cell1_r100_1050 rbl_cell1_r100_1050 ref_cell1_r100_1050 vn_cell1_r100_1050 0 sky130_fd_pr__nfet_01v8 L=0.15 W=1 nf=1 ad=0.29 as=0.29 pd=2.58 ps=2.58 mult=1 m=1
XMN2_cell1_r100_1050 ref_cell1_r100_1050 rbl_cell1_r100_1050 vn_cell1_r100_1050 0 sky130_fd_pr__nfet_01v8 L=0.15 W=1 nf=1 ad=0.29 as=0.29 pd=2.58 ps=2.58 mult=1 m=1
XMP1_cell1_r100_1050 rbl_cell1_r100_1050 ref_cell1_r100_1050 vp_cell1_r100_1050 vdd sky130_fd_pr__pfet_01v8 L=0.15 W=2 nf=1 ad=0.58 as=0.58 pd=4.58 ps=4.58 mult=1 m=1
XMP2_cell1_r100_1050 ref_cell1_r100_1050 rbl_cell1_r100_1050 vp_cell1_r100_1050 vdd sky130_fd_pr__pfet_01v8 L=0.15 W=2 nf=1 ad=0.58 as=0.58 pd=4.58 ps=4.58 mult=1 m=1
XMNF_cell1_r100_1050 vn_cell1_r100_1050 en 0 0 sky130_fd_pr__nfet_01v8 L=0.15 W=2 nf=1 ad=0.58 as=0.58 pd=4.58 ps=4.58 mult=1 m=1
XMPH_cell1_r100_1050 vp_cell1_r100_1050 enb vdd vdd sky130_fd_pr__pfet_01v8 L=0.15 W=4 nf=1 ad=1.16 as=1.16 pd=8.58 ps=8.58 mult=1 m=1
bd_cell1_r100_1050 d_cell1_r100_1050 0 v=v(rbl_cell1_r100_1050)-v(ref_cell1_r100_1050)
bdabs_cell1_r100_1050 dabs_cell1_r100_1050 0 v=abs(v(rbl_cell1_r100_1050)-v(ref_cell1_r100_1050))

* ---- instance 74: cell1_r100_1100 ----
spa_cell1_r100_1100 prea rbl_cell1_r100_1100 ctl 0 swpre
XMWR_cell1_r100_1100_0 sn_cell1_r100_1100_0 0 0 0 sky130_fd_pr__nfet_01v8 L=0.15 W=0.42 nf=1 ad=0.1974 as=0.1974 pd=1.78 ps=1.78 nrd=0.69047619047619  nrs=0.69047619047619 sa=0 sb=0 sd=0 mult=1 m=1
XMRD_cell1_r100_1100_0 rbl_cell1_r100_1100 sn_cell1_r100_1100_0 rwl_sel 0 sky130_fd_pr__nfet_01v8 L=0.15 W=0.42 nf=1 ad=0.1974 as=0.1974 pd=1.78 ps=1.78 nrd=0.69047619047619  nrs=0.69047619047619 sa=0 sb=0 sd=0 mult=1 m=1
csn_cell1_r100_1100_0 sn_cell1_r100_1100_0 0 {C_SN}
XMWR_cell1_r100_1100_1 sn_cell1_r100_1100_1 0 0 0 sky130_fd_pr__nfet_01v8 L=0.15 W=0.42 nf=1 ad=0.1974 as=0.1974 pd=1.78 ps=1.78 nrd=0.69047619047619  nrs=0.69047619047619 sa=0 sb=0 sd=0 mult=1 m=1
XMRD_cell1_r100_1100_1 rbl_cell1_r100_1100 sn_cell1_r100_1100_1 rwl_des 0 sky130_fd_pr__nfet_01v8 L=0.15 W=0.42 nf=1 ad=0.1974 as=0.1974 pd=1.78 ps=1.78 nrd=0.69047619047619  nrs=0.69047619047619 sa=0 sb=0 sd=0 mult=1 m=1
csn_cell1_r100_1100_1 sn_cell1_r100_1100_1 0 {C_SN}
XMWR_cell1_r100_1100_2 sn_cell1_r100_1100_2 0 0 0 sky130_fd_pr__nfet_01v8 L=0.15 W=0.42 nf=1 ad=0.1974 as=0.1974 pd=1.78 ps=1.78 nrd=0.69047619047619  nrs=0.69047619047619 sa=0 sb=0 sd=0 mult=1 m=1
XMRD_cell1_r100_1100_2 rbl_cell1_r100_1100 sn_cell1_r100_1100_2 rwl_des 0 sky130_fd_pr__nfet_01v8 L=0.15 W=0.42 nf=1 ad=0.1974 as=0.1974 pd=1.78 ps=1.78 nrd=0.69047619047619  nrs=0.69047619047619 sa=0 sb=0 sd=0 mult=1 m=1
csn_cell1_r100_1100_2 sn_cell1_r100_1100_2 0 {C_SN}
XMWR_cell1_r100_1100_3 sn_cell1_r100_1100_3 0 0 0 sky130_fd_pr__nfet_01v8 L=0.15 W=0.42 nf=1 ad=0.1974 as=0.1974 pd=1.78 ps=1.78 nrd=0.69047619047619  nrs=0.69047619047619 sa=0 sb=0 sd=0 mult=1 m=1
XMRD_cell1_r100_1100_3 rbl_cell1_r100_1100 sn_cell1_r100_1100_3 rwl_des 0 sky130_fd_pr__nfet_01v8 L=0.15 W=0.42 nf=1 ad=0.1974 as=0.1974 pd=1.78 ps=1.78 nrd=0.69047619047619  nrs=0.69047619047619 sa=0 sb=0 sd=0 mult=1 m=1
csn_cell1_r100_1100_3 sn_cell1_r100_1100_3 0 {C_SN}
crbl_cell1_r100_1100 rbl_cell1_r100_1100 0 {C_RBL}
spr_cell1_r100_1100 pref_100 ref_cell1_r100_1100 ctl 0 swpre
cref_cell1_r100_1100 ref_cell1_r100_1100 0 {C_RBL}   $ ASSUMPTION: ideal matched dummy load
XMN1_cell1_r100_1100 rbl_cell1_r100_1100 ref_cell1_r100_1100 vn_cell1_r100_1100 0 sky130_fd_pr__nfet_01v8 L=0.15 W=1 nf=1 ad=0.29 as=0.29 pd=2.58 ps=2.58 mult=1 m=1
XMN2_cell1_r100_1100 ref_cell1_r100_1100 rbl_cell1_r100_1100 vn_cell1_r100_1100 0 sky130_fd_pr__nfet_01v8 L=0.15 W=1 nf=1 ad=0.29 as=0.29 pd=2.58 ps=2.58 mult=1 m=1
XMP1_cell1_r100_1100 rbl_cell1_r100_1100 ref_cell1_r100_1100 vp_cell1_r100_1100 vdd sky130_fd_pr__pfet_01v8 L=0.15 W=2 nf=1 ad=0.58 as=0.58 pd=4.58 ps=4.58 mult=1 m=1
XMP2_cell1_r100_1100 ref_cell1_r100_1100 rbl_cell1_r100_1100 vp_cell1_r100_1100 vdd sky130_fd_pr__pfet_01v8 L=0.15 W=2 nf=1 ad=0.58 as=0.58 pd=4.58 ps=4.58 mult=1 m=1
XMNF_cell1_r100_1100 vn_cell1_r100_1100 en 0 0 sky130_fd_pr__nfet_01v8 L=0.15 W=2 nf=1 ad=0.58 as=0.58 pd=4.58 ps=4.58 mult=1 m=1
XMPH_cell1_r100_1100 vp_cell1_r100_1100 enb vdd vdd sky130_fd_pr__pfet_01v8 L=0.15 W=4 nf=1 ad=1.16 as=1.16 pd=8.58 ps=8.58 mult=1 m=1
bd_cell1_r100_1100 d_cell1_r100_1100 0 v=v(rbl_cell1_r100_1100)-v(ref_cell1_r100_1100)
bdabs_cell1_r100_1100 dabs_cell1_r100_1100 0 v=abs(v(rbl_cell1_r100_1100)-v(ref_cell1_r100_1100))

* ---- instance 75: cell1_r100_1150 ----
spa_cell1_r100_1150 prea rbl_cell1_r100_1150 ctl 0 swpre
XMWR_cell1_r100_1150_0 sn_cell1_r100_1150_0 0 0 0 sky130_fd_pr__nfet_01v8 L=0.15 W=0.42 nf=1 ad=0.1974 as=0.1974 pd=1.78 ps=1.78 nrd=0.69047619047619  nrs=0.69047619047619 sa=0 sb=0 sd=0 mult=1 m=1
XMRD_cell1_r100_1150_0 rbl_cell1_r100_1150 sn_cell1_r100_1150_0 rwl_sel 0 sky130_fd_pr__nfet_01v8 L=0.15 W=0.42 nf=1 ad=0.1974 as=0.1974 pd=1.78 ps=1.78 nrd=0.69047619047619  nrs=0.69047619047619 sa=0 sb=0 sd=0 mult=1 m=1
csn_cell1_r100_1150_0 sn_cell1_r100_1150_0 0 {C_SN}
XMWR_cell1_r100_1150_1 sn_cell1_r100_1150_1 0 0 0 sky130_fd_pr__nfet_01v8 L=0.15 W=0.42 nf=1 ad=0.1974 as=0.1974 pd=1.78 ps=1.78 nrd=0.69047619047619  nrs=0.69047619047619 sa=0 sb=0 sd=0 mult=1 m=1
XMRD_cell1_r100_1150_1 rbl_cell1_r100_1150 sn_cell1_r100_1150_1 rwl_des 0 sky130_fd_pr__nfet_01v8 L=0.15 W=0.42 nf=1 ad=0.1974 as=0.1974 pd=1.78 ps=1.78 nrd=0.69047619047619  nrs=0.69047619047619 sa=0 sb=0 sd=0 mult=1 m=1
csn_cell1_r100_1150_1 sn_cell1_r100_1150_1 0 {C_SN}
XMWR_cell1_r100_1150_2 sn_cell1_r100_1150_2 0 0 0 sky130_fd_pr__nfet_01v8 L=0.15 W=0.42 nf=1 ad=0.1974 as=0.1974 pd=1.78 ps=1.78 nrd=0.69047619047619  nrs=0.69047619047619 sa=0 sb=0 sd=0 mult=1 m=1
XMRD_cell1_r100_1150_2 rbl_cell1_r100_1150 sn_cell1_r100_1150_2 rwl_des 0 sky130_fd_pr__nfet_01v8 L=0.15 W=0.42 nf=1 ad=0.1974 as=0.1974 pd=1.78 ps=1.78 nrd=0.69047619047619  nrs=0.69047619047619 sa=0 sb=0 sd=0 mult=1 m=1
csn_cell1_r100_1150_2 sn_cell1_r100_1150_2 0 {C_SN}
XMWR_cell1_r100_1150_3 sn_cell1_r100_1150_3 0 0 0 sky130_fd_pr__nfet_01v8 L=0.15 W=0.42 nf=1 ad=0.1974 as=0.1974 pd=1.78 ps=1.78 nrd=0.69047619047619  nrs=0.69047619047619 sa=0 sb=0 sd=0 mult=1 m=1
XMRD_cell1_r100_1150_3 rbl_cell1_r100_1150 sn_cell1_r100_1150_3 rwl_des 0 sky130_fd_pr__nfet_01v8 L=0.15 W=0.42 nf=1 ad=0.1974 as=0.1974 pd=1.78 ps=1.78 nrd=0.69047619047619  nrs=0.69047619047619 sa=0 sb=0 sd=0 mult=1 m=1
csn_cell1_r100_1150_3 sn_cell1_r100_1150_3 0 {C_SN}
crbl_cell1_r100_1150 rbl_cell1_r100_1150 0 {C_RBL}
spr_cell1_r100_1150 pref_100 ref_cell1_r100_1150 ctl 0 swpre
cref_cell1_r100_1150 ref_cell1_r100_1150 0 {C_RBL}   $ ASSUMPTION: ideal matched dummy load
XMN1_cell1_r100_1150 rbl_cell1_r100_1150 ref_cell1_r100_1150 vn_cell1_r100_1150 0 sky130_fd_pr__nfet_01v8 L=0.15 W=1 nf=1 ad=0.29 as=0.29 pd=2.58 ps=2.58 mult=1 m=1
XMN2_cell1_r100_1150 ref_cell1_r100_1150 rbl_cell1_r100_1150 vn_cell1_r100_1150 0 sky130_fd_pr__nfet_01v8 L=0.15 W=1 nf=1 ad=0.29 as=0.29 pd=2.58 ps=2.58 mult=1 m=1
XMP1_cell1_r100_1150 rbl_cell1_r100_1150 ref_cell1_r100_1150 vp_cell1_r100_1150 vdd sky130_fd_pr__pfet_01v8 L=0.15 W=2 nf=1 ad=0.58 as=0.58 pd=4.58 ps=4.58 mult=1 m=1
XMP2_cell1_r100_1150 ref_cell1_r100_1150 rbl_cell1_r100_1150 vp_cell1_r100_1150 vdd sky130_fd_pr__pfet_01v8 L=0.15 W=2 nf=1 ad=0.58 as=0.58 pd=4.58 ps=4.58 mult=1 m=1
XMNF_cell1_r100_1150 vn_cell1_r100_1150 en 0 0 sky130_fd_pr__nfet_01v8 L=0.15 W=2 nf=1 ad=0.58 as=0.58 pd=4.58 ps=4.58 mult=1 m=1
XMPH_cell1_r100_1150 vp_cell1_r100_1150 enb vdd vdd sky130_fd_pr__pfet_01v8 L=0.15 W=4 nf=1 ad=1.16 as=1.16 pd=8.58 ps=8.58 mult=1 m=1
bd_cell1_r100_1150 d_cell1_r100_1150 0 v=v(rbl_cell1_r100_1150)-v(ref_cell1_r100_1150)
bdabs_cell1_r100_1150 dabs_cell1_r100_1150 0 v=abs(v(rbl_cell1_r100_1150)-v(ref_cell1_r100_1150))

* ---- instance 76: cell1_r100_1200 ----
spa_cell1_r100_1200 prea rbl_cell1_r100_1200 ctl 0 swpre
XMWR_cell1_r100_1200_0 sn_cell1_r100_1200_0 0 0 0 sky130_fd_pr__nfet_01v8 L=0.15 W=0.42 nf=1 ad=0.1974 as=0.1974 pd=1.78 ps=1.78 nrd=0.69047619047619  nrs=0.69047619047619 sa=0 sb=0 sd=0 mult=1 m=1
XMRD_cell1_r100_1200_0 rbl_cell1_r100_1200 sn_cell1_r100_1200_0 rwl_sel 0 sky130_fd_pr__nfet_01v8 L=0.15 W=0.42 nf=1 ad=0.1974 as=0.1974 pd=1.78 ps=1.78 nrd=0.69047619047619  nrs=0.69047619047619 sa=0 sb=0 sd=0 mult=1 m=1
csn_cell1_r100_1200_0 sn_cell1_r100_1200_0 0 {C_SN}
XMWR_cell1_r100_1200_1 sn_cell1_r100_1200_1 0 0 0 sky130_fd_pr__nfet_01v8 L=0.15 W=0.42 nf=1 ad=0.1974 as=0.1974 pd=1.78 ps=1.78 nrd=0.69047619047619  nrs=0.69047619047619 sa=0 sb=0 sd=0 mult=1 m=1
XMRD_cell1_r100_1200_1 rbl_cell1_r100_1200 sn_cell1_r100_1200_1 rwl_des 0 sky130_fd_pr__nfet_01v8 L=0.15 W=0.42 nf=1 ad=0.1974 as=0.1974 pd=1.78 ps=1.78 nrd=0.69047619047619  nrs=0.69047619047619 sa=0 sb=0 sd=0 mult=1 m=1
csn_cell1_r100_1200_1 sn_cell1_r100_1200_1 0 {C_SN}
XMWR_cell1_r100_1200_2 sn_cell1_r100_1200_2 0 0 0 sky130_fd_pr__nfet_01v8 L=0.15 W=0.42 nf=1 ad=0.1974 as=0.1974 pd=1.78 ps=1.78 nrd=0.69047619047619  nrs=0.69047619047619 sa=0 sb=0 sd=0 mult=1 m=1
XMRD_cell1_r100_1200_2 rbl_cell1_r100_1200 sn_cell1_r100_1200_2 rwl_des 0 sky130_fd_pr__nfet_01v8 L=0.15 W=0.42 nf=1 ad=0.1974 as=0.1974 pd=1.78 ps=1.78 nrd=0.69047619047619  nrs=0.69047619047619 sa=0 sb=0 sd=0 mult=1 m=1
csn_cell1_r100_1200_2 sn_cell1_r100_1200_2 0 {C_SN}
XMWR_cell1_r100_1200_3 sn_cell1_r100_1200_3 0 0 0 sky130_fd_pr__nfet_01v8 L=0.15 W=0.42 nf=1 ad=0.1974 as=0.1974 pd=1.78 ps=1.78 nrd=0.69047619047619  nrs=0.69047619047619 sa=0 sb=0 sd=0 mult=1 m=1
XMRD_cell1_r100_1200_3 rbl_cell1_r100_1200 sn_cell1_r100_1200_3 rwl_des 0 sky130_fd_pr__nfet_01v8 L=0.15 W=0.42 nf=1 ad=0.1974 as=0.1974 pd=1.78 ps=1.78 nrd=0.69047619047619  nrs=0.69047619047619 sa=0 sb=0 sd=0 mult=1 m=1
csn_cell1_r100_1200_3 sn_cell1_r100_1200_3 0 {C_SN}
crbl_cell1_r100_1200 rbl_cell1_r100_1200 0 {C_RBL}
spr_cell1_r100_1200 pref_100 ref_cell1_r100_1200 ctl 0 swpre
cref_cell1_r100_1200 ref_cell1_r100_1200 0 {C_RBL}   $ ASSUMPTION: ideal matched dummy load
XMN1_cell1_r100_1200 rbl_cell1_r100_1200 ref_cell1_r100_1200 vn_cell1_r100_1200 0 sky130_fd_pr__nfet_01v8 L=0.15 W=1 nf=1 ad=0.29 as=0.29 pd=2.58 ps=2.58 mult=1 m=1
XMN2_cell1_r100_1200 ref_cell1_r100_1200 rbl_cell1_r100_1200 vn_cell1_r100_1200 0 sky130_fd_pr__nfet_01v8 L=0.15 W=1 nf=1 ad=0.29 as=0.29 pd=2.58 ps=2.58 mult=1 m=1
XMP1_cell1_r100_1200 rbl_cell1_r100_1200 ref_cell1_r100_1200 vp_cell1_r100_1200 vdd sky130_fd_pr__pfet_01v8 L=0.15 W=2 nf=1 ad=0.58 as=0.58 pd=4.58 ps=4.58 mult=1 m=1
XMP2_cell1_r100_1200 ref_cell1_r100_1200 rbl_cell1_r100_1200 vp_cell1_r100_1200 vdd sky130_fd_pr__pfet_01v8 L=0.15 W=2 nf=1 ad=0.58 as=0.58 pd=4.58 ps=4.58 mult=1 m=1
XMNF_cell1_r100_1200 vn_cell1_r100_1200 en 0 0 sky130_fd_pr__nfet_01v8 L=0.15 W=2 nf=1 ad=0.58 as=0.58 pd=4.58 ps=4.58 mult=1 m=1
XMPH_cell1_r100_1200 vp_cell1_r100_1200 enb vdd vdd sky130_fd_pr__pfet_01v8 L=0.15 W=4 nf=1 ad=1.16 as=1.16 pd=8.58 ps=8.58 mult=1 m=1
bd_cell1_r100_1200 d_cell1_r100_1200 0 v=v(rbl_cell1_r100_1200)-v(ref_cell1_r100_1200)
bdabs_cell1_r100_1200 dabs_cell1_r100_1200 0 v=abs(v(rbl_cell1_r100_1200)-v(ref_cell1_r100_1200))

* ---- instance 77: cell0_r200_n100 ----
spa_cell0_r200_n100 prea rbl_cell0_r200_n100 ctl 0 swpre
XMWR_cell0_r200_n100_0 sn_cell0_r200_n100_0 0 0 0 sky130_fd_pr__nfet_01v8 L=0.15 W=0.42 nf=1 ad=0.1974 as=0.1974 pd=1.78 ps=1.78 nrd=0.69047619047619  nrs=0.69047619047619 sa=0 sb=0 sd=0 mult=1 m=1
XMRD_cell0_r200_n100_0 rbl_cell0_r200_n100 sn_cell0_r200_n100_0 rwl_sel 0 sky130_fd_pr__nfet_01v8 L=0.15 W=0.42 nf=1 ad=0.1974 as=0.1974 pd=1.78 ps=1.78 nrd=0.69047619047619  nrs=0.69047619047619 sa=0 sb=0 sd=0 mult=1 m=1
csn_cell0_r200_n100_0 sn_cell0_r200_n100_0 0 {C_SN}
XMWR_cell0_r200_n100_1 sn_cell0_r200_n100_1 0 0 0 sky130_fd_pr__nfet_01v8 L=0.15 W=0.42 nf=1 ad=0.1974 as=0.1974 pd=1.78 ps=1.78 nrd=0.69047619047619  nrs=0.69047619047619 sa=0 sb=0 sd=0 mult=1 m=1
XMRD_cell0_r200_n100_1 rbl_cell0_r200_n100 sn_cell0_r200_n100_1 rwl_des 0 sky130_fd_pr__nfet_01v8 L=0.15 W=0.42 nf=1 ad=0.1974 as=0.1974 pd=1.78 ps=1.78 nrd=0.69047619047619  nrs=0.69047619047619 sa=0 sb=0 sd=0 mult=1 m=1
csn_cell0_r200_n100_1 sn_cell0_r200_n100_1 0 {C_SN}
XMWR_cell0_r200_n100_2 sn_cell0_r200_n100_2 0 0 0 sky130_fd_pr__nfet_01v8 L=0.15 W=0.42 nf=1 ad=0.1974 as=0.1974 pd=1.78 ps=1.78 nrd=0.69047619047619  nrs=0.69047619047619 sa=0 sb=0 sd=0 mult=1 m=1
XMRD_cell0_r200_n100_2 rbl_cell0_r200_n100 sn_cell0_r200_n100_2 rwl_des 0 sky130_fd_pr__nfet_01v8 L=0.15 W=0.42 nf=1 ad=0.1974 as=0.1974 pd=1.78 ps=1.78 nrd=0.69047619047619  nrs=0.69047619047619 sa=0 sb=0 sd=0 mult=1 m=1
csn_cell0_r200_n100_2 sn_cell0_r200_n100_2 0 {C_SN}
XMWR_cell0_r200_n100_3 sn_cell0_r200_n100_3 0 0 0 sky130_fd_pr__nfet_01v8 L=0.15 W=0.42 nf=1 ad=0.1974 as=0.1974 pd=1.78 ps=1.78 nrd=0.69047619047619  nrs=0.69047619047619 sa=0 sb=0 sd=0 mult=1 m=1
XMRD_cell0_r200_n100_3 rbl_cell0_r200_n100 sn_cell0_r200_n100_3 rwl_des 0 sky130_fd_pr__nfet_01v8 L=0.15 W=0.42 nf=1 ad=0.1974 as=0.1974 pd=1.78 ps=1.78 nrd=0.69047619047619  nrs=0.69047619047619 sa=0 sb=0 sd=0 mult=1 m=1
csn_cell0_r200_n100_3 sn_cell0_r200_n100_3 0 {C_SN}
crbl_cell0_r200_n100 rbl_cell0_r200_n100 0 {C_RBL}
spr_cell0_r200_n100 pref_200 ref_cell0_r200_n100 ctl 0 swpre
cref_cell0_r200_n100 ref_cell0_r200_n100 0 {C_RBL}   $ ASSUMPTION: ideal matched dummy load
XMN1_cell0_r200_n100 rbl_cell0_r200_n100 ref_cell0_r200_n100 vn_cell0_r200_n100 0 sky130_fd_pr__nfet_01v8 L=0.15 W=1 nf=1 ad=0.29 as=0.29 pd=2.58 ps=2.58 mult=1 m=1
XMN2_cell0_r200_n100 ref_cell0_r200_n100 rbl_cell0_r200_n100 vn_cell0_r200_n100 0 sky130_fd_pr__nfet_01v8 L=0.15 W=1 nf=1 ad=0.29 as=0.29 pd=2.58 ps=2.58 mult=1 m=1
XMP1_cell0_r200_n100 rbl_cell0_r200_n100 ref_cell0_r200_n100 vp_cell0_r200_n100 vdd sky130_fd_pr__pfet_01v8 L=0.15 W=2 nf=1 ad=0.58 as=0.58 pd=4.58 ps=4.58 mult=1 m=1
XMP2_cell0_r200_n100 ref_cell0_r200_n100 rbl_cell0_r200_n100 vp_cell0_r200_n100 vdd sky130_fd_pr__pfet_01v8 L=0.15 W=2 nf=1 ad=0.58 as=0.58 pd=4.58 ps=4.58 mult=1 m=1
XMNF_cell0_r200_n100 vn_cell0_r200_n100 en 0 0 sky130_fd_pr__nfet_01v8 L=0.15 W=2 nf=1 ad=0.58 as=0.58 pd=4.58 ps=4.58 mult=1 m=1
XMPH_cell0_r200_n100 vp_cell0_r200_n100 enb vdd vdd sky130_fd_pr__pfet_01v8 L=0.15 W=4 nf=1 ad=1.16 as=1.16 pd=8.58 ps=8.58 mult=1 m=1
bd_cell0_r200_n100 d_cell0_r200_n100 0 v=v(rbl_cell0_r200_n100)-v(ref_cell0_r200_n100)
bdabs_cell0_r200_n100 dabs_cell0_r200_n100 0 v=abs(v(rbl_cell0_r200_n100)-v(ref_cell0_r200_n100))

* ---- instance 78: cell0_r200_0000 ----
spa_cell0_r200_0000 prea rbl_cell0_r200_0000 ctl 0 swpre
XMWR_cell0_r200_0000_0 sn_cell0_r200_0000_0 0 0 0 sky130_fd_pr__nfet_01v8 L=0.15 W=0.42 nf=1 ad=0.1974 as=0.1974 pd=1.78 ps=1.78 nrd=0.69047619047619  nrs=0.69047619047619 sa=0 sb=0 sd=0 mult=1 m=1
XMRD_cell0_r200_0000_0 rbl_cell0_r200_0000 sn_cell0_r200_0000_0 rwl_sel 0 sky130_fd_pr__nfet_01v8 L=0.15 W=0.42 nf=1 ad=0.1974 as=0.1974 pd=1.78 ps=1.78 nrd=0.69047619047619  nrs=0.69047619047619 sa=0 sb=0 sd=0 mult=1 m=1
csn_cell0_r200_0000_0 sn_cell0_r200_0000_0 0 {C_SN}
XMWR_cell0_r200_0000_1 sn_cell0_r200_0000_1 0 0 0 sky130_fd_pr__nfet_01v8 L=0.15 W=0.42 nf=1 ad=0.1974 as=0.1974 pd=1.78 ps=1.78 nrd=0.69047619047619  nrs=0.69047619047619 sa=0 sb=0 sd=0 mult=1 m=1
XMRD_cell0_r200_0000_1 rbl_cell0_r200_0000 sn_cell0_r200_0000_1 rwl_des 0 sky130_fd_pr__nfet_01v8 L=0.15 W=0.42 nf=1 ad=0.1974 as=0.1974 pd=1.78 ps=1.78 nrd=0.69047619047619  nrs=0.69047619047619 sa=0 sb=0 sd=0 mult=1 m=1
csn_cell0_r200_0000_1 sn_cell0_r200_0000_1 0 {C_SN}
XMWR_cell0_r200_0000_2 sn_cell0_r200_0000_2 0 0 0 sky130_fd_pr__nfet_01v8 L=0.15 W=0.42 nf=1 ad=0.1974 as=0.1974 pd=1.78 ps=1.78 nrd=0.69047619047619  nrs=0.69047619047619 sa=0 sb=0 sd=0 mult=1 m=1
XMRD_cell0_r200_0000_2 rbl_cell0_r200_0000 sn_cell0_r200_0000_2 rwl_des 0 sky130_fd_pr__nfet_01v8 L=0.15 W=0.42 nf=1 ad=0.1974 as=0.1974 pd=1.78 ps=1.78 nrd=0.69047619047619  nrs=0.69047619047619 sa=0 sb=0 sd=0 mult=1 m=1
csn_cell0_r200_0000_2 sn_cell0_r200_0000_2 0 {C_SN}
XMWR_cell0_r200_0000_3 sn_cell0_r200_0000_3 0 0 0 sky130_fd_pr__nfet_01v8 L=0.15 W=0.42 nf=1 ad=0.1974 as=0.1974 pd=1.78 ps=1.78 nrd=0.69047619047619  nrs=0.69047619047619 sa=0 sb=0 sd=0 mult=1 m=1
XMRD_cell0_r200_0000_3 rbl_cell0_r200_0000 sn_cell0_r200_0000_3 rwl_des 0 sky130_fd_pr__nfet_01v8 L=0.15 W=0.42 nf=1 ad=0.1974 as=0.1974 pd=1.78 ps=1.78 nrd=0.69047619047619  nrs=0.69047619047619 sa=0 sb=0 sd=0 mult=1 m=1
csn_cell0_r200_0000_3 sn_cell0_r200_0000_3 0 {C_SN}
crbl_cell0_r200_0000 rbl_cell0_r200_0000 0 {C_RBL}
spr_cell0_r200_0000 pref_200 ref_cell0_r200_0000 ctl 0 swpre
cref_cell0_r200_0000 ref_cell0_r200_0000 0 {C_RBL}   $ ASSUMPTION: ideal matched dummy load
XMN1_cell0_r200_0000 rbl_cell0_r200_0000 ref_cell0_r200_0000 vn_cell0_r200_0000 0 sky130_fd_pr__nfet_01v8 L=0.15 W=1 nf=1 ad=0.29 as=0.29 pd=2.58 ps=2.58 mult=1 m=1
XMN2_cell0_r200_0000 ref_cell0_r200_0000 rbl_cell0_r200_0000 vn_cell0_r200_0000 0 sky130_fd_pr__nfet_01v8 L=0.15 W=1 nf=1 ad=0.29 as=0.29 pd=2.58 ps=2.58 mult=1 m=1
XMP1_cell0_r200_0000 rbl_cell0_r200_0000 ref_cell0_r200_0000 vp_cell0_r200_0000 vdd sky130_fd_pr__pfet_01v8 L=0.15 W=2 nf=1 ad=0.58 as=0.58 pd=4.58 ps=4.58 mult=1 m=1
XMP2_cell0_r200_0000 ref_cell0_r200_0000 rbl_cell0_r200_0000 vp_cell0_r200_0000 vdd sky130_fd_pr__pfet_01v8 L=0.15 W=2 nf=1 ad=0.58 as=0.58 pd=4.58 ps=4.58 mult=1 m=1
XMNF_cell0_r200_0000 vn_cell0_r200_0000 en 0 0 sky130_fd_pr__nfet_01v8 L=0.15 W=2 nf=1 ad=0.58 as=0.58 pd=4.58 ps=4.58 mult=1 m=1
XMPH_cell0_r200_0000 vp_cell0_r200_0000 enb vdd vdd sky130_fd_pr__pfet_01v8 L=0.15 W=4 nf=1 ad=1.16 as=1.16 pd=8.58 ps=8.58 mult=1 m=1
bd_cell0_r200_0000 d_cell0_r200_0000 0 v=v(rbl_cell0_r200_0000)-v(ref_cell0_r200_0000)
bdabs_cell0_r200_0000 dabs_cell0_r200_0000 0 v=abs(v(rbl_cell0_r200_0000)-v(ref_cell0_r200_0000))

* ---- instance 79: cell1_r200_0300 ----
spa_cell1_r200_0300 prea rbl_cell1_r200_0300 ctl 0 swpre
XMWR_cell1_r200_0300_0 sn_cell1_r200_0300_0 0 0 0 sky130_fd_pr__nfet_01v8 L=0.15 W=0.42 nf=1 ad=0.1974 as=0.1974 pd=1.78 ps=1.78 nrd=0.69047619047619  nrs=0.69047619047619 sa=0 sb=0 sd=0 mult=1 m=1
XMRD_cell1_r200_0300_0 rbl_cell1_r200_0300 sn_cell1_r200_0300_0 rwl_sel 0 sky130_fd_pr__nfet_01v8 L=0.15 W=0.42 nf=1 ad=0.1974 as=0.1974 pd=1.78 ps=1.78 nrd=0.69047619047619  nrs=0.69047619047619 sa=0 sb=0 sd=0 mult=1 m=1
csn_cell1_r200_0300_0 sn_cell1_r200_0300_0 0 {C_SN}
XMWR_cell1_r200_0300_1 sn_cell1_r200_0300_1 0 0 0 sky130_fd_pr__nfet_01v8 L=0.15 W=0.42 nf=1 ad=0.1974 as=0.1974 pd=1.78 ps=1.78 nrd=0.69047619047619  nrs=0.69047619047619 sa=0 sb=0 sd=0 mult=1 m=1
XMRD_cell1_r200_0300_1 rbl_cell1_r200_0300 sn_cell1_r200_0300_1 rwl_des 0 sky130_fd_pr__nfet_01v8 L=0.15 W=0.42 nf=1 ad=0.1974 as=0.1974 pd=1.78 ps=1.78 nrd=0.69047619047619  nrs=0.69047619047619 sa=0 sb=0 sd=0 mult=1 m=1
csn_cell1_r200_0300_1 sn_cell1_r200_0300_1 0 {C_SN}
XMWR_cell1_r200_0300_2 sn_cell1_r200_0300_2 0 0 0 sky130_fd_pr__nfet_01v8 L=0.15 W=0.42 nf=1 ad=0.1974 as=0.1974 pd=1.78 ps=1.78 nrd=0.69047619047619  nrs=0.69047619047619 sa=0 sb=0 sd=0 mult=1 m=1
XMRD_cell1_r200_0300_2 rbl_cell1_r200_0300 sn_cell1_r200_0300_2 rwl_des 0 sky130_fd_pr__nfet_01v8 L=0.15 W=0.42 nf=1 ad=0.1974 as=0.1974 pd=1.78 ps=1.78 nrd=0.69047619047619  nrs=0.69047619047619 sa=0 sb=0 sd=0 mult=1 m=1
csn_cell1_r200_0300_2 sn_cell1_r200_0300_2 0 {C_SN}
XMWR_cell1_r200_0300_3 sn_cell1_r200_0300_3 0 0 0 sky130_fd_pr__nfet_01v8 L=0.15 W=0.42 nf=1 ad=0.1974 as=0.1974 pd=1.78 ps=1.78 nrd=0.69047619047619  nrs=0.69047619047619 sa=0 sb=0 sd=0 mult=1 m=1
XMRD_cell1_r200_0300_3 rbl_cell1_r200_0300 sn_cell1_r200_0300_3 rwl_des 0 sky130_fd_pr__nfet_01v8 L=0.15 W=0.42 nf=1 ad=0.1974 as=0.1974 pd=1.78 ps=1.78 nrd=0.69047619047619  nrs=0.69047619047619 sa=0 sb=0 sd=0 mult=1 m=1
csn_cell1_r200_0300_3 sn_cell1_r200_0300_3 0 {C_SN}
crbl_cell1_r200_0300 rbl_cell1_r200_0300 0 {C_RBL}
spr_cell1_r200_0300 pref_200 ref_cell1_r200_0300 ctl 0 swpre
cref_cell1_r200_0300 ref_cell1_r200_0300 0 {C_RBL}   $ ASSUMPTION: ideal matched dummy load
XMN1_cell1_r200_0300 rbl_cell1_r200_0300 ref_cell1_r200_0300 vn_cell1_r200_0300 0 sky130_fd_pr__nfet_01v8 L=0.15 W=1 nf=1 ad=0.29 as=0.29 pd=2.58 ps=2.58 mult=1 m=1
XMN2_cell1_r200_0300 ref_cell1_r200_0300 rbl_cell1_r200_0300 vn_cell1_r200_0300 0 sky130_fd_pr__nfet_01v8 L=0.15 W=1 nf=1 ad=0.29 as=0.29 pd=2.58 ps=2.58 mult=1 m=1
XMP1_cell1_r200_0300 rbl_cell1_r200_0300 ref_cell1_r200_0300 vp_cell1_r200_0300 vdd sky130_fd_pr__pfet_01v8 L=0.15 W=2 nf=1 ad=0.58 as=0.58 pd=4.58 ps=4.58 mult=1 m=1
XMP2_cell1_r200_0300 ref_cell1_r200_0300 rbl_cell1_r200_0300 vp_cell1_r200_0300 vdd sky130_fd_pr__pfet_01v8 L=0.15 W=2 nf=1 ad=0.58 as=0.58 pd=4.58 ps=4.58 mult=1 m=1
XMNF_cell1_r200_0300 vn_cell1_r200_0300 en 0 0 sky130_fd_pr__nfet_01v8 L=0.15 W=2 nf=1 ad=0.58 as=0.58 pd=4.58 ps=4.58 mult=1 m=1
XMPH_cell1_r200_0300 vp_cell1_r200_0300 enb vdd vdd sky130_fd_pr__pfet_01v8 L=0.15 W=4 nf=1 ad=1.16 as=1.16 pd=8.58 ps=8.58 mult=1 m=1
bd_cell1_r200_0300 d_cell1_r200_0300 0 v=v(rbl_cell1_r200_0300)-v(ref_cell1_r200_0300)
bdabs_cell1_r200_0300 dabs_cell1_r200_0300 0 v=abs(v(rbl_cell1_r200_0300)-v(ref_cell1_r200_0300))

* ---- instance 80: cell1_r200_0350 ----
spa_cell1_r200_0350 prea rbl_cell1_r200_0350 ctl 0 swpre
XMWR_cell1_r200_0350_0 sn_cell1_r200_0350_0 0 0 0 sky130_fd_pr__nfet_01v8 L=0.15 W=0.42 nf=1 ad=0.1974 as=0.1974 pd=1.78 ps=1.78 nrd=0.69047619047619  nrs=0.69047619047619 sa=0 sb=0 sd=0 mult=1 m=1
XMRD_cell1_r200_0350_0 rbl_cell1_r200_0350 sn_cell1_r200_0350_0 rwl_sel 0 sky130_fd_pr__nfet_01v8 L=0.15 W=0.42 nf=1 ad=0.1974 as=0.1974 pd=1.78 ps=1.78 nrd=0.69047619047619  nrs=0.69047619047619 sa=0 sb=0 sd=0 mult=1 m=1
csn_cell1_r200_0350_0 sn_cell1_r200_0350_0 0 {C_SN}
XMWR_cell1_r200_0350_1 sn_cell1_r200_0350_1 0 0 0 sky130_fd_pr__nfet_01v8 L=0.15 W=0.42 nf=1 ad=0.1974 as=0.1974 pd=1.78 ps=1.78 nrd=0.69047619047619  nrs=0.69047619047619 sa=0 sb=0 sd=0 mult=1 m=1
XMRD_cell1_r200_0350_1 rbl_cell1_r200_0350 sn_cell1_r200_0350_1 rwl_des 0 sky130_fd_pr__nfet_01v8 L=0.15 W=0.42 nf=1 ad=0.1974 as=0.1974 pd=1.78 ps=1.78 nrd=0.69047619047619  nrs=0.69047619047619 sa=0 sb=0 sd=0 mult=1 m=1
csn_cell1_r200_0350_1 sn_cell1_r200_0350_1 0 {C_SN}
XMWR_cell1_r200_0350_2 sn_cell1_r200_0350_2 0 0 0 sky130_fd_pr__nfet_01v8 L=0.15 W=0.42 nf=1 ad=0.1974 as=0.1974 pd=1.78 ps=1.78 nrd=0.69047619047619  nrs=0.69047619047619 sa=0 sb=0 sd=0 mult=1 m=1
XMRD_cell1_r200_0350_2 rbl_cell1_r200_0350 sn_cell1_r200_0350_2 rwl_des 0 sky130_fd_pr__nfet_01v8 L=0.15 W=0.42 nf=1 ad=0.1974 as=0.1974 pd=1.78 ps=1.78 nrd=0.69047619047619  nrs=0.69047619047619 sa=0 sb=0 sd=0 mult=1 m=1
csn_cell1_r200_0350_2 sn_cell1_r200_0350_2 0 {C_SN}
XMWR_cell1_r200_0350_3 sn_cell1_r200_0350_3 0 0 0 sky130_fd_pr__nfet_01v8 L=0.15 W=0.42 nf=1 ad=0.1974 as=0.1974 pd=1.78 ps=1.78 nrd=0.69047619047619  nrs=0.69047619047619 sa=0 sb=0 sd=0 mult=1 m=1
XMRD_cell1_r200_0350_3 rbl_cell1_r200_0350 sn_cell1_r200_0350_3 rwl_des 0 sky130_fd_pr__nfet_01v8 L=0.15 W=0.42 nf=1 ad=0.1974 as=0.1974 pd=1.78 ps=1.78 nrd=0.69047619047619  nrs=0.69047619047619 sa=0 sb=0 sd=0 mult=1 m=1
csn_cell1_r200_0350_3 sn_cell1_r200_0350_3 0 {C_SN}
crbl_cell1_r200_0350 rbl_cell1_r200_0350 0 {C_RBL}
spr_cell1_r200_0350 pref_200 ref_cell1_r200_0350 ctl 0 swpre
cref_cell1_r200_0350 ref_cell1_r200_0350 0 {C_RBL}   $ ASSUMPTION: ideal matched dummy load
XMN1_cell1_r200_0350 rbl_cell1_r200_0350 ref_cell1_r200_0350 vn_cell1_r200_0350 0 sky130_fd_pr__nfet_01v8 L=0.15 W=1 nf=1 ad=0.29 as=0.29 pd=2.58 ps=2.58 mult=1 m=1
XMN2_cell1_r200_0350 ref_cell1_r200_0350 rbl_cell1_r200_0350 vn_cell1_r200_0350 0 sky130_fd_pr__nfet_01v8 L=0.15 W=1 nf=1 ad=0.29 as=0.29 pd=2.58 ps=2.58 mult=1 m=1
XMP1_cell1_r200_0350 rbl_cell1_r200_0350 ref_cell1_r200_0350 vp_cell1_r200_0350 vdd sky130_fd_pr__pfet_01v8 L=0.15 W=2 nf=1 ad=0.58 as=0.58 pd=4.58 ps=4.58 mult=1 m=1
XMP2_cell1_r200_0350 ref_cell1_r200_0350 rbl_cell1_r200_0350 vp_cell1_r200_0350 vdd sky130_fd_pr__pfet_01v8 L=0.15 W=2 nf=1 ad=0.58 as=0.58 pd=4.58 ps=4.58 mult=1 m=1
XMNF_cell1_r200_0350 vn_cell1_r200_0350 en 0 0 sky130_fd_pr__nfet_01v8 L=0.15 W=2 nf=1 ad=0.58 as=0.58 pd=4.58 ps=4.58 mult=1 m=1
XMPH_cell1_r200_0350 vp_cell1_r200_0350 enb vdd vdd sky130_fd_pr__pfet_01v8 L=0.15 W=4 nf=1 ad=1.16 as=1.16 pd=8.58 ps=8.58 mult=1 m=1
bd_cell1_r200_0350 d_cell1_r200_0350 0 v=v(rbl_cell1_r200_0350)-v(ref_cell1_r200_0350)
bdabs_cell1_r200_0350 dabs_cell1_r200_0350 0 v=abs(v(rbl_cell1_r200_0350)-v(ref_cell1_r200_0350))

* ---- instance 81: cell1_r200_0400 ----
spa_cell1_r200_0400 prea rbl_cell1_r200_0400 ctl 0 swpre
XMWR_cell1_r200_0400_0 sn_cell1_r200_0400_0 0 0 0 sky130_fd_pr__nfet_01v8 L=0.15 W=0.42 nf=1 ad=0.1974 as=0.1974 pd=1.78 ps=1.78 nrd=0.69047619047619  nrs=0.69047619047619 sa=0 sb=0 sd=0 mult=1 m=1
XMRD_cell1_r200_0400_0 rbl_cell1_r200_0400 sn_cell1_r200_0400_0 rwl_sel 0 sky130_fd_pr__nfet_01v8 L=0.15 W=0.42 nf=1 ad=0.1974 as=0.1974 pd=1.78 ps=1.78 nrd=0.69047619047619  nrs=0.69047619047619 sa=0 sb=0 sd=0 mult=1 m=1
csn_cell1_r200_0400_0 sn_cell1_r200_0400_0 0 {C_SN}
XMWR_cell1_r200_0400_1 sn_cell1_r200_0400_1 0 0 0 sky130_fd_pr__nfet_01v8 L=0.15 W=0.42 nf=1 ad=0.1974 as=0.1974 pd=1.78 ps=1.78 nrd=0.69047619047619  nrs=0.69047619047619 sa=0 sb=0 sd=0 mult=1 m=1
XMRD_cell1_r200_0400_1 rbl_cell1_r200_0400 sn_cell1_r200_0400_1 rwl_des 0 sky130_fd_pr__nfet_01v8 L=0.15 W=0.42 nf=1 ad=0.1974 as=0.1974 pd=1.78 ps=1.78 nrd=0.69047619047619  nrs=0.69047619047619 sa=0 sb=0 sd=0 mult=1 m=1
csn_cell1_r200_0400_1 sn_cell1_r200_0400_1 0 {C_SN}
XMWR_cell1_r200_0400_2 sn_cell1_r200_0400_2 0 0 0 sky130_fd_pr__nfet_01v8 L=0.15 W=0.42 nf=1 ad=0.1974 as=0.1974 pd=1.78 ps=1.78 nrd=0.69047619047619  nrs=0.69047619047619 sa=0 sb=0 sd=0 mult=1 m=1
XMRD_cell1_r200_0400_2 rbl_cell1_r200_0400 sn_cell1_r200_0400_2 rwl_des 0 sky130_fd_pr__nfet_01v8 L=0.15 W=0.42 nf=1 ad=0.1974 as=0.1974 pd=1.78 ps=1.78 nrd=0.69047619047619  nrs=0.69047619047619 sa=0 sb=0 sd=0 mult=1 m=1
csn_cell1_r200_0400_2 sn_cell1_r200_0400_2 0 {C_SN}
XMWR_cell1_r200_0400_3 sn_cell1_r200_0400_3 0 0 0 sky130_fd_pr__nfet_01v8 L=0.15 W=0.42 nf=1 ad=0.1974 as=0.1974 pd=1.78 ps=1.78 nrd=0.69047619047619  nrs=0.69047619047619 sa=0 sb=0 sd=0 mult=1 m=1
XMRD_cell1_r200_0400_3 rbl_cell1_r200_0400 sn_cell1_r200_0400_3 rwl_des 0 sky130_fd_pr__nfet_01v8 L=0.15 W=0.42 nf=1 ad=0.1974 as=0.1974 pd=1.78 ps=1.78 nrd=0.69047619047619  nrs=0.69047619047619 sa=0 sb=0 sd=0 mult=1 m=1
csn_cell1_r200_0400_3 sn_cell1_r200_0400_3 0 {C_SN}
crbl_cell1_r200_0400 rbl_cell1_r200_0400 0 {C_RBL}
spr_cell1_r200_0400 pref_200 ref_cell1_r200_0400 ctl 0 swpre
cref_cell1_r200_0400 ref_cell1_r200_0400 0 {C_RBL}   $ ASSUMPTION: ideal matched dummy load
XMN1_cell1_r200_0400 rbl_cell1_r200_0400 ref_cell1_r200_0400 vn_cell1_r200_0400 0 sky130_fd_pr__nfet_01v8 L=0.15 W=1 nf=1 ad=0.29 as=0.29 pd=2.58 ps=2.58 mult=1 m=1
XMN2_cell1_r200_0400 ref_cell1_r200_0400 rbl_cell1_r200_0400 vn_cell1_r200_0400 0 sky130_fd_pr__nfet_01v8 L=0.15 W=1 nf=1 ad=0.29 as=0.29 pd=2.58 ps=2.58 mult=1 m=1
XMP1_cell1_r200_0400 rbl_cell1_r200_0400 ref_cell1_r200_0400 vp_cell1_r200_0400 vdd sky130_fd_pr__pfet_01v8 L=0.15 W=2 nf=1 ad=0.58 as=0.58 pd=4.58 ps=4.58 mult=1 m=1
XMP2_cell1_r200_0400 ref_cell1_r200_0400 rbl_cell1_r200_0400 vp_cell1_r200_0400 vdd sky130_fd_pr__pfet_01v8 L=0.15 W=2 nf=1 ad=0.58 as=0.58 pd=4.58 ps=4.58 mult=1 m=1
XMNF_cell1_r200_0400 vn_cell1_r200_0400 en 0 0 sky130_fd_pr__nfet_01v8 L=0.15 W=2 nf=1 ad=0.58 as=0.58 pd=4.58 ps=4.58 mult=1 m=1
XMPH_cell1_r200_0400 vp_cell1_r200_0400 enb vdd vdd sky130_fd_pr__pfet_01v8 L=0.15 W=4 nf=1 ad=1.16 as=1.16 pd=8.58 ps=8.58 mult=1 m=1
bd_cell1_r200_0400 d_cell1_r200_0400 0 v=v(rbl_cell1_r200_0400)-v(ref_cell1_r200_0400)
bdabs_cell1_r200_0400 dabs_cell1_r200_0400 0 v=abs(v(rbl_cell1_r200_0400)-v(ref_cell1_r200_0400))

* ---- instance 82: cell1_r200_0450 ----
spa_cell1_r200_0450 prea rbl_cell1_r200_0450 ctl 0 swpre
XMWR_cell1_r200_0450_0 sn_cell1_r200_0450_0 0 0 0 sky130_fd_pr__nfet_01v8 L=0.15 W=0.42 nf=1 ad=0.1974 as=0.1974 pd=1.78 ps=1.78 nrd=0.69047619047619  nrs=0.69047619047619 sa=0 sb=0 sd=0 mult=1 m=1
XMRD_cell1_r200_0450_0 rbl_cell1_r200_0450 sn_cell1_r200_0450_0 rwl_sel 0 sky130_fd_pr__nfet_01v8 L=0.15 W=0.42 nf=1 ad=0.1974 as=0.1974 pd=1.78 ps=1.78 nrd=0.69047619047619  nrs=0.69047619047619 sa=0 sb=0 sd=0 mult=1 m=1
csn_cell1_r200_0450_0 sn_cell1_r200_0450_0 0 {C_SN}
XMWR_cell1_r200_0450_1 sn_cell1_r200_0450_1 0 0 0 sky130_fd_pr__nfet_01v8 L=0.15 W=0.42 nf=1 ad=0.1974 as=0.1974 pd=1.78 ps=1.78 nrd=0.69047619047619  nrs=0.69047619047619 sa=0 sb=0 sd=0 mult=1 m=1
XMRD_cell1_r200_0450_1 rbl_cell1_r200_0450 sn_cell1_r200_0450_1 rwl_des 0 sky130_fd_pr__nfet_01v8 L=0.15 W=0.42 nf=1 ad=0.1974 as=0.1974 pd=1.78 ps=1.78 nrd=0.69047619047619  nrs=0.69047619047619 sa=0 sb=0 sd=0 mult=1 m=1
csn_cell1_r200_0450_1 sn_cell1_r200_0450_1 0 {C_SN}
XMWR_cell1_r200_0450_2 sn_cell1_r200_0450_2 0 0 0 sky130_fd_pr__nfet_01v8 L=0.15 W=0.42 nf=1 ad=0.1974 as=0.1974 pd=1.78 ps=1.78 nrd=0.69047619047619  nrs=0.69047619047619 sa=0 sb=0 sd=0 mult=1 m=1
XMRD_cell1_r200_0450_2 rbl_cell1_r200_0450 sn_cell1_r200_0450_2 rwl_des 0 sky130_fd_pr__nfet_01v8 L=0.15 W=0.42 nf=1 ad=0.1974 as=0.1974 pd=1.78 ps=1.78 nrd=0.69047619047619  nrs=0.69047619047619 sa=0 sb=0 sd=0 mult=1 m=1
csn_cell1_r200_0450_2 sn_cell1_r200_0450_2 0 {C_SN}
XMWR_cell1_r200_0450_3 sn_cell1_r200_0450_3 0 0 0 sky130_fd_pr__nfet_01v8 L=0.15 W=0.42 nf=1 ad=0.1974 as=0.1974 pd=1.78 ps=1.78 nrd=0.69047619047619  nrs=0.69047619047619 sa=0 sb=0 sd=0 mult=1 m=1
XMRD_cell1_r200_0450_3 rbl_cell1_r200_0450 sn_cell1_r200_0450_3 rwl_des 0 sky130_fd_pr__nfet_01v8 L=0.15 W=0.42 nf=1 ad=0.1974 as=0.1974 pd=1.78 ps=1.78 nrd=0.69047619047619  nrs=0.69047619047619 sa=0 sb=0 sd=0 mult=1 m=1
csn_cell1_r200_0450_3 sn_cell1_r200_0450_3 0 {C_SN}
crbl_cell1_r200_0450 rbl_cell1_r200_0450 0 {C_RBL}
spr_cell1_r200_0450 pref_200 ref_cell1_r200_0450 ctl 0 swpre
cref_cell1_r200_0450 ref_cell1_r200_0450 0 {C_RBL}   $ ASSUMPTION: ideal matched dummy load
XMN1_cell1_r200_0450 rbl_cell1_r200_0450 ref_cell1_r200_0450 vn_cell1_r200_0450 0 sky130_fd_pr__nfet_01v8 L=0.15 W=1 nf=1 ad=0.29 as=0.29 pd=2.58 ps=2.58 mult=1 m=1
XMN2_cell1_r200_0450 ref_cell1_r200_0450 rbl_cell1_r200_0450 vn_cell1_r200_0450 0 sky130_fd_pr__nfet_01v8 L=0.15 W=1 nf=1 ad=0.29 as=0.29 pd=2.58 ps=2.58 mult=1 m=1
XMP1_cell1_r200_0450 rbl_cell1_r200_0450 ref_cell1_r200_0450 vp_cell1_r200_0450 vdd sky130_fd_pr__pfet_01v8 L=0.15 W=2 nf=1 ad=0.58 as=0.58 pd=4.58 ps=4.58 mult=1 m=1
XMP2_cell1_r200_0450 ref_cell1_r200_0450 rbl_cell1_r200_0450 vp_cell1_r200_0450 vdd sky130_fd_pr__pfet_01v8 L=0.15 W=2 nf=1 ad=0.58 as=0.58 pd=4.58 ps=4.58 mult=1 m=1
XMNF_cell1_r200_0450 vn_cell1_r200_0450 en 0 0 sky130_fd_pr__nfet_01v8 L=0.15 W=2 nf=1 ad=0.58 as=0.58 pd=4.58 ps=4.58 mult=1 m=1
XMPH_cell1_r200_0450 vp_cell1_r200_0450 enb vdd vdd sky130_fd_pr__pfet_01v8 L=0.15 W=4 nf=1 ad=1.16 as=1.16 pd=8.58 ps=8.58 mult=1 m=1
bd_cell1_r200_0450 d_cell1_r200_0450 0 v=v(rbl_cell1_r200_0450)-v(ref_cell1_r200_0450)
bdabs_cell1_r200_0450 dabs_cell1_r200_0450 0 v=abs(v(rbl_cell1_r200_0450)-v(ref_cell1_r200_0450))

* ---- instance 83: cell1_r200_0500 ----
spa_cell1_r200_0500 prea rbl_cell1_r200_0500 ctl 0 swpre
XMWR_cell1_r200_0500_0 sn_cell1_r200_0500_0 0 0 0 sky130_fd_pr__nfet_01v8 L=0.15 W=0.42 nf=1 ad=0.1974 as=0.1974 pd=1.78 ps=1.78 nrd=0.69047619047619  nrs=0.69047619047619 sa=0 sb=0 sd=0 mult=1 m=1
XMRD_cell1_r200_0500_0 rbl_cell1_r200_0500 sn_cell1_r200_0500_0 rwl_sel 0 sky130_fd_pr__nfet_01v8 L=0.15 W=0.42 nf=1 ad=0.1974 as=0.1974 pd=1.78 ps=1.78 nrd=0.69047619047619  nrs=0.69047619047619 sa=0 sb=0 sd=0 mult=1 m=1
csn_cell1_r200_0500_0 sn_cell1_r200_0500_0 0 {C_SN}
XMWR_cell1_r200_0500_1 sn_cell1_r200_0500_1 0 0 0 sky130_fd_pr__nfet_01v8 L=0.15 W=0.42 nf=1 ad=0.1974 as=0.1974 pd=1.78 ps=1.78 nrd=0.69047619047619  nrs=0.69047619047619 sa=0 sb=0 sd=0 mult=1 m=1
XMRD_cell1_r200_0500_1 rbl_cell1_r200_0500 sn_cell1_r200_0500_1 rwl_des 0 sky130_fd_pr__nfet_01v8 L=0.15 W=0.42 nf=1 ad=0.1974 as=0.1974 pd=1.78 ps=1.78 nrd=0.69047619047619  nrs=0.69047619047619 sa=0 sb=0 sd=0 mult=1 m=1
csn_cell1_r200_0500_1 sn_cell1_r200_0500_1 0 {C_SN}
XMWR_cell1_r200_0500_2 sn_cell1_r200_0500_2 0 0 0 sky130_fd_pr__nfet_01v8 L=0.15 W=0.42 nf=1 ad=0.1974 as=0.1974 pd=1.78 ps=1.78 nrd=0.69047619047619  nrs=0.69047619047619 sa=0 sb=0 sd=0 mult=1 m=1
XMRD_cell1_r200_0500_2 rbl_cell1_r200_0500 sn_cell1_r200_0500_2 rwl_des 0 sky130_fd_pr__nfet_01v8 L=0.15 W=0.42 nf=1 ad=0.1974 as=0.1974 pd=1.78 ps=1.78 nrd=0.69047619047619  nrs=0.69047619047619 sa=0 sb=0 sd=0 mult=1 m=1
csn_cell1_r200_0500_2 sn_cell1_r200_0500_2 0 {C_SN}
XMWR_cell1_r200_0500_3 sn_cell1_r200_0500_3 0 0 0 sky130_fd_pr__nfet_01v8 L=0.15 W=0.42 nf=1 ad=0.1974 as=0.1974 pd=1.78 ps=1.78 nrd=0.69047619047619  nrs=0.69047619047619 sa=0 sb=0 sd=0 mult=1 m=1
XMRD_cell1_r200_0500_3 rbl_cell1_r200_0500 sn_cell1_r200_0500_3 rwl_des 0 sky130_fd_pr__nfet_01v8 L=0.15 W=0.42 nf=1 ad=0.1974 as=0.1974 pd=1.78 ps=1.78 nrd=0.69047619047619  nrs=0.69047619047619 sa=0 sb=0 sd=0 mult=1 m=1
csn_cell1_r200_0500_3 sn_cell1_r200_0500_3 0 {C_SN}
crbl_cell1_r200_0500 rbl_cell1_r200_0500 0 {C_RBL}
spr_cell1_r200_0500 pref_200 ref_cell1_r200_0500 ctl 0 swpre
cref_cell1_r200_0500 ref_cell1_r200_0500 0 {C_RBL}   $ ASSUMPTION: ideal matched dummy load
XMN1_cell1_r200_0500 rbl_cell1_r200_0500 ref_cell1_r200_0500 vn_cell1_r200_0500 0 sky130_fd_pr__nfet_01v8 L=0.15 W=1 nf=1 ad=0.29 as=0.29 pd=2.58 ps=2.58 mult=1 m=1
XMN2_cell1_r200_0500 ref_cell1_r200_0500 rbl_cell1_r200_0500 vn_cell1_r200_0500 0 sky130_fd_pr__nfet_01v8 L=0.15 W=1 nf=1 ad=0.29 as=0.29 pd=2.58 ps=2.58 mult=1 m=1
XMP1_cell1_r200_0500 rbl_cell1_r200_0500 ref_cell1_r200_0500 vp_cell1_r200_0500 vdd sky130_fd_pr__pfet_01v8 L=0.15 W=2 nf=1 ad=0.58 as=0.58 pd=4.58 ps=4.58 mult=1 m=1
XMP2_cell1_r200_0500 ref_cell1_r200_0500 rbl_cell1_r200_0500 vp_cell1_r200_0500 vdd sky130_fd_pr__pfet_01v8 L=0.15 W=2 nf=1 ad=0.58 as=0.58 pd=4.58 ps=4.58 mult=1 m=1
XMNF_cell1_r200_0500 vn_cell1_r200_0500 en 0 0 sky130_fd_pr__nfet_01v8 L=0.15 W=2 nf=1 ad=0.58 as=0.58 pd=4.58 ps=4.58 mult=1 m=1
XMPH_cell1_r200_0500 vp_cell1_r200_0500 enb vdd vdd sky130_fd_pr__pfet_01v8 L=0.15 W=4 nf=1 ad=1.16 as=1.16 pd=8.58 ps=8.58 mult=1 m=1
bd_cell1_r200_0500 d_cell1_r200_0500 0 v=v(rbl_cell1_r200_0500)-v(ref_cell1_r200_0500)
bdabs_cell1_r200_0500 dabs_cell1_r200_0500 0 v=abs(v(rbl_cell1_r200_0500)-v(ref_cell1_r200_0500))

* ---- instance 84: cell1_r200_0550 ----
spa_cell1_r200_0550 prea rbl_cell1_r200_0550 ctl 0 swpre
XMWR_cell1_r200_0550_0 sn_cell1_r200_0550_0 0 0 0 sky130_fd_pr__nfet_01v8 L=0.15 W=0.42 nf=1 ad=0.1974 as=0.1974 pd=1.78 ps=1.78 nrd=0.69047619047619  nrs=0.69047619047619 sa=0 sb=0 sd=0 mult=1 m=1
XMRD_cell1_r200_0550_0 rbl_cell1_r200_0550 sn_cell1_r200_0550_0 rwl_sel 0 sky130_fd_pr__nfet_01v8 L=0.15 W=0.42 nf=1 ad=0.1974 as=0.1974 pd=1.78 ps=1.78 nrd=0.69047619047619  nrs=0.69047619047619 sa=0 sb=0 sd=0 mult=1 m=1
csn_cell1_r200_0550_0 sn_cell1_r200_0550_0 0 {C_SN}
XMWR_cell1_r200_0550_1 sn_cell1_r200_0550_1 0 0 0 sky130_fd_pr__nfet_01v8 L=0.15 W=0.42 nf=1 ad=0.1974 as=0.1974 pd=1.78 ps=1.78 nrd=0.69047619047619  nrs=0.69047619047619 sa=0 sb=0 sd=0 mult=1 m=1
XMRD_cell1_r200_0550_1 rbl_cell1_r200_0550 sn_cell1_r200_0550_1 rwl_des 0 sky130_fd_pr__nfet_01v8 L=0.15 W=0.42 nf=1 ad=0.1974 as=0.1974 pd=1.78 ps=1.78 nrd=0.69047619047619  nrs=0.69047619047619 sa=0 sb=0 sd=0 mult=1 m=1
csn_cell1_r200_0550_1 sn_cell1_r200_0550_1 0 {C_SN}
XMWR_cell1_r200_0550_2 sn_cell1_r200_0550_2 0 0 0 sky130_fd_pr__nfet_01v8 L=0.15 W=0.42 nf=1 ad=0.1974 as=0.1974 pd=1.78 ps=1.78 nrd=0.69047619047619  nrs=0.69047619047619 sa=0 sb=0 sd=0 mult=1 m=1
XMRD_cell1_r200_0550_2 rbl_cell1_r200_0550 sn_cell1_r200_0550_2 rwl_des 0 sky130_fd_pr__nfet_01v8 L=0.15 W=0.42 nf=1 ad=0.1974 as=0.1974 pd=1.78 ps=1.78 nrd=0.69047619047619  nrs=0.69047619047619 sa=0 sb=0 sd=0 mult=1 m=1
csn_cell1_r200_0550_2 sn_cell1_r200_0550_2 0 {C_SN}
XMWR_cell1_r200_0550_3 sn_cell1_r200_0550_3 0 0 0 sky130_fd_pr__nfet_01v8 L=0.15 W=0.42 nf=1 ad=0.1974 as=0.1974 pd=1.78 ps=1.78 nrd=0.69047619047619  nrs=0.69047619047619 sa=0 sb=0 sd=0 mult=1 m=1
XMRD_cell1_r200_0550_3 rbl_cell1_r200_0550 sn_cell1_r200_0550_3 rwl_des 0 sky130_fd_pr__nfet_01v8 L=0.15 W=0.42 nf=1 ad=0.1974 as=0.1974 pd=1.78 ps=1.78 nrd=0.69047619047619  nrs=0.69047619047619 sa=0 sb=0 sd=0 mult=1 m=1
csn_cell1_r200_0550_3 sn_cell1_r200_0550_3 0 {C_SN}
crbl_cell1_r200_0550 rbl_cell1_r200_0550 0 {C_RBL}
spr_cell1_r200_0550 pref_200 ref_cell1_r200_0550 ctl 0 swpre
cref_cell1_r200_0550 ref_cell1_r200_0550 0 {C_RBL}   $ ASSUMPTION: ideal matched dummy load
XMN1_cell1_r200_0550 rbl_cell1_r200_0550 ref_cell1_r200_0550 vn_cell1_r200_0550 0 sky130_fd_pr__nfet_01v8 L=0.15 W=1 nf=1 ad=0.29 as=0.29 pd=2.58 ps=2.58 mult=1 m=1
XMN2_cell1_r200_0550 ref_cell1_r200_0550 rbl_cell1_r200_0550 vn_cell1_r200_0550 0 sky130_fd_pr__nfet_01v8 L=0.15 W=1 nf=1 ad=0.29 as=0.29 pd=2.58 ps=2.58 mult=1 m=1
XMP1_cell1_r200_0550 rbl_cell1_r200_0550 ref_cell1_r200_0550 vp_cell1_r200_0550 vdd sky130_fd_pr__pfet_01v8 L=0.15 W=2 nf=1 ad=0.58 as=0.58 pd=4.58 ps=4.58 mult=1 m=1
XMP2_cell1_r200_0550 ref_cell1_r200_0550 rbl_cell1_r200_0550 vp_cell1_r200_0550 vdd sky130_fd_pr__pfet_01v8 L=0.15 W=2 nf=1 ad=0.58 as=0.58 pd=4.58 ps=4.58 mult=1 m=1
XMNF_cell1_r200_0550 vn_cell1_r200_0550 en 0 0 sky130_fd_pr__nfet_01v8 L=0.15 W=2 nf=1 ad=0.58 as=0.58 pd=4.58 ps=4.58 mult=1 m=1
XMPH_cell1_r200_0550 vp_cell1_r200_0550 enb vdd vdd sky130_fd_pr__pfet_01v8 L=0.15 W=4 nf=1 ad=1.16 as=1.16 pd=8.58 ps=8.58 mult=1 m=1
bd_cell1_r200_0550 d_cell1_r200_0550 0 v=v(rbl_cell1_r200_0550)-v(ref_cell1_r200_0550)
bdabs_cell1_r200_0550 dabs_cell1_r200_0550 0 v=abs(v(rbl_cell1_r200_0550)-v(ref_cell1_r200_0550))

* ---- instance 85: cell1_r200_0600 ----
spa_cell1_r200_0600 prea rbl_cell1_r200_0600 ctl 0 swpre
XMWR_cell1_r200_0600_0 sn_cell1_r200_0600_0 0 0 0 sky130_fd_pr__nfet_01v8 L=0.15 W=0.42 nf=1 ad=0.1974 as=0.1974 pd=1.78 ps=1.78 nrd=0.69047619047619  nrs=0.69047619047619 sa=0 sb=0 sd=0 mult=1 m=1
XMRD_cell1_r200_0600_0 rbl_cell1_r200_0600 sn_cell1_r200_0600_0 rwl_sel 0 sky130_fd_pr__nfet_01v8 L=0.15 W=0.42 nf=1 ad=0.1974 as=0.1974 pd=1.78 ps=1.78 nrd=0.69047619047619  nrs=0.69047619047619 sa=0 sb=0 sd=0 mult=1 m=1
csn_cell1_r200_0600_0 sn_cell1_r200_0600_0 0 {C_SN}
XMWR_cell1_r200_0600_1 sn_cell1_r200_0600_1 0 0 0 sky130_fd_pr__nfet_01v8 L=0.15 W=0.42 nf=1 ad=0.1974 as=0.1974 pd=1.78 ps=1.78 nrd=0.69047619047619  nrs=0.69047619047619 sa=0 sb=0 sd=0 mult=1 m=1
XMRD_cell1_r200_0600_1 rbl_cell1_r200_0600 sn_cell1_r200_0600_1 rwl_des 0 sky130_fd_pr__nfet_01v8 L=0.15 W=0.42 nf=1 ad=0.1974 as=0.1974 pd=1.78 ps=1.78 nrd=0.69047619047619  nrs=0.69047619047619 sa=0 sb=0 sd=0 mult=1 m=1
csn_cell1_r200_0600_1 sn_cell1_r200_0600_1 0 {C_SN}
XMWR_cell1_r200_0600_2 sn_cell1_r200_0600_2 0 0 0 sky130_fd_pr__nfet_01v8 L=0.15 W=0.42 nf=1 ad=0.1974 as=0.1974 pd=1.78 ps=1.78 nrd=0.69047619047619  nrs=0.69047619047619 sa=0 sb=0 sd=0 mult=1 m=1
XMRD_cell1_r200_0600_2 rbl_cell1_r200_0600 sn_cell1_r200_0600_2 rwl_des 0 sky130_fd_pr__nfet_01v8 L=0.15 W=0.42 nf=1 ad=0.1974 as=0.1974 pd=1.78 ps=1.78 nrd=0.69047619047619  nrs=0.69047619047619 sa=0 sb=0 sd=0 mult=1 m=1
csn_cell1_r200_0600_2 sn_cell1_r200_0600_2 0 {C_SN}
XMWR_cell1_r200_0600_3 sn_cell1_r200_0600_3 0 0 0 sky130_fd_pr__nfet_01v8 L=0.15 W=0.42 nf=1 ad=0.1974 as=0.1974 pd=1.78 ps=1.78 nrd=0.69047619047619  nrs=0.69047619047619 sa=0 sb=0 sd=0 mult=1 m=1
XMRD_cell1_r200_0600_3 rbl_cell1_r200_0600 sn_cell1_r200_0600_3 rwl_des 0 sky130_fd_pr__nfet_01v8 L=0.15 W=0.42 nf=1 ad=0.1974 as=0.1974 pd=1.78 ps=1.78 nrd=0.69047619047619  nrs=0.69047619047619 sa=0 sb=0 sd=0 mult=1 m=1
csn_cell1_r200_0600_3 sn_cell1_r200_0600_3 0 {C_SN}
crbl_cell1_r200_0600 rbl_cell1_r200_0600 0 {C_RBL}
spr_cell1_r200_0600 pref_200 ref_cell1_r200_0600 ctl 0 swpre
cref_cell1_r200_0600 ref_cell1_r200_0600 0 {C_RBL}   $ ASSUMPTION: ideal matched dummy load
XMN1_cell1_r200_0600 rbl_cell1_r200_0600 ref_cell1_r200_0600 vn_cell1_r200_0600 0 sky130_fd_pr__nfet_01v8 L=0.15 W=1 nf=1 ad=0.29 as=0.29 pd=2.58 ps=2.58 mult=1 m=1
XMN2_cell1_r200_0600 ref_cell1_r200_0600 rbl_cell1_r200_0600 vn_cell1_r200_0600 0 sky130_fd_pr__nfet_01v8 L=0.15 W=1 nf=1 ad=0.29 as=0.29 pd=2.58 ps=2.58 mult=1 m=1
XMP1_cell1_r200_0600 rbl_cell1_r200_0600 ref_cell1_r200_0600 vp_cell1_r200_0600 vdd sky130_fd_pr__pfet_01v8 L=0.15 W=2 nf=1 ad=0.58 as=0.58 pd=4.58 ps=4.58 mult=1 m=1
XMP2_cell1_r200_0600 ref_cell1_r200_0600 rbl_cell1_r200_0600 vp_cell1_r200_0600 vdd sky130_fd_pr__pfet_01v8 L=0.15 W=2 nf=1 ad=0.58 as=0.58 pd=4.58 ps=4.58 mult=1 m=1
XMNF_cell1_r200_0600 vn_cell1_r200_0600 en 0 0 sky130_fd_pr__nfet_01v8 L=0.15 W=2 nf=1 ad=0.58 as=0.58 pd=4.58 ps=4.58 mult=1 m=1
XMPH_cell1_r200_0600 vp_cell1_r200_0600 enb vdd vdd sky130_fd_pr__pfet_01v8 L=0.15 W=4 nf=1 ad=1.16 as=1.16 pd=8.58 ps=8.58 mult=1 m=1
bd_cell1_r200_0600 d_cell1_r200_0600 0 v=v(rbl_cell1_r200_0600)-v(ref_cell1_r200_0600)
bdabs_cell1_r200_0600 dabs_cell1_r200_0600 0 v=abs(v(rbl_cell1_r200_0600)-v(ref_cell1_r200_0600))

* ---- instance 86: cell1_r200_0650 ----
spa_cell1_r200_0650 prea rbl_cell1_r200_0650 ctl 0 swpre
XMWR_cell1_r200_0650_0 sn_cell1_r200_0650_0 0 0 0 sky130_fd_pr__nfet_01v8 L=0.15 W=0.42 nf=1 ad=0.1974 as=0.1974 pd=1.78 ps=1.78 nrd=0.69047619047619  nrs=0.69047619047619 sa=0 sb=0 sd=0 mult=1 m=1
XMRD_cell1_r200_0650_0 rbl_cell1_r200_0650 sn_cell1_r200_0650_0 rwl_sel 0 sky130_fd_pr__nfet_01v8 L=0.15 W=0.42 nf=1 ad=0.1974 as=0.1974 pd=1.78 ps=1.78 nrd=0.69047619047619  nrs=0.69047619047619 sa=0 sb=0 sd=0 mult=1 m=1
csn_cell1_r200_0650_0 sn_cell1_r200_0650_0 0 {C_SN}
XMWR_cell1_r200_0650_1 sn_cell1_r200_0650_1 0 0 0 sky130_fd_pr__nfet_01v8 L=0.15 W=0.42 nf=1 ad=0.1974 as=0.1974 pd=1.78 ps=1.78 nrd=0.69047619047619  nrs=0.69047619047619 sa=0 sb=0 sd=0 mult=1 m=1
XMRD_cell1_r200_0650_1 rbl_cell1_r200_0650 sn_cell1_r200_0650_1 rwl_des 0 sky130_fd_pr__nfet_01v8 L=0.15 W=0.42 nf=1 ad=0.1974 as=0.1974 pd=1.78 ps=1.78 nrd=0.69047619047619  nrs=0.69047619047619 sa=0 sb=0 sd=0 mult=1 m=1
csn_cell1_r200_0650_1 sn_cell1_r200_0650_1 0 {C_SN}
XMWR_cell1_r200_0650_2 sn_cell1_r200_0650_2 0 0 0 sky130_fd_pr__nfet_01v8 L=0.15 W=0.42 nf=1 ad=0.1974 as=0.1974 pd=1.78 ps=1.78 nrd=0.69047619047619  nrs=0.69047619047619 sa=0 sb=0 sd=0 mult=1 m=1
XMRD_cell1_r200_0650_2 rbl_cell1_r200_0650 sn_cell1_r200_0650_2 rwl_des 0 sky130_fd_pr__nfet_01v8 L=0.15 W=0.42 nf=1 ad=0.1974 as=0.1974 pd=1.78 ps=1.78 nrd=0.69047619047619  nrs=0.69047619047619 sa=0 sb=0 sd=0 mult=1 m=1
csn_cell1_r200_0650_2 sn_cell1_r200_0650_2 0 {C_SN}
XMWR_cell1_r200_0650_3 sn_cell1_r200_0650_3 0 0 0 sky130_fd_pr__nfet_01v8 L=0.15 W=0.42 nf=1 ad=0.1974 as=0.1974 pd=1.78 ps=1.78 nrd=0.69047619047619  nrs=0.69047619047619 sa=0 sb=0 sd=0 mult=1 m=1
XMRD_cell1_r200_0650_3 rbl_cell1_r200_0650 sn_cell1_r200_0650_3 rwl_des 0 sky130_fd_pr__nfet_01v8 L=0.15 W=0.42 nf=1 ad=0.1974 as=0.1974 pd=1.78 ps=1.78 nrd=0.69047619047619  nrs=0.69047619047619 sa=0 sb=0 sd=0 mult=1 m=1
csn_cell1_r200_0650_3 sn_cell1_r200_0650_3 0 {C_SN}
crbl_cell1_r200_0650 rbl_cell1_r200_0650 0 {C_RBL}
spr_cell1_r200_0650 pref_200 ref_cell1_r200_0650 ctl 0 swpre
cref_cell1_r200_0650 ref_cell1_r200_0650 0 {C_RBL}   $ ASSUMPTION: ideal matched dummy load
XMN1_cell1_r200_0650 rbl_cell1_r200_0650 ref_cell1_r200_0650 vn_cell1_r200_0650 0 sky130_fd_pr__nfet_01v8 L=0.15 W=1 nf=1 ad=0.29 as=0.29 pd=2.58 ps=2.58 mult=1 m=1
XMN2_cell1_r200_0650 ref_cell1_r200_0650 rbl_cell1_r200_0650 vn_cell1_r200_0650 0 sky130_fd_pr__nfet_01v8 L=0.15 W=1 nf=1 ad=0.29 as=0.29 pd=2.58 ps=2.58 mult=1 m=1
XMP1_cell1_r200_0650 rbl_cell1_r200_0650 ref_cell1_r200_0650 vp_cell1_r200_0650 vdd sky130_fd_pr__pfet_01v8 L=0.15 W=2 nf=1 ad=0.58 as=0.58 pd=4.58 ps=4.58 mult=1 m=1
XMP2_cell1_r200_0650 ref_cell1_r200_0650 rbl_cell1_r200_0650 vp_cell1_r200_0650 vdd sky130_fd_pr__pfet_01v8 L=0.15 W=2 nf=1 ad=0.58 as=0.58 pd=4.58 ps=4.58 mult=1 m=1
XMNF_cell1_r200_0650 vn_cell1_r200_0650 en 0 0 sky130_fd_pr__nfet_01v8 L=0.15 W=2 nf=1 ad=0.58 as=0.58 pd=4.58 ps=4.58 mult=1 m=1
XMPH_cell1_r200_0650 vp_cell1_r200_0650 enb vdd vdd sky130_fd_pr__pfet_01v8 L=0.15 W=4 nf=1 ad=1.16 as=1.16 pd=8.58 ps=8.58 mult=1 m=1
bd_cell1_r200_0650 d_cell1_r200_0650 0 v=v(rbl_cell1_r200_0650)-v(ref_cell1_r200_0650)
bdabs_cell1_r200_0650 dabs_cell1_r200_0650 0 v=abs(v(rbl_cell1_r200_0650)-v(ref_cell1_r200_0650))

* ---- instance 87: cell1_r200_0700 ----
spa_cell1_r200_0700 prea rbl_cell1_r200_0700 ctl 0 swpre
XMWR_cell1_r200_0700_0 sn_cell1_r200_0700_0 0 0 0 sky130_fd_pr__nfet_01v8 L=0.15 W=0.42 nf=1 ad=0.1974 as=0.1974 pd=1.78 ps=1.78 nrd=0.69047619047619  nrs=0.69047619047619 sa=0 sb=0 sd=0 mult=1 m=1
XMRD_cell1_r200_0700_0 rbl_cell1_r200_0700 sn_cell1_r200_0700_0 rwl_sel 0 sky130_fd_pr__nfet_01v8 L=0.15 W=0.42 nf=1 ad=0.1974 as=0.1974 pd=1.78 ps=1.78 nrd=0.69047619047619  nrs=0.69047619047619 sa=0 sb=0 sd=0 mult=1 m=1
csn_cell1_r200_0700_0 sn_cell1_r200_0700_0 0 {C_SN}
XMWR_cell1_r200_0700_1 sn_cell1_r200_0700_1 0 0 0 sky130_fd_pr__nfet_01v8 L=0.15 W=0.42 nf=1 ad=0.1974 as=0.1974 pd=1.78 ps=1.78 nrd=0.69047619047619  nrs=0.69047619047619 sa=0 sb=0 sd=0 mult=1 m=1
XMRD_cell1_r200_0700_1 rbl_cell1_r200_0700 sn_cell1_r200_0700_1 rwl_des 0 sky130_fd_pr__nfet_01v8 L=0.15 W=0.42 nf=1 ad=0.1974 as=0.1974 pd=1.78 ps=1.78 nrd=0.69047619047619  nrs=0.69047619047619 sa=0 sb=0 sd=0 mult=1 m=1
csn_cell1_r200_0700_1 sn_cell1_r200_0700_1 0 {C_SN}
XMWR_cell1_r200_0700_2 sn_cell1_r200_0700_2 0 0 0 sky130_fd_pr__nfet_01v8 L=0.15 W=0.42 nf=1 ad=0.1974 as=0.1974 pd=1.78 ps=1.78 nrd=0.69047619047619  nrs=0.69047619047619 sa=0 sb=0 sd=0 mult=1 m=1
XMRD_cell1_r200_0700_2 rbl_cell1_r200_0700 sn_cell1_r200_0700_2 rwl_des 0 sky130_fd_pr__nfet_01v8 L=0.15 W=0.42 nf=1 ad=0.1974 as=0.1974 pd=1.78 ps=1.78 nrd=0.69047619047619  nrs=0.69047619047619 sa=0 sb=0 sd=0 mult=1 m=1
csn_cell1_r200_0700_2 sn_cell1_r200_0700_2 0 {C_SN}
XMWR_cell1_r200_0700_3 sn_cell1_r200_0700_3 0 0 0 sky130_fd_pr__nfet_01v8 L=0.15 W=0.42 nf=1 ad=0.1974 as=0.1974 pd=1.78 ps=1.78 nrd=0.69047619047619  nrs=0.69047619047619 sa=0 sb=0 sd=0 mult=1 m=1
XMRD_cell1_r200_0700_3 rbl_cell1_r200_0700 sn_cell1_r200_0700_3 rwl_des 0 sky130_fd_pr__nfet_01v8 L=0.15 W=0.42 nf=1 ad=0.1974 as=0.1974 pd=1.78 ps=1.78 nrd=0.69047619047619  nrs=0.69047619047619 sa=0 sb=0 sd=0 mult=1 m=1
csn_cell1_r200_0700_3 sn_cell1_r200_0700_3 0 {C_SN}
crbl_cell1_r200_0700 rbl_cell1_r200_0700 0 {C_RBL}
spr_cell1_r200_0700 pref_200 ref_cell1_r200_0700 ctl 0 swpre
cref_cell1_r200_0700 ref_cell1_r200_0700 0 {C_RBL}   $ ASSUMPTION: ideal matched dummy load
XMN1_cell1_r200_0700 rbl_cell1_r200_0700 ref_cell1_r200_0700 vn_cell1_r200_0700 0 sky130_fd_pr__nfet_01v8 L=0.15 W=1 nf=1 ad=0.29 as=0.29 pd=2.58 ps=2.58 mult=1 m=1
XMN2_cell1_r200_0700 ref_cell1_r200_0700 rbl_cell1_r200_0700 vn_cell1_r200_0700 0 sky130_fd_pr__nfet_01v8 L=0.15 W=1 nf=1 ad=0.29 as=0.29 pd=2.58 ps=2.58 mult=1 m=1
XMP1_cell1_r200_0700 rbl_cell1_r200_0700 ref_cell1_r200_0700 vp_cell1_r200_0700 vdd sky130_fd_pr__pfet_01v8 L=0.15 W=2 nf=1 ad=0.58 as=0.58 pd=4.58 ps=4.58 mult=1 m=1
XMP2_cell1_r200_0700 ref_cell1_r200_0700 rbl_cell1_r200_0700 vp_cell1_r200_0700 vdd sky130_fd_pr__pfet_01v8 L=0.15 W=2 nf=1 ad=0.58 as=0.58 pd=4.58 ps=4.58 mult=1 m=1
XMNF_cell1_r200_0700 vn_cell1_r200_0700 en 0 0 sky130_fd_pr__nfet_01v8 L=0.15 W=2 nf=1 ad=0.58 as=0.58 pd=4.58 ps=4.58 mult=1 m=1
XMPH_cell1_r200_0700 vp_cell1_r200_0700 enb vdd vdd sky130_fd_pr__pfet_01v8 L=0.15 W=4 nf=1 ad=1.16 as=1.16 pd=8.58 ps=8.58 mult=1 m=1
bd_cell1_r200_0700 d_cell1_r200_0700 0 v=v(rbl_cell1_r200_0700)-v(ref_cell1_r200_0700)
bdabs_cell1_r200_0700 dabs_cell1_r200_0700 0 v=abs(v(rbl_cell1_r200_0700)-v(ref_cell1_r200_0700))

* ---- instance 88: cell1_r200_0750 ----
spa_cell1_r200_0750 prea rbl_cell1_r200_0750 ctl 0 swpre
XMWR_cell1_r200_0750_0 sn_cell1_r200_0750_0 0 0 0 sky130_fd_pr__nfet_01v8 L=0.15 W=0.42 nf=1 ad=0.1974 as=0.1974 pd=1.78 ps=1.78 nrd=0.69047619047619  nrs=0.69047619047619 sa=0 sb=0 sd=0 mult=1 m=1
XMRD_cell1_r200_0750_0 rbl_cell1_r200_0750 sn_cell1_r200_0750_0 rwl_sel 0 sky130_fd_pr__nfet_01v8 L=0.15 W=0.42 nf=1 ad=0.1974 as=0.1974 pd=1.78 ps=1.78 nrd=0.69047619047619  nrs=0.69047619047619 sa=0 sb=0 sd=0 mult=1 m=1
csn_cell1_r200_0750_0 sn_cell1_r200_0750_0 0 {C_SN}
XMWR_cell1_r200_0750_1 sn_cell1_r200_0750_1 0 0 0 sky130_fd_pr__nfet_01v8 L=0.15 W=0.42 nf=1 ad=0.1974 as=0.1974 pd=1.78 ps=1.78 nrd=0.69047619047619  nrs=0.69047619047619 sa=0 sb=0 sd=0 mult=1 m=1
XMRD_cell1_r200_0750_1 rbl_cell1_r200_0750 sn_cell1_r200_0750_1 rwl_des 0 sky130_fd_pr__nfet_01v8 L=0.15 W=0.42 nf=1 ad=0.1974 as=0.1974 pd=1.78 ps=1.78 nrd=0.69047619047619  nrs=0.69047619047619 sa=0 sb=0 sd=0 mult=1 m=1
csn_cell1_r200_0750_1 sn_cell1_r200_0750_1 0 {C_SN}
XMWR_cell1_r200_0750_2 sn_cell1_r200_0750_2 0 0 0 sky130_fd_pr__nfet_01v8 L=0.15 W=0.42 nf=1 ad=0.1974 as=0.1974 pd=1.78 ps=1.78 nrd=0.69047619047619  nrs=0.69047619047619 sa=0 sb=0 sd=0 mult=1 m=1
XMRD_cell1_r200_0750_2 rbl_cell1_r200_0750 sn_cell1_r200_0750_2 rwl_des 0 sky130_fd_pr__nfet_01v8 L=0.15 W=0.42 nf=1 ad=0.1974 as=0.1974 pd=1.78 ps=1.78 nrd=0.69047619047619  nrs=0.69047619047619 sa=0 sb=0 sd=0 mult=1 m=1
csn_cell1_r200_0750_2 sn_cell1_r200_0750_2 0 {C_SN}
XMWR_cell1_r200_0750_3 sn_cell1_r200_0750_3 0 0 0 sky130_fd_pr__nfet_01v8 L=0.15 W=0.42 nf=1 ad=0.1974 as=0.1974 pd=1.78 ps=1.78 nrd=0.69047619047619  nrs=0.69047619047619 sa=0 sb=0 sd=0 mult=1 m=1
XMRD_cell1_r200_0750_3 rbl_cell1_r200_0750 sn_cell1_r200_0750_3 rwl_des 0 sky130_fd_pr__nfet_01v8 L=0.15 W=0.42 nf=1 ad=0.1974 as=0.1974 pd=1.78 ps=1.78 nrd=0.69047619047619  nrs=0.69047619047619 sa=0 sb=0 sd=0 mult=1 m=1
csn_cell1_r200_0750_3 sn_cell1_r200_0750_3 0 {C_SN}
crbl_cell1_r200_0750 rbl_cell1_r200_0750 0 {C_RBL}
spr_cell1_r200_0750 pref_200 ref_cell1_r200_0750 ctl 0 swpre
cref_cell1_r200_0750 ref_cell1_r200_0750 0 {C_RBL}   $ ASSUMPTION: ideal matched dummy load
XMN1_cell1_r200_0750 rbl_cell1_r200_0750 ref_cell1_r200_0750 vn_cell1_r200_0750 0 sky130_fd_pr__nfet_01v8 L=0.15 W=1 nf=1 ad=0.29 as=0.29 pd=2.58 ps=2.58 mult=1 m=1
XMN2_cell1_r200_0750 ref_cell1_r200_0750 rbl_cell1_r200_0750 vn_cell1_r200_0750 0 sky130_fd_pr__nfet_01v8 L=0.15 W=1 nf=1 ad=0.29 as=0.29 pd=2.58 ps=2.58 mult=1 m=1
XMP1_cell1_r200_0750 rbl_cell1_r200_0750 ref_cell1_r200_0750 vp_cell1_r200_0750 vdd sky130_fd_pr__pfet_01v8 L=0.15 W=2 nf=1 ad=0.58 as=0.58 pd=4.58 ps=4.58 mult=1 m=1
XMP2_cell1_r200_0750 ref_cell1_r200_0750 rbl_cell1_r200_0750 vp_cell1_r200_0750 vdd sky130_fd_pr__pfet_01v8 L=0.15 W=2 nf=1 ad=0.58 as=0.58 pd=4.58 ps=4.58 mult=1 m=1
XMNF_cell1_r200_0750 vn_cell1_r200_0750 en 0 0 sky130_fd_pr__nfet_01v8 L=0.15 W=2 nf=1 ad=0.58 as=0.58 pd=4.58 ps=4.58 mult=1 m=1
XMPH_cell1_r200_0750 vp_cell1_r200_0750 enb vdd vdd sky130_fd_pr__pfet_01v8 L=0.15 W=4 nf=1 ad=1.16 as=1.16 pd=8.58 ps=8.58 mult=1 m=1
bd_cell1_r200_0750 d_cell1_r200_0750 0 v=v(rbl_cell1_r200_0750)-v(ref_cell1_r200_0750)
bdabs_cell1_r200_0750 dabs_cell1_r200_0750 0 v=abs(v(rbl_cell1_r200_0750)-v(ref_cell1_r200_0750))

* ---- instance 89: cell1_r200_0800 ----
spa_cell1_r200_0800 prea rbl_cell1_r200_0800 ctl 0 swpre
XMWR_cell1_r200_0800_0 sn_cell1_r200_0800_0 0 0 0 sky130_fd_pr__nfet_01v8 L=0.15 W=0.42 nf=1 ad=0.1974 as=0.1974 pd=1.78 ps=1.78 nrd=0.69047619047619  nrs=0.69047619047619 sa=0 sb=0 sd=0 mult=1 m=1
XMRD_cell1_r200_0800_0 rbl_cell1_r200_0800 sn_cell1_r200_0800_0 rwl_sel 0 sky130_fd_pr__nfet_01v8 L=0.15 W=0.42 nf=1 ad=0.1974 as=0.1974 pd=1.78 ps=1.78 nrd=0.69047619047619  nrs=0.69047619047619 sa=0 sb=0 sd=0 mult=1 m=1
csn_cell1_r200_0800_0 sn_cell1_r200_0800_0 0 {C_SN}
XMWR_cell1_r200_0800_1 sn_cell1_r200_0800_1 0 0 0 sky130_fd_pr__nfet_01v8 L=0.15 W=0.42 nf=1 ad=0.1974 as=0.1974 pd=1.78 ps=1.78 nrd=0.69047619047619  nrs=0.69047619047619 sa=0 sb=0 sd=0 mult=1 m=1
XMRD_cell1_r200_0800_1 rbl_cell1_r200_0800 sn_cell1_r200_0800_1 rwl_des 0 sky130_fd_pr__nfet_01v8 L=0.15 W=0.42 nf=1 ad=0.1974 as=0.1974 pd=1.78 ps=1.78 nrd=0.69047619047619  nrs=0.69047619047619 sa=0 sb=0 sd=0 mult=1 m=1
csn_cell1_r200_0800_1 sn_cell1_r200_0800_1 0 {C_SN}
XMWR_cell1_r200_0800_2 sn_cell1_r200_0800_2 0 0 0 sky130_fd_pr__nfet_01v8 L=0.15 W=0.42 nf=1 ad=0.1974 as=0.1974 pd=1.78 ps=1.78 nrd=0.69047619047619  nrs=0.69047619047619 sa=0 sb=0 sd=0 mult=1 m=1
XMRD_cell1_r200_0800_2 rbl_cell1_r200_0800 sn_cell1_r200_0800_2 rwl_des 0 sky130_fd_pr__nfet_01v8 L=0.15 W=0.42 nf=1 ad=0.1974 as=0.1974 pd=1.78 ps=1.78 nrd=0.69047619047619  nrs=0.69047619047619 sa=0 sb=0 sd=0 mult=1 m=1
csn_cell1_r200_0800_2 sn_cell1_r200_0800_2 0 {C_SN}
XMWR_cell1_r200_0800_3 sn_cell1_r200_0800_3 0 0 0 sky130_fd_pr__nfet_01v8 L=0.15 W=0.42 nf=1 ad=0.1974 as=0.1974 pd=1.78 ps=1.78 nrd=0.69047619047619  nrs=0.69047619047619 sa=0 sb=0 sd=0 mult=1 m=1
XMRD_cell1_r200_0800_3 rbl_cell1_r200_0800 sn_cell1_r200_0800_3 rwl_des 0 sky130_fd_pr__nfet_01v8 L=0.15 W=0.42 nf=1 ad=0.1974 as=0.1974 pd=1.78 ps=1.78 nrd=0.69047619047619  nrs=0.69047619047619 sa=0 sb=0 sd=0 mult=1 m=1
csn_cell1_r200_0800_3 sn_cell1_r200_0800_3 0 {C_SN}
crbl_cell1_r200_0800 rbl_cell1_r200_0800 0 {C_RBL}
spr_cell1_r200_0800 pref_200 ref_cell1_r200_0800 ctl 0 swpre
cref_cell1_r200_0800 ref_cell1_r200_0800 0 {C_RBL}   $ ASSUMPTION: ideal matched dummy load
XMN1_cell1_r200_0800 rbl_cell1_r200_0800 ref_cell1_r200_0800 vn_cell1_r200_0800 0 sky130_fd_pr__nfet_01v8 L=0.15 W=1 nf=1 ad=0.29 as=0.29 pd=2.58 ps=2.58 mult=1 m=1
XMN2_cell1_r200_0800 ref_cell1_r200_0800 rbl_cell1_r200_0800 vn_cell1_r200_0800 0 sky130_fd_pr__nfet_01v8 L=0.15 W=1 nf=1 ad=0.29 as=0.29 pd=2.58 ps=2.58 mult=1 m=1
XMP1_cell1_r200_0800 rbl_cell1_r200_0800 ref_cell1_r200_0800 vp_cell1_r200_0800 vdd sky130_fd_pr__pfet_01v8 L=0.15 W=2 nf=1 ad=0.58 as=0.58 pd=4.58 ps=4.58 mult=1 m=1
XMP2_cell1_r200_0800 ref_cell1_r200_0800 rbl_cell1_r200_0800 vp_cell1_r200_0800 vdd sky130_fd_pr__pfet_01v8 L=0.15 W=2 nf=1 ad=0.58 as=0.58 pd=4.58 ps=4.58 mult=1 m=1
XMNF_cell1_r200_0800 vn_cell1_r200_0800 en 0 0 sky130_fd_pr__nfet_01v8 L=0.15 W=2 nf=1 ad=0.58 as=0.58 pd=4.58 ps=4.58 mult=1 m=1
XMPH_cell1_r200_0800 vp_cell1_r200_0800 enb vdd vdd sky130_fd_pr__pfet_01v8 L=0.15 W=4 nf=1 ad=1.16 as=1.16 pd=8.58 ps=8.58 mult=1 m=1
bd_cell1_r200_0800 d_cell1_r200_0800 0 v=v(rbl_cell1_r200_0800)-v(ref_cell1_r200_0800)
bdabs_cell1_r200_0800 dabs_cell1_r200_0800 0 v=abs(v(rbl_cell1_r200_0800)-v(ref_cell1_r200_0800))

* ---- instance 90: cell1_r200_0850 ----
spa_cell1_r200_0850 prea rbl_cell1_r200_0850 ctl 0 swpre
XMWR_cell1_r200_0850_0 sn_cell1_r200_0850_0 0 0 0 sky130_fd_pr__nfet_01v8 L=0.15 W=0.42 nf=1 ad=0.1974 as=0.1974 pd=1.78 ps=1.78 nrd=0.69047619047619  nrs=0.69047619047619 sa=0 sb=0 sd=0 mult=1 m=1
XMRD_cell1_r200_0850_0 rbl_cell1_r200_0850 sn_cell1_r200_0850_0 rwl_sel 0 sky130_fd_pr__nfet_01v8 L=0.15 W=0.42 nf=1 ad=0.1974 as=0.1974 pd=1.78 ps=1.78 nrd=0.69047619047619  nrs=0.69047619047619 sa=0 sb=0 sd=0 mult=1 m=1
csn_cell1_r200_0850_0 sn_cell1_r200_0850_0 0 {C_SN}
XMWR_cell1_r200_0850_1 sn_cell1_r200_0850_1 0 0 0 sky130_fd_pr__nfet_01v8 L=0.15 W=0.42 nf=1 ad=0.1974 as=0.1974 pd=1.78 ps=1.78 nrd=0.69047619047619  nrs=0.69047619047619 sa=0 sb=0 sd=0 mult=1 m=1
XMRD_cell1_r200_0850_1 rbl_cell1_r200_0850 sn_cell1_r200_0850_1 rwl_des 0 sky130_fd_pr__nfet_01v8 L=0.15 W=0.42 nf=1 ad=0.1974 as=0.1974 pd=1.78 ps=1.78 nrd=0.69047619047619  nrs=0.69047619047619 sa=0 sb=0 sd=0 mult=1 m=1
csn_cell1_r200_0850_1 sn_cell1_r200_0850_1 0 {C_SN}
XMWR_cell1_r200_0850_2 sn_cell1_r200_0850_2 0 0 0 sky130_fd_pr__nfet_01v8 L=0.15 W=0.42 nf=1 ad=0.1974 as=0.1974 pd=1.78 ps=1.78 nrd=0.69047619047619  nrs=0.69047619047619 sa=0 sb=0 sd=0 mult=1 m=1
XMRD_cell1_r200_0850_2 rbl_cell1_r200_0850 sn_cell1_r200_0850_2 rwl_des 0 sky130_fd_pr__nfet_01v8 L=0.15 W=0.42 nf=1 ad=0.1974 as=0.1974 pd=1.78 ps=1.78 nrd=0.69047619047619  nrs=0.69047619047619 sa=0 sb=0 sd=0 mult=1 m=1
csn_cell1_r200_0850_2 sn_cell1_r200_0850_2 0 {C_SN}
XMWR_cell1_r200_0850_3 sn_cell1_r200_0850_3 0 0 0 sky130_fd_pr__nfet_01v8 L=0.15 W=0.42 nf=1 ad=0.1974 as=0.1974 pd=1.78 ps=1.78 nrd=0.69047619047619  nrs=0.69047619047619 sa=0 sb=0 sd=0 mult=1 m=1
XMRD_cell1_r200_0850_3 rbl_cell1_r200_0850 sn_cell1_r200_0850_3 rwl_des 0 sky130_fd_pr__nfet_01v8 L=0.15 W=0.42 nf=1 ad=0.1974 as=0.1974 pd=1.78 ps=1.78 nrd=0.69047619047619  nrs=0.69047619047619 sa=0 sb=0 sd=0 mult=1 m=1
csn_cell1_r200_0850_3 sn_cell1_r200_0850_3 0 {C_SN}
crbl_cell1_r200_0850 rbl_cell1_r200_0850 0 {C_RBL}
spr_cell1_r200_0850 pref_200 ref_cell1_r200_0850 ctl 0 swpre
cref_cell1_r200_0850 ref_cell1_r200_0850 0 {C_RBL}   $ ASSUMPTION: ideal matched dummy load
XMN1_cell1_r200_0850 rbl_cell1_r200_0850 ref_cell1_r200_0850 vn_cell1_r200_0850 0 sky130_fd_pr__nfet_01v8 L=0.15 W=1 nf=1 ad=0.29 as=0.29 pd=2.58 ps=2.58 mult=1 m=1
XMN2_cell1_r200_0850 ref_cell1_r200_0850 rbl_cell1_r200_0850 vn_cell1_r200_0850 0 sky130_fd_pr__nfet_01v8 L=0.15 W=1 nf=1 ad=0.29 as=0.29 pd=2.58 ps=2.58 mult=1 m=1
XMP1_cell1_r200_0850 rbl_cell1_r200_0850 ref_cell1_r200_0850 vp_cell1_r200_0850 vdd sky130_fd_pr__pfet_01v8 L=0.15 W=2 nf=1 ad=0.58 as=0.58 pd=4.58 ps=4.58 mult=1 m=1
XMP2_cell1_r200_0850 ref_cell1_r200_0850 rbl_cell1_r200_0850 vp_cell1_r200_0850 vdd sky130_fd_pr__pfet_01v8 L=0.15 W=2 nf=1 ad=0.58 as=0.58 pd=4.58 ps=4.58 mult=1 m=1
XMNF_cell1_r200_0850 vn_cell1_r200_0850 en 0 0 sky130_fd_pr__nfet_01v8 L=0.15 W=2 nf=1 ad=0.58 as=0.58 pd=4.58 ps=4.58 mult=1 m=1
XMPH_cell1_r200_0850 vp_cell1_r200_0850 enb vdd vdd sky130_fd_pr__pfet_01v8 L=0.15 W=4 nf=1 ad=1.16 as=1.16 pd=8.58 ps=8.58 mult=1 m=1
bd_cell1_r200_0850 d_cell1_r200_0850 0 v=v(rbl_cell1_r200_0850)-v(ref_cell1_r200_0850)
bdabs_cell1_r200_0850 dabs_cell1_r200_0850 0 v=abs(v(rbl_cell1_r200_0850)-v(ref_cell1_r200_0850))

* ---- instance 91: cell1_r200_0900 ----
spa_cell1_r200_0900 prea rbl_cell1_r200_0900 ctl 0 swpre
XMWR_cell1_r200_0900_0 sn_cell1_r200_0900_0 0 0 0 sky130_fd_pr__nfet_01v8 L=0.15 W=0.42 nf=1 ad=0.1974 as=0.1974 pd=1.78 ps=1.78 nrd=0.69047619047619  nrs=0.69047619047619 sa=0 sb=0 sd=0 mult=1 m=1
XMRD_cell1_r200_0900_0 rbl_cell1_r200_0900 sn_cell1_r200_0900_0 rwl_sel 0 sky130_fd_pr__nfet_01v8 L=0.15 W=0.42 nf=1 ad=0.1974 as=0.1974 pd=1.78 ps=1.78 nrd=0.69047619047619  nrs=0.69047619047619 sa=0 sb=0 sd=0 mult=1 m=1
csn_cell1_r200_0900_0 sn_cell1_r200_0900_0 0 {C_SN}
XMWR_cell1_r200_0900_1 sn_cell1_r200_0900_1 0 0 0 sky130_fd_pr__nfet_01v8 L=0.15 W=0.42 nf=1 ad=0.1974 as=0.1974 pd=1.78 ps=1.78 nrd=0.69047619047619  nrs=0.69047619047619 sa=0 sb=0 sd=0 mult=1 m=1
XMRD_cell1_r200_0900_1 rbl_cell1_r200_0900 sn_cell1_r200_0900_1 rwl_des 0 sky130_fd_pr__nfet_01v8 L=0.15 W=0.42 nf=1 ad=0.1974 as=0.1974 pd=1.78 ps=1.78 nrd=0.69047619047619  nrs=0.69047619047619 sa=0 sb=0 sd=0 mult=1 m=1
csn_cell1_r200_0900_1 sn_cell1_r200_0900_1 0 {C_SN}
XMWR_cell1_r200_0900_2 sn_cell1_r200_0900_2 0 0 0 sky130_fd_pr__nfet_01v8 L=0.15 W=0.42 nf=1 ad=0.1974 as=0.1974 pd=1.78 ps=1.78 nrd=0.69047619047619  nrs=0.69047619047619 sa=0 sb=0 sd=0 mult=1 m=1
XMRD_cell1_r200_0900_2 rbl_cell1_r200_0900 sn_cell1_r200_0900_2 rwl_des 0 sky130_fd_pr__nfet_01v8 L=0.15 W=0.42 nf=1 ad=0.1974 as=0.1974 pd=1.78 ps=1.78 nrd=0.69047619047619  nrs=0.69047619047619 sa=0 sb=0 sd=0 mult=1 m=1
csn_cell1_r200_0900_2 sn_cell1_r200_0900_2 0 {C_SN}
XMWR_cell1_r200_0900_3 sn_cell1_r200_0900_3 0 0 0 sky130_fd_pr__nfet_01v8 L=0.15 W=0.42 nf=1 ad=0.1974 as=0.1974 pd=1.78 ps=1.78 nrd=0.69047619047619  nrs=0.69047619047619 sa=0 sb=0 sd=0 mult=1 m=1
XMRD_cell1_r200_0900_3 rbl_cell1_r200_0900 sn_cell1_r200_0900_3 rwl_des 0 sky130_fd_pr__nfet_01v8 L=0.15 W=0.42 nf=1 ad=0.1974 as=0.1974 pd=1.78 ps=1.78 nrd=0.69047619047619  nrs=0.69047619047619 sa=0 sb=0 sd=0 mult=1 m=1
csn_cell1_r200_0900_3 sn_cell1_r200_0900_3 0 {C_SN}
crbl_cell1_r200_0900 rbl_cell1_r200_0900 0 {C_RBL}
spr_cell1_r200_0900 pref_200 ref_cell1_r200_0900 ctl 0 swpre
cref_cell1_r200_0900 ref_cell1_r200_0900 0 {C_RBL}   $ ASSUMPTION: ideal matched dummy load
XMN1_cell1_r200_0900 rbl_cell1_r200_0900 ref_cell1_r200_0900 vn_cell1_r200_0900 0 sky130_fd_pr__nfet_01v8 L=0.15 W=1 nf=1 ad=0.29 as=0.29 pd=2.58 ps=2.58 mult=1 m=1
XMN2_cell1_r200_0900 ref_cell1_r200_0900 rbl_cell1_r200_0900 vn_cell1_r200_0900 0 sky130_fd_pr__nfet_01v8 L=0.15 W=1 nf=1 ad=0.29 as=0.29 pd=2.58 ps=2.58 mult=1 m=1
XMP1_cell1_r200_0900 rbl_cell1_r200_0900 ref_cell1_r200_0900 vp_cell1_r200_0900 vdd sky130_fd_pr__pfet_01v8 L=0.15 W=2 nf=1 ad=0.58 as=0.58 pd=4.58 ps=4.58 mult=1 m=1
XMP2_cell1_r200_0900 ref_cell1_r200_0900 rbl_cell1_r200_0900 vp_cell1_r200_0900 vdd sky130_fd_pr__pfet_01v8 L=0.15 W=2 nf=1 ad=0.58 as=0.58 pd=4.58 ps=4.58 mult=1 m=1
XMNF_cell1_r200_0900 vn_cell1_r200_0900 en 0 0 sky130_fd_pr__nfet_01v8 L=0.15 W=2 nf=1 ad=0.58 as=0.58 pd=4.58 ps=4.58 mult=1 m=1
XMPH_cell1_r200_0900 vp_cell1_r200_0900 enb vdd vdd sky130_fd_pr__pfet_01v8 L=0.15 W=4 nf=1 ad=1.16 as=1.16 pd=8.58 ps=8.58 mult=1 m=1
bd_cell1_r200_0900 d_cell1_r200_0900 0 v=v(rbl_cell1_r200_0900)-v(ref_cell1_r200_0900)
bdabs_cell1_r200_0900 dabs_cell1_r200_0900 0 v=abs(v(rbl_cell1_r200_0900)-v(ref_cell1_r200_0900))

* ---- instance 92: cell1_r200_0950 ----
spa_cell1_r200_0950 prea rbl_cell1_r200_0950 ctl 0 swpre
XMWR_cell1_r200_0950_0 sn_cell1_r200_0950_0 0 0 0 sky130_fd_pr__nfet_01v8 L=0.15 W=0.42 nf=1 ad=0.1974 as=0.1974 pd=1.78 ps=1.78 nrd=0.69047619047619  nrs=0.69047619047619 sa=0 sb=0 sd=0 mult=1 m=1
XMRD_cell1_r200_0950_0 rbl_cell1_r200_0950 sn_cell1_r200_0950_0 rwl_sel 0 sky130_fd_pr__nfet_01v8 L=0.15 W=0.42 nf=1 ad=0.1974 as=0.1974 pd=1.78 ps=1.78 nrd=0.69047619047619  nrs=0.69047619047619 sa=0 sb=0 sd=0 mult=1 m=1
csn_cell1_r200_0950_0 sn_cell1_r200_0950_0 0 {C_SN}
XMWR_cell1_r200_0950_1 sn_cell1_r200_0950_1 0 0 0 sky130_fd_pr__nfet_01v8 L=0.15 W=0.42 nf=1 ad=0.1974 as=0.1974 pd=1.78 ps=1.78 nrd=0.69047619047619  nrs=0.69047619047619 sa=0 sb=0 sd=0 mult=1 m=1
XMRD_cell1_r200_0950_1 rbl_cell1_r200_0950 sn_cell1_r200_0950_1 rwl_des 0 sky130_fd_pr__nfet_01v8 L=0.15 W=0.42 nf=1 ad=0.1974 as=0.1974 pd=1.78 ps=1.78 nrd=0.69047619047619  nrs=0.69047619047619 sa=0 sb=0 sd=0 mult=1 m=1
csn_cell1_r200_0950_1 sn_cell1_r200_0950_1 0 {C_SN}
XMWR_cell1_r200_0950_2 sn_cell1_r200_0950_2 0 0 0 sky130_fd_pr__nfet_01v8 L=0.15 W=0.42 nf=1 ad=0.1974 as=0.1974 pd=1.78 ps=1.78 nrd=0.69047619047619  nrs=0.69047619047619 sa=0 sb=0 sd=0 mult=1 m=1
XMRD_cell1_r200_0950_2 rbl_cell1_r200_0950 sn_cell1_r200_0950_2 rwl_des 0 sky130_fd_pr__nfet_01v8 L=0.15 W=0.42 nf=1 ad=0.1974 as=0.1974 pd=1.78 ps=1.78 nrd=0.69047619047619  nrs=0.69047619047619 sa=0 sb=0 sd=0 mult=1 m=1
csn_cell1_r200_0950_2 sn_cell1_r200_0950_2 0 {C_SN}
XMWR_cell1_r200_0950_3 sn_cell1_r200_0950_3 0 0 0 sky130_fd_pr__nfet_01v8 L=0.15 W=0.42 nf=1 ad=0.1974 as=0.1974 pd=1.78 ps=1.78 nrd=0.69047619047619  nrs=0.69047619047619 sa=0 sb=0 sd=0 mult=1 m=1
XMRD_cell1_r200_0950_3 rbl_cell1_r200_0950 sn_cell1_r200_0950_3 rwl_des 0 sky130_fd_pr__nfet_01v8 L=0.15 W=0.42 nf=1 ad=0.1974 as=0.1974 pd=1.78 ps=1.78 nrd=0.69047619047619  nrs=0.69047619047619 sa=0 sb=0 sd=0 mult=1 m=1
csn_cell1_r200_0950_3 sn_cell1_r200_0950_3 0 {C_SN}
crbl_cell1_r200_0950 rbl_cell1_r200_0950 0 {C_RBL}
spr_cell1_r200_0950 pref_200 ref_cell1_r200_0950 ctl 0 swpre
cref_cell1_r200_0950 ref_cell1_r200_0950 0 {C_RBL}   $ ASSUMPTION: ideal matched dummy load
XMN1_cell1_r200_0950 rbl_cell1_r200_0950 ref_cell1_r200_0950 vn_cell1_r200_0950 0 sky130_fd_pr__nfet_01v8 L=0.15 W=1 nf=1 ad=0.29 as=0.29 pd=2.58 ps=2.58 mult=1 m=1
XMN2_cell1_r200_0950 ref_cell1_r200_0950 rbl_cell1_r200_0950 vn_cell1_r200_0950 0 sky130_fd_pr__nfet_01v8 L=0.15 W=1 nf=1 ad=0.29 as=0.29 pd=2.58 ps=2.58 mult=1 m=1
XMP1_cell1_r200_0950 rbl_cell1_r200_0950 ref_cell1_r200_0950 vp_cell1_r200_0950 vdd sky130_fd_pr__pfet_01v8 L=0.15 W=2 nf=1 ad=0.58 as=0.58 pd=4.58 ps=4.58 mult=1 m=1
XMP2_cell1_r200_0950 ref_cell1_r200_0950 rbl_cell1_r200_0950 vp_cell1_r200_0950 vdd sky130_fd_pr__pfet_01v8 L=0.15 W=2 nf=1 ad=0.58 as=0.58 pd=4.58 ps=4.58 mult=1 m=1
XMNF_cell1_r200_0950 vn_cell1_r200_0950 en 0 0 sky130_fd_pr__nfet_01v8 L=0.15 W=2 nf=1 ad=0.58 as=0.58 pd=4.58 ps=4.58 mult=1 m=1
XMPH_cell1_r200_0950 vp_cell1_r200_0950 enb vdd vdd sky130_fd_pr__pfet_01v8 L=0.15 W=4 nf=1 ad=1.16 as=1.16 pd=8.58 ps=8.58 mult=1 m=1
bd_cell1_r200_0950 d_cell1_r200_0950 0 v=v(rbl_cell1_r200_0950)-v(ref_cell1_r200_0950)
bdabs_cell1_r200_0950 dabs_cell1_r200_0950 0 v=abs(v(rbl_cell1_r200_0950)-v(ref_cell1_r200_0950))

* ---- instance 93: cell1_r200_1000 ----
spa_cell1_r200_1000 prea rbl_cell1_r200_1000 ctl 0 swpre
XMWR_cell1_r200_1000_0 sn_cell1_r200_1000_0 0 0 0 sky130_fd_pr__nfet_01v8 L=0.15 W=0.42 nf=1 ad=0.1974 as=0.1974 pd=1.78 ps=1.78 nrd=0.69047619047619  nrs=0.69047619047619 sa=0 sb=0 sd=0 mult=1 m=1
XMRD_cell1_r200_1000_0 rbl_cell1_r200_1000 sn_cell1_r200_1000_0 rwl_sel 0 sky130_fd_pr__nfet_01v8 L=0.15 W=0.42 nf=1 ad=0.1974 as=0.1974 pd=1.78 ps=1.78 nrd=0.69047619047619  nrs=0.69047619047619 sa=0 sb=0 sd=0 mult=1 m=1
csn_cell1_r200_1000_0 sn_cell1_r200_1000_0 0 {C_SN}
XMWR_cell1_r200_1000_1 sn_cell1_r200_1000_1 0 0 0 sky130_fd_pr__nfet_01v8 L=0.15 W=0.42 nf=1 ad=0.1974 as=0.1974 pd=1.78 ps=1.78 nrd=0.69047619047619  nrs=0.69047619047619 sa=0 sb=0 sd=0 mult=1 m=1
XMRD_cell1_r200_1000_1 rbl_cell1_r200_1000 sn_cell1_r200_1000_1 rwl_des 0 sky130_fd_pr__nfet_01v8 L=0.15 W=0.42 nf=1 ad=0.1974 as=0.1974 pd=1.78 ps=1.78 nrd=0.69047619047619  nrs=0.69047619047619 sa=0 sb=0 sd=0 mult=1 m=1
csn_cell1_r200_1000_1 sn_cell1_r200_1000_1 0 {C_SN}
XMWR_cell1_r200_1000_2 sn_cell1_r200_1000_2 0 0 0 sky130_fd_pr__nfet_01v8 L=0.15 W=0.42 nf=1 ad=0.1974 as=0.1974 pd=1.78 ps=1.78 nrd=0.69047619047619  nrs=0.69047619047619 sa=0 sb=0 sd=0 mult=1 m=1
XMRD_cell1_r200_1000_2 rbl_cell1_r200_1000 sn_cell1_r200_1000_2 rwl_des 0 sky130_fd_pr__nfet_01v8 L=0.15 W=0.42 nf=1 ad=0.1974 as=0.1974 pd=1.78 ps=1.78 nrd=0.69047619047619  nrs=0.69047619047619 sa=0 sb=0 sd=0 mult=1 m=1
csn_cell1_r200_1000_2 sn_cell1_r200_1000_2 0 {C_SN}
XMWR_cell1_r200_1000_3 sn_cell1_r200_1000_3 0 0 0 sky130_fd_pr__nfet_01v8 L=0.15 W=0.42 nf=1 ad=0.1974 as=0.1974 pd=1.78 ps=1.78 nrd=0.69047619047619  nrs=0.69047619047619 sa=0 sb=0 sd=0 mult=1 m=1
XMRD_cell1_r200_1000_3 rbl_cell1_r200_1000 sn_cell1_r200_1000_3 rwl_des 0 sky130_fd_pr__nfet_01v8 L=0.15 W=0.42 nf=1 ad=0.1974 as=0.1974 pd=1.78 ps=1.78 nrd=0.69047619047619  nrs=0.69047619047619 sa=0 sb=0 sd=0 mult=1 m=1
csn_cell1_r200_1000_3 sn_cell1_r200_1000_3 0 {C_SN}
crbl_cell1_r200_1000 rbl_cell1_r200_1000 0 {C_RBL}
spr_cell1_r200_1000 pref_200 ref_cell1_r200_1000 ctl 0 swpre
cref_cell1_r200_1000 ref_cell1_r200_1000 0 {C_RBL}   $ ASSUMPTION: ideal matched dummy load
XMN1_cell1_r200_1000 rbl_cell1_r200_1000 ref_cell1_r200_1000 vn_cell1_r200_1000 0 sky130_fd_pr__nfet_01v8 L=0.15 W=1 nf=1 ad=0.29 as=0.29 pd=2.58 ps=2.58 mult=1 m=1
XMN2_cell1_r200_1000 ref_cell1_r200_1000 rbl_cell1_r200_1000 vn_cell1_r200_1000 0 sky130_fd_pr__nfet_01v8 L=0.15 W=1 nf=1 ad=0.29 as=0.29 pd=2.58 ps=2.58 mult=1 m=1
XMP1_cell1_r200_1000 rbl_cell1_r200_1000 ref_cell1_r200_1000 vp_cell1_r200_1000 vdd sky130_fd_pr__pfet_01v8 L=0.15 W=2 nf=1 ad=0.58 as=0.58 pd=4.58 ps=4.58 mult=1 m=1
XMP2_cell1_r200_1000 ref_cell1_r200_1000 rbl_cell1_r200_1000 vp_cell1_r200_1000 vdd sky130_fd_pr__pfet_01v8 L=0.15 W=2 nf=1 ad=0.58 as=0.58 pd=4.58 ps=4.58 mult=1 m=1
XMNF_cell1_r200_1000 vn_cell1_r200_1000 en 0 0 sky130_fd_pr__nfet_01v8 L=0.15 W=2 nf=1 ad=0.58 as=0.58 pd=4.58 ps=4.58 mult=1 m=1
XMPH_cell1_r200_1000 vp_cell1_r200_1000 enb vdd vdd sky130_fd_pr__pfet_01v8 L=0.15 W=4 nf=1 ad=1.16 as=1.16 pd=8.58 ps=8.58 mult=1 m=1
bd_cell1_r200_1000 d_cell1_r200_1000 0 v=v(rbl_cell1_r200_1000)-v(ref_cell1_r200_1000)
bdabs_cell1_r200_1000 dabs_cell1_r200_1000 0 v=abs(v(rbl_cell1_r200_1000)-v(ref_cell1_r200_1000))

* ---- instance 94: cell1_r200_1050 ----
spa_cell1_r200_1050 prea rbl_cell1_r200_1050 ctl 0 swpre
XMWR_cell1_r200_1050_0 sn_cell1_r200_1050_0 0 0 0 sky130_fd_pr__nfet_01v8 L=0.15 W=0.42 nf=1 ad=0.1974 as=0.1974 pd=1.78 ps=1.78 nrd=0.69047619047619  nrs=0.69047619047619 sa=0 sb=0 sd=0 mult=1 m=1
XMRD_cell1_r200_1050_0 rbl_cell1_r200_1050 sn_cell1_r200_1050_0 rwl_sel 0 sky130_fd_pr__nfet_01v8 L=0.15 W=0.42 nf=1 ad=0.1974 as=0.1974 pd=1.78 ps=1.78 nrd=0.69047619047619  nrs=0.69047619047619 sa=0 sb=0 sd=0 mult=1 m=1
csn_cell1_r200_1050_0 sn_cell1_r200_1050_0 0 {C_SN}
XMWR_cell1_r200_1050_1 sn_cell1_r200_1050_1 0 0 0 sky130_fd_pr__nfet_01v8 L=0.15 W=0.42 nf=1 ad=0.1974 as=0.1974 pd=1.78 ps=1.78 nrd=0.69047619047619  nrs=0.69047619047619 sa=0 sb=0 sd=0 mult=1 m=1
XMRD_cell1_r200_1050_1 rbl_cell1_r200_1050 sn_cell1_r200_1050_1 rwl_des 0 sky130_fd_pr__nfet_01v8 L=0.15 W=0.42 nf=1 ad=0.1974 as=0.1974 pd=1.78 ps=1.78 nrd=0.69047619047619  nrs=0.69047619047619 sa=0 sb=0 sd=0 mult=1 m=1
csn_cell1_r200_1050_1 sn_cell1_r200_1050_1 0 {C_SN}
XMWR_cell1_r200_1050_2 sn_cell1_r200_1050_2 0 0 0 sky130_fd_pr__nfet_01v8 L=0.15 W=0.42 nf=1 ad=0.1974 as=0.1974 pd=1.78 ps=1.78 nrd=0.69047619047619  nrs=0.69047619047619 sa=0 sb=0 sd=0 mult=1 m=1
XMRD_cell1_r200_1050_2 rbl_cell1_r200_1050 sn_cell1_r200_1050_2 rwl_des 0 sky130_fd_pr__nfet_01v8 L=0.15 W=0.42 nf=1 ad=0.1974 as=0.1974 pd=1.78 ps=1.78 nrd=0.69047619047619  nrs=0.69047619047619 sa=0 sb=0 sd=0 mult=1 m=1
csn_cell1_r200_1050_2 sn_cell1_r200_1050_2 0 {C_SN}
XMWR_cell1_r200_1050_3 sn_cell1_r200_1050_3 0 0 0 sky130_fd_pr__nfet_01v8 L=0.15 W=0.42 nf=1 ad=0.1974 as=0.1974 pd=1.78 ps=1.78 nrd=0.69047619047619  nrs=0.69047619047619 sa=0 sb=0 sd=0 mult=1 m=1
XMRD_cell1_r200_1050_3 rbl_cell1_r200_1050 sn_cell1_r200_1050_3 rwl_des 0 sky130_fd_pr__nfet_01v8 L=0.15 W=0.42 nf=1 ad=0.1974 as=0.1974 pd=1.78 ps=1.78 nrd=0.69047619047619  nrs=0.69047619047619 sa=0 sb=0 sd=0 mult=1 m=1
csn_cell1_r200_1050_3 sn_cell1_r200_1050_3 0 {C_SN}
crbl_cell1_r200_1050 rbl_cell1_r200_1050 0 {C_RBL}
spr_cell1_r200_1050 pref_200 ref_cell1_r200_1050 ctl 0 swpre
cref_cell1_r200_1050 ref_cell1_r200_1050 0 {C_RBL}   $ ASSUMPTION: ideal matched dummy load
XMN1_cell1_r200_1050 rbl_cell1_r200_1050 ref_cell1_r200_1050 vn_cell1_r200_1050 0 sky130_fd_pr__nfet_01v8 L=0.15 W=1 nf=1 ad=0.29 as=0.29 pd=2.58 ps=2.58 mult=1 m=1
XMN2_cell1_r200_1050 ref_cell1_r200_1050 rbl_cell1_r200_1050 vn_cell1_r200_1050 0 sky130_fd_pr__nfet_01v8 L=0.15 W=1 nf=1 ad=0.29 as=0.29 pd=2.58 ps=2.58 mult=1 m=1
XMP1_cell1_r200_1050 rbl_cell1_r200_1050 ref_cell1_r200_1050 vp_cell1_r200_1050 vdd sky130_fd_pr__pfet_01v8 L=0.15 W=2 nf=1 ad=0.58 as=0.58 pd=4.58 ps=4.58 mult=1 m=1
XMP2_cell1_r200_1050 ref_cell1_r200_1050 rbl_cell1_r200_1050 vp_cell1_r200_1050 vdd sky130_fd_pr__pfet_01v8 L=0.15 W=2 nf=1 ad=0.58 as=0.58 pd=4.58 ps=4.58 mult=1 m=1
XMNF_cell1_r200_1050 vn_cell1_r200_1050 en 0 0 sky130_fd_pr__nfet_01v8 L=0.15 W=2 nf=1 ad=0.58 as=0.58 pd=4.58 ps=4.58 mult=1 m=1
XMPH_cell1_r200_1050 vp_cell1_r200_1050 enb vdd vdd sky130_fd_pr__pfet_01v8 L=0.15 W=4 nf=1 ad=1.16 as=1.16 pd=8.58 ps=8.58 mult=1 m=1
bd_cell1_r200_1050 d_cell1_r200_1050 0 v=v(rbl_cell1_r200_1050)-v(ref_cell1_r200_1050)
bdabs_cell1_r200_1050 dabs_cell1_r200_1050 0 v=abs(v(rbl_cell1_r200_1050)-v(ref_cell1_r200_1050))

* ---- instance 95: cell1_r200_1100 ----
spa_cell1_r200_1100 prea rbl_cell1_r200_1100 ctl 0 swpre
XMWR_cell1_r200_1100_0 sn_cell1_r200_1100_0 0 0 0 sky130_fd_pr__nfet_01v8 L=0.15 W=0.42 nf=1 ad=0.1974 as=0.1974 pd=1.78 ps=1.78 nrd=0.69047619047619  nrs=0.69047619047619 sa=0 sb=0 sd=0 mult=1 m=1
XMRD_cell1_r200_1100_0 rbl_cell1_r200_1100 sn_cell1_r200_1100_0 rwl_sel 0 sky130_fd_pr__nfet_01v8 L=0.15 W=0.42 nf=1 ad=0.1974 as=0.1974 pd=1.78 ps=1.78 nrd=0.69047619047619  nrs=0.69047619047619 sa=0 sb=0 sd=0 mult=1 m=1
csn_cell1_r200_1100_0 sn_cell1_r200_1100_0 0 {C_SN}
XMWR_cell1_r200_1100_1 sn_cell1_r200_1100_1 0 0 0 sky130_fd_pr__nfet_01v8 L=0.15 W=0.42 nf=1 ad=0.1974 as=0.1974 pd=1.78 ps=1.78 nrd=0.69047619047619  nrs=0.69047619047619 sa=0 sb=0 sd=0 mult=1 m=1
XMRD_cell1_r200_1100_1 rbl_cell1_r200_1100 sn_cell1_r200_1100_1 rwl_des 0 sky130_fd_pr__nfet_01v8 L=0.15 W=0.42 nf=1 ad=0.1974 as=0.1974 pd=1.78 ps=1.78 nrd=0.69047619047619  nrs=0.69047619047619 sa=0 sb=0 sd=0 mult=1 m=1
csn_cell1_r200_1100_1 sn_cell1_r200_1100_1 0 {C_SN}
XMWR_cell1_r200_1100_2 sn_cell1_r200_1100_2 0 0 0 sky130_fd_pr__nfet_01v8 L=0.15 W=0.42 nf=1 ad=0.1974 as=0.1974 pd=1.78 ps=1.78 nrd=0.69047619047619  nrs=0.69047619047619 sa=0 sb=0 sd=0 mult=1 m=1
XMRD_cell1_r200_1100_2 rbl_cell1_r200_1100 sn_cell1_r200_1100_2 rwl_des 0 sky130_fd_pr__nfet_01v8 L=0.15 W=0.42 nf=1 ad=0.1974 as=0.1974 pd=1.78 ps=1.78 nrd=0.69047619047619  nrs=0.69047619047619 sa=0 sb=0 sd=0 mult=1 m=1
csn_cell1_r200_1100_2 sn_cell1_r200_1100_2 0 {C_SN}
XMWR_cell1_r200_1100_3 sn_cell1_r200_1100_3 0 0 0 sky130_fd_pr__nfet_01v8 L=0.15 W=0.42 nf=1 ad=0.1974 as=0.1974 pd=1.78 ps=1.78 nrd=0.69047619047619  nrs=0.69047619047619 sa=0 sb=0 sd=0 mult=1 m=1
XMRD_cell1_r200_1100_3 rbl_cell1_r200_1100 sn_cell1_r200_1100_3 rwl_des 0 sky130_fd_pr__nfet_01v8 L=0.15 W=0.42 nf=1 ad=0.1974 as=0.1974 pd=1.78 ps=1.78 nrd=0.69047619047619  nrs=0.69047619047619 sa=0 sb=0 sd=0 mult=1 m=1
csn_cell1_r200_1100_3 sn_cell1_r200_1100_3 0 {C_SN}
crbl_cell1_r200_1100 rbl_cell1_r200_1100 0 {C_RBL}
spr_cell1_r200_1100 pref_200 ref_cell1_r200_1100 ctl 0 swpre
cref_cell1_r200_1100 ref_cell1_r200_1100 0 {C_RBL}   $ ASSUMPTION: ideal matched dummy load
XMN1_cell1_r200_1100 rbl_cell1_r200_1100 ref_cell1_r200_1100 vn_cell1_r200_1100 0 sky130_fd_pr__nfet_01v8 L=0.15 W=1 nf=1 ad=0.29 as=0.29 pd=2.58 ps=2.58 mult=1 m=1
XMN2_cell1_r200_1100 ref_cell1_r200_1100 rbl_cell1_r200_1100 vn_cell1_r200_1100 0 sky130_fd_pr__nfet_01v8 L=0.15 W=1 nf=1 ad=0.29 as=0.29 pd=2.58 ps=2.58 mult=1 m=1
XMP1_cell1_r200_1100 rbl_cell1_r200_1100 ref_cell1_r200_1100 vp_cell1_r200_1100 vdd sky130_fd_pr__pfet_01v8 L=0.15 W=2 nf=1 ad=0.58 as=0.58 pd=4.58 ps=4.58 mult=1 m=1
XMP2_cell1_r200_1100 ref_cell1_r200_1100 rbl_cell1_r200_1100 vp_cell1_r200_1100 vdd sky130_fd_pr__pfet_01v8 L=0.15 W=2 nf=1 ad=0.58 as=0.58 pd=4.58 ps=4.58 mult=1 m=1
XMNF_cell1_r200_1100 vn_cell1_r200_1100 en 0 0 sky130_fd_pr__nfet_01v8 L=0.15 W=2 nf=1 ad=0.58 as=0.58 pd=4.58 ps=4.58 mult=1 m=1
XMPH_cell1_r200_1100 vp_cell1_r200_1100 enb vdd vdd sky130_fd_pr__pfet_01v8 L=0.15 W=4 nf=1 ad=1.16 as=1.16 pd=8.58 ps=8.58 mult=1 m=1
bd_cell1_r200_1100 d_cell1_r200_1100 0 v=v(rbl_cell1_r200_1100)-v(ref_cell1_r200_1100)
bdabs_cell1_r200_1100 dabs_cell1_r200_1100 0 v=abs(v(rbl_cell1_r200_1100)-v(ref_cell1_r200_1100))

* ---- instance 96: cell1_r200_1150 ----
spa_cell1_r200_1150 prea rbl_cell1_r200_1150 ctl 0 swpre
XMWR_cell1_r200_1150_0 sn_cell1_r200_1150_0 0 0 0 sky130_fd_pr__nfet_01v8 L=0.15 W=0.42 nf=1 ad=0.1974 as=0.1974 pd=1.78 ps=1.78 nrd=0.69047619047619  nrs=0.69047619047619 sa=0 sb=0 sd=0 mult=1 m=1
XMRD_cell1_r200_1150_0 rbl_cell1_r200_1150 sn_cell1_r200_1150_0 rwl_sel 0 sky130_fd_pr__nfet_01v8 L=0.15 W=0.42 nf=1 ad=0.1974 as=0.1974 pd=1.78 ps=1.78 nrd=0.69047619047619  nrs=0.69047619047619 sa=0 sb=0 sd=0 mult=1 m=1
csn_cell1_r200_1150_0 sn_cell1_r200_1150_0 0 {C_SN}
XMWR_cell1_r200_1150_1 sn_cell1_r200_1150_1 0 0 0 sky130_fd_pr__nfet_01v8 L=0.15 W=0.42 nf=1 ad=0.1974 as=0.1974 pd=1.78 ps=1.78 nrd=0.69047619047619  nrs=0.69047619047619 sa=0 sb=0 sd=0 mult=1 m=1
XMRD_cell1_r200_1150_1 rbl_cell1_r200_1150 sn_cell1_r200_1150_1 rwl_des 0 sky130_fd_pr__nfet_01v8 L=0.15 W=0.42 nf=1 ad=0.1974 as=0.1974 pd=1.78 ps=1.78 nrd=0.69047619047619  nrs=0.69047619047619 sa=0 sb=0 sd=0 mult=1 m=1
csn_cell1_r200_1150_1 sn_cell1_r200_1150_1 0 {C_SN}
XMWR_cell1_r200_1150_2 sn_cell1_r200_1150_2 0 0 0 sky130_fd_pr__nfet_01v8 L=0.15 W=0.42 nf=1 ad=0.1974 as=0.1974 pd=1.78 ps=1.78 nrd=0.69047619047619  nrs=0.69047619047619 sa=0 sb=0 sd=0 mult=1 m=1
XMRD_cell1_r200_1150_2 rbl_cell1_r200_1150 sn_cell1_r200_1150_2 rwl_des 0 sky130_fd_pr__nfet_01v8 L=0.15 W=0.42 nf=1 ad=0.1974 as=0.1974 pd=1.78 ps=1.78 nrd=0.69047619047619  nrs=0.69047619047619 sa=0 sb=0 sd=0 mult=1 m=1
csn_cell1_r200_1150_2 sn_cell1_r200_1150_2 0 {C_SN}
XMWR_cell1_r200_1150_3 sn_cell1_r200_1150_3 0 0 0 sky130_fd_pr__nfet_01v8 L=0.15 W=0.42 nf=1 ad=0.1974 as=0.1974 pd=1.78 ps=1.78 nrd=0.69047619047619  nrs=0.69047619047619 sa=0 sb=0 sd=0 mult=1 m=1
XMRD_cell1_r200_1150_3 rbl_cell1_r200_1150 sn_cell1_r200_1150_3 rwl_des 0 sky130_fd_pr__nfet_01v8 L=0.15 W=0.42 nf=1 ad=0.1974 as=0.1974 pd=1.78 ps=1.78 nrd=0.69047619047619  nrs=0.69047619047619 sa=0 sb=0 sd=0 mult=1 m=1
csn_cell1_r200_1150_3 sn_cell1_r200_1150_3 0 {C_SN}
crbl_cell1_r200_1150 rbl_cell1_r200_1150 0 {C_RBL}
spr_cell1_r200_1150 pref_200 ref_cell1_r200_1150 ctl 0 swpre
cref_cell1_r200_1150 ref_cell1_r200_1150 0 {C_RBL}   $ ASSUMPTION: ideal matched dummy load
XMN1_cell1_r200_1150 rbl_cell1_r200_1150 ref_cell1_r200_1150 vn_cell1_r200_1150 0 sky130_fd_pr__nfet_01v8 L=0.15 W=1 nf=1 ad=0.29 as=0.29 pd=2.58 ps=2.58 mult=1 m=1
XMN2_cell1_r200_1150 ref_cell1_r200_1150 rbl_cell1_r200_1150 vn_cell1_r200_1150 0 sky130_fd_pr__nfet_01v8 L=0.15 W=1 nf=1 ad=0.29 as=0.29 pd=2.58 ps=2.58 mult=1 m=1
XMP1_cell1_r200_1150 rbl_cell1_r200_1150 ref_cell1_r200_1150 vp_cell1_r200_1150 vdd sky130_fd_pr__pfet_01v8 L=0.15 W=2 nf=1 ad=0.58 as=0.58 pd=4.58 ps=4.58 mult=1 m=1
XMP2_cell1_r200_1150 ref_cell1_r200_1150 rbl_cell1_r200_1150 vp_cell1_r200_1150 vdd sky130_fd_pr__pfet_01v8 L=0.15 W=2 nf=1 ad=0.58 as=0.58 pd=4.58 ps=4.58 mult=1 m=1
XMNF_cell1_r200_1150 vn_cell1_r200_1150 en 0 0 sky130_fd_pr__nfet_01v8 L=0.15 W=2 nf=1 ad=0.58 as=0.58 pd=4.58 ps=4.58 mult=1 m=1
XMPH_cell1_r200_1150 vp_cell1_r200_1150 enb vdd vdd sky130_fd_pr__pfet_01v8 L=0.15 W=4 nf=1 ad=1.16 as=1.16 pd=8.58 ps=8.58 mult=1 m=1
bd_cell1_r200_1150 d_cell1_r200_1150 0 v=v(rbl_cell1_r200_1150)-v(ref_cell1_r200_1150)
bdabs_cell1_r200_1150 dabs_cell1_r200_1150 0 v=abs(v(rbl_cell1_r200_1150)-v(ref_cell1_r200_1150))

* ---- instance 97: cell1_r200_1200 ----
spa_cell1_r200_1200 prea rbl_cell1_r200_1200 ctl 0 swpre
XMWR_cell1_r200_1200_0 sn_cell1_r200_1200_0 0 0 0 sky130_fd_pr__nfet_01v8 L=0.15 W=0.42 nf=1 ad=0.1974 as=0.1974 pd=1.78 ps=1.78 nrd=0.69047619047619  nrs=0.69047619047619 sa=0 sb=0 sd=0 mult=1 m=1
XMRD_cell1_r200_1200_0 rbl_cell1_r200_1200 sn_cell1_r200_1200_0 rwl_sel 0 sky130_fd_pr__nfet_01v8 L=0.15 W=0.42 nf=1 ad=0.1974 as=0.1974 pd=1.78 ps=1.78 nrd=0.69047619047619  nrs=0.69047619047619 sa=0 sb=0 sd=0 mult=1 m=1
csn_cell1_r200_1200_0 sn_cell1_r200_1200_0 0 {C_SN}
XMWR_cell1_r200_1200_1 sn_cell1_r200_1200_1 0 0 0 sky130_fd_pr__nfet_01v8 L=0.15 W=0.42 nf=1 ad=0.1974 as=0.1974 pd=1.78 ps=1.78 nrd=0.69047619047619  nrs=0.69047619047619 sa=0 sb=0 sd=0 mult=1 m=1
XMRD_cell1_r200_1200_1 rbl_cell1_r200_1200 sn_cell1_r200_1200_1 rwl_des 0 sky130_fd_pr__nfet_01v8 L=0.15 W=0.42 nf=1 ad=0.1974 as=0.1974 pd=1.78 ps=1.78 nrd=0.69047619047619  nrs=0.69047619047619 sa=0 sb=0 sd=0 mult=1 m=1
csn_cell1_r200_1200_1 sn_cell1_r200_1200_1 0 {C_SN}
XMWR_cell1_r200_1200_2 sn_cell1_r200_1200_2 0 0 0 sky130_fd_pr__nfet_01v8 L=0.15 W=0.42 nf=1 ad=0.1974 as=0.1974 pd=1.78 ps=1.78 nrd=0.69047619047619  nrs=0.69047619047619 sa=0 sb=0 sd=0 mult=1 m=1
XMRD_cell1_r200_1200_2 rbl_cell1_r200_1200 sn_cell1_r200_1200_2 rwl_des 0 sky130_fd_pr__nfet_01v8 L=0.15 W=0.42 nf=1 ad=0.1974 as=0.1974 pd=1.78 ps=1.78 nrd=0.69047619047619  nrs=0.69047619047619 sa=0 sb=0 sd=0 mult=1 m=1
csn_cell1_r200_1200_2 sn_cell1_r200_1200_2 0 {C_SN}
XMWR_cell1_r200_1200_3 sn_cell1_r200_1200_3 0 0 0 sky130_fd_pr__nfet_01v8 L=0.15 W=0.42 nf=1 ad=0.1974 as=0.1974 pd=1.78 ps=1.78 nrd=0.69047619047619  nrs=0.69047619047619 sa=0 sb=0 sd=0 mult=1 m=1
XMRD_cell1_r200_1200_3 rbl_cell1_r200_1200 sn_cell1_r200_1200_3 rwl_des 0 sky130_fd_pr__nfet_01v8 L=0.15 W=0.42 nf=1 ad=0.1974 as=0.1974 pd=1.78 ps=1.78 nrd=0.69047619047619  nrs=0.69047619047619 sa=0 sb=0 sd=0 mult=1 m=1
csn_cell1_r200_1200_3 sn_cell1_r200_1200_3 0 {C_SN}
crbl_cell1_r200_1200 rbl_cell1_r200_1200 0 {C_RBL}
spr_cell1_r200_1200 pref_200 ref_cell1_r200_1200 ctl 0 swpre
cref_cell1_r200_1200 ref_cell1_r200_1200 0 {C_RBL}   $ ASSUMPTION: ideal matched dummy load
XMN1_cell1_r200_1200 rbl_cell1_r200_1200 ref_cell1_r200_1200 vn_cell1_r200_1200 0 sky130_fd_pr__nfet_01v8 L=0.15 W=1 nf=1 ad=0.29 as=0.29 pd=2.58 ps=2.58 mult=1 m=1
XMN2_cell1_r200_1200 ref_cell1_r200_1200 rbl_cell1_r200_1200 vn_cell1_r200_1200 0 sky130_fd_pr__nfet_01v8 L=0.15 W=1 nf=1 ad=0.29 as=0.29 pd=2.58 ps=2.58 mult=1 m=1
XMP1_cell1_r200_1200 rbl_cell1_r200_1200 ref_cell1_r200_1200 vp_cell1_r200_1200 vdd sky130_fd_pr__pfet_01v8 L=0.15 W=2 nf=1 ad=0.58 as=0.58 pd=4.58 ps=4.58 mult=1 m=1
XMP2_cell1_r200_1200 ref_cell1_r200_1200 rbl_cell1_r200_1200 vp_cell1_r200_1200 vdd sky130_fd_pr__pfet_01v8 L=0.15 W=2 nf=1 ad=0.58 as=0.58 pd=4.58 ps=4.58 mult=1 m=1
XMNF_cell1_r200_1200 vn_cell1_r200_1200 en 0 0 sky130_fd_pr__nfet_01v8 L=0.15 W=2 nf=1 ad=0.58 as=0.58 pd=4.58 ps=4.58 mult=1 m=1
XMPH_cell1_r200_1200 vp_cell1_r200_1200 enb vdd vdd sky130_fd_pr__pfet_01v8 L=0.15 W=4 nf=1 ad=1.16 as=1.16 pd=8.58 ps=8.58 mult=1 m=1
bd_cell1_r200_1200 d_cell1_r200_1200 0 v=v(rbl_cell1_r200_1200)-v(ref_cell1_r200_1200)
bdabs_cell1_r200_1200 dabs_cell1_r200_1200 0 v=abs(v(rbl_cell1_r200_1200)-v(ref_cell1_r200_1200))

* initial conditions (tran uic): precharged rails, stored levels, tail nodes
.ic v(rbl_st_m100mv)=0.700000 v(ref_st_m100mv)=0.800000 v(vn_st_m100mv)=0.45 v(vp_st_m100mv)=1.35 v(rbl_st_m50mv)=0.750000 v(ref_st_m50mv)=0.800000
.ic v(vn_st_m50mv)=0.45 v(vp_st_m50mv)=1.35 v(rbl_st_m20mv)=0.780000 v(ref_st_m20mv)=0.800000 v(vn_st_m20mv)=0.45 v(vp_st_m20mv)=1.35
.ic v(rbl_st_m10mv)=0.790000 v(ref_st_m10mv)=0.800000 v(vn_st_m10mv)=0.45 v(vp_st_m10mv)=1.35 v(rbl_st_m5mv)=0.795000 v(ref_st_m5mv)=0.800000
.ic v(vn_st_m5mv)=0.45 v(vp_st_m5mv)=1.35 v(rbl_st_m2mv)=0.798000 v(ref_st_m2mv)=0.800000 v(vn_st_m2mv)=0.45 v(vp_st_m2mv)=1.35
.ic v(rbl_st_m1mv)=0.799000 v(ref_st_m1mv)=0.800000 v(vn_st_m1mv)=0.45 v(vp_st_m1mv)=1.35 v(rbl_st_p1mv)=0.801000 v(ref_st_p1mv)=0.800000
.ic v(vn_st_p1mv)=0.45 v(vp_st_p1mv)=1.35 v(rbl_st_p2mv)=0.802000 v(ref_st_p2mv)=0.800000 v(vn_st_p2mv)=0.45 v(vp_st_p2mv)=1.35
.ic v(rbl_st_p5mv)=0.805000 v(ref_st_p5mv)=0.800000 v(vn_st_p5mv)=0.45 v(vp_st_p5mv)=1.35 v(rbl_st_p10mv)=0.810000 v(ref_st_p10mv)=0.800000
.ic v(vn_st_p10mv)=0.45 v(vp_st_p10mv)=1.35 v(rbl_st_p20mv)=0.820000 v(ref_st_p20mv)=0.800000 v(vn_st_p20mv)=0.45 v(vp_st_p20mv)=1.35
.ic v(rbl_st_p50mv)=0.850000 v(ref_st_p50mv)=0.800000 v(vn_st_p50mv)=0.45 v(vp_st_p50mv)=1.35 v(rbl_st_p100mv)=0.900000 v(ref_st_p100mv)=0.800000
.ic v(vn_st_p100mv)=0.45 v(vp_st_p100mv)=1.35 v(rbl_cell0_r020_n100)=0.9 v(sn_cell0_r020_n100_0)=-0.1 v(sn_cell0_r020_n100_1)=-0.1 v(sn_cell0_r020_n100_2)=-0.1
.ic v(sn_cell0_r020_n100_3)=-0.1 v(ref_cell0_r020_n100)=0.880000 v(vn_cell0_r020_n100)=0.45 v(vp_cell0_r020_n100)=1.35 v(rbl_cell0_r020_0000)=0.9 v(sn_cell0_r020_0000_0)=0
.ic v(sn_cell0_r020_0000_1)=0 v(sn_cell0_r020_0000_2)=0 v(sn_cell0_r020_0000_3)=0 v(ref_cell0_r020_0000)=0.880000 v(vn_cell0_r020_0000)=0.45 v(vp_cell0_r020_0000)=1.35
.ic v(rbl_cell1_r020_0300)=0.9 v(sn_cell1_r020_0300_0)=0.3 v(sn_cell1_r020_0300_1)=0.3 v(sn_cell1_r020_0300_2)=0.3 v(sn_cell1_r020_0300_3)=0.3 v(ref_cell1_r020_0300)=0.880000
.ic v(vn_cell1_r020_0300)=0.45 v(vp_cell1_r020_0300)=1.35 v(rbl_cell1_r020_0350)=0.9 v(sn_cell1_r020_0350_0)=0.35 v(sn_cell1_r020_0350_1)=0.35 v(sn_cell1_r020_0350_2)=0.35
.ic v(sn_cell1_r020_0350_3)=0.35 v(ref_cell1_r020_0350)=0.880000 v(vn_cell1_r020_0350)=0.45 v(vp_cell1_r020_0350)=1.35 v(rbl_cell1_r020_0400)=0.9 v(sn_cell1_r020_0400_0)=0.4
.ic v(sn_cell1_r020_0400_1)=0.4 v(sn_cell1_r020_0400_2)=0.4 v(sn_cell1_r020_0400_3)=0.4 v(ref_cell1_r020_0400)=0.880000 v(vn_cell1_r020_0400)=0.45 v(vp_cell1_r020_0400)=1.35
.ic v(rbl_cell1_r020_0450)=0.9 v(sn_cell1_r020_0450_0)=0.45 v(sn_cell1_r020_0450_1)=0.45 v(sn_cell1_r020_0450_2)=0.45 v(sn_cell1_r020_0450_3)=0.45 v(ref_cell1_r020_0450)=0.880000
.ic v(vn_cell1_r020_0450)=0.45 v(vp_cell1_r020_0450)=1.35 v(rbl_cell1_r020_0500)=0.9 v(sn_cell1_r020_0500_0)=0.5 v(sn_cell1_r020_0500_1)=0.5 v(sn_cell1_r020_0500_2)=0.5
.ic v(sn_cell1_r020_0500_3)=0.5 v(ref_cell1_r020_0500)=0.880000 v(vn_cell1_r020_0500)=0.45 v(vp_cell1_r020_0500)=1.35 v(rbl_cell1_r020_0550)=0.9 v(sn_cell1_r020_0550_0)=0.55
.ic v(sn_cell1_r020_0550_1)=0.55 v(sn_cell1_r020_0550_2)=0.55 v(sn_cell1_r020_0550_3)=0.55 v(ref_cell1_r020_0550)=0.880000 v(vn_cell1_r020_0550)=0.45 v(vp_cell1_r020_0550)=1.35
.ic v(rbl_cell1_r020_0600)=0.9 v(sn_cell1_r020_0600_0)=0.6 v(sn_cell1_r020_0600_1)=0.6 v(sn_cell1_r020_0600_2)=0.6 v(sn_cell1_r020_0600_3)=0.6 v(ref_cell1_r020_0600)=0.880000
.ic v(vn_cell1_r020_0600)=0.45 v(vp_cell1_r020_0600)=1.35 v(rbl_cell1_r020_0650)=0.9 v(sn_cell1_r020_0650_0)=0.65 v(sn_cell1_r020_0650_1)=0.65 v(sn_cell1_r020_0650_2)=0.65
.ic v(sn_cell1_r020_0650_3)=0.65 v(ref_cell1_r020_0650)=0.880000 v(vn_cell1_r020_0650)=0.45 v(vp_cell1_r020_0650)=1.35 v(rbl_cell1_r020_0700)=0.9 v(sn_cell1_r020_0700_0)=0.7
.ic v(sn_cell1_r020_0700_1)=0.7 v(sn_cell1_r020_0700_2)=0.7 v(sn_cell1_r020_0700_3)=0.7 v(ref_cell1_r020_0700)=0.880000 v(vn_cell1_r020_0700)=0.45 v(vp_cell1_r020_0700)=1.35
.ic v(rbl_cell1_r020_0750)=0.9 v(sn_cell1_r020_0750_0)=0.75 v(sn_cell1_r020_0750_1)=0.75 v(sn_cell1_r020_0750_2)=0.75 v(sn_cell1_r020_0750_3)=0.75 v(ref_cell1_r020_0750)=0.880000
.ic v(vn_cell1_r020_0750)=0.45 v(vp_cell1_r020_0750)=1.35 v(rbl_cell1_r020_0800)=0.9 v(sn_cell1_r020_0800_0)=0.8 v(sn_cell1_r020_0800_1)=0.8 v(sn_cell1_r020_0800_2)=0.8
.ic v(sn_cell1_r020_0800_3)=0.8 v(ref_cell1_r020_0800)=0.880000 v(vn_cell1_r020_0800)=0.45 v(vp_cell1_r020_0800)=1.35 v(rbl_cell1_r020_0850)=0.9 v(sn_cell1_r020_0850_0)=0.85
.ic v(sn_cell1_r020_0850_1)=0.85 v(sn_cell1_r020_0850_2)=0.85 v(sn_cell1_r020_0850_3)=0.85 v(ref_cell1_r020_0850)=0.880000 v(vn_cell1_r020_0850)=0.45 v(vp_cell1_r020_0850)=1.35
.ic v(rbl_cell1_r020_0900)=0.9 v(sn_cell1_r020_0900_0)=0.9 v(sn_cell1_r020_0900_1)=0.9 v(sn_cell1_r020_0900_2)=0.9 v(sn_cell1_r020_0900_3)=0.9 v(ref_cell1_r020_0900)=0.880000
.ic v(vn_cell1_r020_0900)=0.45 v(vp_cell1_r020_0900)=1.35 v(rbl_cell1_r020_0950)=0.9 v(sn_cell1_r020_0950_0)=0.95 v(sn_cell1_r020_0950_1)=0.95 v(sn_cell1_r020_0950_2)=0.95
.ic v(sn_cell1_r020_0950_3)=0.95 v(ref_cell1_r020_0950)=0.880000 v(vn_cell1_r020_0950)=0.45 v(vp_cell1_r020_0950)=1.35 v(rbl_cell1_r020_1000)=0.9 v(sn_cell1_r020_1000_0)=1
.ic v(sn_cell1_r020_1000_1)=1 v(sn_cell1_r020_1000_2)=1 v(sn_cell1_r020_1000_3)=1 v(ref_cell1_r020_1000)=0.880000 v(vn_cell1_r020_1000)=0.45 v(vp_cell1_r020_1000)=1.35
.ic v(rbl_cell1_r020_1050)=0.9 v(sn_cell1_r020_1050_0)=1.05 v(sn_cell1_r020_1050_1)=1.05 v(sn_cell1_r020_1050_2)=1.05 v(sn_cell1_r020_1050_3)=1.05 v(ref_cell1_r020_1050)=0.880000
.ic v(vn_cell1_r020_1050)=0.45 v(vp_cell1_r020_1050)=1.35 v(rbl_cell1_r020_1100)=0.9 v(sn_cell1_r020_1100_0)=1.1 v(sn_cell1_r020_1100_1)=1.1 v(sn_cell1_r020_1100_2)=1.1
.ic v(sn_cell1_r020_1100_3)=1.1 v(ref_cell1_r020_1100)=0.880000 v(vn_cell1_r020_1100)=0.45 v(vp_cell1_r020_1100)=1.35 v(rbl_cell1_r020_1150)=0.9 v(sn_cell1_r020_1150_0)=1.15
.ic v(sn_cell1_r020_1150_1)=1.15 v(sn_cell1_r020_1150_2)=1.15 v(sn_cell1_r020_1150_3)=1.15 v(ref_cell1_r020_1150)=0.880000 v(vn_cell1_r020_1150)=0.45 v(vp_cell1_r020_1150)=1.35
.ic v(rbl_cell1_r020_1200)=0.9 v(sn_cell1_r020_1200_0)=1.2 v(sn_cell1_r020_1200_1)=1.2 v(sn_cell1_r020_1200_2)=1.2 v(sn_cell1_r020_1200_3)=1.2 v(ref_cell1_r020_1200)=0.880000
.ic v(vn_cell1_r020_1200)=0.45 v(vp_cell1_r020_1200)=1.35 v(rbl_cell0_r050_n100)=0.9 v(sn_cell0_r050_n100_0)=-0.1 v(sn_cell0_r050_n100_1)=-0.1 v(sn_cell0_r050_n100_2)=-0.1
.ic v(sn_cell0_r050_n100_3)=-0.1 v(ref_cell0_r050_n100)=0.850000 v(vn_cell0_r050_n100)=0.45 v(vp_cell0_r050_n100)=1.35 v(rbl_cell0_r050_0000)=0.9 v(sn_cell0_r050_0000_0)=0
.ic v(sn_cell0_r050_0000_1)=0 v(sn_cell0_r050_0000_2)=0 v(sn_cell0_r050_0000_3)=0 v(ref_cell0_r050_0000)=0.850000 v(vn_cell0_r050_0000)=0.45 v(vp_cell0_r050_0000)=1.35
.ic v(rbl_cell1_r050_0300)=0.9 v(sn_cell1_r050_0300_0)=0.3 v(sn_cell1_r050_0300_1)=0.3 v(sn_cell1_r050_0300_2)=0.3 v(sn_cell1_r050_0300_3)=0.3 v(ref_cell1_r050_0300)=0.850000
.ic v(vn_cell1_r050_0300)=0.45 v(vp_cell1_r050_0300)=1.35 v(rbl_cell1_r050_0350)=0.9 v(sn_cell1_r050_0350_0)=0.35 v(sn_cell1_r050_0350_1)=0.35 v(sn_cell1_r050_0350_2)=0.35
.ic v(sn_cell1_r050_0350_3)=0.35 v(ref_cell1_r050_0350)=0.850000 v(vn_cell1_r050_0350)=0.45 v(vp_cell1_r050_0350)=1.35 v(rbl_cell1_r050_0400)=0.9 v(sn_cell1_r050_0400_0)=0.4
.ic v(sn_cell1_r050_0400_1)=0.4 v(sn_cell1_r050_0400_2)=0.4 v(sn_cell1_r050_0400_3)=0.4 v(ref_cell1_r050_0400)=0.850000 v(vn_cell1_r050_0400)=0.45 v(vp_cell1_r050_0400)=1.35
.ic v(rbl_cell1_r050_0450)=0.9 v(sn_cell1_r050_0450_0)=0.45 v(sn_cell1_r050_0450_1)=0.45 v(sn_cell1_r050_0450_2)=0.45 v(sn_cell1_r050_0450_3)=0.45 v(ref_cell1_r050_0450)=0.850000
.ic v(vn_cell1_r050_0450)=0.45 v(vp_cell1_r050_0450)=1.35 v(rbl_cell1_r050_0500)=0.9 v(sn_cell1_r050_0500_0)=0.5 v(sn_cell1_r050_0500_1)=0.5 v(sn_cell1_r050_0500_2)=0.5
.ic v(sn_cell1_r050_0500_3)=0.5 v(ref_cell1_r050_0500)=0.850000 v(vn_cell1_r050_0500)=0.45 v(vp_cell1_r050_0500)=1.35 v(rbl_cell1_r050_0550)=0.9 v(sn_cell1_r050_0550_0)=0.55
.ic v(sn_cell1_r050_0550_1)=0.55 v(sn_cell1_r050_0550_2)=0.55 v(sn_cell1_r050_0550_3)=0.55 v(ref_cell1_r050_0550)=0.850000 v(vn_cell1_r050_0550)=0.45 v(vp_cell1_r050_0550)=1.35
.ic v(rbl_cell1_r050_0600)=0.9 v(sn_cell1_r050_0600_0)=0.6 v(sn_cell1_r050_0600_1)=0.6 v(sn_cell1_r050_0600_2)=0.6 v(sn_cell1_r050_0600_3)=0.6 v(ref_cell1_r050_0600)=0.850000
.ic v(vn_cell1_r050_0600)=0.45 v(vp_cell1_r050_0600)=1.35 v(rbl_cell1_r050_0650)=0.9 v(sn_cell1_r050_0650_0)=0.65 v(sn_cell1_r050_0650_1)=0.65 v(sn_cell1_r050_0650_2)=0.65
.ic v(sn_cell1_r050_0650_3)=0.65 v(ref_cell1_r050_0650)=0.850000 v(vn_cell1_r050_0650)=0.45 v(vp_cell1_r050_0650)=1.35 v(rbl_cell1_r050_0700)=0.9 v(sn_cell1_r050_0700_0)=0.7
.ic v(sn_cell1_r050_0700_1)=0.7 v(sn_cell1_r050_0700_2)=0.7 v(sn_cell1_r050_0700_3)=0.7 v(ref_cell1_r050_0700)=0.850000 v(vn_cell1_r050_0700)=0.45 v(vp_cell1_r050_0700)=1.35
.ic v(rbl_cell1_r050_0750)=0.9 v(sn_cell1_r050_0750_0)=0.75 v(sn_cell1_r050_0750_1)=0.75 v(sn_cell1_r050_0750_2)=0.75 v(sn_cell1_r050_0750_3)=0.75 v(ref_cell1_r050_0750)=0.850000
.ic v(vn_cell1_r050_0750)=0.45 v(vp_cell1_r050_0750)=1.35 v(rbl_cell1_r050_0800)=0.9 v(sn_cell1_r050_0800_0)=0.8 v(sn_cell1_r050_0800_1)=0.8 v(sn_cell1_r050_0800_2)=0.8
.ic v(sn_cell1_r050_0800_3)=0.8 v(ref_cell1_r050_0800)=0.850000 v(vn_cell1_r050_0800)=0.45 v(vp_cell1_r050_0800)=1.35 v(rbl_cell1_r050_0850)=0.9 v(sn_cell1_r050_0850_0)=0.85
.ic v(sn_cell1_r050_0850_1)=0.85 v(sn_cell1_r050_0850_2)=0.85 v(sn_cell1_r050_0850_3)=0.85 v(ref_cell1_r050_0850)=0.850000 v(vn_cell1_r050_0850)=0.45 v(vp_cell1_r050_0850)=1.35
.ic v(rbl_cell1_r050_0900)=0.9 v(sn_cell1_r050_0900_0)=0.9 v(sn_cell1_r050_0900_1)=0.9 v(sn_cell1_r050_0900_2)=0.9 v(sn_cell1_r050_0900_3)=0.9 v(ref_cell1_r050_0900)=0.850000
.ic v(vn_cell1_r050_0900)=0.45 v(vp_cell1_r050_0900)=1.35 v(rbl_cell1_r050_0950)=0.9 v(sn_cell1_r050_0950_0)=0.95 v(sn_cell1_r050_0950_1)=0.95 v(sn_cell1_r050_0950_2)=0.95
.ic v(sn_cell1_r050_0950_3)=0.95 v(ref_cell1_r050_0950)=0.850000 v(vn_cell1_r050_0950)=0.45 v(vp_cell1_r050_0950)=1.35 v(rbl_cell1_r050_1000)=0.9 v(sn_cell1_r050_1000_0)=1
.ic v(sn_cell1_r050_1000_1)=1 v(sn_cell1_r050_1000_2)=1 v(sn_cell1_r050_1000_3)=1 v(ref_cell1_r050_1000)=0.850000 v(vn_cell1_r050_1000)=0.45 v(vp_cell1_r050_1000)=1.35
.ic v(rbl_cell1_r050_1050)=0.9 v(sn_cell1_r050_1050_0)=1.05 v(sn_cell1_r050_1050_1)=1.05 v(sn_cell1_r050_1050_2)=1.05 v(sn_cell1_r050_1050_3)=1.05 v(ref_cell1_r050_1050)=0.850000
.ic v(vn_cell1_r050_1050)=0.45 v(vp_cell1_r050_1050)=1.35 v(rbl_cell1_r050_1100)=0.9 v(sn_cell1_r050_1100_0)=1.1 v(sn_cell1_r050_1100_1)=1.1 v(sn_cell1_r050_1100_2)=1.1
.ic v(sn_cell1_r050_1100_3)=1.1 v(ref_cell1_r050_1100)=0.850000 v(vn_cell1_r050_1100)=0.45 v(vp_cell1_r050_1100)=1.35 v(rbl_cell1_r050_1150)=0.9 v(sn_cell1_r050_1150_0)=1.15
.ic v(sn_cell1_r050_1150_1)=1.15 v(sn_cell1_r050_1150_2)=1.15 v(sn_cell1_r050_1150_3)=1.15 v(ref_cell1_r050_1150)=0.850000 v(vn_cell1_r050_1150)=0.45 v(vp_cell1_r050_1150)=1.35
.ic v(rbl_cell1_r050_1200)=0.9 v(sn_cell1_r050_1200_0)=1.2 v(sn_cell1_r050_1200_1)=1.2 v(sn_cell1_r050_1200_2)=1.2 v(sn_cell1_r050_1200_3)=1.2 v(ref_cell1_r050_1200)=0.850000
.ic v(vn_cell1_r050_1200)=0.45 v(vp_cell1_r050_1200)=1.35 v(rbl_cell0_r100_n100)=0.9 v(sn_cell0_r100_n100_0)=-0.1 v(sn_cell0_r100_n100_1)=-0.1 v(sn_cell0_r100_n100_2)=-0.1
.ic v(sn_cell0_r100_n100_3)=-0.1 v(ref_cell0_r100_n100)=0.800000 v(vn_cell0_r100_n100)=0.45 v(vp_cell0_r100_n100)=1.35 v(rbl_cell0_r100_0000)=0.9 v(sn_cell0_r100_0000_0)=0
.ic v(sn_cell0_r100_0000_1)=0 v(sn_cell0_r100_0000_2)=0 v(sn_cell0_r100_0000_3)=0 v(ref_cell0_r100_0000)=0.800000 v(vn_cell0_r100_0000)=0.45 v(vp_cell0_r100_0000)=1.35
.ic v(rbl_cell1_r100_0300)=0.9 v(sn_cell1_r100_0300_0)=0.3 v(sn_cell1_r100_0300_1)=0.3 v(sn_cell1_r100_0300_2)=0.3 v(sn_cell1_r100_0300_3)=0.3 v(ref_cell1_r100_0300)=0.800000
.ic v(vn_cell1_r100_0300)=0.45 v(vp_cell1_r100_0300)=1.35 v(rbl_cell1_r100_0350)=0.9 v(sn_cell1_r100_0350_0)=0.35 v(sn_cell1_r100_0350_1)=0.35 v(sn_cell1_r100_0350_2)=0.35
.ic v(sn_cell1_r100_0350_3)=0.35 v(ref_cell1_r100_0350)=0.800000 v(vn_cell1_r100_0350)=0.45 v(vp_cell1_r100_0350)=1.35 v(rbl_cell1_r100_0400)=0.9 v(sn_cell1_r100_0400_0)=0.4
.ic v(sn_cell1_r100_0400_1)=0.4 v(sn_cell1_r100_0400_2)=0.4 v(sn_cell1_r100_0400_3)=0.4 v(ref_cell1_r100_0400)=0.800000 v(vn_cell1_r100_0400)=0.45 v(vp_cell1_r100_0400)=1.35
.ic v(rbl_cell1_r100_0450)=0.9 v(sn_cell1_r100_0450_0)=0.45 v(sn_cell1_r100_0450_1)=0.45 v(sn_cell1_r100_0450_2)=0.45 v(sn_cell1_r100_0450_3)=0.45 v(ref_cell1_r100_0450)=0.800000
.ic v(vn_cell1_r100_0450)=0.45 v(vp_cell1_r100_0450)=1.35 v(rbl_cell1_r100_0500)=0.9 v(sn_cell1_r100_0500_0)=0.5 v(sn_cell1_r100_0500_1)=0.5 v(sn_cell1_r100_0500_2)=0.5
.ic v(sn_cell1_r100_0500_3)=0.5 v(ref_cell1_r100_0500)=0.800000 v(vn_cell1_r100_0500)=0.45 v(vp_cell1_r100_0500)=1.35 v(rbl_cell1_r100_0550)=0.9 v(sn_cell1_r100_0550_0)=0.55
.ic v(sn_cell1_r100_0550_1)=0.55 v(sn_cell1_r100_0550_2)=0.55 v(sn_cell1_r100_0550_3)=0.55 v(ref_cell1_r100_0550)=0.800000 v(vn_cell1_r100_0550)=0.45 v(vp_cell1_r100_0550)=1.35
.ic v(rbl_cell1_r100_0600)=0.9 v(sn_cell1_r100_0600_0)=0.6 v(sn_cell1_r100_0600_1)=0.6 v(sn_cell1_r100_0600_2)=0.6 v(sn_cell1_r100_0600_3)=0.6 v(ref_cell1_r100_0600)=0.800000
.ic v(vn_cell1_r100_0600)=0.45 v(vp_cell1_r100_0600)=1.35 v(rbl_cell1_r100_0650)=0.9 v(sn_cell1_r100_0650_0)=0.65 v(sn_cell1_r100_0650_1)=0.65 v(sn_cell1_r100_0650_2)=0.65
.ic v(sn_cell1_r100_0650_3)=0.65 v(ref_cell1_r100_0650)=0.800000 v(vn_cell1_r100_0650)=0.45 v(vp_cell1_r100_0650)=1.35 v(rbl_cell1_r100_0700)=0.9 v(sn_cell1_r100_0700_0)=0.7
.ic v(sn_cell1_r100_0700_1)=0.7 v(sn_cell1_r100_0700_2)=0.7 v(sn_cell1_r100_0700_3)=0.7 v(ref_cell1_r100_0700)=0.800000 v(vn_cell1_r100_0700)=0.45 v(vp_cell1_r100_0700)=1.35
.ic v(rbl_cell1_r100_0750)=0.9 v(sn_cell1_r100_0750_0)=0.75 v(sn_cell1_r100_0750_1)=0.75 v(sn_cell1_r100_0750_2)=0.75 v(sn_cell1_r100_0750_3)=0.75 v(ref_cell1_r100_0750)=0.800000
.ic v(vn_cell1_r100_0750)=0.45 v(vp_cell1_r100_0750)=1.35 v(rbl_cell1_r100_0800)=0.9 v(sn_cell1_r100_0800_0)=0.8 v(sn_cell1_r100_0800_1)=0.8 v(sn_cell1_r100_0800_2)=0.8
.ic v(sn_cell1_r100_0800_3)=0.8 v(ref_cell1_r100_0800)=0.800000 v(vn_cell1_r100_0800)=0.45 v(vp_cell1_r100_0800)=1.35 v(rbl_cell1_r100_0850)=0.9 v(sn_cell1_r100_0850_0)=0.85
.ic v(sn_cell1_r100_0850_1)=0.85 v(sn_cell1_r100_0850_2)=0.85 v(sn_cell1_r100_0850_3)=0.85 v(ref_cell1_r100_0850)=0.800000 v(vn_cell1_r100_0850)=0.45 v(vp_cell1_r100_0850)=1.35
.ic v(rbl_cell1_r100_0900)=0.9 v(sn_cell1_r100_0900_0)=0.9 v(sn_cell1_r100_0900_1)=0.9 v(sn_cell1_r100_0900_2)=0.9 v(sn_cell1_r100_0900_3)=0.9 v(ref_cell1_r100_0900)=0.800000
.ic v(vn_cell1_r100_0900)=0.45 v(vp_cell1_r100_0900)=1.35 v(rbl_cell1_r100_0950)=0.9 v(sn_cell1_r100_0950_0)=0.95 v(sn_cell1_r100_0950_1)=0.95 v(sn_cell1_r100_0950_2)=0.95
.ic v(sn_cell1_r100_0950_3)=0.95 v(ref_cell1_r100_0950)=0.800000 v(vn_cell1_r100_0950)=0.45 v(vp_cell1_r100_0950)=1.35 v(rbl_cell1_r100_1000)=0.9 v(sn_cell1_r100_1000_0)=1
.ic v(sn_cell1_r100_1000_1)=1 v(sn_cell1_r100_1000_2)=1 v(sn_cell1_r100_1000_3)=1 v(ref_cell1_r100_1000)=0.800000 v(vn_cell1_r100_1000)=0.45 v(vp_cell1_r100_1000)=1.35
.ic v(rbl_cell1_r100_1050)=0.9 v(sn_cell1_r100_1050_0)=1.05 v(sn_cell1_r100_1050_1)=1.05 v(sn_cell1_r100_1050_2)=1.05 v(sn_cell1_r100_1050_3)=1.05 v(ref_cell1_r100_1050)=0.800000
.ic v(vn_cell1_r100_1050)=0.45 v(vp_cell1_r100_1050)=1.35 v(rbl_cell1_r100_1100)=0.9 v(sn_cell1_r100_1100_0)=1.1 v(sn_cell1_r100_1100_1)=1.1 v(sn_cell1_r100_1100_2)=1.1
.ic v(sn_cell1_r100_1100_3)=1.1 v(ref_cell1_r100_1100)=0.800000 v(vn_cell1_r100_1100)=0.45 v(vp_cell1_r100_1100)=1.35 v(rbl_cell1_r100_1150)=0.9 v(sn_cell1_r100_1150_0)=1.15
.ic v(sn_cell1_r100_1150_1)=1.15 v(sn_cell1_r100_1150_2)=1.15 v(sn_cell1_r100_1150_3)=1.15 v(ref_cell1_r100_1150)=0.800000 v(vn_cell1_r100_1150)=0.45 v(vp_cell1_r100_1150)=1.35
.ic v(rbl_cell1_r100_1200)=0.9 v(sn_cell1_r100_1200_0)=1.2 v(sn_cell1_r100_1200_1)=1.2 v(sn_cell1_r100_1200_2)=1.2 v(sn_cell1_r100_1200_3)=1.2 v(ref_cell1_r100_1200)=0.800000
.ic v(vn_cell1_r100_1200)=0.45 v(vp_cell1_r100_1200)=1.35 v(rbl_cell0_r200_n100)=0.9 v(sn_cell0_r200_n100_0)=-0.1 v(sn_cell0_r200_n100_1)=-0.1 v(sn_cell0_r200_n100_2)=-0.1
.ic v(sn_cell0_r200_n100_3)=-0.1 v(ref_cell0_r200_n100)=0.700000 v(vn_cell0_r200_n100)=0.45 v(vp_cell0_r200_n100)=1.35 v(rbl_cell0_r200_0000)=0.9 v(sn_cell0_r200_0000_0)=0
.ic v(sn_cell0_r200_0000_1)=0 v(sn_cell0_r200_0000_2)=0 v(sn_cell0_r200_0000_3)=0 v(ref_cell0_r200_0000)=0.700000 v(vn_cell0_r200_0000)=0.45 v(vp_cell0_r200_0000)=1.35
.ic v(rbl_cell1_r200_0300)=0.9 v(sn_cell1_r200_0300_0)=0.3 v(sn_cell1_r200_0300_1)=0.3 v(sn_cell1_r200_0300_2)=0.3 v(sn_cell1_r200_0300_3)=0.3 v(ref_cell1_r200_0300)=0.700000
.ic v(vn_cell1_r200_0300)=0.45 v(vp_cell1_r200_0300)=1.35 v(rbl_cell1_r200_0350)=0.9 v(sn_cell1_r200_0350_0)=0.35 v(sn_cell1_r200_0350_1)=0.35 v(sn_cell1_r200_0350_2)=0.35
.ic v(sn_cell1_r200_0350_3)=0.35 v(ref_cell1_r200_0350)=0.700000 v(vn_cell1_r200_0350)=0.45 v(vp_cell1_r200_0350)=1.35 v(rbl_cell1_r200_0400)=0.9 v(sn_cell1_r200_0400_0)=0.4
.ic v(sn_cell1_r200_0400_1)=0.4 v(sn_cell1_r200_0400_2)=0.4 v(sn_cell1_r200_0400_3)=0.4 v(ref_cell1_r200_0400)=0.700000 v(vn_cell1_r200_0400)=0.45 v(vp_cell1_r200_0400)=1.35
.ic v(rbl_cell1_r200_0450)=0.9 v(sn_cell1_r200_0450_0)=0.45 v(sn_cell1_r200_0450_1)=0.45 v(sn_cell1_r200_0450_2)=0.45 v(sn_cell1_r200_0450_3)=0.45 v(ref_cell1_r200_0450)=0.700000
.ic v(vn_cell1_r200_0450)=0.45 v(vp_cell1_r200_0450)=1.35 v(rbl_cell1_r200_0500)=0.9 v(sn_cell1_r200_0500_0)=0.5 v(sn_cell1_r200_0500_1)=0.5 v(sn_cell1_r200_0500_2)=0.5
.ic v(sn_cell1_r200_0500_3)=0.5 v(ref_cell1_r200_0500)=0.700000 v(vn_cell1_r200_0500)=0.45 v(vp_cell1_r200_0500)=1.35 v(rbl_cell1_r200_0550)=0.9 v(sn_cell1_r200_0550_0)=0.55
.ic v(sn_cell1_r200_0550_1)=0.55 v(sn_cell1_r200_0550_2)=0.55 v(sn_cell1_r200_0550_3)=0.55 v(ref_cell1_r200_0550)=0.700000 v(vn_cell1_r200_0550)=0.45 v(vp_cell1_r200_0550)=1.35
.ic v(rbl_cell1_r200_0600)=0.9 v(sn_cell1_r200_0600_0)=0.6 v(sn_cell1_r200_0600_1)=0.6 v(sn_cell1_r200_0600_2)=0.6 v(sn_cell1_r200_0600_3)=0.6 v(ref_cell1_r200_0600)=0.700000
.ic v(vn_cell1_r200_0600)=0.45 v(vp_cell1_r200_0600)=1.35 v(rbl_cell1_r200_0650)=0.9 v(sn_cell1_r200_0650_0)=0.65 v(sn_cell1_r200_0650_1)=0.65 v(sn_cell1_r200_0650_2)=0.65
.ic v(sn_cell1_r200_0650_3)=0.65 v(ref_cell1_r200_0650)=0.700000 v(vn_cell1_r200_0650)=0.45 v(vp_cell1_r200_0650)=1.35 v(rbl_cell1_r200_0700)=0.9 v(sn_cell1_r200_0700_0)=0.7
.ic v(sn_cell1_r200_0700_1)=0.7 v(sn_cell1_r200_0700_2)=0.7 v(sn_cell1_r200_0700_3)=0.7 v(ref_cell1_r200_0700)=0.700000 v(vn_cell1_r200_0700)=0.45 v(vp_cell1_r200_0700)=1.35
.ic v(rbl_cell1_r200_0750)=0.9 v(sn_cell1_r200_0750_0)=0.75 v(sn_cell1_r200_0750_1)=0.75 v(sn_cell1_r200_0750_2)=0.75 v(sn_cell1_r200_0750_3)=0.75 v(ref_cell1_r200_0750)=0.700000
.ic v(vn_cell1_r200_0750)=0.45 v(vp_cell1_r200_0750)=1.35 v(rbl_cell1_r200_0800)=0.9 v(sn_cell1_r200_0800_0)=0.8 v(sn_cell1_r200_0800_1)=0.8 v(sn_cell1_r200_0800_2)=0.8
.ic v(sn_cell1_r200_0800_3)=0.8 v(ref_cell1_r200_0800)=0.700000 v(vn_cell1_r200_0800)=0.45 v(vp_cell1_r200_0800)=1.35 v(rbl_cell1_r200_0850)=0.9 v(sn_cell1_r200_0850_0)=0.85
.ic v(sn_cell1_r200_0850_1)=0.85 v(sn_cell1_r200_0850_2)=0.85 v(sn_cell1_r200_0850_3)=0.85 v(ref_cell1_r200_0850)=0.700000 v(vn_cell1_r200_0850)=0.45 v(vp_cell1_r200_0850)=1.35
.ic v(rbl_cell1_r200_0900)=0.9 v(sn_cell1_r200_0900_0)=0.9 v(sn_cell1_r200_0900_1)=0.9 v(sn_cell1_r200_0900_2)=0.9 v(sn_cell1_r200_0900_3)=0.9 v(ref_cell1_r200_0900)=0.700000
.ic v(vn_cell1_r200_0900)=0.45 v(vp_cell1_r200_0900)=1.35 v(rbl_cell1_r200_0950)=0.9 v(sn_cell1_r200_0950_0)=0.95 v(sn_cell1_r200_0950_1)=0.95 v(sn_cell1_r200_0950_2)=0.95
.ic v(sn_cell1_r200_0950_3)=0.95 v(ref_cell1_r200_0950)=0.700000 v(vn_cell1_r200_0950)=0.45 v(vp_cell1_r200_0950)=1.35 v(rbl_cell1_r200_1000)=0.9 v(sn_cell1_r200_1000_0)=1
.ic v(sn_cell1_r200_1000_1)=1 v(sn_cell1_r200_1000_2)=1 v(sn_cell1_r200_1000_3)=1 v(ref_cell1_r200_1000)=0.700000 v(vn_cell1_r200_1000)=0.45 v(vp_cell1_r200_1000)=1.35
.ic v(rbl_cell1_r200_1050)=0.9 v(sn_cell1_r200_1050_0)=1.05 v(sn_cell1_r200_1050_1)=1.05 v(sn_cell1_r200_1050_2)=1.05 v(sn_cell1_r200_1050_3)=1.05 v(ref_cell1_r200_1050)=0.700000
.ic v(vn_cell1_r200_1050)=0.45 v(vp_cell1_r200_1050)=1.35 v(rbl_cell1_r200_1100)=0.9 v(sn_cell1_r200_1100_0)=1.1 v(sn_cell1_r200_1100_1)=1.1 v(sn_cell1_r200_1100_2)=1.1
.ic v(sn_cell1_r200_1100_3)=1.1 v(ref_cell1_r200_1100)=0.700000 v(vn_cell1_r200_1100)=0.45 v(vp_cell1_r200_1100)=1.35 v(rbl_cell1_r200_1150)=0.9 v(sn_cell1_r200_1150_0)=1.15
.ic v(sn_cell1_r200_1150_1)=1.15 v(sn_cell1_r200_1150_2)=1.15 v(sn_cell1_r200_1150_3)=1.15 v(ref_cell1_r200_1150)=0.700000 v(vn_cell1_r200_1150)=0.45 v(vp_cell1_r200_1150)=1.35
.ic v(rbl_cell1_r200_1200)=0.9 v(sn_cell1_r200_1200_0)=1.2 v(sn_cell1_r200_1200_1)=1.2 v(sn_cell1_r200_1200_2)=1.2 v(sn_cell1_r200_1200_3)=1.2 v(ref_cell1_r200_1200)=0.700000
.ic v(vn_cell1_r200_1200)=0.45 v(vp_cell1_r200_1200)=1.35
