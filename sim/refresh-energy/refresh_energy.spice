* refresh_energy.spice -- ideal-driver array-boundary energy of one row refresh of the extracted
* 4x4 2T gain-cell array, and matched idle control (issue #115). GENERATED by gen_refresh_energy.py;
* do not edit by hand.
*
* PROPOSED/UNRATIFIED SCOPE: 27 C / 125 C, five global corners, 1.8 V (spec/operating-range-decision-PROPOSED.md).
* CIRCUIT BODY for `klt sim`: no .control/.end; .lib/.temp are appended per corner by klt.
*
* Instances (each the committed extracted array, own sources, no shared drivers):
*   act_<p>  refresh of row 0 (precharge -> RWL0 select -> 10 ns sense -> 10 ns WWL0 write-back of the
*            stored bit -> release); idl_<p> matched idle (standby levels, no pulses); nop_c active code
*            path with every pulse at its standby level (control); refw = #110 reference write (SN 0 V,
*            ideal 1.8 V WBL, 20 ns WWL) -- its energy is NOT measured.
*   <p> = z all-zero, o all-one, c checkerboard (bit = (r+c) even), i inverse checkerboard.
* Power nodes p{n,g,r}_<source> = net / max(p,0) / max(-p,0) of p = -v*i in W.
* ASSUMPTIONS (none is a spec value): ideal drivers, ideal 100 ohm precharge switch, stored '1' 0.9 V,
* idle WBL 0 V, standby RBL precharged, ideal decision, global corners only (no mismatch).

.options method=trap gmin=1e-15 abstol=1e-15 chgtol=1e-18
.model swpre sw(vt=0.9 vh=0.1 ron=100 roff=1e12)

* ---- instance act_z: mode active, pattern zero ----
xm1_act_z sn_0_0__t0_act_z wl_0__t3_act_z bl_0__t0_act_z gnd__t0_act_z sky130_fd_pr__nfet_01v8 L=0.15 W=0.42 nf=1 ad=0.1974 as=0.1974 pd=1.78 ps=1.78 mult=1 m=1
xm2_act_z rbl_0__t0_act_z sn_0_0__t1_act_z rwl_0__t0_act_z gnd__t1_act_z sky130_fd_pr__nfet_01v8 L=0.15 W=0.42 nf=1 ad=0.1974 as=0.1974 pd=1.78 ps=1.78 mult=1 m=1
xm3_act_z sn_0_1__t1_act_z wl_0__t0_act_z bl_1__t0_act_z gnd__t2_act_z sky130_fd_pr__nfet_01v8 L=0.15 W=0.42 nf=1 ad=0.1974 as=0.1974 pd=1.78 ps=1.78 mult=1 m=1
xm4_act_z rbl_1__t0_act_z sn_0_1__t0_act_z rwl_0__t1_act_z gnd__t3_act_z sky130_fd_pr__nfet_01v8 L=0.15 W=0.42 nf=1 ad=0.1974 as=0.1974 pd=1.78 ps=1.78 mult=1 m=1
xm5_act_z sn_0_2__t1_act_z wl_0__t1_act_z bl_2__t0_act_z gnd__t4_act_z sky130_fd_pr__nfet_01v8 L=0.15 W=0.42 nf=1 ad=0.1974 as=0.1974 pd=1.78 ps=1.78 mult=1 m=1
xm6_act_z rbl_2__t0_act_z sn_0_2__t0_act_z rwl_0__t2_act_z gnd__t5_act_z sky130_fd_pr__nfet_01v8 L=0.15 W=0.42 nf=1 ad=0.1974 as=0.1974 pd=1.78 ps=1.78 mult=1 m=1
xm7_act_z sn_0_3__t1_act_z wl_0__t2_act_z bl_3__t0_act_z gnd__t6_act_z sky130_fd_pr__nfet_01v8 L=0.15 W=0.42 nf=1 ad=0.1974 as=0.1974 pd=1.78 ps=1.78 mult=1 m=1
xm8_act_z rbl_3__t0_act_z sn_0_3__t0_act_z rwl_0__t3_act_z gnd__t7_act_z sky130_fd_pr__nfet_01v8 L=0.15 W=0.42 nf=1 ad=0.1974 as=0.1974 pd=1.78 ps=1.78 mult=1 m=1
xm9_act_z sn_1_0__t1_act_z wl_1__t0_act_z bl_0__t1_act_z gnd__t8_act_z sky130_fd_pr__nfet_01v8 L=0.15 W=0.42 nf=1 ad=0.1974 as=0.1974 pd=1.78 ps=1.78 mult=1 m=1
xm10_act_z rbl_0__t1_act_z sn_1_0__t0_act_z rwl_1__t0_act_z gnd__t9_act_z sky130_fd_pr__nfet_01v8 L=0.15 W=0.42 nf=1 ad=0.1974 as=0.1974 pd=1.78 ps=1.78 mult=1 m=1
xm11_act_z sn_1_1__t1_act_z wl_1__t1_act_z bl_1__t1_act_z gnd__t10_act_z sky130_fd_pr__nfet_01v8 L=0.15 W=0.42 nf=1 ad=0.1974 as=0.1974 pd=1.78 ps=1.78 mult=1 m=1
xm12_act_z rbl_1__t1_act_z sn_1_1__t0_act_z rwl_1__t1_act_z gnd__t11_act_z sky130_fd_pr__nfet_01v8 L=0.15 W=0.42 nf=1 ad=0.1974 as=0.1974 pd=1.78 ps=1.78 mult=1 m=1
xm13_act_z sn_1_2__t1_act_z wl_1__t2_act_z bl_2__t1_act_z gnd__t12_act_z sky130_fd_pr__nfet_01v8 L=0.15 W=0.42 nf=1 ad=0.1974 as=0.1974 pd=1.78 ps=1.78 mult=1 m=1
xm14_act_z rbl_2__t1_act_z sn_1_2__t0_act_z rwl_1__t2_act_z gnd__t13_act_z sky130_fd_pr__nfet_01v8 L=0.15 W=0.42 nf=1 ad=0.1974 as=0.1974 pd=1.78 ps=1.78 mult=1 m=1
xm15_act_z sn_1_3__t1_act_z wl_1__t3_act_z bl_3__t1_act_z gnd__t14_act_z sky130_fd_pr__nfet_01v8 L=0.15 W=0.42 nf=1 ad=0.1974 as=0.1974 pd=1.78 ps=1.78 mult=1 m=1
xm16_act_z rbl_3__t1_act_z sn_1_3__t0_act_z rwl_1__t3_act_z gnd__t15_act_z sky130_fd_pr__nfet_01v8 L=0.15 W=0.42 nf=1 ad=0.1974 as=0.1974 pd=1.78 ps=1.78 mult=1 m=1
xm17_act_z sn_2_0__t1_act_z wl_2__t3_act_z bl_0__t3_act_z gnd__t16_act_z sky130_fd_pr__nfet_01v8 L=0.15 W=0.42 nf=1 ad=0.1974 as=0.1974 pd=1.78 ps=1.78 mult=1 m=1
xm18_act_z rbl_0__t2_act_z sn_2_0__t0_act_z rwl_2__t0_act_z gnd__t17_act_z sky130_fd_pr__nfet_01v8 L=0.15 W=0.42 nf=1 ad=0.1974 as=0.1974 pd=1.78 ps=1.78 mult=1 m=1
xm19_act_z sn_2_1__t1_act_z wl_2__t0_act_z bl_1__t2_act_z gnd__t18_act_z sky130_fd_pr__nfet_01v8 L=0.15 W=0.42 nf=1 ad=0.1974 as=0.1974 pd=1.78 ps=1.78 mult=1 m=1
xm20_act_z rbl_1__t2_act_z sn_2_1__t0_act_z rwl_2__t1_act_z gnd__t19_act_z sky130_fd_pr__nfet_01v8 L=0.15 W=0.42 nf=1 ad=0.1974 as=0.1974 pd=1.78 ps=1.78 mult=1 m=1
xm21_act_z sn_2_2__t1_act_z wl_2__t1_act_z bl_2__t2_act_z gnd__t20_act_z sky130_fd_pr__nfet_01v8 L=0.15 W=0.42 nf=1 ad=0.1974 as=0.1974 pd=1.78 ps=1.78 mult=1 m=1
xm22_act_z rbl_2__t2_act_z sn_2_2__t0_act_z rwl_2__t2_act_z gnd__t21_act_z sky130_fd_pr__nfet_01v8 L=0.15 W=0.42 nf=1 ad=0.1974 as=0.1974 pd=1.78 ps=1.78 mult=1 m=1
xm23_act_z sn_2_3__t1_act_z wl_2__t2_act_z bl_3__t2_act_z gnd__t22_act_z sky130_fd_pr__nfet_01v8 L=0.15 W=0.42 nf=1 ad=0.1974 as=0.1974 pd=1.78 ps=1.78 mult=1 m=1
xm24_act_z rbl_3__t2_act_z sn_2_3__t0_act_z rwl_2__t3_act_z gnd__t23_act_z sky130_fd_pr__nfet_01v8 L=0.15 W=0.42 nf=1 ad=0.1974 as=0.1974 pd=1.78 ps=1.78 mult=1 m=1
xm25_act_z sn_3_0__t1_act_z wl_3__t0_act_z bl_0__t2_act_z gnd__t24_act_z sky130_fd_pr__nfet_01v8 L=0.15 W=0.42 nf=1 ad=0.1974 as=0.1974 pd=1.78 ps=1.78 mult=1 m=1
xm26_act_z rbl_0__t3_act_z sn_3_0__t0_act_z rwl_3__t0_act_z gnd__t25_act_z sky130_fd_pr__nfet_01v8 L=0.15 W=0.42 nf=1 ad=0.1974 as=0.1974 pd=1.78 ps=1.78 mult=1 m=1
xm27_act_z sn_3_1__t1_act_z wl_3__t1_act_z bl_1__t3_act_z gnd__t26_act_z sky130_fd_pr__nfet_01v8 L=0.15 W=0.42 nf=1 ad=0.1974 as=0.1974 pd=1.78 ps=1.78 mult=1 m=1
xm28_act_z rbl_1__t3_act_z sn_3_1__t0_act_z rwl_3__t1_act_z gnd__t27_act_z sky130_fd_pr__nfet_01v8 L=0.15 W=0.42 nf=1 ad=0.1974 as=0.1974 pd=1.78 ps=1.78 mult=1 m=1
xm29_act_z sn_3_2__t1_act_z wl_3__t2_act_z bl_2__t3_act_z gnd__t28_act_z sky130_fd_pr__nfet_01v8 L=0.15 W=0.42 nf=1 ad=0.1974 as=0.1974 pd=1.78 ps=1.78 mult=1 m=1
xm30_act_z rbl_2__t3_act_z sn_3_2__t0_act_z rwl_3__t2_act_z gnd__t29_act_z sky130_fd_pr__nfet_01v8 L=0.15 W=0.42 nf=1 ad=0.1974 as=0.1974 pd=1.78 ps=1.78 mult=1 m=1
xm31_act_z sn_3_3__t1_act_z wl_3__t3_act_z bl_3__t3_act_z gnd__t30_act_z sky130_fd_pr__nfet_01v8 L=0.15 W=0.42 nf=1 ad=0.1974 as=0.1974 pd=1.78 ps=1.78 mult=1 m=1
xm32_act_z rbl_3__t3_act_z sn_3_3__t0_act_z rwl_3__t3_act_z gnd__t31_act_z sky130_fd_pr__nfet_01v8 L=0.15 W=0.42 nf=1 ad=0.1974 as=0.1974 pd=1.78 ps=1.78 mult=1 m=1
rgnd_t0_act_z gnd__t0_act_z gnd_act_z 63.3529
rgnd_t1_act_z gnd__t1_act_z gnd_act_z 49.0465
rgnd_t2_act_z gnd__t2_act_z gnd_act_z 36.5177
rgnd_t3_act_z gnd__t3_act_z gnd_act_z 28.2406
rgnd_t4_act_z gnd__t4_act_z gnd_act_z 28.2406
rgnd_t5_act_z gnd__t5_act_z gnd_act_z 36.5177
rgnd_t6_act_z gnd__t6_act_z gnd_act_z 49.0465
rgnd_t7_act_z gnd__t7_act_z gnd_act_z 63.3529
rgnd_t8_act_z gnd__t8_act_z gnd_act_z 58.0019
rgnd_t9_act_z gnd__t9_act_z gnd_act_z 41.907
rgnd_t10_act_z gnd__t10_act_z gnd_act_z 26.1568
rgnd_t11_act_z gnd__t11_act_z gnd_act_z 12.1726
rgnd_t12_act_z gnd__t12_act_z gnd_act_z 12.1726
rgnd_t13_act_z gnd__t13_act_z gnd_act_z 26.1568
rgnd_t14_act_z gnd__t14_act_z gnd_act_z 41.907
rgnd_t15_act_z gnd__t15_act_z gnd_act_z 58.0019
rgnd_t16_act_z gnd__t16_act_z gnd_act_z 58.0019
rgnd_t17_act_z gnd__t17_act_z gnd_act_z 41.907
rgnd_t18_act_z gnd__t18_act_z gnd_act_z 26.1568
rgnd_t19_act_z gnd__t19_act_z gnd_act_z 12.1726
rgnd_t20_act_z gnd__t20_act_z gnd_act_z 12.1726
rgnd_t21_act_z gnd__t21_act_z gnd_act_z 26.1568
rgnd_t22_act_z gnd__t22_act_z gnd_act_z 41.907
rgnd_t23_act_z gnd__t23_act_z gnd_act_z 58.0019
rgnd_t24_act_z gnd__t24_act_z gnd_act_z 63.3529
rgnd_t25_act_z gnd__t25_act_z gnd_act_z 49.0465
rgnd_t26_act_z gnd__t26_act_z gnd_act_z 36.5177
rgnd_t27_act_z gnd__t27_act_z gnd_act_z 28.2406
rgnd_t28_act_z gnd__t28_act_z gnd_act_z 28.2406
rgnd_t29_act_z gnd__t29_act_z gnd_act_z 36.5177
rgnd_t30_act_z gnd__t30_act_z gnd_act_z 49.0465
rgnd_t31_act_z gnd__t31_act_z gnd_act_z 63.3529
rbl_0_t0_act_z bl_0__t0_act_z bl_0_act_z 144.555
rbl_0_t1_act_z bl_0__t1_act_z bl_0_act_z 48.1851
rbl_0_t2_act_z bl_0__t2_act_z bl_0_act_z 144.555
rbl_0_t3_act_z bl_0__t3_act_z bl_0_act_z 48.1851
rbl_1_t0_act_z bl_1__t0_act_z bl_1_act_z 144.555
rbl_1_t1_act_z bl_1__t1_act_z bl_1_act_z 48.1851
rbl_1_t2_act_z bl_1__t2_act_z bl_1_act_z 48.1851
rbl_1_t3_act_z bl_1__t3_act_z bl_1_act_z 144.555
rbl_2_t0_act_z bl_2__t0_act_z bl_2_act_z 144.555
rbl_2_t1_act_z bl_2__t1_act_z bl_2_act_z 48.1851
rbl_2_t2_act_z bl_2__t2_act_z bl_2_act_z 48.1851
rbl_2_t3_act_z bl_2__t3_act_z bl_2_act_z 144.555
rbl_3_t0_act_z bl_3__t0_act_z bl_3_act_z 144.555
rbl_3_t1_act_z bl_3__t1_act_z bl_3_act_z 48.1851
rbl_3_t2_act_z bl_3__t2_act_z bl_3_act_z 48.1851
rbl_3_t3_act_z bl_3__t3_act_z bl_3_act_z 144.555
rrbl_0_t0_act_z rbl_0__t0_act_z rbl_0_act_z 144.555
rrbl_0_t1_act_z rbl_0__t1_act_z rbl_0_act_z 48.1851
rrbl_0_t2_act_z rbl_0__t2_act_z rbl_0_act_z 48.1851
rrbl_0_t3_act_z rbl_0__t3_act_z rbl_0_act_z 144.555
rrbl_1_t0_act_z rbl_1__t0_act_z rbl_1_act_z 144.555
rrbl_1_t1_act_z rbl_1__t1_act_z rbl_1_act_z 48.1851
rrbl_1_t2_act_z rbl_1__t2_act_z rbl_1_act_z 48.1851
rrbl_1_t3_act_z rbl_1__t3_act_z rbl_1_act_z 144.555
rrbl_2_t0_act_z rbl_2__t0_act_z rbl_2_act_z 144.555
rrbl_2_t1_act_z rbl_2__t1_act_z rbl_2_act_z 48.1851
rrbl_2_t2_act_z rbl_2__t2_act_z rbl_2_act_z 48.1851
rrbl_2_t3_act_z rbl_2__t3_act_z rbl_2_act_z 144.555
rrbl_3_t0_act_z rbl_3__t0_act_z rbl_3_act_z 144.555
rrbl_3_t1_act_z rbl_3__t1_act_z rbl_3_act_z 48.1851
rrbl_3_t2_act_z rbl_3__t2_act_z rbl_3_act_z 48.1851
rrbl_3_t3_act_z rbl_3__t3_act_z rbl_3_act_z 144.555
rrwl_0_t0_act_z rwl_0__t0_act_z rwl_0_act_z 21.6897
rrwl_0_t1_act_z rwl_0__t1_act_z rwl_0_act_z 7.22989
rrwl_0_t2_act_z rwl_0__t2_act_z rwl_0_act_z 7.22989
rrwl_0_t3_act_z rwl_0__t3_act_z rwl_0_act_z 21.6897
rrwl_1_t0_act_z rwl_1__t0_act_z rwl_1_act_z 21.6897
rrwl_1_t1_act_z rwl_1__t1_act_z rwl_1_act_z 7.22989
rrwl_1_t2_act_z rwl_1__t2_act_z rwl_1_act_z 7.22989
rrwl_1_t3_act_z rwl_1__t3_act_z rwl_1_act_z 21.6897
rrwl_2_t0_act_z rwl_2__t0_act_z rwl_2_act_z 21.6897
rrwl_2_t1_act_z rwl_2__t1_act_z rwl_2_act_z 7.22989
rrwl_2_t2_act_z rwl_2__t2_act_z rwl_2_act_z 7.22989
rrwl_2_t3_act_z rwl_2__t3_act_z rwl_2_act_z 21.6897
rrwl_3_t0_act_z rwl_3__t0_act_z rwl_3_act_z 21.6897
rrwl_3_t1_act_z rwl_3__t1_act_z rwl_3_act_z 7.22989
rrwl_3_t2_act_z rwl_3__t2_act_z rwl_3_act_z 7.22989
rrwl_3_t3_act_z rwl_3__t3_act_z rwl_3_act_z 21.6897
rsn_0_0_t0_act_z sn_0_0__t0_act_z sn_0_0_act_z 125.123
rsn_0_0_t1_act_z sn_0_0__t1_act_z sn_0_0_act_z 125.123
rsn_0_1_t0_act_z sn_0_1__t0_act_z sn_0_1_act_z 125.123
rsn_0_1_t1_act_z sn_0_1__t1_act_z sn_0_1_act_z 125.123
rsn_0_2_t0_act_z sn_0_2__t0_act_z sn_0_2_act_z 125.123
rsn_0_2_t1_act_z sn_0_2__t1_act_z sn_0_2_act_z 125.123
rsn_0_3_t0_act_z sn_0_3__t0_act_z sn_0_3_act_z 125.123
rsn_0_3_t1_act_z sn_0_3__t1_act_z sn_0_3_act_z 125.123
rsn_1_0_t0_act_z sn_1_0__t0_act_z sn_1_0_act_z 125.123
rsn_1_0_t1_act_z sn_1_0__t1_act_z sn_1_0_act_z 125.123
rsn_1_1_t0_act_z sn_1_1__t0_act_z sn_1_1_act_z 125.123
rsn_1_1_t1_act_z sn_1_1__t1_act_z sn_1_1_act_z 125.123
rsn_1_2_t0_act_z sn_1_2__t0_act_z sn_1_2_act_z 125.123
rsn_1_2_t1_act_z sn_1_2__t1_act_z sn_1_2_act_z 125.123
rsn_1_3_t0_act_z sn_1_3__t0_act_z sn_1_3_act_z 125.123
rsn_1_3_t1_act_z sn_1_3__t1_act_z sn_1_3_act_z 125.123
rsn_2_0_t0_act_z sn_2_0__t0_act_z sn_2_0_act_z 125.123
rsn_2_0_t1_act_z sn_2_0__t1_act_z sn_2_0_act_z 125.123
rsn_2_1_t0_act_z sn_2_1__t0_act_z sn_2_1_act_z 125.123
rsn_2_1_t1_act_z sn_2_1__t1_act_z sn_2_1_act_z 125.123
rsn_2_2_t0_act_z sn_2_2__t0_act_z sn_2_2_act_z 125.123
rsn_2_2_t1_act_z sn_2_2__t1_act_z sn_2_2_act_z 125.123
rsn_2_3_t0_act_z sn_2_3__t0_act_z sn_2_3_act_z 125.123
rsn_2_3_t1_act_z sn_2_3__t1_act_z sn_2_3_act_z 125.123
rsn_3_0_t0_act_z sn_3_0__t0_act_z sn_3_0_act_z 125.123
rsn_3_0_t1_act_z sn_3_0__t1_act_z sn_3_0_act_z 125.123
rsn_3_1_t0_act_z sn_3_1__t0_act_z sn_3_1_act_z 125.123
rsn_3_1_t1_act_z sn_3_1__t1_act_z sn_3_1_act_z 125.123
rsn_3_2_t0_act_z sn_3_2__t0_act_z sn_3_2_act_z 125.123
rsn_3_2_t1_act_z sn_3_2__t1_act_z sn_3_2_act_z 125.123
rsn_3_3_t0_act_z sn_3_3__t0_act_z sn_3_3_act_z 125.123
rsn_3_3_t1_act_z sn_3_3__t1_act_z sn_3_3_act_z 125.123
rwl_0_t0_act_z wl_0__t0_act_z wl_0_act_z 54.2844
rwl_0_t1_act_z wl_0__t1_act_z wl_0_act_z 54.2844
rwl_0_t2_act_z wl_0__t2_act_z wl_0_act_z 162.853
rwl_0_t3_act_z wl_0__t3_act_z wl_0_act_z 162.853
rwl_1_t0_act_z wl_1__t0_act_z wl_1_act_z 162.853
rwl_1_t1_act_z wl_1__t1_act_z wl_1_act_z 54.2844
rwl_1_t2_act_z wl_1__t2_act_z wl_1_act_z 54.2844
rwl_1_t3_act_z wl_1__t3_act_z wl_1_act_z 162.853
rwl_2_t0_act_z wl_2__t0_act_z wl_2_act_z 54.2844
rwl_2_t1_act_z wl_2__t1_act_z wl_2_act_z 54.2844
rwl_2_t2_act_z wl_2__t2_act_z wl_2_act_z 162.853
rwl_2_t3_act_z wl_2__t3_act_z wl_2_act_z 162.853
rwl_3_t0_act_z wl_3__t0_act_z wl_3_act_z 162.853
rwl_3_t1_act_z wl_3__t1_act_z wl_3_act_z 54.2844
rwl_3_t2_act_z wl_3__t2_act_z wl_3_act_z 54.2844
rwl_3_t3_act_z wl_3__t3_act_z wl_3_act_z 162.853
cgnd_act_z gnd_act_z vsubs_act_z 4.09475e-15
cbl_0_act_z bl_0_act_z vsubs_act_z 5.96076e-16
cbl_1_act_z bl_1_act_z vsubs_act_z 5.81168e-16
cbl_2_act_z bl_2_act_z vsubs_act_z 5.81168e-16
cbl_3_act_z bl_3_act_z vsubs_act_z 5.81168e-16
crbl_0_act_z rbl_0_act_z vsubs_act_z 5.81168e-16
crbl_1_act_z rbl_1_act_z vsubs_act_z 5.81168e-16
crbl_2_act_z rbl_2_act_z vsubs_act_z 5.81168e-16
crbl_3_act_z rbl_3_act_z vsubs_act_z 5.96076e-16
crwl_0_act_z rwl_0_act_z vsubs_act_z 1.18713e-15
crwl_1_act_z rwl_1_act_z vsubs_act_z 1.18713e-15
crwl_2_act_z rwl_2_act_z vsubs_act_z 1.18713e-15
crwl_3_act_z rwl_3_act_z vsubs_act_z 1.18713e-15
csn_0_0_act_z sn_0_0_act_z vsubs_act_z 4.33689e-16
csn_0_1_act_z sn_0_1_act_z vsubs_act_z 4.30576e-16
csn_0_2_act_z sn_0_2_act_z vsubs_act_z 4.30576e-16
csn_0_3_act_z sn_0_3_act_z vsubs_act_z 4.32518e-16
csn_1_0_act_z sn_1_0_act_z vsubs_act_z 4.33689e-16
csn_1_1_act_z sn_1_1_act_z vsubs_act_z 4.30576e-16
csn_1_2_act_z sn_1_2_act_z vsubs_act_z 4.30576e-16
csn_1_3_act_z sn_1_3_act_z vsubs_act_z 4.32518e-16
csn_2_0_act_z sn_2_0_act_z vsubs_act_z 4.33689e-16
csn_2_1_act_z sn_2_1_act_z vsubs_act_z 4.30576e-16
csn_2_2_act_z sn_2_2_act_z vsubs_act_z 4.30576e-16
csn_2_3_act_z sn_2_3_act_z vsubs_act_z 4.32518e-16
csn_3_0_act_z sn_3_0_act_z vsubs_act_z 4.33689e-16
csn_3_1_act_z sn_3_1_act_z vsubs_act_z 4.30576e-16
csn_3_2_act_z sn_3_2_act_z vsubs_act_z 4.30576e-16
csn_3_3_act_z sn_3_3_act_z vsubs_act_z 4.32518e-16
cwl_0_act_z wl_0_act_z vsubs_act_z 1.90928e-15
cwl_1_act_z wl_1_act_z vsubs_act_z 1.90928e-15
cwl_2_act_z wl_2_act_z vsubs_act_z 1.90928e-15
cwl_3_act_z wl_3_act_z vsubs_act_z 1.91375e-15
ccc_bl_0_sn_0_0_act_z bl_0_act_z sn_0_0_act_z 1.071e-17
ccc_bl_0_sn_1_0_act_z bl_0_act_z sn_1_0_act_z 1.071e-17
ccc_bl_0_sn_2_0_act_z bl_0_act_z sn_2_0_act_z 1.071e-17
ccc_bl_0_sn_3_0_act_z bl_0_act_z sn_3_0_act_z 1.071e-17
ccc_bl_0_wl_0_act_z bl_0_act_z wl_0_act_z 2.4327e-17
ccc_bl_0_wl_1_act_z bl_0_act_z wl_1_act_z 2.4327e-17
ccc_bl_0_wl_2_act_z bl_0_act_z wl_2_act_z 2.4327e-17
ccc_bl_1_rbl_0_act_z bl_1_act_z rbl_0_act_z 1.29795e-16
ccc_bl_1_rwl_0_act_z bl_1_act_z rwl_0_act_z 9.028e-18
ccc_bl_1_rwl_1_act_z bl_1_act_z rwl_1_act_z 9.028e-18
ccc_bl_1_rwl_2_act_z bl_1_act_z rwl_2_act_z 9.028e-18
ccc_bl_1_rwl_3_act_z bl_1_act_z rwl_3_act_z 9.028e-18
ccc_bl_1_sn_0_1_act_z bl_1_act_z sn_0_1_act_z 1.071e-17
ccc_bl_1_sn_1_1_act_z bl_1_act_z sn_1_1_act_z 1.071e-17
ccc_bl_1_sn_2_1_act_z bl_1_act_z sn_2_1_act_z 1.071e-17
ccc_bl_1_sn_3_1_act_z bl_1_act_z sn_3_1_act_z 1.071e-17
ccc_bl_1_wl_0_act_z bl_1_act_z wl_0_act_z 2.7627e-17
ccc_bl_1_wl_1_act_z bl_1_act_z wl_1_act_z 2.7627e-17
ccc_bl_1_wl_2_act_z bl_1_act_z wl_2_act_z 2.7627e-17
ccc_bl_2_rbl_1_act_z bl_2_act_z rbl_1_act_z 1.29795e-16
ccc_bl_2_rwl_0_act_z bl_2_act_z rwl_0_act_z 9.028e-18
ccc_bl_2_rwl_1_act_z bl_2_act_z rwl_1_act_z 9.028e-18
ccc_bl_2_rwl_2_act_z bl_2_act_z rwl_2_act_z 9.028e-18
ccc_bl_2_rwl_3_act_z bl_2_act_z rwl_3_act_z 9.028e-18
ccc_bl_2_sn_0_2_act_z bl_2_act_z sn_0_2_act_z 1.071e-17
ccc_bl_2_sn_1_2_act_z bl_2_act_z sn_1_2_act_z 1.071e-17
ccc_bl_2_sn_2_2_act_z bl_2_act_z sn_2_2_act_z 1.071e-17
ccc_bl_2_sn_3_2_act_z bl_2_act_z sn_3_2_act_z 1.071e-17
ccc_bl_2_wl_0_act_z bl_2_act_z wl_0_act_z 2.7627e-17
ccc_bl_2_wl_1_act_z bl_2_act_z wl_1_act_z 2.7627e-17
ccc_bl_2_wl_2_act_z bl_2_act_z wl_2_act_z 2.7627e-17
ccc_bl_3_rbl_2_act_z bl_3_act_z rbl_2_act_z 1.29795e-16
ccc_bl_3_rwl_0_act_z bl_3_act_z rwl_0_act_z 9.028e-18
ccc_bl_3_rwl_1_act_z bl_3_act_z rwl_1_act_z 9.028e-18
ccc_bl_3_rwl_2_act_z bl_3_act_z rwl_2_act_z 9.028e-18
ccc_bl_3_rwl_3_act_z bl_3_act_z rwl_3_act_z 9.028e-18
ccc_bl_3_sn_0_3_act_z bl_3_act_z sn_0_3_act_z 1.071e-17
ccc_bl_3_sn_1_3_act_z bl_3_act_z sn_1_3_act_z 1.071e-17
ccc_bl_3_sn_2_3_act_z bl_3_act_z sn_2_3_act_z 1.071e-17
ccc_bl_3_sn_3_3_act_z bl_3_act_z sn_3_3_act_z 1.071e-17
ccc_bl_3_wl_0_act_z bl_3_act_z wl_0_act_z 2.7627e-17
ccc_bl_3_wl_1_act_z bl_3_act_z wl_1_act_z 2.7627e-17
ccc_bl_3_wl_2_act_z bl_3_act_z wl_2_act_z 2.7627e-17
ccc_rbl_0_rwl_0_act_z rbl_0_act_z rwl_0_act_z 1.9738e-17
ccc_rbl_0_rwl_1_act_z rbl_0_act_z rwl_1_act_z 1.9738e-17
ccc_rbl_0_rwl_2_act_z rbl_0_act_z rwl_2_act_z 1.9738e-17
ccc_rbl_0_rwl_3_act_z rbl_0_act_z rwl_3_act_z 1.9738e-17
ccc_rbl_0_sn_0_0_act_z rbl_0_act_z sn_0_0_act_z 1.071e-17
ccc_rbl_0_sn_1_0_act_z rbl_0_act_z sn_1_0_act_z 2.4327e-17
ccc_rbl_0_sn_2_0_act_z rbl_0_act_z sn_2_0_act_z 2.4327e-17
ccc_rbl_0_wl_0_act_z rbl_0_act_z wl_0_act_z 3.3e-18
ccc_rbl_0_wl_1_act_z rbl_0_act_z wl_1_act_z 3.3e-18
ccc_rbl_0_wl_2_act_z rbl_0_act_z wl_2_act_z 3.3e-18
ccc_rbl_1_rwl_0_act_z rbl_1_act_z rwl_0_act_z 1.9738e-17
ccc_rbl_1_rwl_1_act_z rbl_1_act_z rwl_1_act_z 1.9738e-17
ccc_rbl_1_rwl_2_act_z rbl_1_act_z rwl_2_act_z 1.9738e-17
ccc_rbl_1_rwl_3_act_z rbl_1_act_z rwl_3_act_z 1.9738e-17
ccc_rbl_1_sn_0_1_act_z rbl_1_act_z sn_0_1_act_z 1.071e-17
ccc_rbl_1_sn_1_1_act_z rbl_1_act_z sn_1_1_act_z 2.4327e-17
ccc_rbl_1_sn_2_1_act_z rbl_1_act_z sn_2_1_act_z 2.4327e-17
ccc_rbl_1_wl_0_act_z rbl_1_act_z wl_0_act_z 3.3e-18
ccc_rbl_1_wl_1_act_z rbl_1_act_z wl_1_act_z 3.3e-18
ccc_rbl_1_wl_2_act_z rbl_1_act_z wl_2_act_z 3.3e-18
ccc_rbl_2_rwl_0_act_z rbl_2_act_z rwl_0_act_z 1.9738e-17
ccc_rbl_2_rwl_1_act_z rbl_2_act_z rwl_1_act_z 1.9738e-17
ccc_rbl_2_rwl_2_act_z rbl_2_act_z rwl_2_act_z 1.9738e-17
ccc_rbl_2_rwl_3_act_z rbl_2_act_z rwl_3_act_z 1.9738e-17
ccc_rbl_2_sn_0_2_act_z rbl_2_act_z sn_0_2_act_z 1.071e-17
ccc_rbl_2_sn_1_2_act_z rbl_2_act_z sn_1_2_act_z 2.4327e-17
ccc_rbl_2_sn_2_2_act_z rbl_2_act_z sn_2_2_act_z 2.4327e-17
ccc_rbl_2_wl_0_act_z rbl_2_act_z wl_0_act_z 3.3e-18
ccc_rbl_2_wl_1_act_z rbl_2_act_z wl_1_act_z 3.3e-18
ccc_rbl_2_wl_2_act_z rbl_2_act_z wl_2_act_z 3.3e-18
ccc_rbl_3_rwl_0_act_z rbl_3_act_z rwl_0_act_z 1.071e-17
ccc_rbl_3_rwl_1_act_z rbl_3_act_z rwl_1_act_z 1.071e-17
ccc_rbl_3_rwl_2_act_z rbl_3_act_z rwl_2_act_z 1.071e-17
ccc_rbl_3_rwl_3_act_z rbl_3_act_z rwl_3_act_z 1.071e-17
ccc_rbl_3_sn_0_3_act_z rbl_3_act_z sn_0_3_act_z 1.071e-17
ccc_rbl_3_sn_1_3_act_z rbl_3_act_z sn_1_3_act_z 2.4327e-17
ccc_rbl_3_sn_2_3_act_z rbl_3_act_z sn_2_3_act_z 2.4327e-17
ccc_rwl_0_sn_0_0_act_z rwl_0_act_z sn_0_0_act_z 1.0072e-17
ccc_rwl_0_sn_0_1_act_z rwl_0_act_z sn_0_1_act_z 1.9682e-17
ccc_rwl_0_sn_0_2_act_z rwl_0_act_z sn_0_2_act_z 1.9682e-17
ccc_rwl_0_sn_0_3_act_z rwl_0_act_z sn_0_3_act_z 1.9682e-17
ccc_rwl_1_sn_1_0_act_z rwl_1_act_z sn_1_0_act_z 1.0072e-17
ccc_rwl_1_sn_1_1_act_z rwl_1_act_z sn_1_1_act_z 1.9682e-17
ccc_rwl_1_sn_1_2_act_z rwl_1_act_z sn_1_2_act_z 1.9682e-17
ccc_rwl_1_sn_1_3_act_z rwl_1_act_z sn_1_3_act_z 1.9682e-17
ccc_rwl_2_sn_2_0_act_z rwl_2_act_z sn_2_0_act_z 1.0072e-17
ccc_rwl_2_sn_2_1_act_z rwl_2_act_z sn_2_1_act_z 1.9682e-17
ccc_rwl_2_sn_2_2_act_z rwl_2_act_z sn_2_2_act_z 1.9682e-17
ccc_rwl_2_sn_2_3_act_z rwl_2_act_z sn_2_3_act_z 1.9682e-17
ccc_rwl_3_sn_3_0_act_z rwl_3_act_z sn_3_0_act_z 1.0072e-17
ccc_rwl_3_sn_3_1_act_z rwl_3_act_z sn_3_1_act_z 1.9682e-17
ccc_rwl_3_sn_3_2_act_z rwl_3_act_z sn_3_2_act_z 1.9682e-17
ccc_rwl_3_sn_3_3_act_z rwl_3_act_z sn_3_3_act_z 1.9682e-17
ccc_sn_0_0_wl_0_act_z sn_0_0_act_z wl_0_act_z 1.9664e-17
ccc_sn_0_1_wl_0_act_z sn_0_1_act_z wl_0_act_z 1.9664e-17
ccc_sn_0_2_wl_0_act_z sn_0_2_act_z wl_0_act_z 1.9664e-17
ccc_sn_0_3_wl_0_act_z sn_0_3_act_z wl_0_act_z 1.3668e-17
ccc_sn_1_0_wl_1_act_z sn_1_0_act_z wl_1_act_z 1.9664e-17
ccc_sn_1_1_wl_1_act_z sn_1_1_act_z wl_1_act_z 1.6705e-17
ccc_sn_1_2_wl_1_act_z sn_1_2_act_z wl_1_act_z 1.6705e-17
ccc_sn_1_3_wl_1_act_z sn_1_3_act_z wl_1_act_z 1.071e-17
ccc_sn_2_0_wl_2_act_z sn_2_0_act_z wl_2_act_z 1.9664e-17
ccc_sn_2_1_wl_2_act_z sn_2_1_act_z wl_2_act_z 1.6705e-17
ccc_sn_2_2_wl_2_act_z sn_2_2_act_z wl_2_act_z 1.6705e-17
ccc_sn_2_3_wl_2_act_z sn_2_3_act_z wl_2_act_z 1.071e-17
ccc_sn_3_0_wl_3_act_z sn_3_0_act_z wl_3_act_z 1.9664e-17
ccc_sn_3_1_wl_3_act_z sn_3_1_act_z wl_3_act_z 1.6705e-17
ccc_sn_3_2_wl_3_act_z sn_3_2_act_z wl_3_act_z 1.6705e-17
ccc_sn_3_3_wl_3_act_z sn_3_3_act_z wl_3_act_z 1.071e-17
vpre0_act_z pre0_act_z 0 dc 0.9
vpre1_act_z pre1_act_z 0 dc 0.9
vpre2_act_z pre2_act_z 0 dc 0.9
vpre3_act_z pre3_act_z 0 dc 0.9
vwbl0_act_z bl_0_act_z 0 dc 0
vwbl1_act_z bl_1_act_z 0 dc 0
vwbl2_act_z bl_2_act_z 0 dc 0
vwbl3_act_z bl_3_act_z 0 dc 0
vrwl0_act_z rwl_0_act_z 0 pwl(0.000000e+00 1.8 9.000000e-09 1.8 9.100000e-09 0 3.200000e-08 0 3.210000e-08 1.8)
vrwl1_act_z rwl_1_act_z 0 dc 1.8
vrwl2_act_z rwl_2_act_z 0 dc 1.8
vrwl3_act_z rwl_3_act_z 0 dc 1.8
vwwl0_act_z wl_0_act_z 0 pwl(0.000000e+00 0 2.000000e-08 0 2.010000e-08 1.8 3.000000e-08 1.8 3.010000e-08 0)
vwwl1_act_z wl_1_act_z 0 dc 0
vwwl2_act_z wl_2_act_z 0 dc 0
vwwl3_act_z wl_3_act_z 0 dc 0
vbody_act_z gnd_act_z 0 dc 0
vsub_act_z vsubs_act_z 0 dc 0
vctl_act_z ctl_act_z 0 pwl(0.000000e+00 1.8 7.000000e-09 1.8 7.100000e-09 0 3.200000e-08 0 3.210000e-08 1.8)   $ EXCLUDED: switch control, outside the boundary
spre0_act_z pre0_act_z rbl_0_act_z ctl_act_z 0 swpre
spre1_act_z pre1_act_z rbl_1_act_z ctl_act_z 0 swpre
spre2_act_z pre2_act_z rbl_2_act_z ctl_act_z 0 swpre
spre3_act_z pre3_act_z rbl_3_act_z ctl_act_z 0 swpre
bpn_vpre0_act_z pn_vpre0_act_z 0 v=(-v(pre0_act_z)*i(vpre0_act_z))
bpg_vpre0_act_z pg_vpre0_act_z 0 v=max((-v(pre0_act_z)*i(vpre0_act_z)),0)
bpr_vpre0_act_z pr_vpre0_act_z 0 v=max(-(-v(pre0_act_z)*i(vpre0_act_z)),0)
bpn_vpre1_act_z pn_vpre1_act_z 0 v=(-v(pre1_act_z)*i(vpre1_act_z))
bpg_vpre1_act_z pg_vpre1_act_z 0 v=max((-v(pre1_act_z)*i(vpre1_act_z)),0)
bpr_vpre1_act_z pr_vpre1_act_z 0 v=max(-(-v(pre1_act_z)*i(vpre1_act_z)),0)
bpn_vpre2_act_z pn_vpre2_act_z 0 v=(-v(pre2_act_z)*i(vpre2_act_z))
bpg_vpre2_act_z pg_vpre2_act_z 0 v=max((-v(pre2_act_z)*i(vpre2_act_z)),0)
bpr_vpre2_act_z pr_vpre2_act_z 0 v=max(-(-v(pre2_act_z)*i(vpre2_act_z)),0)
bpn_vpre3_act_z pn_vpre3_act_z 0 v=(-v(pre3_act_z)*i(vpre3_act_z))
bpg_vpre3_act_z pg_vpre3_act_z 0 v=max((-v(pre3_act_z)*i(vpre3_act_z)),0)
bpr_vpre3_act_z pr_vpre3_act_z 0 v=max(-(-v(pre3_act_z)*i(vpre3_act_z)),0)
bpn_vwbl0_act_z pn_vwbl0_act_z 0 v=(-v(bl_0_act_z)*i(vwbl0_act_z))
bpg_vwbl0_act_z pg_vwbl0_act_z 0 v=max((-v(bl_0_act_z)*i(vwbl0_act_z)),0)
bpr_vwbl0_act_z pr_vwbl0_act_z 0 v=max(-(-v(bl_0_act_z)*i(vwbl0_act_z)),0)
bpn_vwbl1_act_z pn_vwbl1_act_z 0 v=(-v(bl_1_act_z)*i(vwbl1_act_z))
bpg_vwbl1_act_z pg_vwbl1_act_z 0 v=max((-v(bl_1_act_z)*i(vwbl1_act_z)),0)
bpr_vwbl1_act_z pr_vwbl1_act_z 0 v=max(-(-v(bl_1_act_z)*i(vwbl1_act_z)),0)
bpn_vwbl2_act_z pn_vwbl2_act_z 0 v=(-v(bl_2_act_z)*i(vwbl2_act_z))
bpg_vwbl2_act_z pg_vwbl2_act_z 0 v=max((-v(bl_2_act_z)*i(vwbl2_act_z)),0)
bpr_vwbl2_act_z pr_vwbl2_act_z 0 v=max(-(-v(bl_2_act_z)*i(vwbl2_act_z)),0)
bpn_vwbl3_act_z pn_vwbl3_act_z 0 v=(-v(bl_3_act_z)*i(vwbl3_act_z))
bpg_vwbl3_act_z pg_vwbl3_act_z 0 v=max((-v(bl_3_act_z)*i(vwbl3_act_z)),0)
bpr_vwbl3_act_z pr_vwbl3_act_z 0 v=max(-(-v(bl_3_act_z)*i(vwbl3_act_z)),0)
bpn_vrwl0_act_z pn_vrwl0_act_z 0 v=(-v(rwl_0_act_z)*i(vrwl0_act_z))
bpg_vrwl0_act_z pg_vrwl0_act_z 0 v=max((-v(rwl_0_act_z)*i(vrwl0_act_z)),0)
bpr_vrwl0_act_z pr_vrwl0_act_z 0 v=max(-(-v(rwl_0_act_z)*i(vrwl0_act_z)),0)
bpn_vrwl1_act_z pn_vrwl1_act_z 0 v=(-v(rwl_1_act_z)*i(vrwl1_act_z))
bpg_vrwl1_act_z pg_vrwl1_act_z 0 v=max((-v(rwl_1_act_z)*i(vrwl1_act_z)),0)
bpr_vrwl1_act_z pr_vrwl1_act_z 0 v=max(-(-v(rwl_1_act_z)*i(vrwl1_act_z)),0)
bpn_vrwl2_act_z pn_vrwl2_act_z 0 v=(-v(rwl_2_act_z)*i(vrwl2_act_z))
bpg_vrwl2_act_z pg_vrwl2_act_z 0 v=max((-v(rwl_2_act_z)*i(vrwl2_act_z)),0)
bpr_vrwl2_act_z pr_vrwl2_act_z 0 v=max(-(-v(rwl_2_act_z)*i(vrwl2_act_z)),0)
bpn_vrwl3_act_z pn_vrwl3_act_z 0 v=(-v(rwl_3_act_z)*i(vrwl3_act_z))
bpg_vrwl3_act_z pg_vrwl3_act_z 0 v=max((-v(rwl_3_act_z)*i(vrwl3_act_z)),0)
bpr_vrwl3_act_z pr_vrwl3_act_z 0 v=max(-(-v(rwl_3_act_z)*i(vrwl3_act_z)),0)
bpn_vwwl0_act_z pn_vwwl0_act_z 0 v=(-v(wl_0_act_z)*i(vwwl0_act_z))
bpg_vwwl0_act_z pg_vwwl0_act_z 0 v=max((-v(wl_0_act_z)*i(vwwl0_act_z)),0)
bpr_vwwl0_act_z pr_vwwl0_act_z 0 v=max(-(-v(wl_0_act_z)*i(vwwl0_act_z)),0)
bpn_vwwl1_act_z pn_vwwl1_act_z 0 v=(-v(wl_1_act_z)*i(vwwl1_act_z))
bpg_vwwl1_act_z pg_vwwl1_act_z 0 v=max((-v(wl_1_act_z)*i(vwwl1_act_z)),0)
bpr_vwwl1_act_z pr_vwwl1_act_z 0 v=max(-(-v(wl_1_act_z)*i(vwwl1_act_z)),0)
bpn_vwwl2_act_z pn_vwwl2_act_z 0 v=(-v(wl_2_act_z)*i(vwwl2_act_z))
bpg_vwwl2_act_z pg_vwwl2_act_z 0 v=max((-v(wl_2_act_z)*i(vwwl2_act_z)),0)
bpr_vwwl2_act_z pr_vwwl2_act_z 0 v=max(-(-v(wl_2_act_z)*i(vwwl2_act_z)),0)
bpn_vwwl3_act_z pn_vwwl3_act_z 0 v=(-v(wl_3_act_z)*i(vwwl3_act_z))
bpg_vwwl3_act_z pg_vwwl3_act_z 0 v=max((-v(wl_3_act_z)*i(vwwl3_act_z)),0)
bpr_vwwl3_act_z pr_vwwl3_act_z 0 v=max(-(-v(wl_3_act_z)*i(vwwl3_act_z)),0)
bpn_vbody_act_z pn_vbody_act_z 0 v=(-v(gnd_act_z)*i(vbody_act_z))
bpg_vbody_act_z pg_vbody_act_z 0 v=max((-v(gnd_act_z)*i(vbody_act_z)),0)
bpr_vbody_act_z pr_vbody_act_z 0 v=max(-(-v(gnd_act_z)*i(vbody_act_z)),0)
bpn_vsub_act_z pn_vsub_act_z 0 v=(-v(vsubs_act_z)*i(vsub_act_z))
bpg_vsub_act_z pg_vsub_act_z 0 v=max((-v(vsubs_act_z)*i(vsub_act_z)),0)
bpr_vsub_act_z pr_vsub_act_z 0 v=max(-(-v(vsubs_act_z)*i(vsub_act_z)),0)

* ---- instance act_o: mode active, pattern one ----
xm1_act_o sn_0_0__t0_act_o wl_0__t3_act_o bl_0__t0_act_o gnd__t0_act_o sky130_fd_pr__nfet_01v8 L=0.15 W=0.42 nf=1 ad=0.1974 as=0.1974 pd=1.78 ps=1.78 mult=1 m=1
xm2_act_o rbl_0__t0_act_o sn_0_0__t1_act_o rwl_0__t0_act_o gnd__t1_act_o sky130_fd_pr__nfet_01v8 L=0.15 W=0.42 nf=1 ad=0.1974 as=0.1974 pd=1.78 ps=1.78 mult=1 m=1
xm3_act_o sn_0_1__t1_act_o wl_0__t0_act_o bl_1__t0_act_o gnd__t2_act_o sky130_fd_pr__nfet_01v8 L=0.15 W=0.42 nf=1 ad=0.1974 as=0.1974 pd=1.78 ps=1.78 mult=1 m=1
xm4_act_o rbl_1__t0_act_o sn_0_1__t0_act_o rwl_0__t1_act_o gnd__t3_act_o sky130_fd_pr__nfet_01v8 L=0.15 W=0.42 nf=1 ad=0.1974 as=0.1974 pd=1.78 ps=1.78 mult=1 m=1
xm5_act_o sn_0_2__t1_act_o wl_0__t1_act_o bl_2__t0_act_o gnd__t4_act_o sky130_fd_pr__nfet_01v8 L=0.15 W=0.42 nf=1 ad=0.1974 as=0.1974 pd=1.78 ps=1.78 mult=1 m=1
xm6_act_o rbl_2__t0_act_o sn_0_2__t0_act_o rwl_0__t2_act_o gnd__t5_act_o sky130_fd_pr__nfet_01v8 L=0.15 W=0.42 nf=1 ad=0.1974 as=0.1974 pd=1.78 ps=1.78 mult=1 m=1
xm7_act_o sn_0_3__t1_act_o wl_0__t2_act_o bl_3__t0_act_o gnd__t6_act_o sky130_fd_pr__nfet_01v8 L=0.15 W=0.42 nf=1 ad=0.1974 as=0.1974 pd=1.78 ps=1.78 mult=1 m=1
xm8_act_o rbl_3__t0_act_o sn_0_3__t0_act_o rwl_0__t3_act_o gnd__t7_act_o sky130_fd_pr__nfet_01v8 L=0.15 W=0.42 nf=1 ad=0.1974 as=0.1974 pd=1.78 ps=1.78 mult=1 m=1
xm9_act_o sn_1_0__t1_act_o wl_1__t0_act_o bl_0__t1_act_o gnd__t8_act_o sky130_fd_pr__nfet_01v8 L=0.15 W=0.42 nf=1 ad=0.1974 as=0.1974 pd=1.78 ps=1.78 mult=1 m=1
xm10_act_o rbl_0__t1_act_o sn_1_0__t0_act_o rwl_1__t0_act_o gnd__t9_act_o sky130_fd_pr__nfet_01v8 L=0.15 W=0.42 nf=1 ad=0.1974 as=0.1974 pd=1.78 ps=1.78 mult=1 m=1
xm11_act_o sn_1_1__t1_act_o wl_1__t1_act_o bl_1__t1_act_o gnd__t10_act_o sky130_fd_pr__nfet_01v8 L=0.15 W=0.42 nf=1 ad=0.1974 as=0.1974 pd=1.78 ps=1.78 mult=1 m=1
xm12_act_o rbl_1__t1_act_o sn_1_1__t0_act_o rwl_1__t1_act_o gnd__t11_act_o sky130_fd_pr__nfet_01v8 L=0.15 W=0.42 nf=1 ad=0.1974 as=0.1974 pd=1.78 ps=1.78 mult=1 m=1
xm13_act_o sn_1_2__t1_act_o wl_1__t2_act_o bl_2__t1_act_o gnd__t12_act_o sky130_fd_pr__nfet_01v8 L=0.15 W=0.42 nf=1 ad=0.1974 as=0.1974 pd=1.78 ps=1.78 mult=1 m=1
xm14_act_o rbl_2__t1_act_o sn_1_2__t0_act_o rwl_1__t2_act_o gnd__t13_act_o sky130_fd_pr__nfet_01v8 L=0.15 W=0.42 nf=1 ad=0.1974 as=0.1974 pd=1.78 ps=1.78 mult=1 m=1
xm15_act_o sn_1_3__t1_act_o wl_1__t3_act_o bl_3__t1_act_o gnd__t14_act_o sky130_fd_pr__nfet_01v8 L=0.15 W=0.42 nf=1 ad=0.1974 as=0.1974 pd=1.78 ps=1.78 mult=1 m=1
xm16_act_o rbl_3__t1_act_o sn_1_3__t0_act_o rwl_1__t3_act_o gnd__t15_act_o sky130_fd_pr__nfet_01v8 L=0.15 W=0.42 nf=1 ad=0.1974 as=0.1974 pd=1.78 ps=1.78 mult=1 m=1
xm17_act_o sn_2_0__t1_act_o wl_2__t3_act_o bl_0__t3_act_o gnd__t16_act_o sky130_fd_pr__nfet_01v8 L=0.15 W=0.42 nf=1 ad=0.1974 as=0.1974 pd=1.78 ps=1.78 mult=1 m=1
xm18_act_o rbl_0__t2_act_o sn_2_0__t0_act_o rwl_2__t0_act_o gnd__t17_act_o sky130_fd_pr__nfet_01v8 L=0.15 W=0.42 nf=1 ad=0.1974 as=0.1974 pd=1.78 ps=1.78 mult=1 m=1
xm19_act_o sn_2_1__t1_act_o wl_2__t0_act_o bl_1__t2_act_o gnd__t18_act_o sky130_fd_pr__nfet_01v8 L=0.15 W=0.42 nf=1 ad=0.1974 as=0.1974 pd=1.78 ps=1.78 mult=1 m=1
xm20_act_o rbl_1__t2_act_o sn_2_1__t0_act_o rwl_2__t1_act_o gnd__t19_act_o sky130_fd_pr__nfet_01v8 L=0.15 W=0.42 nf=1 ad=0.1974 as=0.1974 pd=1.78 ps=1.78 mult=1 m=1
xm21_act_o sn_2_2__t1_act_o wl_2__t1_act_o bl_2__t2_act_o gnd__t20_act_o sky130_fd_pr__nfet_01v8 L=0.15 W=0.42 nf=1 ad=0.1974 as=0.1974 pd=1.78 ps=1.78 mult=1 m=1
xm22_act_o rbl_2__t2_act_o sn_2_2__t0_act_o rwl_2__t2_act_o gnd__t21_act_o sky130_fd_pr__nfet_01v8 L=0.15 W=0.42 nf=1 ad=0.1974 as=0.1974 pd=1.78 ps=1.78 mult=1 m=1
xm23_act_o sn_2_3__t1_act_o wl_2__t2_act_o bl_3__t2_act_o gnd__t22_act_o sky130_fd_pr__nfet_01v8 L=0.15 W=0.42 nf=1 ad=0.1974 as=0.1974 pd=1.78 ps=1.78 mult=1 m=1
xm24_act_o rbl_3__t2_act_o sn_2_3__t0_act_o rwl_2__t3_act_o gnd__t23_act_o sky130_fd_pr__nfet_01v8 L=0.15 W=0.42 nf=1 ad=0.1974 as=0.1974 pd=1.78 ps=1.78 mult=1 m=1
xm25_act_o sn_3_0__t1_act_o wl_3__t0_act_o bl_0__t2_act_o gnd__t24_act_o sky130_fd_pr__nfet_01v8 L=0.15 W=0.42 nf=1 ad=0.1974 as=0.1974 pd=1.78 ps=1.78 mult=1 m=1
xm26_act_o rbl_0__t3_act_o sn_3_0__t0_act_o rwl_3__t0_act_o gnd__t25_act_o sky130_fd_pr__nfet_01v8 L=0.15 W=0.42 nf=1 ad=0.1974 as=0.1974 pd=1.78 ps=1.78 mult=1 m=1
xm27_act_o sn_3_1__t1_act_o wl_3__t1_act_o bl_1__t3_act_o gnd__t26_act_o sky130_fd_pr__nfet_01v8 L=0.15 W=0.42 nf=1 ad=0.1974 as=0.1974 pd=1.78 ps=1.78 mult=1 m=1
xm28_act_o rbl_1__t3_act_o sn_3_1__t0_act_o rwl_3__t1_act_o gnd__t27_act_o sky130_fd_pr__nfet_01v8 L=0.15 W=0.42 nf=1 ad=0.1974 as=0.1974 pd=1.78 ps=1.78 mult=1 m=1
xm29_act_o sn_3_2__t1_act_o wl_3__t2_act_o bl_2__t3_act_o gnd__t28_act_o sky130_fd_pr__nfet_01v8 L=0.15 W=0.42 nf=1 ad=0.1974 as=0.1974 pd=1.78 ps=1.78 mult=1 m=1
xm30_act_o rbl_2__t3_act_o sn_3_2__t0_act_o rwl_3__t2_act_o gnd__t29_act_o sky130_fd_pr__nfet_01v8 L=0.15 W=0.42 nf=1 ad=0.1974 as=0.1974 pd=1.78 ps=1.78 mult=1 m=1
xm31_act_o sn_3_3__t1_act_o wl_3__t3_act_o bl_3__t3_act_o gnd__t30_act_o sky130_fd_pr__nfet_01v8 L=0.15 W=0.42 nf=1 ad=0.1974 as=0.1974 pd=1.78 ps=1.78 mult=1 m=1
xm32_act_o rbl_3__t3_act_o sn_3_3__t0_act_o rwl_3__t3_act_o gnd__t31_act_o sky130_fd_pr__nfet_01v8 L=0.15 W=0.42 nf=1 ad=0.1974 as=0.1974 pd=1.78 ps=1.78 mult=1 m=1
rgnd_t0_act_o gnd__t0_act_o gnd_act_o 63.3529
rgnd_t1_act_o gnd__t1_act_o gnd_act_o 49.0465
rgnd_t2_act_o gnd__t2_act_o gnd_act_o 36.5177
rgnd_t3_act_o gnd__t3_act_o gnd_act_o 28.2406
rgnd_t4_act_o gnd__t4_act_o gnd_act_o 28.2406
rgnd_t5_act_o gnd__t5_act_o gnd_act_o 36.5177
rgnd_t6_act_o gnd__t6_act_o gnd_act_o 49.0465
rgnd_t7_act_o gnd__t7_act_o gnd_act_o 63.3529
rgnd_t8_act_o gnd__t8_act_o gnd_act_o 58.0019
rgnd_t9_act_o gnd__t9_act_o gnd_act_o 41.907
rgnd_t10_act_o gnd__t10_act_o gnd_act_o 26.1568
rgnd_t11_act_o gnd__t11_act_o gnd_act_o 12.1726
rgnd_t12_act_o gnd__t12_act_o gnd_act_o 12.1726
rgnd_t13_act_o gnd__t13_act_o gnd_act_o 26.1568
rgnd_t14_act_o gnd__t14_act_o gnd_act_o 41.907
rgnd_t15_act_o gnd__t15_act_o gnd_act_o 58.0019
rgnd_t16_act_o gnd__t16_act_o gnd_act_o 58.0019
rgnd_t17_act_o gnd__t17_act_o gnd_act_o 41.907
rgnd_t18_act_o gnd__t18_act_o gnd_act_o 26.1568
rgnd_t19_act_o gnd__t19_act_o gnd_act_o 12.1726
rgnd_t20_act_o gnd__t20_act_o gnd_act_o 12.1726
rgnd_t21_act_o gnd__t21_act_o gnd_act_o 26.1568
rgnd_t22_act_o gnd__t22_act_o gnd_act_o 41.907
rgnd_t23_act_o gnd__t23_act_o gnd_act_o 58.0019
rgnd_t24_act_o gnd__t24_act_o gnd_act_o 63.3529
rgnd_t25_act_o gnd__t25_act_o gnd_act_o 49.0465
rgnd_t26_act_o gnd__t26_act_o gnd_act_o 36.5177
rgnd_t27_act_o gnd__t27_act_o gnd_act_o 28.2406
rgnd_t28_act_o gnd__t28_act_o gnd_act_o 28.2406
rgnd_t29_act_o gnd__t29_act_o gnd_act_o 36.5177
rgnd_t30_act_o gnd__t30_act_o gnd_act_o 49.0465
rgnd_t31_act_o gnd__t31_act_o gnd_act_o 63.3529
rbl_0_t0_act_o bl_0__t0_act_o bl_0_act_o 144.555
rbl_0_t1_act_o bl_0__t1_act_o bl_0_act_o 48.1851
rbl_0_t2_act_o bl_0__t2_act_o bl_0_act_o 144.555
rbl_0_t3_act_o bl_0__t3_act_o bl_0_act_o 48.1851
rbl_1_t0_act_o bl_1__t0_act_o bl_1_act_o 144.555
rbl_1_t1_act_o bl_1__t1_act_o bl_1_act_o 48.1851
rbl_1_t2_act_o bl_1__t2_act_o bl_1_act_o 48.1851
rbl_1_t3_act_o bl_1__t3_act_o bl_1_act_o 144.555
rbl_2_t0_act_o bl_2__t0_act_o bl_2_act_o 144.555
rbl_2_t1_act_o bl_2__t1_act_o bl_2_act_o 48.1851
rbl_2_t2_act_o bl_2__t2_act_o bl_2_act_o 48.1851
rbl_2_t3_act_o bl_2__t3_act_o bl_2_act_o 144.555
rbl_3_t0_act_o bl_3__t0_act_o bl_3_act_o 144.555
rbl_3_t1_act_o bl_3__t1_act_o bl_3_act_o 48.1851
rbl_3_t2_act_o bl_3__t2_act_o bl_3_act_o 48.1851
rbl_3_t3_act_o bl_3__t3_act_o bl_3_act_o 144.555
rrbl_0_t0_act_o rbl_0__t0_act_o rbl_0_act_o 144.555
rrbl_0_t1_act_o rbl_0__t1_act_o rbl_0_act_o 48.1851
rrbl_0_t2_act_o rbl_0__t2_act_o rbl_0_act_o 48.1851
rrbl_0_t3_act_o rbl_0__t3_act_o rbl_0_act_o 144.555
rrbl_1_t0_act_o rbl_1__t0_act_o rbl_1_act_o 144.555
rrbl_1_t1_act_o rbl_1__t1_act_o rbl_1_act_o 48.1851
rrbl_1_t2_act_o rbl_1__t2_act_o rbl_1_act_o 48.1851
rrbl_1_t3_act_o rbl_1__t3_act_o rbl_1_act_o 144.555
rrbl_2_t0_act_o rbl_2__t0_act_o rbl_2_act_o 144.555
rrbl_2_t1_act_o rbl_2__t1_act_o rbl_2_act_o 48.1851
rrbl_2_t2_act_o rbl_2__t2_act_o rbl_2_act_o 48.1851
rrbl_2_t3_act_o rbl_2__t3_act_o rbl_2_act_o 144.555
rrbl_3_t0_act_o rbl_3__t0_act_o rbl_3_act_o 144.555
rrbl_3_t1_act_o rbl_3__t1_act_o rbl_3_act_o 48.1851
rrbl_3_t2_act_o rbl_3__t2_act_o rbl_3_act_o 48.1851
rrbl_3_t3_act_o rbl_3__t3_act_o rbl_3_act_o 144.555
rrwl_0_t0_act_o rwl_0__t0_act_o rwl_0_act_o 21.6897
rrwl_0_t1_act_o rwl_0__t1_act_o rwl_0_act_o 7.22989
rrwl_0_t2_act_o rwl_0__t2_act_o rwl_0_act_o 7.22989
rrwl_0_t3_act_o rwl_0__t3_act_o rwl_0_act_o 21.6897
rrwl_1_t0_act_o rwl_1__t0_act_o rwl_1_act_o 21.6897
rrwl_1_t1_act_o rwl_1__t1_act_o rwl_1_act_o 7.22989
rrwl_1_t2_act_o rwl_1__t2_act_o rwl_1_act_o 7.22989
rrwl_1_t3_act_o rwl_1__t3_act_o rwl_1_act_o 21.6897
rrwl_2_t0_act_o rwl_2__t0_act_o rwl_2_act_o 21.6897
rrwl_2_t1_act_o rwl_2__t1_act_o rwl_2_act_o 7.22989
rrwl_2_t2_act_o rwl_2__t2_act_o rwl_2_act_o 7.22989
rrwl_2_t3_act_o rwl_2__t3_act_o rwl_2_act_o 21.6897
rrwl_3_t0_act_o rwl_3__t0_act_o rwl_3_act_o 21.6897
rrwl_3_t1_act_o rwl_3__t1_act_o rwl_3_act_o 7.22989
rrwl_3_t2_act_o rwl_3__t2_act_o rwl_3_act_o 7.22989
rrwl_3_t3_act_o rwl_3__t3_act_o rwl_3_act_o 21.6897
rsn_0_0_t0_act_o sn_0_0__t0_act_o sn_0_0_act_o 125.123
rsn_0_0_t1_act_o sn_0_0__t1_act_o sn_0_0_act_o 125.123
rsn_0_1_t0_act_o sn_0_1__t0_act_o sn_0_1_act_o 125.123
rsn_0_1_t1_act_o sn_0_1__t1_act_o sn_0_1_act_o 125.123
rsn_0_2_t0_act_o sn_0_2__t0_act_o sn_0_2_act_o 125.123
rsn_0_2_t1_act_o sn_0_2__t1_act_o sn_0_2_act_o 125.123
rsn_0_3_t0_act_o sn_0_3__t0_act_o sn_0_3_act_o 125.123
rsn_0_3_t1_act_o sn_0_3__t1_act_o sn_0_3_act_o 125.123
rsn_1_0_t0_act_o sn_1_0__t0_act_o sn_1_0_act_o 125.123
rsn_1_0_t1_act_o sn_1_0__t1_act_o sn_1_0_act_o 125.123
rsn_1_1_t0_act_o sn_1_1__t0_act_o sn_1_1_act_o 125.123
rsn_1_1_t1_act_o sn_1_1__t1_act_o sn_1_1_act_o 125.123
rsn_1_2_t0_act_o sn_1_2__t0_act_o sn_1_2_act_o 125.123
rsn_1_2_t1_act_o sn_1_2__t1_act_o sn_1_2_act_o 125.123
rsn_1_3_t0_act_o sn_1_3__t0_act_o sn_1_3_act_o 125.123
rsn_1_3_t1_act_o sn_1_3__t1_act_o sn_1_3_act_o 125.123
rsn_2_0_t0_act_o sn_2_0__t0_act_o sn_2_0_act_o 125.123
rsn_2_0_t1_act_o sn_2_0__t1_act_o sn_2_0_act_o 125.123
rsn_2_1_t0_act_o sn_2_1__t0_act_o sn_2_1_act_o 125.123
rsn_2_1_t1_act_o sn_2_1__t1_act_o sn_2_1_act_o 125.123
rsn_2_2_t0_act_o sn_2_2__t0_act_o sn_2_2_act_o 125.123
rsn_2_2_t1_act_o sn_2_2__t1_act_o sn_2_2_act_o 125.123
rsn_2_3_t0_act_o sn_2_3__t0_act_o sn_2_3_act_o 125.123
rsn_2_3_t1_act_o sn_2_3__t1_act_o sn_2_3_act_o 125.123
rsn_3_0_t0_act_o sn_3_0__t0_act_o sn_3_0_act_o 125.123
rsn_3_0_t1_act_o sn_3_0__t1_act_o sn_3_0_act_o 125.123
rsn_3_1_t0_act_o sn_3_1__t0_act_o sn_3_1_act_o 125.123
rsn_3_1_t1_act_o sn_3_1__t1_act_o sn_3_1_act_o 125.123
rsn_3_2_t0_act_o sn_3_2__t0_act_o sn_3_2_act_o 125.123
rsn_3_2_t1_act_o sn_3_2__t1_act_o sn_3_2_act_o 125.123
rsn_3_3_t0_act_o sn_3_3__t0_act_o sn_3_3_act_o 125.123
rsn_3_3_t1_act_o sn_3_3__t1_act_o sn_3_3_act_o 125.123
rwl_0_t0_act_o wl_0__t0_act_o wl_0_act_o 54.2844
rwl_0_t1_act_o wl_0__t1_act_o wl_0_act_o 54.2844
rwl_0_t2_act_o wl_0__t2_act_o wl_0_act_o 162.853
rwl_0_t3_act_o wl_0__t3_act_o wl_0_act_o 162.853
rwl_1_t0_act_o wl_1__t0_act_o wl_1_act_o 162.853
rwl_1_t1_act_o wl_1__t1_act_o wl_1_act_o 54.2844
rwl_1_t2_act_o wl_1__t2_act_o wl_1_act_o 54.2844
rwl_1_t3_act_o wl_1__t3_act_o wl_1_act_o 162.853
rwl_2_t0_act_o wl_2__t0_act_o wl_2_act_o 54.2844
rwl_2_t1_act_o wl_2__t1_act_o wl_2_act_o 54.2844
rwl_2_t2_act_o wl_2__t2_act_o wl_2_act_o 162.853
rwl_2_t3_act_o wl_2__t3_act_o wl_2_act_o 162.853
rwl_3_t0_act_o wl_3__t0_act_o wl_3_act_o 162.853
rwl_3_t1_act_o wl_3__t1_act_o wl_3_act_o 54.2844
rwl_3_t2_act_o wl_3__t2_act_o wl_3_act_o 54.2844
rwl_3_t3_act_o wl_3__t3_act_o wl_3_act_o 162.853
cgnd_act_o gnd_act_o vsubs_act_o 4.09475e-15
cbl_0_act_o bl_0_act_o vsubs_act_o 5.96076e-16
cbl_1_act_o bl_1_act_o vsubs_act_o 5.81168e-16
cbl_2_act_o bl_2_act_o vsubs_act_o 5.81168e-16
cbl_3_act_o bl_3_act_o vsubs_act_o 5.81168e-16
crbl_0_act_o rbl_0_act_o vsubs_act_o 5.81168e-16
crbl_1_act_o rbl_1_act_o vsubs_act_o 5.81168e-16
crbl_2_act_o rbl_2_act_o vsubs_act_o 5.81168e-16
crbl_3_act_o rbl_3_act_o vsubs_act_o 5.96076e-16
crwl_0_act_o rwl_0_act_o vsubs_act_o 1.18713e-15
crwl_1_act_o rwl_1_act_o vsubs_act_o 1.18713e-15
crwl_2_act_o rwl_2_act_o vsubs_act_o 1.18713e-15
crwl_3_act_o rwl_3_act_o vsubs_act_o 1.18713e-15
csn_0_0_act_o sn_0_0_act_o vsubs_act_o 4.33689e-16
csn_0_1_act_o sn_0_1_act_o vsubs_act_o 4.30576e-16
csn_0_2_act_o sn_0_2_act_o vsubs_act_o 4.30576e-16
csn_0_3_act_o sn_0_3_act_o vsubs_act_o 4.32518e-16
csn_1_0_act_o sn_1_0_act_o vsubs_act_o 4.33689e-16
csn_1_1_act_o sn_1_1_act_o vsubs_act_o 4.30576e-16
csn_1_2_act_o sn_1_2_act_o vsubs_act_o 4.30576e-16
csn_1_3_act_o sn_1_3_act_o vsubs_act_o 4.32518e-16
csn_2_0_act_o sn_2_0_act_o vsubs_act_o 4.33689e-16
csn_2_1_act_o sn_2_1_act_o vsubs_act_o 4.30576e-16
csn_2_2_act_o sn_2_2_act_o vsubs_act_o 4.30576e-16
csn_2_3_act_o sn_2_3_act_o vsubs_act_o 4.32518e-16
csn_3_0_act_o sn_3_0_act_o vsubs_act_o 4.33689e-16
csn_3_1_act_o sn_3_1_act_o vsubs_act_o 4.30576e-16
csn_3_2_act_o sn_3_2_act_o vsubs_act_o 4.30576e-16
csn_3_3_act_o sn_3_3_act_o vsubs_act_o 4.32518e-16
cwl_0_act_o wl_0_act_o vsubs_act_o 1.90928e-15
cwl_1_act_o wl_1_act_o vsubs_act_o 1.90928e-15
cwl_2_act_o wl_2_act_o vsubs_act_o 1.90928e-15
cwl_3_act_o wl_3_act_o vsubs_act_o 1.91375e-15
ccc_bl_0_sn_0_0_act_o bl_0_act_o sn_0_0_act_o 1.071e-17
ccc_bl_0_sn_1_0_act_o bl_0_act_o sn_1_0_act_o 1.071e-17
ccc_bl_0_sn_2_0_act_o bl_0_act_o sn_2_0_act_o 1.071e-17
ccc_bl_0_sn_3_0_act_o bl_0_act_o sn_3_0_act_o 1.071e-17
ccc_bl_0_wl_0_act_o bl_0_act_o wl_0_act_o 2.4327e-17
ccc_bl_0_wl_1_act_o bl_0_act_o wl_1_act_o 2.4327e-17
ccc_bl_0_wl_2_act_o bl_0_act_o wl_2_act_o 2.4327e-17
ccc_bl_1_rbl_0_act_o bl_1_act_o rbl_0_act_o 1.29795e-16
ccc_bl_1_rwl_0_act_o bl_1_act_o rwl_0_act_o 9.028e-18
ccc_bl_1_rwl_1_act_o bl_1_act_o rwl_1_act_o 9.028e-18
ccc_bl_1_rwl_2_act_o bl_1_act_o rwl_2_act_o 9.028e-18
ccc_bl_1_rwl_3_act_o bl_1_act_o rwl_3_act_o 9.028e-18
ccc_bl_1_sn_0_1_act_o bl_1_act_o sn_0_1_act_o 1.071e-17
ccc_bl_1_sn_1_1_act_o bl_1_act_o sn_1_1_act_o 1.071e-17
ccc_bl_1_sn_2_1_act_o bl_1_act_o sn_2_1_act_o 1.071e-17
ccc_bl_1_sn_3_1_act_o bl_1_act_o sn_3_1_act_o 1.071e-17
ccc_bl_1_wl_0_act_o bl_1_act_o wl_0_act_o 2.7627e-17
ccc_bl_1_wl_1_act_o bl_1_act_o wl_1_act_o 2.7627e-17
ccc_bl_1_wl_2_act_o bl_1_act_o wl_2_act_o 2.7627e-17
ccc_bl_2_rbl_1_act_o bl_2_act_o rbl_1_act_o 1.29795e-16
ccc_bl_2_rwl_0_act_o bl_2_act_o rwl_0_act_o 9.028e-18
ccc_bl_2_rwl_1_act_o bl_2_act_o rwl_1_act_o 9.028e-18
ccc_bl_2_rwl_2_act_o bl_2_act_o rwl_2_act_o 9.028e-18
ccc_bl_2_rwl_3_act_o bl_2_act_o rwl_3_act_o 9.028e-18
ccc_bl_2_sn_0_2_act_o bl_2_act_o sn_0_2_act_o 1.071e-17
ccc_bl_2_sn_1_2_act_o bl_2_act_o sn_1_2_act_o 1.071e-17
ccc_bl_2_sn_2_2_act_o bl_2_act_o sn_2_2_act_o 1.071e-17
ccc_bl_2_sn_3_2_act_o bl_2_act_o sn_3_2_act_o 1.071e-17
ccc_bl_2_wl_0_act_o bl_2_act_o wl_0_act_o 2.7627e-17
ccc_bl_2_wl_1_act_o bl_2_act_o wl_1_act_o 2.7627e-17
ccc_bl_2_wl_2_act_o bl_2_act_o wl_2_act_o 2.7627e-17
ccc_bl_3_rbl_2_act_o bl_3_act_o rbl_2_act_o 1.29795e-16
ccc_bl_3_rwl_0_act_o bl_3_act_o rwl_0_act_o 9.028e-18
ccc_bl_3_rwl_1_act_o bl_3_act_o rwl_1_act_o 9.028e-18
ccc_bl_3_rwl_2_act_o bl_3_act_o rwl_2_act_o 9.028e-18
ccc_bl_3_rwl_3_act_o bl_3_act_o rwl_3_act_o 9.028e-18
ccc_bl_3_sn_0_3_act_o bl_3_act_o sn_0_3_act_o 1.071e-17
ccc_bl_3_sn_1_3_act_o bl_3_act_o sn_1_3_act_o 1.071e-17
ccc_bl_3_sn_2_3_act_o bl_3_act_o sn_2_3_act_o 1.071e-17
ccc_bl_3_sn_3_3_act_o bl_3_act_o sn_3_3_act_o 1.071e-17
ccc_bl_3_wl_0_act_o bl_3_act_o wl_0_act_o 2.7627e-17
ccc_bl_3_wl_1_act_o bl_3_act_o wl_1_act_o 2.7627e-17
ccc_bl_3_wl_2_act_o bl_3_act_o wl_2_act_o 2.7627e-17
ccc_rbl_0_rwl_0_act_o rbl_0_act_o rwl_0_act_o 1.9738e-17
ccc_rbl_0_rwl_1_act_o rbl_0_act_o rwl_1_act_o 1.9738e-17
ccc_rbl_0_rwl_2_act_o rbl_0_act_o rwl_2_act_o 1.9738e-17
ccc_rbl_0_rwl_3_act_o rbl_0_act_o rwl_3_act_o 1.9738e-17
ccc_rbl_0_sn_0_0_act_o rbl_0_act_o sn_0_0_act_o 1.071e-17
ccc_rbl_0_sn_1_0_act_o rbl_0_act_o sn_1_0_act_o 2.4327e-17
ccc_rbl_0_sn_2_0_act_o rbl_0_act_o sn_2_0_act_o 2.4327e-17
ccc_rbl_0_wl_0_act_o rbl_0_act_o wl_0_act_o 3.3e-18
ccc_rbl_0_wl_1_act_o rbl_0_act_o wl_1_act_o 3.3e-18
ccc_rbl_0_wl_2_act_o rbl_0_act_o wl_2_act_o 3.3e-18
ccc_rbl_1_rwl_0_act_o rbl_1_act_o rwl_0_act_o 1.9738e-17
ccc_rbl_1_rwl_1_act_o rbl_1_act_o rwl_1_act_o 1.9738e-17
ccc_rbl_1_rwl_2_act_o rbl_1_act_o rwl_2_act_o 1.9738e-17
ccc_rbl_1_rwl_3_act_o rbl_1_act_o rwl_3_act_o 1.9738e-17
ccc_rbl_1_sn_0_1_act_o rbl_1_act_o sn_0_1_act_o 1.071e-17
ccc_rbl_1_sn_1_1_act_o rbl_1_act_o sn_1_1_act_o 2.4327e-17
ccc_rbl_1_sn_2_1_act_o rbl_1_act_o sn_2_1_act_o 2.4327e-17
ccc_rbl_1_wl_0_act_o rbl_1_act_o wl_0_act_o 3.3e-18
ccc_rbl_1_wl_1_act_o rbl_1_act_o wl_1_act_o 3.3e-18
ccc_rbl_1_wl_2_act_o rbl_1_act_o wl_2_act_o 3.3e-18
ccc_rbl_2_rwl_0_act_o rbl_2_act_o rwl_0_act_o 1.9738e-17
ccc_rbl_2_rwl_1_act_o rbl_2_act_o rwl_1_act_o 1.9738e-17
ccc_rbl_2_rwl_2_act_o rbl_2_act_o rwl_2_act_o 1.9738e-17
ccc_rbl_2_rwl_3_act_o rbl_2_act_o rwl_3_act_o 1.9738e-17
ccc_rbl_2_sn_0_2_act_o rbl_2_act_o sn_0_2_act_o 1.071e-17
ccc_rbl_2_sn_1_2_act_o rbl_2_act_o sn_1_2_act_o 2.4327e-17
ccc_rbl_2_sn_2_2_act_o rbl_2_act_o sn_2_2_act_o 2.4327e-17
ccc_rbl_2_wl_0_act_o rbl_2_act_o wl_0_act_o 3.3e-18
ccc_rbl_2_wl_1_act_o rbl_2_act_o wl_1_act_o 3.3e-18
ccc_rbl_2_wl_2_act_o rbl_2_act_o wl_2_act_o 3.3e-18
ccc_rbl_3_rwl_0_act_o rbl_3_act_o rwl_0_act_o 1.071e-17
ccc_rbl_3_rwl_1_act_o rbl_3_act_o rwl_1_act_o 1.071e-17
ccc_rbl_3_rwl_2_act_o rbl_3_act_o rwl_2_act_o 1.071e-17
ccc_rbl_3_rwl_3_act_o rbl_3_act_o rwl_3_act_o 1.071e-17
ccc_rbl_3_sn_0_3_act_o rbl_3_act_o sn_0_3_act_o 1.071e-17
ccc_rbl_3_sn_1_3_act_o rbl_3_act_o sn_1_3_act_o 2.4327e-17
ccc_rbl_3_sn_2_3_act_o rbl_3_act_o sn_2_3_act_o 2.4327e-17
ccc_rwl_0_sn_0_0_act_o rwl_0_act_o sn_0_0_act_o 1.0072e-17
ccc_rwl_0_sn_0_1_act_o rwl_0_act_o sn_0_1_act_o 1.9682e-17
ccc_rwl_0_sn_0_2_act_o rwl_0_act_o sn_0_2_act_o 1.9682e-17
ccc_rwl_0_sn_0_3_act_o rwl_0_act_o sn_0_3_act_o 1.9682e-17
ccc_rwl_1_sn_1_0_act_o rwl_1_act_o sn_1_0_act_o 1.0072e-17
ccc_rwl_1_sn_1_1_act_o rwl_1_act_o sn_1_1_act_o 1.9682e-17
ccc_rwl_1_sn_1_2_act_o rwl_1_act_o sn_1_2_act_o 1.9682e-17
ccc_rwl_1_sn_1_3_act_o rwl_1_act_o sn_1_3_act_o 1.9682e-17
ccc_rwl_2_sn_2_0_act_o rwl_2_act_o sn_2_0_act_o 1.0072e-17
ccc_rwl_2_sn_2_1_act_o rwl_2_act_o sn_2_1_act_o 1.9682e-17
ccc_rwl_2_sn_2_2_act_o rwl_2_act_o sn_2_2_act_o 1.9682e-17
ccc_rwl_2_sn_2_3_act_o rwl_2_act_o sn_2_3_act_o 1.9682e-17
ccc_rwl_3_sn_3_0_act_o rwl_3_act_o sn_3_0_act_o 1.0072e-17
ccc_rwl_3_sn_3_1_act_o rwl_3_act_o sn_3_1_act_o 1.9682e-17
ccc_rwl_3_sn_3_2_act_o rwl_3_act_o sn_3_2_act_o 1.9682e-17
ccc_rwl_3_sn_3_3_act_o rwl_3_act_o sn_3_3_act_o 1.9682e-17
ccc_sn_0_0_wl_0_act_o sn_0_0_act_o wl_0_act_o 1.9664e-17
ccc_sn_0_1_wl_0_act_o sn_0_1_act_o wl_0_act_o 1.9664e-17
ccc_sn_0_2_wl_0_act_o sn_0_2_act_o wl_0_act_o 1.9664e-17
ccc_sn_0_3_wl_0_act_o sn_0_3_act_o wl_0_act_o 1.3668e-17
ccc_sn_1_0_wl_1_act_o sn_1_0_act_o wl_1_act_o 1.9664e-17
ccc_sn_1_1_wl_1_act_o sn_1_1_act_o wl_1_act_o 1.6705e-17
ccc_sn_1_2_wl_1_act_o sn_1_2_act_o wl_1_act_o 1.6705e-17
ccc_sn_1_3_wl_1_act_o sn_1_3_act_o wl_1_act_o 1.071e-17
ccc_sn_2_0_wl_2_act_o sn_2_0_act_o wl_2_act_o 1.9664e-17
ccc_sn_2_1_wl_2_act_o sn_2_1_act_o wl_2_act_o 1.6705e-17
ccc_sn_2_2_wl_2_act_o sn_2_2_act_o wl_2_act_o 1.6705e-17
ccc_sn_2_3_wl_2_act_o sn_2_3_act_o wl_2_act_o 1.071e-17
ccc_sn_3_0_wl_3_act_o sn_3_0_act_o wl_3_act_o 1.9664e-17
ccc_sn_3_1_wl_3_act_o sn_3_1_act_o wl_3_act_o 1.6705e-17
ccc_sn_3_2_wl_3_act_o sn_3_2_act_o wl_3_act_o 1.6705e-17
ccc_sn_3_3_wl_3_act_o sn_3_3_act_o wl_3_act_o 1.071e-17
vpre0_act_o pre0_act_o 0 dc 0.9
vpre1_act_o pre1_act_o 0 dc 0.9
vpre2_act_o pre2_act_o 0 dc 0.9
vpre3_act_o pre3_act_o 0 dc 0.9
vwbl0_act_o bl_0_act_o 0 pwl(0.000000e+00 0 2.000000e-08 0 2.010000e-08 1.8 3.200000e-08 1.8 3.210000e-08 0)
vwbl1_act_o bl_1_act_o 0 pwl(0.000000e+00 0 2.000000e-08 0 2.010000e-08 1.8 3.200000e-08 1.8 3.210000e-08 0)
vwbl2_act_o bl_2_act_o 0 pwl(0.000000e+00 0 2.000000e-08 0 2.010000e-08 1.8 3.200000e-08 1.8 3.210000e-08 0)
vwbl3_act_o bl_3_act_o 0 pwl(0.000000e+00 0 2.000000e-08 0 2.010000e-08 1.8 3.200000e-08 1.8 3.210000e-08 0)
vrwl0_act_o rwl_0_act_o 0 pwl(0.000000e+00 1.8 9.000000e-09 1.8 9.100000e-09 0 3.200000e-08 0 3.210000e-08 1.8)
vrwl1_act_o rwl_1_act_o 0 dc 1.8
vrwl2_act_o rwl_2_act_o 0 dc 1.8
vrwl3_act_o rwl_3_act_o 0 dc 1.8
vwwl0_act_o wl_0_act_o 0 pwl(0.000000e+00 0 2.000000e-08 0 2.010000e-08 1.8 3.000000e-08 1.8 3.010000e-08 0)
vwwl1_act_o wl_1_act_o 0 dc 0
vwwl2_act_o wl_2_act_o 0 dc 0
vwwl3_act_o wl_3_act_o 0 dc 0
vbody_act_o gnd_act_o 0 dc 0
vsub_act_o vsubs_act_o 0 dc 0
vctl_act_o ctl_act_o 0 pwl(0.000000e+00 1.8 7.000000e-09 1.8 7.100000e-09 0 3.200000e-08 0 3.210000e-08 1.8)   $ EXCLUDED: switch control, outside the boundary
spre0_act_o pre0_act_o rbl_0_act_o ctl_act_o 0 swpre
spre1_act_o pre1_act_o rbl_1_act_o ctl_act_o 0 swpre
spre2_act_o pre2_act_o rbl_2_act_o ctl_act_o 0 swpre
spre3_act_o pre3_act_o rbl_3_act_o ctl_act_o 0 swpre
bpn_vpre0_act_o pn_vpre0_act_o 0 v=(-v(pre0_act_o)*i(vpre0_act_o))
bpg_vpre0_act_o pg_vpre0_act_o 0 v=max((-v(pre0_act_o)*i(vpre0_act_o)),0)
bpr_vpre0_act_o pr_vpre0_act_o 0 v=max(-(-v(pre0_act_o)*i(vpre0_act_o)),0)
bpn_vpre1_act_o pn_vpre1_act_o 0 v=(-v(pre1_act_o)*i(vpre1_act_o))
bpg_vpre1_act_o pg_vpre1_act_o 0 v=max((-v(pre1_act_o)*i(vpre1_act_o)),0)
bpr_vpre1_act_o pr_vpre1_act_o 0 v=max(-(-v(pre1_act_o)*i(vpre1_act_o)),0)
bpn_vpre2_act_o pn_vpre2_act_o 0 v=(-v(pre2_act_o)*i(vpre2_act_o))
bpg_vpre2_act_o pg_vpre2_act_o 0 v=max((-v(pre2_act_o)*i(vpre2_act_o)),0)
bpr_vpre2_act_o pr_vpre2_act_o 0 v=max(-(-v(pre2_act_o)*i(vpre2_act_o)),0)
bpn_vpre3_act_o pn_vpre3_act_o 0 v=(-v(pre3_act_o)*i(vpre3_act_o))
bpg_vpre3_act_o pg_vpre3_act_o 0 v=max((-v(pre3_act_o)*i(vpre3_act_o)),0)
bpr_vpre3_act_o pr_vpre3_act_o 0 v=max(-(-v(pre3_act_o)*i(vpre3_act_o)),0)
bpn_vwbl0_act_o pn_vwbl0_act_o 0 v=(-v(bl_0_act_o)*i(vwbl0_act_o))
bpg_vwbl0_act_o pg_vwbl0_act_o 0 v=max((-v(bl_0_act_o)*i(vwbl0_act_o)),0)
bpr_vwbl0_act_o pr_vwbl0_act_o 0 v=max(-(-v(bl_0_act_o)*i(vwbl0_act_o)),0)
bpn_vwbl1_act_o pn_vwbl1_act_o 0 v=(-v(bl_1_act_o)*i(vwbl1_act_o))
bpg_vwbl1_act_o pg_vwbl1_act_o 0 v=max((-v(bl_1_act_o)*i(vwbl1_act_o)),0)
bpr_vwbl1_act_o pr_vwbl1_act_o 0 v=max(-(-v(bl_1_act_o)*i(vwbl1_act_o)),0)
bpn_vwbl2_act_o pn_vwbl2_act_o 0 v=(-v(bl_2_act_o)*i(vwbl2_act_o))
bpg_vwbl2_act_o pg_vwbl2_act_o 0 v=max((-v(bl_2_act_o)*i(vwbl2_act_o)),0)
bpr_vwbl2_act_o pr_vwbl2_act_o 0 v=max(-(-v(bl_2_act_o)*i(vwbl2_act_o)),0)
bpn_vwbl3_act_o pn_vwbl3_act_o 0 v=(-v(bl_3_act_o)*i(vwbl3_act_o))
bpg_vwbl3_act_o pg_vwbl3_act_o 0 v=max((-v(bl_3_act_o)*i(vwbl3_act_o)),0)
bpr_vwbl3_act_o pr_vwbl3_act_o 0 v=max(-(-v(bl_3_act_o)*i(vwbl3_act_o)),0)
bpn_vrwl0_act_o pn_vrwl0_act_o 0 v=(-v(rwl_0_act_o)*i(vrwl0_act_o))
bpg_vrwl0_act_o pg_vrwl0_act_o 0 v=max((-v(rwl_0_act_o)*i(vrwl0_act_o)),0)
bpr_vrwl0_act_o pr_vrwl0_act_o 0 v=max(-(-v(rwl_0_act_o)*i(vrwl0_act_o)),0)
bpn_vrwl1_act_o pn_vrwl1_act_o 0 v=(-v(rwl_1_act_o)*i(vrwl1_act_o))
bpg_vrwl1_act_o pg_vrwl1_act_o 0 v=max((-v(rwl_1_act_o)*i(vrwl1_act_o)),0)
bpr_vrwl1_act_o pr_vrwl1_act_o 0 v=max(-(-v(rwl_1_act_o)*i(vrwl1_act_o)),0)
bpn_vrwl2_act_o pn_vrwl2_act_o 0 v=(-v(rwl_2_act_o)*i(vrwl2_act_o))
bpg_vrwl2_act_o pg_vrwl2_act_o 0 v=max((-v(rwl_2_act_o)*i(vrwl2_act_o)),0)
bpr_vrwl2_act_o pr_vrwl2_act_o 0 v=max(-(-v(rwl_2_act_o)*i(vrwl2_act_o)),0)
bpn_vrwl3_act_o pn_vrwl3_act_o 0 v=(-v(rwl_3_act_o)*i(vrwl3_act_o))
bpg_vrwl3_act_o pg_vrwl3_act_o 0 v=max((-v(rwl_3_act_o)*i(vrwl3_act_o)),0)
bpr_vrwl3_act_o pr_vrwl3_act_o 0 v=max(-(-v(rwl_3_act_o)*i(vrwl3_act_o)),0)
bpn_vwwl0_act_o pn_vwwl0_act_o 0 v=(-v(wl_0_act_o)*i(vwwl0_act_o))
bpg_vwwl0_act_o pg_vwwl0_act_o 0 v=max((-v(wl_0_act_o)*i(vwwl0_act_o)),0)
bpr_vwwl0_act_o pr_vwwl0_act_o 0 v=max(-(-v(wl_0_act_o)*i(vwwl0_act_o)),0)
bpn_vwwl1_act_o pn_vwwl1_act_o 0 v=(-v(wl_1_act_o)*i(vwwl1_act_o))
bpg_vwwl1_act_o pg_vwwl1_act_o 0 v=max((-v(wl_1_act_o)*i(vwwl1_act_o)),0)
bpr_vwwl1_act_o pr_vwwl1_act_o 0 v=max(-(-v(wl_1_act_o)*i(vwwl1_act_o)),0)
bpn_vwwl2_act_o pn_vwwl2_act_o 0 v=(-v(wl_2_act_o)*i(vwwl2_act_o))
bpg_vwwl2_act_o pg_vwwl2_act_o 0 v=max((-v(wl_2_act_o)*i(vwwl2_act_o)),0)
bpr_vwwl2_act_o pr_vwwl2_act_o 0 v=max(-(-v(wl_2_act_o)*i(vwwl2_act_o)),0)
bpn_vwwl3_act_o pn_vwwl3_act_o 0 v=(-v(wl_3_act_o)*i(vwwl3_act_o))
bpg_vwwl3_act_o pg_vwwl3_act_o 0 v=max((-v(wl_3_act_o)*i(vwwl3_act_o)),0)
bpr_vwwl3_act_o pr_vwwl3_act_o 0 v=max(-(-v(wl_3_act_o)*i(vwwl3_act_o)),0)
bpn_vbody_act_o pn_vbody_act_o 0 v=(-v(gnd_act_o)*i(vbody_act_o))
bpg_vbody_act_o pg_vbody_act_o 0 v=max((-v(gnd_act_o)*i(vbody_act_o)),0)
bpr_vbody_act_o pr_vbody_act_o 0 v=max(-(-v(gnd_act_o)*i(vbody_act_o)),0)
bpn_vsub_act_o pn_vsub_act_o 0 v=(-v(vsubs_act_o)*i(vsub_act_o))
bpg_vsub_act_o pg_vsub_act_o 0 v=max((-v(vsubs_act_o)*i(vsub_act_o)),0)
bpr_vsub_act_o pr_vsub_act_o 0 v=max(-(-v(vsubs_act_o)*i(vsub_act_o)),0)

* ---- instance act_c: mode active, pattern checker ----
xm1_act_c sn_0_0__t0_act_c wl_0__t3_act_c bl_0__t0_act_c gnd__t0_act_c sky130_fd_pr__nfet_01v8 L=0.15 W=0.42 nf=1 ad=0.1974 as=0.1974 pd=1.78 ps=1.78 mult=1 m=1
xm2_act_c rbl_0__t0_act_c sn_0_0__t1_act_c rwl_0__t0_act_c gnd__t1_act_c sky130_fd_pr__nfet_01v8 L=0.15 W=0.42 nf=1 ad=0.1974 as=0.1974 pd=1.78 ps=1.78 mult=1 m=1
xm3_act_c sn_0_1__t1_act_c wl_0__t0_act_c bl_1__t0_act_c gnd__t2_act_c sky130_fd_pr__nfet_01v8 L=0.15 W=0.42 nf=1 ad=0.1974 as=0.1974 pd=1.78 ps=1.78 mult=1 m=1
xm4_act_c rbl_1__t0_act_c sn_0_1__t0_act_c rwl_0__t1_act_c gnd__t3_act_c sky130_fd_pr__nfet_01v8 L=0.15 W=0.42 nf=1 ad=0.1974 as=0.1974 pd=1.78 ps=1.78 mult=1 m=1
xm5_act_c sn_0_2__t1_act_c wl_0__t1_act_c bl_2__t0_act_c gnd__t4_act_c sky130_fd_pr__nfet_01v8 L=0.15 W=0.42 nf=1 ad=0.1974 as=0.1974 pd=1.78 ps=1.78 mult=1 m=1
xm6_act_c rbl_2__t0_act_c sn_0_2__t0_act_c rwl_0__t2_act_c gnd__t5_act_c sky130_fd_pr__nfet_01v8 L=0.15 W=0.42 nf=1 ad=0.1974 as=0.1974 pd=1.78 ps=1.78 mult=1 m=1
xm7_act_c sn_0_3__t1_act_c wl_0__t2_act_c bl_3__t0_act_c gnd__t6_act_c sky130_fd_pr__nfet_01v8 L=0.15 W=0.42 nf=1 ad=0.1974 as=0.1974 pd=1.78 ps=1.78 mult=1 m=1
xm8_act_c rbl_3__t0_act_c sn_0_3__t0_act_c rwl_0__t3_act_c gnd__t7_act_c sky130_fd_pr__nfet_01v8 L=0.15 W=0.42 nf=1 ad=0.1974 as=0.1974 pd=1.78 ps=1.78 mult=1 m=1
xm9_act_c sn_1_0__t1_act_c wl_1__t0_act_c bl_0__t1_act_c gnd__t8_act_c sky130_fd_pr__nfet_01v8 L=0.15 W=0.42 nf=1 ad=0.1974 as=0.1974 pd=1.78 ps=1.78 mult=1 m=1
xm10_act_c rbl_0__t1_act_c sn_1_0__t0_act_c rwl_1__t0_act_c gnd__t9_act_c sky130_fd_pr__nfet_01v8 L=0.15 W=0.42 nf=1 ad=0.1974 as=0.1974 pd=1.78 ps=1.78 mult=1 m=1
xm11_act_c sn_1_1__t1_act_c wl_1__t1_act_c bl_1__t1_act_c gnd__t10_act_c sky130_fd_pr__nfet_01v8 L=0.15 W=0.42 nf=1 ad=0.1974 as=0.1974 pd=1.78 ps=1.78 mult=1 m=1
xm12_act_c rbl_1__t1_act_c sn_1_1__t0_act_c rwl_1__t1_act_c gnd__t11_act_c sky130_fd_pr__nfet_01v8 L=0.15 W=0.42 nf=1 ad=0.1974 as=0.1974 pd=1.78 ps=1.78 mult=1 m=1
xm13_act_c sn_1_2__t1_act_c wl_1__t2_act_c bl_2__t1_act_c gnd__t12_act_c sky130_fd_pr__nfet_01v8 L=0.15 W=0.42 nf=1 ad=0.1974 as=0.1974 pd=1.78 ps=1.78 mult=1 m=1
xm14_act_c rbl_2__t1_act_c sn_1_2__t0_act_c rwl_1__t2_act_c gnd__t13_act_c sky130_fd_pr__nfet_01v8 L=0.15 W=0.42 nf=1 ad=0.1974 as=0.1974 pd=1.78 ps=1.78 mult=1 m=1
xm15_act_c sn_1_3__t1_act_c wl_1__t3_act_c bl_3__t1_act_c gnd__t14_act_c sky130_fd_pr__nfet_01v8 L=0.15 W=0.42 nf=1 ad=0.1974 as=0.1974 pd=1.78 ps=1.78 mult=1 m=1
xm16_act_c rbl_3__t1_act_c sn_1_3__t0_act_c rwl_1__t3_act_c gnd__t15_act_c sky130_fd_pr__nfet_01v8 L=0.15 W=0.42 nf=1 ad=0.1974 as=0.1974 pd=1.78 ps=1.78 mult=1 m=1
xm17_act_c sn_2_0__t1_act_c wl_2__t3_act_c bl_0__t3_act_c gnd__t16_act_c sky130_fd_pr__nfet_01v8 L=0.15 W=0.42 nf=1 ad=0.1974 as=0.1974 pd=1.78 ps=1.78 mult=1 m=1
xm18_act_c rbl_0__t2_act_c sn_2_0__t0_act_c rwl_2__t0_act_c gnd__t17_act_c sky130_fd_pr__nfet_01v8 L=0.15 W=0.42 nf=1 ad=0.1974 as=0.1974 pd=1.78 ps=1.78 mult=1 m=1
xm19_act_c sn_2_1__t1_act_c wl_2__t0_act_c bl_1__t2_act_c gnd__t18_act_c sky130_fd_pr__nfet_01v8 L=0.15 W=0.42 nf=1 ad=0.1974 as=0.1974 pd=1.78 ps=1.78 mult=1 m=1
xm20_act_c rbl_1__t2_act_c sn_2_1__t0_act_c rwl_2__t1_act_c gnd__t19_act_c sky130_fd_pr__nfet_01v8 L=0.15 W=0.42 nf=1 ad=0.1974 as=0.1974 pd=1.78 ps=1.78 mult=1 m=1
xm21_act_c sn_2_2__t1_act_c wl_2__t1_act_c bl_2__t2_act_c gnd__t20_act_c sky130_fd_pr__nfet_01v8 L=0.15 W=0.42 nf=1 ad=0.1974 as=0.1974 pd=1.78 ps=1.78 mult=1 m=1
xm22_act_c rbl_2__t2_act_c sn_2_2__t0_act_c rwl_2__t2_act_c gnd__t21_act_c sky130_fd_pr__nfet_01v8 L=0.15 W=0.42 nf=1 ad=0.1974 as=0.1974 pd=1.78 ps=1.78 mult=1 m=1
xm23_act_c sn_2_3__t1_act_c wl_2__t2_act_c bl_3__t2_act_c gnd__t22_act_c sky130_fd_pr__nfet_01v8 L=0.15 W=0.42 nf=1 ad=0.1974 as=0.1974 pd=1.78 ps=1.78 mult=1 m=1
xm24_act_c rbl_3__t2_act_c sn_2_3__t0_act_c rwl_2__t3_act_c gnd__t23_act_c sky130_fd_pr__nfet_01v8 L=0.15 W=0.42 nf=1 ad=0.1974 as=0.1974 pd=1.78 ps=1.78 mult=1 m=1
xm25_act_c sn_3_0__t1_act_c wl_3__t0_act_c bl_0__t2_act_c gnd__t24_act_c sky130_fd_pr__nfet_01v8 L=0.15 W=0.42 nf=1 ad=0.1974 as=0.1974 pd=1.78 ps=1.78 mult=1 m=1
xm26_act_c rbl_0__t3_act_c sn_3_0__t0_act_c rwl_3__t0_act_c gnd__t25_act_c sky130_fd_pr__nfet_01v8 L=0.15 W=0.42 nf=1 ad=0.1974 as=0.1974 pd=1.78 ps=1.78 mult=1 m=1
xm27_act_c sn_3_1__t1_act_c wl_3__t1_act_c bl_1__t3_act_c gnd__t26_act_c sky130_fd_pr__nfet_01v8 L=0.15 W=0.42 nf=1 ad=0.1974 as=0.1974 pd=1.78 ps=1.78 mult=1 m=1
xm28_act_c rbl_1__t3_act_c sn_3_1__t0_act_c rwl_3__t1_act_c gnd__t27_act_c sky130_fd_pr__nfet_01v8 L=0.15 W=0.42 nf=1 ad=0.1974 as=0.1974 pd=1.78 ps=1.78 mult=1 m=1
xm29_act_c sn_3_2__t1_act_c wl_3__t2_act_c bl_2__t3_act_c gnd__t28_act_c sky130_fd_pr__nfet_01v8 L=0.15 W=0.42 nf=1 ad=0.1974 as=0.1974 pd=1.78 ps=1.78 mult=1 m=1
xm30_act_c rbl_2__t3_act_c sn_3_2__t0_act_c rwl_3__t2_act_c gnd__t29_act_c sky130_fd_pr__nfet_01v8 L=0.15 W=0.42 nf=1 ad=0.1974 as=0.1974 pd=1.78 ps=1.78 mult=1 m=1
xm31_act_c sn_3_3__t1_act_c wl_3__t3_act_c bl_3__t3_act_c gnd__t30_act_c sky130_fd_pr__nfet_01v8 L=0.15 W=0.42 nf=1 ad=0.1974 as=0.1974 pd=1.78 ps=1.78 mult=1 m=1
xm32_act_c rbl_3__t3_act_c sn_3_3__t0_act_c rwl_3__t3_act_c gnd__t31_act_c sky130_fd_pr__nfet_01v8 L=0.15 W=0.42 nf=1 ad=0.1974 as=0.1974 pd=1.78 ps=1.78 mult=1 m=1
rgnd_t0_act_c gnd__t0_act_c gnd_act_c 63.3529
rgnd_t1_act_c gnd__t1_act_c gnd_act_c 49.0465
rgnd_t2_act_c gnd__t2_act_c gnd_act_c 36.5177
rgnd_t3_act_c gnd__t3_act_c gnd_act_c 28.2406
rgnd_t4_act_c gnd__t4_act_c gnd_act_c 28.2406
rgnd_t5_act_c gnd__t5_act_c gnd_act_c 36.5177
rgnd_t6_act_c gnd__t6_act_c gnd_act_c 49.0465
rgnd_t7_act_c gnd__t7_act_c gnd_act_c 63.3529
rgnd_t8_act_c gnd__t8_act_c gnd_act_c 58.0019
rgnd_t9_act_c gnd__t9_act_c gnd_act_c 41.907
rgnd_t10_act_c gnd__t10_act_c gnd_act_c 26.1568
rgnd_t11_act_c gnd__t11_act_c gnd_act_c 12.1726
rgnd_t12_act_c gnd__t12_act_c gnd_act_c 12.1726
rgnd_t13_act_c gnd__t13_act_c gnd_act_c 26.1568
rgnd_t14_act_c gnd__t14_act_c gnd_act_c 41.907
rgnd_t15_act_c gnd__t15_act_c gnd_act_c 58.0019
rgnd_t16_act_c gnd__t16_act_c gnd_act_c 58.0019
rgnd_t17_act_c gnd__t17_act_c gnd_act_c 41.907
rgnd_t18_act_c gnd__t18_act_c gnd_act_c 26.1568
rgnd_t19_act_c gnd__t19_act_c gnd_act_c 12.1726
rgnd_t20_act_c gnd__t20_act_c gnd_act_c 12.1726
rgnd_t21_act_c gnd__t21_act_c gnd_act_c 26.1568
rgnd_t22_act_c gnd__t22_act_c gnd_act_c 41.907
rgnd_t23_act_c gnd__t23_act_c gnd_act_c 58.0019
rgnd_t24_act_c gnd__t24_act_c gnd_act_c 63.3529
rgnd_t25_act_c gnd__t25_act_c gnd_act_c 49.0465
rgnd_t26_act_c gnd__t26_act_c gnd_act_c 36.5177
rgnd_t27_act_c gnd__t27_act_c gnd_act_c 28.2406
rgnd_t28_act_c gnd__t28_act_c gnd_act_c 28.2406
rgnd_t29_act_c gnd__t29_act_c gnd_act_c 36.5177
rgnd_t30_act_c gnd__t30_act_c gnd_act_c 49.0465
rgnd_t31_act_c gnd__t31_act_c gnd_act_c 63.3529
rbl_0_t0_act_c bl_0__t0_act_c bl_0_act_c 144.555
rbl_0_t1_act_c bl_0__t1_act_c bl_0_act_c 48.1851
rbl_0_t2_act_c bl_0__t2_act_c bl_0_act_c 144.555
rbl_0_t3_act_c bl_0__t3_act_c bl_0_act_c 48.1851
rbl_1_t0_act_c bl_1__t0_act_c bl_1_act_c 144.555
rbl_1_t1_act_c bl_1__t1_act_c bl_1_act_c 48.1851
rbl_1_t2_act_c bl_1__t2_act_c bl_1_act_c 48.1851
rbl_1_t3_act_c bl_1__t3_act_c bl_1_act_c 144.555
rbl_2_t0_act_c bl_2__t0_act_c bl_2_act_c 144.555
rbl_2_t1_act_c bl_2__t1_act_c bl_2_act_c 48.1851
rbl_2_t2_act_c bl_2__t2_act_c bl_2_act_c 48.1851
rbl_2_t3_act_c bl_2__t3_act_c bl_2_act_c 144.555
rbl_3_t0_act_c bl_3__t0_act_c bl_3_act_c 144.555
rbl_3_t1_act_c bl_3__t1_act_c bl_3_act_c 48.1851
rbl_3_t2_act_c bl_3__t2_act_c bl_3_act_c 48.1851
rbl_3_t3_act_c bl_3__t3_act_c bl_3_act_c 144.555
rrbl_0_t0_act_c rbl_0__t0_act_c rbl_0_act_c 144.555
rrbl_0_t1_act_c rbl_0__t1_act_c rbl_0_act_c 48.1851
rrbl_0_t2_act_c rbl_0__t2_act_c rbl_0_act_c 48.1851
rrbl_0_t3_act_c rbl_0__t3_act_c rbl_0_act_c 144.555
rrbl_1_t0_act_c rbl_1__t0_act_c rbl_1_act_c 144.555
rrbl_1_t1_act_c rbl_1__t1_act_c rbl_1_act_c 48.1851
rrbl_1_t2_act_c rbl_1__t2_act_c rbl_1_act_c 48.1851
rrbl_1_t3_act_c rbl_1__t3_act_c rbl_1_act_c 144.555
rrbl_2_t0_act_c rbl_2__t0_act_c rbl_2_act_c 144.555
rrbl_2_t1_act_c rbl_2__t1_act_c rbl_2_act_c 48.1851
rrbl_2_t2_act_c rbl_2__t2_act_c rbl_2_act_c 48.1851
rrbl_2_t3_act_c rbl_2__t3_act_c rbl_2_act_c 144.555
rrbl_3_t0_act_c rbl_3__t0_act_c rbl_3_act_c 144.555
rrbl_3_t1_act_c rbl_3__t1_act_c rbl_3_act_c 48.1851
rrbl_3_t2_act_c rbl_3__t2_act_c rbl_3_act_c 48.1851
rrbl_3_t3_act_c rbl_3__t3_act_c rbl_3_act_c 144.555
rrwl_0_t0_act_c rwl_0__t0_act_c rwl_0_act_c 21.6897
rrwl_0_t1_act_c rwl_0__t1_act_c rwl_0_act_c 7.22989
rrwl_0_t2_act_c rwl_0__t2_act_c rwl_0_act_c 7.22989
rrwl_0_t3_act_c rwl_0__t3_act_c rwl_0_act_c 21.6897
rrwl_1_t0_act_c rwl_1__t0_act_c rwl_1_act_c 21.6897
rrwl_1_t1_act_c rwl_1__t1_act_c rwl_1_act_c 7.22989
rrwl_1_t2_act_c rwl_1__t2_act_c rwl_1_act_c 7.22989
rrwl_1_t3_act_c rwl_1__t3_act_c rwl_1_act_c 21.6897
rrwl_2_t0_act_c rwl_2__t0_act_c rwl_2_act_c 21.6897
rrwl_2_t1_act_c rwl_2__t1_act_c rwl_2_act_c 7.22989
rrwl_2_t2_act_c rwl_2__t2_act_c rwl_2_act_c 7.22989
rrwl_2_t3_act_c rwl_2__t3_act_c rwl_2_act_c 21.6897
rrwl_3_t0_act_c rwl_3__t0_act_c rwl_3_act_c 21.6897
rrwl_3_t1_act_c rwl_3__t1_act_c rwl_3_act_c 7.22989
rrwl_3_t2_act_c rwl_3__t2_act_c rwl_3_act_c 7.22989
rrwl_3_t3_act_c rwl_3__t3_act_c rwl_3_act_c 21.6897
rsn_0_0_t0_act_c sn_0_0__t0_act_c sn_0_0_act_c 125.123
rsn_0_0_t1_act_c sn_0_0__t1_act_c sn_0_0_act_c 125.123
rsn_0_1_t0_act_c sn_0_1__t0_act_c sn_0_1_act_c 125.123
rsn_0_1_t1_act_c sn_0_1__t1_act_c sn_0_1_act_c 125.123
rsn_0_2_t0_act_c sn_0_2__t0_act_c sn_0_2_act_c 125.123
rsn_0_2_t1_act_c sn_0_2__t1_act_c sn_0_2_act_c 125.123
rsn_0_3_t0_act_c sn_0_3__t0_act_c sn_0_3_act_c 125.123
rsn_0_3_t1_act_c sn_0_3__t1_act_c sn_0_3_act_c 125.123
rsn_1_0_t0_act_c sn_1_0__t0_act_c sn_1_0_act_c 125.123
rsn_1_0_t1_act_c sn_1_0__t1_act_c sn_1_0_act_c 125.123
rsn_1_1_t0_act_c sn_1_1__t0_act_c sn_1_1_act_c 125.123
rsn_1_1_t1_act_c sn_1_1__t1_act_c sn_1_1_act_c 125.123
rsn_1_2_t0_act_c sn_1_2__t0_act_c sn_1_2_act_c 125.123
rsn_1_2_t1_act_c sn_1_2__t1_act_c sn_1_2_act_c 125.123
rsn_1_3_t0_act_c sn_1_3__t0_act_c sn_1_3_act_c 125.123
rsn_1_3_t1_act_c sn_1_3__t1_act_c sn_1_3_act_c 125.123
rsn_2_0_t0_act_c sn_2_0__t0_act_c sn_2_0_act_c 125.123
rsn_2_0_t1_act_c sn_2_0__t1_act_c sn_2_0_act_c 125.123
rsn_2_1_t0_act_c sn_2_1__t0_act_c sn_2_1_act_c 125.123
rsn_2_1_t1_act_c sn_2_1__t1_act_c sn_2_1_act_c 125.123
rsn_2_2_t0_act_c sn_2_2__t0_act_c sn_2_2_act_c 125.123
rsn_2_2_t1_act_c sn_2_2__t1_act_c sn_2_2_act_c 125.123
rsn_2_3_t0_act_c sn_2_3__t0_act_c sn_2_3_act_c 125.123
rsn_2_3_t1_act_c sn_2_3__t1_act_c sn_2_3_act_c 125.123
rsn_3_0_t0_act_c sn_3_0__t0_act_c sn_3_0_act_c 125.123
rsn_3_0_t1_act_c sn_3_0__t1_act_c sn_3_0_act_c 125.123
rsn_3_1_t0_act_c sn_3_1__t0_act_c sn_3_1_act_c 125.123
rsn_3_1_t1_act_c sn_3_1__t1_act_c sn_3_1_act_c 125.123
rsn_3_2_t0_act_c sn_3_2__t0_act_c sn_3_2_act_c 125.123
rsn_3_2_t1_act_c sn_3_2__t1_act_c sn_3_2_act_c 125.123
rsn_3_3_t0_act_c sn_3_3__t0_act_c sn_3_3_act_c 125.123
rsn_3_3_t1_act_c sn_3_3__t1_act_c sn_3_3_act_c 125.123
rwl_0_t0_act_c wl_0__t0_act_c wl_0_act_c 54.2844
rwl_0_t1_act_c wl_0__t1_act_c wl_0_act_c 54.2844
rwl_0_t2_act_c wl_0__t2_act_c wl_0_act_c 162.853
rwl_0_t3_act_c wl_0__t3_act_c wl_0_act_c 162.853
rwl_1_t0_act_c wl_1__t0_act_c wl_1_act_c 162.853
rwl_1_t1_act_c wl_1__t1_act_c wl_1_act_c 54.2844
rwl_1_t2_act_c wl_1__t2_act_c wl_1_act_c 54.2844
rwl_1_t3_act_c wl_1__t3_act_c wl_1_act_c 162.853
rwl_2_t0_act_c wl_2__t0_act_c wl_2_act_c 54.2844
rwl_2_t1_act_c wl_2__t1_act_c wl_2_act_c 54.2844
rwl_2_t2_act_c wl_2__t2_act_c wl_2_act_c 162.853
rwl_2_t3_act_c wl_2__t3_act_c wl_2_act_c 162.853
rwl_3_t0_act_c wl_3__t0_act_c wl_3_act_c 162.853
rwl_3_t1_act_c wl_3__t1_act_c wl_3_act_c 54.2844
rwl_3_t2_act_c wl_3__t2_act_c wl_3_act_c 54.2844
rwl_3_t3_act_c wl_3__t3_act_c wl_3_act_c 162.853
cgnd_act_c gnd_act_c vsubs_act_c 4.09475e-15
cbl_0_act_c bl_0_act_c vsubs_act_c 5.96076e-16
cbl_1_act_c bl_1_act_c vsubs_act_c 5.81168e-16
cbl_2_act_c bl_2_act_c vsubs_act_c 5.81168e-16
cbl_3_act_c bl_3_act_c vsubs_act_c 5.81168e-16
crbl_0_act_c rbl_0_act_c vsubs_act_c 5.81168e-16
crbl_1_act_c rbl_1_act_c vsubs_act_c 5.81168e-16
crbl_2_act_c rbl_2_act_c vsubs_act_c 5.81168e-16
crbl_3_act_c rbl_3_act_c vsubs_act_c 5.96076e-16
crwl_0_act_c rwl_0_act_c vsubs_act_c 1.18713e-15
crwl_1_act_c rwl_1_act_c vsubs_act_c 1.18713e-15
crwl_2_act_c rwl_2_act_c vsubs_act_c 1.18713e-15
crwl_3_act_c rwl_3_act_c vsubs_act_c 1.18713e-15
csn_0_0_act_c sn_0_0_act_c vsubs_act_c 4.33689e-16
csn_0_1_act_c sn_0_1_act_c vsubs_act_c 4.30576e-16
csn_0_2_act_c sn_0_2_act_c vsubs_act_c 4.30576e-16
csn_0_3_act_c sn_0_3_act_c vsubs_act_c 4.32518e-16
csn_1_0_act_c sn_1_0_act_c vsubs_act_c 4.33689e-16
csn_1_1_act_c sn_1_1_act_c vsubs_act_c 4.30576e-16
csn_1_2_act_c sn_1_2_act_c vsubs_act_c 4.30576e-16
csn_1_3_act_c sn_1_3_act_c vsubs_act_c 4.32518e-16
csn_2_0_act_c sn_2_0_act_c vsubs_act_c 4.33689e-16
csn_2_1_act_c sn_2_1_act_c vsubs_act_c 4.30576e-16
csn_2_2_act_c sn_2_2_act_c vsubs_act_c 4.30576e-16
csn_2_3_act_c sn_2_3_act_c vsubs_act_c 4.32518e-16
csn_3_0_act_c sn_3_0_act_c vsubs_act_c 4.33689e-16
csn_3_1_act_c sn_3_1_act_c vsubs_act_c 4.30576e-16
csn_3_2_act_c sn_3_2_act_c vsubs_act_c 4.30576e-16
csn_3_3_act_c sn_3_3_act_c vsubs_act_c 4.32518e-16
cwl_0_act_c wl_0_act_c vsubs_act_c 1.90928e-15
cwl_1_act_c wl_1_act_c vsubs_act_c 1.90928e-15
cwl_2_act_c wl_2_act_c vsubs_act_c 1.90928e-15
cwl_3_act_c wl_3_act_c vsubs_act_c 1.91375e-15
ccc_bl_0_sn_0_0_act_c bl_0_act_c sn_0_0_act_c 1.071e-17
ccc_bl_0_sn_1_0_act_c bl_0_act_c sn_1_0_act_c 1.071e-17
ccc_bl_0_sn_2_0_act_c bl_0_act_c sn_2_0_act_c 1.071e-17
ccc_bl_0_sn_3_0_act_c bl_0_act_c sn_3_0_act_c 1.071e-17
ccc_bl_0_wl_0_act_c bl_0_act_c wl_0_act_c 2.4327e-17
ccc_bl_0_wl_1_act_c bl_0_act_c wl_1_act_c 2.4327e-17
ccc_bl_0_wl_2_act_c bl_0_act_c wl_2_act_c 2.4327e-17
ccc_bl_1_rbl_0_act_c bl_1_act_c rbl_0_act_c 1.29795e-16
ccc_bl_1_rwl_0_act_c bl_1_act_c rwl_0_act_c 9.028e-18
ccc_bl_1_rwl_1_act_c bl_1_act_c rwl_1_act_c 9.028e-18
ccc_bl_1_rwl_2_act_c bl_1_act_c rwl_2_act_c 9.028e-18
ccc_bl_1_rwl_3_act_c bl_1_act_c rwl_3_act_c 9.028e-18
ccc_bl_1_sn_0_1_act_c bl_1_act_c sn_0_1_act_c 1.071e-17
ccc_bl_1_sn_1_1_act_c bl_1_act_c sn_1_1_act_c 1.071e-17
ccc_bl_1_sn_2_1_act_c bl_1_act_c sn_2_1_act_c 1.071e-17
ccc_bl_1_sn_3_1_act_c bl_1_act_c sn_3_1_act_c 1.071e-17
ccc_bl_1_wl_0_act_c bl_1_act_c wl_0_act_c 2.7627e-17
ccc_bl_1_wl_1_act_c bl_1_act_c wl_1_act_c 2.7627e-17
ccc_bl_1_wl_2_act_c bl_1_act_c wl_2_act_c 2.7627e-17
ccc_bl_2_rbl_1_act_c bl_2_act_c rbl_1_act_c 1.29795e-16
ccc_bl_2_rwl_0_act_c bl_2_act_c rwl_0_act_c 9.028e-18
ccc_bl_2_rwl_1_act_c bl_2_act_c rwl_1_act_c 9.028e-18
ccc_bl_2_rwl_2_act_c bl_2_act_c rwl_2_act_c 9.028e-18
ccc_bl_2_rwl_3_act_c bl_2_act_c rwl_3_act_c 9.028e-18
ccc_bl_2_sn_0_2_act_c bl_2_act_c sn_0_2_act_c 1.071e-17
ccc_bl_2_sn_1_2_act_c bl_2_act_c sn_1_2_act_c 1.071e-17
ccc_bl_2_sn_2_2_act_c bl_2_act_c sn_2_2_act_c 1.071e-17
ccc_bl_2_sn_3_2_act_c bl_2_act_c sn_3_2_act_c 1.071e-17
ccc_bl_2_wl_0_act_c bl_2_act_c wl_0_act_c 2.7627e-17
ccc_bl_2_wl_1_act_c bl_2_act_c wl_1_act_c 2.7627e-17
ccc_bl_2_wl_2_act_c bl_2_act_c wl_2_act_c 2.7627e-17
ccc_bl_3_rbl_2_act_c bl_3_act_c rbl_2_act_c 1.29795e-16
ccc_bl_3_rwl_0_act_c bl_3_act_c rwl_0_act_c 9.028e-18
ccc_bl_3_rwl_1_act_c bl_3_act_c rwl_1_act_c 9.028e-18
ccc_bl_3_rwl_2_act_c bl_3_act_c rwl_2_act_c 9.028e-18
ccc_bl_3_rwl_3_act_c bl_3_act_c rwl_3_act_c 9.028e-18
ccc_bl_3_sn_0_3_act_c bl_3_act_c sn_0_3_act_c 1.071e-17
ccc_bl_3_sn_1_3_act_c bl_3_act_c sn_1_3_act_c 1.071e-17
ccc_bl_3_sn_2_3_act_c bl_3_act_c sn_2_3_act_c 1.071e-17
ccc_bl_3_sn_3_3_act_c bl_3_act_c sn_3_3_act_c 1.071e-17
ccc_bl_3_wl_0_act_c bl_3_act_c wl_0_act_c 2.7627e-17
ccc_bl_3_wl_1_act_c bl_3_act_c wl_1_act_c 2.7627e-17
ccc_bl_3_wl_2_act_c bl_3_act_c wl_2_act_c 2.7627e-17
ccc_rbl_0_rwl_0_act_c rbl_0_act_c rwl_0_act_c 1.9738e-17
ccc_rbl_0_rwl_1_act_c rbl_0_act_c rwl_1_act_c 1.9738e-17
ccc_rbl_0_rwl_2_act_c rbl_0_act_c rwl_2_act_c 1.9738e-17
ccc_rbl_0_rwl_3_act_c rbl_0_act_c rwl_3_act_c 1.9738e-17
ccc_rbl_0_sn_0_0_act_c rbl_0_act_c sn_0_0_act_c 1.071e-17
ccc_rbl_0_sn_1_0_act_c rbl_0_act_c sn_1_0_act_c 2.4327e-17
ccc_rbl_0_sn_2_0_act_c rbl_0_act_c sn_2_0_act_c 2.4327e-17
ccc_rbl_0_wl_0_act_c rbl_0_act_c wl_0_act_c 3.3e-18
ccc_rbl_0_wl_1_act_c rbl_0_act_c wl_1_act_c 3.3e-18
ccc_rbl_0_wl_2_act_c rbl_0_act_c wl_2_act_c 3.3e-18
ccc_rbl_1_rwl_0_act_c rbl_1_act_c rwl_0_act_c 1.9738e-17
ccc_rbl_1_rwl_1_act_c rbl_1_act_c rwl_1_act_c 1.9738e-17
ccc_rbl_1_rwl_2_act_c rbl_1_act_c rwl_2_act_c 1.9738e-17
ccc_rbl_1_rwl_3_act_c rbl_1_act_c rwl_3_act_c 1.9738e-17
ccc_rbl_1_sn_0_1_act_c rbl_1_act_c sn_0_1_act_c 1.071e-17
ccc_rbl_1_sn_1_1_act_c rbl_1_act_c sn_1_1_act_c 2.4327e-17
ccc_rbl_1_sn_2_1_act_c rbl_1_act_c sn_2_1_act_c 2.4327e-17
ccc_rbl_1_wl_0_act_c rbl_1_act_c wl_0_act_c 3.3e-18
ccc_rbl_1_wl_1_act_c rbl_1_act_c wl_1_act_c 3.3e-18
ccc_rbl_1_wl_2_act_c rbl_1_act_c wl_2_act_c 3.3e-18
ccc_rbl_2_rwl_0_act_c rbl_2_act_c rwl_0_act_c 1.9738e-17
ccc_rbl_2_rwl_1_act_c rbl_2_act_c rwl_1_act_c 1.9738e-17
ccc_rbl_2_rwl_2_act_c rbl_2_act_c rwl_2_act_c 1.9738e-17
ccc_rbl_2_rwl_3_act_c rbl_2_act_c rwl_3_act_c 1.9738e-17
ccc_rbl_2_sn_0_2_act_c rbl_2_act_c sn_0_2_act_c 1.071e-17
ccc_rbl_2_sn_1_2_act_c rbl_2_act_c sn_1_2_act_c 2.4327e-17
ccc_rbl_2_sn_2_2_act_c rbl_2_act_c sn_2_2_act_c 2.4327e-17
ccc_rbl_2_wl_0_act_c rbl_2_act_c wl_0_act_c 3.3e-18
ccc_rbl_2_wl_1_act_c rbl_2_act_c wl_1_act_c 3.3e-18
ccc_rbl_2_wl_2_act_c rbl_2_act_c wl_2_act_c 3.3e-18
ccc_rbl_3_rwl_0_act_c rbl_3_act_c rwl_0_act_c 1.071e-17
ccc_rbl_3_rwl_1_act_c rbl_3_act_c rwl_1_act_c 1.071e-17
ccc_rbl_3_rwl_2_act_c rbl_3_act_c rwl_2_act_c 1.071e-17
ccc_rbl_3_rwl_3_act_c rbl_3_act_c rwl_3_act_c 1.071e-17
ccc_rbl_3_sn_0_3_act_c rbl_3_act_c sn_0_3_act_c 1.071e-17
ccc_rbl_3_sn_1_3_act_c rbl_3_act_c sn_1_3_act_c 2.4327e-17
ccc_rbl_3_sn_2_3_act_c rbl_3_act_c sn_2_3_act_c 2.4327e-17
ccc_rwl_0_sn_0_0_act_c rwl_0_act_c sn_0_0_act_c 1.0072e-17
ccc_rwl_0_sn_0_1_act_c rwl_0_act_c sn_0_1_act_c 1.9682e-17
ccc_rwl_0_sn_0_2_act_c rwl_0_act_c sn_0_2_act_c 1.9682e-17
ccc_rwl_0_sn_0_3_act_c rwl_0_act_c sn_0_3_act_c 1.9682e-17
ccc_rwl_1_sn_1_0_act_c rwl_1_act_c sn_1_0_act_c 1.0072e-17
ccc_rwl_1_sn_1_1_act_c rwl_1_act_c sn_1_1_act_c 1.9682e-17
ccc_rwl_1_sn_1_2_act_c rwl_1_act_c sn_1_2_act_c 1.9682e-17
ccc_rwl_1_sn_1_3_act_c rwl_1_act_c sn_1_3_act_c 1.9682e-17
ccc_rwl_2_sn_2_0_act_c rwl_2_act_c sn_2_0_act_c 1.0072e-17
ccc_rwl_2_sn_2_1_act_c rwl_2_act_c sn_2_1_act_c 1.9682e-17
ccc_rwl_2_sn_2_2_act_c rwl_2_act_c sn_2_2_act_c 1.9682e-17
ccc_rwl_2_sn_2_3_act_c rwl_2_act_c sn_2_3_act_c 1.9682e-17
ccc_rwl_3_sn_3_0_act_c rwl_3_act_c sn_3_0_act_c 1.0072e-17
ccc_rwl_3_sn_3_1_act_c rwl_3_act_c sn_3_1_act_c 1.9682e-17
ccc_rwl_3_sn_3_2_act_c rwl_3_act_c sn_3_2_act_c 1.9682e-17
ccc_rwl_3_sn_3_3_act_c rwl_3_act_c sn_3_3_act_c 1.9682e-17
ccc_sn_0_0_wl_0_act_c sn_0_0_act_c wl_0_act_c 1.9664e-17
ccc_sn_0_1_wl_0_act_c sn_0_1_act_c wl_0_act_c 1.9664e-17
ccc_sn_0_2_wl_0_act_c sn_0_2_act_c wl_0_act_c 1.9664e-17
ccc_sn_0_3_wl_0_act_c sn_0_3_act_c wl_0_act_c 1.3668e-17
ccc_sn_1_0_wl_1_act_c sn_1_0_act_c wl_1_act_c 1.9664e-17
ccc_sn_1_1_wl_1_act_c sn_1_1_act_c wl_1_act_c 1.6705e-17
ccc_sn_1_2_wl_1_act_c sn_1_2_act_c wl_1_act_c 1.6705e-17
ccc_sn_1_3_wl_1_act_c sn_1_3_act_c wl_1_act_c 1.071e-17
ccc_sn_2_0_wl_2_act_c sn_2_0_act_c wl_2_act_c 1.9664e-17
ccc_sn_2_1_wl_2_act_c sn_2_1_act_c wl_2_act_c 1.6705e-17
ccc_sn_2_2_wl_2_act_c sn_2_2_act_c wl_2_act_c 1.6705e-17
ccc_sn_2_3_wl_2_act_c sn_2_3_act_c wl_2_act_c 1.071e-17
ccc_sn_3_0_wl_3_act_c sn_3_0_act_c wl_3_act_c 1.9664e-17
ccc_sn_3_1_wl_3_act_c sn_3_1_act_c wl_3_act_c 1.6705e-17
ccc_sn_3_2_wl_3_act_c sn_3_2_act_c wl_3_act_c 1.6705e-17
ccc_sn_3_3_wl_3_act_c sn_3_3_act_c wl_3_act_c 1.071e-17
vpre0_act_c pre0_act_c 0 dc 0.9
vpre1_act_c pre1_act_c 0 dc 0.9
vpre2_act_c pre2_act_c 0 dc 0.9
vpre3_act_c pre3_act_c 0 dc 0.9
vwbl0_act_c bl_0_act_c 0 pwl(0.000000e+00 0 2.000000e-08 0 2.010000e-08 1.8 3.200000e-08 1.8 3.210000e-08 0)
vwbl1_act_c bl_1_act_c 0 dc 0
vwbl2_act_c bl_2_act_c 0 pwl(0.000000e+00 0 2.000000e-08 0 2.010000e-08 1.8 3.200000e-08 1.8 3.210000e-08 0)
vwbl3_act_c bl_3_act_c 0 dc 0
vrwl0_act_c rwl_0_act_c 0 pwl(0.000000e+00 1.8 9.000000e-09 1.8 9.100000e-09 0 3.200000e-08 0 3.210000e-08 1.8)
vrwl1_act_c rwl_1_act_c 0 dc 1.8
vrwl2_act_c rwl_2_act_c 0 dc 1.8
vrwl3_act_c rwl_3_act_c 0 dc 1.8
vwwl0_act_c wl_0_act_c 0 pwl(0.000000e+00 0 2.000000e-08 0 2.010000e-08 1.8 3.000000e-08 1.8 3.010000e-08 0)
vwwl1_act_c wl_1_act_c 0 dc 0
vwwl2_act_c wl_2_act_c 0 dc 0
vwwl3_act_c wl_3_act_c 0 dc 0
vbody_act_c gnd_act_c 0 dc 0
vsub_act_c vsubs_act_c 0 dc 0
vctl_act_c ctl_act_c 0 pwl(0.000000e+00 1.8 7.000000e-09 1.8 7.100000e-09 0 3.200000e-08 0 3.210000e-08 1.8)   $ EXCLUDED: switch control, outside the boundary
spre0_act_c pre0_act_c rbl_0_act_c ctl_act_c 0 swpre
spre1_act_c pre1_act_c rbl_1_act_c ctl_act_c 0 swpre
spre2_act_c pre2_act_c rbl_2_act_c ctl_act_c 0 swpre
spre3_act_c pre3_act_c rbl_3_act_c ctl_act_c 0 swpre
bpn_vpre0_act_c pn_vpre0_act_c 0 v=(-v(pre0_act_c)*i(vpre0_act_c))
bpg_vpre0_act_c pg_vpre0_act_c 0 v=max((-v(pre0_act_c)*i(vpre0_act_c)),0)
bpr_vpre0_act_c pr_vpre0_act_c 0 v=max(-(-v(pre0_act_c)*i(vpre0_act_c)),0)
bpn_vpre1_act_c pn_vpre1_act_c 0 v=(-v(pre1_act_c)*i(vpre1_act_c))
bpg_vpre1_act_c pg_vpre1_act_c 0 v=max((-v(pre1_act_c)*i(vpre1_act_c)),0)
bpr_vpre1_act_c pr_vpre1_act_c 0 v=max(-(-v(pre1_act_c)*i(vpre1_act_c)),0)
bpn_vpre2_act_c pn_vpre2_act_c 0 v=(-v(pre2_act_c)*i(vpre2_act_c))
bpg_vpre2_act_c pg_vpre2_act_c 0 v=max((-v(pre2_act_c)*i(vpre2_act_c)),0)
bpr_vpre2_act_c pr_vpre2_act_c 0 v=max(-(-v(pre2_act_c)*i(vpre2_act_c)),0)
bpn_vpre3_act_c pn_vpre3_act_c 0 v=(-v(pre3_act_c)*i(vpre3_act_c))
bpg_vpre3_act_c pg_vpre3_act_c 0 v=max((-v(pre3_act_c)*i(vpre3_act_c)),0)
bpr_vpre3_act_c pr_vpre3_act_c 0 v=max(-(-v(pre3_act_c)*i(vpre3_act_c)),0)
bpn_vwbl0_act_c pn_vwbl0_act_c 0 v=(-v(bl_0_act_c)*i(vwbl0_act_c))
bpg_vwbl0_act_c pg_vwbl0_act_c 0 v=max((-v(bl_0_act_c)*i(vwbl0_act_c)),0)
bpr_vwbl0_act_c pr_vwbl0_act_c 0 v=max(-(-v(bl_0_act_c)*i(vwbl0_act_c)),0)
bpn_vwbl1_act_c pn_vwbl1_act_c 0 v=(-v(bl_1_act_c)*i(vwbl1_act_c))
bpg_vwbl1_act_c pg_vwbl1_act_c 0 v=max((-v(bl_1_act_c)*i(vwbl1_act_c)),0)
bpr_vwbl1_act_c pr_vwbl1_act_c 0 v=max(-(-v(bl_1_act_c)*i(vwbl1_act_c)),0)
bpn_vwbl2_act_c pn_vwbl2_act_c 0 v=(-v(bl_2_act_c)*i(vwbl2_act_c))
bpg_vwbl2_act_c pg_vwbl2_act_c 0 v=max((-v(bl_2_act_c)*i(vwbl2_act_c)),0)
bpr_vwbl2_act_c pr_vwbl2_act_c 0 v=max(-(-v(bl_2_act_c)*i(vwbl2_act_c)),0)
bpn_vwbl3_act_c pn_vwbl3_act_c 0 v=(-v(bl_3_act_c)*i(vwbl3_act_c))
bpg_vwbl3_act_c pg_vwbl3_act_c 0 v=max((-v(bl_3_act_c)*i(vwbl3_act_c)),0)
bpr_vwbl3_act_c pr_vwbl3_act_c 0 v=max(-(-v(bl_3_act_c)*i(vwbl3_act_c)),0)
bpn_vrwl0_act_c pn_vrwl0_act_c 0 v=(-v(rwl_0_act_c)*i(vrwl0_act_c))
bpg_vrwl0_act_c pg_vrwl0_act_c 0 v=max((-v(rwl_0_act_c)*i(vrwl0_act_c)),0)
bpr_vrwl0_act_c pr_vrwl0_act_c 0 v=max(-(-v(rwl_0_act_c)*i(vrwl0_act_c)),0)
bpn_vrwl1_act_c pn_vrwl1_act_c 0 v=(-v(rwl_1_act_c)*i(vrwl1_act_c))
bpg_vrwl1_act_c pg_vrwl1_act_c 0 v=max((-v(rwl_1_act_c)*i(vrwl1_act_c)),0)
bpr_vrwl1_act_c pr_vrwl1_act_c 0 v=max(-(-v(rwl_1_act_c)*i(vrwl1_act_c)),0)
bpn_vrwl2_act_c pn_vrwl2_act_c 0 v=(-v(rwl_2_act_c)*i(vrwl2_act_c))
bpg_vrwl2_act_c pg_vrwl2_act_c 0 v=max((-v(rwl_2_act_c)*i(vrwl2_act_c)),0)
bpr_vrwl2_act_c pr_vrwl2_act_c 0 v=max(-(-v(rwl_2_act_c)*i(vrwl2_act_c)),0)
bpn_vrwl3_act_c pn_vrwl3_act_c 0 v=(-v(rwl_3_act_c)*i(vrwl3_act_c))
bpg_vrwl3_act_c pg_vrwl3_act_c 0 v=max((-v(rwl_3_act_c)*i(vrwl3_act_c)),0)
bpr_vrwl3_act_c pr_vrwl3_act_c 0 v=max(-(-v(rwl_3_act_c)*i(vrwl3_act_c)),0)
bpn_vwwl0_act_c pn_vwwl0_act_c 0 v=(-v(wl_0_act_c)*i(vwwl0_act_c))
bpg_vwwl0_act_c pg_vwwl0_act_c 0 v=max((-v(wl_0_act_c)*i(vwwl0_act_c)),0)
bpr_vwwl0_act_c pr_vwwl0_act_c 0 v=max(-(-v(wl_0_act_c)*i(vwwl0_act_c)),0)
bpn_vwwl1_act_c pn_vwwl1_act_c 0 v=(-v(wl_1_act_c)*i(vwwl1_act_c))
bpg_vwwl1_act_c pg_vwwl1_act_c 0 v=max((-v(wl_1_act_c)*i(vwwl1_act_c)),0)
bpr_vwwl1_act_c pr_vwwl1_act_c 0 v=max(-(-v(wl_1_act_c)*i(vwwl1_act_c)),0)
bpn_vwwl2_act_c pn_vwwl2_act_c 0 v=(-v(wl_2_act_c)*i(vwwl2_act_c))
bpg_vwwl2_act_c pg_vwwl2_act_c 0 v=max((-v(wl_2_act_c)*i(vwwl2_act_c)),0)
bpr_vwwl2_act_c pr_vwwl2_act_c 0 v=max(-(-v(wl_2_act_c)*i(vwwl2_act_c)),0)
bpn_vwwl3_act_c pn_vwwl3_act_c 0 v=(-v(wl_3_act_c)*i(vwwl3_act_c))
bpg_vwwl3_act_c pg_vwwl3_act_c 0 v=max((-v(wl_3_act_c)*i(vwwl3_act_c)),0)
bpr_vwwl3_act_c pr_vwwl3_act_c 0 v=max(-(-v(wl_3_act_c)*i(vwwl3_act_c)),0)
bpn_vbody_act_c pn_vbody_act_c 0 v=(-v(gnd_act_c)*i(vbody_act_c))
bpg_vbody_act_c pg_vbody_act_c 0 v=max((-v(gnd_act_c)*i(vbody_act_c)),0)
bpr_vbody_act_c pr_vbody_act_c 0 v=max(-(-v(gnd_act_c)*i(vbody_act_c)),0)
bpn_vsub_act_c pn_vsub_act_c 0 v=(-v(vsubs_act_c)*i(vsub_act_c))
bpg_vsub_act_c pg_vsub_act_c 0 v=max((-v(vsubs_act_c)*i(vsub_act_c)),0)
bpr_vsub_act_c pr_vsub_act_c 0 v=max(-(-v(vsubs_act_c)*i(vsub_act_c)),0)

* ---- instance act_i: mode active, pattern inv_checker ----
xm1_act_i sn_0_0__t0_act_i wl_0__t3_act_i bl_0__t0_act_i gnd__t0_act_i sky130_fd_pr__nfet_01v8 L=0.15 W=0.42 nf=1 ad=0.1974 as=0.1974 pd=1.78 ps=1.78 mult=1 m=1
xm2_act_i rbl_0__t0_act_i sn_0_0__t1_act_i rwl_0__t0_act_i gnd__t1_act_i sky130_fd_pr__nfet_01v8 L=0.15 W=0.42 nf=1 ad=0.1974 as=0.1974 pd=1.78 ps=1.78 mult=1 m=1
xm3_act_i sn_0_1__t1_act_i wl_0__t0_act_i bl_1__t0_act_i gnd__t2_act_i sky130_fd_pr__nfet_01v8 L=0.15 W=0.42 nf=1 ad=0.1974 as=0.1974 pd=1.78 ps=1.78 mult=1 m=1
xm4_act_i rbl_1__t0_act_i sn_0_1__t0_act_i rwl_0__t1_act_i gnd__t3_act_i sky130_fd_pr__nfet_01v8 L=0.15 W=0.42 nf=1 ad=0.1974 as=0.1974 pd=1.78 ps=1.78 mult=1 m=1
xm5_act_i sn_0_2__t1_act_i wl_0__t1_act_i bl_2__t0_act_i gnd__t4_act_i sky130_fd_pr__nfet_01v8 L=0.15 W=0.42 nf=1 ad=0.1974 as=0.1974 pd=1.78 ps=1.78 mult=1 m=1
xm6_act_i rbl_2__t0_act_i sn_0_2__t0_act_i rwl_0__t2_act_i gnd__t5_act_i sky130_fd_pr__nfet_01v8 L=0.15 W=0.42 nf=1 ad=0.1974 as=0.1974 pd=1.78 ps=1.78 mult=1 m=1
xm7_act_i sn_0_3__t1_act_i wl_0__t2_act_i bl_3__t0_act_i gnd__t6_act_i sky130_fd_pr__nfet_01v8 L=0.15 W=0.42 nf=1 ad=0.1974 as=0.1974 pd=1.78 ps=1.78 mult=1 m=1
xm8_act_i rbl_3__t0_act_i sn_0_3__t0_act_i rwl_0__t3_act_i gnd__t7_act_i sky130_fd_pr__nfet_01v8 L=0.15 W=0.42 nf=1 ad=0.1974 as=0.1974 pd=1.78 ps=1.78 mult=1 m=1
xm9_act_i sn_1_0__t1_act_i wl_1__t0_act_i bl_0__t1_act_i gnd__t8_act_i sky130_fd_pr__nfet_01v8 L=0.15 W=0.42 nf=1 ad=0.1974 as=0.1974 pd=1.78 ps=1.78 mult=1 m=1
xm10_act_i rbl_0__t1_act_i sn_1_0__t0_act_i rwl_1__t0_act_i gnd__t9_act_i sky130_fd_pr__nfet_01v8 L=0.15 W=0.42 nf=1 ad=0.1974 as=0.1974 pd=1.78 ps=1.78 mult=1 m=1
xm11_act_i sn_1_1__t1_act_i wl_1__t1_act_i bl_1__t1_act_i gnd__t10_act_i sky130_fd_pr__nfet_01v8 L=0.15 W=0.42 nf=1 ad=0.1974 as=0.1974 pd=1.78 ps=1.78 mult=1 m=1
xm12_act_i rbl_1__t1_act_i sn_1_1__t0_act_i rwl_1__t1_act_i gnd__t11_act_i sky130_fd_pr__nfet_01v8 L=0.15 W=0.42 nf=1 ad=0.1974 as=0.1974 pd=1.78 ps=1.78 mult=1 m=1
xm13_act_i sn_1_2__t1_act_i wl_1__t2_act_i bl_2__t1_act_i gnd__t12_act_i sky130_fd_pr__nfet_01v8 L=0.15 W=0.42 nf=1 ad=0.1974 as=0.1974 pd=1.78 ps=1.78 mult=1 m=1
xm14_act_i rbl_2__t1_act_i sn_1_2__t0_act_i rwl_1__t2_act_i gnd__t13_act_i sky130_fd_pr__nfet_01v8 L=0.15 W=0.42 nf=1 ad=0.1974 as=0.1974 pd=1.78 ps=1.78 mult=1 m=1
xm15_act_i sn_1_3__t1_act_i wl_1__t3_act_i bl_3__t1_act_i gnd__t14_act_i sky130_fd_pr__nfet_01v8 L=0.15 W=0.42 nf=1 ad=0.1974 as=0.1974 pd=1.78 ps=1.78 mult=1 m=1
xm16_act_i rbl_3__t1_act_i sn_1_3__t0_act_i rwl_1__t3_act_i gnd__t15_act_i sky130_fd_pr__nfet_01v8 L=0.15 W=0.42 nf=1 ad=0.1974 as=0.1974 pd=1.78 ps=1.78 mult=1 m=1
xm17_act_i sn_2_0__t1_act_i wl_2__t3_act_i bl_0__t3_act_i gnd__t16_act_i sky130_fd_pr__nfet_01v8 L=0.15 W=0.42 nf=1 ad=0.1974 as=0.1974 pd=1.78 ps=1.78 mult=1 m=1
xm18_act_i rbl_0__t2_act_i sn_2_0__t0_act_i rwl_2__t0_act_i gnd__t17_act_i sky130_fd_pr__nfet_01v8 L=0.15 W=0.42 nf=1 ad=0.1974 as=0.1974 pd=1.78 ps=1.78 mult=1 m=1
xm19_act_i sn_2_1__t1_act_i wl_2__t0_act_i bl_1__t2_act_i gnd__t18_act_i sky130_fd_pr__nfet_01v8 L=0.15 W=0.42 nf=1 ad=0.1974 as=0.1974 pd=1.78 ps=1.78 mult=1 m=1
xm20_act_i rbl_1__t2_act_i sn_2_1__t0_act_i rwl_2__t1_act_i gnd__t19_act_i sky130_fd_pr__nfet_01v8 L=0.15 W=0.42 nf=1 ad=0.1974 as=0.1974 pd=1.78 ps=1.78 mult=1 m=1
xm21_act_i sn_2_2__t1_act_i wl_2__t1_act_i bl_2__t2_act_i gnd__t20_act_i sky130_fd_pr__nfet_01v8 L=0.15 W=0.42 nf=1 ad=0.1974 as=0.1974 pd=1.78 ps=1.78 mult=1 m=1
xm22_act_i rbl_2__t2_act_i sn_2_2__t0_act_i rwl_2__t2_act_i gnd__t21_act_i sky130_fd_pr__nfet_01v8 L=0.15 W=0.42 nf=1 ad=0.1974 as=0.1974 pd=1.78 ps=1.78 mult=1 m=1
xm23_act_i sn_2_3__t1_act_i wl_2__t2_act_i bl_3__t2_act_i gnd__t22_act_i sky130_fd_pr__nfet_01v8 L=0.15 W=0.42 nf=1 ad=0.1974 as=0.1974 pd=1.78 ps=1.78 mult=1 m=1
xm24_act_i rbl_3__t2_act_i sn_2_3__t0_act_i rwl_2__t3_act_i gnd__t23_act_i sky130_fd_pr__nfet_01v8 L=0.15 W=0.42 nf=1 ad=0.1974 as=0.1974 pd=1.78 ps=1.78 mult=1 m=1
xm25_act_i sn_3_0__t1_act_i wl_3__t0_act_i bl_0__t2_act_i gnd__t24_act_i sky130_fd_pr__nfet_01v8 L=0.15 W=0.42 nf=1 ad=0.1974 as=0.1974 pd=1.78 ps=1.78 mult=1 m=1
xm26_act_i rbl_0__t3_act_i sn_3_0__t0_act_i rwl_3__t0_act_i gnd__t25_act_i sky130_fd_pr__nfet_01v8 L=0.15 W=0.42 nf=1 ad=0.1974 as=0.1974 pd=1.78 ps=1.78 mult=1 m=1
xm27_act_i sn_3_1__t1_act_i wl_3__t1_act_i bl_1__t3_act_i gnd__t26_act_i sky130_fd_pr__nfet_01v8 L=0.15 W=0.42 nf=1 ad=0.1974 as=0.1974 pd=1.78 ps=1.78 mult=1 m=1
xm28_act_i rbl_1__t3_act_i sn_3_1__t0_act_i rwl_3__t1_act_i gnd__t27_act_i sky130_fd_pr__nfet_01v8 L=0.15 W=0.42 nf=1 ad=0.1974 as=0.1974 pd=1.78 ps=1.78 mult=1 m=1
xm29_act_i sn_3_2__t1_act_i wl_3__t2_act_i bl_2__t3_act_i gnd__t28_act_i sky130_fd_pr__nfet_01v8 L=0.15 W=0.42 nf=1 ad=0.1974 as=0.1974 pd=1.78 ps=1.78 mult=1 m=1
xm30_act_i rbl_2__t3_act_i sn_3_2__t0_act_i rwl_3__t2_act_i gnd__t29_act_i sky130_fd_pr__nfet_01v8 L=0.15 W=0.42 nf=1 ad=0.1974 as=0.1974 pd=1.78 ps=1.78 mult=1 m=1
xm31_act_i sn_3_3__t1_act_i wl_3__t3_act_i bl_3__t3_act_i gnd__t30_act_i sky130_fd_pr__nfet_01v8 L=0.15 W=0.42 nf=1 ad=0.1974 as=0.1974 pd=1.78 ps=1.78 mult=1 m=1
xm32_act_i rbl_3__t3_act_i sn_3_3__t0_act_i rwl_3__t3_act_i gnd__t31_act_i sky130_fd_pr__nfet_01v8 L=0.15 W=0.42 nf=1 ad=0.1974 as=0.1974 pd=1.78 ps=1.78 mult=1 m=1
rgnd_t0_act_i gnd__t0_act_i gnd_act_i 63.3529
rgnd_t1_act_i gnd__t1_act_i gnd_act_i 49.0465
rgnd_t2_act_i gnd__t2_act_i gnd_act_i 36.5177
rgnd_t3_act_i gnd__t3_act_i gnd_act_i 28.2406
rgnd_t4_act_i gnd__t4_act_i gnd_act_i 28.2406
rgnd_t5_act_i gnd__t5_act_i gnd_act_i 36.5177
rgnd_t6_act_i gnd__t6_act_i gnd_act_i 49.0465
rgnd_t7_act_i gnd__t7_act_i gnd_act_i 63.3529
rgnd_t8_act_i gnd__t8_act_i gnd_act_i 58.0019
rgnd_t9_act_i gnd__t9_act_i gnd_act_i 41.907
rgnd_t10_act_i gnd__t10_act_i gnd_act_i 26.1568
rgnd_t11_act_i gnd__t11_act_i gnd_act_i 12.1726
rgnd_t12_act_i gnd__t12_act_i gnd_act_i 12.1726
rgnd_t13_act_i gnd__t13_act_i gnd_act_i 26.1568
rgnd_t14_act_i gnd__t14_act_i gnd_act_i 41.907
rgnd_t15_act_i gnd__t15_act_i gnd_act_i 58.0019
rgnd_t16_act_i gnd__t16_act_i gnd_act_i 58.0019
rgnd_t17_act_i gnd__t17_act_i gnd_act_i 41.907
rgnd_t18_act_i gnd__t18_act_i gnd_act_i 26.1568
rgnd_t19_act_i gnd__t19_act_i gnd_act_i 12.1726
rgnd_t20_act_i gnd__t20_act_i gnd_act_i 12.1726
rgnd_t21_act_i gnd__t21_act_i gnd_act_i 26.1568
rgnd_t22_act_i gnd__t22_act_i gnd_act_i 41.907
rgnd_t23_act_i gnd__t23_act_i gnd_act_i 58.0019
rgnd_t24_act_i gnd__t24_act_i gnd_act_i 63.3529
rgnd_t25_act_i gnd__t25_act_i gnd_act_i 49.0465
rgnd_t26_act_i gnd__t26_act_i gnd_act_i 36.5177
rgnd_t27_act_i gnd__t27_act_i gnd_act_i 28.2406
rgnd_t28_act_i gnd__t28_act_i gnd_act_i 28.2406
rgnd_t29_act_i gnd__t29_act_i gnd_act_i 36.5177
rgnd_t30_act_i gnd__t30_act_i gnd_act_i 49.0465
rgnd_t31_act_i gnd__t31_act_i gnd_act_i 63.3529
rbl_0_t0_act_i bl_0__t0_act_i bl_0_act_i 144.555
rbl_0_t1_act_i bl_0__t1_act_i bl_0_act_i 48.1851
rbl_0_t2_act_i bl_0__t2_act_i bl_0_act_i 144.555
rbl_0_t3_act_i bl_0__t3_act_i bl_0_act_i 48.1851
rbl_1_t0_act_i bl_1__t0_act_i bl_1_act_i 144.555
rbl_1_t1_act_i bl_1__t1_act_i bl_1_act_i 48.1851
rbl_1_t2_act_i bl_1__t2_act_i bl_1_act_i 48.1851
rbl_1_t3_act_i bl_1__t3_act_i bl_1_act_i 144.555
rbl_2_t0_act_i bl_2__t0_act_i bl_2_act_i 144.555
rbl_2_t1_act_i bl_2__t1_act_i bl_2_act_i 48.1851
rbl_2_t2_act_i bl_2__t2_act_i bl_2_act_i 48.1851
rbl_2_t3_act_i bl_2__t3_act_i bl_2_act_i 144.555
rbl_3_t0_act_i bl_3__t0_act_i bl_3_act_i 144.555
rbl_3_t1_act_i bl_3__t1_act_i bl_3_act_i 48.1851
rbl_3_t2_act_i bl_3__t2_act_i bl_3_act_i 48.1851
rbl_3_t3_act_i bl_3__t3_act_i bl_3_act_i 144.555
rrbl_0_t0_act_i rbl_0__t0_act_i rbl_0_act_i 144.555
rrbl_0_t1_act_i rbl_0__t1_act_i rbl_0_act_i 48.1851
rrbl_0_t2_act_i rbl_0__t2_act_i rbl_0_act_i 48.1851
rrbl_0_t3_act_i rbl_0__t3_act_i rbl_0_act_i 144.555
rrbl_1_t0_act_i rbl_1__t0_act_i rbl_1_act_i 144.555
rrbl_1_t1_act_i rbl_1__t1_act_i rbl_1_act_i 48.1851
rrbl_1_t2_act_i rbl_1__t2_act_i rbl_1_act_i 48.1851
rrbl_1_t3_act_i rbl_1__t3_act_i rbl_1_act_i 144.555
rrbl_2_t0_act_i rbl_2__t0_act_i rbl_2_act_i 144.555
rrbl_2_t1_act_i rbl_2__t1_act_i rbl_2_act_i 48.1851
rrbl_2_t2_act_i rbl_2__t2_act_i rbl_2_act_i 48.1851
rrbl_2_t3_act_i rbl_2__t3_act_i rbl_2_act_i 144.555
rrbl_3_t0_act_i rbl_3__t0_act_i rbl_3_act_i 144.555
rrbl_3_t1_act_i rbl_3__t1_act_i rbl_3_act_i 48.1851
rrbl_3_t2_act_i rbl_3__t2_act_i rbl_3_act_i 48.1851
rrbl_3_t3_act_i rbl_3__t3_act_i rbl_3_act_i 144.555
rrwl_0_t0_act_i rwl_0__t0_act_i rwl_0_act_i 21.6897
rrwl_0_t1_act_i rwl_0__t1_act_i rwl_0_act_i 7.22989
rrwl_0_t2_act_i rwl_0__t2_act_i rwl_0_act_i 7.22989
rrwl_0_t3_act_i rwl_0__t3_act_i rwl_0_act_i 21.6897
rrwl_1_t0_act_i rwl_1__t0_act_i rwl_1_act_i 21.6897
rrwl_1_t1_act_i rwl_1__t1_act_i rwl_1_act_i 7.22989
rrwl_1_t2_act_i rwl_1__t2_act_i rwl_1_act_i 7.22989
rrwl_1_t3_act_i rwl_1__t3_act_i rwl_1_act_i 21.6897
rrwl_2_t0_act_i rwl_2__t0_act_i rwl_2_act_i 21.6897
rrwl_2_t1_act_i rwl_2__t1_act_i rwl_2_act_i 7.22989
rrwl_2_t2_act_i rwl_2__t2_act_i rwl_2_act_i 7.22989
rrwl_2_t3_act_i rwl_2__t3_act_i rwl_2_act_i 21.6897
rrwl_3_t0_act_i rwl_3__t0_act_i rwl_3_act_i 21.6897
rrwl_3_t1_act_i rwl_3__t1_act_i rwl_3_act_i 7.22989
rrwl_3_t2_act_i rwl_3__t2_act_i rwl_3_act_i 7.22989
rrwl_3_t3_act_i rwl_3__t3_act_i rwl_3_act_i 21.6897
rsn_0_0_t0_act_i sn_0_0__t0_act_i sn_0_0_act_i 125.123
rsn_0_0_t1_act_i sn_0_0__t1_act_i sn_0_0_act_i 125.123
rsn_0_1_t0_act_i sn_0_1__t0_act_i sn_0_1_act_i 125.123
rsn_0_1_t1_act_i sn_0_1__t1_act_i sn_0_1_act_i 125.123
rsn_0_2_t0_act_i sn_0_2__t0_act_i sn_0_2_act_i 125.123
rsn_0_2_t1_act_i sn_0_2__t1_act_i sn_0_2_act_i 125.123
rsn_0_3_t0_act_i sn_0_3__t0_act_i sn_0_3_act_i 125.123
rsn_0_3_t1_act_i sn_0_3__t1_act_i sn_0_3_act_i 125.123
rsn_1_0_t0_act_i sn_1_0__t0_act_i sn_1_0_act_i 125.123
rsn_1_0_t1_act_i sn_1_0__t1_act_i sn_1_0_act_i 125.123
rsn_1_1_t0_act_i sn_1_1__t0_act_i sn_1_1_act_i 125.123
rsn_1_1_t1_act_i sn_1_1__t1_act_i sn_1_1_act_i 125.123
rsn_1_2_t0_act_i sn_1_2__t0_act_i sn_1_2_act_i 125.123
rsn_1_2_t1_act_i sn_1_2__t1_act_i sn_1_2_act_i 125.123
rsn_1_3_t0_act_i sn_1_3__t0_act_i sn_1_3_act_i 125.123
rsn_1_3_t1_act_i sn_1_3__t1_act_i sn_1_3_act_i 125.123
rsn_2_0_t0_act_i sn_2_0__t0_act_i sn_2_0_act_i 125.123
rsn_2_0_t1_act_i sn_2_0__t1_act_i sn_2_0_act_i 125.123
rsn_2_1_t0_act_i sn_2_1__t0_act_i sn_2_1_act_i 125.123
rsn_2_1_t1_act_i sn_2_1__t1_act_i sn_2_1_act_i 125.123
rsn_2_2_t0_act_i sn_2_2__t0_act_i sn_2_2_act_i 125.123
rsn_2_2_t1_act_i sn_2_2__t1_act_i sn_2_2_act_i 125.123
rsn_2_3_t0_act_i sn_2_3__t0_act_i sn_2_3_act_i 125.123
rsn_2_3_t1_act_i sn_2_3__t1_act_i sn_2_3_act_i 125.123
rsn_3_0_t0_act_i sn_3_0__t0_act_i sn_3_0_act_i 125.123
rsn_3_0_t1_act_i sn_3_0__t1_act_i sn_3_0_act_i 125.123
rsn_3_1_t0_act_i sn_3_1__t0_act_i sn_3_1_act_i 125.123
rsn_3_1_t1_act_i sn_3_1__t1_act_i sn_3_1_act_i 125.123
rsn_3_2_t0_act_i sn_3_2__t0_act_i sn_3_2_act_i 125.123
rsn_3_2_t1_act_i sn_3_2__t1_act_i sn_3_2_act_i 125.123
rsn_3_3_t0_act_i sn_3_3__t0_act_i sn_3_3_act_i 125.123
rsn_3_3_t1_act_i sn_3_3__t1_act_i sn_3_3_act_i 125.123
rwl_0_t0_act_i wl_0__t0_act_i wl_0_act_i 54.2844
rwl_0_t1_act_i wl_0__t1_act_i wl_0_act_i 54.2844
rwl_0_t2_act_i wl_0__t2_act_i wl_0_act_i 162.853
rwl_0_t3_act_i wl_0__t3_act_i wl_0_act_i 162.853
rwl_1_t0_act_i wl_1__t0_act_i wl_1_act_i 162.853
rwl_1_t1_act_i wl_1__t1_act_i wl_1_act_i 54.2844
rwl_1_t2_act_i wl_1__t2_act_i wl_1_act_i 54.2844
rwl_1_t3_act_i wl_1__t3_act_i wl_1_act_i 162.853
rwl_2_t0_act_i wl_2__t0_act_i wl_2_act_i 54.2844
rwl_2_t1_act_i wl_2__t1_act_i wl_2_act_i 54.2844
rwl_2_t2_act_i wl_2__t2_act_i wl_2_act_i 162.853
rwl_2_t3_act_i wl_2__t3_act_i wl_2_act_i 162.853
rwl_3_t0_act_i wl_3__t0_act_i wl_3_act_i 162.853
rwl_3_t1_act_i wl_3__t1_act_i wl_3_act_i 54.2844
rwl_3_t2_act_i wl_3__t2_act_i wl_3_act_i 54.2844
rwl_3_t3_act_i wl_3__t3_act_i wl_3_act_i 162.853
cgnd_act_i gnd_act_i vsubs_act_i 4.09475e-15
cbl_0_act_i bl_0_act_i vsubs_act_i 5.96076e-16
cbl_1_act_i bl_1_act_i vsubs_act_i 5.81168e-16
cbl_2_act_i bl_2_act_i vsubs_act_i 5.81168e-16
cbl_3_act_i bl_3_act_i vsubs_act_i 5.81168e-16
crbl_0_act_i rbl_0_act_i vsubs_act_i 5.81168e-16
crbl_1_act_i rbl_1_act_i vsubs_act_i 5.81168e-16
crbl_2_act_i rbl_2_act_i vsubs_act_i 5.81168e-16
crbl_3_act_i rbl_3_act_i vsubs_act_i 5.96076e-16
crwl_0_act_i rwl_0_act_i vsubs_act_i 1.18713e-15
crwl_1_act_i rwl_1_act_i vsubs_act_i 1.18713e-15
crwl_2_act_i rwl_2_act_i vsubs_act_i 1.18713e-15
crwl_3_act_i rwl_3_act_i vsubs_act_i 1.18713e-15
csn_0_0_act_i sn_0_0_act_i vsubs_act_i 4.33689e-16
csn_0_1_act_i sn_0_1_act_i vsubs_act_i 4.30576e-16
csn_0_2_act_i sn_0_2_act_i vsubs_act_i 4.30576e-16
csn_0_3_act_i sn_0_3_act_i vsubs_act_i 4.32518e-16
csn_1_0_act_i sn_1_0_act_i vsubs_act_i 4.33689e-16
csn_1_1_act_i sn_1_1_act_i vsubs_act_i 4.30576e-16
csn_1_2_act_i sn_1_2_act_i vsubs_act_i 4.30576e-16
csn_1_3_act_i sn_1_3_act_i vsubs_act_i 4.32518e-16
csn_2_0_act_i sn_2_0_act_i vsubs_act_i 4.33689e-16
csn_2_1_act_i sn_2_1_act_i vsubs_act_i 4.30576e-16
csn_2_2_act_i sn_2_2_act_i vsubs_act_i 4.30576e-16
csn_2_3_act_i sn_2_3_act_i vsubs_act_i 4.32518e-16
csn_3_0_act_i sn_3_0_act_i vsubs_act_i 4.33689e-16
csn_3_1_act_i sn_3_1_act_i vsubs_act_i 4.30576e-16
csn_3_2_act_i sn_3_2_act_i vsubs_act_i 4.30576e-16
csn_3_3_act_i sn_3_3_act_i vsubs_act_i 4.32518e-16
cwl_0_act_i wl_0_act_i vsubs_act_i 1.90928e-15
cwl_1_act_i wl_1_act_i vsubs_act_i 1.90928e-15
cwl_2_act_i wl_2_act_i vsubs_act_i 1.90928e-15
cwl_3_act_i wl_3_act_i vsubs_act_i 1.91375e-15
ccc_bl_0_sn_0_0_act_i bl_0_act_i sn_0_0_act_i 1.071e-17
ccc_bl_0_sn_1_0_act_i bl_0_act_i sn_1_0_act_i 1.071e-17
ccc_bl_0_sn_2_0_act_i bl_0_act_i sn_2_0_act_i 1.071e-17
ccc_bl_0_sn_3_0_act_i bl_0_act_i sn_3_0_act_i 1.071e-17
ccc_bl_0_wl_0_act_i bl_0_act_i wl_0_act_i 2.4327e-17
ccc_bl_0_wl_1_act_i bl_0_act_i wl_1_act_i 2.4327e-17
ccc_bl_0_wl_2_act_i bl_0_act_i wl_2_act_i 2.4327e-17
ccc_bl_1_rbl_0_act_i bl_1_act_i rbl_0_act_i 1.29795e-16
ccc_bl_1_rwl_0_act_i bl_1_act_i rwl_0_act_i 9.028e-18
ccc_bl_1_rwl_1_act_i bl_1_act_i rwl_1_act_i 9.028e-18
ccc_bl_1_rwl_2_act_i bl_1_act_i rwl_2_act_i 9.028e-18
ccc_bl_1_rwl_3_act_i bl_1_act_i rwl_3_act_i 9.028e-18
ccc_bl_1_sn_0_1_act_i bl_1_act_i sn_0_1_act_i 1.071e-17
ccc_bl_1_sn_1_1_act_i bl_1_act_i sn_1_1_act_i 1.071e-17
ccc_bl_1_sn_2_1_act_i bl_1_act_i sn_2_1_act_i 1.071e-17
ccc_bl_1_sn_3_1_act_i bl_1_act_i sn_3_1_act_i 1.071e-17
ccc_bl_1_wl_0_act_i bl_1_act_i wl_0_act_i 2.7627e-17
ccc_bl_1_wl_1_act_i bl_1_act_i wl_1_act_i 2.7627e-17
ccc_bl_1_wl_2_act_i bl_1_act_i wl_2_act_i 2.7627e-17
ccc_bl_2_rbl_1_act_i bl_2_act_i rbl_1_act_i 1.29795e-16
ccc_bl_2_rwl_0_act_i bl_2_act_i rwl_0_act_i 9.028e-18
ccc_bl_2_rwl_1_act_i bl_2_act_i rwl_1_act_i 9.028e-18
ccc_bl_2_rwl_2_act_i bl_2_act_i rwl_2_act_i 9.028e-18
ccc_bl_2_rwl_3_act_i bl_2_act_i rwl_3_act_i 9.028e-18
ccc_bl_2_sn_0_2_act_i bl_2_act_i sn_0_2_act_i 1.071e-17
ccc_bl_2_sn_1_2_act_i bl_2_act_i sn_1_2_act_i 1.071e-17
ccc_bl_2_sn_2_2_act_i bl_2_act_i sn_2_2_act_i 1.071e-17
ccc_bl_2_sn_3_2_act_i bl_2_act_i sn_3_2_act_i 1.071e-17
ccc_bl_2_wl_0_act_i bl_2_act_i wl_0_act_i 2.7627e-17
ccc_bl_2_wl_1_act_i bl_2_act_i wl_1_act_i 2.7627e-17
ccc_bl_2_wl_2_act_i bl_2_act_i wl_2_act_i 2.7627e-17
ccc_bl_3_rbl_2_act_i bl_3_act_i rbl_2_act_i 1.29795e-16
ccc_bl_3_rwl_0_act_i bl_3_act_i rwl_0_act_i 9.028e-18
ccc_bl_3_rwl_1_act_i bl_3_act_i rwl_1_act_i 9.028e-18
ccc_bl_3_rwl_2_act_i bl_3_act_i rwl_2_act_i 9.028e-18
ccc_bl_3_rwl_3_act_i bl_3_act_i rwl_3_act_i 9.028e-18
ccc_bl_3_sn_0_3_act_i bl_3_act_i sn_0_3_act_i 1.071e-17
ccc_bl_3_sn_1_3_act_i bl_3_act_i sn_1_3_act_i 1.071e-17
ccc_bl_3_sn_2_3_act_i bl_3_act_i sn_2_3_act_i 1.071e-17
ccc_bl_3_sn_3_3_act_i bl_3_act_i sn_3_3_act_i 1.071e-17
ccc_bl_3_wl_0_act_i bl_3_act_i wl_0_act_i 2.7627e-17
ccc_bl_3_wl_1_act_i bl_3_act_i wl_1_act_i 2.7627e-17
ccc_bl_3_wl_2_act_i bl_3_act_i wl_2_act_i 2.7627e-17
ccc_rbl_0_rwl_0_act_i rbl_0_act_i rwl_0_act_i 1.9738e-17
ccc_rbl_0_rwl_1_act_i rbl_0_act_i rwl_1_act_i 1.9738e-17
ccc_rbl_0_rwl_2_act_i rbl_0_act_i rwl_2_act_i 1.9738e-17
ccc_rbl_0_rwl_3_act_i rbl_0_act_i rwl_3_act_i 1.9738e-17
ccc_rbl_0_sn_0_0_act_i rbl_0_act_i sn_0_0_act_i 1.071e-17
ccc_rbl_0_sn_1_0_act_i rbl_0_act_i sn_1_0_act_i 2.4327e-17
ccc_rbl_0_sn_2_0_act_i rbl_0_act_i sn_2_0_act_i 2.4327e-17
ccc_rbl_0_wl_0_act_i rbl_0_act_i wl_0_act_i 3.3e-18
ccc_rbl_0_wl_1_act_i rbl_0_act_i wl_1_act_i 3.3e-18
ccc_rbl_0_wl_2_act_i rbl_0_act_i wl_2_act_i 3.3e-18
ccc_rbl_1_rwl_0_act_i rbl_1_act_i rwl_0_act_i 1.9738e-17
ccc_rbl_1_rwl_1_act_i rbl_1_act_i rwl_1_act_i 1.9738e-17
ccc_rbl_1_rwl_2_act_i rbl_1_act_i rwl_2_act_i 1.9738e-17
ccc_rbl_1_rwl_3_act_i rbl_1_act_i rwl_3_act_i 1.9738e-17
ccc_rbl_1_sn_0_1_act_i rbl_1_act_i sn_0_1_act_i 1.071e-17
ccc_rbl_1_sn_1_1_act_i rbl_1_act_i sn_1_1_act_i 2.4327e-17
ccc_rbl_1_sn_2_1_act_i rbl_1_act_i sn_2_1_act_i 2.4327e-17
ccc_rbl_1_wl_0_act_i rbl_1_act_i wl_0_act_i 3.3e-18
ccc_rbl_1_wl_1_act_i rbl_1_act_i wl_1_act_i 3.3e-18
ccc_rbl_1_wl_2_act_i rbl_1_act_i wl_2_act_i 3.3e-18
ccc_rbl_2_rwl_0_act_i rbl_2_act_i rwl_0_act_i 1.9738e-17
ccc_rbl_2_rwl_1_act_i rbl_2_act_i rwl_1_act_i 1.9738e-17
ccc_rbl_2_rwl_2_act_i rbl_2_act_i rwl_2_act_i 1.9738e-17
ccc_rbl_2_rwl_3_act_i rbl_2_act_i rwl_3_act_i 1.9738e-17
ccc_rbl_2_sn_0_2_act_i rbl_2_act_i sn_0_2_act_i 1.071e-17
ccc_rbl_2_sn_1_2_act_i rbl_2_act_i sn_1_2_act_i 2.4327e-17
ccc_rbl_2_sn_2_2_act_i rbl_2_act_i sn_2_2_act_i 2.4327e-17
ccc_rbl_2_wl_0_act_i rbl_2_act_i wl_0_act_i 3.3e-18
ccc_rbl_2_wl_1_act_i rbl_2_act_i wl_1_act_i 3.3e-18
ccc_rbl_2_wl_2_act_i rbl_2_act_i wl_2_act_i 3.3e-18
ccc_rbl_3_rwl_0_act_i rbl_3_act_i rwl_0_act_i 1.071e-17
ccc_rbl_3_rwl_1_act_i rbl_3_act_i rwl_1_act_i 1.071e-17
ccc_rbl_3_rwl_2_act_i rbl_3_act_i rwl_2_act_i 1.071e-17
ccc_rbl_3_rwl_3_act_i rbl_3_act_i rwl_3_act_i 1.071e-17
ccc_rbl_3_sn_0_3_act_i rbl_3_act_i sn_0_3_act_i 1.071e-17
ccc_rbl_3_sn_1_3_act_i rbl_3_act_i sn_1_3_act_i 2.4327e-17
ccc_rbl_3_sn_2_3_act_i rbl_3_act_i sn_2_3_act_i 2.4327e-17
ccc_rwl_0_sn_0_0_act_i rwl_0_act_i sn_0_0_act_i 1.0072e-17
ccc_rwl_0_sn_0_1_act_i rwl_0_act_i sn_0_1_act_i 1.9682e-17
ccc_rwl_0_sn_0_2_act_i rwl_0_act_i sn_0_2_act_i 1.9682e-17
ccc_rwl_0_sn_0_3_act_i rwl_0_act_i sn_0_3_act_i 1.9682e-17
ccc_rwl_1_sn_1_0_act_i rwl_1_act_i sn_1_0_act_i 1.0072e-17
ccc_rwl_1_sn_1_1_act_i rwl_1_act_i sn_1_1_act_i 1.9682e-17
ccc_rwl_1_sn_1_2_act_i rwl_1_act_i sn_1_2_act_i 1.9682e-17
ccc_rwl_1_sn_1_3_act_i rwl_1_act_i sn_1_3_act_i 1.9682e-17
ccc_rwl_2_sn_2_0_act_i rwl_2_act_i sn_2_0_act_i 1.0072e-17
ccc_rwl_2_sn_2_1_act_i rwl_2_act_i sn_2_1_act_i 1.9682e-17
ccc_rwl_2_sn_2_2_act_i rwl_2_act_i sn_2_2_act_i 1.9682e-17
ccc_rwl_2_sn_2_3_act_i rwl_2_act_i sn_2_3_act_i 1.9682e-17
ccc_rwl_3_sn_3_0_act_i rwl_3_act_i sn_3_0_act_i 1.0072e-17
ccc_rwl_3_sn_3_1_act_i rwl_3_act_i sn_3_1_act_i 1.9682e-17
ccc_rwl_3_sn_3_2_act_i rwl_3_act_i sn_3_2_act_i 1.9682e-17
ccc_rwl_3_sn_3_3_act_i rwl_3_act_i sn_3_3_act_i 1.9682e-17
ccc_sn_0_0_wl_0_act_i sn_0_0_act_i wl_0_act_i 1.9664e-17
ccc_sn_0_1_wl_0_act_i sn_0_1_act_i wl_0_act_i 1.9664e-17
ccc_sn_0_2_wl_0_act_i sn_0_2_act_i wl_0_act_i 1.9664e-17
ccc_sn_0_3_wl_0_act_i sn_0_3_act_i wl_0_act_i 1.3668e-17
ccc_sn_1_0_wl_1_act_i sn_1_0_act_i wl_1_act_i 1.9664e-17
ccc_sn_1_1_wl_1_act_i sn_1_1_act_i wl_1_act_i 1.6705e-17
ccc_sn_1_2_wl_1_act_i sn_1_2_act_i wl_1_act_i 1.6705e-17
ccc_sn_1_3_wl_1_act_i sn_1_3_act_i wl_1_act_i 1.071e-17
ccc_sn_2_0_wl_2_act_i sn_2_0_act_i wl_2_act_i 1.9664e-17
ccc_sn_2_1_wl_2_act_i sn_2_1_act_i wl_2_act_i 1.6705e-17
ccc_sn_2_2_wl_2_act_i sn_2_2_act_i wl_2_act_i 1.6705e-17
ccc_sn_2_3_wl_2_act_i sn_2_3_act_i wl_2_act_i 1.071e-17
ccc_sn_3_0_wl_3_act_i sn_3_0_act_i wl_3_act_i 1.9664e-17
ccc_sn_3_1_wl_3_act_i sn_3_1_act_i wl_3_act_i 1.6705e-17
ccc_sn_3_2_wl_3_act_i sn_3_2_act_i wl_3_act_i 1.6705e-17
ccc_sn_3_3_wl_3_act_i sn_3_3_act_i wl_3_act_i 1.071e-17
vpre0_act_i pre0_act_i 0 dc 0.9
vpre1_act_i pre1_act_i 0 dc 0.9
vpre2_act_i pre2_act_i 0 dc 0.9
vpre3_act_i pre3_act_i 0 dc 0.9
vwbl0_act_i bl_0_act_i 0 dc 0
vwbl1_act_i bl_1_act_i 0 pwl(0.000000e+00 0 2.000000e-08 0 2.010000e-08 1.8 3.200000e-08 1.8 3.210000e-08 0)
vwbl2_act_i bl_2_act_i 0 dc 0
vwbl3_act_i bl_3_act_i 0 pwl(0.000000e+00 0 2.000000e-08 0 2.010000e-08 1.8 3.200000e-08 1.8 3.210000e-08 0)
vrwl0_act_i rwl_0_act_i 0 pwl(0.000000e+00 1.8 9.000000e-09 1.8 9.100000e-09 0 3.200000e-08 0 3.210000e-08 1.8)
vrwl1_act_i rwl_1_act_i 0 dc 1.8
vrwl2_act_i rwl_2_act_i 0 dc 1.8
vrwl3_act_i rwl_3_act_i 0 dc 1.8
vwwl0_act_i wl_0_act_i 0 pwl(0.000000e+00 0 2.000000e-08 0 2.010000e-08 1.8 3.000000e-08 1.8 3.010000e-08 0)
vwwl1_act_i wl_1_act_i 0 dc 0
vwwl2_act_i wl_2_act_i 0 dc 0
vwwl3_act_i wl_3_act_i 0 dc 0
vbody_act_i gnd_act_i 0 dc 0
vsub_act_i vsubs_act_i 0 dc 0
vctl_act_i ctl_act_i 0 pwl(0.000000e+00 1.8 7.000000e-09 1.8 7.100000e-09 0 3.200000e-08 0 3.210000e-08 1.8)   $ EXCLUDED: switch control, outside the boundary
spre0_act_i pre0_act_i rbl_0_act_i ctl_act_i 0 swpre
spre1_act_i pre1_act_i rbl_1_act_i ctl_act_i 0 swpre
spre2_act_i pre2_act_i rbl_2_act_i ctl_act_i 0 swpre
spre3_act_i pre3_act_i rbl_3_act_i ctl_act_i 0 swpre
bpn_vpre0_act_i pn_vpre0_act_i 0 v=(-v(pre0_act_i)*i(vpre0_act_i))
bpg_vpre0_act_i pg_vpre0_act_i 0 v=max((-v(pre0_act_i)*i(vpre0_act_i)),0)
bpr_vpre0_act_i pr_vpre0_act_i 0 v=max(-(-v(pre0_act_i)*i(vpre0_act_i)),0)
bpn_vpre1_act_i pn_vpre1_act_i 0 v=(-v(pre1_act_i)*i(vpre1_act_i))
bpg_vpre1_act_i pg_vpre1_act_i 0 v=max((-v(pre1_act_i)*i(vpre1_act_i)),0)
bpr_vpre1_act_i pr_vpre1_act_i 0 v=max(-(-v(pre1_act_i)*i(vpre1_act_i)),0)
bpn_vpre2_act_i pn_vpre2_act_i 0 v=(-v(pre2_act_i)*i(vpre2_act_i))
bpg_vpre2_act_i pg_vpre2_act_i 0 v=max((-v(pre2_act_i)*i(vpre2_act_i)),0)
bpr_vpre2_act_i pr_vpre2_act_i 0 v=max(-(-v(pre2_act_i)*i(vpre2_act_i)),0)
bpn_vpre3_act_i pn_vpre3_act_i 0 v=(-v(pre3_act_i)*i(vpre3_act_i))
bpg_vpre3_act_i pg_vpre3_act_i 0 v=max((-v(pre3_act_i)*i(vpre3_act_i)),0)
bpr_vpre3_act_i pr_vpre3_act_i 0 v=max(-(-v(pre3_act_i)*i(vpre3_act_i)),0)
bpn_vwbl0_act_i pn_vwbl0_act_i 0 v=(-v(bl_0_act_i)*i(vwbl0_act_i))
bpg_vwbl0_act_i pg_vwbl0_act_i 0 v=max((-v(bl_0_act_i)*i(vwbl0_act_i)),0)
bpr_vwbl0_act_i pr_vwbl0_act_i 0 v=max(-(-v(bl_0_act_i)*i(vwbl0_act_i)),0)
bpn_vwbl1_act_i pn_vwbl1_act_i 0 v=(-v(bl_1_act_i)*i(vwbl1_act_i))
bpg_vwbl1_act_i pg_vwbl1_act_i 0 v=max((-v(bl_1_act_i)*i(vwbl1_act_i)),0)
bpr_vwbl1_act_i pr_vwbl1_act_i 0 v=max(-(-v(bl_1_act_i)*i(vwbl1_act_i)),0)
bpn_vwbl2_act_i pn_vwbl2_act_i 0 v=(-v(bl_2_act_i)*i(vwbl2_act_i))
bpg_vwbl2_act_i pg_vwbl2_act_i 0 v=max((-v(bl_2_act_i)*i(vwbl2_act_i)),0)
bpr_vwbl2_act_i pr_vwbl2_act_i 0 v=max(-(-v(bl_2_act_i)*i(vwbl2_act_i)),0)
bpn_vwbl3_act_i pn_vwbl3_act_i 0 v=(-v(bl_3_act_i)*i(vwbl3_act_i))
bpg_vwbl3_act_i pg_vwbl3_act_i 0 v=max((-v(bl_3_act_i)*i(vwbl3_act_i)),0)
bpr_vwbl3_act_i pr_vwbl3_act_i 0 v=max(-(-v(bl_3_act_i)*i(vwbl3_act_i)),0)
bpn_vrwl0_act_i pn_vrwl0_act_i 0 v=(-v(rwl_0_act_i)*i(vrwl0_act_i))
bpg_vrwl0_act_i pg_vrwl0_act_i 0 v=max((-v(rwl_0_act_i)*i(vrwl0_act_i)),0)
bpr_vrwl0_act_i pr_vrwl0_act_i 0 v=max(-(-v(rwl_0_act_i)*i(vrwl0_act_i)),0)
bpn_vrwl1_act_i pn_vrwl1_act_i 0 v=(-v(rwl_1_act_i)*i(vrwl1_act_i))
bpg_vrwl1_act_i pg_vrwl1_act_i 0 v=max((-v(rwl_1_act_i)*i(vrwl1_act_i)),0)
bpr_vrwl1_act_i pr_vrwl1_act_i 0 v=max(-(-v(rwl_1_act_i)*i(vrwl1_act_i)),0)
bpn_vrwl2_act_i pn_vrwl2_act_i 0 v=(-v(rwl_2_act_i)*i(vrwl2_act_i))
bpg_vrwl2_act_i pg_vrwl2_act_i 0 v=max((-v(rwl_2_act_i)*i(vrwl2_act_i)),0)
bpr_vrwl2_act_i pr_vrwl2_act_i 0 v=max(-(-v(rwl_2_act_i)*i(vrwl2_act_i)),0)
bpn_vrwl3_act_i pn_vrwl3_act_i 0 v=(-v(rwl_3_act_i)*i(vrwl3_act_i))
bpg_vrwl3_act_i pg_vrwl3_act_i 0 v=max((-v(rwl_3_act_i)*i(vrwl3_act_i)),0)
bpr_vrwl3_act_i pr_vrwl3_act_i 0 v=max(-(-v(rwl_3_act_i)*i(vrwl3_act_i)),0)
bpn_vwwl0_act_i pn_vwwl0_act_i 0 v=(-v(wl_0_act_i)*i(vwwl0_act_i))
bpg_vwwl0_act_i pg_vwwl0_act_i 0 v=max((-v(wl_0_act_i)*i(vwwl0_act_i)),0)
bpr_vwwl0_act_i pr_vwwl0_act_i 0 v=max(-(-v(wl_0_act_i)*i(vwwl0_act_i)),0)
bpn_vwwl1_act_i pn_vwwl1_act_i 0 v=(-v(wl_1_act_i)*i(vwwl1_act_i))
bpg_vwwl1_act_i pg_vwwl1_act_i 0 v=max((-v(wl_1_act_i)*i(vwwl1_act_i)),0)
bpr_vwwl1_act_i pr_vwwl1_act_i 0 v=max(-(-v(wl_1_act_i)*i(vwwl1_act_i)),0)
bpn_vwwl2_act_i pn_vwwl2_act_i 0 v=(-v(wl_2_act_i)*i(vwwl2_act_i))
bpg_vwwl2_act_i pg_vwwl2_act_i 0 v=max((-v(wl_2_act_i)*i(vwwl2_act_i)),0)
bpr_vwwl2_act_i pr_vwwl2_act_i 0 v=max(-(-v(wl_2_act_i)*i(vwwl2_act_i)),0)
bpn_vwwl3_act_i pn_vwwl3_act_i 0 v=(-v(wl_3_act_i)*i(vwwl3_act_i))
bpg_vwwl3_act_i pg_vwwl3_act_i 0 v=max((-v(wl_3_act_i)*i(vwwl3_act_i)),0)
bpr_vwwl3_act_i pr_vwwl3_act_i 0 v=max(-(-v(wl_3_act_i)*i(vwwl3_act_i)),0)
bpn_vbody_act_i pn_vbody_act_i 0 v=(-v(gnd_act_i)*i(vbody_act_i))
bpg_vbody_act_i pg_vbody_act_i 0 v=max((-v(gnd_act_i)*i(vbody_act_i)),0)
bpr_vbody_act_i pr_vbody_act_i 0 v=max(-(-v(gnd_act_i)*i(vbody_act_i)),0)
bpn_vsub_act_i pn_vsub_act_i 0 v=(-v(vsubs_act_i)*i(vsub_act_i))
bpg_vsub_act_i pg_vsub_act_i 0 v=max((-v(vsubs_act_i)*i(vsub_act_i)),0)
bpr_vsub_act_i pr_vsub_act_i 0 v=max(-(-v(vsubs_act_i)*i(vsub_act_i)),0)

* ---- instance idl_z: mode idle, pattern zero ----
xm1_idl_z sn_0_0__t0_idl_z wl_0__t3_idl_z bl_0__t0_idl_z gnd__t0_idl_z sky130_fd_pr__nfet_01v8 L=0.15 W=0.42 nf=1 ad=0.1974 as=0.1974 pd=1.78 ps=1.78 mult=1 m=1
xm2_idl_z rbl_0__t0_idl_z sn_0_0__t1_idl_z rwl_0__t0_idl_z gnd__t1_idl_z sky130_fd_pr__nfet_01v8 L=0.15 W=0.42 nf=1 ad=0.1974 as=0.1974 pd=1.78 ps=1.78 mult=1 m=1
xm3_idl_z sn_0_1__t1_idl_z wl_0__t0_idl_z bl_1__t0_idl_z gnd__t2_idl_z sky130_fd_pr__nfet_01v8 L=0.15 W=0.42 nf=1 ad=0.1974 as=0.1974 pd=1.78 ps=1.78 mult=1 m=1
xm4_idl_z rbl_1__t0_idl_z sn_0_1__t0_idl_z rwl_0__t1_idl_z gnd__t3_idl_z sky130_fd_pr__nfet_01v8 L=0.15 W=0.42 nf=1 ad=0.1974 as=0.1974 pd=1.78 ps=1.78 mult=1 m=1
xm5_idl_z sn_0_2__t1_idl_z wl_0__t1_idl_z bl_2__t0_idl_z gnd__t4_idl_z sky130_fd_pr__nfet_01v8 L=0.15 W=0.42 nf=1 ad=0.1974 as=0.1974 pd=1.78 ps=1.78 mult=1 m=1
xm6_idl_z rbl_2__t0_idl_z sn_0_2__t0_idl_z rwl_0__t2_idl_z gnd__t5_idl_z sky130_fd_pr__nfet_01v8 L=0.15 W=0.42 nf=1 ad=0.1974 as=0.1974 pd=1.78 ps=1.78 mult=1 m=1
xm7_idl_z sn_0_3__t1_idl_z wl_0__t2_idl_z bl_3__t0_idl_z gnd__t6_idl_z sky130_fd_pr__nfet_01v8 L=0.15 W=0.42 nf=1 ad=0.1974 as=0.1974 pd=1.78 ps=1.78 mult=1 m=1
xm8_idl_z rbl_3__t0_idl_z sn_0_3__t0_idl_z rwl_0__t3_idl_z gnd__t7_idl_z sky130_fd_pr__nfet_01v8 L=0.15 W=0.42 nf=1 ad=0.1974 as=0.1974 pd=1.78 ps=1.78 mult=1 m=1
xm9_idl_z sn_1_0__t1_idl_z wl_1__t0_idl_z bl_0__t1_idl_z gnd__t8_idl_z sky130_fd_pr__nfet_01v8 L=0.15 W=0.42 nf=1 ad=0.1974 as=0.1974 pd=1.78 ps=1.78 mult=1 m=1
xm10_idl_z rbl_0__t1_idl_z sn_1_0__t0_idl_z rwl_1__t0_idl_z gnd__t9_idl_z sky130_fd_pr__nfet_01v8 L=0.15 W=0.42 nf=1 ad=0.1974 as=0.1974 pd=1.78 ps=1.78 mult=1 m=1
xm11_idl_z sn_1_1__t1_idl_z wl_1__t1_idl_z bl_1__t1_idl_z gnd__t10_idl_z sky130_fd_pr__nfet_01v8 L=0.15 W=0.42 nf=1 ad=0.1974 as=0.1974 pd=1.78 ps=1.78 mult=1 m=1
xm12_idl_z rbl_1__t1_idl_z sn_1_1__t0_idl_z rwl_1__t1_idl_z gnd__t11_idl_z sky130_fd_pr__nfet_01v8 L=0.15 W=0.42 nf=1 ad=0.1974 as=0.1974 pd=1.78 ps=1.78 mult=1 m=1
xm13_idl_z sn_1_2__t1_idl_z wl_1__t2_idl_z bl_2__t1_idl_z gnd__t12_idl_z sky130_fd_pr__nfet_01v8 L=0.15 W=0.42 nf=1 ad=0.1974 as=0.1974 pd=1.78 ps=1.78 mult=1 m=1
xm14_idl_z rbl_2__t1_idl_z sn_1_2__t0_idl_z rwl_1__t2_idl_z gnd__t13_idl_z sky130_fd_pr__nfet_01v8 L=0.15 W=0.42 nf=1 ad=0.1974 as=0.1974 pd=1.78 ps=1.78 mult=1 m=1
xm15_idl_z sn_1_3__t1_idl_z wl_1__t3_idl_z bl_3__t1_idl_z gnd__t14_idl_z sky130_fd_pr__nfet_01v8 L=0.15 W=0.42 nf=1 ad=0.1974 as=0.1974 pd=1.78 ps=1.78 mult=1 m=1
xm16_idl_z rbl_3__t1_idl_z sn_1_3__t0_idl_z rwl_1__t3_idl_z gnd__t15_idl_z sky130_fd_pr__nfet_01v8 L=0.15 W=0.42 nf=1 ad=0.1974 as=0.1974 pd=1.78 ps=1.78 mult=1 m=1
xm17_idl_z sn_2_0__t1_idl_z wl_2__t3_idl_z bl_0__t3_idl_z gnd__t16_idl_z sky130_fd_pr__nfet_01v8 L=0.15 W=0.42 nf=1 ad=0.1974 as=0.1974 pd=1.78 ps=1.78 mult=1 m=1
xm18_idl_z rbl_0__t2_idl_z sn_2_0__t0_idl_z rwl_2__t0_idl_z gnd__t17_idl_z sky130_fd_pr__nfet_01v8 L=0.15 W=0.42 nf=1 ad=0.1974 as=0.1974 pd=1.78 ps=1.78 mult=1 m=1
xm19_idl_z sn_2_1__t1_idl_z wl_2__t0_idl_z bl_1__t2_idl_z gnd__t18_idl_z sky130_fd_pr__nfet_01v8 L=0.15 W=0.42 nf=1 ad=0.1974 as=0.1974 pd=1.78 ps=1.78 mult=1 m=1
xm20_idl_z rbl_1__t2_idl_z sn_2_1__t0_idl_z rwl_2__t1_idl_z gnd__t19_idl_z sky130_fd_pr__nfet_01v8 L=0.15 W=0.42 nf=1 ad=0.1974 as=0.1974 pd=1.78 ps=1.78 mult=1 m=1
xm21_idl_z sn_2_2__t1_idl_z wl_2__t1_idl_z bl_2__t2_idl_z gnd__t20_idl_z sky130_fd_pr__nfet_01v8 L=0.15 W=0.42 nf=1 ad=0.1974 as=0.1974 pd=1.78 ps=1.78 mult=1 m=1
xm22_idl_z rbl_2__t2_idl_z sn_2_2__t0_idl_z rwl_2__t2_idl_z gnd__t21_idl_z sky130_fd_pr__nfet_01v8 L=0.15 W=0.42 nf=1 ad=0.1974 as=0.1974 pd=1.78 ps=1.78 mult=1 m=1
xm23_idl_z sn_2_3__t1_idl_z wl_2__t2_idl_z bl_3__t2_idl_z gnd__t22_idl_z sky130_fd_pr__nfet_01v8 L=0.15 W=0.42 nf=1 ad=0.1974 as=0.1974 pd=1.78 ps=1.78 mult=1 m=1
xm24_idl_z rbl_3__t2_idl_z sn_2_3__t0_idl_z rwl_2__t3_idl_z gnd__t23_idl_z sky130_fd_pr__nfet_01v8 L=0.15 W=0.42 nf=1 ad=0.1974 as=0.1974 pd=1.78 ps=1.78 mult=1 m=1
xm25_idl_z sn_3_0__t1_idl_z wl_3__t0_idl_z bl_0__t2_idl_z gnd__t24_idl_z sky130_fd_pr__nfet_01v8 L=0.15 W=0.42 nf=1 ad=0.1974 as=0.1974 pd=1.78 ps=1.78 mult=1 m=1
xm26_idl_z rbl_0__t3_idl_z sn_3_0__t0_idl_z rwl_3__t0_idl_z gnd__t25_idl_z sky130_fd_pr__nfet_01v8 L=0.15 W=0.42 nf=1 ad=0.1974 as=0.1974 pd=1.78 ps=1.78 mult=1 m=1
xm27_idl_z sn_3_1__t1_idl_z wl_3__t1_idl_z bl_1__t3_idl_z gnd__t26_idl_z sky130_fd_pr__nfet_01v8 L=0.15 W=0.42 nf=1 ad=0.1974 as=0.1974 pd=1.78 ps=1.78 mult=1 m=1
xm28_idl_z rbl_1__t3_idl_z sn_3_1__t0_idl_z rwl_3__t1_idl_z gnd__t27_idl_z sky130_fd_pr__nfet_01v8 L=0.15 W=0.42 nf=1 ad=0.1974 as=0.1974 pd=1.78 ps=1.78 mult=1 m=1
xm29_idl_z sn_3_2__t1_idl_z wl_3__t2_idl_z bl_2__t3_idl_z gnd__t28_idl_z sky130_fd_pr__nfet_01v8 L=0.15 W=0.42 nf=1 ad=0.1974 as=0.1974 pd=1.78 ps=1.78 mult=1 m=1
xm30_idl_z rbl_2__t3_idl_z sn_3_2__t0_idl_z rwl_3__t2_idl_z gnd__t29_idl_z sky130_fd_pr__nfet_01v8 L=0.15 W=0.42 nf=1 ad=0.1974 as=0.1974 pd=1.78 ps=1.78 mult=1 m=1
xm31_idl_z sn_3_3__t1_idl_z wl_3__t3_idl_z bl_3__t3_idl_z gnd__t30_idl_z sky130_fd_pr__nfet_01v8 L=0.15 W=0.42 nf=1 ad=0.1974 as=0.1974 pd=1.78 ps=1.78 mult=1 m=1
xm32_idl_z rbl_3__t3_idl_z sn_3_3__t0_idl_z rwl_3__t3_idl_z gnd__t31_idl_z sky130_fd_pr__nfet_01v8 L=0.15 W=0.42 nf=1 ad=0.1974 as=0.1974 pd=1.78 ps=1.78 mult=1 m=1
rgnd_t0_idl_z gnd__t0_idl_z gnd_idl_z 63.3529
rgnd_t1_idl_z gnd__t1_idl_z gnd_idl_z 49.0465
rgnd_t2_idl_z gnd__t2_idl_z gnd_idl_z 36.5177
rgnd_t3_idl_z gnd__t3_idl_z gnd_idl_z 28.2406
rgnd_t4_idl_z gnd__t4_idl_z gnd_idl_z 28.2406
rgnd_t5_idl_z gnd__t5_idl_z gnd_idl_z 36.5177
rgnd_t6_idl_z gnd__t6_idl_z gnd_idl_z 49.0465
rgnd_t7_idl_z gnd__t7_idl_z gnd_idl_z 63.3529
rgnd_t8_idl_z gnd__t8_idl_z gnd_idl_z 58.0019
rgnd_t9_idl_z gnd__t9_idl_z gnd_idl_z 41.907
rgnd_t10_idl_z gnd__t10_idl_z gnd_idl_z 26.1568
rgnd_t11_idl_z gnd__t11_idl_z gnd_idl_z 12.1726
rgnd_t12_idl_z gnd__t12_idl_z gnd_idl_z 12.1726
rgnd_t13_idl_z gnd__t13_idl_z gnd_idl_z 26.1568
rgnd_t14_idl_z gnd__t14_idl_z gnd_idl_z 41.907
rgnd_t15_idl_z gnd__t15_idl_z gnd_idl_z 58.0019
rgnd_t16_idl_z gnd__t16_idl_z gnd_idl_z 58.0019
rgnd_t17_idl_z gnd__t17_idl_z gnd_idl_z 41.907
rgnd_t18_idl_z gnd__t18_idl_z gnd_idl_z 26.1568
rgnd_t19_idl_z gnd__t19_idl_z gnd_idl_z 12.1726
rgnd_t20_idl_z gnd__t20_idl_z gnd_idl_z 12.1726
rgnd_t21_idl_z gnd__t21_idl_z gnd_idl_z 26.1568
rgnd_t22_idl_z gnd__t22_idl_z gnd_idl_z 41.907
rgnd_t23_idl_z gnd__t23_idl_z gnd_idl_z 58.0019
rgnd_t24_idl_z gnd__t24_idl_z gnd_idl_z 63.3529
rgnd_t25_idl_z gnd__t25_idl_z gnd_idl_z 49.0465
rgnd_t26_idl_z gnd__t26_idl_z gnd_idl_z 36.5177
rgnd_t27_idl_z gnd__t27_idl_z gnd_idl_z 28.2406
rgnd_t28_idl_z gnd__t28_idl_z gnd_idl_z 28.2406
rgnd_t29_idl_z gnd__t29_idl_z gnd_idl_z 36.5177
rgnd_t30_idl_z gnd__t30_idl_z gnd_idl_z 49.0465
rgnd_t31_idl_z gnd__t31_idl_z gnd_idl_z 63.3529
rbl_0_t0_idl_z bl_0__t0_idl_z bl_0_idl_z 144.555
rbl_0_t1_idl_z bl_0__t1_idl_z bl_0_idl_z 48.1851
rbl_0_t2_idl_z bl_0__t2_idl_z bl_0_idl_z 144.555
rbl_0_t3_idl_z bl_0__t3_idl_z bl_0_idl_z 48.1851
rbl_1_t0_idl_z bl_1__t0_idl_z bl_1_idl_z 144.555
rbl_1_t1_idl_z bl_1__t1_idl_z bl_1_idl_z 48.1851
rbl_1_t2_idl_z bl_1__t2_idl_z bl_1_idl_z 48.1851
rbl_1_t3_idl_z bl_1__t3_idl_z bl_1_idl_z 144.555
rbl_2_t0_idl_z bl_2__t0_idl_z bl_2_idl_z 144.555
rbl_2_t1_idl_z bl_2__t1_idl_z bl_2_idl_z 48.1851
rbl_2_t2_idl_z bl_2__t2_idl_z bl_2_idl_z 48.1851
rbl_2_t3_idl_z bl_2__t3_idl_z bl_2_idl_z 144.555
rbl_3_t0_idl_z bl_3__t0_idl_z bl_3_idl_z 144.555
rbl_3_t1_idl_z bl_3__t1_idl_z bl_3_idl_z 48.1851
rbl_3_t2_idl_z bl_3__t2_idl_z bl_3_idl_z 48.1851
rbl_3_t3_idl_z bl_3__t3_idl_z bl_3_idl_z 144.555
rrbl_0_t0_idl_z rbl_0__t0_idl_z rbl_0_idl_z 144.555
rrbl_0_t1_idl_z rbl_0__t1_idl_z rbl_0_idl_z 48.1851
rrbl_0_t2_idl_z rbl_0__t2_idl_z rbl_0_idl_z 48.1851
rrbl_0_t3_idl_z rbl_0__t3_idl_z rbl_0_idl_z 144.555
rrbl_1_t0_idl_z rbl_1__t0_idl_z rbl_1_idl_z 144.555
rrbl_1_t1_idl_z rbl_1__t1_idl_z rbl_1_idl_z 48.1851
rrbl_1_t2_idl_z rbl_1__t2_idl_z rbl_1_idl_z 48.1851
rrbl_1_t3_idl_z rbl_1__t3_idl_z rbl_1_idl_z 144.555
rrbl_2_t0_idl_z rbl_2__t0_idl_z rbl_2_idl_z 144.555
rrbl_2_t1_idl_z rbl_2__t1_idl_z rbl_2_idl_z 48.1851
rrbl_2_t2_idl_z rbl_2__t2_idl_z rbl_2_idl_z 48.1851
rrbl_2_t3_idl_z rbl_2__t3_idl_z rbl_2_idl_z 144.555
rrbl_3_t0_idl_z rbl_3__t0_idl_z rbl_3_idl_z 144.555
rrbl_3_t1_idl_z rbl_3__t1_idl_z rbl_3_idl_z 48.1851
rrbl_3_t2_idl_z rbl_3__t2_idl_z rbl_3_idl_z 48.1851
rrbl_3_t3_idl_z rbl_3__t3_idl_z rbl_3_idl_z 144.555
rrwl_0_t0_idl_z rwl_0__t0_idl_z rwl_0_idl_z 21.6897
rrwl_0_t1_idl_z rwl_0__t1_idl_z rwl_0_idl_z 7.22989
rrwl_0_t2_idl_z rwl_0__t2_idl_z rwl_0_idl_z 7.22989
rrwl_0_t3_idl_z rwl_0__t3_idl_z rwl_0_idl_z 21.6897
rrwl_1_t0_idl_z rwl_1__t0_idl_z rwl_1_idl_z 21.6897
rrwl_1_t1_idl_z rwl_1__t1_idl_z rwl_1_idl_z 7.22989
rrwl_1_t2_idl_z rwl_1__t2_idl_z rwl_1_idl_z 7.22989
rrwl_1_t3_idl_z rwl_1__t3_idl_z rwl_1_idl_z 21.6897
rrwl_2_t0_idl_z rwl_2__t0_idl_z rwl_2_idl_z 21.6897
rrwl_2_t1_idl_z rwl_2__t1_idl_z rwl_2_idl_z 7.22989
rrwl_2_t2_idl_z rwl_2__t2_idl_z rwl_2_idl_z 7.22989
rrwl_2_t3_idl_z rwl_2__t3_idl_z rwl_2_idl_z 21.6897
rrwl_3_t0_idl_z rwl_3__t0_idl_z rwl_3_idl_z 21.6897
rrwl_3_t1_idl_z rwl_3__t1_idl_z rwl_3_idl_z 7.22989
rrwl_3_t2_idl_z rwl_3__t2_idl_z rwl_3_idl_z 7.22989
rrwl_3_t3_idl_z rwl_3__t3_idl_z rwl_3_idl_z 21.6897
rsn_0_0_t0_idl_z sn_0_0__t0_idl_z sn_0_0_idl_z 125.123
rsn_0_0_t1_idl_z sn_0_0__t1_idl_z sn_0_0_idl_z 125.123
rsn_0_1_t0_idl_z sn_0_1__t0_idl_z sn_0_1_idl_z 125.123
rsn_0_1_t1_idl_z sn_0_1__t1_idl_z sn_0_1_idl_z 125.123
rsn_0_2_t0_idl_z sn_0_2__t0_idl_z sn_0_2_idl_z 125.123
rsn_0_2_t1_idl_z sn_0_2__t1_idl_z sn_0_2_idl_z 125.123
rsn_0_3_t0_idl_z sn_0_3__t0_idl_z sn_0_3_idl_z 125.123
rsn_0_3_t1_idl_z sn_0_3__t1_idl_z sn_0_3_idl_z 125.123
rsn_1_0_t0_idl_z sn_1_0__t0_idl_z sn_1_0_idl_z 125.123
rsn_1_0_t1_idl_z sn_1_0__t1_idl_z sn_1_0_idl_z 125.123
rsn_1_1_t0_idl_z sn_1_1__t0_idl_z sn_1_1_idl_z 125.123
rsn_1_1_t1_idl_z sn_1_1__t1_idl_z sn_1_1_idl_z 125.123
rsn_1_2_t0_idl_z sn_1_2__t0_idl_z sn_1_2_idl_z 125.123
rsn_1_2_t1_idl_z sn_1_2__t1_idl_z sn_1_2_idl_z 125.123
rsn_1_3_t0_idl_z sn_1_3__t0_idl_z sn_1_3_idl_z 125.123
rsn_1_3_t1_idl_z sn_1_3__t1_idl_z sn_1_3_idl_z 125.123
rsn_2_0_t0_idl_z sn_2_0__t0_idl_z sn_2_0_idl_z 125.123
rsn_2_0_t1_idl_z sn_2_0__t1_idl_z sn_2_0_idl_z 125.123
rsn_2_1_t0_idl_z sn_2_1__t0_idl_z sn_2_1_idl_z 125.123
rsn_2_1_t1_idl_z sn_2_1__t1_idl_z sn_2_1_idl_z 125.123
rsn_2_2_t0_idl_z sn_2_2__t0_idl_z sn_2_2_idl_z 125.123
rsn_2_2_t1_idl_z sn_2_2__t1_idl_z sn_2_2_idl_z 125.123
rsn_2_3_t0_idl_z sn_2_3__t0_idl_z sn_2_3_idl_z 125.123
rsn_2_3_t1_idl_z sn_2_3__t1_idl_z sn_2_3_idl_z 125.123
rsn_3_0_t0_idl_z sn_3_0__t0_idl_z sn_3_0_idl_z 125.123
rsn_3_0_t1_idl_z sn_3_0__t1_idl_z sn_3_0_idl_z 125.123
rsn_3_1_t0_idl_z sn_3_1__t0_idl_z sn_3_1_idl_z 125.123
rsn_3_1_t1_idl_z sn_3_1__t1_idl_z sn_3_1_idl_z 125.123
rsn_3_2_t0_idl_z sn_3_2__t0_idl_z sn_3_2_idl_z 125.123
rsn_3_2_t1_idl_z sn_3_2__t1_idl_z sn_3_2_idl_z 125.123
rsn_3_3_t0_idl_z sn_3_3__t0_idl_z sn_3_3_idl_z 125.123
rsn_3_3_t1_idl_z sn_3_3__t1_idl_z sn_3_3_idl_z 125.123
rwl_0_t0_idl_z wl_0__t0_idl_z wl_0_idl_z 54.2844
rwl_0_t1_idl_z wl_0__t1_idl_z wl_0_idl_z 54.2844
rwl_0_t2_idl_z wl_0__t2_idl_z wl_0_idl_z 162.853
rwl_0_t3_idl_z wl_0__t3_idl_z wl_0_idl_z 162.853
rwl_1_t0_idl_z wl_1__t0_idl_z wl_1_idl_z 162.853
rwl_1_t1_idl_z wl_1__t1_idl_z wl_1_idl_z 54.2844
rwl_1_t2_idl_z wl_1__t2_idl_z wl_1_idl_z 54.2844
rwl_1_t3_idl_z wl_1__t3_idl_z wl_1_idl_z 162.853
rwl_2_t0_idl_z wl_2__t0_idl_z wl_2_idl_z 54.2844
rwl_2_t1_idl_z wl_2__t1_idl_z wl_2_idl_z 54.2844
rwl_2_t2_idl_z wl_2__t2_idl_z wl_2_idl_z 162.853
rwl_2_t3_idl_z wl_2__t3_idl_z wl_2_idl_z 162.853
rwl_3_t0_idl_z wl_3__t0_idl_z wl_3_idl_z 162.853
rwl_3_t1_idl_z wl_3__t1_idl_z wl_3_idl_z 54.2844
rwl_3_t2_idl_z wl_3__t2_idl_z wl_3_idl_z 54.2844
rwl_3_t3_idl_z wl_3__t3_idl_z wl_3_idl_z 162.853
cgnd_idl_z gnd_idl_z vsubs_idl_z 4.09475e-15
cbl_0_idl_z bl_0_idl_z vsubs_idl_z 5.96076e-16
cbl_1_idl_z bl_1_idl_z vsubs_idl_z 5.81168e-16
cbl_2_idl_z bl_2_idl_z vsubs_idl_z 5.81168e-16
cbl_3_idl_z bl_3_idl_z vsubs_idl_z 5.81168e-16
crbl_0_idl_z rbl_0_idl_z vsubs_idl_z 5.81168e-16
crbl_1_idl_z rbl_1_idl_z vsubs_idl_z 5.81168e-16
crbl_2_idl_z rbl_2_idl_z vsubs_idl_z 5.81168e-16
crbl_3_idl_z rbl_3_idl_z vsubs_idl_z 5.96076e-16
crwl_0_idl_z rwl_0_idl_z vsubs_idl_z 1.18713e-15
crwl_1_idl_z rwl_1_idl_z vsubs_idl_z 1.18713e-15
crwl_2_idl_z rwl_2_idl_z vsubs_idl_z 1.18713e-15
crwl_3_idl_z rwl_3_idl_z vsubs_idl_z 1.18713e-15
csn_0_0_idl_z sn_0_0_idl_z vsubs_idl_z 4.33689e-16
csn_0_1_idl_z sn_0_1_idl_z vsubs_idl_z 4.30576e-16
csn_0_2_idl_z sn_0_2_idl_z vsubs_idl_z 4.30576e-16
csn_0_3_idl_z sn_0_3_idl_z vsubs_idl_z 4.32518e-16
csn_1_0_idl_z sn_1_0_idl_z vsubs_idl_z 4.33689e-16
csn_1_1_idl_z sn_1_1_idl_z vsubs_idl_z 4.30576e-16
csn_1_2_idl_z sn_1_2_idl_z vsubs_idl_z 4.30576e-16
csn_1_3_idl_z sn_1_3_idl_z vsubs_idl_z 4.32518e-16
csn_2_0_idl_z sn_2_0_idl_z vsubs_idl_z 4.33689e-16
csn_2_1_idl_z sn_2_1_idl_z vsubs_idl_z 4.30576e-16
csn_2_2_idl_z sn_2_2_idl_z vsubs_idl_z 4.30576e-16
csn_2_3_idl_z sn_2_3_idl_z vsubs_idl_z 4.32518e-16
csn_3_0_idl_z sn_3_0_idl_z vsubs_idl_z 4.33689e-16
csn_3_1_idl_z sn_3_1_idl_z vsubs_idl_z 4.30576e-16
csn_3_2_idl_z sn_3_2_idl_z vsubs_idl_z 4.30576e-16
csn_3_3_idl_z sn_3_3_idl_z vsubs_idl_z 4.32518e-16
cwl_0_idl_z wl_0_idl_z vsubs_idl_z 1.90928e-15
cwl_1_idl_z wl_1_idl_z vsubs_idl_z 1.90928e-15
cwl_2_idl_z wl_2_idl_z vsubs_idl_z 1.90928e-15
cwl_3_idl_z wl_3_idl_z vsubs_idl_z 1.91375e-15
ccc_bl_0_sn_0_0_idl_z bl_0_idl_z sn_0_0_idl_z 1.071e-17
ccc_bl_0_sn_1_0_idl_z bl_0_idl_z sn_1_0_idl_z 1.071e-17
ccc_bl_0_sn_2_0_idl_z bl_0_idl_z sn_2_0_idl_z 1.071e-17
ccc_bl_0_sn_3_0_idl_z bl_0_idl_z sn_3_0_idl_z 1.071e-17
ccc_bl_0_wl_0_idl_z bl_0_idl_z wl_0_idl_z 2.4327e-17
ccc_bl_0_wl_1_idl_z bl_0_idl_z wl_1_idl_z 2.4327e-17
ccc_bl_0_wl_2_idl_z bl_0_idl_z wl_2_idl_z 2.4327e-17
ccc_bl_1_rbl_0_idl_z bl_1_idl_z rbl_0_idl_z 1.29795e-16
ccc_bl_1_rwl_0_idl_z bl_1_idl_z rwl_0_idl_z 9.028e-18
ccc_bl_1_rwl_1_idl_z bl_1_idl_z rwl_1_idl_z 9.028e-18
ccc_bl_1_rwl_2_idl_z bl_1_idl_z rwl_2_idl_z 9.028e-18
ccc_bl_1_rwl_3_idl_z bl_1_idl_z rwl_3_idl_z 9.028e-18
ccc_bl_1_sn_0_1_idl_z bl_1_idl_z sn_0_1_idl_z 1.071e-17
ccc_bl_1_sn_1_1_idl_z bl_1_idl_z sn_1_1_idl_z 1.071e-17
ccc_bl_1_sn_2_1_idl_z bl_1_idl_z sn_2_1_idl_z 1.071e-17
ccc_bl_1_sn_3_1_idl_z bl_1_idl_z sn_3_1_idl_z 1.071e-17
ccc_bl_1_wl_0_idl_z bl_1_idl_z wl_0_idl_z 2.7627e-17
ccc_bl_1_wl_1_idl_z bl_1_idl_z wl_1_idl_z 2.7627e-17
ccc_bl_1_wl_2_idl_z bl_1_idl_z wl_2_idl_z 2.7627e-17
ccc_bl_2_rbl_1_idl_z bl_2_idl_z rbl_1_idl_z 1.29795e-16
ccc_bl_2_rwl_0_idl_z bl_2_idl_z rwl_0_idl_z 9.028e-18
ccc_bl_2_rwl_1_idl_z bl_2_idl_z rwl_1_idl_z 9.028e-18
ccc_bl_2_rwl_2_idl_z bl_2_idl_z rwl_2_idl_z 9.028e-18
ccc_bl_2_rwl_3_idl_z bl_2_idl_z rwl_3_idl_z 9.028e-18
ccc_bl_2_sn_0_2_idl_z bl_2_idl_z sn_0_2_idl_z 1.071e-17
ccc_bl_2_sn_1_2_idl_z bl_2_idl_z sn_1_2_idl_z 1.071e-17
ccc_bl_2_sn_2_2_idl_z bl_2_idl_z sn_2_2_idl_z 1.071e-17
ccc_bl_2_sn_3_2_idl_z bl_2_idl_z sn_3_2_idl_z 1.071e-17
ccc_bl_2_wl_0_idl_z bl_2_idl_z wl_0_idl_z 2.7627e-17
ccc_bl_2_wl_1_idl_z bl_2_idl_z wl_1_idl_z 2.7627e-17
ccc_bl_2_wl_2_idl_z bl_2_idl_z wl_2_idl_z 2.7627e-17
ccc_bl_3_rbl_2_idl_z bl_3_idl_z rbl_2_idl_z 1.29795e-16
ccc_bl_3_rwl_0_idl_z bl_3_idl_z rwl_0_idl_z 9.028e-18
ccc_bl_3_rwl_1_idl_z bl_3_idl_z rwl_1_idl_z 9.028e-18
ccc_bl_3_rwl_2_idl_z bl_3_idl_z rwl_2_idl_z 9.028e-18
ccc_bl_3_rwl_3_idl_z bl_3_idl_z rwl_3_idl_z 9.028e-18
ccc_bl_3_sn_0_3_idl_z bl_3_idl_z sn_0_3_idl_z 1.071e-17
ccc_bl_3_sn_1_3_idl_z bl_3_idl_z sn_1_3_idl_z 1.071e-17
ccc_bl_3_sn_2_3_idl_z bl_3_idl_z sn_2_3_idl_z 1.071e-17
ccc_bl_3_sn_3_3_idl_z bl_3_idl_z sn_3_3_idl_z 1.071e-17
ccc_bl_3_wl_0_idl_z bl_3_idl_z wl_0_idl_z 2.7627e-17
ccc_bl_3_wl_1_idl_z bl_3_idl_z wl_1_idl_z 2.7627e-17
ccc_bl_3_wl_2_idl_z bl_3_idl_z wl_2_idl_z 2.7627e-17
ccc_rbl_0_rwl_0_idl_z rbl_0_idl_z rwl_0_idl_z 1.9738e-17
ccc_rbl_0_rwl_1_idl_z rbl_0_idl_z rwl_1_idl_z 1.9738e-17
ccc_rbl_0_rwl_2_idl_z rbl_0_idl_z rwl_2_idl_z 1.9738e-17
ccc_rbl_0_rwl_3_idl_z rbl_0_idl_z rwl_3_idl_z 1.9738e-17
ccc_rbl_0_sn_0_0_idl_z rbl_0_idl_z sn_0_0_idl_z 1.071e-17
ccc_rbl_0_sn_1_0_idl_z rbl_0_idl_z sn_1_0_idl_z 2.4327e-17
ccc_rbl_0_sn_2_0_idl_z rbl_0_idl_z sn_2_0_idl_z 2.4327e-17
ccc_rbl_0_wl_0_idl_z rbl_0_idl_z wl_0_idl_z 3.3e-18
ccc_rbl_0_wl_1_idl_z rbl_0_idl_z wl_1_idl_z 3.3e-18
ccc_rbl_0_wl_2_idl_z rbl_0_idl_z wl_2_idl_z 3.3e-18
ccc_rbl_1_rwl_0_idl_z rbl_1_idl_z rwl_0_idl_z 1.9738e-17
ccc_rbl_1_rwl_1_idl_z rbl_1_idl_z rwl_1_idl_z 1.9738e-17
ccc_rbl_1_rwl_2_idl_z rbl_1_idl_z rwl_2_idl_z 1.9738e-17
ccc_rbl_1_rwl_3_idl_z rbl_1_idl_z rwl_3_idl_z 1.9738e-17
ccc_rbl_1_sn_0_1_idl_z rbl_1_idl_z sn_0_1_idl_z 1.071e-17
ccc_rbl_1_sn_1_1_idl_z rbl_1_idl_z sn_1_1_idl_z 2.4327e-17
ccc_rbl_1_sn_2_1_idl_z rbl_1_idl_z sn_2_1_idl_z 2.4327e-17
ccc_rbl_1_wl_0_idl_z rbl_1_idl_z wl_0_idl_z 3.3e-18
ccc_rbl_1_wl_1_idl_z rbl_1_idl_z wl_1_idl_z 3.3e-18
ccc_rbl_1_wl_2_idl_z rbl_1_idl_z wl_2_idl_z 3.3e-18
ccc_rbl_2_rwl_0_idl_z rbl_2_idl_z rwl_0_idl_z 1.9738e-17
ccc_rbl_2_rwl_1_idl_z rbl_2_idl_z rwl_1_idl_z 1.9738e-17
ccc_rbl_2_rwl_2_idl_z rbl_2_idl_z rwl_2_idl_z 1.9738e-17
ccc_rbl_2_rwl_3_idl_z rbl_2_idl_z rwl_3_idl_z 1.9738e-17
ccc_rbl_2_sn_0_2_idl_z rbl_2_idl_z sn_0_2_idl_z 1.071e-17
ccc_rbl_2_sn_1_2_idl_z rbl_2_idl_z sn_1_2_idl_z 2.4327e-17
ccc_rbl_2_sn_2_2_idl_z rbl_2_idl_z sn_2_2_idl_z 2.4327e-17
ccc_rbl_2_wl_0_idl_z rbl_2_idl_z wl_0_idl_z 3.3e-18
ccc_rbl_2_wl_1_idl_z rbl_2_idl_z wl_1_idl_z 3.3e-18
ccc_rbl_2_wl_2_idl_z rbl_2_idl_z wl_2_idl_z 3.3e-18
ccc_rbl_3_rwl_0_idl_z rbl_3_idl_z rwl_0_idl_z 1.071e-17
ccc_rbl_3_rwl_1_idl_z rbl_3_idl_z rwl_1_idl_z 1.071e-17
ccc_rbl_3_rwl_2_idl_z rbl_3_idl_z rwl_2_idl_z 1.071e-17
ccc_rbl_3_rwl_3_idl_z rbl_3_idl_z rwl_3_idl_z 1.071e-17
ccc_rbl_3_sn_0_3_idl_z rbl_3_idl_z sn_0_3_idl_z 1.071e-17
ccc_rbl_3_sn_1_3_idl_z rbl_3_idl_z sn_1_3_idl_z 2.4327e-17
ccc_rbl_3_sn_2_3_idl_z rbl_3_idl_z sn_2_3_idl_z 2.4327e-17
ccc_rwl_0_sn_0_0_idl_z rwl_0_idl_z sn_0_0_idl_z 1.0072e-17
ccc_rwl_0_sn_0_1_idl_z rwl_0_idl_z sn_0_1_idl_z 1.9682e-17
ccc_rwl_0_sn_0_2_idl_z rwl_0_idl_z sn_0_2_idl_z 1.9682e-17
ccc_rwl_0_sn_0_3_idl_z rwl_0_idl_z sn_0_3_idl_z 1.9682e-17
ccc_rwl_1_sn_1_0_idl_z rwl_1_idl_z sn_1_0_idl_z 1.0072e-17
ccc_rwl_1_sn_1_1_idl_z rwl_1_idl_z sn_1_1_idl_z 1.9682e-17
ccc_rwl_1_sn_1_2_idl_z rwl_1_idl_z sn_1_2_idl_z 1.9682e-17
ccc_rwl_1_sn_1_3_idl_z rwl_1_idl_z sn_1_3_idl_z 1.9682e-17
ccc_rwl_2_sn_2_0_idl_z rwl_2_idl_z sn_2_0_idl_z 1.0072e-17
ccc_rwl_2_sn_2_1_idl_z rwl_2_idl_z sn_2_1_idl_z 1.9682e-17
ccc_rwl_2_sn_2_2_idl_z rwl_2_idl_z sn_2_2_idl_z 1.9682e-17
ccc_rwl_2_sn_2_3_idl_z rwl_2_idl_z sn_2_3_idl_z 1.9682e-17
ccc_rwl_3_sn_3_0_idl_z rwl_3_idl_z sn_3_0_idl_z 1.0072e-17
ccc_rwl_3_sn_3_1_idl_z rwl_3_idl_z sn_3_1_idl_z 1.9682e-17
ccc_rwl_3_sn_3_2_idl_z rwl_3_idl_z sn_3_2_idl_z 1.9682e-17
ccc_rwl_3_sn_3_3_idl_z rwl_3_idl_z sn_3_3_idl_z 1.9682e-17
ccc_sn_0_0_wl_0_idl_z sn_0_0_idl_z wl_0_idl_z 1.9664e-17
ccc_sn_0_1_wl_0_idl_z sn_0_1_idl_z wl_0_idl_z 1.9664e-17
ccc_sn_0_2_wl_0_idl_z sn_0_2_idl_z wl_0_idl_z 1.9664e-17
ccc_sn_0_3_wl_0_idl_z sn_0_3_idl_z wl_0_idl_z 1.3668e-17
ccc_sn_1_0_wl_1_idl_z sn_1_0_idl_z wl_1_idl_z 1.9664e-17
ccc_sn_1_1_wl_1_idl_z sn_1_1_idl_z wl_1_idl_z 1.6705e-17
ccc_sn_1_2_wl_1_idl_z sn_1_2_idl_z wl_1_idl_z 1.6705e-17
ccc_sn_1_3_wl_1_idl_z sn_1_3_idl_z wl_1_idl_z 1.071e-17
ccc_sn_2_0_wl_2_idl_z sn_2_0_idl_z wl_2_idl_z 1.9664e-17
ccc_sn_2_1_wl_2_idl_z sn_2_1_idl_z wl_2_idl_z 1.6705e-17
ccc_sn_2_2_wl_2_idl_z sn_2_2_idl_z wl_2_idl_z 1.6705e-17
ccc_sn_2_3_wl_2_idl_z sn_2_3_idl_z wl_2_idl_z 1.071e-17
ccc_sn_3_0_wl_3_idl_z sn_3_0_idl_z wl_3_idl_z 1.9664e-17
ccc_sn_3_1_wl_3_idl_z sn_3_1_idl_z wl_3_idl_z 1.6705e-17
ccc_sn_3_2_wl_3_idl_z sn_3_2_idl_z wl_3_idl_z 1.6705e-17
ccc_sn_3_3_wl_3_idl_z sn_3_3_idl_z wl_3_idl_z 1.071e-17
vpre0_idl_z pre0_idl_z 0 dc 0.9
vpre1_idl_z pre1_idl_z 0 dc 0.9
vpre2_idl_z pre2_idl_z 0 dc 0.9
vpre3_idl_z pre3_idl_z 0 dc 0.9
vwbl0_idl_z bl_0_idl_z 0 dc 0
vwbl1_idl_z bl_1_idl_z 0 dc 0
vwbl2_idl_z bl_2_idl_z 0 dc 0
vwbl3_idl_z bl_3_idl_z 0 dc 0
vrwl0_idl_z rwl_0_idl_z 0 dc 1.8
vrwl1_idl_z rwl_1_idl_z 0 dc 1.8
vrwl2_idl_z rwl_2_idl_z 0 dc 1.8
vrwl3_idl_z rwl_3_idl_z 0 dc 1.8
vwwl0_idl_z wl_0_idl_z 0 dc 0
vwwl1_idl_z wl_1_idl_z 0 dc 0
vwwl2_idl_z wl_2_idl_z 0 dc 0
vwwl3_idl_z wl_3_idl_z 0 dc 0
vbody_idl_z gnd_idl_z 0 dc 0
vsub_idl_z vsubs_idl_z 0 dc 0
vctl_idl_z ctl_idl_z 0 dc 1.8   $ EXCLUDED: switch control, outside the boundary
spre0_idl_z pre0_idl_z rbl_0_idl_z ctl_idl_z 0 swpre
spre1_idl_z pre1_idl_z rbl_1_idl_z ctl_idl_z 0 swpre
spre2_idl_z pre2_idl_z rbl_2_idl_z ctl_idl_z 0 swpre
spre3_idl_z pre3_idl_z rbl_3_idl_z ctl_idl_z 0 swpre
bpn_vpre0_idl_z pn_vpre0_idl_z 0 v=(-v(pre0_idl_z)*i(vpre0_idl_z))
bpg_vpre0_idl_z pg_vpre0_idl_z 0 v=max((-v(pre0_idl_z)*i(vpre0_idl_z)),0)
bpr_vpre0_idl_z pr_vpre0_idl_z 0 v=max(-(-v(pre0_idl_z)*i(vpre0_idl_z)),0)
bpn_vpre1_idl_z pn_vpre1_idl_z 0 v=(-v(pre1_idl_z)*i(vpre1_idl_z))
bpg_vpre1_idl_z pg_vpre1_idl_z 0 v=max((-v(pre1_idl_z)*i(vpre1_idl_z)),0)
bpr_vpre1_idl_z pr_vpre1_idl_z 0 v=max(-(-v(pre1_idl_z)*i(vpre1_idl_z)),0)
bpn_vpre2_idl_z pn_vpre2_idl_z 0 v=(-v(pre2_idl_z)*i(vpre2_idl_z))
bpg_vpre2_idl_z pg_vpre2_idl_z 0 v=max((-v(pre2_idl_z)*i(vpre2_idl_z)),0)
bpr_vpre2_idl_z pr_vpre2_idl_z 0 v=max(-(-v(pre2_idl_z)*i(vpre2_idl_z)),0)
bpn_vpre3_idl_z pn_vpre3_idl_z 0 v=(-v(pre3_idl_z)*i(vpre3_idl_z))
bpg_vpre3_idl_z pg_vpre3_idl_z 0 v=max((-v(pre3_idl_z)*i(vpre3_idl_z)),0)
bpr_vpre3_idl_z pr_vpre3_idl_z 0 v=max(-(-v(pre3_idl_z)*i(vpre3_idl_z)),0)
bpn_vwbl0_idl_z pn_vwbl0_idl_z 0 v=(-v(bl_0_idl_z)*i(vwbl0_idl_z))
bpg_vwbl0_idl_z pg_vwbl0_idl_z 0 v=max((-v(bl_0_idl_z)*i(vwbl0_idl_z)),0)
bpr_vwbl0_idl_z pr_vwbl0_idl_z 0 v=max(-(-v(bl_0_idl_z)*i(vwbl0_idl_z)),0)
bpn_vwbl1_idl_z pn_vwbl1_idl_z 0 v=(-v(bl_1_idl_z)*i(vwbl1_idl_z))
bpg_vwbl1_idl_z pg_vwbl1_idl_z 0 v=max((-v(bl_1_idl_z)*i(vwbl1_idl_z)),0)
bpr_vwbl1_idl_z pr_vwbl1_idl_z 0 v=max(-(-v(bl_1_idl_z)*i(vwbl1_idl_z)),0)
bpn_vwbl2_idl_z pn_vwbl2_idl_z 0 v=(-v(bl_2_idl_z)*i(vwbl2_idl_z))
bpg_vwbl2_idl_z pg_vwbl2_idl_z 0 v=max((-v(bl_2_idl_z)*i(vwbl2_idl_z)),0)
bpr_vwbl2_idl_z pr_vwbl2_idl_z 0 v=max(-(-v(bl_2_idl_z)*i(vwbl2_idl_z)),0)
bpn_vwbl3_idl_z pn_vwbl3_idl_z 0 v=(-v(bl_3_idl_z)*i(vwbl3_idl_z))
bpg_vwbl3_idl_z pg_vwbl3_idl_z 0 v=max((-v(bl_3_idl_z)*i(vwbl3_idl_z)),0)
bpr_vwbl3_idl_z pr_vwbl3_idl_z 0 v=max(-(-v(bl_3_idl_z)*i(vwbl3_idl_z)),0)
bpn_vrwl0_idl_z pn_vrwl0_idl_z 0 v=(-v(rwl_0_idl_z)*i(vrwl0_idl_z))
bpg_vrwl0_idl_z pg_vrwl0_idl_z 0 v=max((-v(rwl_0_idl_z)*i(vrwl0_idl_z)),0)
bpr_vrwl0_idl_z pr_vrwl0_idl_z 0 v=max(-(-v(rwl_0_idl_z)*i(vrwl0_idl_z)),0)
bpn_vrwl1_idl_z pn_vrwl1_idl_z 0 v=(-v(rwl_1_idl_z)*i(vrwl1_idl_z))
bpg_vrwl1_idl_z pg_vrwl1_idl_z 0 v=max((-v(rwl_1_idl_z)*i(vrwl1_idl_z)),0)
bpr_vrwl1_idl_z pr_vrwl1_idl_z 0 v=max(-(-v(rwl_1_idl_z)*i(vrwl1_idl_z)),0)
bpn_vrwl2_idl_z pn_vrwl2_idl_z 0 v=(-v(rwl_2_idl_z)*i(vrwl2_idl_z))
bpg_vrwl2_idl_z pg_vrwl2_idl_z 0 v=max((-v(rwl_2_idl_z)*i(vrwl2_idl_z)),0)
bpr_vrwl2_idl_z pr_vrwl2_idl_z 0 v=max(-(-v(rwl_2_idl_z)*i(vrwl2_idl_z)),0)
bpn_vrwl3_idl_z pn_vrwl3_idl_z 0 v=(-v(rwl_3_idl_z)*i(vrwl3_idl_z))
bpg_vrwl3_idl_z pg_vrwl3_idl_z 0 v=max((-v(rwl_3_idl_z)*i(vrwl3_idl_z)),0)
bpr_vrwl3_idl_z pr_vrwl3_idl_z 0 v=max(-(-v(rwl_3_idl_z)*i(vrwl3_idl_z)),0)
bpn_vwwl0_idl_z pn_vwwl0_idl_z 0 v=(-v(wl_0_idl_z)*i(vwwl0_idl_z))
bpg_vwwl0_idl_z pg_vwwl0_idl_z 0 v=max((-v(wl_0_idl_z)*i(vwwl0_idl_z)),0)
bpr_vwwl0_idl_z pr_vwwl0_idl_z 0 v=max(-(-v(wl_0_idl_z)*i(vwwl0_idl_z)),0)
bpn_vwwl1_idl_z pn_vwwl1_idl_z 0 v=(-v(wl_1_idl_z)*i(vwwl1_idl_z))
bpg_vwwl1_idl_z pg_vwwl1_idl_z 0 v=max((-v(wl_1_idl_z)*i(vwwl1_idl_z)),0)
bpr_vwwl1_idl_z pr_vwwl1_idl_z 0 v=max(-(-v(wl_1_idl_z)*i(vwwl1_idl_z)),0)
bpn_vwwl2_idl_z pn_vwwl2_idl_z 0 v=(-v(wl_2_idl_z)*i(vwwl2_idl_z))
bpg_vwwl2_idl_z pg_vwwl2_idl_z 0 v=max((-v(wl_2_idl_z)*i(vwwl2_idl_z)),0)
bpr_vwwl2_idl_z pr_vwwl2_idl_z 0 v=max(-(-v(wl_2_idl_z)*i(vwwl2_idl_z)),0)
bpn_vwwl3_idl_z pn_vwwl3_idl_z 0 v=(-v(wl_3_idl_z)*i(vwwl3_idl_z))
bpg_vwwl3_idl_z pg_vwwl3_idl_z 0 v=max((-v(wl_3_idl_z)*i(vwwl3_idl_z)),0)
bpr_vwwl3_idl_z pr_vwwl3_idl_z 0 v=max(-(-v(wl_3_idl_z)*i(vwwl3_idl_z)),0)
bpn_vbody_idl_z pn_vbody_idl_z 0 v=(-v(gnd_idl_z)*i(vbody_idl_z))
bpg_vbody_idl_z pg_vbody_idl_z 0 v=max((-v(gnd_idl_z)*i(vbody_idl_z)),0)
bpr_vbody_idl_z pr_vbody_idl_z 0 v=max(-(-v(gnd_idl_z)*i(vbody_idl_z)),0)
bpn_vsub_idl_z pn_vsub_idl_z 0 v=(-v(vsubs_idl_z)*i(vsub_idl_z))
bpg_vsub_idl_z pg_vsub_idl_z 0 v=max((-v(vsubs_idl_z)*i(vsub_idl_z)),0)
bpr_vsub_idl_z pr_vsub_idl_z 0 v=max(-(-v(vsubs_idl_z)*i(vsub_idl_z)),0)

* ---- instance idl_o: mode idle, pattern one ----
xm1_idl_o sn_0_0__t0_idl_o wl_0__t3_idl_o bl_0__t0_idl_o gnd__t0_idl_o sky130_fd_pr__nfet_01v8 L=0.15 W=0.42 nf=1 ad=0.1974 as=0.1974 pd=1.78 ps=1.78 mult=1 m=1
xm2_idl_o rbl_0__t0_idl_o sn_0_0__t1_idl_o rwl_0__t0_idl_o gnd__t1_idl_o sky130_fd_pr__nfet_01v8 L=0.15 W=0.42 nf=1 ad=0.1974 as=0.1974 pd=1.78 ps=1.78 mult=1 m=1
xm3_idl_o sn_0_1__t1_idl_o wl_0__t0_idl_o bl_1__t0_idl_o gnd__t2_idl_o sky130_fd_pr__nfet_01v8 L=0.15 W=0.42 nf=1 ad=0.1974 as=0.1974 pd=1.78 ps=1.78 mult=1 m=1
xm4_idl_o rbl_1__t0_idl_o sn_0_1__t0_idl_o rwl_0__t1_idl_o gnd__t3_idl_o sky130_fd_pr__nfet_01v8 L=0.15 W=0.42 nf=1 ad=0.1974 as=0.1974 pd=1.78 ps=1.78 mult=1 m=1
xm5_idl_o sn_0_2__t1_idl_o wl_0__t1_idl_o bl_2__t0_idl_o gnd__t4_idl_o sky130_fd_pr__nfet_01v8 L=0.15 W=0.42 nf=1 ad=0.1974 as=0.1974 pd=1.78 ps=1.78 mult=1 m=1
xm6_idl_o rbl_2__t0_idl_o sn_0_2__t0_idl_o rwl_0__t2_idl_o gnd__t5_idl_o sky130_fd_pr__nfet_01v8 L=0.15 W=0.42 nf=1 ad=0.1974 as=0.1974 pd=1.78 ps=1.78 mult=1 m=1
xm7_idl_o sn_0_3__t1_idl_o wl_0__t2_idl_o bl_3__t0_idl_o gnd__t6_idl_o sky130_fd_pr__nfet_01v8 L=0.15 W=0.42 nf=1 ad=0.1974 as=0.1974 pd=1.78 ps=1.78 mult=1 m=1
xm8_idl_o rbl_3__t0_idl_o sn_0_3__t0_idl_o rwl_0__t3_idl_o gnd__t7_idl_o sky130_fd_pr__nfet_01v8 L=0.15 W=0.42 nf=1 ad=0.1974 as=0.1974 pd=1.78 ps=1.78 mult=1 m=1
xm9_idl_o sn_1_0__t1_idl_o wl_1__t0_idl_o bl_0__t1_idl_o gnd__t8_idl_o sky130_fd_pr__nfet_01v8 L=0.15 W=0.42 nf=1 ad=0.1974 as=0.1974 pd=1.78 ps=1.78 mult=1 m=1
xm10_idl_o rbl_0__t1_idl_o sn_1_0__t0_idl_o rwl_1__t0_idl_o gnd__t9_idl_o sky130_fd_pr__nfet_01v8 L=0.15 W=0.42 nf=1 ad=0.1974 as=0.1974 pd=1.78 ps=1.78 mult=1 m=1
xm11_idl_o sn_1_1__t1_idl_o wl_1__t1_idl_o bl_1__t1_idl_o gnd__t10_idl_o sky130_fd_pr__nfet_01v8 L=0.15 W=0.42 nf=1 ad=0.1974 as=0.1974 pd=1.78 ps=1.78 mult=1 m=1
xm12_idl_o rbl_1__t1_idl_o sn_1_1__t0_idl_o rwl_1__t1_idl_o gnd__t11_idl_o sky130_fd_pr__nfet_01v8 L=0.15 W=0.42 nf=1 ad=0.1974 as=0.1974 pd=1.78 ps=1.78 mult=1 m=1
xm13_idl_o sn_1_2__t1_idl_o wl_1__t2_idl_o bl_2__t1_idl_o gnd__t12_idl_o sky130_fd_pr__nfet_01v8 L=0.15 W=0.42 nf=1 ad=0.1974 as=0.1974 pd=1.78 ps=1.78 mult=1 m=1
xm14_idl_o rbl_2__t1_idl_o sn_1_2__t0_idl_o rwl_1__t2_idl_o gnd__t13_idl_o sky130_fd_pr__nfet_01v8 L=0.15 W=0.42 nf=1 ad=0.1974 as=0.1974 pd=1.78 ps=1.78 mult=1 m=1
xm15_idl_o sn_1_3__t1_idl_o wl_1__t3_idl_o bl_3__t1_idl_o gnd__t14_idl_o sky130_fd_pr__nfet_01v8 L=0.15 W=0.42 nf=1 ad=0.1974 as=0.1974 pd=1.78 ps=1.78 mult=1 m=1
xm16_idl_o rbl_3__t1_idl_o sn_1_3__t0_idl_o rwl_1__t3_idl_o gnd__t15_idl_o sky130_fd_pr__nfet_01v8 L=0.15 W=0.42 nf=1 ad=0.1974 as=0.1974 pd=1.78 ps=1.78 mult=1 m=1
xm17_idl_o sn_2_0__t1_idl_o wl_2__t3_idl_o bl_0__t3_idl_o gnd__t16_idl_o sky130_fd_pr__nfet_01v8 L=0.15 W=0.42 nf=1 ad=0.1974 as=0.1974 pd=1.78 ps=1.78 mult=1 m=1
xm18_idl_o rbl_0__t2_idl_o sn_2_0__t0_idl_o rwl_2__t0_idl_o gnd__t17_idl_o sky130_fd_pr__nfet_01v8 L=0.15 W=0.42 nf=1 ad=0.1974 as=0.1974 pd=1.78 ps=1.78 mult=1 m=1
xm19_idl_o sn_2_1__t1_idl_o wl_2__t0_idl_o bl_1__t2_idl_o gnd__t18_idl_o sky130_fd_pr__nfet_01v8 L=0.15 W=0.42 nf=1 ad=0.1974 as=0.1974 pd=1.78 ps=1.78 mult=1 m=1
xm20_idl_o rbl_1__t2_idl_o sn_2_1__t0_idl_o rwl_2__t1_idl_o gnd__t19_idl_o sky130_fd_pr__nfet_01v8 L=0.15 W=0.42 nf=1 ad=0.1974 as=0.1974 pd=1.78 ps=1.78 mult=1 m=1
xm21_idl_o sn_2_2__t1_idl_o wl_2__t1_idl_o bl_2__t2_idl_o gnd__t20_idl_o sky130_fd_pr__nfet_01v8 L=0.15 W=0.42 nf=1 ad=0.1974 as=0.1974 pd=1.78 ps=1.78 mult=1 m=1
xm22_idl_o rbl_2__t2_idl_o sn_2_2__t0_idl_o rwl_2__t2_idl_o gnd__t21_idl_o sky130_fd_pr__nfet_01v8 L=0.15 W=0.42 nf=1 ad=0.1974 as=0.1974 pd=1.78 ps=1.78 mult=1 m=1
xm23_idl_o sn_2_3__t1_idl_o wl_2__t2_idl_o bl_3__t2_idl_o gnd__t22_idl_o sky130_fd_pr__nfet_01v8 L=0.15 W=0.42 nf=1 ad=0.1974 as=0.1974 pd=1.78 ps=1.78 mult=1 m=1
xm24_idl_o rbl_3__t2_idl_o sn_2_3__t0_idl_o rwl_2__t3_idl_o gnd__t23_idl_o sky130_fd_pr__nfet_01v8 L=0.15 W=0.42 nf=1 ad=0.1974 as=0.1974 pd=1.78 ps=1.78 mult=1 m=1
xm25_idl_o sn_3_0__t1_idl_o wl_3__t0_idl_o bl_0__t2_idl_o gnd__t24_idl_o sky130_fd_pr__nfet_01v8 L=0.15 W=0.42 nf=1 ad=0.1974 as=0.1974 pd=1.78 ps=1.78 mult=1 m=1
xm26_idl_o rbl_0__t3_idl_o sn_3_0__t0_idl_o rwl_3__t0_idl_o gnd__t25_idl_o sky130_fd_pr__nfet_01v8 L=0.15 W=0.42 nf=1 ad=0.1974 as=0.1974 pd=1.78 ps=1.78 mult=1 m=1
xm27_idl_o sn_3_1__t1_idl_o wl_3__t1_idl_o bl_1__t3_idl_o gnd__t26_idl_o sky130_fd_pr__nfet_01v8 L=0.15 W=0.42 nf=1 ad=0.1974 as=0.1974 pd=1.78 ps=1.78 mult=1 m=1
xm28_idl_o rbl_1__t3_idl_o sn_3_1__t0_idl_o rwl_3__t1_idl_o gnd__t27_idl_o sky130_fd_pr__nfet_01v8 L=0.15 W=0.42 nf=1 ad=0.1974 as=0.1974 pd=1.78 ps=1.78 mult=1 m=1
xm29_idl_o sn_3_2__t1_idl_o wl_3__t2_idl_o bl_2__t3_idl_o gnd__t28_idl_o sky130_fd_pr__nfet_01v8 L=0.15 W=0.42 nf=1 ad=0.1974 as=0.1974 pd=1.78 ps=1.78 mult=1 m=1
xm30_idl_o rbl_2__t3_idl_o sn_3_2__t0_idl_o rwl_3__t2_idl_o gnd__t29_idl_o sky130_fd_pr__nfet_01v8 L=0.15 W=0.42 nf=1 ad=0.1974 as=0.1974 pd=1.78 ps=1.78 mult=1 m=1
xm31_idl_o sn_3_3__t1_idl_o wl_3__t3_idl_o bl_3__t3_idl_o gnd__t30_idl_o sky130_fd_pr__nfet_01v8 L=0.15 W=0.42 nf=1 ad=0.1974 as=0.1974 pd=1.78 ps=1.78 mult=1 m=1
xm32_idl_o rbl_3__t3_idl_o sn_3_3__t0_idl_o rwl_3__t3_idl_o gnd__t31_idl_o sky130_fd_pr__nfet_01v8 L=0.15 W=0.42 nf=1 ad=0.1974 as=0.1974 pd=1.78 ps=1.78 mult=1 m=1
rgnd_t0_idl_o gnd__t0_idl_o gnd_idl_o 63.3529
rgnd_t1_idl_o gnd__t1_idl_o gnd_idl_o 49.0465
rgnd_t2_idl_o gnd__t2_idl_o gnd_idl_o 36.5177
rgnd_t3_idl_o gnd__t3_idl_o gnd_idl_o 28.2406
rgnd_t4_idl_o gnd__t4_idl_o gnd_idl_o 28.2406
rgnd_t5_idl_o gnd__t5_idl_o gnd_idl_o 36.5177
rgnd_t6_idl_o gnd__t6_idl_o gnd_idl_o 49.0465
rgnd_t7_idl_o gnd__t7_idl_o gnd_idl_o 63.3529
rgnd_t8_idl_o gnd__t8_idl_o gnd_idl_o 58.0019
rgnd_t9_idl_o gnd__t9_idl_o gnd_idl_o 41.907
rgnd_t10_idl_o gnd__t10_idl_o gnd_idl_o 26.1568
rgnd_t11_idl_o gnd__t11_idl_o gnd_idl_o 12.1726
rgnd_t12_idl_o gnd__t12_idl_o gnd_idl_o 12.1726
rgnd_t13_idl_o gnd__t13_idl_o gnd_idl_o 26.1568
rgnd_t14_idl_o gnd__t14_idl_o gnd_idl_o 41.907
rgnd_t15_idl_o gnd__t15_idl_o gnd_idl_o 58.0019
rgnd_t16_idl_o gnd__t16_idl_o gnd_idl_o 58.0019
rgnd_t17_idl_o gnd__t17_idl_o gnd_idl_o 41.907
rgnd_t18_idl_o gnd__t18_idl_o gnd_idl_o 26.1568
rgnd_t19_idl_o gnd__t19_idl_o gnd_idl_o 12.1726
rgnd_t20_idl_o gnd__t20_idl_o gnd_idl_o 12.1726
rgnd_t21_idl_o gnd__t21_idl_o gnd_idl_o 26.1568
rgnd_t22_idl_o gnd__t22_idl_o gnd_idl_o 41.907
rgnd_t23_idl_o gnd__t23_idl_o gnd_idl_o 58.0019
rgnd_t24_idl_o gnd__t24_idl_o gnd_idl_o 63.3529
rgnd_t25_idl_o gnd__t25_idl_o gnd_idl_o 49.0465
rgnd_t26_idl_o gnd__t26_idl_o gnd_idl_o 36.5177
rgnd_t27_idl_o gnd__t27_idl_o gnd_idl_o 28.2406
rgnd_t28_idl_o gnd__t28_idl_o gnd_idl_o 28.2406
rgnd_t29_idl_o gnd__t29_idl_o gnd_idl_o 36.5177
rgnd_t30_idl_o gnd__t30_idl_o gnd_idl_o 49.0465
rgnd_t31_idl_o gnd__t31_idl_o gnd_idl_o 63.3529
rbl_0_t0_idl_o bl_0__t0_idl_o bl_0_idl_o 144.555
rbl_0_t1_idl_o bl_0__t1_idl_o bl_0_idl_o 48.1851
rbl_0_t2_idl_o bl_0__t2_idl_o bl_0_idl_o 144.555
rbl_0_t3_idl_o bl_0__t3_idl_o bl_0_idl_o 48.1851
rbl_1_t0_idl_o bl_1__t0_idl_o bl_1_idl_o 144.555
rbl_1_t1_idl_o bl_1__t1_idl_o bl_1_idl_o 48.1851
rbl_1_t2_idl_o bl_1__t2_idl_o bl_1_idl_o 48.1851
rbl_1_t3_idl_o bl_1__t3_idl_o bl_1_idl_o 144.555
rbl_2_t0_idl_o bl_2__t0_idl_o bl_2_idl_o 144.555
rbl_2_t1_idl_o bl_2__t1_idl_o bl_2_idl_o 48.1851
rbl_2_t2_idl_o bl_2__t2_idl_o bl_2_idl_o 48.1851
rbl_2_t3_idl_o bl_2__t3_idl_o bl_2_idl_o 144.555
rbl_3_t0_idl_o bl_3__t0_idl_o bl_3_idl_o 144.555
rbl_3_t1_idl_o bl_3__t1_idl_o bl_3_idl_o 48.1851
rbl_3_t2_idl_o bl_3__t2_idl_o bl_3_idl_o 48.1851
rbl_3_t3_idl_o bl_3__t3_idl_o bl_3_idl_o 144.555
rrbl_0_t0_idl_o rbl_0__t0_idl_o rbl_0_idl_o 144.555
rrbl_0_t1_idl_o rbl_0__t1_idl_o rbl_0_idl_o 48.1851
rrbl_0_t2_idl_o rbl_0__t2_idl_o rbl_0_idl_o 48.1851
rrbl_0_t3_idl_o rbl_0__t3_idl_o rbl_0_idl_o 144.555
rrbl_1_t0_idl_o rbl_1__t0_idl_o rbl_1_idl_o 144.555
rrbl_1_t1_idl_o rbl_1__t1_idl_o rbl_1_idl_o 48.1851
rrbl_1_t2_idl_o rbl_1__t2_idl_o rbl_1_idl_o 48.1851
rrbl_1_t3_idl_o rbl_1__t3_idl_o rbl_1_idl_o 144.555
rrbl_2_t0_idl_o rbl_2__t0_idl_o rbl_2_idl_o 144.555
rrbl_2_t1_idl_o rbl_2__t1_idl_o rbl_2_idl_o 48.1851
rrbl_2_t2_idl_o rbl_2__t2_idl_o rbl_2_idl_o 48.1851
rrbl_2_t3_idl_o rbl_2__t3_idl_o rbl_2_idl_o 144.555
rrbl_3_t0_idl_o rbl_3__t0_idl_o rbl_3_idl_o 144.555
rrbl_3_t1_idl_o rbl_3__t1_idl_o rbl_3_idl_o 48.1851
rrbl_3_t2_idl_o rbl_3__t2_idl_o rbl_3_idl_o 48.1851
rrbl_3_t3_idl_o rbl_3__t3_idl_o rbl_3_idl_o 144.555
rrwl_0_t0_idl_o rwl_0__t0_idl_o rwl_0_idl_o 21.6897
rrwl_0_t1_idl_o rwl_0__t1_idl_o rwl_0_idl_o 7.22989
rrwl_0_t2_idl_o rwl_0__t2_idl_o rwl_0_idl_o 7.22989
rrwl_0_t3_idl_o rwl_0__t3_idl_o rwl_0_idl_o 21.6897
rrwl_1_t0_idl_o rwl_1__t0_idl_o rwl_1_idl_o 21.6897
rrwl_1_t1_idl_o rwl_1__t1_idl_o rwl_1_idl_o 7.22989
rrwl_1_t2_idl_o rwl_1__t2_idl_o rwl_1_idl_o 7.22989
rrwl_1_t3_idl_o rwl_1__t3_idl_o rwl_1_idl_o 21.6897
rrwl_2_t0_idl_o rwl_2__t0_idl_o rwl_2_idl_o 21.6897
rrwl_2_t1_idl_o rwl_2__t1_idl_o rwl_2_idl_o 7.22989
rrwl_2_t2_idl_o rwl_2__t2_idl_o rwl_2_idl_o 7.22989
rrwl_2_t3_idl_o rwl_2__t3_idl_o rwl_2_idl_o 21.6897
rrwl_3_t0_idl_o rwl_3__t0_idl_o rwl_3_idl_o 21.6897
rrwl_3_t1_idl_o rwl_3__t1_idl_o rwl_3_idl_o 7.22989
rrwl_3_t2_idl_o rwl_3__t2_idl_o rwl_3_idl_o 7.22989
rrwl_3_t3_idl_o rwl_3__t3_idl_o rwl_3_idl_o 21.6897
rsn_0_0_t0_idl_o sn_0_0__t0_idl_o sn_0_0_idl_o 125.123
rsn_0_0_t1_idl_o sn_0_0__t1_idl_o sn_0_0_idl_o 125.123
rsn_0_1_t0_idl_o sn_0_1__t0_idl_o sn_0_1_idl_o 125.123
rsn_0_1_t1_idl_o sn_0_1__t1_idl_o sn_0_1_idl_o 125.123
rsn_0_2_t0_idl_o sn_0_2__t0_idl_o sn_0_2_idl_o 125.123
rsn_0_2_t1_idl_o sn_0_2__t1_idl_o sn_0_2_idl_o 125.123
rsn_0_3_t0_idl_o sn_0_3__t0_idl_o sn_0_3_idl_o 125.123
rsn_0_3_t1_idl_o sn_0_3__t1_idl_o sn_0_3_idl_o 125.123
rsn_1_0_t0_idl_o sn_1_0__t0_idl_o sn_1_0_idl_o 125.123
rsn_1_0_t1_idl_o sn_1_0__t1_idl_o sn_1_0_idl_o 125.123
rsn_1_1_t0_idl_o sn_1_1__t0_idl_o sn_1_1_idl_o 125.123
rsn_1_1_t1_idl_o sn_1_1__t1_idl_o sn_1_1_idl_o 125.123
rsn_1_2_t0_idl_o sn_1_2__t0_idl_o sn_1_2_idl_o 125.123
rsn_1_2_t1_idl_o sn_1_2__t1_idl_o sn_1_2_idl_o 125.123
rsn_1_3_t0_idl_o sn_1_3__t0_idl_o sn_1_3_idl_o 125.123
rsn_1_3_t1_idl_o sn_1_3__t1_idl_o sn_1_3_idl_o 125.123
rsn_2_0_t0_idl_o sn_2_0__t0_idl_o sn_2_0_idl_o 125.123
rsn_2_0_t1_idl_o sn_2_0__t1_idl_o sn_2_0_idl_o 125.123
rsn_2_1_t0_idl_o sn_2_1__t0_idl_o sn_2_1_idl_o 125.123
rsn_2_1_t1_idl_o sn_2_1__t1_idl_o sn_2_1_idl_o 125.123
rsn_2_2_t0_idl_o sn_2_2__t0_idl_o sn_2_2_idl_o 125.123
rsn_2_2_t1_idl_o sn_2_2__t1_idl_o sn_2_2_idl_o 125.123
rsn_2_3_t0_idl_o sn_2_3__t0_idl_o sn_2_3_idl_o 125.123
rsn_2_3_t1_idl_o sn_2_3__t1_idl_o sn_2_3_idl_o 125.123
rsn_3_0_t0_idl_o sn_3_0__t0_idl_o sn_3_0_idl_o 125.123
rsn_3_0_t1_idl_o sn_3_0__t1_idl_o sn_3_0_idl_o 125.123
rsn_3_1_t0_idl_o sn_3_1__t0_idl_o sn_3_1_idl_o 125.123
rsn_3_1_t1_idl_o sn_3_1__t1_idl_o sn_3_1_idl_o 125.123
rsn_3_2_t0_idl_o sn_3_2__t0_idl_o sn_3_2_idl_o 125.123
rsn_3_2_t1_idl_o sn_3_2__t1_idl_o sn_3_2_idl_o 125.123
rsn_3_3_t0_idl_o sn_3_3__t0_idl_o sn_3_3_idl_o 125.123
rsn_3_3_t1_idl_o sn_3_3__t1_idl_o sn_3_3_idl_o 125.123
rwl_0_t0_idl_o wl_0__t0_idl_o wl_0_idl_o 54.2844
rwl_0_t1_idl_o wl_0__t1_idl_o wl_0_idl_o 54.2844
rwl_0_t2_idl_o wl_0__t2_idl_o wl_0_idl_o 162.853
rwl_0_t3_idl_o wl_0__t3_idl_o wl_0_idl_o 162.853
rwl_1_t0_idl_o wl_1__t0_idl_o wl_1_idl_o 162.853
rwl_1_t1_idl_o wl_1__t1_idl_o wl_1_idl_o 54.2844
rwl_1_t2_idl_o wl_1__t2_idl_o wl_1_idl_o 54.2844
rwl_1_t3_idl_o wl_1__t3_idl_o wl_1_idl_o 162.853
rwl_2_t0_idl_o wl_2__t0_idl_o wl_2_idl_o 54.2844
rwl_2_t1_idl_o wl_2__t1_idl_o wl_2_idl_o 54.2844
rwl_2_t2_idl_o wl_2__t2_idl_o wl_2_idl_o 162.853
rwl_2_t3_idl_o wl_2__t3_idl_o wl_2_idl_o 162.853
rwl_3_t0_idl_o wl_3__t0_idl_o wl_3_idl_o 162.853
rwl_3_t1_idl_o wl_3__t1_idl_o wl_3_idl_o 54.2844
rwl_3_t2_idl_o wl_3__t2_idl_o wl_3_idl_o 54.2844
rwl_3_t3_idl_o wl_3__t3_idl_o wl_3_idl_o 162.853
cgnd_idl_o gnd_idl_o vsubs_idl_o 4.09475e-15
cbl_0_idl_o bl_0_idl_o vsubs_idl_o 5.96076e-16
cbl_1_idl_o bl_1_idl_o vsubs_idl_o 5.81168e-16
cbl_2_idl_o bl_2_idl_o vsubs_idl_o 5.81168e-16
cbl_3_idl_o bl_3_idl_o vsubs_idl_o 5.81168e-16
crbl_0_idl_o rbl_0_idl_o vsubs_idl_o 5.81168e-16
crbl_1_idl_o rbl_1_idl_o vsubs_idl_o 5.81168e-16
crbl_2_idl_o rbl_2_idl_o vsubs_idl_o 5.81168e-16
crbl_3_idl_o rbl_3_idl_o vsubs_idl_o 5.96076e-16
crwl_0_idl_o rwl_0_idl_o vsubs_idl_o 1.18713e-15
crwl_1_idl_o rwl_1_idl_o vsubs_idl_o 1.18713e-15
crwl_2_idl_o rwl_2_idl_o vsubs_idl_o 1.18713e-15
crwl_3_idl_o rwl_3_idl_o vsubs_idl_o 1.18713e-15
csn_0_0_idl_o sn_0_0_idl_o vsubs_idl_o 4.33689e-16
csn_0_1_idl_o sn_0_1_idl_o vsubs_idl_o 4.30576e-16
csn_0_2_idl_o sn_0_2_idl_o vsubs_idl_o 4.30576e-16
csn_0_3_idl_o sn_0_3_idl_o vsubs_idl_o 4.32518e-16
csn_1_0_idl_o sn_1_0_idl_o vsubs_idl_o 4.33689e-16
csn_1_1_idl_o sn_1_1_idl_o vsubs_idl_o 4.30576e-16
csn_1_2_idl_o sn_1_2_idl_o vsubs_idl_o 4.30576e-16
csn_1_3_idl_o sn_1_3_idl_o vsubs_idl_o 4.32518e-16
csn_2_0_idl_o sn_2_0_idl_o vsubs_idl_o 4.33689e-16
csn_2_1_idl_o sn_2_1_idl_o vsubs_idl_o 4.30576e-16
csn_2_2_idl_o sn_2_2_idl_o vsubs_idl_o 4.30576e-16
csn_2_3_idl_o sn_2_3_idl_o vsubs_idl_o 4.32518e-16
csn_3_0_idl_o sn_3_0_idl_o vsubs_idl_o 4.33689e-16
csn_3_1_idl_o sn_3_1_idl_o vsubs_idl_o 4.30576e-16
csn_3_2_idl_o sn_3_2_idl_o vsubs_idl_o 4.30576e-16
csn_3_3_idl_o sn_3_3_idl_o vsubs_idl_o 4.32518e-16
cwl_0_idl_o wl_0_idl_o vsubs_idl_o 1.90928e-15
cwl_1_idl_o wl_1_idl_o vsubs_idl_o 1.90928e-15
cwl_2_idl_o wl_2_idl_o vsubs_idl_o 1.90928e-15
cwl_3_idl_o wl_3_idl_o vsubs_idl_o 1.91375e-15
ccc_bl_0_sn_0_0_idl_o bl_0_idl_o sn_0_0_idl_o 1.071e-17
ccc_bl_0_sn_1_0_idl_o bl_0_idl_o sn_1_0_idl_o 1.071e-17
ccc_bl_0_sn_2_0_idl_o bl_0_idl_o sn_2_0_idl_o 1.071e-17
ccc_bl_0_sn_3_0_idl_o bl_0_idl_o sn_3_0_idl_o 1.071e-17
ccc_bl_0_wl_0_idl_o bl_0_idl_o wl_0_idl_o 2.4327e-17
ccc_bl_0_wl_1_idl_o bl_0_idl_o wl_1_idl_o 2.4327e-17
ccc_bl_0_wl_2_idl_o bl_0_idl_o wl_2_idl_o 2.4327e-17
ccc_bl_1_rbl_0_idl_o bl_1_idl_o rbl_0_idl_o 1.29795e-16
ccc_bl_1_rwl_0_idl_o bl_1_idl_o rwl_0_idl_o 9.028e-18
ccc_bl_1_rwl_1_idl_o bl_1_idl_o rwl_1_idl_o 9.028e-18
ccc_bl_1_rwl_2_idl_o bl_1_idl_o rwl_2_idl_o 9.028e-18
ccc_bl_1_rwl_3_idl_o bl_1_idl_o rwl_3_idl_o 9.028e-18
ccc_bl_1_sn_0_1_idl_o bl_1_idl_o sn_0_1_idl_o 1.071e-17
ccc_bl_1_sn_1_1_idl_o bl_1_idl_o sn_1_1_idl_o 1.071e-17
ccc_bl_1_sn_2_1_idl_o bl_1_idl_o sn_2_1_idl_o 1.071e-17
ccc_bl_1_sn_3_1_idl_o bl_1_idl_o sn_3_1_idl_o 1.071e-17
ccc_bl_1_wl_0_idl_o bl_1_idl_o wl_0_idl_o 2.7627e-17
ccc_bl_1_wl_1_idl_o bl_1_idl_o wl_1_idl_o 2.7627e-17
ccc_bl_1_wl_2_idl_o bl_1_idl_o wl_2_idl_o 2.7627e-17
ccc_bl_2_rbl_1_idl_o bl_2_idl_o rbl_1_idl_o 1.29795e-16
ccc_bl_2_rwl_0_idl_o bl_2_idl_o rwl_0_idl_o 9.028e-18
ccc_bl_2_rwl_1_idl_o bl_2_idl_o rwl_1_idl_o 9.028e-18
ccc_bl_2_rwl_2_idl_o bl_2_idl_o rwl_2_idl_o 9.028e-18
ccc_bl_2_rwl_3_idl_o bl_2_idl_o rwl_3_idl_o 9.028e-18
ccc_bl_2_sn_0_2_idl_o bl_2_idl_o sn_0_2_idl_o 1.071e-17
ccc_bl_2_sn_1_2_idl_o bl_2_idl_o sn_1_2_idl_o 1.071e-17
ccc_bl_2_sn_2_2_idl_o bl_2_idl_o sn_2_2_idl_o 1.071e-17
ccc_bl_2_sn_3_2_idl_o bl_2_idl_o sn_3_2_idl_o 1.071e-17
ccc_bl_2_wl_0_idl_o bl_2_idl_o wl_0_idl_o 2.7627e-17
ccc_bl_2_wl_1_idl_o bl_2_idl_o wl_1_idl_o 2.7627e-17
ccc_bl_2_wl_2_idl_o bl_2_idl_o wl_2_idl_o 2.7627e-17
ccc_bl_3_rbl_2_idl_o bl_3_idl_o rbl_2_idl_o 1.29795e-16
ccc_bl_3_rwl_0_idl_o bl_3_idl_o rwl_0_idl_o 9.028e-18
ccc_bl_3_rwl_1_idl_o bl_3_idl_o rwl_1_idl_o 9.028e-18
ccc_bl_3_rwl_2_idl_o bl_3_idl_o rwl_2_idl_o 9.028e-18
ccc_bl_3_rwl_3_idl_o bl_3_idl_o rwl_3_idl_o 9.028e-18
ccc_bl_3_sn_0_3_idl_o bl_3_idl_o sn_0_3_idl_o 1.071e-17
ccc_bl_3_sn_1_3_idl_o bl_3_idl_o sn_1_3_idl_o 1.071e-17
ccc_bl_3_sn_2_3_idl_o bl_3_idl_o sn_2_3_idl_o 1.071e-17
ccc_bl_3_sn_3_3_idl_o bl_3_idl_o sn_3_3_idl_o 1.071e-17
ccc_bl_3_wl_0_idl_o bl_3_idl_o wl_0_idl_o 2.7627e-17
ccc_bl_3_wl_1_idl_o bl_3_idl_o wl_1_idl_o 2.7627e-17
ccc_bl_3_wl_2_idl_o bl_3_idl_o wl_2_idl_o 2.7627e-17
ccc_rbl_0_rwl_0_idl_o rbl_0_idl_o rwl_0_idl_o 1.9738e-17
ccc_rbl_0_rwl_1_idl_o rbl_0_idl_o rwl_1_idl_o 1.9738e-17
ccc_rbl_0_rwl_2_idl_o rbl_0_idl_o rwl_2_idl_o 1.9738e-17
ccc_rbl_0_rwl_3_idl_o rbl_0_idl_o rwl_3_idl_o 1.9738e-17
ccc_rbl_0_sn_0_0_idl_o rbl_0_idl_o sn_0_0_idl_o 1.071e-17
ccc_rbl_0_sn_1_0_idl_o rbl_0_idl_o sn_1_0_idl_o 2.4327e-17
ccc_rbl_0_sn_2_0_idl_o rbl_0_idl_o sn_2_0_idl_o 2.4327e-17
ccc_rbl_0_wl_0_idl_o rbl_0_idl_o wl_0_idl_o 3.3e-18
ccc_rbl_0_wl_1_idl_o rbl_0_idl_o wl_1_idl_o 3.3e-18
ccc_rbl_0_wl_2_idl_o rbl_0_idl_o wl_2_idl_o 3.3e-18
ccc_rbl_1_rwl_0_idl_o rbl_1_idl_o rwl_0_idl_o 1.9738e-17
ccc_rbl_1_rwl_1_idl_o rbl_1_idl_o rwl_1_idl_o 1.9738e-17
ccc_rbl_1_rwl_2_idl_o rbl_1_idl_o rwl_2_idl_o 1.9738e-17
ccc_rbl_1_rwl_3_idl_o rbl_1_idl_o rwl_3_idl_o 1.9738e-17
ccc_rbl_1_sn_0_1_idl_o rbl_1_idl_o sn_0_1_idl_o 1.071e-17
ccc_rbl_1_sn_1_1_idl_o rbl_1_idl_o sn_1_1_idl_o 2.4327e-17
ccc_rbl_1_sn_2_1_idl_o rbl_1_idl_o sn_2_1_idl_o 2.4327e-17
ccc_rbl_1_wl_0_idl_o rbl_1_idl_o wl_0_idl_o 3.3e-18
ccc_rbl_1_wl_1_idl_o rbl_1_idl_o wl_1_idl_o 3.3e-18
ccc_rbl_1_wl_2_idl_o rbl_1_idl_o wl_2_idl_o 3.3e-18
ccc_rbl_2_rwl_0_idl_o rbl_2_idl_o rwl_0_idl_o 1.9738e-17
ccc_rbl_2_rwl_1_idl_o rbl_2_idl_o rwl_1_idl_o 1.9738e-17
ccc_rbl_2_rwl_2_idl_o rbl_2_idl_o rwl_2_idl_o 1.9738e-17
ccc_rbl_2_rwl_3_idl_o rbl_2_idl_o rwl_3_idl_o 1.9738e-17
ccc_rbl_2_sn_0_2_idl_o rbl_2_idl_o sn_0_2_idl_o 1.071e-17
ccc_rbl_2_sn_1_2_idl_o rbl_2_idl_o sn_1_2_idl_o 2.4327e-17
ccc_rbl_2_sn_2_2_idl_o rbl_2_idl_o sn_2_2_idl_o 2.4327e-17
ccc_rbl_2_wl_0_idl_o rbl_2_idl_o wl_0_idl_o 3.3e-18
ccc_rbl_2_wl_1_idl_o rbl_2_idl_o wl_1_idl_o 3.3e-18
ccc_rbl_2_wl_2_idl_o rbl_2_idl_o wl_2_idl_o 3.3e-18
ccc_rbl_3_rwl_0_idl_o rbl_3_idl_o rwl_0_idl_o 1.071e-17
ccc_rbl_3_rwl_1_idl_o rbl_3_idl_o rwl_1_idl_o 1.071e-17
ccc_rbl_3_rwl_2_idl_o rbl_3_idl_o rwl_2_idl_o 1.071e-17
ccc_rbl_3_rwl_3_idl_o rbl_3_idl_o rwl_3_idl_o 1.071e-17
ccc_rbl_3_sn_0_3_idl_o rbl_3_idl_o sn_0_3_idl_o 1.071e-17
ccc_rbl_3_sn_1_3_idl_o rbl_3_idl_o sn_1_3_idl_o 2.4327e-17
ccc_rbl_3_sn_2_3_idl_o rbl_3_idl_o sn_2_3_idl_o 2.4327e-17
ccc_rwl_0_sn_0_0_idl_o rwl_0_idl_o sn_0_0_idl_o 1.0072e-17
ccc_rwl_0_sn_0_1_idl_o rwl_0_idl_o sn_0_1_idl_o 1.9682e-17
ccc_rwl_0_sn_0_2_idl_o rwl_0_idl_o sn_0_2_idl_o 1.9682e-17
ccc_rwl_0_sn_0_3_idl_o rwl_0_idl_o sn_0_3_idl_o 1.9682e-17
ccc_rwl_1_sn_1_0_idl_o rwl_1_idl_o sn_1_0_idl_o 1.0072e-17
ccc_rwl_1_sn_1_1_idl_o rwl_1_idl_o sn_1_1_idl_o 1.9682e-17
ccc_rwl_1_sn_1_2_idl_o rwl_1_idl_o sn_1_2_idl_o 1.9682e-17
ccc_rwl_1_sn_1_3_idl_o rwl_1_idl_o sn_1_3_idl_o 1.9682e-17
ccc_rwl_2_sn_2_0_idl_o rwl_2_idl_o sn_2_0_idl_o 1.0072e-17
ccc_rwl_2_sn_2_1_idl_o rwl_2_idl_o sn_2_1_idl_o 1.9682e-17
ccc_rwl_2_sn_2_2_idl_o rwl_2_idl_o sn_2_2_idl_o 1.9682e-17
ccc_rwl_2_sn_2_3_idl_o rwl_2_idl_o sn_2_3_idl_o 1.9682e-17
ccc_rwl_3_sn_3_0_idl_o rwl_3_idl_o sn_3_0_idl_o 1.0072e-17
ccc_rwl_3_sn_3_1_idl_o rwl_3_idl_o sn_3_1_idl_o 1.9682e-17
ccc_rwl_3_sn_3_2_idl_o rwl_3_idl_o sn_3_2_idl_o 1.9682e-17
ccc_rwl_3_sn_3_3_idl_o rwl_3_idl_o sn_3_3_idl_o 1.9682e-17
ccc_sn_0_0_wl_0_idl_o sn_0_0_idl_o wl_0_idl_o 1.9664e-17
ccc_sn_0_1_wl_0_idl_o sn_0_1_idl_o wl_0_idl_o 1.9664e-17
ccc_sn_0_2_wl_0_idl_o sn_0_2_idl_o wl_0_idl_o 1.9664e-17
ccc_sn_0_3_wl_0_idl_o sn_0_3_idl_o wl_0_idl_o 1.3668e-17
ccc_sn_1_0_wl_1_idl_o sn_1_0_idl_o wl_1_idl_o 1.9664e-17
ccc_sn_1_1_wl_1_idl_o sn_1_1_idl_o wl_1_idl_o 1.6705e-17
ccc_sn_1_2_wl_1_idl_o sn_1_2_idl_o wl_1_idl_o 1.6705e-17
ccc_sn_1_3_wl_1_idl_o sn_1_3_idl_o wl_1_idl_o 1.071e-17
ccc_sn_2_0_wl_2_idl_o sn_2_0_idl_o wl_2_idl_o 1.9664e-17
ccc_sn_2_1_wl_2_idl_o sn_2_1_idl_o wl_2_idl_o 1.6705e-17
ccc_sn_2_2_wl_2_idl_o sn_2_2_idl_o wl_2_idl_o 1.6705e-17
ccc_sn_2_3_wl_2_idl_o sn_2_3_idl_o wl_2_idl_o 1.071e-17
ccc_sn_3_0_wl_3_idl_o sn_3_0_idl_o wl_3_idl_o 1.9664e-17
ccc_sn_3_1_wl_3_idl_o sn_3_1_idl_o wl_3_idl_o 1.6705e-17
ccc_sn_3_2_wl_3_idl_o sn_3_2_idl_o wl_3_idl_o 1.6705e-17
ccc_sn_3_3_wl_3_idl_o sn_3_3_idl_o wl_3_idl_o 1.071e-17
vpre0_idl_o pre0_idl_o 0 dc 0.9
vpre1_idl_o pre1_idl_o 0 dc 0.9
vpre2_idl_o pre2_idl_o 0 dc 0.9
vpre3_idl_o pre3_idl_o 0 dc 0.9
vwbl0_idl_o bl_0_idl_o 0 dc 0
vwbl1_idl_o bl_1_idl_o 0 dc 0
vwbl2_idl_o bl_2_idl_o 0 dc 0
vwbl3_idl_o bl_3_idl_o 0 dc 0
vrwl0_idl_o rwl_0_idl_o 0 dc 1.8
vrwl1_idl_o rwl_1_idl_o 0 dc 1.8
vrwl2_idl_o rwl_2_idl_o 0 dc 1.8
vrwl3_idl_o rwl_3_idl_o 0 dc 1.8
vwwl0_idl_o wl_0_idl_o 0 dc 0
vwwl1_idl_o wl_1_idl_o 0 dc 0
vwwl2_idl_o wl_2_idl_o 0 dc 0
vwwl3_idl_o wl_3_idl_o 0 dc 0
vbody_idl_o gnd_idl_o 0 dc 0
vsub_idl_o vsubs_idl_o 0 dc 0
vctl_idl_o ctl_idl_o 0 dc 1.8   $ EXCLUDED: switch control, outside the boundary
spre0_idl_o pre0_idl_o rbl_0_idl_o ctl_idl_o 0 swpre
spre1_idl_o pre1_idl_o rbl_1_idl_o ctl_idl_o 0 swpre
spre2_idl_o pre2_idl_o rbl_2_idl_o ctl_idl_o 0 swpre
spre3_idl_o pre3_idl_o rbl_3_idl_o ctl_idl_o 0 swpre
bpn_vpre0_idl_o pn_vpre0_idl_o 0 v=(-v(pre0_idl_o)*i(vpre0_idl_o))
bpg_vpre0_idl_o pg_vpre0_idl_o 0 v=max((-v(pre0_idl_o)*i(vpre0_idl_o)),0)
bpr_vpre0_idl_o pr_vpre0_idl_o 0 v=max(-(-v(pre0_idl_o)*i(vpre0_idl_o)),0)
bpn_vpre1_idl_o pn_vpre1_idl_o 0 v=(-v(pre1_idl_o)*i(vpre1_idl_o))
bpg_vpre1_idl_o pg_vpre1_idl_o 0 v=max((-v(pre1_idl_o)*i(vpre1_idl_o)),0)
bpr_vpre1_idl_o pr_vpre1_idl_o 0 v=max(-(-v(pre1_idl_o)*i(vpre1_idl_o)),0)
bpn_vpre2_idl_o pn_vpre2_idl_o 0 v=(-v(pre2_idl_o)*i(vpre2_idl_o))
bpg_vpre2_idl_o pg_vpre2_idl_o 0 v=max((-v(pre2_idl_o)*i(vpre2_idl_o)),0)
bpr_vpre2_idl_o pr_vpre2_idl_o 0 v=max(-(-v(pre2_idl_o)*i(vpre2_idl_o)),0)
bpn_vpre3_idl_o pn_vpre3_idl_o 0 v=(-v(pre3_idl_o)*i(vpre3_idl_o))
bpg_vpre3_idl_o pg_vpre3_idl_o 0 v=max((-v(pre3_idl_o)*i(vpre3_idl_o)),0)
bpr_vpre3_idl_o pr_vpre3_idl_o 0 v=max(-(-v(pre3_idl_o)*i(vpre3_idl_o)),0)
bpn_vwbl0_idl_o pn_vwbl0_idl_o 0 v=(-v(bl_0_idl_o)*i(vwbl0_idl_o))
bpg_vwbl0_idl_o pg_vwbl0_idl_o 0 v=max((-v(bl_0_idl_o)*i(vwbl0_idl_o)),0)
bpr_vwbl0_idl_o pr_vwbl0_idl_o 0 v=max(-(-v(bl_0_idl_o)*i(vwbl0_idl_o)),0)
bpn_vwbl1_idl_o pn_vwbl1_idl_o 0 v=(-v(bl_1_idl_o)*i(vwbl1_idl_o))
bpg_vwbl1_idl_o pg_vwbl1_idl_o 0 v=max((-v(bl_1_idl_o)*i(vwbl1_idl_o)),0)
bpr_vwbl1_idl_o pr_vwbl1_idl_o 0 v=max(-(-v(bl_1_idl_o)*i(vwbl1_idl_o)),0)
bpn_vwbl2_idl_o pn_vwbl2_idl_o 0 v=(-v(bl_2_idl_o)*i(vwbl2_idl_o))
bpg_vwbl2_idl_o pg_vwbl2_idl_o 0 v=max((-v(bl_2_idl_o)*i(vwbl2_idl_o)),0)
bpr_vwbl2_idl_o pr_vwbl2_idl_o 0 v=max(-(-v(bl_2_idl_o)*i(vwbl2_idl_o)),0)
bpn_vwbl3_idl_o pn_vwbl3_idl_o 0 v=(-v(bl_3_idl_o)*i(vwbl3_idl_o))
bpg_vwbl3_idl_o pg_vwbl3_idl_o 0 v=max((-v(bl_3_idl_o)*i(vwbl3_idl_o)),0)
bpr_vwbl3_idl_o pr_vwbl3_idl_o 0 v=max(-(-v(bl_3_idl_o)*i(vwbl3_idl_o)),0)
bpn_vrwl0_idl_o pn_vrwl0_idl_o 0 v=(-v(rwl_0_idl_o)*i(vrwl0_idl_o))
bpg_vrwl0_idl_o pg_vrwl0_idl_o 0 v=max((-v(rwl_0_idl_o)*i(vrwl0_idl_o)),0)
bpr_vrwl0_idl_o pr_vrwl0_idl_o 0 v=max(-(-v(rwl_0_idl_o)*i(vrwl0_idl_o)),0)
bpn_vrwl1_idl_o pn_vrwl1_idl_o 0 v=(-v(rwl_1_idl_o)*i(vrwl1_idl_o))
bpg_vrwl1_idl_o pg_vrwl1_idl_o 0 v=max((-v(rwl_1_idl_o)*i(vrwl1_idl_o)),0)
bpr_vrwl1_idl_o pr_vrwl1_idl_o 0 v=max(-(-v(rwl_1_idl_o)*i(vrwl1_idl_o)),0)
bpn_vrwl2_idl_o pn_vrwl2_idl_o 0 v=(-v(rwl_2_idl_o)*i(vrwl2_idl_o))
bpg_vrwl2_idl_o pg_vrwl2_idl_o 0 v=max((-v(rwl_2_idl_o)*i(vrwl2_idl_o)),0)
bpr_vrwl2_idl_o pr_vrwl2_idl_o 0 v=max(-(-v(rwl_2_idl_o)*i(vrwl2_idl_o)),0)
bpn_vrwl3_idl_o pn_vrwl3_idl_o 0 v=(-v(rwl_3_idl_o)*i(vrwl3_idl_o))
bpg_vrwl3_idl_o pg_vrwl3_idl_o 0 v=max((-v(rwl_3_idl_o)*i(vrwl3_idl_o)),0)
bpr_vrwl3_idl_o pr_vrwl3_idl_o 0 v=max(-(-v(rwl_3_idl_o)*i(vrwl3_idl_o)),0)
bpn_vwwl0_idl_o pn_vwwl0_idl_o 0 v=(-v(wl_0_idl_o)*i(vwwl0_idl_o))
bpg_vwwl0_idl_o pg_vwwl0_idl_o 0 v=max((-v(wl_0_idl_o)*i(vwwl0_idl_o)),0)
bpr_vwwl0_idl_o pr_vwwl0_idl_o 0 v=max(-(-v(wl_0_idl_o)*i(vwwl0_idl_o)),0)
bpn_vwwl1_idl_o pn_vwwl1_idl_o 0 v=(-v(wl_1_idl_o)*i(vwwl1_idl_o))
bpg_vwwl1_idl_o pg_vwwl1_idl_o 0 v=max((-v(wl_1_idl_o)*i(vwwl1_idl_o)),0)
bpr_vwwl1_idl_o pr_vwwl1_idl_o 0 v=max(-(-v(wl_1_idl_o)*i(vwwl1_idl_o)),0)
bpn_vwwl2_idl_o pn_vwwl2_idl_o 0 v=(-v(wl_2_idl_o)*i(vwwl2_idl_o))
bpg_vwwl2_idl_o pg_vwwl2_idl_o 0 v=max((-v(wl_2_idl_o)*i(vwwl2_idl_o)),0)
bpr_vwwl2_idl_o pr_vwwl2_idl_o 0 v=max(-(-v(wl_2_idl_o)*i(vwwl2_idl_o)),0)
bpn_vwwl3_idl_o pn_vwwl3_idl_o 0 v=(-v(wl_3_idl_o)*i(vwwl3_idl_o))
bpg_vwwl3_idl_o pg_vwwl3_idl_o 0 v=max((-v(wl_3_idl_o)*i(vwwl3_idl_o)),0)
bpr_vwwl3_idl_o pr_vwwl3_idl_o 0 v=max(-(-v(wl_3_idl_o)*i(vwwl3_idl_o)),0)
bpn_vbody_idl_o pn_vbody_idl_o 0 v=(-v(gnd_idl_o)*i(vbody_idl_o))
bpg_vbody_idl_o pg_vbody_idl_o 0 v=max((-v(gnd_idl_o)*i(vbody_idl_o)),0)
bpr_vbody_idl_o pr_vbody_idl_o 0 v=max(-(-v(gnd_idl_o)*i(vbody_idl_o)),0)
bpn_vsub_idl_o pn_vsub_idl_o 0 v=(-v(vsubs_idl_o)*i(vsub_idl_o))
bpg_vsub_idl_o pg_vsub_idl_o 0 v=max((-v(vsubs_idl_o)*i(vsub_idl_o)),0)
bpr_vsub_idl_o pr_vsub_idl_o 0 v=max(-(-v(vsubs_idl_o)*i(vsub_idl_o)),0)

* ---- instance idl_c: mode idle, pattern checker ----
xm1_idl_c sn_0_0__t0_idl_c wl_0__t3_idl_c bl_0__t0_idl_c gnd__t0_idl_c sky130_fd_pr__nfet_01v8 L=0.15 W=0.42 nf=1 ad=0.1974 as=0.1974 pd=1.78 ps=1.78 mult=1 m=1
xm2_idl_c rbl_0__t0_idl_c sn_0_0__t1_idl_c rwl_0__t0_idl_c gnd__t1_idl_c sky130_fd_pr__nfet_01v8 L=0.15 W=0.42 nf=1 ad=0.1974 as=0.1974 pd=1.78 ps=1.78 mult=1 m=1
xm3_idl_c sn_0_1__t1_idl_c wl_0__t0_idl_c bl_1__t0_idl_c gnd__t2_idl_c sky130_fd_pr__nfet_01v8 L=0.15 W=0.42 nf=1 ad=0.1974 as=0.1974 pd=1.78 ps=1.78 mult=1 m=1
xm4_idl_c rbl_1__t0_idl_c sn_0_1__t0_idl_c rwl_0__t1_idl_c gnd__t3_idl_c sky130_fd_pr__nfet_01v8 L=0.15 W=0.42 nf=1 ad=0.1974 as=0.1974 pd=1.78 ps=1.78 mult=1 m=1
xm5_idl_c sn_0_2__t1_idl_c wl_0__t1_idl_c bl_2__t0_idl_c gnd__t4_idl_c sky130_fd_pr__nfet_01v8 L=0.15 W=0.42 nf=1 ad=0.1974 as=0.1974 pd=1.78 ps=1.78 mult=1 m=1
xm6_idl_c rbl_2__t0_idl_c sn_0_2__t0_idl_c rwl_0__t2_idl_c gnd__t5_idl_c sky130_fd_pr__nfet_01v8 L=0.15 W=0.42 nf=1 ad=0.1974 as=0.1974 pd=1.78 ps=1.78 mult=1 m=1
xm7_idl_c sn_0_3__t1_idl_c wl_0__t2_idl_c bl_3__t0_idl_c gnd__t6_idl_c sky130_fd_pr__nfet_01v8 L=0.15 W=0.42 nf=1 ad=0.1974 as=0.1974 pd=1.78 ps=1.78 mult=1 m=1
xm8_idl_c rbl_3__t0_idl_c sn_0_3__t0_idl_c rwl_0__t3_idl_c gnd__t7_idl_c sky130_fd_pr__nfet_01v8 L=0.15 W=0.42 nf=1 ad=0.1974 as=0.1974 pd=1.78 ps=1.78 mult=1 m=1
xm9_idl_c sn_1_0__t1_idl_c wl_1__t0_idl_c bl_0__t1_idl_c gnd__t8_idl_c sky130_fd_pr__nfet_01v8 L=0.15 W=0.42 nf=1 ad=0.1974 as=0.1974 pd=1.78 ps=1.78 mult=1 m=1
xm10_idl_c rbl_0__t1_idl_c sn_1_0__t0_idl_c rwl_1__t0_idl_c gnd__t9_idl_c sky130_fd_pr__nfet_01v8 L=0.15 W=0.42 nf=1 ad=0.1974 as=0.1974 pd=1.78 ps=1.78 mult=1 m=1
xm11_idl_c sn_1_1__t1_idl_c wl_1__t1_idl_c bl_1__t1_idl_c gnd__t10_idl_c sky130_fd_pr__nfet_01v8 L=0.15 W=0.42 nf=1 ad=0.1974 as=0.1974 pd=1.78 ps=1.78 mult=1 m=1
xm12_idl_c rbl_1__t1_idl_c sn_1_1__t0_idl_c rwl_1__t1_idl_c gnd__t11_idl_c sky130_fd_pr__nfet_01v8 L=0.15 W=0.42 nf=1 ad=0.1974 as=0.1974 pd=1.78 ps=1.78 mult=1 m=1
xm13_idl_c sn_1_2__t1_idl_c wl_1__t2_idl_c bl_2__t1_idl_c gnd__t12_idl_c sky130_fd_pr__nfet_01v8 L=0.15 W=0.42 nf=1 ad=0.1974 as=0.1974 pd=1.78 ps=1.78 mult=1 m=1
xm14_idl_c rbl_2__t1_idl_c sn_1_2__t0_idl_c rwl_1__t2_idl_c gnd__t13_idl_c sky130_fd_pr__nfet_01v8 L=0.15 W=0.42 nf=1 ad=0.1974 as=0.1974 pd=1.78 ps=1.78 mult=1 m=1
xm15_idl_c sn_1_3__t1_idl_c wl_1__t3_idl_c bl_3__t1_idl_c gnd__t14_idl_c sky130_fd_pr__nfet_01v8 L=0.15 W=0.42 nf=1 ad=0.1974 as=0.1974 pd=1.78 ps=1.78 mult=1 m=1
xm16_idl_c rbl_3__t1_idl_c sn_1_3__t0_idl_c rwl_1__t3_idl_c gnd__t15_idl_c sky130_fd_pr__nfet_01v8 L=0.15 W=0.42 nf=1 ad=0.1974 as=0.1974 pd=1.78 ps=1.78 mult=1 m=1
xm17_idl_c sn_2_0__t1_idl_c wl_2__t3_idl_c bl_0__t3_idl_c gnd__t16_idl_c sky130_fd_pr__nfet_01v8 L=0.15 W=0.42 nf=1 ad=0.1974 as=0.1974 pd=1.78 ps=1.78 mult=1 m=1
xm18_idl_c rbl_0__t2_idl_c sn_2_0__t0_idl_c rwl_2__t0_idl_c gnd__t17_idl_c sky130_fd_pr__nfet_01v8 L=0.15 W=0.42 nf=1 ad=0.1974 as=0.1974 pd=1.78 ps=1.78 mult=1 m=1
xm19_idl_c sn_2_1__t1_idl_c wl_2__t0_idl_c bl_1__t2_idl_c gnd__t18_idl_c sky130_fd_pr__nfet_01v8 L=0.15 W=0.42 nf=1 ad=0.1974 as=0.1974 pd=1.78 ps=1.78 mult=1 m=1
xm20_idl_c rbl_1__t2_idl_c sn_2_1__t0_idl_c rwl_2__t1_idl_c gnd__t19_idl_c sky130_fd_pr__nfet_01v8 L=0.15 W=0.42 nf=1 ad=0.1974 as=0.1974 pd=1.78 ps=1.78 mult=1 m=1
xm21_idl_c sn_2_2__t1_idl_c wl_2__t1_idl_c bl_2__t2_idl_c gnd__t20_idl_c sky130_fd_pr__nfet_01v8 L=0.15 W=0.42 nf=1 ad=0.1974 as=0.1974 pd=1.78 ps=1.78 mult=1 m=1
xm22_idl_c rbl_2__t2_idl_c sn_2_2__t0_idl_c rwl_2__t2_idl_c gnd__t21_idl_c sky130_fd_pr__nfet_01v8 L=0.15 W=0.42 nf=1 ad=0.1974 as=0.1974 pd=1.78 ps=1.78 mult=1 m=1
xm23_idl_c sn_2_3__t1_idl_c wl_2__t2_idl_c bl_3__t2_idl_c gnd__t22_idl_c sky130_fd_pr__nfet_01v8 L=0.15 W=0.42 nf=1 ad=0.1974 as=0.1974 pd=1.78 ps=1.78 mult=1 m=1
xm24_idl_c rbl_3__t2_idl_c sn_2_3__t0_idl_c rwl_2__t3_idl_c gnd__t23_idl_c sky130_fd_pr__nfet_01v8 L=0.15 W=0.42 nf=1 ad=0.1974 as=0.1974 pd=1.78 ps=1.78 mult=1 m=1
xm25_idl_c sn_3_0__t1_idl_c wl_3__t0_idl_c bl_0__t2_idl_c gnd__t24_idl_c sky130_fd_pr__nfet_01v8 L=0.15 W=0.42 nf=1 ad=0.1974 as=0.1974 pd=1.78 ps=1.78 mult=1 m=1
xm26_idl_c rbl_0__t3_idl_c sn_3_0__t0_idl_c rwl_3__t0_idl_c gnd__t25_idl_c sky130_fd_pr__nfet_01v8 L=0.15 W=0.42 nf=1 ad=0.1974 as=0.1974 pd=1.78 ps=1.78 mult=1 m=1
xm27_idl_c sn_3_1__t1_idl_c wl_3__t1_idl_c bl_1__t3_idl_c gnd__t26_idl_c sky130_fd_pr__nfet_01v8 L=0.15 W=0.42 nf=1 ad=0.1974 as=0.1974 pd=1.78 ps=1.78 mult=1 m=1
xm28_idl_c rbl_1__t3_idl_c sn_3_1__t0_idl_c rwl_3__t1_idl_c gnd__t27_idl_c sky130_fd_pr__nfet_01v8 L=0.15 W=0.42 nf=1 ad=0.1974 as=0.1974 pd=1.78 ps=1.78 mult=1 m=1
xm29_idl_c sn_3_2__t1_idl_c wl_3__t2_idl_c bl_2__t3_idl_c gnd__t28_idl_c sky130_fd_pr__nfet_01v8 L=0.15 W=0.42 nf=1 ad=0.1974 as=0.1974 pd=1.78 ps=1.78 mult=1 m=1
xm30_idl_c rbl_2__t3_idl_c sn_3_2__t0_idl_c rwl_3__t2_idl_c gnd__t29_idl_c sky130_fd_pr__nfet_01v8 L=0.15 W=0.42 nf=1 ad=0.1974 as=0.1974 pd=1.78 ps=1.78 mult=1 m=1
xm31_idl_c sn_3_3__t1_idl_c wl_3__t3_idl_c bl_3__t3_idl_c gnd__t30_idl_c sky130_fd_pr__nfet_01v8 L=0.15 W=0.42 nf=1 ad=0.1974 as=0.1974 pd=1.78 ps=1.78 mult=1 m=1
xm32_idl_c rbl_3__t3_idl_c sn_3_3__t0_idl_c rwl_3__t3_idl_c gnd__t31_idl_c sky130_fd_pr__nfet_01v8 L=0.15 W=0.42 nf=1 ad=0.1974 as=0.1974 pd=1.78 ps=1.78 mult=1 m=1
rgnd_t0_idl_c gnd__t0_idl_c gnd_idl_c 63.3529
rgnd_t1_idl_c gnd__t1_idl_c gnd_idl_c 49.0465
rgnd_t2_idl_c gnd__t2_idl_c gnd_idl_c 36.5177
rgnd_t3_idl_c gnd__t3_idl_c gnd_idl_c 28.2406
rgnd_t4_idl_c gnd__t4_idl_c gnd_idl_c 28.2406
rgnd_t5_idl_c gnd__t5_idl_c gnd_idl_c 36.5177
rgnd_t6_idl_c gnd__t6_idl_c gnd_idl_c 49.0465
rgnd_t7_idl_c gnd__t7_idl_c gnd_idl_c 63.3529
rgnd_t8_idl_c gnd__t8_idl_c gnd_idl_c 58.0019
rgnd_t9_idl_c gnd__t9_idl_c gnd_idl_c 41.907
rgnd_t10_idl_c gnd__t10_idl_c gnd_idl_c 26.1568
rgnd_t11_idl_c gnd__t11_idl_c gnd_idl_c 12.1726
rgnd_t12_idl_c gnd__t12_idl_c gnd_idl_c 12.1726
rgnd_t13_idl_c gnd__t13_idl_c gnd_idl_c 26.1568
rgnd_t14_idl_c gnd__t14_idl_c gnd_idl_c 41.907
rgnd_t15_idl_c gnd__t15_idl_c gnd_idl_c 58.0019
rgnd_t16_idl_c gnd__t16_idl_c gnd_idl_c 58.0019
rgnd_t17_idl_c gnd__t17_idl_c gnd_idl_c 41.907
rgnd_t18_idl_c gnd__t18_idl_c gnd_idl_c 26.1568
rgnd_t19_idl_c gnd__t19_idl_c gnd_idl_c 12.1726
rgnd_t20_idl_c gnd__t20_idl_c gnd_idl_c 12.1726
rgnd_t21_idl_c gnd__t21_idl_c gnd_idl_c 26.1568
rgnd_t22_idl_c gnd__t22_idl_c gnd_idl_c 41.907
rgnd_t23_idl_c gnd__t23_idl_c gnd_idl_c 58.0019
rgnd_t24_idl_c gnd__t24_idl_c gnd_idl_c 63.3529
rgnd_t25_idl_c gnd__t25_idl_c gnd_idl_c 49.0465
rgnd_t26_idl_c gnd__t26_idl_c gnd_idl_c 36.5177
rgnd_t27_idl_c gnd__t27_idl_c gnd_idl_c 28.2406
rgnd_t28_idl_c gnd__t28_idl_c gnd_idl_c 28.2406
rgnd_t29_idl_c gnd__t29_idl_c gnd_idl_c 36.5177
rgnd_t30_idl_c gnd__t30_idl_c gnd_idl_c 49.0465
rgnd_t31_idl_c gnd__t31_idl_c gnd_idl_c 63.3529
rbl_0_t0_idl_c bl_0__t0_idl_c bl_0_idl_c 144.555
rbl_0_t1_idl_c bl_0__t1_idl_c bl_0_idl_c 48.1851
rbl_0_t2_idl_c bl_0__t2_idl_c bl_0_idl_c 144.555
rbl_0_t3_idl_c bl_0__t3_idl_c bl_0_idl_c 48.1851
rbl_1_t0_idl_c bl_1__t0_idl_c bl_1_idl_c 144.555
rbl_1_t1_idl_c bl_1__t1_idl_c bl_1_idl_c 48.1851
rbl_1_t2_idl_c bl_1__t2_idl_c bl_1_idl_c 48.1851
rbl_1_t3_idl_c bl_1__t3_idl_c bl_1_idl_c 144.555
rbl_2_t0_idl_c bl_2__t0_idl_c bl_2_idl_c 144.555
rbl_2_t1_idl_c bl_2__t1_idl_c bl_2_idl_c 48.1851
rbl_2_t2_idl_c bl_2__t2_idl_c bl_2_idl_c 48.1851
rbl_2_t3_idl_c bl_2__t3_idl_c bl_2_idl_c 144.555
rbl_3_t0_idl_c bl_3__t0_idl_c bl_3_idl_c 144.555
rbl_3_t1_idl_c bl_3__t1_idl_c bl_3_idl_c 48.1851
rbl_3_t2_idl_c bl_3__t2_idl_c bl_3_idl_c 48.1851
rbl_3_t3_idl_c bl_3__t3_idl_c bl_3_idl_c 144.555
rrbl_0_t0_idl_c rbl_0__t0_idl_c rbl_0_idl_c 144.555
rrbl_0_t1_idl_c rbl_0__t1_idl_c rbl_0_idl_c 48.1851
rrbl_0_t2_idl_c rbl_0__t2_idl_c rbl_0_idl_c 48.1851
rrbl_0_t3_idl_c rbl_0__t3_idl_c rbl_0_idl_c 144.555
rrbl_1_t0_idl_c rbl_1__t0_idl_c rbl_1_idl_c 144.555
rrbl_1_t1_idl_c rbl_1__t1_idl_c rbl_1_idl_c 48.1851
rrbl_1_t2_idl_c rbl_1__t2_idl_c rbl_1_idl_c 48.1851
rrbl_1_t3_idl_c rbl_1__t3_idl_c rbl_1_idl_c 144.555
rrbl_2_t0_idl_c rbl_2__t0_idl_c rbl_2_idl_c 144.555
rrbl_2_t1_idl_c rbl_2__t1_idl_c rbl_2_idl_c 48.1851
rrbl_2_t2_idl_c rbl_2__t2_idl_c rbl_2_idl_c 48.1851
rrbl_2_t3_idl_c rbl_2__t3_idl_c rbl_2_idl_c 144.555
rrbl_3_t0_idl_c rbl_3__t0_idl_c rbl_3_idl_c 144.555
rrbl_3_t1_idl_c rbl_3__t1_idl_c rbl_3_idl_c 48.1851
rrbl_3_t2_idl_c rbl_3__t2_idl_c rbl_3_idl_c 48.1851
rrbl_3_t3_idl_c rbl_3__t3_idl_c rbl_3_idl_c 144.555
rrwl_0_t0_idl_c rwl_0__t0_idl_c rwl_0_idl_c 21.6897
rrwl_0_t1_idl_c rwl_0__t1_idl_c rwl_0_idl_c 7.22989
rrwl_0_t2_idl_c rwl_0__t2_idl_c rwl_0_idl_c 7.22989
rrwl_0_t3_idl_c rwl_0__t3_idl_c rwl_0_idl_c 21.6897
rrwl_1_t0_idl_c rwl_1__t0_idl_c rwl_1_idl_c 21.6897
rrwl_1_t1_idl_c rwl_1__t1_idl_c rwl_1_idl_c 7.22989
rrwl_1_t2_idl_c rwl_1__t2_idl_c rwl_1_idl_c 7.22989
rrwl_1_t3_idl_c rwl_1__t3_idl_c rwl_1_idl_c 21.6897
rrwl_2_t0_idl_c rwl_2__t0_idl_c rwl_2_idl_c 21.6897
rrwl_2_t1_idl_c rwl_2__t1_idl_c rwl_2_idl_c 7.22989
rrwl_2_t2_idl_c rwl_2__t2_idl_c rwl_2_idl_c 7.22989
rrwl_2_t3_idl_c rwl_2__t3_idl_c rwl_2_idl_c 21.6897
rrwl_3_t0_idl_c rwl_3__t0_idl_c rwl_3_idl_c 21.6897
rrwl_3_t1_idl_c rwl_3__t1_idl_c rwl_3_idl_c 7.22989
rrwl_3_t2_idl_c rwl_3__t2_idl_c rwl_3_idl_c 7.22989
rrwl_3_t3_idl_c rwl_3__t3_idl_c rwl_3_idl_c 21.6897
rsn_0_0_t0_idl_c sn_0_0__t0_idl_c sn_0_0_idl_c 125.123
rsn_0_0_t1_idl_c sn_0_0__t1_idl_c sn_0_0_idl_c 125.123
rsn_0_1_t0_idl_c sn_0_1__t0_idl_c sn_0_1_idl_c 125.123
rsn_0_1_t1_idl_c sn_0_1__t1_idl_c sn_0_1_idl_c 125.123
rsn_0_2_t0_idl_c sn_0_2__t0_idl_c sn_0_2_idl_c 125.123
rsn_0_2_t1_idl_c sn_0_2__t1_idl_c sn_0_2_idl_c 125.123
rsn_0_3_t0_idl_c sn_0_3__t0_idl_c sn_0_3_idl_c 125.123
rsn_0_3_t1_idl_c sn_0_3__t1_idl_c sn_0_3_idl_c 125.123
rsn_1_0_t0_idl_c sn_1_0__t0_idl_c sn_1_0_idl_c 125.123
rsn_1_0_t1_idl_c sn_1_0__t1_idl_c sn_1_0_idl_c 125.123
rsn_1_1_t0_idl_c sn_1_1__t0_idl_c sn_1_1_idl_c 125.123
rsn_1_1_t1_idl_c sn_1_1__t1_idl_c sn_1_1_idl_c 125.123
rsn_1_2_t0_idl_c sn_1_2__t0_idl_c sn_1_2_idl_c 125.123
rsn_1_2_t1_idl_c sn_1_2__t1_idl_c sn_1_2_idl_c 125.123
rsn_1_3_t0_idl_c sn_1_3__t0_idl_c sn_1_3_idl_c 125.123
rsn_1_3_t1_idl_c sn_1_3__t1_idl_c sn_1_3_idl_c 125.123
rsn_2_0_t0_idl_c sn_2_0__t0_idl_c sn_2_0_idl_c 125.123
rsn_2_0_t1_idl_c sn_2_0__t1_idl_c sn_2_0_idl_c 125.123
rsn_2_1_t0_idl_c sn_2_1__t0_idl_c sn_2_1_idl_c 125.123
rsn_2_1_t1_idl_c sn_2_1__t1_idl_c sn_2_1_idl_c 125.123
rsn_2_2_t0_idl_c sn_2_2__t0_idl_c sn_2_2_idl_c 125.123
rsn_2_2_t1_idl_c sn_2_2__t1_idl_c sn_2_2_idl_c 125.123
rsn_2_3_t0_idl_c sn_2_3__t0_idl_c sn_2_3_idl_c 125.123
rsn_2_3_t1_idl_c sn_2_3__t1_idl_c sn_2_3_idl_c 125.123
rsn_3_0_t0_idl_c sn_3_0__t0_idl_c sn_3_0_idl_c 125.123
rsn_3_0_t1_idl_c sn_3_0__t1_idl_c sn_3_0_idl_c 125.123
rsn_3_1_t0_idl_c sn_3_1__t0_idl_c sn_3_1_idl_c 125.123
rsn_3_1_t1_idl_c sn_3_1__t1_idl_c sn_3_1_idl_c 125.123
rsn_3_2_t0_idl_c sn_3_2__t0_idl_c sn_3_2_idl_c 125.123
rsn_3_2_t1_idl_c sn_3_2__t1_idl_c sn_3_2_idl_c 125.123
rsn_3_3_t0_idl_c sn_3_3__t0_idl_c sn_3_3_idl_c 125.123
rsn_3_3_t1_idl_c sn_3_3__t1_idl_c sn_3_3_idl_c 125.123
rwl_0_t0_idl_c wl_0__t0_idl_c wl_0_idl_c 54.2844
rwl_0_t1_idl_c wl_0__t1_idl_c wl_0_idl_c 54.2844
rwl_0_t2_idl_c wl_0__t2_idl_c wl_0_idl_c 162.853
rwl_0_t3_idl_c wl_0__t3_idl_c wl_0_idl_c 162.853
rwl_1_t0_idl_c wl_1__t0_idl_c wl_1_idl_c 162.853
rwl_1_t1_idl_c wl_1__t1_idl_c wl_1_idl_c 54.2844
rwl_1_t2_idl_c wl_1__t2_idl_c wl_1_idl_c 54.2844
rwl_1_t3_idl_c wl_1__t3_idl_c wl_1_idl_c 162.853
rwl_2_t0_idl_c wl_2__t0_idl_c wl_2_idl_c 54.2844
rwl_2_t1_idl_c wl_2__t1_idl_c wl_2_idl_c 54.2844
rwl_2_t2_idl_c wl_2__t2_idl_c wl_2_idl_c 162.853
rwl_2_t3_idl_c wl_2__t3_idl_c wl_2_idl_c 162.853
rwl_3_t0_idl_c wl_3__t0_idl_c wl_3_idl_c 162.853
rwl_3_t1_idl_c wl_3__t1_idl_c wl_3_idl_c 54.2844
rwl_3_t2_idl_c wl_3__t2_idl_c wl_3_idl_c 54.2844
rwl_3_t3_idl_c wl_3__t3_idl_c wl_3_idl_c 162.853
cgnd_idl_c gnd_idl_c vsubs_idl_c 4.09475e-15
cbl_0_idl_c bl_0_idl_c vsubs_idl_c 5.96076e-16
cbl_1_idl_c bl_1_idl_c vsubs_idl_c 5.81168e-16
cbl_2_idl_c bl_2_idl_c vsubs_idl_c 5.81168e-16
cbl_3_idl_c bl_3_idl_c vsubs_idl_c 5.81168e-16
crbl_0_idl_c rbl_0_idl_c vsubs_idl_c 5.81168e-16
crbl_1_idl_c rbl_1_idl_c vsubs_idl_c 5.81168e-16
crbl_2_idl_c rbl_2_idl_c vsubs_idl_c 5.81168e-16
crbl_3_idl_c rbl_3_idl_c vsubs_idl_c 5.96076e-16
crwl_0_idl_c rwl_0_idl_c vsubs_idl_c 1.18713e-15
crwl_1_idl_c rwl_1_idl_c vsubs_idl_c 1.18713e-15
crwl_2_idl_c rwl_2_idl_c vsubs_idl_c 1.18713e-15
crwl_3_idl_c rwl_3_idl_c vsubs_idl_c 1.18713e-15
csn_0_0_idl_c sn_0_0_idl_c vsubs_idl_c 4.33689e-16
csn_0_1_idl_c sn_0_1_idl_c vsubs_idl_c 4.30576e-16
csn_0_2_idl_c sn_0_2_idl_c vsubs_idl_c 4.30576e-16
csn_0_3_idl_c sn_0_3_idl_c vsubs_idl_c 4.32518e-16
csn_1_0_idl_c sn_1_0_idl_c vsubs_idl_c 4.33689e-16
csn_1_1_idl_c sn_1_1_idl_c vsubs_idl_c 4.30576e-16
csn_1_2_idl_c sn_1_2_idl_c vsubs_idl_c 4.30576e-16
csn_1_3_idl_c sn_1_3_idl_c vsubs_idl_c 4.32518e-16
csn_2_0_idl_c sn_2_0_idl_c vsubs_idl_c 4.33689e-16
csn_2_1_idl_c sn_2_1_idl_c vsubs_idl_c 4.30576e-16
csn_2_2_idl_c sn_2_2_idl_c vsubs_idl_c 4.30576e-16
csn_2_3_idl_c sn_2_3_idl_c vsubs_idl_c 4.32518e-16
csn_3_0_idl_c sn_3_0_idl_c vsubs_idl_c 4.33689e-16
csn_3_1_idl_c sn_3_1_idl_c vsubs_idl_c 4.30576e-16
csn_3_2_idl_c sn_3_2_idl_c vsubs_idl_c 4.30576e-16
csn_3_3_idl_c sn_3_3_idl_c vsubs_idl_c 4.32518e-16
cwl_0_idl_c wl_0_idl_c vsubs_idl_c 1.90928e-15
cwl_1_idl_c wl_1_idl_c vsubs_idl_c 1.90928e-15
cwl_2_idl_c wl_2_idl_c vsubs_idl_c 1.90928e-15
cwl_3_idl_c wl_3_idl_c vsubs_idl_c 1.91375e-15
ccc_bl_0_sn_0_0_idl_c bl_0_idl_c sn_0_0_idl_c 1.071e-17
ccc_bl_0_sn_1_0_idl_c bl_0_idl_c sn_1_0_idl_c 1.071e-17
ccc_bl_0_sn_2_0_idl_c bl_0_idl_c sn_2_0_idl_c 1.071e-17
ccc_bl_0_sn_3_0_idl_c bl_0_idl_c sn_3_0_idl_c 1.071e-17
ccc_bl_0_wl_0_idl_c bl_0_idl_c wl_0_idl_c 2.4327e-17
ccc_bl_0_wl_1_idl_c bl_0_idl_c wl_1_idl_c 2.4327e-17
ccc_bl_0_wl_2_idl_c bl_0_idl_c wl_2_idl_c 2.4327e-17
ccc_bl_1_rbl_0_idl_c bl_1_idl_c rbl_0_idl_c 1.29795e-16
ccc_bl_1_rwl_0_idl_c bl_1_idl_c rwl_0_idl_c 9.028e-18
ccc_bl_1_rwl_1_idl_c bl_1_idl_c rwl_1_idl_c 9.028e-18
ccc_bl_1_rwl_2_idl_c bl_1_idl_c rwl_2_idl_c 9.028e-18
ccc_bl_1_rwl_3_idl_c bl_1_idl_c rwl_3_idl_c 9.028e-18
ccc_bl_1_sn_0_1_idl_c bl_1_idl_c sn_0_1_idl_c 1.071e-17
ccc_bl_1_sn_1_1_idl_c bl_1_idl_c sn_1_1_idl_c 1.071e-17
ccc_bl_1_sn_2_1_idl_c bl_1_idl_c sn_2_1_idl_c 1.071e-17
ccc_bl_1_sn_3_1_idl_c bl_1_idl_c sn_3_1_idl_c 1.071e-17
ccc_bl_1_wl_0_idl_c bl_1_idl_c wl_0_idl_c 2.7627e-17
ccc_bl_1_wl_1_idl_c bl_1_idl_c wl_1_idl_c 2.7627e-17
ccc_bl_1_wl_2_idl_c bl_1_idl_c wl_2_idl_c 2.7627e-17
ccc_bl_2_rbl_1_idl_c bl_2_idl_c rbl_1_idl_c 1.29795e-16
ccc_bl_2_rwl_0_idl_c bl_2_idl_c rwl_0_idl_c 9.028e-18
ccc_bl_2_rwl_1_idl_c bl_2_idl_c rwl_1_idl_c 9.028e-18
ccc_bl_2_rwl_2_idl_c bl_2_idl_c rwl_2_idl_c 9.028e-18
ccc_bl_2_rwl_3_idl_c bl_2_idl_c rwl_3_idl_c 9.028e-18
ccc_bl_2_sn_0_2_idl_c bl_2_idl_c sn_0_2_idl_c 1.071e-17
ccc_bl_2_sn_1_2_idl_c bl_2_idl_c sn_1_2_idl_c 1.071e-17
ccc_bl_2_sn_2_2_idl_c bl_2_idl_c sn_2_2_idl_c 1.071e-17
ccc_bl_2_sn_3_2_idl_c bl_2_idl_c sn_3_2_idl_c 1.071e-17
ccc_bl_2_wl_0_idl_c bl_2_idl_c wl_0_idl_c 2.7627e-17
ccc_bl_2_wl_1_idl_c bl_2_idl_c wl_1_idl_c 2.7627e-17
ccc_bl_2_wl_2_idl_c bl_2_idl_c wl_2_idl_c 2.7627e-17
ccc_bl_3_rbl_2_idl_c bl_3_idl_c rbl_2_idl_c 1.29795e-16
ccc_bl_3_rwl_0_idl_c bl_3_idl_c rwl_0_idl_c 9.028e-18
ccc_bl_3_rwl_1_idl_c bl_3_idl_c rwl_1_idl_c 9.028e-18
ccc_bl_3_rwl_2_idl_c bl_3_idl_c rwl_2_idl_c 9.028e-18
ccc_bl_3_rwl_3_idl_c bl_3_idl_c rwl_3_idl_c 9.028e-18
ccc_bl_3_sn_0_3_idl_c bl_3_idl_c sn_0_3_idl_c 1.071e-17
ccc_bl_3_sn_1_3_idl_c bl_3_idl_c sn_1_3_idl_c 1.071e-17
ccc_bl_3_sn_2_3_idl_c bl_3_idl_c sn_2_3_idl_c 1.071e-17
ccc_bl_3_sn_3_3_idl_c bl_3_idl_c sn_3_3_idl_c 1.071e-17
ccc_bl_3_wl_0_idl_c bl_3_idl_c wl_0_idl_c 2.7627e-17
ccc_bl_3_wl_1_idl_c bl_3_idl_c wl_1_idl_c 2.7627e-17
ccc_bl_3_wl_2_idl_c bl_3_idl_c wl_2_idl_c 2.7627e-17
ccc_rbl_0_rwl_0_idl_c rbl_0_idl_c rwl_0_idl_c 1.9738e-17
ccc_rbl_0_rwl_1_idl_c rbl_0_idl_c rwl_1_idl_c 1.9738e-17
ccc_rbl_0_rwl_2_idl_c rbl_0_idl_c rwl_2_idl_c 1.9738e-17
ccc_rbl_0_rwl_3_idl_c rbl_0_idl_c rwl_3_idl_c 1.9738e-17
ccc_rbl_0_sn_0_0_idl_c rbl_0_idl_c sn_0_0_idl_c 1.071e-17
ccc_rbl_0_sn_1_0_idl_c rbl_0_idl_c sn_1_0_idl_c 2.4327e-17
ccc_rbl_0_sn_2_0_idl_c rbl_0_idl_c sn_2_0_idl_c 2.4327e-17
ccc_rbl_0_wl_0_idl_c rbl_0_idl_c wl_0_idl_c 3.3e-18
ccc_rbl_0_wl_1_idl_c rbl_0_idl_c wl_1_idl_c 3.3e-18
ccc_rbl_0_wl_2_idl_c rbl_0_idl_c wl_2_idl_c 3.3e-18
ccc_rbl_1_rwl_0_idl_c rbl_1_idl_c rwl_0_idl_c 1.9738e-17
ccc_rbl_1_rwl_1_idl_c rbl_1_idl_c rwl_1_idl_c 1.9738e-17
ccc_rbl_1_rwl_2_idl_c rbl_1_idl_c rwl_2_idl_c 1.9738e-17
ccc_rbl_1_rwl_3_idl_c rbl_1_idl_c rwl_3_idl_c 1.9738e-17
ccc_rbl_1_sn_0_1_idl_c rbl_1_idl_c sn_0_1_idl_c 1.071e-17
ccc_rbl_1_sn_1_1_idl_c rbl_1_idl_c sn_1_1_idl_c 2.4327e-17
ccc_rbl_1_sn_2_1_idl_c rbl_1_idl_c sn_2_1_idl_c 2.4327e-17
ccc_rbl_1_wl_0_idl_c rbl_1_idl_c wl_0_idl_c 3.3e-18
ccc_rbl_1_wl_1_idl_c rbl_1_idl_c wl_1_idl_c 3.3e-18
ccc_rbl_1_wl_2_idl_c rbl_1_idl_c wl_2_idl_c 3.3e-18
ccc_rbl_2_rwl_0_idl_c rbl_2_idl_c rwl_0_idl_c 1.9738e-17
ccc_rbl_2_rwl_1_idl_c rbl_2_idl_c rwl_1_idl_c 1.9738e-17
ccc_rbl_2_rwl_2_idl_c rbl_2_idl_c rwl_2_idl_c 1.9738e-17
ccc_rbl_2_rwl_3_idl_c rbl_2_idl_c rwl_3_idl_c 1.9738e-17
ccc_rbl_2_sn_0_2_idl_c rbl_2_idl_c sn_0_2_idl_c 1.071e-17
ccc_rbl_2_sn_1_2_idl_c rbl_2_idl_c sn_1_2_idl_c 2.4327e-17
ccc_rbl_2_sn_2_2_idl_c rbl_2_idl_c sn_2_2_idl_c 2.4327e-17
ccc_rbl_2_wl_0_idl_c rbl_2_idl_c wl_0_idl_c 3.3e-18
ccc_rbl_2_wl_1_idl_c rbl_2_idl_c wl_1_idl_c 3.3e-18
ccc_rbl_2_wl_2_idl_c rbl_2_idl_c wl_2_idl_c 3.3e-18
ccc_rbl_3_rwl_0_idl_c rbl_3_idl_c rwl_0_idl_c 1.071e-17
ccc_rbl_3_rwl_1_idl_c rbl_3_idl_c rwl_1_idl_c 1.071e-17
ccc_rbl_3_rwl_2_idl_c rbl_3_idl_c rwl_2_idl_c 1.071e-17
ccc_rbl_3_rwl_3_idl_c rbl_3_idl_c rwl_3_idl_c 1.071e-17
ccc_rbl_3_sn_0_3_idl_c rbl_3_idl_c sn_0_3_idl_c 1.071e-17
ccc_rbl_3_sn_1_3_idl_c rbl_3_idl_c sn_1_3_idl_c 2.4327e-17
ccc_rbl_3_sn_2_3_idl_c rbl_3_idl_c sn_2_3_idl_c 2.4327e-17
ccc_rwl_0_sn_0_0_idl_c rwl_0_idl_c sn_0_0_idl_c 1.0072e-17
ccc_rwl_0_sn_0_1_idl_c rwl_0_idl_c sn_0_1_idl_c 1.9682e-17
ccc_rwl_0_sn_0_2_idl_c rwl_0_idl_c sn_0_2_idl_c 1.9682e-17
ccc_rwl_0_sn_0_3_idl_c rwl_0_idl_c sn_0_3_idl_c 1.9682e-17
ccc_rwl_1_sn_1_0_idl_c rwl_1_idl_c sn_1_0_idl_c 1.0072e-17
ccc_rwl_1_sn_1_1_idl_c rwl_1_idl_c sn_1_1_idl_c 1.9682e-17
ccc_rwl_1_sn_1_2_idl_c rwl_1_idl_c sn_1_2_idl_c 1.9682e-17
ccc_rwl_1_sn_1_3_idl_c rwl_1_idl_c sn_1_3_idl_c 1.9682e-17
ccc_rwl_2_sn_2_0_idl_c rwl_2_idl_c sn_2_0_idl_c 1.0072e-17
ccc_rwl_2_sn_2_1_idl_c rwl_2_idl_c sn_2_1_idl_c 1.9682e-17
ccc_rwl_2_sn_2_2_idl_c rwl_2_idl_c sn_2_2_idl_c 1.9682e-17
ccc_rwl_2_sn_2_3_idl_c rwl_2_idl_c sn_2_3_idl_c 1.9682e-17
ccc_rwl_3_sn_3_0_idl_c rwl_3_idl_c sn_3_0_idl_c 1.0072e-17
ccc_rwl_3_sn_3_1_idl_c rwl_3_idl_c sn_3_1_idl_c 1.9682e-17
ccc_rwl_3_sn_3_2_idl_c rwl_3_idl_c sn_3_2_idl_c 1.9682e-17
ccc_rwl_3_sn_3_3_idl_c rwl_3_idl_c sn_3_3_idl_c 1.9682e-17
ccc_sn_0_0_wl_0_idl_c sn_0_0_idl_c wl_0_idl_c 1.9664e-17
ccc_sn_0_1_wl_0_idl_c sn_0_1_idl_c wl_0_idl_c 1.9664e-17
ccc_sn_0_2_wl_0_idl_c sn_0_2_idl_c wl_0_idl_c 1.9664e-17
ccc_sn_0_3_wl_0_idl_c sn_0_3_idl_c wl_0_idl_c 1.3668e-17
ccc_sn_1_0_wl_1_idl_c sn_1_0_idl_c wl_1_idl_c 1.9664e-17
ccc_sn_1_1_wl_1_idl_c sn_1_1_idl_c wl_1_idl_c 1.6705e-17
ccc_sn_1_2_wl_1_idl_c sn_1_2_idl_c wl_1_idl_c 1.6705e-17
ccc_sn_1_3_wl_1_idl_c sn_1_3_idl_c wl_1_idl_c 1.071e-17
ccc_sn_2_0_wl_2_idl_c sn_2_0_idl_c wl_2_idl_c 1.9664e-17
ccc_sn_2_1_wl_2_idl_c sn_2_1_idl_c wl_2_idl_c 1.6705e-17
ccc_sn_2_2_wl_2_idl_c sn_2_2_idl_c wl_2_idl_c 1.6705e-17
ccc_sn_2_3_wl_2_idl_c sn_2_3_idl_c wl_2_idl_c 1.071e-17
ccc_sn_3_0_wl_3_idl_c sn_3_0_idl_c wl_3_idl_c 1.9664e-17
ccc_sn_3_1_wl_3_idl_c sn_3_1_idl_c wl_3_idl_c 1.6705e-17
ccc_sn_3_2_wl_3_idl_c sn_3_2_idl_c wl_3_idl_c 1.6705e-17
ccc_sn_3_3_wl_3_idl_c sn_3_3_idl_c wl_3_idl_c 1.071e-17
vpre0_idl_c pre0_idl_c 0 dc 0.9
vpre1_idl_c pre1_idl_c 0 dc 0.9
vpre2_idl_c pre2_idl_c 0 dc 0.9
vpre3_idl_c pre3_idl_c 0 dc 0.9
vwbl0_idl_c bl_0_idl_c 0 dc 0
vwbl1_idl_c bl_1_idl_c 0 dc 0
vwbl2_idl_c bl_2_idl_c 0 dc 0
vwbl3_idl_c bl_3_idl_c 0 dc 0
vrwl0_idl_c rwl_0_idl_c 0 dc 1.8
vrwl1_idl_c rwl_1_idl_c 0 dc 1.8
vrwl2_idl_c rwl_2_idl_c 0 dc 1.8
vrwl3_idl_c rwl_3_idl_c 0 dc 1.8
vwwl0_idl_c wl_0_idl_c 0 dc 0
vwwl1_idl_c wl_1_idl_c 0 dc 0
vwwl2_idl_c wl_2_idl_c 0 dc 0
vwwl3_idl_c wl_3_idl_c 0 dc 0
vbody_idl_c gnd_idl_c 0 dc 0
vsub_idl_c vsubs_idl_c 0 dc 0
vctl_idl_c ctl_idl_c 0 dc 1.8   $ EXCLUDED: switch control, outside the boundary
spre0_idl_c pre0_idl_c rbl_0_idl_c ctl_idl_c 0 swpre
spre1_idl_c pre1_idl_c rbl_1_idl_c ctl_idl_c 0 swpre
spre2_idl_c pre2_idl_c rbl_2_idl_c ctl_idl_c 0 swpre
spre3_idl_c pre3_idl_c rbl_3_idl_c ctl_idl_c 0 swpre
bpn_vpre0_idl_c pn_vpre0_idl_c 0 v=(-v(pre0_idl_c)*i(vpre0_idl_c))
bpg_vpre0_idl_c pg_vpre0_idl_c 0 v=max((-v(pre0_idl_c)*i(vpre0_idl_c)),0)
bpr_vpre0_idl_c pr_vpre0_idl_c 0 v=max(-(-v(pre0_idl_c)*i(vpre0_idl_c)),0)
bpn_vpre1_idl_c pn_vpre1_idl_c 0 v=(-v(pre1_idl_c)*i(vpre1_idl_c))
bpg_vpre1_idl_c pg_vpre1_idl_c 0 v=max((-v(pre1_idl_c)*i(vpre1_idl_c)),0)
bpr_vpre1_idl_c pr_vpre1_idl_c 0 v=max(-(-v(pre1_idl_c)*i(vpre1_idl_c)),0)
bpn_vpre2_idl_c pn_vpre2_idl_c 0 v=(-v(pre2_idl_c)*i(vpre2_idl_c))
bpg_vpre2_idl_c pg_vpre2_idl_c 0 v=max((-v(pre2_idl_c)*i(vpre2_idl_c)),0)
bpr_vpre2_idl_c pr_vpre2_idl_c 0 v=max(-(-v(pre2_idl_c)*i(vpre2_idl_c)),0)
bpn_vpre3_idl_c pn_vpre3_idl_c 0 v=(-v(pre3_idl_c)*i(vpre3_idl_c))
bpg_vpre3_idl_c pg_vpre3_idl_c 0 v=max((-v(pre3_idl_c)*i(vpre3_idl_c)),0)
bpr_vpre3_idl_c pr_vpre3_idl_c 0 v=max(-(-v(pre3_idl_c)*i(vpre3_idl_c)),0)
bpn_vwbl0_idl_c pn_vwbl0_idl_c 0 v=(-v(bl_0_idl_c)*i(vwbl0_idl_c))
bpg_vwbl0_idl_c pg_vwbl0_idl_c 0 v=max((-v(bl_0_idl_c)*i(vwbl0_idl_c)),0)
bpr_vwbl0_idl_c pr_vwbl0_idl_c 0 v=max(-(-v(bl_0_idl_c)*i(vwbl0_idl_c)),0)
bpn_vwbl1_idl_c pn_vwbl1_idl_c 0 v=(-v(bl_1_idl_c)*i(vwbl1_idl_c))
bpg_vwbl1_idl_c pg_vwbl1_idl_c 0 v=max((-v(bl_1_idl_c)*i(vwbl1_idl_c)),0)
bpr_vwbl1_idl_c pr_vwbl1_idl_c 0 v=max(-(-v(bl_1_idl_c)*i(vwbl1_idl_c)),0)
bpn_vwbl2_idl_c pn_vwbl2_idl_c 0 v=(-v(bl_2_idl_c)*i(vwbl2_idl_c))
bpg_vwbl2_idl_c pg_vwbl2_idl_c 0 v=max((-v(bl_2_idl_c)*i(vwbl2_idl_c)),0)
bpr_vwbl2_idl_c pr_vwbl2_idl_c 0 v=max(-(-v(bl_2_idl_c)*i(vwbl2_idl_c)),0)
bpn_vwbl3_idl_c pn_vwbl3_idl_c 0 v=(-v(bl_3_idl_c)*i(vwbl3_idl_c))
bpg_vwbl3_idl_c pg_vwbl3_idl_c 0 v=max((-v(bl_3_idl_c)*i(vwbl3_idl_c)),0)
bpr_vwbl3_idl_c pr_vwbl3_idl_c 0 v=max(-(-v(bl_3_idl_c)*i(vwbl3_idl_c)),0)
bpn_vrwl0_idl_c pn_vrwl0_idl_c 0 v=(-v(rwl_0_idl_c)*i(vrwl0_idl_c))
bpg_vrwl0_idl_c pg_vrwl0_idl_c 0 v=max((-v(rwl_0_idl_c)*i(vrwl0_idl_c)),0)
bpr_vrwl0_idl_c pr_vrwl0_idl_c 0 v=max(-(-v(rwl_0_idl_c)*i(vrwl0_idl_c)),0)
bpn_vrwl1_idl_c pn_vrwl1_idl_c 0 v=(-v(rwl_1_idl_c)*i(vrwl1_idl_c))
bpg_vrwl1_idl_c pg_vrwl1_idl_c 0 v=max((-v(rwl_1_idl_c)*i(vrwl1_idl_c)),0)
bpr_vrwl1_idl_c pr_vrwl1_idl_c 0 v=max(-(-v(rwl_1_idl_c)*i(vrwl1_idl_c)),0)
bpn_vrwl2_idl_c pn_vrwl2_idl_c 0 v=(-v(rwl_2_idl_c)*i(vrwl2_idl_c))
bpg_vrwl2_idl_c pg_vrwl2_idl_c 0 v=max((-v(rwl_2_idl_c)*i(vrwl2_idl_c)),0)
bpr_vrwl2_idl_c pr_vrwl2_idl_c 0 v=max(-(-v(rwl_2_idl_c)*i(vrwl2_idl_c)),0)
bpn_vrwl3_idl_c pn_vrwl3_idl_c 0 v=(-v(rwl_3_idl_c)*i(vrwl3_idl_c))
bpg_vrwl3_idl_c pg_vrwl3_idl_c 0 v=max((-v(rwl_3_idl_c)*i(vrwl3_idl_c)),0)
bpr_vrwl3_idl_c pr_vrwl3_idl_c 0 v=max(-(-v(rwl_3_idl_c)*i(vrwl3_idl_c)),0)
bpn_vwwl0_idl_c pn_vwwl0_idl_c 0 v=(-v(wl_0_idl_c)*i(vwwl0_idl_c))
bpg_vwwl0_idl_c pg_vwwl0_idl_c 0 v=max((-v(wl_0_idl_c)*i(vwwl0_idl_c)),0)
bpr_vwwl0_idl_c pr_vwwl0_idl_c 0 v=max(-(-v(wl_0_idl_c)*i(vwwl0_idl_c)),0)
bpn_vwwl1_idl_c pn_vwwl1_idl_c 0 v=(-v(wl_1_idl_c)*i(vwwl1_idl_c))
bpg_vwwl1_idl_c pg_vwwl1_idl_c 0 v=max((-v(wl_1_idl_c)*i(vwwl1_idl_c)),0)
bpr_vwwl1_idl_c pr_vwwl1_idl_c 0 v=max(-(-v(wl_1_idl_c)*i(vwwl1_idl_c)),0)
bpn_vwwl2_idl_c pn_vwwl2_idl_c 0 v=(-v(wl_2_idl_c)*i(vwwl2_idl_c))
bpg_vwwl2_idl_c pg_vwwl2_idl_c 0 v=max((-v(wl_2_idl_c)*i(vwwl2_idl_c)),0)
bpr_vwwl2_idl_c pr_vwwl2_idl_c 0 v=max(-(-v(wl_2_idl_c)*i(vwwl2_idl_c)),0)
bpn_vwwl3_idl_c pn_vwwl3_idl_c 0 v=(-v(wl_3_idl_c)*i(vwwl3_idl_c))
bpg_vwwl3_idl_c pg_vwwl3_idl_c 0 v=max((-v(wl_3_idl_c)*i(vwwl3_idl_c)),0)
bpr_vwwl3_idl_c pr_vwwl3_idl_c 0 v=max(-(-v(wl_3_idl_c)*i(vwwl3_idl_c)),0)
bpn_vbody_idl_c pn_vbody_idl_c 0 v=(-v(gnd_idl_c)*i(vbody_idl_c))
bpg_vbody_idl_c pg_vbody_idl_c 0 v=max((-v(gnd_idl_c)*i(vbody_idl_c)),0)
bpr_vbody_idl_c pr_vbody_idl_c 0 v=max(-(-v(gnd_idl_c)*i(vbody_idl_c)),0)
bpn_vsub_idl_c pn_vsub_idl_c 0 v=(-v(vsubs_idl_c)*i(vsub_idl_c))
bpg_vsub_idl_c pg_vsub_idl_c 0 v=max((-v(vsubs_idl_c)*i(vsub_idl_c)),0)
bpr_vsub_idl_c pr_vsub_idl_c 0 v=max(-(-v(vsubs_idl_c)*i(vsub_idl_c)),0)

* ---- instance idl_i: mode idle, pattern inv_checker ----
xm1_idl_i sn_0_0__t0_idl_i wl_0__t3_idl_i bl_0__t0_idl_i gnd__t0_idl_i sky130_fd_pr__nfet_01v8 L=0.15 W=0.42 nf=1 ad=0.1974 as=0.1974 pd=1.78 ps=1.78 mult=1 m=1
xm2_idl_i rbl_0__t0_idl_i sn_0_0__t1_idl_i rwl_0__t0_idl_i gnd__t1_idl_i sky130_fd_pr__nfet_01v8 L=0.15 W=0.42 nf=1 ad=0.1974 as=0.1974 pd=1.78 ps=1.78 mult=1 m=1
xm3_idl_i sn_0_1__t1_idl_i wl_0__t0_idl_i bl_1__t0_idl_i gnd__t2_idl_i sky130_fd_pr__nfet_01v8 L=0.15 W=0.42 nf=1 ad=0.1974 as=0.1974 pd=1.78 ps=1.78 mult=1 m=1
xm4_idl_i rbl_1__t0_idl_i sn_0_1__t0_idl_i rwl_0__t1_idl_i gnd__t3_idl_i sky130_fd_pr__nfet_01v8 L=0.15 W=0.42 nf=1 ad=0.1974 as=0.1974 pd=1.78 ps=1.78 mult=1 m=1
xm5_idl_i sn_0_2__t1_idl_i wl_0__t1_idl_i bl_2__t0_idl_i gnd__t4_idl_i sky130_fd_pr__nfet_01v8 L=0.15 W=0.42 nf=1 ad=0.1974 as=0.1974 pd=1.78 ps=1.78 mult=1 m=1
xm6_idl_i rbl_2__t0_idl_i sn_0_2__t0_idl_i rwl_0__t2_idl_i gnd__t5_idl_i sky130_fd_pr__nfet_01v8 L=0.15 W=0.42 nf=1 ad=0.1974 as=0.1974 pd=1.78 ps=1.78 mult=1 m=1
xm7_idl_i sn_0_3__t1_idl_i wl_0__t2_idl_i bl_3__t0_idl_i gnd__t6_idl_i sky130_fd_pr__nfet_01v8 L=0.15 W=0.42 nf=1 ad=0.1974 as=0.1974 pd=1.78 ps=1.78 mult=1 m=1
xm8_idl_i rbl_3__t0_idl_i sn_0_3__t0_idl_i rwl_0__t3_idl_i gnd__t7_idl_i sky130_fd_pr__nfet_01v8 L=0.15 W=0.42 nf=1 ad=0.1974 as=0.1974 pd=1.78 ps=1.78 mult=1 m=1
xm9_idl_i sn_1_0__t1_idl_i wl_1__t0_idl_i bl_0__t1_idl_i gnd__t8_idl_i sky130_fd_pr__nfet_01v8 L=0.15 W=0.42 nf=1 ad=0.1974 as=0.1974 pd=1.78 ps=1.78 mult=1 m=1
xm10_idl_i rbl_0__t1_idl_i sn_1_0__t0_idl_i rwl_1__t0_idl_i gnd__t9_idl_i sky130_fd_pr__nfet_01v8 L=0.15 W=0.42 nf=1 ad=0.1974 as=0.1974 pd=1.78 ps=1.78 mult=1 m=1
xm11_idl_i sn_1_1__t1_idl_i wl_1__t1_idl_i bl_1__t1_idl_i gnd__t10_idl_i sky130_fd_pr__nfet_01v8 L=0.15 W=0.42 nf=1 ad=0.1974 as=0.1974 pd=1.78 ps=1.78 mult=1 m=1
xm12_idl_i rbl_1__t1_idl_i sn_1_1__t0_idl_i rwl_1__t1_idl_i gnd__t11_idl_i sky130_fd_pr__nfet_01v8 L=0.15 W=0.42 nf=1 ad=0.1974 as=0.1974 pd=1.78 ps=1.78 mult=1 m=1
xm13_idl_i sn_1_2__t1_idl_i wl_1__t2_idl_i bl_2__t1_idl_i gnd__t12_idl_i sky130_fd_pr__nfet_01v8 L=0.15 W=0.42 nf=1 ad=0.1974 as=0.1974 pd=1.78 ps=1.78 mult=1 m=1
xm14_idl_i rbl_2__t1_idl_i sn_1_2__t0_idl_i rwl_1__t2_idl_i gnd__t13_idl_i sky130_fd_pr__nfet_01v8 L=0.15 W=0.42 nf=1 ad=0.1974 as=0.1974 pd=1.78 ps=1.78 mult=1 m=1
xm15_idl_i sn_1_3__t1_idl_i wl_1__t3_idl_i bl_3__t1_idl_i gnd__t14_idl_i sky130_fd_pr__nfet_01v8 L=0.15 W=0.42 nf=1 ad=0.1974 as=0.1974 pd=1.78 ps=1.78 mult=1 m=1
xm16_idl_i rbl_3__t1_idl_i sn_1_3__t0_idl_i rwl_1__t3_idl_i gnd__t15_idl_i sky130_fd_pr__nfet_01v8 L=0.15 W=0.42 nf=1 ad=0.1974 as=0.1974 pd=1.78 ps=1.78 mult=1 m=1
xm17_idl_i sn_2_0__t1_idl_i wl_2__t3_idl_i bl_0__t3_idl_i gnd__t16_idl_i sky130_fd_pr__nfet_01v8 L=0.15 W=0.42 nf=1 ad=0.1974 as=0.1974 pd=1.78 ps=1.78 mult=1 m=1
xm18_idl_i rbl_0__t2_idl_i sn_2_0__t0_idl_i rwl_2__t0_idl_i gnd__t17_idl_i sky130_fd_pr__nfet_01v8 L=0.15 W=0.42 nf=1 ad=0.1974 as=0.1974 pd=1.78 ps=1.78 mult=1 m=1
xm19_idl_i sn_2_1__t1_idl_i wl_2__t0_idl_i bl_1__t2_idl_i gnd__t18_idl_i sky130_fd_pr__nfet_01v8 L=0.15 W=0.42 nf=1 ad=0.1974 as=0.1974 pd=1.78 ps=1.78 mult=1 m=1
xm20_idl_i rbl_1__t2_idl_i sn_2_1__t0_idl_i rwl_2__t1_idl_i gnd__t19_idl_i sky130_fd_pr__nfet_01v8 L=0.15 W=0.42 nf=1 ad=0.1974 as=0.1974 pd=1.78 ps=1.78 mult=1 m=1
xm21_idl_i sn_2_2__t1_idl_i wl_2__t1_idl_i bl_2__t2_idl_i gnd__t20_idl_i sky130_fd_pr__nfet_01v8 L=0.15 W=0.42 nf=1 ad=0.1974 as=0.1974 pd=1.78 ps=1.78 mult=1 m=1
xm22_idl_i rbl_2__t2_idl_i sn_2_2__t0_idl_i rwl_2__t2_idl_i gnd__t21_idl_i sky130_fd_pr__nfet_01v8 L=0.15 W=0.42 nf=1 ad=0.1974 as=0.1974 pd=1.78 ps=1.78 mult=1 m=1
xm23_idl_i sn_2_3__t1_idl_i wl_2__t2_idl_i bl_3__t2_idl_i gnd__t22_idl_i sky130_fd_pr__nfet_01v8 L=0.15 W=0.42 nf=1 ad=0.1974 as=0.1974 pd=1.78 ps=1.78 mult=1 m=1
xm24_idl_i rbl_3__t2_idl_i sn_2_3__t0_idl_i rwl_2__t3_idl_i gnd__t23_idl_i sky130_fd_pr__nfet_01v8 L=0.15 W=0.42 nf=1 ad=0.1974 as=0.1974 pd=1.78 ps=1.78 mult=1 m=1
xm25_idl_i sn_3_0__t1_idl_i wl_3__t0_idl_i bl_0__t2_idl_i gnd__t24_idl_i sky130_fd_pr__nfet_01v8 L=0.15 W=0.42 nf=1 ad=0.1974 as=0.1974 pd=1.78 ps=1.78 mult=1 m=1
xm26_idl_i rbl_0__t3_idl_i sn_3_0__t0_idl_i rwl_3__t0_idl_i gnd__t25_idl_i sky130_fd_pr__nfet_01v8 L=0.15 W=0.42 nf=1 ad=0.1974 as=0.1974 pd=1.78 ps=1.78 mult=1 m=1
xm27_idl_i sn_3_1__t1_idl_i wl_3__t1_idl_i bl_1__t3_idl_i gnd__t26_idl_i sky130_fd_pr__nfet_01v8 L=0.15 W=0.42 nf=1 ad=0.1974 as=0.1974 pd=1.78 ps=1.78 mult=1 m=1
xm28_idl_i rbl_1__t3_idl_i sn_3_1__t0_idl_i rwl_3__t1_idl_i gnd__t27_idl_i sky130_fd_pr__nfet_01v8 L=0.15 W=0.42 nf=1 ad=0.1974 as=0.1974 pd=1.78 ps=1.78 mult=1 m=1
xm29_idl_i sn_3_2__t1_idl_i wl_3__t2_idl_i bl_2__t3_idl_i gnd__t28_idl_i sky130_fd_pr__nfet_01v8 L=0.15 W=0.42 nf=1 ad=0.1974 as=0.1974 pd=1.78 ps=1.78 mult=1 m=1
xm30_idl_i rbl_2__t3_idl_i sn_3_2__t0_idl_i rwl_3__t2_idl_i gnd__t29_idl_i sky130_fd_pr__nfet_01v8 L=0.15 W=0.42 nf=1 ad=0.1974 as=0.1974 pd=1.78 ps=1.78 mult=1 m=1
xm31_idl_i sn_3_3__t1_idl_i wl_3__t3_idl_i bl_3__t3_idl_i gnd__t30_idl_i sky130_fd_pr__nfet_01v8 L=0.15 W=0.42 nf=1 ad=0.1974 as=0.1974 pd=1.78 ps=1.78 mult=1 m=1
xm32_idl_i rbl_3__t3_idl_i sn_3_3__t0_idl_i rwl_3__t3_idl_i gnd__t31_idl_i sky130_fd_pr__nfet_01v8 L=0.15 W=0.42 nf=1 ad=0.1974 as=0.1974 pd=1.78 ps=1.78 mult=1 m=1
rgnd_t0_idl_i gnd__t0_idl_i gnd_idl_i 63.3529
rgnd_t1_idl_i gnd__t1_idl_i gnd_idl_i 49.0465
rgnd_t2_idl_i gnd__t2_idl_i gnd_idl_i 36.5177
rgnd_t3_idl_i gnd__t3_idl_i gnd_idl_i 28.2406
rgnd_t4_idl_i gnd__t4_idl_i gnd_idl_i 28.2406
rgnd_t5_idl_i gnd__t5_idl_i gnd_idl_i 36.5177
rgnd_t6_idl_i gnd__t6_idl_i gnd_idl_i 49.0465
rgnd_t7_idl_i gnd__t7_idl_i gnd_idl_i 63.3529
rgnd_t8_idl_i gnd__t8_idl_i gnd_idl_i 58.0019
rgnd_t9_idl_i gnd__t9_idl_i gnd_idl_i 41.907
rgnd_t10_idl_i gnd__t10_idl_i gnd_idl_i 26.1568
rgnd_t11_idl_i gnd__t11_idl_i gnd_idl_i 12.1726
rgnd_t12_idl_i gnd__t12_idl_i gnd_idl_i 12.1726
rgnd_t13_idl_i gnd__t13_idl_i gnd_idl_i 26.1568
rgnd_t14_idl_i gnd__t14_idl_i gnd_idl_i 41.907
rgnd_t15_idl_i gnd__t15_idl_i gnd_idl_i 58.0019
rgnd_t16_idl_i gnd__t16_idl_i gnd_idl_i 58.0019
rgnd_t17_idl_i gnd__t17_idl_i gnd_idl_i 41.907
rgnd_t18_idl_i gnd__t18_idl_i gnd_idl_i 26.1568
rgnd_t19_idl_i gnd__t19_idl_i gnd_idl_i 12.1726
rgnd_t20_idl_i gnd__t20_idl_i gnd_idl_i 12.1726
rgnd_t21_idl_i gnd__t21_idl_i gnd_idl_i 26.1568
rgnd_t22_idl_i gnd__t22_idl_i gnd_idl_i 41.907
rgnd_t23_idl_i gnd__t23_idl_i gnd_idl_i 58.0019
rgnd_t24_idl_i gnd__t24_idl_i gnd_idl_i 63.3529
rgnd_t25_idl_i gnd__t25_idl_i gnd_idl_i 49.0465
rgnd_t26_idl_i gnd__t26_idl_i gnd_idl_i 36.5177
rgnd_t27_idl_i gnd__t27_idl_i gnd_idl_i 28.2406
rgnd_t28_idl_i gnd__t28_idl_i gnd_idl_i 28.2406
rgnd_t29_idl_i gnd__t29_idl_i gnd_idl_i 36.5177
rgnd_t30_idl_i gnd__t30_idl_i gnd_idl_i 49.0465
rgnd_t31_idl_i gnd__t31_idl_i gnd_idl_i 63.3529
rbl_0_t0_idl_i bl_0__t0_idl_i bl_0_idl_i 144.555
rbl_0_t1_idl_i bl_0__t1_idl_i bl_0_idl_i 48.1851
rbl_0_t2_idl_i bl_0__t2_idl_i bl_0_idl_i 144.555
rbl_0_t3_idl_i bl_0__t3_idl_i bl_0_idl_i 48.1851
rbl_1_t0_idl_i bl_1__t0_idl_i bl_1_idl_i 144.555
rbl_1_t1_idl_i bl_1__t1_idl_i bl_1_idl_i 48.1851
rbl_1_t2_idl_i bl_1__t2_idl_i bl_1_idl_i 48.1851
rbl_1_t3_idl_i bl_1__t3_idl_i bl_1_idl_i 144.555
rbl_2_t0_idl_i bl_2__t0_idl_i bl_2_idl_i 144.555
rbl_2_t1_idl_i bl_2__t1_idl_i bl_2_idl_i 48.1851
rbl_2_t2_idl_i bl_2__t2_idl_i bl_2_idl_i 48.1851
rbl_2_t3_idl_i bl_2__t3_idl_i bl_2_idl_i 144.555
rbl_3_t0_idl_i bl_3__t0_idl_i bl_3_idl_i 144.555
rbl_3_t1_idl_i bl_3__t1_idl_i bl_3_idl_i 48.1851
rbl_3_t2_idl_i bl_3__t2_idl_i bl_3_idl_i 48.1851
rbl_3_t3_idl_i bl_3__t3_idl_i bl_3_idl_i 144.555
rrbl_0_t0_idl_i rbl_0__t0_idl_i rbl_0_idl_i 144.555
rrbl_0_t1_idl_i rbl_0__t1_idl_i rbl_0_idl_i 48.1851
rrbl_0_t2_idl_i rbl_0__t2_idl_i rbl_0_idl_i 48.1851
rrbl_0_t3_idl_i rbl_0__t3_idl_i rbl_0_idl_i 144.555
rrbl_1_t0_idl_i rbl_1__t0_idl_i rbl_1_idl_i 144.555
rrbl_1_t1_idl_i rbl_1__t1_idl_i rbl_1_idl_i 48.1851
rrbl_1_t2_idl_i rbl_1__t2_idl_i rbl_1_idl_i 48.1851
rrbl_1_t3_idl_i rbl_1__t3_idl_i rbl_1_idl_i 144.555
rrbl_2_t0_idl_i rbl_2__t0_idl_i rbl_2_idl_i 144.555
rrbl_2_t1_idl_i rbl_2__t1_idl_i rbl_2_idl_i 48.1851
rrbl_2_t2_idl_i rbl_2__t2_idl_i rbl_2_idl_i 48.1851
rrbl_2_t3_idl_i rbl_2__t3_idl_i rbl_2_idl_i 144.555
rrbl_3_t0_idl_i rbl_3__t0_idl_i rbl_3_idl_i 144.555
rrbl_3_t1_idl_i rbl_3__t1_idl_i rbl_3_idl_i 48.1851
rrbl_3_t2_idl_i rbl_3__t2_idl_i rbl_3_idl_i 48.1851
rrbl_3_t3_idl_i rbl_3__t3_idl_i rbl_3_idl_i 144.555
rrwl_0_t0_idl_i rwl_0__t0_idl_i rwl_0_idl_i 21.6897
rrwl_0_t1_idl_i rwl_0__t1_idl_i rwl_0_idl_i 7.22989
rrwl_0_t2_idl_i rwl_0__t2_idl_i rwl_0_idl_i 7.22989
rrwl_0_t3_idl_i rwl_0__t3_idl_i rwl_0_idl_i 21.6897
rrwl_1_t0_idl_i rwl_1__t0_idl_i rwl_1_idl_i 21.6897
rrwl_1_t1_idl_i rwl_1__t1_idl_i rwl_1_idl_i 7.22989
rrwl_1_t2_idl_i rwl_1__t2_idl_i rwl_1_idl_i 7.22989
rrwl_1_t3_idl_i rwl_1__t3_idl_i rwl_1_idl_i 21.6897
rrwl_2_t0_idl_i rwl_2__t0_idl_i rwl_2_idl_i 21.6897
rrwl_2_t1_idl_i rwl_2__t1_idl_i rwl_2_idl_i 7.22989
rrwl_2_t2_idl_i rwl_2__t2_idl_i rwl_2_idl_i 7.22989
rrwl_2_t3_idl_i rwl_2__t3_idl_i rwl_2_idl_i 21.6897
rrwl_3_t0_idl_i rwl_3__t0_idl_i rwl_3_idl_i 21.6897
rrwl_3_t1_idl_i rwl_3__t1_idl_i rwl_3_idl_i 7.22989
rrwl_3_t2_idl_i rwl_3__t2_idl_i rwl_3_idl_i 7.22989
rrwl_3_t3_idl_i rwl_3__t3_idl_i rwl_3_idl_i 21.6897
rsn_0_0_t0_idl_i sn_0_0__t0_idl_i sn_0_0_idl_i 125.123
rsn_0_0_t1_idl_i sn_0_0__t1_idl_i sn_0_0_idl_i 125.123
rsn_0_1_t0_idl_i sn_0_1__t0_idl_i sn_0_1_idl_i 125.123
rsn_0_1_t1_idl_i sn_0_1__t1_idl_i sn_0_1_idl_i 125.123
rsn_0_2_t0_idl_i sn_0_2__t0_idl_i sn_0_2_idl_i 125.123
rsn_0_2_t1_idl_i sn_0_2__t1_idl_i sn_0_2_idl_i 125.123
rsn_0_3_t0_idl_i sn_0_3__t0_idl_i sn_0_3_idl_i 125.123
rsn_0_3_t1_idl_i sn_0_3__t1_idl_i sn_0_3_idl_i 125.123
rsn_1_0_t0_idl_i sn_1_0__t0_idl_i sn_1_0_idl_i 125.123
rsn_1_0_t1_idl_i sn_1_0__t1_idl_i sn_1_0_idl_i 125.123
rsn_1_1_t0_idl_i sn_1_1__t0_idl_i sn_1_1_idl_i 125.123
rsn_1_1_t1_idl_i sn_1_1__t1_idl_i sn_1_1_idl_i 125.123
rsn_1_2_t0_idl_i sn_1_2__t0_idl_i sn_1_2_idl_i 125.123
rsn_1_2_t1_idl_i sn_1_2__t1_idl_i sn_1_2_idl_i 125.123
rsn_1_3_t0_idl_i sn_1_3__t0_idl_i sn_1_3_idl_i 125.123
rsn_1_3_t1_idl_i sn_1_3__t1_idl_i sn_1_3_idl_i 125.123
rsn_2_0_t0_idl_i sn_2_0__t0_idl_i sn_2_0_idl_i 125.123
rsn_2_0_t1_idl_i sn_2_0__t1_idl_i sn_2_0_idl_i 125.123
rsn_2_1_t0_idl_i sn_2_1__t0_idl_i sn_2_1_idl_i 125.123
rsn_2_1_t1_idl_i sn_2_1__t1_idl_i sn_2_1_idl_i 125.123
rsn_2_2_t0_idl_i sn_2_2__t0_idl_i sn_2_2_idl_i 125.123
rsn_2_2_t1_idl_i sn_2_2__t1_idl_i sn_2_2_idl_i 125.123
rsn_2_3_t0_idl_i sn_2_3__t0_idl_i sn_2_3_idl_i 125.123
rsn_2_3_t1_idl_i sn_2_3__t1_idl_i sn_2_3_idl_i 125.123
rsn_3_0_t0_idl_i sn_3_0__t0_idl_i sn_3_0_idl_i 125.123
rsn_3_0_t1_idl_i sn_3_0__t1_idl_i sn_3_0_idl_i 125.123
rsn_3_1_t0_idl_i sn_3_1__t0_idl_i sn_3_1_idl_i 125.123
rsn_3_1_t1_idl_i sn_3_1__t1_idl_i sn_3_1_idl_i 125.123
rsn_3_2_t0_idl_i sn_3_2__t0_idl_i sn_3_2_idl_i 125.123
rsn_3_2_t1_idl_i sn_3_2__t1_idl_i sn_3_2_idl_i 125.123
rsn_3_3_t0_idl_i sn_3_3__t0_idl_i sn_3_3_idl_i 125.123
rsn_3_3_t1_idl_i sn_3_3__t1_idl_i sn_3_3_idl_i 125.123
rwl_0_t0_idl_i wl_0__t0_idl_i wl_0_idl_i 54.2844
rwl_0_t1_idl_i wl_0__t1_idl_i wl_0_idl_i 54.2844
rwl_0_t2_idl_i wl_0__t2_idl_i wl_0_idl_i 162.853
rwl_0_t3_idl_i wl_0__t3_idl_i wl_0_idl_i 162.853
rwl_1_t0_idl_i wl_1__t0_idl_i wl_1_idl_i 162.853
rwl_1_t1_idl_i wl_1__t1_idl_i wl_1_idl_i 54.2844
rwl_1_t2_idl_i wl_1__t2_idl_i wl_1_idl_i 54.2844
rwl_1_t3_idl_i wl_1__t3_idl_i wl_1_idl_i 162.853
rwl_2_t0_idl_i wl_2__t0_idl_i wl_2_idl_i 54.2844
rwl_2_t1_idl_i wl_2__t1_idl_i wl_2_idl_i 54.2844
rwl_2_t2_idl_i wl_2__t2_idl_i wl_2_idl_i 162.853
rwl_2_t3_idl_i wl_2__t3_idl_i wl_2_idl_i 162.853
rwl_3_t0_idl_i wl_3__t0_idl_i wl_3_idl_i 162.853
rwl_3_t1_idl_i wl_3__t1_idl_i wl_3_idl_i 54.2844
rwl_3_t2_idl_i wl_3__t2_idl_i wl_3_idl_i 54.2844
rwl_3_t3_idl_i wl_3__t3_idl_i wl_3_idl_i 162.853
cgnd_idl_i gnd_idl_i vsubs_idl_i 4.09475e-15
cbl_0_idl_i bl_0_idl_i vsubs_idl_i 5.96076e-16
cbl_1_idl_i bl_1_idl_i vsubs_idl_i 5.81168e-16
cbl_2_idl_i bl_2_idl_i vsubs_idl_i 5.81168e-16
cbl_3_idl_i bl_3_idl_i vsubs_idl_i 5.81168e-16
crbl_0_idl_i rbl_0_idl_i vsubs_idl_i 5.81168e-16
crbl_1_idl_i rbl_1_idl_i vsubs_idl_i 5.81168e-16
crbl_2_idl_i rbl_2_idl_i vsubs_idl_i 5.81168e-16
crbl_3_idl_i rbl_3_idl_i vsubs_idl_i 5.96076e-16
crwl_0_idl_i rwl_0_idl_i vsubs_idl_i 1.18713e-15
crwl_1_idl_i rwl_1_idl_i vsubs_idl_i 1.18713e-15
crwl_2_idl_i rwl_2_idl_i vsubs_idl_i 1.18713e-15
crwl_3_idl_i rwl_3_idl_i vsubs_idl_i 1.18713e-15
csn_0_0_idl_i sn_0_0_idl_i vsubs_idl_i 4.33689e-16
csn_0_1_idl_i sn_0_1_idl_i vsubs_idl_i 4.30576e-16
csn_0_2_idl_i sn_0_2_idl_i vsubs_idl_i 4.30576e-16
csn_0_3_idl_i sn_0_3_idl_i vsubs_idl_i 4.32518e-16
csn_1_0_idl_i sn_1_0_idl_i vsubs_idl_i 4.33689e-16
csn_1_1_idl_i sn_1_1_idl_i vsubs_idl_i 4.30576e-16
csn_1_2_idl_i sn_1_2_idl_i vsubs_idl_i 4.30576e-16
csn_1_3_idl_i sn_1_3_idl_i vsubs_idl_i 4.32518e-16
csn_2_0_idl_i sn_2_0_idl_i vsubs_idl_i 4.33689e-16
csn_2_1_idl_i sn_2_1_idl_i vsubs_idl_i 4.30576e-16
csn_2_2_idl_i sn_2_2_idl_i vsubs_idl_i 4.30576e-16
csn_2_3_idl_i sn_2_3_idl_i vsubs_idl_i 4.32518e-16
csn_3_0_idl_i sn_3_0_idl_i vsubs_idl_i 4.33689e-16
csn_3_1_idl_i sn_3_1_idl_i vsubs_idl_i 4.30576e-16
csn_3_2_idl_i sn_3_2_idl_i vsubs_idl_i 4.30576e-16
csn_3_3_idl_i sn_3_3_idl_i vsubs_idl_i 4.32518e-16
cwl_0_idl_i wl_0_idl_i vsubs_idl_i 1.90928e-15
cwl_1_idl_i wl_1_idl_i vsubs_idl_i 1.90928e-15
cwl_2_idl_i wl_2_idl_i vsubs_idl_i 1.90928e-15
cwl_3_idl_i wl_3_idl_i vsubs_idl_i 1.91375e-15
ccc_bl_0_sn_0_0_idl_i bl_0_idl_i sn_0_0_idl_i 1.071e-17
ccc_bl_0_sn_1_0_idl_i bl_0_idl_i sn_1_0_idl_i 1.071e-17
ccc_bl_0_sn_2_0_idl_i bl_0_idl_i sn_2_0_idl_i 1.071e-17
ccc_bl_0_sn_3_0_idl_i bl_0_idl_i sn_3_0_idl_i 1.071e-17
ccc_bl_0_wl_0_idl_i bl_0_idl_i wl_0_idl_i 2.4327e-17
ccc_bl_0_wl_1_idl_i bl_0_idl_i wl_1_idl_i 2.4327e-17
ccc_bl_0_wl_2_idl_i bl_0_idl_i wl_2_idl_i 2.4327e-17
ccc_bl_1_rbl_0_idl_i bl_1_idl_i rbl_0_idl_i 1.29795e-16
ccc_bl_1_rwl_0_idl_i bl_1_idl_i rwl_0_idl_i 9.028e-18
ccc_bl_1_rwl_1_idl_i bl_1_idl_i rwl_1_idl_i 9.028e-18
ccc_bl_1_rwl_2_idl_i bl_1_idl_i rwl_2_idl_i 9.028e-18
ccc_bl_1_rwl_3_idl_i bl_1_idl_i rwl_3_idl_i 9.028e-18
ccc_bl_1_sn_0_1_idl_i bl_1_idl_i sn_0_1_idl_i 1.071e-17
ccc_bl_1_sn_1_1_idl_i bl_1_idl_i sn_1_1_idl_i 1.071e-17
ccc_bl_1_sn_2_1_idl_i bl_1_idl_i sn_2_1_idl_i 1.071e-17
ccc_bl_1_sn_3_1_idl_i bl_1_idl_i sn_3_1_idl_i 1.071e-17
ccc_bl_1_wl_0_idl_i bl_1_idl_i wl_0_idl_i 2.7627e-17
ccc_bl_1_wl_1_idl_i bl_1_idl_i wl_1_idl_i 2.7627e-17
ccc_bl_1_wl_2_idl_i bl_1_idl_i wl_2_idl_i 2.7627e-17
ccc_bl_2_rbl_1_idl_i bl_2_idl_i rbl_1_idl_i 1.29795e-16
ccc_bl_2_rwl_0_idl_i bl_2_idl_i rwl_0_idl_i 9.028e-18
ccc_bl_2_rwl_1_idl_i bl_2_idl_i rwl_1_idl_i 9.028e-18
ccc_bl_2_rwl_2_idl_i bl_2_idl_i rwl_2_idl_i 9.028e-18
ccc_bl_2_rwl_3_idl_i bl_2_idl_i rwl_3_idl_i 9.028e-18
ccc_bl_2_sn_0_2_idl_i bl_2_idl_i sn_0_2_idl_i 1.071e-17
ccc_bl_2_sn_1_2_idl_i bl_2_idl_i sn_1_2_idl_i 1.071e-17
ccc_bl_2_sn_2_2_idl_i bl_2_idl_i sn_2_2_idl_i 1.071e-17
ccc_bl_2_sn_3_2_idl_i bl_2_idl_i sn_3_2_idl_i 1.071e-17
ccc_bl_2_wl_0_idl_i bl_2_idl_i wl_0_idl_i 2.7627e-17
ccc_bl_2_wl_1_idl_i bl_2_idl_i wl_1_idl_i 2.7627e-17
ccc_bl_2_wl_2_idl_i bl_2_idl_i wl_2_idl_i 2.7627e-17
ccc_bl_3_rbl_2_idl_i bl_3_idl_i rbl_2_idl_i 1.29795e-16
ccc_bl_3_rwl_0_idl_i bl_3_idl_i rwl_0_idl_i 9.028e-18
ccc_bl_3_rwl_1_idl_i bl_3_idl_i rwl_1_idl_i 9.028e-18
ccc_bl_3_rwl_2_idl_i bl_3_idl_i rwl_2_idl_i 9.028e-18
ccc_bl_3_rwl_3_idl_i bl_3_idl_i rwl_3_idl_i 9.028e-18
ccc_bl_3_sn_0_3_idl_i bl_3_idl_i sn_0_3_idl_i 1.071e-17
ccc_bl_3_sn_1_3_idl_i bl_3_idl_i sn_1_3_idl_i 1.071e-17
ccc_bl_3_sn_2_3_idl_i bl_3_idl_i sn_2_3_idl_i 1.071e-17
ccc_bl_3_sn_3_3_idl_i bl_3_idl_i sn_3_3_idl_i 1.071e-17
ccc_bl_3_wl_0_idl_i bl_3_idl_i wl_0_idl_i 2.7627e-17
ccc_bl_3_wl_1_idl_i bl_3_idl_i wl_1_idl_i 2.7627e-17
ccc_bl_3_wl_2_idl_i bl_3_idl_i wl_2_idl_i 2.7627e-17
ccc_rbl_0_rwl_0_idl_i rbl_0_idl_i rwl_0_idl_i 1.9738e-17
ccc_rbl_0_rwl_1_idl_i rbl_0_idl_i rwl_1_idl_i 1.9738e-17
ccc_rbl_0_rwl_2_idl_i rbl_0_idl_i rwl_2_idl_i 1.9738e-17
ccc_rbl_0_rwl_3_idl_i rbl_0_idl_i rwl_3_idl_i 1.9738e-17
ccc_rbl_0_sn_0_0_idl_i rbl_0_idl_i sn_0_0_idl_i 1.071e-17
ccc_rbl_0_sn_1_0_idl_i rbl_0_idl_i sn_1_0_idl_i 2.4327e-17
ccc_rbl_0_sn_2_0_idl_i rbl_0_idl_i sn_2_0_idl_i 2.4327e-17
ccc_rbl_0_wl_0_idl_i rbl_0_idl_i wl_0_idl_i 3.3e-18
ccc_rbl_0_wl_1_idl_i rbl_0_idl_i wl_1_idl_i 3.3e-18
ccc_rbl_0_wl_2_idl_i rbl_0_idl_i wl_2_idl_i 3.3e-18
ccc_rbl_1_rwl_0_idl_i rbl_1_idl_i rwl_0_idl_i 1.9738e-17
ccc_rbl_1_rwl_1_idl_i rbl_1_idl_i rwl_1_idl_i 1.9738e-17
ccc_rbl_1_rwl_2_idl_i rbl_1_idl_i rwl_2_idl_i 1.9738e-17
ccc_rbl_1_rwl_3_idl_i rbl_1_idl_i rwl_3_idl_i 1.9738e-17
ccc_rbl_1_sn_0_1_idl_i rbl_1_idl_i sn_0_1_idl_i 1.071e-17
ccc_rbl_1_sn_1_1_idl_i rbl_1_idl_i sn_1_1_idl_i 2.4327e-17
ccc_rbl_1_sn_2_1_idl_i rbl_1_idl_i sn_2_1_idl_i 2.4327e-17
ccc_rbl_1_wl_0_idl_i rbl_1_idl_i wl_0_idl_i 3.3e-18
ccc_rbl_1_wl_1_idl_i rbl_1_idl_i wl_1_idl_i 3.3e-18
ccc_rbl_1_wl_2_idl_i rbl_1_idl_i wl_2_idl_i 3.3e-18
ccc_rbl_2_rwl_0_idl_i rbl_2_idl_i rwl_0_idl_i 1.9738e-17
ccc_rbl_2_rwl_1_idl_i rbl_2_idl_i rwl_1_idl_i 1.9738e-17
ccc_rbl_2_rwl_2_idl_i rbl_2_idl_i rwl_2_idl_i 1.9738e-17
ccc_rbl_2_rwl_3_idl_i rbl_2_idl_i rwl_3_idl_i 1.9738e-17
ccc_rbl_2_sn_0_2_idl_i rbl_2_idl_i sn_0_2_idl_i 1.071e-17
ccc_rbl_2_sn_1_2_idl_i rbl_2_idl_i sn_1_2_idl_i 2.4327e-17
ccc_rbl_2_sn_2_2_idl_i rbl_2_idl_i sn_2_2_idl_i 2.4327e-17
ccc_rbl_2_wl_0_idl_i rbl_2_idl_i wl_0_idl_i 3.3e-18
ccc_rbl_2_wl_1_idl_i rbl_2_idl_i wl_1_idl_i 3.3e-18
ccc_rbl_2_wl_2_idl_i rbl_2_idl_i wl_2_idl_i 3.3e-18
ccc_rbl_3_rwl_0_idl_i rbl_3_idl_i rwl_0_idl_i 1.071e-17
ccc_rbl_3_rwl_1_idl_i rbl_3_idl_i rwl_1_idl_i 1.071e-17
ccc_rbl_3_rwl_2_idl_i rbl_3_idl_i rwl_2_idl_i 1.071e-17
ccc_rbl_3_rwl_3_idl_i rbl_3_idl_i rwl_3_idl_i 1.071e-17
ccc_rbl_3_sn_0_3_idl_i rbl_3_idl_i sn_0_3_idl_i 1.071e-17
ccc_rbl_3_sn_1_3_idl_i rbl_3_idl_i sn_1_3_idl_i 2.4327e-17
ccc_rbl_3_sn_2_3_idl_i rbl_3_idl_i sn_2_3_idl_i 2.4327e-17
ccc_rwl_0_sn_0_0_idl_i rwl_0_idl_i sn_0_0_idl_i 1.0072e-17
ccc_rwl_0_sn_0_1_idl_i rwl_0_idl_i sn_0_1_idl_i 1.9682e-17
ccc_rwl_0_sn_0_2_idl_i rwl_0_idl_i sn_0_2_idl_i 1.9682e-17
ccc_rwl_0_sn_0_3_idl_i rwl_0_idl_i sn_0_3_idl_i 1.9682e-17
ccc_rwl_1_sn_1_0_idl_i rwl_1_idl_i sn_1_0_idl_i 1.0072e-17
ccc_rwl_1_sn_1_1_idl_i rwl_1_idl_i sn_1_1_idl_i 1.9682e-17
ccc_rwl_1_sn_1_2_idl_i rwl_1_idl_i sn_1_2_idl_i 1.9682e-17
ccc_rwl_1_sn_1_3_idl_i rwl_1_idl_i sn_1_3_idl_i 1.9682e-17
ccc_rwl_2_sn_2_0_idl_i rwl_2_idl_i sn_2_0_idl_i 1.0072e-17
ccc_rwl_2_sn_2_1_idl_i rwl_2_idl_i sn_2_1_idl_i 1.9682e-17
ccc_rwl_2_sn_2_2_idl_i rwl_2_idl_i sn_2_2_idl_i 1.9682e-17
ccc_rwl_2_sn_2_3_idl_i rwl_2_idl_i sn_2_3_idl_i 1.9682e-17
ccc_rwl_3_sn_3_0_idl_i rwl_3_idl_i sn_3_0_idl_i 1.0072e-17
ccc_rwl_3_sn_3_1_idl_i rwl_3_idl_i sn_3_1_idl_i 1.9682e-17
ccc_rwl_3_sn_3_2_idl_i rwl_3_idl_i sn_3_2_idl_i 1.9682e-17
ccc_rwl_3_sn_3_3_idl_i rwl_3_idl_i sn_3_3_idl_i 1.9682e-17
ccc_sn_0_0_wl_0_idl_i sn_0_0_idl_i wl_0_idl_i 1.9664e-17
ccc_sn_0_1_wl_0_idl_i sn_0_1_idl_i wl_0_idl_i 1.9664e-17
ccc_sn_0_2_wl_0_idl_i sn_0_2_idl_i wl_0_idl_i 1.9664e-17
ccc_sn_0_3_wl_0_idl_i sn_0_3_idl_i wl_0_idl_i 1.3668e-17
ccc_sn_1_0_wl_1_idl_i sn_1_0_idl_i wl_1_idl_i 1.9664e-17
ccc_sn_1_1_wl_1_idl_i sn_1_1_idl_i wl_1_idl_i 1.6705e-17
ccc_sn_1_2_wl_1_idl_i sn_1_2_idl_i wl_1_idl_i 1.6705e-17
ccc_sn_1_3_wl_1_idl_i sn_1_3_idl_i wl_1_idl_i 1.071e-17
ccc_sn_2_0_wl_2_idl_i sn_2_0_idl_i wl_2_idl_i 1.9664e-17
ccc_sn_2_1_wl_2_idl_i sn_2_1_idl_i wl_2_idl_i 1.6705e-17
ccc_sn_2_2_wl_2_idl_i sn_2_2_idl_i wl_2_idl_i 1.6705e-17
ccc_sn_2_3_wl_2_idl_i sn_2_3_idl_i wl_2_idl_i 1.071e-17
ccc_sn_3_0_wl_3_idl_i sn_3_0_idl_i wl_3_idl_i 1.9664e-17
ccc_sn_3_1_wl_3_idl_i sn_3_1_idl_i wl_3_idl_i 1.6705e-17
ccc_sn_3_2_wl_3_idl_i sn_3_2_idl_i wl_3_idl_i 1.6705e-17
ccc_sn_3_3_wl_3_idl_i sn_3_3_idl_i wl_3_idl_i 1.071e-17
vpre0_idl_i pre0_idl_i 0 dc 0.9
vpre1_idl_i pre1_idl_i 0 dc 0.9
vpre2_idl_i pre2_idl_i 0 dc 0.9
vpre3_idl_i pre3_idl_i 0 dc 0.9
vwbl0_idl_i bl_0_idl_i 0 dc 0
vwbl1_idl_i bl_1_idl_i 0 dc 0
vwbl2_idl_i bl_2_idl_i 0 dc 0
vwbl3_idl_i bl_3_idl_i 0 dc 0
vrwl0_idl_i rwl_0_idl_i 0 dc 1.8
vrwl1_idl_i rwl_1_idl_i 0 dc 1.8
vrwl2_idl_i rwl_2_idl_i 0 dc 1.8
vrwl3_idl_i rwl_3_idl_i 0 dc 1.8
vwwl0_idl_i wl_0_idl_i 0 dc 0
vwwl1_idl_i wl_1_idl_i 0 dc 0
vwwl2_idl_i wl_2_idl_i 0 dc 0
vwwl3_idl_i wl_3_idl_i 0 dc 0
vbody_idl_i gnd_idl_i 0 dc 0
vsub_idl_i vsubs_idl_i 0 dc 0
vctl_idl_i ctl_idl_i 0 dc 1.8   $ EXCLUDED: switch control, outside the boundary
spre0_idl_i pre0_idl_i rbl_0_idl_i ctl_idl_i 0 swpre
spre1_idl_i pre1_idl_i rbl_1_idl_i ctl_idl_i 0 swpre
spre2_idl_i pre2_idl_i rbl_2_idl_i ctl_idl_i 0 swpre
spre3_idl_i pre3_idl_i rbl_3_idl_i ctl_idl_i 0 swpre
bpn_vpre0_idl_i pn_vpre0_idl_i 0 v=(-v(pre0_idl_i)*i(vpre0_idl_i))
bpg_vpre0_idl_i pg_vpre0_idl_i 0 v=max((-v(pre0_idl_i)*i(vpre0_idl_i)),0)
bpr_vpre0_idl_i pr_vpre0_idl_i 0 v=max(-(-v(pre0_idl_i)*i(vpre0_idl_i)),0)
bpn_vpre1_idl_i pn_vpre1_idl_i 0 v=(-v(pre1_idl_i)*i(vpre1_idl_i))
bpg_vpre1_idl_i pg_vpre1_idl_i 0 v=max((-v(pre1_idl_i)*i(vpre1_idl_i)),0)
bpr_vpre1_idl_i pr_vpre1_idl_i 0 v=max(-(-v(pre1_idl_i)*i(vpre1_idl_i)),0)
bpn_vpre2_idl_i pn_vpre2_idl_i 0 v=(-v(pre2_idl_i)*i(vpre2_idl_i))
bpg_vpre2_idl_i pg_vpre2_idl_i 0 v=max((-v(pre2_idl_i)*i(vpre2_idl_i)),0)
bpr_vpre2_idl_i pr_vpre2_idl_i 0 v=max(-(-v(pre2_idl_i)*i(vpre2_idl_i)),0)
bpn_vpre3_idl_i pn_vpre3_idl_i 0 v=(-v(pre3_idl_i)*i(vpre3_idl_i))
bpg_vpre3_idl_i pg_vpre3_idl_i 0 v=max((-v(pre3_idl_i)*i(vpre3_idl_i)),0)
bpr_vpre3_idl_i pr_vpre3_idl_i 0 v=max(-(-v(pre3_idl_i)*i(vpre3_idl_i)),0)
bpn_vwbl0_idl_i pn_vwbl0_idl_i 0 v=(-v(bl_0_idl_i)*i(vwbl0_idl_i))
bpg_vwbl0_idl_i pg_vwbl0_idl_i 0 v=max((-v(bl_0_idl_i)*i(vwbl0_idl_i)),0)
bpr_vwbl0_idl_i pr_vwbl0_idl_i 0 v=max(-(-v(bl_0_idl_i)*i(vwbl0_idl_i)),0)
bpn_vwbl1_idl_i pn_vwbl1_idl_i 0 v=(-v(bl_1_idl_i)*i(vwbl1_idl_i))
bpg_vwbl1_idl_i pg_vwbl1_idl_i 0 v=max((-v(bl_1_idl_i)*i(vwbl1_idl_i)),0)
bpr_vwbl1_idl_i pr_vwbl1_idl_i 0 v=max(-(-v(bl_1_idl_i)*i(vwbl1_idl_i)),0)
bpn_vwbl2_idl_i pn_vwbl2_idl_i 0 v=(-v(bl_2_idl_i)*i(vwbl2_idl_i))
bpg_vwbl2_idl_i pg_vwbl2_idl_i 0 v=max((-v(bl_2_idl_i)*i(vwbl2_idl_i)),0)
bpr_vwbl2_idl_i pr_vwbl2_idl_i 0 v=max(-(-v(bl_2_idl_i)*i(vwbl2_idl_i)),0)
bpn_vwbl3_idl_i pn_vwbl3_idl_i 0 v=(-v(bl_3_idl_i)*i(vwbl3_idl_i))
bpg_vwbl3_idl_i pg_vwbl3_idl_i 0 v=max((-v(bl_3_idl_i)*i(vwbl3_idl_i)),0)
bpr_vwbl3_idl_i pr_vwbl3_idl_i 0 v=max(-(-v(bl_3_idl_i)*i(vwbl3_idl_i)),0)
bpn_vrwl0_idl_i pn_vrwl0_idl_i 0 v=(-v(rwl_0_idl_i)*i(vrwl0_idl_i))
bpg_vrwl0_idl_i pg_vrwl0_idl_i 0 v=max((-v(rwl_0_idl_i)*i(vrwl0_idl_i)),0)
bpr_vrwl0_idl_i pr_vrwl0_idl_i 0 v=max(-(-v(rwl_0_idl_i)*i(vrwl0_idl_i)),0)
bpn_vrwl1_idl_i pn_vrwl1_idl_i 0 v=(-v(rwl_1_idl_i)*i(vrwl1_idl_i))
bpg_vrwl1_idl_i pg_vrwl1_idl_i 0 v=max((-v(rwl_1_idl_i)*i(vrwl1_idl_i)),0)
bpr_vrwl1_idl_i pr_vrwl1_idl_i 0 v=max(-(-v(rwl_1_idl_i)*i(vrwl1_idl_i)),0)
bpn_vrwl2_idl_i pn_vrwl2_idl_i 0 v=(-v(rwl_2_idl_i)*i(vrwl2_idl_i))
bpg_vrwl2_idl_i pg_vrwl2_idl_i 0 v=max((-v(rwl_2_idl_i)*i(vrwl2_idl_i)),0)
bpr_vrwl2_idl_i pr_vrwl2_idl_i 0 v=max(-(-v(rwl_2_idl_i)*i(vrwl2_idl_i)),0)
bpn_vrwl3_idl_i pn_vrwl3_idl_i 0 v=(-v(rwl_3_idl_i)*i(vrwl3_idl_i))
bpg_vrwl3_idl_i pg_vrwl3_idl_i 0 v=max((-v(rwl_3_idl_i)*i(vrwl3_idl_i)),0)
bpr_vrwl3_idl_i pr_vrwl3_idl_i 0 v=max(-(-v(rwl_3_idl_i)*i(vrwl3_idl_i)),0)
bpn_vwwl0_idl_i pn_vwwl0_idl_i 0 v=(-v(wl_0_idl_i)*i(vwwl0_idl_i))
bpg_vwwl0_idl_i pg_vwwl0_idl_i 0 v=max((-v(wl_0_idl_i)*i(vwwl0_idl_i)),0)
bpr_vwwl0_idl_i pr_vwwl0_idl_i 0 v=max(-(-v(wl_0_idl_i)*i(vwwl0_idl_i)),0)
bpn_vwwl1_idl_i pn_vwwl1_idl_i 0 v=(-v(wl_1_idl_i)*i(vwwl1_idl_i))
bpg_vwwl1_idl_i pg_vwwl1_idl_i 0 v=max((-v(wl_1_idl_i)*i(vwwl1_idl_i)),0)
bpr_vwwl1_idl_i pr_vwwl1_idl_i 0 v=max(-(-v(wl_1_idl_i)*i(vwwl1_idl_i)),0)
bpn_vwwl2_idl_i pn_vwwl2_idl_i 0 v=(-v(wl_2_idl_i)*i(vwwl2_idl_i))
bpg_vwwl2_idl_i pg_vwwl2_idl_i 0 v=max((-v(wl_2_idl_i)*i(vwwl2_idl_i)),0)
bpr_vwwl2_idl_i pr_vwwl2_idl_i 0 v=max(-(-v(wl_2_idl_i)*i(vwwl2_idl_i)),0)
bpn_vwwl3_idl_i pn_vwwl3_idl_i 0 v=(-v(wl_3_idl_i)*i(vwwl3_idl_i))
bpg_vwwl3_idl_i pg_vwwl3_idl_i 0 v=max((-v(wl_3_idl_i)*i(vwwl3_idl_i)),0)
bpr_vwwl3_idl_i pr_vwwl3_idl_i 0 v=max(-(-v(wl_3_idl_i)*i(vwwl3_idl_i)),0)
bpn_vbody_idl_i pn_vbody_idl_i 0 v=(-v(gnd_idl_i)*i(vbody_idl_i))
bpg_vbody_idl_i pg_vbody_idl_i 0 v=max((-v(gnd_idl_i)*i(vbody_idl_i)),0)
bpr_vbody_idl_i pr_vbody_idl_i 0 v=max(-(-v(gnd_idl_i)*i(vbody_idl_i)),0)
bpn_vsub_idl_i pn_vsub_idl_i 0 v=(-v(vsubs_idl_i)*i(vsub_idl_i))
bpg_vsub_idl_i pg_vsub_idl_i 0 v=max((-v(vsubs_idl_i)*i(vsub_idl_i)),0)
bpr_vsub_idl_i pr_vsub_idl_i 0 v=max(-(-v(vsubs_idl_i)*i(vsub_idl_i)),0)

* ---- instance nop_c: mode nop, pattern checker ----
xm1_nop_c sn_0_0__t0_nop_c wl_0__t3_nop_c bl_0__t0_nop_c gnd__t0_nop_c sky130_fd_pr__nfet_01v8 L=0.15 W=0.42 nf=1 ad=0.1974 as=0.1974 pd=1.78 ps=1.78 mult=1 m=1
xm2_nop_c rbl_0__t0_nop_c sn_0_0__t1_nop_c rwl_0__t0_nop_c gnd__t1_nop_c sky130_fd_pr__nfet_01v8 L=0.15 W=0.42 nf=1 ad=0.1974 as=0.1974 pd=1.78 ps=1.78 mult=1 m=1
xm3_nop_c sn_0_1__t1_nop_c wl_0__t0_nop_c bl_1__t0_nop_c gnd__t2_nop_c sky130_fd_pr__nfet_01v8 L=0.15 W=0.42 nf=1 ad=0.1974 as=0.1974 pd=1.78 ps=1.78 mult=1 m=1
xm4_nop_c rbl_1__t0_nop_c sn_0_1__t0_nop_c rwl_0__t1_nop_c gnd__t3_nop_c sky130_fd_pr__nfet_01v8 L=0.15 W=0.42 nf=1 ad=0.1974 as=0.1974 pd=1.78 ps=1.78 mult=1 m=1
xm5_nop_c sn_0_2__t1_nop_c wl_0__t1_nop_c bl_2__t0_nop_c gnd__t4_nop_c sky130_fd_pr__nfet_01v8 L=0.15 W=0.42 nf=1 ad=0.1974 as=0.1974 pd=1.78 ps=1.78 mult=1 m=1
xm6_nop_c rbl_2__t0_nop_c sn_0_2__t0_nop_c rwl_0__t2_nop_c gnd__t5_nop_c sky130_fd_pr__nfet_01v8 L=0.15 W=0.42 nf=1 ad=0.1974 as=0.1974 pd=1.78 ps=1.78 mult=1 m=1
xm7_nop_c sn_0_3__t1_nop_c wl_0__t2_nop_c bl_3__t0_nop_c gnd__t6_nop_c sky130_fd_pr__nfet_01v8 L=0.15 W=0.42 nf=1 ad=0.1974 as=0.1974 pd=1.78 ps=1.78 mult=1 m=1
xm8_nop_c rbl_3__t0_nop_c sn_0_3__t0_nop_c rwl_0__t3_nop_c gnd__t7_nop_c sky130_fd_pr__nfet_01v8 L=0.15 W=0.42 nf=1 ad=0.1974 as=0.1974 pd=1.78 ps=1.78 mult=1 m=1
xm9_nop_c sn_1_0__t1_nop_c wl_1__t0_nop_c bl_0__t1_nop_c gnd__t8_nop_c sky130_fd_pr__nfet_01v8 L=0.15 W=0.42 nf=1 ad=0.1974 as=0.1974 pd=1.78 ps=1.78 mult=1 m=1
xm10_nop_c rbl_0__t1_nop_c sn_1_0__t0_nop_c rwl_1__t0_nop_c gnd__t9_nop_c sky130_fd_pr__nfet_01v8 L=0.15 W=0.42 nf=1 ad=0.1974 as=0.1974 pd=1.78 ps=1.78 mult=1 m=1
xm11_nop_c sn_1_1__t1_nop_c wl_1__t1_nop_c bl_1__t1_nop_c gnd__t10_nop_c sky130_fd_pr__nfet_01v8 L=0.15 W=0.42 nf=1 ad=0.1974 as=0.1974 pd=1.78 ps=1.78 mult=1 m=1
xm12_nop_c rbl_1__t1_nop_c sn_1_1__t0_nop_c rwl_1__t1_nop_c gnd__t11_nop_c sky130_fd_pr__nfet_01v8 L=0.15 W=0.42 nf=1 ad=0.1974 as=0.1974 pd=1.78 ps=1.78 mult=1 m=1
xm13_nop_c sn_1_2__t1_nop_c wl_1__t2_nop_c bl_2__t1_nop_c gnd__t12_nop_c sky130_fd_pr__nfet_01v8 L=0.15 W=0.42 nf=1 ad=0.1974 as=0.1974 pd=1.78 ps=1.78 mult=1 m=1
xm14_nop_c rbl_2__t1_nop_c sn_1_2__t0_nop_c rwl_1__t2_nop_c gnd__t13_nop_c sky130_fd_pr__nfet_01v8 L=0.15 W=0.42 nf=1 ad=0.1974 as=0.1974 pd=1.78 ps=1.78 mult=1 m=1
xm15_nop_c sn_1_3__t1_nop_c wl_1__t3_nop_c bl_3__t1_nop_c gnd__t14_nop_c sky130_fd_pr__nfet_01v8 L=0.15 W=0.42 nf=1 ad=0.1974 as=0.1974 pd=1.78 ps=1.78 mult=1 m=1
xm16_nop_c rbl_3__t1_nop_c sn_1_3__t0_nop_c rwl_1__t3_nop_c gnd__t15_nop_c sky130_fd_pr__nfet_01v8 L=0.15 W=0.42 nf=1 ad=0.1974 as=0.1974 pd=1.78 ps=1.78 mult=1 m=1
xm17_nop_c sn_2_0__t1_nop_c wl_2__t3_nop_c bl_0__t3_nop_c gnd__t16_nop_c sky130_fd_pr__nfet_01v8 L=0.15 W=0.42 nf=1 ad=0.1974 as=0.1974 pd=1.78 ps=1.78 mult=1 m=1
xm18_nop_c rbl_0__t2_nop_c sn_2_0__t0_nop_c rwl_2__t0_nop_c gnd__t17_nop_c sky130_fd_pr__nfet_01v8 L=0.15 W=0.42 nf=1 ad=0.1974 as=0.1974 pd=1.78 ps=1.78 mult=1 m=1
xm19_nop_c sn_2_1__t1_nop_c wl_2__t0_nop_c bl_1__t2_nop_c gnd__t18_nop_c sky130_fd_pr__nfet_01v8 L=0.15 W=0.42 nf=1 ad=0.1974 as=0.1974 pd=1.78 ps=1.78 mult=1 m=1
xm20_nop_c rbl_1__t2_nop_c sn_2_1__t0_nop_c rwl_2__t1_nop_c gnd__t19_nop_c sky130_fd_pr__nfet_01v8 L=0.15 W=0.42 nf=1 ad=0.1974 as=0.1974 pd=1.78 ps=1.78 mult=1 m=1
xm21_nop_c sn_2_2__t1_nop_c wl_2__t1_nop_c bl_2__t2_nop_c gnd__t20_nop_c sky130_fd_pr__nfet_01v8 L=0.15 W=0.42 nf=1 ad=0.1974 as=0.1974 pd=1.78 ps=1.78 mult=1 m=1
xm22_nop_c rbl_2__t2_nop_c sn_2_2__t0_nop_c rwl_2__t2_nop_c gnd__t21_nop_c sky130_fd_pr__nfet_01v8 L=0.15 W=0.42 nf=1 ad=0.1974 as=0.1974 pd=1.78 ps=1.78 mult=1 m=1
xm23_nop_c sn_2_3__t1_nop_c wl_2__t2_nop_c bl_3__t2_nop_c gnd__t22_nop_c sky130_fd_pr__nfet_01v8 L=0.15 W=0.42 nf=1 ad=0.1974 as=0.1974 pd=1.78 ps=1.78 mult=1 m=1
xm24_nop_c rbl_3__t2_nop_c sn_2_3__t0_nop_c rwl_2__t3_nop_c gnd__t23_nop_c sky130_fd_pr__nfet_01v8 L=0.15 W=0.42 nf=1 ad=0.1974 as=0.1974 pd=1.78 ps=1.78 mult=1 m=1
xm25_nop_c sn_3_0__t1_nop_c wl_3__t0_nop_c bl_0__t2_nop_c gnd__t24_nop_c sky130_fd_pr__nfet_01v8 L=0.15 W=0.42 nf=1 ad=0.1974 as=0.1974 pd=1.78 ps=1.78 mult=1 m=1
xm26_nop_c rbl_0__t3_nop_c sn_3_0__t0_nop_c rwl_3__t0_nop_c gnd__t25_nop_c sky130_fd_pr__nfet_01v8 L=0.15 W=0.42 nf=1 ad=0.1974 as=0.1974 pd=1.78 ps=1.78 mult=1 m=1
xm27_nop_c sn_3_1__t1_nop_c wl_3__t1_nop_c bl_1__t3_nop_c gnd__t26_nop_c sky130_fd_pr__nfet_01v8 L=0.15 W=0.42 nf=1 ad=0.1974 as=0.1974 pd=1.78 ps=1.78 mult=1 m=1
xm28_nop_c rbl_1__t3_nop_c sn_3_1__t0_nop_c rwl_3__t1_nop_c gnd__t27_nop_c sky130_fd_pr__nfet_01v8 L=0.15 W=0.42 nf=1 ad=0.1974 as=0.1974 pd=1.78 ps=1.78 mult=1 m=1
xm29_nop_c sn_3_2__t1_nop_c wl_3__t2_nop_c bl_2__t3_nop_c gnd__t28_nop_c sky130_fd_pr__nfet_01v8 L=0.15 W=0.42 nf=1 ad=0.1974 as=0.1974 pd=1.78 ps=1.78 mult=1 m=1
xm30_nop_c rbl_2__t3_nop_c sn_3_2__t0_nop_c rwl_3__t2_nop_c gnd__t29_nop_c sky130_fd_pr__nfet_01v8 L=0.15 W=0.42 nf=1 ad=0.1974 as=0.1974 pd=1.78 ps=1.78 mult=1 m=1
xm31_nop_c sn_3_3__t1_nop_c wl_3__t3_nop_c bl_3__t3_nop_c gnd__t30_nop_c sky130_fd_pr__nfet_01v8 L=0.15 W=0.42 nf=1 ad=0.1974 as=0.1974 pd=1.78 ps=1.78 mult=1 m=1
xm32_nop_c rbl_3__t3_nop_c sn_3_3__t0_nop_c rwl_3__t3_nop_c gnd__t31_nop_c sky130_fd_pr__nfet_01v8 L=0.15 W=0.42 nf=1 ad=0.1974 as=0.1974 pd=1.78 ps=1.78 mult=1 m=1
rgnd_t0_nop_c gnd__t0_nop_c gnd_nop_c 63.3529
rgnd_t1_nop_c gnd__t1_nop_c gnd_nop_c 49.0465
rgnd_t2_nop_c gnd__t2_nop_c gnd_nop_c 36.5177
rgnd_t3_nop_c gnd__t3_nop_c gnd_nop_c 28.2406
rgnd_t4_nop_c gnd__t4_nop_c gnd_nop_c 28.2406
rgnd_t5_nop_c gnd__t5_nop_c gnd_nop_c 36.5177
rgnd_t6_nop_c gnd__t6_nop_c gnd_nop_c 49.0465
rgnd_t7_nop_c gnd__t7_nop_c gnd_nop_c 63.3529
rgnd_t8_nop_c gnd__t8_nop_c gnd_nop_c 58.0019
rgnd_t9_nop_c gnd__t9_nop_c gnd_nop_c 41.907
rgnd_t10_nop_c gnd__t10_nop_c gnd_nop_c 26.1568
rgnd_t11_nop_c gnd__t11_nop_c gnd_nop_c 12.1726
rgnd_t12_nop_c gnd__t12_nop_c gnd_nop_c 12.1726
rgnd_t13_nop_c gnd__t13_nop_c gnd_nop_c 26.1568
rgnd_t14_nop_c gnd__t14_nop_c gnd_nop_c 41.907
rgnd_t15_nop_c gnd__t15_nop_c gnd_nop_c 58.0019
rgnd_t16_nop_c gnd__t16_nop_c gnd_nop_c 58.0019
rgnd_t17_nop_c gnd__t17_nop_c gnd_nop_c 41.907
rgnd_t18_nop_c gnd__t18_nop_c gnd_nop_c 26.1568
rgnd_t19_nop_c gnd__t19_nop_c gnd_nop_c 12.1726
rgnd_t20_nop_c gnd__t20_nop_c gnd_nop_c 12.1726
rgnd_t21_nop_c gnd__t21_nop_c gnd_nop_c 26.1568
rgnd_t22_nop_c gnd__t22_nop_c gnd_nop_c 41.907
rgnd_t23_nop_c gnd__t23_nop_c gnd_nop_c 58.0019
rgnd_t24_nop_c gnd__t24_nop_c gnd_nop_c 63.3529
rgnd_t25_nop_c gnd__t25_nop_c gnd_nop_c 49.0465
rgnd_t26_nop_c gnd__t26_nop_c gnd_nop_c 36.5177
rgnd_t27_nop_c gnd__t27_nop_c gnd_nop_c 28.2406
rgnd_t28_nop_c gnd__t28_nop_c gnd_nop_c 28.2406
rgnd_t29_nop_c gnd__t29_nop_c gnd_nop_c 36.5177
rgnd_t30_nop_c gnd__t30_nop_c gnd_nop_c 49.0465
rgnd_t31_nop_c gnd__t31_nop_c gnd_nop_c 63.3529
rbl_0_t0_nop_c bl_0__t0_nop_c bl_0_nop_c 144.555
rbl_0_t1_nop_c bl_0__t1_nop_c bl_0_nop_c 48.1851
rbl_0_t2_nop_c bl_0__t2_nop_c bl_0_nop_c 144.555
rbl_0_t3_nop_c bl_0__t3_nop_c bl_0_nop_c 48.1851
rbl_1_t0_nop_c bl_1__t0_nop_c bl_1_nop_c 144.555
rbl_1_t1_nop_c bl_1__t1_nop_c bl_1_nop_c 48.1851
rbl_1_t2_nop_c bl_1__t2_nop_c bl_1_nop_c 48.1851
rbl_1_t3_nop_c bl_1__t3_nop_c bl_1_nop_c 144.555
rbl_2_t0_nop_c bl_2__t0_nop_c bl_2_nop_c 144.555
rbl_2_t1_nop_c bl_2__t1_nop_c bl_2_nop_c 48.1851
rbl_2_t2_nop_c bl_2__t2_nop_c bl_2_nop_c 48.1851
rbl_2_t3_nop_c bl_2__t3_nop_c bl_2_nop_c 144.555
rbl_3_t0_nop_c bl_3__t0_nop_c bl_3_nop_c 144.555
rbl_3_t1_nop_c bl_3__t1_nop_c bl_3_nop_c 48.1851
rbl_3_t2_nop_c bl_3__t2_nop_c bl_3_nop_c 48.1851
rbl_3_t3_nop_c bl_3__t3_nop_c bl_3_nop_c 144.555
rrbl_0_t0_nop_c rbl_0__t0_nop_c rbl_0_nop_c 144.555
rrbl_0_t1_nop_c rbl_0__t1_nop_c rbl_0_nop_c 48.1851
rrbl_0_t2_nop_c rbl_0__t2_nop_c rbl_0_nop_c 48.1851
rrbl_0_t3_nop_c rbl_0__t3_nop_c rbl_0_nop_c 144.555
rrbl_1_t0_nop_c rbl_1__t0_nop_c rbl_1_nop_c 144.555
rrbl_1_t1_nop_c rbl_1__t1_nop_c rbl_1_nop_c 48.1851
rrbl_1_t2_nop_c rbl_1__t2_nop_c rbl_1_nop_c 48.1851
rrbl_1_t3_nop_c rbl_1__t3_nop_c rbl_1_nop_c 144.555
rrbl_2_t0_nop_c rbl_2__t0_nop_c rbl_2_nop_c 144.555
rrbl_2_t1_nop_c rbl_2__t1_nop_c rbl_2_nop_c 48.1851
rrbl_2_t2_nop_c rbl_2__t2_nop_c rbl_2_nop_c 48.1851
rrbl_2_t3_nop_c rbl_2__t3_nop_c rbl_2_nop_c 144.555
rrbl_3_t0_nop_c rbl_3__t0_nop_c rbl_3_nop_c 144.555
rrbl_3_t1_nop_c rbl_3__t1_nop_c rbl_3_nop_c 48.1851
rrbl_3_t2_nop_c rbl_3__t2_nop_c rbl_3_nop_c 48.1851
rrbl_3_t3_nop_c rbl_3__t3_nop_c rbl_3_nop_c 144.555
rrwl_0_t0_nop_c rwl_0__t0_nop_c rwl_0_nop_c 21.6897
rrwl_0_t1_nop_c rwl_0__t1_nop_c rwl_0_nop_c 7.22989
rrwl_0_t2_nop_c rwl_0__t2_nop_c rwl_0_nop_c 7.22989
rrwl_0_t3_nop_c rwl_0__t3_nop_c rwl_0_nop_c 21.6897
rrwl_1_t0_nop_c rwl_1__t0_nop_c rwl_1_nop_c 21.6897
rrwl_1_t1_nop_c rwl_1__t1_nop_c rwl_1_nop_c 7.22989
rrwl_1_t2_nop_c rwl_1__t2_nop_c rwl_1_nop_c 7.22989
rrwl_1_t3_nop_c rwl_1__t3_nop_c rwl_1_nop_c 21.6897
rrwl_2_t0_nop_c rwl_2__t0_nop_c rwl_2_nop_c 21.6897
rrwl_2_t1_nop_c rwl_2__t1_nop_c rwl_2_nop_c 7.22989
rrwl_2_t2_nop_c rwl_2__t2_nop_c rwl_2_nop_c 7.22989
rrwl_2_t3_nop_c rwl_2__t3_nop_c rwl_2_nop_c 21.6897
rrwl_3_t0_nop_c rwl_3__t0_nop_c rwl_3_nop_c 21.6897
rrwl_3_t1_nop_c rwl_3__t1_nop_c rwl_3_nop_c 7.22989
rrwl_3_t2_nop_c rwl_3__t2_nop_c rwl_3_nop_c 7.22989
rrwl_3_t3_nop_c rwl_3__t3_nop_c rwl_3_nop_c 21.6897
rsn_0_0_t0_nop_c sn_0_0__t0_nop_c sn_0_0_nop_c 125.123
rsn_0_0_t1_nop_c sn_0_0__t1_nop_c sn_0_0_nop_c 125.123
rsn_0_1_t0_nop_c sn_0_1__t0_nop_c sn_0_1_nop_c 125.123
rsn_0_1_t1_nop_c sn_0_1__t1_nop_c sn_0_1_nop_c 125.123
rsn_0_2_t0_nop_c sn_0_2__t0_nop_c sn_0_2_nop_c 125.123
rsn_0_2_t1_nop_c sn_0_2__t1_nop_c sn_0_2_nop_c 125.123
rsn_0_3_t0_nop_c sn_0_3__t0_nop_c sn_0_3_nop_c 125.123
rsn_0_3_t1_nop_c sn_0_3__t1_nop_c sn_0_3_nop_c 125.123
rsn_1_0_t0_nop_c sn_1_0__t0_nop_c sn_1_0_nop_c 125.123
rsn_1_0_t1_nop_c sn_1_0__t1_nop_c sn_1_0_nop_c 125.123
rsn_1_1_t0_nop_c sn_1_1__t0_nop_c sn_1_1_nop_c 125.123
rsn_1_1_t1_nop_c sn_1_1__t1_nop_c sn_1_1_nop_c 125.123
rsn_1_2_t0_nop_c sn_1_2__t0_nop_c sn_1_2_nop_c 125.123
rsn_1_2_t1_nop_c sn_1_2__t1_nop_c sn_1_2_nop_c 125.123
rsn_1_3_t0_nop_c sn_1_3__t0_nop_c sn_1_3_nop_c 125.123
rsn_1_3_t1_nop_c sn_1_3__t1_nop_c sn_1_3_nop_c 125.123
rsn_2_0_t0_nop_c sn_2_0__t0_nop_c sn_2_0_nop_c 125.123
rsn_2_0_t1_nop_c sn_2_0__t1_nop_c sn_2_0_nop_c 125.123
rsn_2_1_t0_nop_c sn_2_1__t0_nop_c sn_2_1_nop_c 125.123
rsn_2_1_t1_nop_c sn_2_1__t1_nop_c sn_2_1_nop_c 125.123
rsn_2_2_t0_nop_c sn_2_2__t0_nop_c sn_2_2_nop_c 125.123
rsn_2_2_t1_nop_c sn_2_2__t1_nop_c sn_2_2_nop_c 125.123
rsn_2_3_t0_nop_c sn_2_3__t0_nop_c sn_2_3_nop_c 125.123
rsn_2_3_t1_nop_c sn_2_3__t1_nop_c sn_2_3_nop_c 125.123
rsn_3_0_t0_nop_c sn_3_0__t0_nop_c sn_3_0_nop_c 125.123
rsn_3_0_t1_nop_c sn_3_0__t1_nop_c sn_3_0_nop_c 125.123
rsn_3_1_t0_nop_c sn_3_1__t0_nop_c sn_3_1_nop_c 125.123
rsn_3_1_t1_nop_c sn_3_1__t1_nop_c sn_3_1_nop_c 125.123
rsn_3_2_t0_nop_c sn_3_2__t0_nop_c sn_3_2_nop_c 125.123
rsn_3_2_t1_nop_c sn_3_2__t1_nop_c sn_3_2_nop_c 125.123
rsn_3_3_t0_nop_c sn_3_3__t0_nop_c sn_3_3_nop_c 125.123
rsn_3_3_t1_nop_c sn_3_3__t1_nop_c sn_3_3_nop_c 125.123
rwl_0_t0_nop_c wl_0__t0_nop_c wl_0_nop_c 54.2844
rwl_0_t1_nop_c wl_0__t1_nop_c wl_0_nop_c 54.2844
rwl_0_t2_nop_c wl_0__t2_nop_c wl_0_nop_c 162.853
rwl_0_t3_nop_c wl_0__t3_nop_c wl_0_nop_c 162.853
rwl_1_t0_nop_c wl_1__t0_nop_c wl_1_nop_c 162.853
rwl_1_t1_nop_c wl_1__t1_nop_c wl_1_nop_c 54.2844
rwl_1_t2_nop_c wl_1__t2_nop_c wl_1_nop_c 54.2844
rwl_1_t3_nop_c wl_1__t3_nop_c wl_1_nop_c 162.853
rwl_2_t0_nop_c wl_2__t0_nop_c wl_2_nop_c 54.2844
rwl_2_t1_nop_c wl_2__t1_nop_c wl_2_nop_c 54.2844
rwl_2_t2_nop_c wl_2__t2_nop_c wl_2_nop_c 162.853
rwl_2_t3_nop_c wl_2__t3_nop_c wl_2_nop_c 162.853
rwl_3_t0_nop_c wl_3__t0_nop_c wl_3_nop_c 162.853
rwl_3_t1_nop_c wl_3__t1_nop_c wl_3_nop_c 54.2844
rwl_3_t2_nop_c wl_3__t2_nop_c wl_3_nop_c 54.2844
rwl_3_t3_nop_c wl_3__t3_nop_c wl_3_nop_c 162.853
cgnd_nop_c gnd_nop_c vsubs_nop_c 4.09475e-15
cbl_0_nop_c bl_0_nop_c vsubs_nop_c 5.96076e-16
cbl_1_nop_c bl_1_nop_c vsubs_nop_c 5.81168e-16
cbl_2_nop_c bl_2_nop_c vsubs_nop_c 5.81168e-16
cbl_3_nop_c bl_3_nop_c vsubs_nop_c 5.81168e-16
crbl_0_nop_c rbl_0_nop_c vsubs_nop_c 5.81168e-16
crbl_1_nop_c rbl_1_nop_c vsubs_nop_c 5.81168e-16
crbl_2_nop_c rbl_2_nop_c vsubs_nop_c 5.81168e-16
crbl_3_nop_c rbl_3_nop_c vsubs_nop_c 5.96076e-16
crwl_0_nop_c rwl_0_nop_c vsubs_nop_c 1.18713e-15
crwl_1_nop_c rwl_1_nop_c vsubs_nop_c 1.18713e-15
crwl_2_nop_c rwl_2_nop_c vsubs_nop_c 1.18713e-15
crwl_3_nop_c rwl_3_nop_c vsubs_nop_c 1.18713e-15
csn_0_0_nop_c sn_0_0_nop_c vsubs_nop_c 4.33689e-16
csn_0_1_nop_c sn_0_1_nop_c vsubs_nop_c 4.30576e-16
csn_0_2_nop_c sn_0_2_nop_c vsubs_nop_c 4.30576e-16
csn_0_3_nop_c sn_0_3_nop_c vsubs_nop_c 4.32518e-16
csn_1_0_nop_c sn_1_0_nop_c vsubs_nop_c 4.33689e-16
csn_1_1_nop_c sn_1_1_nop_c vsubs_nop_c 4.30576e-16
csn_1_2_nop_c sn_1_2_nop_c vsubs_nop_c 4.30576e-16
csn_1_3_nop_c sn_1_3_nop_c vsubs_nop_c 4.32518e-16
csn_2_0_nop_c sn_2_0_nop_c vsubs_nop_c 4.33689e-16
csn_2_1_nop_c sn_2_1_nop_c vsubs_nop_c 4.30576e-16
csn_2_2_nop_c sn_2_2_nop_c vsubs_nop_c 4.30576e-16
csn_2_3_nop_c sn_2_3_nop_c vsubs_nop_c 4.32518e-16
csn_3_0_nop_c sn_3_0_nop_c vsubs_nop_c 4.33689e-16
csn_3_1_nop_c sn_3_1_nop_c vsubs_nop_c 4.30576e-16
csn_3_2_nop_c sn_3_2_nop_c vsubs_nop_c 4.30576e-16
csn_3_3_nop_c sn_3_3_nop_c vsubs_nop_c 4.32518e-16
cwl_0_nop_c wl_0_nop_c vsubs_nop_c 1.90928e-15
cwl_1_nop_c wl_1_nop_c vsubs_nop_c 1.90928e-15
cwl_2_nop_c wl_2_nop_c vsubs_nop_c 1.90928e-15
cwl_3_nop_c wl_3_nop_c vsubs_nop_c 1.91375e-15
ccc_bl_0_sn_0_0_nop_c bl_0_nop_c sn_0_0_nop_c 1.071e-17
ccc_bl_0_sn_1_0_nop_c bl_0_nop_c sn_1_0_nop_c 1.071e-17
ccc_bl_0_sn_2_0_nop_c bl_0_nop_c sn_2_0_nop_c 1.071e-17
ccc_bl_0_sn_3_0_nop_c bl_0_nop_c sn_3_0_nop_c 1.071e-17
ccc_bl_0_wl_0_nop_c bl_0_nop_c wl_0_nop_c 2.4327e-17
ccc_bl_0_wl_1_nop_c bl_0_nop_c wl_1_nop_c 2.4327e-17
ccc_bl_0_wl_2_nop_c bl_0_nop_c wl_2_nop_c 2.4327e-17
ccc_bl_1_rbl_0_nop_c bl_1_nop_c rbl_0_nop_c 1.29795e-16
ccc_bl_1_rwl_0_nop_c bl_1_nop_c rwl_0_nop_c 9.028e-18
ccc_bl_1_rwl_1_nop_c bl_1_nop_c rwl_1_nop_c 9.028e-18
ccc_bl_1_rwl_2_nop_c bl_1_nop_c rwl_2_nop_c 9.028e-18
ccc_bl_1_rwl_3_nop_c bl_1_nop_c rwl_3_nop_c 9.028e-18
ccc_bl_1_sn_0_1_nop_c bl_1_nop_c sn_0_1_nop_c 1.071e-17
ccc_bl_1_sn_1_1_nop_c bl_1_nop_c sn_1_1_nop_c 1.071e-17
ccc_bl_1_sn_2_1_nop_c bl_1_nop_c sn_2_1_nop_c 1.071e-17
ccc_bl_1_sn_3_1_nop_c bl_1_nop_c sn_3_1_nop_c 1.071e-17
ccc_bl_1_wl_0_nop_c bl_1_nop_c wl_0_nop_c 2.7627e-17
ccc_bl_1_wl_1_nop_c bl_1_nop_c wl_1_nop_c 2.7627e-17
ccc_bl_1_wl_2_nop_c bl_1_nop_c wl_2_nop_c 2.7627e-17
ccc_bl_2_rbl_1_nop_c bl_2_nop_c rbl_1_nop_c 1.29795e-16
ccc_bl_2_rwl_0_nop_c bl_2_nop_c rwl_0_nop_c 9.028e-18
ccc_bl_2_rwl_1_nop_c bl_2_nop_c rwl_1_nop_c 9.028e-18
ccc_bl_2_rwl_2_nop_c bl_2_nop_c rwl_2_nop_c 9.028e-18
ccc_bl_2_rwl_3_nop_c bl_2_nop_c rwl_3_nop_c 9.028e-18
ccc_bl_2_sn_0_2_nop_c bl_2_nop_c sn_0_2_nop_c 1.071e-17
ccc_bl_2_sn_1_2_nop_c bl_2_nop_c sn_1_2_nop_c 1.071e-17
ccc_bl_2_sn_2_2_nop_c bl_2_nop_c sn_2_2_nop_c 1.071e-17
ccc_bl_2_sn_3_2_nop_c bl_2_nop_c sn_3_2_nop_c 1.071e-17
ccc_bl_2_wl_0_nop_c bl_2_nop_c wl_0_nop_c 2.7627e-17
ccc_bl_2_wl_1_nop_c bl_2_nop_c wl_1_nop_c 2.7627e-17
ccc_bl_2_wl_2_nop_c bl_2_nop_c wl_2_nop_c 2.7627e-17
ccc_bl_3_rbl_2_nop_c bl_3_nop_c rbl_2_nop_c 1.29795e-16
ccc_bl_3_rwl_0_nop_c bl_3_nop_c rwl_0_nop_c 9.028e-18
ccc_bl_3_rwl_1_nop_c bl_3_nop_c rwl_1_nop_c 9.028e-18
ccc_bl_3_rwl_2_nop_c bl_3_nop_c rwl_2_nop_c 9.028e-18
ccc_bl_3_rwl_3_nop_c bl_3_nop_c rwl_3_nop_c 9.028e-18
ccc_bl_3_sn_0_3_nop_c bl_3_nop_c sn_0_3_nop_c 1.071e-17
ccc_bl_3_sn_1_3_nop_c bl_3_nop_c sn_1_3_nop_c 1.071e-17
ccc_bl_3_sn_2_3_nop_c bl_3_nop_c sn_2_3_nop_c 1.071e-17
ccc_bl_3_sn_3_3_nop_c bl_3_nop_c sn_3_3_nop_c 1.071e-17
ccc_bl_3_wl_0_nop_c bl_3_nop_c wl_0_nop_c 2.7627e-17
ccc_bl_3_wl_1_nop_c bl_3_nop_c wl_1_nop_c 2.7627e-17
ccc_bl_3_wl_2_nop_c bl_3_nop_c wl_2_nop_c 2.7627e-17
ccc_rbl_0_rwl_0_nop_c rbl_0_nop_c rwl_0_nop_c 1.9738e-17
ccc_rbl_0_rwl_1_nop_c rbl_0_nop_c rwl_1_nop_c 1.9738e-17
ccc_rbl_0_rwl_2_nop_c rbl_0_nop_c rwl_2_nop_c 1.9738e-17
ccc_rbl_0_rwl_3_nop_c rbl_0_nop_c rwl_3_nop_c 1.9738e-17
ccc_rbl_0_sn_0_0_nop_c rbl_0_nop_c sn_0_0_nop_c 1.071e-17
ccc_rbl_0_sn_1_0_nop_c rbl_0_nop_c sn_1_0_nop_c 2.4327e-17
ccc_rbl_0_sn_2_0_nop_c rbl_0_nop_c sn_2_0_nop_c 2.4327e-17
ccc_rbl_0_wl_0_nop_c rbl_0_nop_c wl_0_nop_c 3.3e-18
ccc_rbl_0_wl_1_nop_c rbl_0_nop_c wl_1_nop_c 3.3e-18
ccc_rbl_0_wl_2_nop_c rbl_0_nop_c wl_2_nop_c 3.3e-18
ccc_rbl_1_rwl_0_nop_c rbl_1_nop_c rwl_0_nop_c 1.9738e-17
ccc_rbl_1_rwl_1_nop_c rbl_1_nop_c rwl_1_nop_c 1.9738e-17
ccc_rbl_1_rwl_2_nop_c rbl_1_nop_c rwl_2_nop_c 1.9738e-17
ccc_rbl_1_rwl_3_nop_c rbl_1_nop_c rwl_3_nop_c 1.9738e-17
ccc_rbl_1_sn_0_1_nop_c rbl_1_nop_c sn_0_1_nop_c 1.071e-17
ccc_rbl_1_sn_1_1_nop_c rbl_1_nop_c sn_1_1_nop_c 2.4327e-17
ccc_rbl_1_sn_2_1_nop_c rbl_1_nop_c sn_2_1_nop_c 2.4327e-17
ccc_rbl_1_wl_0_nop_c rbl_1_nop_c wl_0_nop_c 3.3e-18
ccc_rbl_1_wl_1_nop_c rbl_1_nop_c wl_1_nop_c 3.3e-18
ccc_rbl_1_wl_2_nop_c rbl_1_nop_c wl_2_nop_c 3.3e-18
ccc_rbl_2_rwl_0_nop_c rbl_2_nop_c rwl_0_nop_c 1.9738e-17
ccc_rbl_2_rwl_1_nop_c rbl_2_nop_c rwl_1_nop_c 1.9738e-17
ccc_rbl_2_rwl_2_nop_c rbl_2_nop_c rwl_2_nop_c 1.9738e-17
ccc_rbl_2_rwl_3_nop_c rbl_2_nop_c rwl_3_nop_c 1.9738e-17
ccc_rbl_2_sn_0_2_nop_c rbl_2_nop_c sn_0_2_nop_c 1.071e-17
ccc_rbl_2_sn_1_2_nop_c rbl_2_nop_c sn_1_2_nop_c 2.4327e-17
ccc_rbl_2_sn_2_2_nop_c rbl_2_nop_c sn_2_2_nop_c 2.4327e-17
ccc_rbl_2_wl_0_nop_c rbl_2_nop_c wl_0_nop_c 3.3e-18
ccc_rbl_2_wl_1_nop_c rbl_2_nop_c wl_1_nop_c 3.3e-18
ccc_rbl_2_wl_2_nop_c rbl_2_nop_c wl_2_nop_c 3.3e-18
ccc_rbl_3_rwl_0_nop_c rbl_3_nop_c rwl_0_nop_c 1.071e-17
ccc_rbl_3_rwl_1_nop_c rbl_3_nop_c rwl_1_nop_c 1.071e-17
ccc_rbl_3_rwl_2_nop_c rbl_3_nop_c rwl_2_nop_c 1.071e-17
ccc_rbl_3_rwl_3_nop_c rbl_3_nop_c rwl_3_nop_c 1.071e-17
ccc_rbl_3_sn_0_3_nop_c rbl_3_nop_c sn_0_3_nop_c 1.071e-17
ccc_rbl_3_sn_1_3_nop_c rbl_3_nop_c sn_1_3_nop_c 2.4327e-17
ccc_rbl_3_sn_2_3_nop_c rbl_3_nop_c sn_2_3_nop_c 2.4327e-17
ccc_rwl_0_sn_0_0_nop_c rwl_0_nop_c sn_0_0_nop_c 1.0072e-17
ccc_rwl_0_sn_0_1_nop_c rwl_0_nop_c sn_0_1_nop_c 1.9682e-17
ccc_rwl_0_sn_0_2_nop_c rwl_0_nop_c sn_0_2_nop_c 1.9682e-17
ccc_rwl_0_sn_0_3_nop_c rwl_0_nop_c sn_0_3_nop_c 1.9682e-17
ccc_rwl_1_sn_1_0_nop_c rwl_1_nop_c sn_1_0_nop_c 1.0072e-17
ccc_rwl_1_sn_1_1_nop_c rwl_1_nop_c sn_1_1_nop_c 1.9682e-17
ccc_rwl_1_sn_1_2_nop_c rwl_1_nop_c sn_1_2_nop_c 1.9682e-17
ccc_rwl_1_sn_1_3_nop_c rwl_1_nop_c sn_1_3_nop_c 1.9682e-17
ccc_rwl_2_sn_2_0_nop_c rwl_2_nop_c sn_2_0_nop_c 1.0072e-17
ccc_rwl_2_sn_2_1_nop_c rwl_2_nop_c sn_2_1_nop_c 1.9682e-17
ccc_rwl_2_sn_2_2_nop_c rwl_2_nop_c sn_2_2_nop_c 1.9682e-17
ccc_rwl_2_sn_2_3_nop_c rwl_2_nop_c sn_2_3_nop_c 1.9682e-17
ccc_rwl_3_sn_3_0_nop_c rwl_3_nop_c sn_3_0_nop_c 1.0072e-17
ccc_rwl_3_sn_3_1_nop_c rwl_3_nop_c sn_3_1_nop_c 1.9682e-17
ccc_rwl_3_sn_3_2_nop_c rwl_3_nop_c sn_3_2_nop_c 1.9682e-17
ccc_rwl_3_sn_3_3_nop_c rwl_3_nop_c sn_3_3_nop_c 1.9682e-17
ccc_sn_0_0_wl_0_nop_c sn_0_0_nop_c wl_0_nop_c 1.9664e-17
ccc_sn_0_1_wl_0_nop_c sn_0_1_nop_c wl_0_nop_c 1.9664e-17
ccc_sn_0_2_wl_0_nop_c sn_0_2_nop_c wl_0_nop_c 1.9664e-17
ccc_sn_0_3_wl_0_nop_c sn_0_3_nop_c wl_0_nop_c 1.3668e-17
ccc_sn_1_0_wl_1_nop_c sn_1_0_nop_c wl_1_nop_c 1.9664e-17
ccc_sn_1_1_wl_1_nop_c sn_1_1_nop_c wl_1_nop_c 1.6705e-17
ccc_sn_1_2_wl_1_nop_c sn_1_2_nop_c wl_1_nop_c 1.6705e-17
ccc_sn_1_3_wl_1_nop_c sn_1_3_nop_c wl_1_nop_c 1.071e-17
ccc_sn_2_0_wl_2_nop_c sn_2_0_nop_c wl_2_nop_c 1.9664e-17
ccc_sn_2_1_wl_2_nop_c sn_2_1_nop_c wl_2_nop_c 1.6705e-17
ccc_sn_2_2_wl_2_nop_c sn_2_2_nop_c wl_2_nop_c 1.6705e-17
ccc_sn_2_3_wl_2_nop_c sn_2_3_nop_c wl_2_nop_c 1.071e-17
ccc_sn_3_0_wl_3_nop_c sn_3_0_nop_c wl_3_nop_c 1.9664e-17
ccc_sn_3_1_wl_3_nop_c sn_3_1_nop_c wl_3_nop_c 1.6705e-17
ccc_sn_3_2_wl_3_nop_c sn_3_2_nop_c wl_3_nop_c 1.6705e-17
ccc_sn_3_3_wl_3_nop_c sn_3_3_nop_c wl_3_nop_c 1.071e-17
vpre0_nop_c pre0_nop_c 0 dc 0.9
vpre1_nop_c pre1_nop_c 0 dc 0.9
vpre2_nop_c pre2_nop_c 0 dc 0.9
vpre3_nop_c pre3_nop_c 0 dc 0.9
vwbl0_nop_c bl_0_nop_c 0 dc 0
vwbl1_nop_c bl_1_nop_c 0 dc 0
vwbl2_nop_c bl_2_nop_c 0 dc 0
vwbl3_nop_c bl_3_nop_c 0 dc 0
vrwl0_nop_c rwl_0_nop_c 0 dc 1.8
vrwl1_nop_c rwl_1_nop_c 0 dc 1.8
vrwl2_nop_c rwl_2_nop_c 0 dc 1.8
vrwl3_nop_c rwl_3_nop_c 0 dc 1.8
vwwl0_nop_c wl_0_nop_c 0 dc 0
vwwl1_nop_c wl_1_nop_c 0 dc 0
vwwl2_nop_c wl_2_nop_c 0 dc 0
vwwl3_nop_c wl_3_nop_c 0 dc 0
vbody_nop_c gnd_nop_c 0 dc 0
vsub_nop_c vsubs_nop_c 0 dc 0
vctl_nop_c ctl_nop_c 0 dc 1.8   $ EXCLUDED: switch control, outside the boundary
spre0_nop_c pre0_nop_c rbl_0_nop_c ctl_nop_c 0 swpre
spre1_nop_c pre1_nop_c rbl_1_nop_c ctl_nop_c 0 swpre
spre2_nop_c pre2_nop_c rbl_2_nop_c ctl_nop_c 0 swpre
spre3_nop_c pre3_nop_c rbl_3_nop_c ctl_nop_c 0 swpre
bpn_vpre0_nop_c pn_vpre0_nop_c 0 v=(-v(pre0_nop_c)*i(vpre0_nop_c))
bpg_vpre0_nop_c pg_vpre0_nop_c 0 v=max((-v(pre0_nop_c)*i(vpre0_nop_c)),0)
bpr_vpre0_nop_c pr_vpre0_nop_c 0 v=max(-(-v(pre0_nop_c)*i(vpre0_nop_c)),0)
bpn_vpre1_nop_c pn_vpre1_nop_c 0 v=(-v(pre1_nop_c)*i(vpre1_nop_c))
bpg_vpre1_nop_c pg_vpre1_nop_c 0 v=max((-v(pre1_nop_c)*i(vpre1_nop_c)),0)
bpr_vpre1_nop_c pr_vpre1_nop_c 0 v=max(-(-v(pre1_nop_c)*i(vpre1_nop_c)),0)
bpn_vpre2_nop_c pn_vpre2_nop_c 0 v=(-v(pre2_nop_c)*i(vpre2_nop_c))
bpg_vpre2_nop_c pg_vpre2_nop_c 0 v=max((-v(pre2_nop_c)*i(vpre2_nop_c)),0)
bpr_vpre2_nop_c pr_vpre2_nop_c 0 v=max(-(-v(pre2_nop_c)*i(vpre2_nop_c)),0)
bpn_vpre3_nop_c pn_vpre3_nop_c 0 v=(-v(pre3_nop_c)*i(vpre3_nop_c))
bpg_vpre3_nop_c pg_vpre3_nop_c 0 v=max((-v(pre3_nop_c)*i(vpre3_nop_c)),0)
bpr_vpre3_nop_c pr_vpre3_nop_c 0 v=max(-(-v(pre3_nop_c)*i(vpre3_nop_c)),0)
bpn_vwbl0_nop_c pn_vwbl0_nop_c 0 v=(-v(bl_0_nop_c)*i(vwbl0_nop_c))
bpg_vwbl0_nop_c pg_vwbl0_nop_c 0 v=max((-v(bl_0_nop_c)*i(vwbl0_nop_c)),0)
bpr_vwbl0_nop_c pr_vwbl0_nop_c 0 v=max(-(-v(bl_0_nop_c)*i(vwbl0_nop_c)),0)
bpn_vwbl1_nop_c pn_vwbl1_nop_c 0 v=(-v(bl_1_nop_c)*i(vwbl1_nop_c))
bpg_vwbl1_nop_c pg_vwbl1_nop_c 0 v=max((-v(bl_1_nop_c)*i(vwbl1_nop_c)),0)
bpr_vwbl1_nop_c pr_vwbl1_nop_c 0 v=max(-(-v(bl_1_nop_c)*i(vwbl1_nop_c)),0)
bpn_vwbl2_nop_c pn_vwbl2_nop_c 0 v=(-v(bl_2_nop_c)*i(vwbl2_nop_c))
bpg_vwbl2_nop_c pg_vwbl2_nop_c 0 v=max((-v(bl_2_nop_c)*i(vwbl2_nop_c)),0)
bpr_vwbl2_nop_c pr_vwbl2_nop_c 0 v=max(-(-v(bl_2_nop_c)*i(vwbl2_nop_c)),0)
bpn_vwbl3_nop_c pn_vwbl3_nop_c 0 v=(-v(bl_3_nop_c)*i(vwbl3_nop_c))
bpg_vwbl3_nop_c pg_vwbl3_nop_c 0 v=max((-v(bl_3_nop_c)*i(vwbl3_nop_c)),0)
bpr_vwbl3_nop_c pr_vwbl3_nop_c 0 v=max(-(-v(bl_3_nop_c)*i(vwbl3_nop_c)),0)
bpn_vrwl0_nop_c pn_vrwl0_nop_c 0 v=(-v(rwl_0_nop_c)*i(vrwl0_nop_c))
bpg_vrwl0_nop_c pg_vrwl0_nop_c 0 v=max((-v(rwl_0_nop_c)*i(vrwl0_nop_c)),0)
bpr_vrwl0_nop_c pr_vrwl0_nop_c 0 v=max(-(-v(rwl_0_nop_c)*i(vrwl0_nop_c)),0)
bpn_vrwl1_nop_c pn_vrwl1_nop_c 0 v=(-v(rwl_1_nop_c)*i(vrwl1_nop_c))
bpg_vrwl1_nop_c pg_vrwl1_nop_c 0 v=max((-v(rwl_1_nop_c)*i(vrwl1_nop_c)),0)
bpr_vrwl1_nop_c pr_vrwl1_nop_c 0 v=max(-(-v(rwl_1_nop_c)*i(vrwl1_nop_c)),0)
bpn_vrwl2_nop_c pn_vrwl2_nop_c 0 v=(-v(rwl_2_nop_c)*i(vrwl2_nop_c))
bpg_vrwl2_nop_c pg_vrwl2_nop_c 0 v=max((-v(rwl_2_nop_c)*i(vrwl2_nop_c)),0)
bpr_vrwl2_nop_c pr_vrwl2_nop_c 0 v=max(-(-v(rwl_2_nop_c)*i(vrwl2_nop_c)),0)
bpn_vrwl3_nop_c pn_vrwl3_nop_c 0 v=(-v(rwl_3_nop_c)*i(vrwl3_nop_c))
bpg_vrwl3_nop_c pg_vrwl3_nop_c 0 v=max((-v(rwl_3_nop_c)*i(vrwl3_nop_c)),0)
bpr_vrwl3_nop_c pr_vrwl3_nop_c 0 v=max(-(-v(rwl_3_nop_c)*i(vrwl3_nop_c)),0)
bpn_vwwl0_nop_c pn_vwwl0_nop_c 0 v=(-v(wl_0_nop_c)*i(vwwl0_nop_c))
bpg_vwwl0_nop_c pg_vwwl0_nop_c 0 v=max((-v(wl_0_nop_c)*i(vwwl0_nop_c)),0)
bpr_vwwl0_nop_c pr_vwwl0_nop_c 0 v=max(-(-v(wl_0_nop_c)*i(vwwl0_nop_c)),0)
bpn_vwwl1_nop_c pn_vwwl1_nop_c 0 v=(-v(wl_1_nop_c)*i(vwwl1_nop_c))
bpg_vwwl1_nop_c pg_vwwl1_nop_c 0 v=max((-v(wl_1_nop_c)*i(vwwl1_nop_c)),0)
bpr_vwwl1_nop_c pr_vwwl1_nop_c 0 v=max(-(-v(wl_1_nop_c)*i(vwwl1_nop_c)),0)
bpn_vwwl2_nop_c pn_vwwl2_nop_c 0 v=(-v(wl_2_nop_c)*i(vwwl2_nop_c))
bpg_vwwl2_nop_c pg_vwwl2_nop_c 0 v=max((-v(wl_2_nop_c)*i(vwwl2_nop_c)),0)
bpr_vwwl2_nop_c pr_vwwl2_nop_c 0 v=max(-(-v(wl_2_nop_c)*i(vwwl2_nop_c)),0)
bpn_vwwl3_nop_c pn_vwwl3_nop_c 0 v=(-v(wl_3_nop_c)*i(vwwl3_nop_c))
bpg_vwwl3_nop_c pg_vwwl3_nop_c 0 v=max((-v(wl_3_nop_c)*i(vwwl3_nop_c)),0)
bpr_vwwl3_nop_c pr_vwwl3_nop_c 0 v=max(-(-v(wl_3_nop_c)*i(vwwl3_nop_c)),0)
bpn_vbody_nop_c pn_vbody_nop_c 0 v=(-v(gnd_nop_c)*i(vbody_nop_c))
bpg_vbody_nop_c pg_vbody_nop_c 0 v=max((-v(gnd_nop_c)*i(vbody_nop_c)),0)
bpr_vbody_nop_c pr_vbody_nop_c 0 v=max(-(-v(gnd_nop_c)*i(vbody_nop_c)),0)
bpn_vsub_nop_c pn_vsub_nop_c 0 v=(-v(vsubs_nop_c)*i(vsub_nop_c))
bpg_vsub_nop_c pg_vsub_nop_c 0 v=max((-v(vsubs_nop_c)*i(vsub_nop_c)),0)
bpr_vsub_nop_c pr_vsub_nop_c 0 v=max(-(-v(vsubs_nop_c)*i(vsub_nop_c)),0)

* ---- instance refw: mode ref, pattern None ----
xm1_refw sn_0_0__t0_refw wl_0__t3_refw bl_0__t0_refw gnd__t0_refw sky130_fd_pr__nfet_01v8 L=0.15 W=0.42 nf=1 ad=0.1974 as=0.1974 pd=1.78 ps=1.78 mult=1 m=1
xm2_refw rbl_0__t0_refw sn_0_0__t1_refw rwl_0__t0_refw gnd__t1_refw sky130_fd_pr__nfet_01v8 L=0.15 W=0.42 nf=1 ad=0.1974 as=0.1974 pd=1.78 ps=1.78 mult=1 m=1
xm3_refw sn_0_1__t1_refw wl_0__t0_refw bl_1__t0_refw gnd__t2_refw sky130_fd_pr__nfet_01v8 L=0.15 W=0.42 nf=1 ad=0.1974 as=0.1974 pd=1.78 ps=1.78 mult=1 m=1
xm4_refw rbl_1__t0_refw sn_0_1__t0_refw rwl_0__t1_refw gnd__t3_refw sky130_fd_pr__nfet_01v8 L=0.15 W=0.42 nf=1 ad=0.1974 as=0.1974 pd=1.78 ps=1.78 mult=1 m=1
xm5_refw sn_0_2__t1_refw wl_0__t1_refw bl_2__t0_refw gnd__t4_refw sky130_fd_pr__nfet_01v8 L=0.15 W=0.42 nf=1 ad=0.1974 as=0.1974 pd=1.78 ps=1.78 mult=1 m=1
xm6_refw rbl_2__t0_refw sn_0_2__t0_refw rwl_0__t2_refw gnd__t5_refw sky130_fd_pr__nfet_01v8 L=0.15 W=0.42 nf=1 ad=0.1974 as=0.1974 pd=1.78 ps=1.78 mult=1 m=1
xm7_refw sn_0_3__t1_refw wl_0__t2_refw bl_3__t0_refw gnd__t6_refw sky130_fd_pr__nfet_01v8 L=0.15 W=0.42 nf=1 ad=0.1974 as=0.1974 pd=1.78 ps=1.78 mult=1 m=1
xm8_refw rbl_3__t0_refw sn_0_3__t0_refw rwl_0__t3_refw gnd__t7_refw sky130_fd_pr__nfet_01v8 L=0.15 W=0.42 nf=1 ad=0.1974 as=0.1974 pd=1.78 ps=1.78 mult=1 m=1
xm9_refw sn_1_0__t1_refw wl_1__t0_refw bl_0__t1_refw gnd__t8_refw sky130_fd_pr__nfet_01v8 L=0.15 W=0.42 nf=1 ad=0.1974 as=0.1974 pd=1.78 ps=1.78 mult=1 m=1
xm10_refw rbl_0__t1_refw sn_1_0__t0_refw rwl_1__t0_refw gnd__t9_refw sky130_fd_pr__nfet_01v8 L=0.15 W=0.42 nf=1 ad=0.1974 as=0.1974 pd=1.78 ps=1.78 mult=1 m=1
xm11_refw sn_1_1__t1_refw wl_1__t1_refw bl_1__t1_refw gnd__t10_refw sky130_fd_pr__nfet_01v8 L=0.15 W=0.42 nf=1 ad=0.1974 as=0.1974 pd=1.78 ps=1.78 mult=1 m=1
xm12_refw rbl_1__t1_refw sn_1_1__t0_refw rwl_1__t1_refw gnd__t11_refw sky130_fd_pr__nfet_01v8 L=0.15 W=0.42 nf=1 ad=0.1974 as=0.1974 pd=1.78 ps=1.78 mult=1 m=1
xm13_refw sn_1_2__t1_refw wl_1__t2_refw bl_2__t1_refw gnd__t12_refw sky130_fd_pr__nfet_01v8 L=0.15 W=0.42 nf=1 ad=0.1974 as=0.1974 pd=1.78 ps=1.78 mult=1 m=1
xm14_refw rbl_2__t1_refw sn_1_2__t0_refw rwl_1__t2_refw gnd__t13_refw sky130_fd_pr__nfet_01v8 L=0.15 W=0.42 nf=1 ad=0.1974 as=0.1974 pd=1.78 ps=1.78 mult=1 m=1
xm15_refw sn_1_3__t1_refw wl_1__t3_refw bl_3__t1_refw gnd__t14_refw sky130_fd_pr__nfet_01v8 L=0.15 W=0.42 nf=1 ad=0.1974 as=0.1974 pd=1.78 ps=1.78 mult=1 m=1
xm16_refw rbl_3__t1_refw sn_1_3__t0_refw rwl_1__t3_refw gnd__t15_refw sky130_fd_pr__nfet_01v8 L=0.15 W=0.42 nf=1 ad=0.1974 as=0.1974 pd=1.78 ps=1.78 mult=1 m=1
xm17_refw sn_2_0__t1_refw wl_2__t3_refw bl_0__t3_refw gnd__t16_refw sky130_fd_pr__nfet_01v8 L=0.15 W=0.42 nf=1 ad=0.1974 as=0.1974 pd=1.78 ps=1.78 mult=1 m=1
xm18_refw rbl_0__t2_refw sn_2_0__t0_refw rwl_2__t0_refw gnd__t17_refw sky130_fd_pr__nfet_01v8 L=0.15 W=0.42 nf=1 ad=0.1974 as=0.1974 pd=1.78 ps=1.78 mult=1 m=1
xm19_refw sn_2_1__t1_refw wl_2__t0_refw bl_1__t2_refw gnd__t18_refw sky130_fd_pr__nfet_01v8 L=0.15 W=0.42 nf=1 ad=0.1974 as=0.1974 pd=1.78 ps=1.78 mult=1 m=1
xm20_refw rbl_1__t2_refw sn_2_1__t0_refw rwl_2__t1_refw gnd__t19_refw sky130_fd_pr__nfet_01v8 L=0.15 W=0.42 nf=1 ad=0.1974 as=0.1974 pd=1.78 ps=1.78 mult=1 m=1
xm21_refw sn_2_2__t1_refw wl_2__t1_refw bl_2__t2_refw gnd__t20_refw sky130_fd_pr__nfet_01v8 L=0.15 W=0.42 nf=1 ad=0.1974 as=0.1974 pd=1.78 ps=1.78 mult=1 m=1
xm22_refw rbl_2__t2_refw sn_2_2__t0_refw rwl_2__t2_refw gnd__t21_refw sky130_fd_pr__nfet_01v8 L=0.15 W=0.42 nf=1 ad=0.1974 as=0.1974 pd=1.78 ps=1.78 mult=1 m=1
xm23_refw sn_2_3__t1_refw wl_2__t2_refw bl_3__t2_refw gnd__t22_refw sky130_fd_pr__nfet_01v8 L=0.15 W=0.42 nf=1 ad=0.1974 as=0.1974 pd=1.78 ps=1.78 mult=1 m=1
xm24_refw rbl_3__t2_refw sn_2_3__t0_refw rwl_2__t3_refw gnd__t23_refw sky130_fd_pr__nfet_01v8 L=0.15 W=0.42 nf=1 ad=0.1974 as=0.1974 pd=1.78 ps=1.78 mult=1 m=1
xm25_refw sn_3_0__t1_refw wl_3__t0_refw bl_0__t2_refw gnd__t24_refw sky130_fd_pr__nfet_01v8 L=0.15 W=0.42 nf=1 ad=0.1974 as=0.1974 pd=1.78 ps=1.78 mult=1 m=1
xm26_refw rbl_0__t3_refw sn_3_0__t0_refw rwl_3__t0_refw gnd__t25_refw sky130_fd_pr__nfet_01v8 L=0.15 W=0.42 nf=1 ad=0.1974 as=0.1974 pd=1.78 ps=1.78 mult=1 m=1
xm27_refw sn_3_1__t1_refw wl_3__t1_refw bl_1__t3_refw gnd__t26_refw sky130_fd_pr__nfet_01v8 L=0.15 W=0.42 nf=1 ad=0.1974 as=0.1974 pd=1.78 ps=1.78 mult=1 m=1
xm28_refw rbl_1__t3_refw sn_3_1__t0_refw rwl_3__t1_refw gnd__t27_refw sky130_fd_pr__nfet_01v8 L=0.15 W=0.42 nf=1 ad=0.1974 as=0.1974 pd=1.78 ps=1.78 mult=1 m=1
xm29_refw sn_3_2__t1_refw wl_3__t2_refw bl_2__t3_refw gnd__t28_refw sky130_fd_pr__nfet_01v8 L=0.15 W=0.42 nf=1 ad=0.1974 as=0.1974 pd=1.78 ps=1.78 mult=1 m=1
xm30_refw rbl_2__t3_refw sn_3_2__t0_refw rwl_3__t2_refw gnd__t29_refw sky130_fd_pr__nfet_01v8 L=0.15 W=0.42 nf=1 ad=0.1974 as=0.1974 pd=1.78 ps=1.78 mult=1 m=1
xm31_refw sn_3_3__t1_refw wl_3__t3_refw bl_3__t3_refw gnd__t30_refw sky130_fd_pr__nfet_01v8 L=0.15 W=0.42 nf=1 ad=0.1974 as=0.1974 pd=1.78 ps=1.78 mult=1 m=1
xm32_refw rbl_3__t3_refw sn_3_3__t0_refw rwl_3__t3_refw gnd__t31_refw sky130_fd_pr__nfet_01v8 L=0.15 W=0.42 nf=1 ad=0.1974 as=0.1974 pd=1.78 ps=1.78 mult=1 m=1
rgnd_t0_refw gnd__t0_refw gnd_refw 63.3529
rgnd_t1_refw gnd__t1_refw gnd_refw 49.0465
rgnd_t2_refw gnd__t2_refw gnd_refw 36.5177
rgnd_t3_refw gnd__t3_refw gnd_refw 28.2406
rgnd_t4_refw gnd__t4_refw gnd_refw 28.2406
rgnd_t5_refw gnd__t5_refw gnd_refw 36.5177
rgnd_t6_refw gnd__t6_refw gnd_refw 49.0465
rgnd_t7_refw gnd__t7_refw gnd_refw 63.3529
rgnd_t8_refw gnd__t8_refw gnd_refw 58.0019
rgnd_t9_refw gnd__t9_refw gnd_refw 41.907
rgnd_t10_refw gnd__t10_refw gnd_refw 26.1568
rgnd_t11_refw gnd__t11_refw gnd_refw 12.1726
rgnd_t12_refw gnd__t12_refw gnd_refw 12.1726
rgnd_t13_refw gnd__t13_refw gnd_refw 26.1568
rgnd_t14_refw gnd__t14_refw gnd_refw 41.907
rgnd_t15_refw gnd__t15_refw gnd_refw 58.0019
rgnd_t16_refw gnd__t16_refw gnd_refw 58.0019
rgnd_t17_refw gnd__t17_refw gnd_refw 41.907
rgnd_t18_refw gnd__t18_refw gnd_refw 26.1568
rgnd_t19_refw gnd__t19_refw gnd_refw 12.1726
rgnd_t20_refw gnd__t20_refw gnd_refw 12.1726
rgnd_t21_refw gnd__t21_refw gnd_refw 26.1568
rgnd_t22_refw gnd__t22_refw gnd_refw 41.907
rgnd_t23_refw gnd__t23_refw gnd_refw 58.0019
rgnd_t24_refw gnd__t24_refw gnd_refw 63.3529
rgnd_t25_refw gnd__t25_refw gnd_refw 49.0465
rgnd_t26_refw gnd__t26_refw gnd_refw 36.5177
rgnd_t27_refw gnd__t27_refw gnd_refw 28.2406
rgnd_t28_refw gnd__t28_refw gnd_refw 28.2406
rgnd_t29_refw gnd__t29_refw gnd_refw 36.5177
rgnd_t30_refw gnd__t30_refw gnd_refw 49.0465
rgnd_t31_refw gnd__t31_refw gnd_refw 63.3529
rbl_0_t0_refw bl_0__t0_refw bl_0_refw 144.555
rbl_0_t1_refw bl_0__t1_refw bl_0_refw 48.1851
rbl_0_t2_refw bl_0__t2_refw bl_0_refw 144.555
rbl_0_t3_refw bl_0__t3_refw bl_0_refw 48.1851
rbl_1_t0_refw bl_1__t0_refw bl_1_refw 144.555
rbl_1_t1_refw bl_1__t1_refw bl_1_refw 48.1851
rbl_1_t2_refw bl_1__t2_refw bl_1_refw 48.1851
rbl_1_t3_refw bl_1__t3_refw bl_1_refw 144.555
rbl_2_t0_refw bl_2__t0_refw bl_2_refw 144.555
rbl_2_t1_refw bl_2__t1_refw bl_2_refw 48.1851
rbl_2_t2_refw bl_2__t2_refw bl_2_refw 48.1851
rbl_2_t3_refw bl_2__t3_refw bl_2_refw 144.555
rbl_3_t0_refw bl_3__t0_refw bl_3_refw 144.555
rbl_3_t1_refw bl_3__t1_refw bl_3_refw 48.1851
rbl_3_t2_refw bl_3__t2_refw bl_3_refw 48.1851
rbl_3_t3_refw bl_3__t3_refw bl_3_refw 144.555
rrbl_0_t0_refw rbl_0__t0_refw rbl_0_refw 144.555
rrbl_0_t1_refw rbl_0__t1_refw rbl_0_refw 48.1851
rrbl_0_t2_refw rbl_0__t2_refw rbl_0_refw 48.1851
rrbl_0_t3_refw rbl_0__t3_refw rbl_0_refw 144.555
rrbl_1_t0_refw rbl_1__t0_refw rbl_1_refw 144.555
rrbl_1_t1_refw rbl_1__t1_refw rbl_1_refw 48.1851
rrbl_1_t2_refw rbl_1__t2_refw rbl_1_refw 48.1851
rrbl_1_t3_refw rbl_1__t3_refw rbl_1_refw 144.555
rrbl_2_t0_refw rbl_2__t0_refw rbl_2_refw 144.555
rrbl_2_t1_refw rbl_2__t1_refw rbl_2_refw 48.1851
rrbl_2_t2_refw rbl_2__t2_refw rbl_2_refw 48.1851
rrbl_2_t3_refw rbl_2__t3_refw rbl_2_refw 144.555
rrbl_3_t0_refw rbl_3__t0_refw rbl_3_refw 144.555
rrbl_3_t1_refw rbl_3__t1_refw rbl_3_refw 48.1851
rrbl_3_t2_refw rbl_3__t2_refw rbl_3_refw 48.1851
rrbl_3_t3_refw rbl_3__t3_refw rbl_3_refw 144.555
rrwl_0_t0_refw rwl_0__t0_refw rwl_0_refw 21.6897
rrwl_0_t1_refw rwl_0__t1_refw rwl_0_refw 7.22989
rrwl_0_t2_refw rwl_0__t2_refw rwl_0_refw 7.22989
rrwl_0_t3_refw rwl_0__t3_refw rwl_0_refw 21.6897
rrwl_1_t0_refw rwl_1__t0_refw rwl_1_refw 21.6897
rrwl_1_t1_refw rwl_1__t1_refw rwl_1_refw 7.22989
rrwl_1_t2_refw rwl_1__t2_refw rwl_1_refw 7.22989
rrwl_1_t3_refw rwl_1__t3_refw rwl_1_refw 21.6897
rrwl_2_t0_refw rwl_2__t0_refw rwl_2_refw 21.6897
rrwl_2_t1_refw rwl_2__t1_refw rwl_2_refw 7.22989
rrwl_2_t2_refw rwl_2__t2_refw rwl_2_refw 7.22989
rrwl_2_t3_refw rwl_2__t3_refw rwl_2_refw 21.6897
rrwl_3_t0_refw rwl_3__t0_refw rwl_3_refw 21.6897
rrwl_3_t1_refw rwl_3__t1_refw rwl_3_refw 7.22989
rrwl_3_t2_refw rwl_3__t2_refw rwl_3_refw 7.22989
rrwl_3_t3_refw rwl_3__t3_refw rwl_3_refw 21.6897
rsn_0_0_t0_refw sn_0_0__t0_refw sn_0_0_refw 125.123
rsn_0_0_t1_refw sn_0_0__t1_refw sn_0_0_refw 125.123
rsn_0_1_t0_refw sn_0_1__t0_refw sn_0_1_refw 125.123
rsn_0_1_t1_refw sn_0_1__t1_refw sn_0_1_refw 125.123
rsn_0_2_t0_refw sn_0_2__t0_refw sn_0_2_refw 125.123
rsn_0_2_t1_refw sn_0_2__t1_refw sn_0_2_refw 125.123
rsn_0_3_t0_refw sn_0_3__t0_refw sn_0_3_refw 125.123
rsn_0_3_t1_refw sn_0_3__t1_refw sn_0_3_refw 125.123
rsn_1_0_t0_refw sn_1_0__t0_refw sn_1_0_refw 125.123
rsn_1_0_t1_refw sn_1_0__t1_refw sn_1_0_refw 125.123
rsn_1_1_t0_refw sn_1_1__t0_refw sn_1_1_refw 125.123
rsn_1_1_t1_refw sn_1_1__t1_refw sn_1_1_refw 125.123
rsn_1_2_t0_refw sn_1_2__t0_refw sn_1_2_refw 125.123
rsn_1_2_t1_refw sn_1_2__t1_refw sn_1_2_refw 125.123
rsn_1_3_t0_refw sn_1_3__t0_refw sn_1_3_refw 125.123
rsn_1_3_t1_refw sn_1_3__t1_refw sn_1_3_refw 125.123
rsn_2_0_t0_refw sn_2_0__t0_refw sn_2_0_refw 125.123
rsn_2_0_t1_refw sn_2_0__t1_refw sn_2_0_refw 125.123
rsn_2_1_t0_refw sn_2_1__t0_refw sn_2_1_refw 125.123
rsn_2_1_t1_refw sn_2_1__t1_refw sn_2_1_refw 125.123
rsn_2_2_t0_refw sn_2_2__t0_refw sn_2_2_refw 125.123
rsn_2_2_t1_refw sn_2_2__t1_refw sn_2_2_refw 125.123
rsn_2_3_t0_refw sn_2_3__t0_refw sn_2_3_refw 125.123
rsn_2_3_t1_refw sn_2_3__t1_refw sn_2_3_refw 125.123
rsn_3_0_t0_refw sn_3_0__t0_refw sn_3_0_refw 125.123
rsn_3_0_t1_refw sn_3_0__t1_refw sn_3_0_refw 125.123
rsn_3_1_t0_refw sn_3_1__t0_refw sn_3_1_refw 125.123
rsn_3_1_t1_refw sn_3_1__t1_refw sn_3_1_refw 125.123
rsn_3_2_t0_refw sn_3_2__t0_refw sn_3_2_refw 125.123
rsn_3_2_t1_refw sn_3_2__t1_refw sn_3_2_refw 125.123
rsn_3_3_t0_refw sn_3_3__t0_refw sn_3_3_refw 125.123
rsn_3_3_t1_refw sn_3_3__t1_refw sn_3_3_refw 125.123
rwl_0_t0_refw wl_0__t0_refw wl_0_refw 54.2844
rwl_0_t1_refw wl_0__t1_refw wl_0_refw 54.2844
rwl_0_t2_refw wl_0__t2_refw wl_0_refw 162.853
rwl_0_t3_refw wl_0__t3_refw wl_0_refw 162.853
rwl_1_t0_refw wl_1__t0_refw wl_1_refw 162.853
rwl_1_t1_refw wl_1__t1_refw wl_1_refw 54.2844
rwl_1_t2_refw wl_1__t2_refw wl_1_refw 54.2844
rwl_1_t3_refw wl_1__t3_refw wl_1_refw 162.853
rwl_2_t0_refw wl_2__t0_refw wl_2_refw 54.2844
rwl_2_t1_refw wl_2__t1_refw wl_2_refw 54.2844
rwl_2_t2_refw wl_2__t2_refw wl_2_refw 162.853
rwl_2_t3_refw wl_2__t3_refw wl_2_refw 162.853
rwl_3_t0_refw wl_3__t0_refw wl_3_refw 162.853
rwl_3_t1_refw wl_3__t1_refw wl_3_refw 54.2844
rwl_3_t2_refw wl_3__t2_refw wl_3_refw 54.2844
rwl_3_t3_refw wl_3__t3_refw wl_3_refw 162.853
cgnd_refw gnd_refw vsubs_refw 4.09475e-15
cbl_0_refw bl_0_refw vsubs_refw 5.96076e-16
cbl_1_refw bl_1_refw vsubs_refw 5.81168e-16
cbl_2_refw bl_2_refw vsubs_refw 5.81168e-16
cbl_3_refw bl_3_refw vsubs_refw 5.81168e-16
crbl_0_refw rbl_0_refw vsubs_refw 5.81168e-16
crbl_1_refw rbl_1_refw vsubs_refw 5.81168e-16
crbl_2_refw rbl_2_refw vsubs_refw 5.81168e-16
crbl_3_refw rbl_3_refw vsubs_refw 5.96076e-16
crwl_0_refw rwl_0_refw vsubs_refw 1.18713e-15
crwl_1_refw rwl_1_refw vsubs_refw 1.18713e-15
crwl_2_refw rwl_2_refw vsubs_refw 1.18713e-15
crwl_3_refw rwl_3_refw vsubs_refw 1.18713e-15
csn_0_0_refw sn_0_0_refw vsubs_refw 4.33689e-16
csn_0_1_refw sn_0_1_refw vsubs_refw 4.30576e-16
csn_0_2_refw sn_0_2_refw vsubs_refw 4.30576e-16
csn_0_3_refw sn_0_3_refw vsubs_refw 4.32518e-16
csn_1_0_refw sn_1_0_refw vsubs_refw 4.33689e-16
csn_1_1_refw sn_1_1_refw vsubs_refw 4.30576e-16
csn_1_2_refw sn_1_2_refw vsubs_refw 4.30576e-16
csn_1_3_refw sn_1_3_refw vsubs_refw 4.32518e-16
csn_2_0_refw sn_2_0_refw vsubs_refw 4.33689e-16
csn_2_1_refw sn_2_1_refw vsubs_refw 4.30576e-16
csn_2_2_refw sn_2_2_refw vsubs_refw 4.30576e-16
csn_2_3_refw sn_2_3_refw vsubs_refw 4.32518e-16
csn_3_0_refw sn_3_0_refw vsubs_refw 4.33689e-16
csn_3_1_refw sn_3_1_refw vsubs_refw 4.30576e-16
csn_3_2_refw sn_3_2_refw vsubs_refw 4.30576e-16
csn_3_3_refw sn_3_3_refw vsubs_refw 4.32518e-16
cwl_0_refw wl_0_refw vsubs_refw 1.90928e-15
cwl_1_refw wl_1_refw vsubs_refw 1.90928e-15
cwl_2_refw wl_2_refw vsubs_refw 1.90928e-15
cwl_3_refw wl_3_refw vsubs_refw 1.91375e-15
ccc_bl_0_sn_0_0_refw bl_0_refw sn_0_0_refw 1.071e-17
ccc_bl_0_sn_1_0_refw bl_0_refw sn_1_0_refw 1.071e-17
ccc_bl_0_sn_2_0_refw bl_0_refw sn_2_0_refw 1.071e-17
ccc_bl_0_sn_3_0_refw bl_0_refw sn_3_0_refw 1.071e-17
ccc_bl_0_wl_0_refw bl_0_refw wl_0_refw 2.4327e-17
ccc_bl_0_wl_1_refw bl_0_refw wl_1_refw 2.4327e-17
ccc_bl_0_wl_2_refw bl_0_refw wl_2_refw 2.4327e-17
ccc_bl_1_rbl_0_refw bl_1_refw rbl_0_refw 1.29795e-16
ccc_bl_1_rwl_0_refw bl_1_refw rwl_0_refw 9.028e-18
ccc_bl_1_rwl_1_refw bl_1_refw rwl_1_refw 9.028e-18
ccc_bl_1_rwl_2_refw bl_1_refw rwl_2_refw 9.028e-18
ccc_bl_1_rwl_3_refw bl_1_refw rwl_3_refw 9.028e-18
ccc_bl_1_sn_0_1_refw bl_1_refw sn_0_1_refw 1.071e-17
ccc_bl_1_sn_1_1_refw bl_1_refw sn_1_1_refw 1.071e-17
ccc_bl_1_sn_2_1_refw bl_1_refw sn_2_1_refw 1.071e-17
ccc_bl_1_sn_3_1_refw bl_1_refw sn_3_1_refw 1.071e-17
ccc_bl_1_wl_0_refw bl_1_refw wl_0_refw 2.7627e-17
ccc_bl_1_wl_1_refw bl_1_refw wl_1_refw 2.7627e-17
ccc_bl_1_wl_2_refw bl_1_refw wl_2_refw 2.7627e-17
ccc_bl_2_rbl_1_refw bl_2_refw rbl_1_refw 1.29795e-16
ccc_bl_2_rwl_0_refw bl_2_refw rwl_0_refw 9.028e-18
ccc_bl_2_rwl_1_refw bl_2_refw rwl_1_refw 9.028e-18
ccc_bl_2_rwl_2_refw bl_2_refw rwl_2_refw 9.028e-18
ccc_bl_2_rwl_3_refw bl_2_refw rwl_3_refw 9.028e-18
ccc_bl_2_sn_0_2_refw bl_2_refw sn_0_2_refw 1.071e-17
ccc_bl_2_sn_1_2_refw bl_2_refw sn_1_2_refw 1.071e-17
ccc_bl_2_sn_2_2_refw bl_2_refw sn_2_2_refw 1.071e-17
ccc_bl_2_sn_3_2_refw bl_2_refw sn_3_2_refw 1.071e-17
ccc_bl_2_wl_0_refw bl_2_refw wl_0_refw 2.7627e-17
ccc_bl_2_wl_1_refw bl_2_refw wl_1_refw 2.7627e-17
ccc_bl_2_wl_2_refw bl_2_refw wl_2_refw 2.7627e-17
ccc_bl_3_rbl_2_refw bl_3_refw rbl_2_refw 1.29795e-16
ccc_bl_3_rwl_0_refw bl_3_refw rwl_0_refw 9.028e-18
ccc_bl_3_rwl_1_refw bl_3_refw rwl_1_refw 9.028e-18
ccc_bl_3_rwl_2_refw bl_3_refw rwl_2_refw 9.028e-18
ccc_bl_3_rwl_3_refw bl_3_refw rwl_3_refw 9.028e-18
ccc_bl_3_sn_0_3_refw bl_3_refw sn_0_3_refw 1.071e-17
ccc_bl_3_sn_1_3_refw bl_3_refw sn_1_3_refw 1.071e-17
ccc_bl_3_sn_2_3_refw bl_3_refw sn_2_3_refw 1.071e-17
ccc_bl_3_sn_3_3_refw bl_3_refw sn_3_3_refw 1.071e-17
ccc_bl_3_wl_0_refw bl_3_refw wl_0_refw 2.7627e-17
ccc_bl_3_wl_1_refw bl_3_refw wl_1_refw 2.7627e-17
ccc_bl_3_wl_2_refw bl_3_refw wl_2_refw 2.7627e-17
ccc_rbl_0_rwl_0_refw rbl_0_refw rwl_0_refw 1.9738e-17
ccc_rbl_0_rwl_1_refw rbl_0_refw rwl_1_refw 1.9738e-17
ccc_rbl_0_rwl_2_refw rbl_0_refw rwl_2_refw 1.9738e-17
ccc_rbl_0_rwl_3_refw rbl_0_refw rwl_3_refw 1.9738e-17
ccc_rbl_0_sn_0_0_refw rbl_0_refw sn_0_0_refw 1.071e-17
ccc_rbl_0_sn_1_0_refw rbl_0_refw sn_1_0_refw 2.4327e-17
ccc_rbl_0_sn_2_0_refw rbl_0_refw sn_2_0_refw 2.4327e-17
ccc_rbl_0_wl_0_refw rbl_0_refw wl_0_refw 3.3e-18
ccc_rbl_0_wl_1_refw rbl_0_refw wl_1_refw 3.3e-18
ccc_rbl_0_wl_2_refw rbl_0_refw wl_2_refw 3.3e-18
ccc_rbl_1_rwl_0_refw rbl_1_refw rwl_0_refw 1.9738e-17
ccc_rbl_1_rwl_1_refw rbl_1_refw rwl_1_refw 1.9738e-17
ccc_rbl_1_rwl_2_refw rbl_1_refw rwl_2_refw 1.9738e-17
ccc_rbl_1_rwl_3_refw rbl_1_refw rwl_3_refw 1.9738e-17
ccc_rbl_1_sn_0_1_refw rbl_1_refw sn_0_1_refw 1.071e-17
ccc_rbl_1_sn_1_1_refw rbl_1_refw sn_1_1_refw 2.4327e-17
ccc_rbl_1_sn_2_1_refw rbl_1_refw sn_2_1_refw 2.4327e-17
ccc_rbl_1_wl_0_refw rbl_1_refw wl_0_refw 3.3e-18
ccc_rbl_1_wl_1_refw rbl_1_refw wl_1_refw 3.3e-18
ccc_rbl_1_wl_2_refw rbl_1_refw wl_2_refw 3.3e-18
ccc_rbl_2_rwl_0_refw rbl_2_refw rwl_0_refw 1.9738e-17
ccc_rbl_2_rwl_1_refw rbl_2_refw rwl_1_refw 1.9738e-17
ccc_rbl_2_rwl_2_refw rbl_2_refw rwl_2_refw 1.9738e-17
ccc_rbl_2_rwl_3_refw rbl_2_refw rwl_3_refw 1.9738e-17
ccc_rbl_2_sn_0_2_refw rbl_2_refw sn_0_2_refw 1.071e-17
ccc_rbl_2_sn_1_2_refw rbl_2_refw sn_1_2_refw 2.4327e-17
ccc_rbl_2_sn_2_2_refw rbl_2_refw sn_2_2_refw 2.4327e-17
ccc_rbl_2_wl_0_refw rbl_2_refw wl_0_refw 3.3e-18
ccc_rbl_2_wl_1_refw rbl_2_refw wl_1_refw 3.3e-18
ccc_rbl_2_wl_2_refw rbl_2_refw wl_2_refw 3.3e-18
ccc_rbl_3_rwl_0_refw rbl_3_refw rwl_0_refw 1.071e-17
ccc_rbl_3_rwl_1_refw rbl_3_refw rwl_1_refw 1.071e-17
ccc_rbl_3_rwl_2_refw rbl_3_refw rwl_2_refw 1.071e-17
ccc_rbl_3_rwl_3_refw rbl_3_refw rwl_3_refw 1.071e-17
ccc_rbl_3_sn_0_3_refw rbl_3_refw sn_0_3_refw 1.071e-17
ccc_rbl_3_sn_1_3_refw rbl_3_refw sn_1_3_refw 2.4327e-17
ccc_rbl_3_sn_2_3_refw rbl_3_refw sn_2_3_refw 2.4327e-17
ccc_rwl_0_sn_0_0_refw rwl_0_refw sn_0_0_refw 1.0072e-17
ccc_rwl_0_sn_0_1_refw rwl_0_refw sn_0_1_refw 1.9682e-17
ccc_rwl_0_sn_0_2_refw rwl_0_refw sn_0_2_refw 1.9682e-17
ccc_rwl_0_sn_0_3_refw rwl_0_refw sn_0_3_refw 1.9682e-17
ccc_rwl_1_sn_1_0_refw rwl_1_refw sn_1_0_refw 1.0072e-17
ccc_rwl_1_sn_1_1_refw rwl_1_refw sn_1_1_refw 1.9682e-17
ccc_rwl_1_sn_1_2_refw rwl_1_refw sn_1_2_refw 1.9682e-17
ccc_rwl_1_sn_1_3_refw rwl_1_refw sn_1_3_refw 1.9682e-17
ccc_rwl_2_sn_2_0_refw rwl_2_refw sn_2_0_refw 1.0072e-17
ccc_rwl_2_sn_2_1_refw rwl_2_refw sn_2_1_refw 1.9682e-17
ccc_rwl_2_sn_2_2_refw rwl_2_refw sn_2_2_refw 1.9682e-17
ccc_rwl_2_sn_2_3_refw rwl_2_refw sn_2_3_refw 1.9682e-17
ccc_rwl_3_sn_3_0_refw rwl_3_refw sn_3_0_refw 1.0072e-17
ccc_rwl_3_sn_3_1_refw rwl_3_refw sn_3_1_refw 1.9682e-17
ccc_rwl_3_sn_3_2_refw rwl_3_refw sn_3_2_refw 1.9682e-17
ccc_rwl_3_sn_3_3_refw rwl_3_refw sn_3_3_refw 1.9682e-17
ccc_sn_0_0_wl_0_refw sn_0_0_refw wl_0_refw 1.9664e-17
ccc_sn_0_1_wl_0_refw sn_0_1_refw wl_0_refw 1.9664e-17
ccc_sn_0_2_wl_0_refw sn_0_2_refw wl_0_refw 1.9664e-17
ccc_sn_0_3_wl_0_refw sn_0_3_refw wl_0_refw 1.3668e-17
ccc_sn_1_0_wl_1_refw sn_1_0_refw wl_1_refw 1.9664e-17
ccc_sn_1_1_wl_1_refw sn_1_1_refw wl_1_refw 1.6705e-17
ccc_sn_1_2_wl_1_refw sn_1_2_refw wl_1_refw 1.6705e-17
ccc_sn_1_3_wl_1_refw sn_1_3_refw wl_1_refw 1.071e-17
ccc_sn_2_0_wl_2_refw sn_2_0_refw wl_2_refw 1.9664e-17
ccc_sn_2_1_wl_2_refw sn_2_1_refw wl_2_refw 1.6705e-17
ccc_sn_2_2_wl_2_refw sn_2_2_refw wl_2_refw 1.6705e-17
ccc_sn_2_3_wl_2_refw sn_2_3_refw wl_2_refw 1.071e-17
ccc_sn_3_0_wl_3_refw sn_3_0_refw wl_3_refw 1.9664e-17
ccc_sn_3_1_wl_3_refw sn_3_1_refw wl_3_refw 1.6705e-17
ccc_sn_3_2_wl_3_refw sn_3_2_refw wl_3_refw 1.6705e-17
ccc_sn_3_3_wl_3_refw sn_3_3_refw wl_3_refw 1.071e-17
vpre0_refw pre0_refw 0 dc 0.9
vpre1_refw pre1_refw 0 dc 0.9
vpre2_refw pre2_refw 0 dc 0.9
vpre3_refw pre3_refw 0 dc 0.9
vwbl0_refw bl_0_refw 0 dc 1.8
vwbl1_refw bl_1_refw 0 dc 1.8
vwbl2_refw bl_2_refw 0 dc 1.8
vwbl3_refw bl_3_refw 0 dc 1.8
vrwl0_refw rwl_0_refw 0 pwl(0.000000e+00 1.8 9.000000e-09 1.8 9.100000e-09 0 4.200000e-08 0 4.210000e-08 1.8)
vrwl1_refw rwl_1_refw 0 dc 1.8
vrwl2_refw rwl_2_refw 0 dc 1.8
vrwl3_refw rwl_3_refw 0 dc 1.8
vwwl0_refw wl_0_refw 0 pwl(0.000000e+00 0 2.000000e-08 0 2.010000e-08 1.8 4.000000e-08 1.8 4.010000e-08 0)
vwwl1_refw wl_1_refw 0 dc 0
vwwl2_refw wl_2_refw 0 dc 0
vwwl3_refw wl_3_refw 0 dc 0
vbody_refw gnd_refw 0 dc 0
vsub_refw vsubs_refw 0 dc 0
vctl_refw ctl_refw 0 pwl(0.000000e+00 1.8 7.000000e-09 1.8 7.100000e-09 0 4.200000e-08 0 4.210000e-08 1.8)   $ EXCLUDED: switch control, outside the boundary
spre0_refw pre0_refw rbl_0_refw ctl_refw 0 swpre
spre1_refw pre1_refw rbl_1_refw ctl_refw 0 swpre
spre2_refw pre2_refw rbl_2_refw ctl_refw 0 swpre
spre3_refw pre3_refw rbl_3_refw ctl_refw 0 swpre

* initial conditions (tran uic)
.ic v(bl_0_act_z)=0 v(bl_0__t0_act_z)=0 v(bl_0__t1_act_z)=0 v(bl_0__t2_act_z)=0 v(bl_0__t3_act_z)=0 v(bl_1_act_z)=0
.ic v(bl_1__t0_act_z)=0 v(bl_1__t1_act_z)=0 v(bl_1__t2_act_z)=0 v(bl_1__t3_act_z)=0 v(bl_2_act_z)=0 v(bl_2__t0_act_z)=0
.ic v(bl_2__t1_act_z)=0 v(bl_2__t2_act_z)=0 v(bl_2__t3_act_z)=0 v(bl_3_act_z)=0 v(bl_3__t0_act_z)=0 v(bl_3__t1_act_z)=0
.ic v(bl_3__t2_act_z)=0 v(bl_3__t3_act_z)=0 v(rbl_0_act_z)=0.9 v(rbl_0__t0_act_z)=0.9 v(rbl_0__t1_act_z)=0.9 v(rbl_0__t2_act_z)=0.9
.ic v(rbl_0__t3_act_z)=0.9 v(rbl_1_act_z)=0.9 v(rbl_1__t0_act_z)=0.9 v(rbl_1__t1_act_z)=0.9 v(rbl_1__t2_act_z)=0.9 v(rbl_1__t3_act_z)=0.9
.ic v(rbl_2_act_z)=0.9 v(rbl_2__t0_act_z)=0.9 v(rbl_2__t1_act_z)=0.9 v(rbl_2__t2_act_z)=0.9 v(rbl_2__t3_act_z)=0.9 v(rbl_3_act_z)=0.9
.ic v(rbl_3__t0_act_z)=0.9 v(rbl_3__t1_act_z)=0.9 v(rbl_3__t2_act_z)=0.9 v(rbl_3__t3_act_z)=0.9 v(rwl_0_act_z)=1.8 v(rwl_0__t0_act_z)=1.8
.ic v(rwl_0__t1_act_z)=1.8 v(rwl_0__t2_act_z)=1.8 v(rwl_0__t3_act_z)=1.8 v(rwl_1_act_z)=1.8 v(rwl_1__t0_act_z)=1.8 v(rwl_1__t1_act_z)=1.8
.ic v(rwl_1__t2_act_z)=1.8 v(rwl_1__t3_act_z)=1.8 v(rwl_2_act_z)=1.8 v(rwl_2__t0_act_z)=1.8 v(rwl_2__t1_act_z)=1.8 v(rwl_2__t2_act_z)=1.8
.ic v(rwl_2__t3_act_z)=1.8 v(rwl_3_act_z)=1.8 v(rwl_3__t0_act_z)=1.8 v(rwl_3__t1_act_z)=1.8 v(rwl_3__t2_act_z)=1.8 v(rwl_3__t3_act_z)=1.8
.ic v(sn_0_0_act_z)=0 v(sn_0_0__t0_act_z)=0 v(sn_0_0__t1_act_z)=0 v(sn_0_1_act_z)=0 v(sn_0_1__t0_act_z)=0 v(sn_0_1__t1_act_z)=0
.ic v(sn_0_2_act_z)=0 v(sn_0_2__t0_act_z)=0 v(sn_0_2__t1_act_z)=0 v(sn_0_3_act_z)=0 v(sn_0_3__t0_act_z)=0 v(sn_0_3__t1_act_z)=0
.ic v(sn_1_0_act_z)=0 v(sn_1_0__t0_act_z)=0 v(sn_1_0__t1_act_z)=0 v(sn_1_1_act_z)=0 v(sn_1_1__t0_act_z)=0 v(sn_1_1__t1_act_z)=0
.ic v(sn_1_2_act_z)=0 v(sn_1_2__t0_act_z)=0 v(sn_1_2__t1_act_z)=0 v(sn_1_3_act_z)=0 v(sn_1_3__t0_act_z)=0 v(sn_1_3__t1_act_z)=0
.ic v(sn_2_0_act_z)=0 v(sn_2_0__t0_act_z)=0 v(sn_2_0__t1_act_z)=0 v(sn_2_1_act_z)=0 v(sn_2_1__t0_act_z)=0 v(sn_2_1__t1_act_z)=0
.ic v(sn_2_2_act_z)=0 v(sn_2_2__t0_act_z)=0 v(sn_2_2__t1_act_z)=0 v(sn_2_3_act_z)=0 v(sn_2_3__t0_act_z)=0 v(sn_2_3__t1_act_z)=0
.ic v(sn_3_0_act_z)=0 v(sn_3_0__t0_act_z)=0 v(sn_3_0__t1_act_z)=0 v(sn_3_1_act_z)=0 v(sn_3_1__t0_act_z)=0 v(sn_3_1__t1_act_z)=0
.ic v(sn_3_2_act_z)=0 v(sn_3_2__t0_act_z)=0 v(sn_3_2__t1_act_z)=0 v(sn_3_3_act_z)=0 v(sn_3_3__t0_act_z)=0 v(sn_3_3__t1_act_z)=0
.ic v(wl_0_act_z)=0 v(wl_0__t0_act_z)=0 v(wl_0__t1_act_z)=0 v(wl_0__t2_act_z)=0 v(wl_0__t3_act_z)=0 v(wl_1_act_z)=0
.ic v(wl_1__t0_act_z)=0 v(wl_1__t1_act_z)=0 v(wl_1__t2_act_z)=0 v(wl_1__t3_act_z)=0 v(wl_2_act_z)=0 v(wl_2__t0_act_z)=0
.ic v(wl_2__t1_act_z)=0 v(wl_2__t2_act_z)=0 v(wl_2__t3_act_z)=0 v(wl_3_act_z)=0 v(wl_3__t0_act_z)=0 v(wl_3__t1_act_z)=0
.ic v(wl_3__t2_act_z)=0 v(wl_3__t3_act_z)=0 v(bl_0_act_o)=0 v(bl_0__t0_act_o)=0 v(bl_0__t1_act_o)=0 v(bl_0__t2_act_o)=0
.ic v(bl_0__t3_act_o)=0 v(bl_1_act_o)=0 v(bl_1__t0_act_o)=0 v(bl_1__t1_act_o)=0 v(bl_1__t2_act_o)=0 v(bl_1__t3_act_o)=0
.ic v(bl_2_act_o)=0 v(bl_2__t0_act_o)=0 v(bl_2__t1_act_o)=0 v(bl_2__t2_act_o)=0 v(bl_2__t3_act_o)=0 v(bl_3_act_o)=0
.ic v(bl_3__t0_act_o)=0 v(bl_3__t1_act_o)=0 v(bl_3__t2_act_o)=0 v(bl_3__t3_act_o)=0 v(rbl_0_act_o)=0.9 v(rbl_0__t0_act_o)=0.9
.ic v(rbl_0__t1_act_o)=0.9 v(rbl_0__t2_act_o)=0.9 v(rbl_0__t3_act_o)=0.9 v(rbl_1_act_o)=0.9 v(rbl_1__t0_act_o)=0.9 v(rbl_1__t1_act_o)=0.9
.ic v(rbl_1__t2_act_o)=0.9 v(rbl_1__t3_act_o)=0.9 v(rbl_2_act_o)=0.9 v(rbl_2__t0_act_o)=0.9 v(rbl_2__t1_act_o)=0.9 v(rbl_2__t2_act_o)=0.9
.ic v(rbl_2__t3_act_o)=0.9 v(rbl_3_act_o)=0.9 v(rbl_3__t0_act_o)=0.9 v(rbl_3__t1_act_o)=0.9 v(rbl_3__t2_act_o)=0.9 v(rbl_3__t3_act_o)=0.9
.ic v(rwl_0_act_o)=1.8 v(rwl_0__t0_act_o)=1.8 v(rwl_0__t1_act_o)=1.8 v(rwl_0__t2_act_o)=1.8 v(rwl_0__t3_act_o)=1.8 v(rwl_1_act_o)=1.8
.ic v(rwl_1__t0_act_o)=1.8 v(rwl_1__t1_act_o)=1.8 v(rwl_1__t2_act_o)=1.8 v(rwl_1__t3_act_o)=1.8 v(rwl_2_act_o)=1.8 v(rwl_2__t0_act_o)=1.8
.ic v(rwl_2__t1_act_o)=1.8 v(rwl_2__t2_act_o)=1.8 v(rwl_2__t3_act_o)=1.8 v(rwl_3_act_o)=1.8 v(rwl_3__t0_act_o)=1.8 v(rwl_3__t1_act_o)=1.8
.ic v(rwl_3__t2_act_o)=1.8 v(rwl_3__t3_act_o)=1.8 v(sn_0_0_act_o)=0.9 v(sn_0_0__t0_act_o)=0.9 v(sn_0_0__t1_act_o)=0.9 v(sn_0_1_act_o)=0.9
.ic v(sn_0_1__t0_act_o)=0.9 v(sn_0_1__t1_act_o)=0.9 v(sn_0_2_act_o)=0.9 v(sn_0_2__t0_act_o)=0.9 v(sn_0_2__t1_act_o)=0.9 v(sn_0_3_act_o)=0.9
.ic v(sn_0_3__t0_act_o)=0.9 v(sn_0_3__t1_act_o)=0.9 v(sn_1_0_act_o)=0.9 v(sn_1_0__t0_act_o)=0.9 v(sn_1_0__t1_act_o)=0.9 v(sn_1_1_act_o)=0.9
.ic v(sn_1_1__t0_act_o)=0.9 v(sn_1_1__t1_act_o)=0.9 v(sn_1_2_act_o)=0.9 v(sn_1_2__t0_act_o)=0.9 v(sn_1_2__t1_act_o)=0.9 v(sn_1_3_act_o)=0.9
.ic v(sn_1_3__t0_act_o)=0.9 v(sn_1_3__t1_act_o)=0.9 v(sn_2_0_act_o)=0.9 v(sn_2_0__t0_act_o)=0.9 v(sn_2_0__t1_act_o)=0.9 v(sn_2_1_act_o)=0.9
.ic v(sn_2_1__t0_act_o)=0.9 v(sn_2_1__t1_act_o)=0.9 v(sn_2_2_act_o)=0.9 v(sn_2_2__t0_act_o)=0.9 v(sn_2_2__t1_act_o)=0.9 v(sn_2_3_act_o)=0.9
.ic v(sn_2_3__t0_act_o)=0.9 v(sn_2_3__t1_act_o)=0.9 v(sn_3_0_act_o)=0.9 v(sn_3_0__t0_act_o)=0.9 v(sn_3_0__t1_act_o)=0.9 v(sn_3_1_act_o)=0.9
.ic v(sn_3_1__t0_act_o)=0.9 v(sn_3_1__t1_act_o)=0.9 v(sn_3_2_act_o)=0.9 v(sn_3_2__t0_act_o)=0.9 v(sn_3_2__t1_act_o)=0.9 v(sn_3_3_act_o)=0.9
.ic v(sn_3_3__t0_act_o)=0.9 v(sn_3_3__t1_act_o)=0.9 v(wl_0_act_o)=0 v(wl_0__t0_act_o)=0 v(wl_0__t1_act_o)=0 v(wl_0__t2_act_o)=0
.ic v(wl_0__t3_act_o)=0 v(wl_1_act_o)=0 v(wl_1__t0_act_o)=0 v(wl_1__t1_act_o)=0 v(wl_1__t2_act_o)=0 v(wl_1__t3_act_o)=0
.ic v(wl_2_act_o)=0 v(wl_2__t0_act_o)=0 v(wl_2__t1_act_o)=0 v(wl_2__t2_act_o)=0 v(wl_2__t3_act_o)=0 v(wl_3_act_o)=0
.ic v(wl_3__t0_act_o)=0 v(wl_3__t1_act_o)=0 v(wl_3__t2_act_o)=0 v(wl_3__t3_act_o)=0 v(bl_0_act_c)=0 v(bl_0__t0_act_c)=0
.ic v(bl_0__t1_act_c)=0 v(bl_0__t2_act_c)=0 v(bl_0__t3_act_c)=0 v(bl_1_act_c)=0 v(bl_1__t0_act_c)=0 v(bl_1__t1_act_c)=0
.ic v(bl_1__t2_act_c)=0 v(bl_1__t3_act_c)=0 v(bl_2_act_c)=0 v(bl_2__t0_act_c)=0 v(bl_2__t1_act_c)=0 v(bl_2__t2_act_c)=0
.ic v(bl_2__t3_act_c)=0 v(bl_3_act_c)=0 v(bl_3__t0_act_c)=0 v(bl_3__t1_act_c)=0 v(bl_3__t2_act_c)=0 v(bl_3__t3_act_c)=0
.ic v(rbl_0_act_c)=0.9 v(rbl_0__t0_act_c)=0.9 v(rbl_0__t1_act_c)=0.9 v(rbl_0__t2_act_c)=0.9 v(rbl_0__t3_act_c)=0.9 v(rbl_1_act_c)=0.9
.ic v(rbl_1__t0_act_c)=0.9 v(rbl_1__t1_act_c)=0.9 v(rbl_1__t2_act_c)=0.9 v(rbl_1__t3_act_c)=0.9 v(rbl_2_act_c)=0.9 v(rbl_2__t0_act_c)=0.9
.ic v(rbl_2__t1_act_c)=0.9 v(rbl_2__t2_act_c)=0.9 v(rbl_2__t3_act_c)=0.9 v(rbl_3_act_c)=0.9 v(rbl_3__t0_act_c)=0.9 v(rbl_3__t1_act_c)=0.9
.ic v(rbl_3__t2_act_c)=0.9 v(rbl_3__t3_act_c)=0.9 v(rwl_0_act_c)=1.8 v(rwl_0__t0_act_c)=1.8 v(rwl_0__t1_act_c)=1.8 v(rwl_0__t2_act_c)=1.8
.ic v(rwl_0__t3_act_c)=1.8 v(rwl_1_act_c)=1.8 v(rwl_1__t0_act_c)=1.8 v(rwl_1__t1_act_c)=1.8 v(rwl_1__t2_act_c)=1.8 v(rwl_1__t3_act_c)=1.8
.ic v(rwl_2_act_c)=1.8 v(rwl_2__t0_act_c)=1.8 v(rwl_2__t1_act_c)=1.8 v(rwl_2__t2_act_c)=1.8 v(rwl_2__t3_act_c)=1.8 v(rwl_3_act_c)=1.8
.ic v(rwl_3__t0_act_c)=1.8 v(rwl_3__t1_act_c)=1.8 v(rwl_3__t2_act_c)=1.8 v(rwl_3__t3_act_c)=1.8 v(sn_0_0_act_c)=0.9 v(sn_0_0__t0_act_c)=0.9
.ic v(sn_0_0__t1_act_c)=0.9 v(sn_0_1_act_c)=0 v(sn_0_1__t0_act_c)=0 v(sn_0_1__t1_act_c)=0 v(sn_0_2_act_c)=0.9 v(sn_0_2__t0_act_c)=0.9
.ic v(sn_0_2__t1_act_c)=0.9 v(sn_0_3_act_c)=0 v(sn_0_3__t0_act_c)=0 v(sn_0_3__t1_act_c)=0 v(sn_1_0_act_c)=0 v(sn_1_0__t0_act_c)=0
.ic v(sn_1_0__t1_act_c)=0 v(sn_1_1_act_c)=0.9 v(sn_1_1__t0_act_c)=0.9 v(sn_1_1__t1_act_c)=0.9 v(sn_1_2_act_c)=0 v(sn_1_2__t0_act_c)=0
.ic v(sn_1_2__t1_act_c)=0 v(sn_1_3_act_c)=0.9 v(sn_1_3__t0_act_c)=0.9 v(sn_1_3__t1_act_c)=0.9 v(sn_2_0_act_c)=0.9 v(sn_2_0__t0_act_c)=0.9
.ic v(sn_2_0__t1_act_c)=0.9 v(sn_2_1_act_c)=0 v(sn_2_1__t0_act_c)=0 v(sn_2_1__t1_act_c)=0 v(sn_2_2_act_c)=0.9 v(sn_2_2__t0_act_c)=0.9
.ic v(sn_2_2__t1_act_c)=0.9 v(sn_2_3_act_c)=0 v(sn_2_3__t0_act_c)=0 v(sn_2_3__t1_act_c)=0 v(sn_3_0_act_c)=0 v(sn_3_0__t0_act_c)=0
.ic v(sn_3_0__t1_act_c)=0 v(sn_3_1_act_c)=0.9 v(sn_3_1__t0_act_c)=0.9 v(sn_3_1__t1_act_c)=0.9 v(sn_3_2_act_c)=0 v(sn_3_2__t0_act_c)=0
.ic v(sn_3_2__t1_act_c)=0 v(sn_3_3_act_c)=0.9 v(sn_3_3__t0_act_c)=0.9 v(sn_3_3__t1_act_c)=0.9 v(wl_0_act_c)=0 v(wl_0__t0_act_c)=0
.ic v(wl_0__t1_act_c)=0 v(wl_0__t2_act_c)=0 v(wl_0__t3_act_c)=0 v(wl_1_act_c)=0 v(wl_1__t0_act_c)=0 v(wl_1__t1_act_c)=0
.ic v(wl_1__t2_act_c)=0 v(wl_1__t3_act_c)=0 v(wl_2_act_c)=0 v(wl_2__t0_act_c)=0 v(wl_2__t1_act_c)=0 v(wl_2__t2_act_c)=0
.ic v(wl_2__t3_act_c)=0 v(wl_3_act_c)=0 v(wl_3__t0_act_c)=0 v(wl_3__t1_act_c)=0 v(wl_3__t2_act_c)=0 v(wl_3__t3_act_c)=0
.ic v(bl_0_act_i)=0 v(bl_0__t0_act_i)=0 v(bl_0__t1_act_i)=0 v(bl_0__t2_act_i)=0 v(bl_0__t3_act_i)=0 v(bl_1_act_i)=0
.ic v(bl_1__t0_act_i)=0 v(bl_1__t1_act_i)=0 v(bl_1__t2_act_i)=0 v(bl_1__t3_act_i)=0 v(bl_2_act_i)=0 v(bl_2__t0_act_i)=0
.ic v(bl_2__t1_act_i)=0 v(bl_2__t2_act_i)=0 v(bl_2__t3_act_i)=0 v(bl_3_act_i)=0 v(bl_3__t0_act_i)=0 v(bl_3__t1_act_i)=0
.ic v(bl_3__t2_act_i)=0 v(bl_3__t3_act_i)=0 v(rbl_0_act_i)=0.9 v(rbl_0__t0_act_i)=0.9 v(rbl_0__t1_act_i)=0.9 v(rbl_0__t2_act_i)=0.9
.ic v(rbl_0__t3_act_i)=0.9 v(rbl_1_act_i)=0.9 v(rbl_1__t0_act_i)=0.9 v(rbl_1__t1_act_i)=0.9 v(rbl_1__t2_act_i)=0.9 v(rbl_1__t3_act_i)=0.9
.ic v(rbl_2_act_i)=0.9 v(rbl_2__t0_act_i)=0.9 v(rbl_2__t1_act_i)=0.9 v(rbl_2__t2_act_i)=0.9 v(rbl_2__t3_act_i)=0.9 v(rbl_3_act_i)=0.9
.ic v(rbl_3__t0_act_i)=0.9 v(rbl_3__t1_act_i)=0.9 v(rbl_3__t2_act_i)=0.9 v(rbl_3__t3_act_i)=0.9 v(rwl_0_act_i)=1.8 v(rwl_0__t0_act_i)=1.8
.ic v(rwl_0__t1_act_i)=1.8 v(rwl_0__t2_act_i)=1.8 v(rwl_0__t3_act_i)=1.8 v(rwl_1_act_i)=1.8 v(rwl_1__t0_act_i)=1.8 v(rwl_1__t1_act_i)=1.8
.ic v(rwl_1__t2_act_i)=1.8 v(rwl_1__t3_act_i)=1.8 v(rwl_2_act_i)=1.8 v(rwl_2__t0_act_i)=1.8 v(rwl_2__t1_act_i)=1.8 v(rwl_2__t2_act_i)=1.8
.ic v(rwl_2__t3_act_i)=1.8 v(rwl_3_act_i)=1.8 v(rwl_3__t0_act_i)=1.8 v(rwl_3__t1_act_i)=1.8 v(rwl_3__t2_act_i)=1.8 v(rwl_3__t3_act_i)=1.8
.ic v(sn_0_0_act_i)=0 v(sn_0_0__t0_act_i)=0 v(sn_0_0__t1_act_i)=0 v(sn_0_1_act_i)=0.9 v(sn_0_1__t0_act_i)=0.9 v(sn_0_1__t1_act_i)=0.9
.ic v(sn_0_2_act_i)=0 v(sn_0_2__t0_act_i)=0 v(sn_0_2__t1_act_i)=0 v(sn_0_3_act_i)=0.9 v(sn_0_3__t0_act_i)=0.9 v(sn_0_3__t1_act_i)=0.9
.ic v(sn_1_0_act_i)=0.9 v(sn_1_0__t0_act_i)=0.9 v(sn_1_0__t1_act_i)=0.9 v(sn_1_1_act_i)=0 v(sn_1_1__t0_act_i)=0 v(sn_1_1__t1_act_i)=0
.ic v(sn_1_2_act_i)=0.9 v(sn_1_2__t0_act_i)=0.9 v(sn_1_2__t1_act_i)=0.9 v(sn_1_3_act_i)=0 v(sn_1_3__t0_act_i)=0 v(sn_1_3__t1_act_i)=0
.ic v(sn_2_0_act_i)=0 v(sn_2_0__t0_act_i)=0 v(sn_2_0__t1_act_i)=0 v(sn_2_1_act_i)=0.9 v(sn_2_1__t0_act_i)=0.9 v(sn_2_1__t1_act_i)=0.9
.ic v(sn_2_2_act_i)=0 v(sn_2_2__t0_act_i)=0 v(sn_2_2__t1_act_i)=0 v(sn_2_3_act_i)=0.9 v(sn_2_3__t0_act_i)=0.9 v(sn_2_3__t1_act_i)=0.9
.ic v(sn_3_0_act_i)=0.9 v(sn_3_0__t0_act_i)=0.9 v(sn_3_0__t1_act_i)=0.9 v(sn_3_1_act_i)=0 v(sn_3_1__t0_act_i)=0 v(sn_3_1__t1_act_i)=0
.ic v(sn_3_2_act_i)=0.9 v(sn_3_2__t0_act_i)=0.9 v(sn_3_2__t1_act_i)=0.9 v(sn_3_3_act_i)=0 v(sn_3_3__t0_act_i)=0 v(sn_3_3__t1_act_i)=0
.ic v(wl_0_act_i)=0 v(wl_0__t0_act_i)=0 v(wl_0__t1_act_i)=0 v(wl_0__t2_act_i)=0 v(wl_0__t3_act_i)=0 v(wl_1_act_i)=0
.ic v(wl_1__t0_act_i)=0 v(wl_1__t1_act_i)=0 v(wl_1__t2_act_i)=0 v(wl_1__t3_act_i)=0 v(wl_2_act_i)=0 v(wl_2__t0_act_i)=0
.ic v(wl_2__t1_act_i)=0 v(wl_2__t2_act_i)=0 v(wl_2__t3_act_i)=0 v(wl_3_act_i)=0 v(wl_3__t0_act_i)=0 v(wl_3__t1_act_i)=0
.ic v(wl_3__t2_act_i)=0 v(wl_3__t3_act_i)=0 v(bl_0_idl_z)=0 v(bl_0__t0_idl_z)=0 v(bl_0__t1_idl_z)=0 v(bl_0__t2_idl_z)=0
.ic v(bl_0__t3_idl_z)=0 v(bl_1_idl_z)=0 v(bl_1__t0_idl_z)=0 v(bl_1__t1_idl_z)=0 v(bl_1__t2_idl_z)=0 v(bl_1__t3_idl_z)=0
.ic v(bl_2_idl_z)=0 v(bl_2__t0_idl_z)=0 v(bl_2__t1_idl_z)=0 v(bl_2__t2_idl_z)=0 v(bl_2__t3_idl_z)=0 v(bl_3_idl_z)=0
.ic v(bl_3__t0_idl_z)=0 v(bl_3__t1_idl_z)=0 v(bl_3__t2_idl_z)=0 v(bl_3__t3_idl_z)=0 v(rbl_0_idl_z)=0.9 v(rbl_0__t0_idl_z)=0.9
.ic v(rbl_0__t1_idl_z)=0.9 v(rbl_0__t2_idl_z)=0.9 v(rbl_0__t3_idl_z)=0.9 v(rbl_1_idl_z)=0.9 v(rbl_1__t0_idl_z)=0.9 v(rbl_1__t1_idl_z)=0.9
.ic v(rbl_1__t2_idl_z)=0.9 v(rbl_1__t3_idl_z)=0.9 v(rbl_2_idl_z)=0.9 v(rbl_2__t0_idl_z)=0.9 v(rbl_2__t1_idl_z)=0.9 v(rbl_2__t2_idl_z)=0.9
.ic v(rbl_2__t3_idl_z)=0.9 v(rbl_3_idl_z)=0.9 v(rbl_3__t0_idl_z)=0.9 v(rbl_3__t1_idl_z)=0.9 v(rbl_3__t2_idl_z)=0.9 v(rbl_3__t3_idl_z)=0.9
.ic v(rwl_0_idl_z)=1.8 v(rwl_0__t0_idl_z)=1.8 v(rwl_0__t1_idl_z)=1.8 v(rwl_0__t2_idl_z)=1.8 v(rwl_0__t3_idl_z)=1.8 v(rwl_1_idl_z)=1.8
.ic v(rwl_1__t0_idl_z)=1.8 v(rwl_1__t1_idl_z)=1.8 v(rwl_1__t2_idl_z)=1.8 v(rwl_1__t3_idl_z)=1.8 v(rwl_2_idl_z)=1.8 v(rwl_2__t0_idl_z)=1.8
.ic v(rwl_2__t1_idl_z)=1.8 v(rwl_2__t2_idl_z)=1.8 v(rwl_2__t3_idl_z)=1.8 v(rwl_3_idl_z)=1.8 v(rwl_3__t0_idl_z)=1.8 v(rwl_3__t1_idl_z)=1.8
.ic v(rwl_3__t2_idl_z)=1.8 v(rwl_3__t3_idl_z)=1.8 v(sn_0_0_idl_z)=0 v(sn_0_0__t0_idl_z)=0 v(sn_0_0__t1_idl_z)=0 v(sn_0_1_idl_z)=0
.ic v(sn_0_1__t0_idl_z)=0 v(sn_0_1__t1_idl_z)=0 v(sn_0_2_idl_z)=0 v(sn_0_2__t0_idl_z)=0 v(sn_0_2__t1_idl_z)=0 v(sn_0_3_idl_z)=0
.ic v(sn_0_3__t0_idl_z)=0 v(sn_0_3__t1_idl_z)=0 v(sn_1_0_idl_z)=0 v(sn_1_0__t0_idl_z)=0 v(sn_1_0__t1_idl_z)=0 v(sn_1_1_idl_z)=0
.ic v(sn_1_1__t0_idl_z)=0 v(sn_1_1__t1_idl_z)=0 v(sn_1_2_idl_z)=0 v(sn_1_2__t0_idl_z)=0 v(sn_1_2__t1_idl_z)=0 v(sn_1_3_idl_z)=0
.ic v(sn_1_3__t0_idl_z)=0 v(sn_1_3__t1_idl_z)=0 v(sn_2_0_idl_z)=0 v(sn_2_0__t0_idl_z)=0 v(sn_2_0__t1_idl_z)=0 v(sn_2_1_idl_z)=0
.ic v(sn_2_1__t0_idl_z)=0 v(sn_2_1__t1_idl_z)=0 v(sn_2_2_idl_z)=0 v(sn_2_2__t0_idl_z)=0 v(sn_2_2__t1_idl_z)=0 v(sn_2_3_idl_z)=0
.ic v(sn_2_3__t0_idl_z)=0 v(sn_2_3__t1_idl_z)=0 v(sn_3_0_idl_z)=0 v(sn_3_0__t0_idl_z)=0 v(sn_3_0__t1_idl_z)=0 v(sn_3_1_idl_z)=0
.ic v(sn_3_1__t0_idl_z)=0 v(sn_3_1__t1_idl_z)=0 v(sn_3_2_idl_z)=0 v(sn_3_2__t0_idl_z)=0 v(sn_3_2__t1_idl_z)=0 v(sn_3_3_idl_z)=0
.ic v(sn_3_3__t0_idl_z)=0 v(sn_3_3__t1_idl_z)=0 v(wl_0_idl_z)=0 v(wl_0__t0_idl_z)=0 v(wl_0__t1_idl_z)=0 v(wl_0__t2_idl_z)=0
.ic v(wl_0__t3_idl_z)=0 v(wl_1_idl_z)=0 v(wl_1__t0_idl_z)=0 v(wl_1__t1_idl_z)=0 v(wl_1__t2_idl_z)=0 v(wl_1__t3_idl_z)=0
.ic v(wl_2_idl_z)=0 v(wl_2__t0_idl_z)=0 v(wl_2__t1_idl_z)=0 v(wl_2__t2_idl_z)=0 v(wl_2__t3_idl_z)=0 v(wl_3_idl_z)=0
.ic v(wl_3__t0_idl_z)=0 v(wl_3__t1_idl_z)=0 v(wl_3__t2_idl_z)=0 v(wl_3__t3_idl_z)=0 v(bl_0_idl_o)=0 v(bl_0__t0_idl_o)=0
.ic v(bl_0__t1_idl_o)=0 v(bl_0__t2_idl_o)=0 v(bl_0__t3_idl_o)=0 v(bl_1_idl_o)=0 v(bl_1__t0_idl_o)=0 v(bl_1__t1_idl_o)=0
.ic v(bl_1__t2_idl_o)=0 v(bl_1__t3_idl_o)=0 v(bl_2_idl_o)=0 v(bl_2__t0_idl_o)=0 v(bl_2__t1_idl_o)=0 v(bl_2__t2_idl_o)=0
.ic v(bl_2__t3_idl_o)=0 v(bl_3_idl_o)=0 v(bl_3__t0_idl_o)=0 v(bl_3__t1_idl_o)=0 v(bl_3__t2_idl_o)=0 v(bl_3__t3_idl_o)=0
.ic v(rbl_0_idl_o)=0.9 v(rbl_0__t0_idl_o)=0.9 v(rbl_0__t1_idl_o)=0.9 v(rbl_0__t2_idl_o)=0.9 v(rbl_0__t3_idl_o)=0.9 v(rbl_1_idl_o)=0.9
.ic v(rbl_1__t0_idl_o)=0.9 v(rbl_1__t1_idl_o)=0.9 v(rbl_1__t2_idl_o)=0.9 v(rbl_1__t3_idl_o)=0.9 v(rbl_2_idl_o)=0.9 v(rbl_2__t0_idl_o)=0.9
.ic v(rbl_2__t1_idl_o)=0.9 v(rbl_2__t2_idl_o)=0.9 v(rbl_2__t3_idl_o)=0.9 v(rbl_3_idl_o)=0.9 v(rbl_3__t0_idl_o)=0.9 v(rbl_3__t1_idl_o)=0.9
.ic v(rbl_3__t2_idl_o)=0.9 v(rbl_3__t3_idl_o)=0.9 v(rwl_0_idl_o)=1.8 v(rwl_0__t0_idl_o)=1.8 v(rwl_0__t1_idl_o)=1.8 v(rwl_0__t2_idl_o)=1.8
.ic v(rwl_0__t3_idl_o)=1.8 v(rwl_1_idl_o)=1.8 v(rwl_1__t0_idl_o)=1.8 v(rwl_1__t1_idl_o)=1.8 v(rwl_1__t2_idl_o)=1.8 v(rwl_1__t3_idl_o)=1.8
.ic v(rwl_2_idl_o)=1.8 v(rwl_2__t0_idl_o)=1.8 v(rwl_2__t1_idl_o)=1.8 v(rwl_2__t2_idl_o)=1.8 v(rwl_2__t3_idl_o)=1.8 v(rwl_3_idl_o)=1.8
.ic v(rwl_3__t0_idl_o)=1.8 v(rwl_3__t1_idl_o)=1.8 v(rwl_3__t2_idl_o)=1.8 v(rwl_3__t3_idl_o)=1.8 v(sn_0_0_idl_o)=0.9 v(sn_0_0__t0_idl_o)=0.9
.ic v(sn_0_0__t1_idl_o)=0.9 v(sn_0_1_idl_o)=0.9 v(sn_0_1__t0_idl_o)=0.9 v(sn_0_1__t1_idl_o)=0.9 v(sn_0_2_idl_o)=0.9 v(sn_0_2__t0_idl_o)=0.9
.ic v(sn_0_2__t1_idl_o)=0.9 v(sn_0_3_idl_o)=0.9 v(sn_0_3__t0_idl_o)=0.9 v(sn_0_3__t1_idl_o)=0.9 v(sn_1_0_idl_o)=0.9 v(sn_1_0__t0_idl_o)=0.9
.ic v(sn_1_0__t1_idl_o)=0.9 v(sn_1_1_idl_o)=0.9 v(sn_1_1__t0_idl_o)=0.9 v(sn_1_1__t1_idl_o)=0.9 v(sn_1_2_idl_o)=0.9 v(sn_1_2__t0_idl_o)=0.9
.ic v(sn_1_2__t1_idl_o)=0.9 v(sn_1_3_idl_o)=0.9 v(sn_1_3__t0_idl_o)=0.9 v(sn_1_3__t1_idl_o)=0.9 v(sn_2_0_idl_o)=0.9 v(sn_2_0__t0_idl_o)=0.9
.ic v(sn_2_0__t1_idl_o)=0.9 v(sn_2_1_idl_o)=0.9 v(sn_2_1__t0_idl_o)=0.9 v(sn_2_1__t1_idl_o)=0.9 v(sn_2_2_idl_o)=0.9 v(sn_2_2__t0_idl_o)=0.9
.ic v(sn_2_2__t1_idl_o)=0.9 v(sn_2_3_idl_o)=0.9 v(sn_2_3__t0_idl_o)=0.9 v(sn_2_3__t1_idl_o)=0.9 v(sn_3_0_idl_o)=0.9 v(sn_3_0__t0_idl_o)=0.9
.ic v(sn_3_0__t1_idl_o)=0.9 v(sn_3_1_idl_o)=0.9 v(sn_3_1__t0_idl_o)=0.9 v(sn_3_1__t1_idl_o)=0.9 v(sn_3_2_idl_o)=0.9 v(sn_3_2__t0_idl_o)=0.9
.ic v(sn_3_2__t1_idl_o)=0.9 v(sn_3_3_idl_o)=0.9 v(sn_3_3__t0_idl_o)=0.9 v(sn_3_3__t1_idl_o)=0.9 v(wl_0_idl_o)=0 v(wl_0__t0_idl_o)=0
.ic v(wl_0__t1_idl_o)=0 v(wl_0__t2_idl_o)=0 v(wl_0__t3_idl_o)=0 v(wl_1_idl_o)=0 v(wl_1__t0_idl_o)=0 v(wl_1__t1_idl_o)=0
.ic v(wl_1__t2_idl_o)=0 v(wl_1__t3_idl_o)=0 v(wl_2_idl_o)=0 v(wl_2__t0_idl_o)=0 v(wl_2__t1_idl_o)=0 v(wl_2__t2_idl_o)=0
.ic v(wl_2__t3_idl_o)=0 v(wl_3_idl_o)=0 v(wl_3__t0_idl_o)=0 v(wl_3__t1_idl_o)=0 v(wl_3__t2_idl_o)=0 v(wl_3__t3_idl_o)=0
.ic v(bl_0_idl_c)=0 v(bl_0__t0_idl_c)=0 v(bl_0__t1_idl_c)=0 v(bl_0__t2_idl_c)=0 v(bl_0__t3_idl_c)=0 v(bl_1_idl_c)=0
.ic v(bl_1__t0_idl_c)=0 v(bl_1__t1_idl_c)=0 v(bl_1__t2_idl_c)=0 v(bl_1__t3_idl_c)=0 v(bl_2_idl_c)=0 v(bl_2__t0_idl_c)=0
.ic v(bl_2__t1_idl_c)=0 v(bl_2__t2_idl_c)=0 v(bl_2__t3_idl_c)=0 v(bl_3_idl_c)=0 v(bl_3__t0_idl_c)=0 v(bl_3__t1_idl_c)=0
.ic v(bl_3__t2_idl_c)=0 v(bl_3__t3_idl_c)=0 v(rbl_0_idl_c)=0.9 v(rbl_0__t0_idl_c)=0.9 v(rbl_0__t1_idl_c)=0.9 v(rbl_0__t2_idl_c)=0.9
.ic v(rbl_0__t3_idl_c)=0.9 v(rbl_1_idl_c)=0.9 v(rbl_1__t0_idl_c)=0.9 v(rbl_1__t1_idl_c)=0.9 v(rbl_1__t2_idl_c)=0.9 v(rbl_1__t3_idl_c)=0.9
.ic v(rbl_2_idl_c)=0.9 v(rbl_2__t0_idl_c)=0.9 v(rbl_2__t1_idl_c)=0.9 v(rbl_2__t2_idl_c)=0.9 v(rbl_2__t3_idl_c)=0.9 v(rbl_3_idl_c)=0.9
.ic v(rbl_3__t0_idl_c)=0.9 v(rbl_3__t1_idl_c)=0.9 v(rbl_3__t2_idl_c)=0.9 v(rbl_3__t3_idl_c)=0.9 v(rwl_0_idl_c)=1.8 v(rwl_0__t0_idl_c)=1.8
.ic v(rwl_0__t1_idl_c)=1.8 v(rwl_0__t2_idl_c)=1.8 v(rwl_0__t3_idl_c)=1.8 v(rwl_1_idl_c)=1.8 v(rwl_1__t0_idl_c)=1.8 v(rwl_1__t1_idl_c)=1.8
.ic v(rwl_1__t2_idl_c)=1.8 v(rwl_1__t3_idl_c)=1.8 v(rwl_2_idl_c)=1.8 v(rwl_2__t0_idl_c)=1.8 v(rwl_2__t1_idl_c)=1.8 v(rwl_2__t2_idl_c)=1.8
.ic v(rwl_2__t3_idl_c)=1.8 v(rwl_3_idl_c)=1.8 v(rwl_3__t0_idl_c)=1.8 v(rwl_3__t1_idl_c)=1.8 v(rwl_3__t2_idl_c)=1.8 v(rwl_3__t3_idl_c)=1.8
.ic v(sn_0_0_idl_c)=0.9 v(sn_0_0__t0_idl_c)=0.9 v(sn_0_0__t1_idl_c)=0.9 v(sn_0_1_idl_c)=0 v(sn_0_1__t0_idl_c)=0 v(sn_0_1__t1_idl_c)=0
.ic v(sn_0_2_idl_c)=0.9 v(sn_0_2__t0_idl_c)=0.9 v(sn_0_2__t1_idl_c)=0.9 v(sn_0_3_idl_c)=0 v(sn_0_3__t0_idl_c)=0 v(sn_0_3__t1_idl_c)=0
.ic v(sn_1_0_idl_c)=0 v(sn_1_0__t0_idl_c)=0 v(sn_1_0__t1_idl_c)=0 v(sn_1_1_idl_c)=0.9 v(sn_1_1__t0_idl_c)=0.9 v(sn_1_1__t1_idl_c)=0.9
.ic v(sn_1_2_idl_c)=0 v(sn_1_2__t0_idl_c)=0 v(sn_1_2__t1_idl_c)=0 v(sn_1_3_idl_c)=0.9 v(sn_1_3__t0_idl_c)=0.9 v(sn_1_3__t1_idl_c)=0.9
.ic v(sn_2_0_idl_c)=0.9 v(sn_2_0__t0_idl_c)=0.9 v(sn_2_0__t1_idl_c)=0.9 v(sn_2_1_idl_c)=0 v(sn_2_1__t0_idl_c)=0 v(sn_2_1__t1_idl_c)=0
.ic v(sn_2_2_idl_c)=0.9 v(sn_2_2__t0_idl_c)=0.9 v(sn_2_2__t1_idl_c)=0.9 v(sn_2_3_idl_c)=0 v(sn_2_3__t0_idl_c)=0 v(sn_2_3__t1_idl_c)=0
.ic v(sn_3_0_idl_c)=0 v(sn_3_0__t0_idl_c)=0 v(sn_3_0__t1_idl_c)=0 v(sn_3_1_idl_c)=0.9 v(sn_3_1__t0_idl_c)=0.9 v(sn_3_1__t1_idl_c)=0.9
.ic v(sn_3_2_idl_c)=0 v(sn_3_2__t0_idl_c)=0 v(sn_3_2__t1_idl_c)=0 v(sn_3_3_idl_c)=0.9 v(sn_3_3__t0_idl_c)=0.9 v(sn_3_3__t1_idl_c)=0.9
.ic v(wl_0_idl_c)=0 v(wl_0__t0_idl_c)=0 v(wl_0__t1_idl_c)=0 v(wl_0__t2_idl_c)=0 v(wl_0__t3_idl_c)=0 v(wl_1_idl_c)=0
.ic v(wl_1__t0_idl_c)=0 v(wl_1__t1_idl_c)=0 v(wl_1__t2_idl_c)=0 v(wl_1__t3_idl_c)=0 v(wl_2_idl_c)=0 v(wl_2__t0_idl_c)=0
.ic v(wl_2__t1_idl_c)=0 v(wl_2__t2_idl_c)=0 v(wl_2__t3_idl_c)=0 v(wl_3_idl_c)=0 v(wl_3__t0_idl_c)=0 v(wl_3__t1_idl_c)=0
.ic v(wl_3__t2_idl_c)=0 v(wl_3__t3_idl_c)=0 v(bl_0_idl_i)=0 v(bl_0__t0_idl_i)=0 v(bl_0__t1_idl_i)=0 v(bl_0__t2_idl_i)=0
.ic v(bl_0__t3_idl_i)=0 v(bl_1_idl_i)=0 v(bl_1__t0_idl_i)=0 v(bl_1__t1_idl_i)=0 v(bl_1__t2_idl_i)=0 v(bl_1__t3_idl_i)=0
.ic v(bl_2_idl_i)=0 v(bl_2__t0_idl_i)=0 v(bl_2__t1_idl_i)=0 v(bl_2__t2_idl_i)=0 v(bl_2__t3_idl_i)=0 v(bl_3_idl_i)=0
.ic v(bl_3__t0_idl_i)=0 v(bl_3__t1_idl_i)=0 v(bl_3__t2_idl_i)=0 v(bl_3__t3_idl_i)=0 v(rbl_0_idl_i)=0.9 v(rbl_0__t0_idl_i)=0.9
.ic v(rbl_0__t1_idl_i)=0.9 v(rbl_0__t2_idl_i)=0.9 v(rbl_0__t3_idl_i)=0.9 v(rbl_1_idl_i)=0.9 v(rbl_1__t0_idl_i)=0.9 v(rbl_1__t1_idl_i)=0.9
.ic v(rbl_1__t2_idl_i)=0.9 v(rbl_1__t3_idl_i)=0.9 v(rbl_2_idl_i)=0.9 v(rbl_2__t0_idl_i)=0.9 v(rbl_2__t1_idl_i)=0.9 v(rbl_2__t2_idl_i)=0.9
.ic v(rbl_2__t3_idl_i)=0.9 v(rbl_3_idl_i)=0.9 v(rbl_3__t0_idl_i)=0.9 v(rbl_3__t1_idl_i)=0.9 v(rbl_3__t2_idl_i)=0.9 v(rbl_3__t3_idl_i)=0.9
.ic v(rwl_0_idl_i)=1.8 v(rwl_0__t0_idl_i)=1.8 v(rwl_0__t1_idl_i)=1.8 v(rwl_0__t2_idl_i)=1.8 v(rwl_0__t3_idl_i)=1.8 v(rwl_1_idl_i)=1.8
.ic v(rwl_1__t0_idl_i)=1.8 v(rwl_1__t1_idl_i)=1.8 v(rwl_1__t2_idl_i)=1.8 v(rwl_1__t3_idl_i)=1.8 v(rwl_2_idl_i)=1.8 v(rwl_2__t0_idl_i)=1.8
.ic v(rwl_2__t1_idl_i)=1.8 v(rwl_2__t2_idl_i)=1.8 v(rwl_2__t3_idl_i)=1.8 v(rwl_3_idl_i)=1.8 v(rwl_3__t0_idl_i)=1.8 v(rwl_3__t1_idl_i)=1.8
.ic v(rwl_3__t2_idl_i)=1.8 v(rwl_3__t3_idl_i)=1.8 v(sn_0_0_idl_i)=0 v(sn_0_0__t0_idl_i)=0 v(sn_0_0__t1_idl_i)=0 v(sn_0_1_idl_i)=0.9
.ic v(sn_0_1__t0_idl_i)=0.9 v(sn_0_1__t1_idl_i)=0.9 v(sn_0_2_idl_i)=0 v(sn_0_2__t0_idl_i)=0 v(sn_0_2__t1_idl_i)=0 v(sn_0_3_idl_i)=0.9
.ic v(sn_0_3__t0_idl_i)=0.9 v(sn_0_3__t1_idl_i)=0.9 v(sn_1_0_idl_i)=0.9 v(sn_1_0__t0_idl_i)=0.9 v(sn_1_0__t1_idl_i)=0.9 v(sn_1_1_idl_i)=0
.ic v(sn_1_1__t0_idl_i)=0 v(sn_1_1__t1_idl_i)=0 v(sn_1_2_idl_i)=0.9 v(sn_1_2__t0_idl_i)=0.9 v(sn_1_2__t1_idl_i)=0.9 v(sn_1_3_idl_i)=0
.ic v(sn_1_3__t0_idl_i)=0 v(sn_1_3__t1_idl_i)=0 v(sn_2_0_idl_i)=0 v(sn_2_0__t0_idl_i)=0 v(sn_2_0__t1_idl_i)=0 v(sn_2_1_idl_i)=0.9
.ic v(sn_2_1__t0_idl_i)=0.9 v(sn_2_1__t1_idl_i)=0.9 v(sn_2_2_idl_i)=0 v(sn_2_2__t0_idl_i)=0 v(sn_2_2__t1_idl_i)=0 v(sn_2_3_idl_i)=0.9
.ic v(sn_2_3__t0_idl_i)=0.9 v(sn_2_3__t1_idl_i)=0.9 v(sn_3_0_idl_i)=0.9 v(sn_3_0__t0_idl_i)=0.9 v(sn_3_0__t1_idl_i)=0.9 v(sn_3_1_idl_i)=0
.ic v(sn_3_1__t0_idl_i)=0 v(sn_3_1__t1_idl_i)=0 v(sn_3_2_idl_i)=0.9 v(sn_3_2__t0_idl_i)=0.9 v(sn_3_2__t1_idl_i)=0.9 v(sn_3_3_idl_i)=0
.ic v(sn_3_3__t0_idl_i)=0 v(sn_3_3__t1_idl_i)=0 v(wl_0_idl_i)=0 v(wl_0__t0_idl_i)=0 v(wl_0__t1_idl_i)=0 v(wl_0__t2_idl_i)=0
.ic v(wl_0__t3_idl_i)=0 v(wl_1_idl_i)=0 v(wl_1__t0_idl_i)=0 v(wl_1__t1_idl_i)=0 v(wl_1__t2_idl_i)=0 v(wl_1__t3_idl_i)=0
.ic v(wl_2_idl_i)=0 v(wl_2__t0_idl_i)=0 v(wl_2__t1_idl_i)=0 v(wl_2__t2_idl_i)=0 v(wl_2__t3_idl_i)=0 v(wl_3_idl_i)=0
.ic v(wl_3__t0_idl_i)=0 v(wl_3__t1_idl_i)=0 v(wl_3__t2_idl_i)=0 v(wl_3__t3_idl_i)=0 v(bl_0_nop_c)=0 v(bl_0__t0_nop_c)=0
.ic v(bl_0__t1_nop_c)=0 v(bl_0__t2_nop_c)=0 v(bl_0__t3_nop_c)=0 v(bl_1_nop_c)=0 v(bl_1__t0_nop_c)=0 v(bl_1__t1_nop_c)=0
.ic v(bl_1__t2_nop_c)=0 v(bl_1__t3_nop_c)=0 v(bl_2_nop_c)=0 v(bl_2__t0_nop_c)=0 v(bl_2__t1_nop_c)=0 v(bl_2__t2_nop_c)=0
.ic v(bl_2__t3_nop_c)=0 v(bl_3_nop_c)=0 v(bl_3__t0_nop_c)=0 v(bl_3__t1_nop_c)=0 v(bl_3__t2_nop_c)=0 v(bl_3__t3_nop_c)=0
.ic v(rbl_0_nop_c)=0.9 v(rbl_0__t0_nop_c)=0.9 v(rbl_0__t1_nop_c)=0.9 v(rbl_0__t2_nop_c)=0.9 v(rbl_0__t3_nop_c)=0.9 v(rbl_1_nop_c)=0.9
.ic v(rbl_1__t0_nop_c)=0.9 v(rbl_1__t1_nop_c)=0.9 v(rbl_1__t2_nop_c)=0.9 v(rbl_1__t3_nop_c)=0.9 v(rbl_2_nop_c)=0.9 v(rbl_2__t0_nop_c)=0.9
.ic v(rbl_2__t1_nop_c)=0.9 v(rbl_2__t2_nop_c)=0.9 v(rbl_2__t3_nop_c)=0.9 v(rbl_3_nop_c)=0.9 v(rbl_3__t0_nop_c)=0.9 v(rbl_3__t1_nop_c)=0.9
.ic v(rbl_3__t2_nop_c)=0.9 v(rbl_3__t3_nop_c)=0.9 v(rwl_0_nop_c)=1.8 v(rwl_0__t0_nop_c)=1.8 v(rwl_0__t1_nop_c)=1.8 v(rwl_0__t2_nop_c)=1.8
.ic v(rwl_0__t3_nop_c)=1.8 v(rwl_1_nop_c)=1.8 v(rwl_1__t0_nop_c)=1.8 v(rwl_1__t1_nop_c)=1.8 v(rwl_1__t2_nop_c)=1.8 v(rwl_1__t3_nop_c)=1.8
.ic v(rwl_2_nop_c)=1.8 v(rwl_2__t0_nop_c)=1.8 v(rwl_2__t1_nop_c)=1.8 v(rwl_2__t2_nop_c)=1.8 v(rwl_2__t3_nop_c)=1.8 v(rwl_3_nop_c)=1.8
.ic v(rwl_3__t0_nop_c)=1.8 v(rwl_3__t1_nop_c)=1.8 v(rwl_3__t2_nop_c)=1.8 v(rwl_3__t3_nop_c)=1.8 v(sn_0_0_nop_c)=0.9 v(sn_0_0__t0_nop_c)=0.9
.ic v(sn_0_0__t1_nop_c)=0.9 v(sn_0_1_nop_c)=0 v(sn_0_1__t0_nop_c)=0 v(sn_0_1__t1_nop_c)=0 v(sn_0_2_nop_c)=0.9 v(sn_0_2__t0_nop_c)=0.9
.ic v(sn_0_2__t1_nop_c)=0.9 v(sn_0_3_nop_c)=0 v(sn_0_3__t0_nop_c)=0 v(sn_0_3__t1_nop_c)=0 v(sn_1_0_nop_c)=0 v(sn_1_0__t0_nop_c)=0
.ic v(sn_1_0__t1_nop_c)=0 v(sn_1_1_nop_c)=0.9 v(sn_1_1__t0_nop_c)=0.9 v(sn_1_1__t1_nop_c)=0.9 v(sn_1_2_nop_c)=0 v(sn_1_2__t0_nop_c)=0
.ic v(sn_1_2__t1_nop_c)=0 v(sn_1_3_nop_c)=0.9 v(sn_1_3__t0_nop_c)=0.9 v(sn_1_3__t1_nop_c)=0.9 v(sn_2_0_nop_c)=0.9 v(sn_2_0__t0_nop_c)=0.9
.ic v(sn_2_0__t1_nop_c)=0.9 v(sn_2_1_nop_c)=0 v(sn_2_1__t0_nop_c)=0 v(sn_2_1__t1_nop_c)=0 v(sn_2_2_nop_c)=0.9 v(sn_2_2__t0_nop_c)=0.9
.ic v(sn_2_2__t1_nop_c)=0.9 v(sn_2_3_nop_c)=0 v(sn_2_3__t0_nop_c)=0 v(sn_2_3__t1_nop_c)=0 v(sn_3_0_nop_c)=0 v(sn_3_0__t0_nop_c)=0
.ic v(sn_3_0__t1_nop_c)=0 v(sn_3_1_nop_c)=0.9 v(sn_3_1__t0_nop_c)=0.9 v(sn_3_1__t1_nop_c)=0.9 v(sn_3_2_nop_c)=0 v(sn_3_2__t0_nop_c)=0
.ic v(sn_3_2__t1_nop_c)=0 v(sn_3_3_nop_c)=0.9 v(sn_3_3__t0_nop_c)=0.9 v(sn_3_3__t1_nop_c)=0.9 v(wl_0_nop_c)=0 v(wl_0__t0_nop_c)=0
.ic v(wl_0__t1_nop_c)=0 v(wl_0__t2_nop_c)=0 v(wl_0__t3_nop_c)=0 v(wl_1_nop_c)=0 v(wl_1__t0_nop_c)=0 v(wl_1__t1_nop_c)=0
.ic v(wl_1__t2_nop_c)=0 v(wl_1__t3_nop_c)=0 v(wl_2_nop_c)=0 v(wl_2__t0_nop_c)=0 v(wl_2__t1_nop_c)=0 v(wl_2__t2_nop_c)=0
.ic v(wl_2__t3_nop_c)=0 v(wl_3_nop_c)=0 v(wl_3__t0_nop_c)=0 v(wl_3__t1_nop_c)=0 v(wl_3__t2_nop_c)=0 v(wl_3__t3_nop_c)=0
.ic v(bl_0_refw)=1.8 v(bl_0__t0_refw)=1.8 v(bl_0__t1_refw)=1.8 v(bl_0__t2_refw)=1.8 v(bl_0__t3_refw)=1.8 v(bl_1_refw)=1.8
.ic v(bl_1__t0_refw)=1.8 v(bl_1__t1_refw)=1.8 v(bl_1__t2_refw)=1.8 v(bl_1__t3_refw)=1.8 v(bl_2_refw)=1.8 v(bl_2__t0_refw)=1.8
.ic v(bl_2__t1_refw)=1.8 v(bl_2__t2_refw)=1.8 v(bl_2__t3_refw)=1.8 v(bl_3_refw)=1.8 v(bl_3__t0_refw)=1.8 v(bl_3__t1_refw)=1.8
.ic v(bl_3__t2_refw)=1.8 v(bl_3__t3_refw)=1.8 v(rbl_0_refw)=0.9 v(rbl_0__t0_refw)=0.9 v(rbl_0__t1_refw)=0.9 v(rbl_0__t2_refw)=0.9
.ic v(rbl_0__t3_refw)=0.9 v(rbl_1_refw)=0.9 v(rbl_1__t0_refw)=0.9 v(rbl_1__t1_refw)=0.9 v(rbl_1__t2_refw)=0.9 v(rbl_1__t3_refw)=0.9
.ic v(rbl_2_refw)=0.9 v(rbl_2__t0_refw)=0.9 v(rbl_2__t1_refw)=0.9 v(rbl_2__t2_refw)=0.9 v(rbl_2__t3_refw)=0.9 v(rbl_3_refw)=0.9
.ic v(rbl_3__t0_refw)=0.9 v(rbl_3__t1_refw)=0.9 v(rbl_3__t2_refw)=0.9 v(rbl_3__t3_refw)=0.9 v(rwl_0_refw)=1.8 v(rwl_0__t0_refw)=1.8
.ic v(rwl_0__t1_refw)=1.8 v(rwl_0__t2_refw)=1.8 v(rwl_0__t3_refw)=1.8 v(rwl_1_refw)=1.8 v(rwl_1__t0_refw)=1.8 v(rwl_1__t1_refw)=1.8
.ic v(rwl_1__t2_refw)=1.8 v(rwl_1__t3_refw)=1.8 v(rwl_2_refw)=1.8 v(rwl_2__t0_refw)=1.8 v(rwl_2__t1_refw)=1.8 v(rwl_2__t2_refw)=1.8
.ic v(rwl_2__t3_refw)=1.8 v(rwl_3_refw)=1.8 v(rwl_3__t0_refw)=1.8 v(rwl_3__t1_refw)=1.8 v(rwl_3__t2_refw)=1.8 v(rwl_3__t3_refw)=1.8
.ic v(sn_0_0_refw)=0 v(sn_0_0__t0_refw)=0 v(sn_0_0__t1_refw)=0 v(sn_0_1_refw)=0 v(sn_0_1__t0_refw)=0 v(sn_0_1__t1_refw)=0
.ic v(sn_0_2_refw)=0 v(sn_0_2__t0_refw)=0 v(sn_0_2__t1_refw)=0 v(sn_0_3_refw)=0 v(sn_0_3__t0_refw)=0 v(sn_0_3__t1_refw)=0
.ic v(sn_1_0_refw)=0 v(sn_1_0__t0_refw)=0 v(sn_1_0__t1_refw)=0 v(sn_1_1_refw)=0 v(sn_1_1__t0_refw)=0 v(sn_1_1__t1_refw)=0
.ic v(sn_1_2_refw)=0 v(sn_1_2__t0_refw)=0 v(sn_1_2__t1_refw)=0 v(sn_1_3_refw)=0 v(sn_1_3__t0_refw)=0 v(sn_1_3__t1_refw)=0
.ic v(sn_2_0_refw)=0 v(sn_2_0__t0_refw)=0 v(sn_2_0__t1_refw)=0 v(sn_2_1_refw)=0 v(sn_2_1__t0_refw)=0 v(sn_2_1__t1_refw)=0
.ic v(sn_2_2_refw)=0 v(sn_2_2__t0_refw)=0 v(sn_2_2__t1_refw)=0 v(sn_2_3_refw)=0 v(sn_2_3__t0_refw)=0 v(sn_2_3__t1_refw)=0
.ic v(sn_3_0_refw)=0 v(sn_3_0__t0_refw)=0 v(sn_3_0__t1_refw)=0 v(sn_3_1_refw)=0 v(sn_3_1__t0_refw)=0 v(sn_3_1__t1_refw)=0
.ic v(sn_3_2_refw)=0 v(sn_3_2__t0_refw)=0 v(sn_3_2__t1_refw)=0 v(sn_3_3_refw)=0 v(sn_3_3__t0_refw)=0 v(sn_3_3__t1_refw)=0
.ic v(wl_0_refw)=0 v(wl_0__t0_refw)=0 v(wl_0__t1_refw)=0 v(wl_0__t2_refw)=0 v(wl_0__t3_refw)=0 v(wl_1_refw)=0
.ic v(wl_1__t0_refw)=0 v(wl_1__t1_refw)=0 v(wl_1__t2_refw)=0 v(wl_1__t3_refw)=0 v(wl_2_refw)=0 v(wl_2__t0_refw)=0
.ic v(wl_2__t1_refw)=0 v(wl_2__t2_refw)=0 v(wl_2__t3_refw)=0 v(wl_3_refw)=0 v(wl_3__t0_refw)=0 v(wl_3__t1_refw)=0
.ic v(wl_3__t2_refw)=0 v(wl_3__t3_refw)=0
