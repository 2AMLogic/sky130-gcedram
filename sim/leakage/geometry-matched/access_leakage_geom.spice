* access_leakage_geom.spice -- geometry-matched access-device off-state leakage (issue #149).
* GENERATED by gen_geometry_leakage.py from layout/gain_cell_2t_array.extract.parasitics.json; do not edit.
*
* CIRCUIT BODY for `klt sim`: no .control/.end; the PDK .lib/.temp cards are appended per corner by klt.
* Bias is identical to sim/leakage/tb_access_leakage.spice.tmpl: drain (storage node) = VDD,
* gate = source = body = 0 V; observable abs(i(vsn_*)) (via a B source). Two independent DUTs per corner:
*   xext : extracted drawn diffusion (ad/as/pd/ps from the extraction, um / um^2 via .option scale=1u)
*   xleg : same-batch CONTROL with the legacy testbench card (no ad/as/pd/ps -> wrapper default 0)
.param VDD = 1.8
vsn_ext sn_ext 0 dc {VDD}
xext sn_ext 0 0 0 sky130_fd_pr__nfet_01v8 l=0.15 w=0.42 ad=0.1974 as=0.1974 pd=1.78 ps=1.78
vsn_leg sn_leg 0 dc {VDD}
xleg sn_leg 0 0 0 sky130_fd_pr__nfet_01v8 l=0.15 w=0.42
* |I(vsn_*)| as a node voltage (1 V per A) so a .meas card can read it; the dc sweep only
* steps vsn_ext (1.8 -> 1.9 V); both observations are taken AT=1.8 V, the specified bias.
biabs_ext iabs_ext 0 v=abs(i(vsn_ext))
biabs_leg iabs_leg 0 v=abs(i(vsn_leg))
