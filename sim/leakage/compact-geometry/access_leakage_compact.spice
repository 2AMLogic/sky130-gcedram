* access_leakage_compact.spice -- access-device off-state leakage with the extracted diffusion
* geometry of the uniform-grid and compact bitcell layouts (issue #161).
* GENERATED by compact_geometry_leakage.py from the committed klt extract --parasitics reports; do not edit.
*
* CIRCUIT BODY for `klt sim`: no .control/.end; the PDK .lib/.temp cards are appended per corner by klt.
* Bias identical to sim/leakage/tb_access_leakage.spice.tmpl: drain (storage-node side) = VDD, gate = source
* = body = 0 V. The DUT drain carries the STORAGE-NODE-side diffusion (ad/pd), the source the bit-line side
* (as/ps); units um / um^2 via the PDK's .option scale=1u. DUTs (all in one batch, same engine/PDK):
*   xbase: layout/gain_cell_2t_array.extract.parasitics.json  ad=0.1974 pd=1.78 as=0.1974 ps=1.78
*   xv2: layout/compact/gain_cell_2t_v2_array.extract.parasitics.json  ad=0.1197 pd=1.41 as=0.0588 ps=0.7
*   xv1: layout/compact/gain_cell_2t_v1_array.extract.parasitics.json  ad=0.1197 pd=1.41 as=0.1197 ps=1.41
*   xleg : legacy testbench card (l=0.15 w=0.42, no diffusion parameters) -- same-batch CONTROL
.param VDD = 1.8
vsn_base sn_base 0 dc {VDD}
xbase sn_base 0 0 0 sky130_fd_pr__nfet_01v8 l=0.15 w=0.42 ad=0.1974 as=0.1974 pd=1.78 ps=1.78
vsn_v2 sn_v2 0 dc {VDD}
xv2 sn_v2 0 0 0 sky130_fd_pr__nfet_01v8 l=0.15 w=0.42 ad=0.1197 as=0.0588 pd=1.41 ps=0.7
vsn_v1 sn_v1 0 dc {VDD}
xv1 sn_v1 0 0 0 sky130_fd_pr__nfet_01v8 l=0.15 w=0.42 ad=0.1197 as=0.1197 pd=1.41 ps=1.41
vsn_leg sn_leg 0 dc {VDD}
xleg sn_leg 0 0 0 sky130_fd_pr__nfet_01v8 l=0.15 w=0.42
* |I(vsn_*)| as a node voltage (1 V per A) so a .meas card can read it; the dc sweep steps vsn_base only
* (1.8 -> 1.9 V); every observation is taken AT=1.8 V, the specified bias.
biabs_base iabs_base 0 v=abs(i(vsn_base))
biabs_v2 iabs_v2 0 v=abs(i(vsn_v2))
biabs_v1 iabs_v1 0 v=abs(i(vsn_v1))
biabs_leg iabs_leg 0 v=abs(i(vsn_leg))
