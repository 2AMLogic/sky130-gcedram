* sense_mismatch_control.spice -- NEGATIVE CONTROL of the stage-only latch offset
* GENERATED by sim/sense-mismatch/gen_sense_mismatch.py (issue #81); do not edit by hand.
*
* PROPOSED/UNRATIFIED SCOPE: corners/temperatures from spec/operating-range-decision-PROPOSED.md.
* CIRCUIT BODY for `klt sim`: no .control/.end; klt appends the .lib (a *_mm mismatch section,
* MC_MM_SWITCH=1), .temp and the per-sample `.options seed` cards.
* Latch/footer/header devices, sizes, timing and bias are those of sim/sense-stage/gen_sense_stage.py.
* Every sky130 FET instance gets its own AGAUSS Vth-mismatch draw (the PDK switch is global per
* section: footer/header/cell devices also carry mismatch, see README).
* Instance kinds: s<p|m|z><mV>_<r>: rbl precharged to VREF+d, no cells, replica r
*
* ASSUMPTIONS (labelled; none is a spec value): C_RBL, VRBL, reference level, sense instant,
* latch/footer/header sizes, ideal precharge switch, ideal drivers, ideal matched dummy load.

.param VDD     = 1.8
.param VRBL    = 0.9   $ ASSUMPTION (contract)
.param TEDGE   = 1e-10
.param T_READ  = 1e-08   $ select edge
.param T_PGAP  = 2e-09   $ precharge released this long before T_READ
.param T_EN    = 2e-08   $ ASSUMPTION: latch enable = contract sense instant (T_READ+10n)
.param C_RBL   = 1e-14   $ ASSUMPTION (contract; not extracted)

* ---- shared drivers (ideal) ----
vdd   vdd 0 dc {VDD}
vctl  ctl 0 pwl(0 {VDD} {T_READ-T_PGAP} {VDD} {T_READ-T_PGAP+TEDGE} 0)
ven   en  0 pwl(0 0 {T_EN} 0 {T_EN+TEDGE} {VDD})
venb  enb 0 pwl(0 {VDD} {T_EN} {VDD} {T_EN+TEDGE} 0)
.model swpre sw(vt=0.9 vh=0.1 ron=100 roff=1e12)
* SEEDED DEFECT (issue #384 negative control): shared reference forced +0.13 V
* (input-referred offset on every instance; d_eff = d - 0.13). Deterministic:
* same corners, n and seed as request_row2e.json (common random numbers).

vref_100 pref_100 0 dc 0.93   $ reference = VRBL - 0.1 (ASSUMPTION) + seeded defect 0.13 V
vpa_z000 pa_z000 0 dc 0.800000
vpa_p002 pa_p002 0 dc 0.802000
vpa_m002 pa_m002 0 dc 0.798000
vpa_p005 pa_p005 0 dc 0.805000
vpa_m005 pa_m005 0 dc 0.795000
vpa_p010 pa_p010 0 dc 0.810000
vpa_m010 pa_m010 0 dc 0.790000
vpa_p015 pa_p015 0 dc 0.815000
vpa_m015 pa_m015 0 dc 0.785000
vpa_p020 pa_p020 0 dc 0.820000
vpa_m020 pa_m020 0 dc 0.780000
vpa_p030 pa_p030 0 dc 0.830000
vpa_m030 pa_m030 0 dc 0.770000
vpa_p040 pa_p040 0 dc 0.840000
vpa_m040 pa_m040 0 dc 0.760000
vpa_p050 pa_p050 0 dc 0.850000
vpa_m050 pa_m050 0 dc 0.750000
vpa_p060 pa_p060 0 dc 0.860000
vpa_m060 pa_m060 0 dc 0.740000
vpa_p080 pa_p080 0 dc 0.880000
vpa_m080 pa_m080 0 dc 0.720000
vpa_p100 pa_p100 0 dc 0.900000
vpa_m100 pa_m100 0 dc 0.700000
vpa_p150 pa_p150 0 dc 0.950000
vpa_m150 pa_m150 0 dc 0.650000

* ---- sz000_0: d = 0 mV, replica 0 ----
spa_sz000_0 pa_z000 rbl_sz000_0 ctl 0 swpre
crbl_sz000_0 rbl_sz000_0 0 {C_RBL}
spr_sz000_0 pref_100 ref_sz000_0 ctl 0 swpre
cref_sz000_0 ref_sz000_0 0 {C_RBL}   $ ASSUMPTION: ideal matched dummy load
XMN1_sz000_0 rbl_sz000_0 ref_sz000_0 vn_sz000_0 0 sky130_fd_pr__nfet_01v8 L=0.15 W=1 nf=1 ad=0.29 as=0.29 pd=2.58 ps=2.58 nrd=0.29 nrs=0.29 sa=0 sb=0 sd=0 mult=1 m=1
XMN2_sz000_0 ref_sz000_0 rbl_sz000_0 vn_sz000_0 0 sky130_fd_pr__nfet_01v8 L=0.15 W=1 nf=1 ad=0.29 as=0.29 pd=2.58 ps=2.58 nrd=0.29 nrs=0.29 sa=0 sb=0 sd=0 mult=1 m=1
XMP1_sz000_0 rbl_sz000_0 ref_sz000_0 vp_sz000_0 vdd sky130_fd_pr__pfet_01v8 L=0.15 W=2 nf=1 ad=0.58 as=0.58 pd=4.58 ps=4.58 nrd=0.145 nrs=0.145 sa=0 sb=0 sd=0 mult=1 m=1
XMP2_sz000_0 ref_sz000_0 rbl_sz000_0 vp_sz000_0 vdd sky130_fd_pr__pfet_01v8 L=0.15 W=2 nf=1 ad=0.58 as=0.58 pd=4.58 ps=4.58 nrd=0.145 nrs=0.145 sa=0 sb=0 sd=0 mult=1 m=1
XMNF_sz000_0 vn_sz000_0 en 0 0 sky130_fd_pr__nfet_01v8 L=0.15 W=2 nf=1 ad=0.58 as=0.58 pd=4.58 ps=4.58 nrd=0.145 nrs=0.145 sa=0 sb=0 sd=0 mult=1 m=1
XMPH_sz000_0 vp_sz000_0 enb vdd vdd sky130_fd_pr__pfet_01v8 L=0.15 W=4 nf=1 ad=1.16 as=1.16 pd=8.58 ps=8.58 nrd=0.0725 nrs=0.0725 sa=0 sb=0 sd=0 mult=1 m=1
bd_sz000_0 d_sz000_0 0 v=v(rbl_sz000_0)-v(ref_sz000_0)
bdabs_sz000_0 dabs_sz000_0 0 v=abs(v(rbl_sz000_0)-v(ref_sz000_0))

* ---- sz000_1: d = 0 mV, replica 1 ----
spa_sz000_1 pa_z000 rbl_sz000_1 ctl 0 swpre
crbl_sz000_1 rbl_sz000_1 0 {C_RBL}
spr_sz000_1 pref_100 ref_sz000_1 ctl 0 swpre
cref_sz000_1 ref_sz000_1 0 {C_RBL}   $ ASSUMPTION: ideal matched dummy load
XMN1_sz000_1 rbl_sz000_1 ref_sz000_1 vn_sz000_1 0 sky130_fd_pr__nfet_01v8 L=0.15 W=1 nf=1 ad=0.29 as=0.29 pd=2.58 ps=2.58 nrd=0.29 nrs=0.29 sa=0 sb=0 sd=0 mult=1 m=1
XMN2_sz000_1 ref_sz000_1 rbl_sz000_1 vn_sz000_1 0 sky130_fd_pr__nfet_01v8 L=0.15 W=1 nf=1 ad=0.29 as=0.29 pd=2.58 ps=2.58 nrd=0.29 nrs=0.29 sa=0 sb=0 sd=0 mult=1 m=1
XMP1_sz000_1 rbl_sz000_1 ref_sz000_1 vp_sz000_1 vdd sky130_fd_pr__pfet_01v8 L=0.15 W=2 nf=1 ad=0.58 as=0.58 pd=4.58 ps=4.58 nrd=0.145 nrs=0.145 sa=0 sb=0 sd=0 mult=1 m=1
XMP2_sz000_1 ref_sz000_1 rbl_sz000_1 vp_sz000_1 vdd sky130_fd_pr__pfet_01v8 L=0.15 W=2 nf=1 ad=0.58 as=0.58 pd=4.58 ps=4.58 nrd=0.145 nrs=0.145 sa=0 sb=0 sd=0 mult=1 m=1
XMNF_sz000_1 vn_sz000_1 en 0 0 sky130_fd_pr__nfet_01v8 L=0.15 W=2 nf=1 ad=0.58 as=0.58 pd=4.58 ps=4.58 nrd=0.145 nrs=0.145 sa=0 sb=0 sd=0 mult=1 m=1
XMPH_sz000_1 vp_sz000_1 enb vdd vdd sky130_fd_pr__pfet_01v8 L=0.15 W=4 nf=1 ad=1.16 as=1.16 pd=8.58 ps=8.58 nrd=0.0725 nrs=0.0725 sa=0 sb=0 sd=0 mult=1 m=1
bd_sz000_1 d_sz000_1 0 v=v(rbl_sz000_1)-v(ref_sz000_1)
bdabs_sz000_1 dabs_sz000_1 0 v=abs(v(rbl_sz000_1)-v(ref_sz000_1))

* ---- sz000_2: d = 0 mV, replica 2 ----
spa_sz000_2 pa_z000 rbl_sz000_2 ctl 0 swpre
crbl_sz000_2 rbl_sz000_2 0 {C_RBL}
spr_sz000_2 pref_100 ref_sz000_2 ctl 0 swpre
cref_sz000_2 ref_sz000_2 0 {C_RBL}   $ ASSUMPTION: ideal matched dummy load
XMN1_sz000_2 rbl_sz000_2 ref_sz000_2 vn_sz000_2 0 sky130_fd_pr__nfet_01v8 L=0.15 W=1 nf=1 ad=0.29 as=0.29 pd=2.58 ps=2.58 nrd=0.29 nrs=0.29 sa=0 sb=0 sd=0 mult=1 m=1
XMN2_sz000_2 ref_sz000_2 rbl_sz000_2 vn_sz000_2 0 sky130_fd_pr__nfet_01v8 L=0.15 W=1 nf=1 ad=0.29 as=0.29 pd=2.58 ps=2.58 nrd=0.29 nrs=0.29 sa=0 sb=0 sd=0 mult=1 m=1
XMP1_sz000_2 rbl_sz000_2 ref_sz000_2 vp_sz000_2 vdd sky130_fd_pr__pfet_01v8 L=0.15 W=2 nf=1 ad=0.58 as=0.58 pd=4.58 ps=4.58 nrd=0.145 nrs=0.145 sa=0 sb=0 sd=0 mult=1 m=1
XMP2_sz000_2 ref_sz000_2 rbl_sz000_2 vp_sz000_2 vdd sky130_fd_pr__pfet_01v8 L=0.15 W=2 nf=1 ad=0.58 as=0.58 pd=4.58 ps=4.58 nrd=0.145 nrs=0.145 sa=0 sb=0 sd=0 mult=1 m=1
XMNF_sz000_2 vn_sz000_2 en 0 0 sky130_fd_pr__nfet_01v8 L=0.15 W=2 nf=1 ad=0.58 as=0.58 pd=4.58 ps=4.58 nrd=0.145 nrs=0.145 sa=0 sb=0 sd=0 mult=1 m=1
XMPH_sz000_2 vp_sz000_2 enb vdd vdd sky130_fd_pr__pfet_01v8 L=0.15 W=4 nf=1 ad=1.16 as=1.16 pd=8.58 ps=8.58 nrd=0.0725 nrs=0.0725 sa=0 sb=0 sd=0 mult=1 m=1
bd_sz000_2 d_sz000_2 0 v=v(rbl_sz000_2)-v(ref_sz000_2)
bdabs_sz000_2 dabs_sz000_2 0 v=abs(v(rbl_sz000_2)-v(ref_sz000_2))

* ---- sz000_3: d = 0 mV, replica 3 ----
spa_sz000_3 pa_z000 rbl_sz000_3 ctl 0 swpre
crbl_sz000_3 rbl_sz000_3 0 {C_RBL}
spr_sz000_3 pref_100 ref_sz000_3 ctl 0 swpre
cref_sz000_3 ref_sz000_3 0 {C_RBL}   $ ASSUMPTION: ideal matched dummy load
XMN1_sz000_3 rbl_sz000_3 ref_sz000_3 vn_sz000_3 0 sky130_fd_pr__nfet_01v8 L=0.15 W=1 nf=1 ad=0.29 as=0.29 pd=2.58 ps=2.58 nrd=0.29 nrs=0.29 sa=0 sb=0 sd=0 mult=1 m=1
XMN2_sz000_3 ref_sz000_3 rbl_sz000_3 vn_sz000_3 0 sky130_fd_pr__nfet_01v8 L=0.15 W=1 nf=1 ad=0.29 as=0.29 pd=2.58 ps=2.58 nrd=0.29 nrs=0.29 sa=0 sb=0 sd=0 mult=1 m=1
XMP1_sz000_3 rbl_sz000_3 ref_sz000_3 vp_sz000_3 vdd sky130_fd_pr__pfet_01v8 L=0.15 W=2 nf=1 ad=0.58 as=0.58 pd=4.58 ps=4.58 nrd=0.145 nrs=0.145 sa=0 sb=0 sd=0 mult=1 m=1
XMP2_sz000_3 ref_sz000_3 rbl_sz000_3 vp_sz000_3 vdd sky130_fd_pr__pfet_01v8 L=0.15 W=2 nf=1 ad=0.58 as=0.58 pd=4.58 ps=4.58 nrd=0.145 nrs=0.145 sa=0 sb=0 sd=0 mult=1 m=1
XMNF_sz000_3 vn_sz000_3 en 0 0 sky130_fd_pr__nfet_01v8 L=0.15 W=2 nf=1 ad=0.58 as=0.58 pd=4.58 ps=4.58 nrd=0.145 nrs=0.145 sa=0 sb=0 sd=0 mult=1 m=1
XMPH_sz000_3 vp_sz000_3 enb vdd vdd sky130_fd_pr__pfet_01v8 L=0.15 W=4 nf=1 ad=1.16 as=1.16 pd=8.58 ps=8.58 nrd=0.0725 nrs=0.0725 sa=0 sb=0 sd=0 mult=1 m=1
bd_sz000_3 d_sz000_3 0 v=v(rbl_sz000_3)-v(ref_sz000_3)
bdabs_sz000_3 dabs_sz000_3 0 v=abs(v(rbl_sz000_3)-v(ref_sz000_3))

* ---- sz000_4: d = 0 mV, replica 4 ----
spa_sz000_4 pa_z000 rbl_sz000_4 ctl 0 swpre
crbl_sz000_4 rbl_sz000_4 0 {C_RBL}
spr_sz000_4 pref_100 ref_sz000_4 ctl 0 swpre
cref_sz000_4 ref_sz000_4 0 {C_RBL}   $ ASSUMPTION: ideal matched dummy load
XMN1_sz000_4 rbl_sz000_4 ref_sz000_4 vn_sz000_4 0 sky130_fd_pr__nfet_01v8 L=0.15 W=1 nf=1 ad=0.29 as=0.29 pd=2.58 ps=2.58 nrd=0.29 nrs=0.29 sa=0 sb=0 sd=0 mult=1 m=1
XMN2_sz000_4 ref_sz000_4 rbl_sz000_4 vn_sz000_4 0 sky130_fd_pr__nfet_01v8 L=0.15 W=1 nf=1 ad=0.29 as=0.29 pd=2.58 ps=2.58 nrd=0.29 nrs=0.29 sa=0 sb=0 sd=0 mult=1 m=1
XMP1_sz000_4 rbl_sz000_4 ref_sz000_4 vp_sz000_4 vdd sky130_fd_pr__pfet_01v8 L=0.15 W=2 nf=1 ad=0.58 as=0.58 pd=4.58 ps=4.58 nrd=0.145 nrs=0.145 sa=0 sb=0 sd=0 mult=1 m=1
XMP2_sz000_4 ref_sz000_4 rbl_sz000_4 vp_sz000_4 vdd sky130_fd_pr__pfet_01v8 L=0.15 W=2 nf=1 ad=0.58 as=0.58 pd=4.58 ps=4.58 nrd=0.145 nrs=0.145 sa=0 sb=0 sd=0 mult=1 m=1
XMNF_sz000_4 vn_sz000_4 en 0 0 sky130_fd_pr__nfet_01v8 L=0.15 W=2 nf=1 ad=0.58 as=0.58 pd=4.58 ps=4.58 nrd=0.145 nrs=0.145 sa=0 sb=0 sd=0 mult=1 m=1
XMPH_sz000_4 vp_sz000_4 enb vdd vdd sky130_fd_pr__pfet_01v8 L=0.15 W=4 nf=1 ad=1.16 as=1.16 pd=8.58 ps=8.58 nrd=0.0725 nrs=0.0725 sa=0 sb=0 sd=0 mult=1 m=1
bd_sz000_4 d_sz000_4 0 v=v(rbl_sz000_4)-v(ref_sz000_4)
bdabs_sz000_4 dabs_sz000_4 0 v=abs(v(rbl_sz000_4)-v(ref_sz000_4))

* ---- sz000_5: d = 0 mV, replica 5 ----
spa_sz000_5 pa_z000 rbl_sz000_5 ctl 0 swpre
crbl_sz000_5 rbl_sz000_5 0 {C_RBL}
spr_sz000_5 pref_100 ref_sz000_5 ctl 0 swpre
cref_sz000_5 ref_sz000_5 0 {C_RBL}   $ ASSUMPTION: ideal matched dummy load
XMN1_sz000_5 rbl_sz000_5 ref_sz000_5 vn_sz000_5 0 sky130_fd_pr__nfet_01v8 L=0.15 W=1 nf=1 ad=0.29 as=0.29 pd=2.58 ps=2.58 nrd=0.29 nrs=0.29 sa=0 sb=0 sd=0 mult=1 m=1
XMN2_sz000_5 ref_sz000_5 rbl_sz000_5 vn_sz000_5 0 sky130_fd_pr__nfet_01v8 L=0.15 W=1 nf=1 ad=0.29 as=0.29 pd=2.58 ps=2.58 nrd=0.29 nrs=0.29 sa=0 sb=0 sd=0 mult=1 m=1
XMP1_sz000_5 rbl_sz000_5 ref_sz000_5 vp_sz000_5 vdd sky130_fd_pr__pfet_01v8 L=0.15 W=2 nf=1 ad=0.58 as=0.58 pd=4.58 ps=4.58 nrd=0.145 nrs=0.145 sa=0 sb=0 sd=0 mult=1 m=1
XMP2_sz000_5 ref_sz000_5 rbl_sz000_5 vp_sz000_5 vdd sky130_fd_pr__pfet_01v8 L=0.15 W=2 nf=1 ad=0.58 as=0.58 pd=4.58 ps=4.58 nrd=0.145 nrs=0.145 sa=0 sb=0 sd=0 mult=1 m=1
XMNF_sz000_5 vn_sz000_5 en 0 0 sky130_fd_pr__nfet_01v8 L=0.15 W=2 nf=1 ad=0.58 as=0.58 pd=4.58 ps=4.58 nrd=0.145 nrs=0.145 sa=0 sb=0 sd=0 mult=1 m=1
XMPH_sz000_5 vp_sz000_5 enb vdd vdd sky130_fd_pr__pfet_01v8 L=0.15 W=4 nf=1 ad=1.16 as=1.16 pd=8.58 ps=8.58 nrd=0.0725 nrs=0.0725 sa=0 sb=0 sd=0 mult=1 m=1
bd_sz000_5 d_sz000_5 0 v=v(rbl_sz000_5)-v(ref_sz000_5)
bdabs_sz000_5 dabs_sz000_5 0 v=abs(v(rbl_sz000_5)-v(ref_sz000_5))

* ---- sp002_0: d = 2 mV, replica 0 ----
spa_sp002_0 pa_p002 rbl_sp002_0 ctl 0 swpre
crbl_sp002_0 rbl_sp002_0 0 {C_RBL}
spr_sp002_0 pref_100 ref_sp002_0 ctl 0 swpre
cref_sp002_0 ref_sp002_0 0 {C_RBL}   $ ASSUMPTION: ideal matched dummy load
XMN1_sp002_0 rbl_sp002_0 ref_sp002_0 vn_sp002_0 0 sky130_fd_pr__nfet_01v8 L=0.15 W=1 nf=1 ad=0.29 as=0.29 pd=2.58 ps=2.58 nrd=0.29 nrs=0.29 sa=0 sb=0 sd=0 mult=1 m=1
XMN2_sp002_0 ref_sp002_0 rbl_sp002_0 vn_sp002_0 0 sky130_fd_pr__nfet_01v8 L=0.15 W=1 nf=1 ad=0.29 as=0.29 pd=2.58 ps=2.58 nrd=0.29 nrs=0.29 sa=0 sb=0 sd=0 mult=1 m=1
XMP1_sp002_0 rbl_sp002_0 ref_sp002_0 vp_sp002_0 vdd sky130_fd_pr__pfet_01v8 L=0.15 W=2 nf=1 ad=0.58 as=0.58 pd=4.58 ps=4.58 nrd=0.145 nrs=0.145 sa=0 sb=0 sd=0 mult=1 m=1
XMP2_sp002_0 ref_sp002_0 rbl_sp002_0 vp_sp002_0 vdd sky130_fd_pr__pfet_01v8 L=0.15 W=2 nf=1 ad=0.58 as=0.58 pd=4.58 ps=4.58 nrd=0.145 nrs=0.145 sa=0 sb=0 sd=0 mult=1 m=1
XMNF_sp002_0 vn_sp002_0 en 0 0 sky130_fd_pr__nfet_01v8 L=0.15 W=2 nf=1 ad=0.58 as=0.58 pd=4.58 ps=4.58 nrd=0.145 nrs=0.145 sa=0 sb=0 sd=0 mult=1 m=1
XMPH_sp002_0 vp_sp002_0 enb vdd vdd sky130_fd_pr__pfet_01v8 L=0.15 W=4 nf=1 ad=1.16 as=1.16 pd=8.58 ps=8.58 nrd=0.0725 nrs=0.0725 sa=0 sb=0 sd=0 mult=1 m=1
bd_sp002_0 d_sp002_0 0 v=v(rbl_sp002_0)-v(ref_sp002_0)
bdabs_sp002_0 dabs_sp002_0 0 v=abs(v(rbl_sp002_0)-v(ref_sp002_0))

* ---- sp002_1: d = 2 mV, replica 1 ----
spa_sp002_1 pa_p002 rbl_sp002_1 ctl 0 swpre
crbl_sp002_1 rbl_sp002_1 0 {C_RBL}
spr_sp002_1 pref_100 ref_sp002_1 ctl 0 swpre
cref_sp002_1 ref_sp002_1 0 {C_RBL}   $ ASSUMPTION: ideal matched dummy load
XMN1_sp002_1 rbl_sp002_1 ref_sp002_1 vn_sp002_1 0 sky130_fd_pr__nfet_01v8 L=0.15 W=1 nf=1 ad=0.29 as=0.29 pd=2.58 ps=2.58 nrd=0.29 nrs=0.29 sa=0 sb=0 sd=0 mult=1 m=1
XMN2_sp002_1 ref_sp002_1 rbl_sp002_1 vn_sp002_1 0 sky130_fd_pr__nfet_01v8 L=0.15 W=1 nf=1 ad=0.29 as=0.29 pd=2.58 ps=2.58 nrd=0.29 nrs=0.29 sa=0 sb=0 sd=0 mult=1 m=1
XMP1_sp002_1 rbl_sp002_1 ref_sp002_1 vp_sp002_1 vdd sky130_fd_pr__pfet_01v8 L=0.15 W=2 nf=1 ad=0.58 as=0.58 pd=4.58 ps=4.58 nrd=0.145 nrs=0.145 sa=0 sb=0 sd=0 mult=1 m=1
XMP2_sp002_1 ref_sp002_1 rbl_sp002_1 vp_sp002_1 vdd sky130_fd_pr__pfet_01v8 L=0.15 W=2 nf=1 ad=0.58 as=0.58 pd=4.58 ps=4.58 nrd=0.145 nrs=0.145 sa=0 sb=0 sd=0 mult=1 m=1
XMNF_sp002_1 vn_sp002_1 en 0 0 sky130_fd_pr__nfet_01v8 L=0.15 W=2 nf=1 ad=0.58 as=0.58 pd=4.58 ps=4.58 nrd=0.145 nrs=0.145 sa=0 sb=0 sd=0 mult=1 m=1
XMPH_sp002_1 vp_sp002_1 enb vdd vdd sky130_fd_pr__pfet_01v8 L=0.15 W=4 nf=1 ad=1.16 as=1.16 pd=8.58 ps=8.58 nrd=0.0725 nrs=0.0725 sa=0 sb=0 sd=0 mult=1 m=1
bd_sp002_1 d_sp002_1 0 v=v(rbl_sp002_1)-v(ref_sp002_1)
bdabs_sp002_1 dabs_sp002_1 0 v=abs(v(rbl_sp002_1)-v(ref_sp002_1))

* ---- sp002_2: d = 2 mV, replica 2 ----
spa_sp002_2 pa_p002 rbl_sp002_2 ctl 0 swpre
crbl_sp002_2 rbl_sp002_2 0 {C_RBL}
spr_sp002_2 pref_100 ref_sp002_2 ctl 0 swpre
cref_sp002_2 ref_sp002_2 0 {C_RBL}   $ ASSUMPTION: ideal matched dummy load
XMN1_sp002_2 rbl_sp002_2 ref_sp002_2 vn_sp002_2 0 sky130_fd_pr__nfet_01v8 L=0.15 W=1 nf=1 ad=0.29 as=0.29 pd=2.58 ps=2.58 nrd=0.29 nrs=0.29 sa=0 sb=0 sd=0 mult=1 m=1
XMN2_sp002_2 ref_sp002_2 rbl_sp002_2 vn_sp002_2 0 sky130_fd_pr__nfet_01v8 L=0.15 W=1 nf=1 ad=0.29 as=0.29 pd=2.58 ps=2.58 nrd=0.29 nrs=0.29 sa=0 sb=0 sd=0 mult=1 m=1
XMP1_sp002_2 rbl_sp002_2 ref_sp002_2 vp_sp002_2 vdd sky130_fd_pr__pfet_01v8 L=0.15 W=2 nf=1 ad=0.58 as=0.58 pd=4.58 ps=4.58 nrd=0.145 nrs=0.145 sa=0 sb=0 sd=0 mult=1 m=1
XMP2_sp002_2 ref_sp002_2 rbl_sp002_2 vp_sp002_2 vdd sky130_fd_pr__pfet_01v8 L=0.15 W=2 nf=1 ad=0.58 as=0.58 pd=4.58 ps=4.58 nrd=0.145 nrs=0.145 sa=0 sb=0 sd=0 mult=1 m=1
XMNF_sp002_2 vn_sp002_2 en 0 0 sky130_fd_pr__nfet_01v8 L=0.15 W=2 nf=1 ad=0.58 as=0.58 pd=4.58 ps=4.58 nrd=0.145 nrs=0.145 sa=0 sb=0 sd=0 mult=1 m=1
XMPH_sp002_2 vp_sp002_2 enb vdd vdd sky130_fd_pr__pfet_01v8 L=0.15 W=4 nf=1 ad=1.16 as=1.16 pd=8.58 ps=8.58 nrd=0.0725 nrs=0.0725 sa=0 sb=0 sd=0 mult=1 m=1
bd_sp002_2 d_sp002_2 0 v=v(rbl_sp002_2)-v(ref_sp002_2)
bdabs_sp002_2 dabs_sp002_2 0 v=abs(v(rbl_sp002_2)-v(ref_sp002_2))

* ---- sp002_3: d = 2 mV, replica 3 ----
spa_sp002_3 pa_p002 rbl_sp002_3 ctl 0 swpre
crbl_sp002_3 rbl_sp002_3 0 {C_RBL}
spr_sp002_3 pref_100 ref_sp002_3 ctl 0 swpre
cref_sp002_3 ref_sp002_3 0 {C_RBL}   $ ASSUMPTION: ideal matched dummy load
XMN1_sp002_3 rbl_sp002_3 ref_sp002_3 vn_sp002_3 0 sky130_fd_pr__nfet_01v8 L=0.15 W=1 nf=1 ad=0.29 as=0.29 pd=2.58 ps=2.58 nrd=0.29 nrs=0.29 sa=0 sb=0 sd=0 mult=1 m=1
XMN2_sp002_3 ref_sp002_3 rbl_sp002_3 vn_sp002_3 0 sky130_fd_pr__nfet_01v8 L=0.15 W=1 nf=1 ad=0.29 as=0.29 pd=2.58 ps=2.58 nrd=0.29 nrs=0.29 sa=0 sb=0 sd=0 mult=1 m=1
XMP1_sp002_3 rbl_sp002_3 ref_sp002_3 vp_sp002_3 vdd sky130_fd_pr__pfet_01v8 L=0.15 W=2 nf=1 ad=0.58 as=0.58 pd=4.58 ps=4.58 nrd=0.145 nrs=0.145 sa=0 sb=0 sd=0 mult=1 m=1
XMP2_sp002_3 ref_sp002_3 rbl_sp002_3 vp_sp002_3 vdd sky130_fd_pr__pfet_01v8 L=0.15 W=2 nf=1 ad=0.58 as=0.58 pd=4.58 ps=4.58 nrd=0.145 nrs=0.145 sa=0 sb=0 sd=0 mult=1 m=1
XMNF_sp002_3 vn_sp002_3 en 0 0 sky130_fd_pr__nfet_01v8 L=0.15 W=2 nf=1 ad=0.58 as=0.58 pd=4.58 ps=4.58 nrd=0.145 nrs=0.145 sa=0 sb=0 sd=0 mult=1 m=1
XMPH_sp002_3 vp_sp002_3 enb vdd vdd sky130_fd_pr__pfet_01v8 L=0.15 W=4 nf=1 ad=1.16 as=1.16 pd=8.58 ps=8.58 nrd=0.0725 nrs=0.0725 sa=0 sb=0 sd=0 mult=1 m=1
bd_sp002_3 d_sp002_3 0 v=v(rbl_sp002_3)-v(ref_sp002_3)
bdabs_sp002_3 dabs_sp002_3 0 v=abs(v(rbl_sp002_3)-v(ref_sp002_3))

* ---- sp002_4: d = 2 mV, replica 4 ----
spa_sp002_4 pa_p002 rbl_sp002_4 ctl 0 swpre
crbl_sp002_4 rbl_sp002_4 0 {C_RBL}
spr_sp002_4 pref_100 ref_sp002_4 ctl 0 swpre
cref_sp002_4 ref_sp002_4 0 {C_RBL}   $ ASSUMPTION: ideal matched dummy load
XMN1_sp002_4 rbl_sp002_4 ref_sp002_4 vn_sp002_4 0 sky130_fd_pr__nfet_01v8 L=0.15 W=1 nf=1 ad=0.29 as=0.29 pd=2.58 ps=2.58 nrd=0.29 nrs=0.29 sa=0 sb=0 sd=0 mult=1 m=1
XMN2_sp002_4 ref_sp002_4 rbl_sp002_4 vn_sp002_4 0 sky130_fd_pr__nfet_01v8 L=0.15 W=1 nf=1 ad=0.29 as=0.29 pd=2.58 ps=2.58 nrd=0.29 nrs=0.29 sa=0 sb=0 sd=0 mult=1 m=1
XMP1_sp002_4 rbl_sp002_4 ref_sp002_4 vp_sp002_4 vdd sky130_fd_pr__pfet_01v8 L=0.15 W=2 nf=1 ad=0.58 as=0.58 pd=4.58 ps=4.58 nrd=0.145 nrs=0.145 sa=0 sb=0 sd=0 mult=1 m=1
XMP2_sp002_4 ref_sp002_4 rbl_sp002_4 vp_sp002_4 vdd sky130_fd_pr__pfet_01v8 L=0.15 W=2 nf=1 ad=0.58 as=0.58 pd=4.58 ps=4.58 nrd=0.145 nrs=0.145 sa=0 sb=0 sd=0 mult=1 m=1
XMNF_sp002_4 vn_sp002_4 en 0 0 sky130_fd_pr__nfet_01v8 L=0.15 W=2 nf=1 ad=0.58 as=0.58 pd=4.58 ps=4.58 nrd=0.145 nrs=0.145 sa=0 sb=0 sd=0 mult=1 m=1
XMPH_sp002_4 vp_sp002_4 enb vdd vdd sky130_fd_pr__pfet_01v8 L=0.15 W=4 nf=1 ad=1.16 as=1.16 pd=8.58 ps=8.58 nrd=0.0725 nrs=0.0725 sa=0 sb=0 sd=0 mult=1 m=1
bd_sp002_4 d_sp002_4 0 v=v(rbl_sp002_4)-v(ref_sp002_4)
bdabs_sp002_4 dabs_sp002_4 0 v=abs(v(rbl_sp002_4)-v(ref_sp002_4))

* ---- sp002_5: d = 2 mV, replica 5 ----
spa_sp002_5 pa_p002 rbl_sp002_5 ctl 0 swpre
crbl_sp002_5 rbl_sp002_5 0 {C_RBL}
spr_sp002_5 pref_100 ref_sp002_5 ctl 0 swpre
cref_sp002_5 ref_sp002_5 0 {C_RBL}   $ ASSUMPTION: ideal matched dummy load
XMN1_sp002_5 rbl_sp002_5 ref_sp002_5 vn_sp002_5 0 sky130_fd_pr__nfet_01v8 L=0.15 W=1 nf=1 ad=0.29 as=0.29 pd=2.58 ps=2.58 nrd=0.29 nrs=0.29 sa=0 sb=0 sd=0 mult=1 m=1
XMN2_sp002_5 ref_sp002_5 rbl_sp002_5 vn_sp002_5 0 sky130_fd_pr__nfet_01v8 L=0.15 W=1 nf=1 ad=0.29 as=0.29 pd=2.58 ps=2.58 nrd=0.29 nrs=0.29 sa=0 sb=0 sd=0 mult=1 m=1
XMP1_sp002_5 rbl_sp002_5 ref_sp002_5 vp_sp002_5 vdd sky130_fd_pr__pfet_01v8 L=0.15 W=2 nf=1 ad=0.58 as=0.58 pd=4.58 ps=4.58 nrd=0.145 nrs=0.145 sa=0 sb=0 sd=0 mult=1 m=1
XMP2_sp002_5 ref_sp002_5 rbl_sp002_5 vp_sp002_5 vdd sky130_fd_pr__pfet_01v8 L=0.15 W=2 nf=1 ad=0.58 as=0.58 pd=4.58 ps=4.58 nrd=0.145 nrs=0.145 sa=0 sb=0 sd=0 mult=1 m=1
XMNF_sp002_5 vn_sp002_5 en 0 0 sky130_fd_pr__nfet_01v8 L=0.15 W=2 nf=1 ad=0.58 as=0.58 pd=4.58 ps=4.58 nrd=0.145 nrs=0.145 sa=0 sb=0 sd=0 mult=1 m=1
XMPH_sp002_5 vp_sp002_5 enb vdd vdd sky130_fd_pr__pfet_01v8 L=0.15 W=4 nf=1 ad=1.16 as=1.16 pd=8.58 ps=8.58 nrd=0.0725 nrs=0.0725 sa=0 sb=0 sd=0 mult=1 m=1
bd_sp002_5 d_sp002_5 0 v=v(rbl_sp002_5)-v(ref_sp002_5)
bdabs_sp002_5 dabs_sp002_5 0 v=abs(v(rbl_sp002_5)-v(ref_sp002_5))

* ---- sm002_0: d = -2 mV, replica 0 ----
spa_sm002_0 pa_m002 rbl_sm002_0 ctl 0 swpre
crbl_sm002_0 rbl_sm002_0 0 {C_RBL}
spr_sm002_0 pref_100 ref_sm002_0 ctl 0 swpre
cref_sm002_0 ref_sm002_0 0 {C_RBL}   $ ASSUMPTION: ideal matched dummy load
XMN1_sm002_0 rbl_sm002_0 ref_sm002_0 vn_sm002_0 0 sky130_fd_pr__nfet_01v8 L=0.15 W=1 nf=1 ad=0.29 as=0.29 pd=2.58 ps=2.58 nrd=0.29 nrs=0.29 sa=0 sb=0 sd=0 mult=1 m=1
XMN2_sm002_0 ref_sm002_0 rbl_sm002_0 vn_sm002_0 0 sky130_fd_pr__nfet_01v8 L=0.15 W=1 nf=1 ad=0.29 as=0.29 pd=2.58 ps=2.58 nrd=0.29 nrs=0.29 sa=0 sb=0 sd=0 mult=1 m=1
XMP1_sm002_0 rbl_sm002_0 ref_sm002_0 vp_sm002_0 vdd sky130_fd_pr__pfet_01v8 L=0.15 W=2 nf=1 ad=0.58 as=0.58 pd=4.58 ps=4.58 nrd=0.145 nrs=0.145 sa=0 sb=0 sd=0 mult=1 m=1
XMP2_sm002_0 ref_sm002_0 rbl_sm002_0 vp_sm002_0 vdd sky130_fd_pr__pfet_01v8 L=0.15 W=2 nf=1 ad=0.58 as=0.58 pd=4.58 ps=4.58 nrd=0.145 nrs=0.145 sa=0 sb=0 sd=0 mult=1 m=1
XMNF_sm002_0 vn_sm002_0 en 0 0 sky130_fd_pr__nfet_01v8 L=0.15 W=2 nf=1 ad=0.58 as=0.58 pd=4.58 ps=4.58 nrd=0.145 nrs=0.145 sa=0 sb=0 sd=0 mult=1 m=1
XMPH_sm002_0 vp_sm002_0 enb vdd vdd sky130_fd_pr__pfet_01v8 L=0.15 W=4 nf=1 ad=1.16 as=1.16 pd=8.58 ps=8.58 nrd=0.0725 nrs=0.0725 sa=0 sb=0 sd=0 mult=1 m=1
bd_sm002_0 d_sm002_0 0 v=v(rbl_sm002_0)-v(ref_sm002_0)
bdabs_sm002_0 dabs_sm002_0 0 v=abs(v(rbl_sm002_0)-v(ref_sm002_0))

* ---- sm002_1: d = -2 mV, replica 1 ----
spa_sm002_1 pa_m002 rbl_sm002_1 ctl 0 swpre
crbl_sm002_1 rbl_sm002_1 0 {C_RBL}
spr_sm002_1 pref_100 ref_sm002_1 ctl 0 swpre
cref_sm002_1 ref_sm002_1 0 {C_RBL}   $ ASSUMPTION: ideal matched dummy load
XMN1_sm002_1 rbl_sm002_1 ref_sm002_1 vn_sm002_1 0 sky130_fd_pr__nfet_01v8 L=0.15 W=1 nf=1 ad=0.29 as=0.29 pd=2.58 ps=2.58 nrd=0.29 nrs=0.29 sa=0 sb=0 sd=0 mult=1 m=1
XMN2_sm002_1 ref_sm002_1 rbl_sm002_1 vn_sm002_1 0 sky130_fd_pr__nfet_01v8 L=0.15 W=1 nf=1 ad=0.29 as=0.29 pd=2.58 ps=2.58 nrd=0.29 nrs=0.29 sa=0 sb=0 sd=0 mult=1 m=1
XMP1_sm002_1 rbl_sm002_1 ref_sm002_1 vp_sm002_1 vdd sky130_fd_pr__pfet_01v8 L=0.15 W=2 nf=1 ad=0.58 as=0.58 pd=4.58 ps=4.58 nrd=0.145 nrs=0.145 sa=0 sb=0 sd=0 mult=1 m=1
XMP2_sm002_1 ref_sm002_1 rbl_sm002_1 vp_sm002_1 vdd sky130_fd_pr__pfet_01v8 L=0.15 W=2 nf=1 ad=0.58 as=0.58 pd=4.58 ps=4.58 nrd=0.145 nrs=0.145 sa=0 sb=0 sd=0 mult=1 m=1
XMNF_sm002_1 vn_sm002_1 en 0 0 sky130_fd_pr__nfet_01v8 L=0.15 W=2 nf=1 ad=0.58 as=0.58 pd=4.58 ps=4.58 nrd=0.145 nrs=0.145 sa=0 sb=0 sd=0 mult=1 m=1
XMPH_sm002_1 vp_sm002_1 enb vdd vdd sky130_fd_pr__pfet_01v8 L=0.15 W=4 nf=1 ad=1.16 as=1.16 pd=8.58 ps=8.58 nrd=0.0725 nrs=0.0725 sa=0 sb=0 sd=0 mult=1 m=1
bd_sm002_1 d_sm002_1 0 v=v(rbl_sm002_1)-v(ref_sm002_1)
bdabs_sm002_1 dabs_sm002_1 0 v=abs(v(rbl_sm002_1)-v(ref_sm002_1))

* ---- sm002_2: d = -2 mV, replica 2 ----
spa_sm002_2 pa_m002 rbl_sm002_2 ctl 0 swpre
crbl_sm002_2 rbl_sm002_2 0 {C_RBL}
spr_sm002_2 pref_100 ref_sm002_2 ctl 0 swpre
cref_sm002_2 ref_sm002_2 0 {C_RBL}   $ ASSUMPTION: ideal matched dummy load
XMN1_sm002_2 rbl_sm002_2 ref_sm002_2 vn_sm002_2 0 sky130_fd_pr__nfet_01v8 L=0.15 W=1 nf=1 ad=0.29 as=0.29 pd=2.58 ps=2.58 nrd=0.29 nrs=0.29 sa=0 sb=0 sd=0 mult=1 m=1
XMN2_sm002_2 ref_sm002_2 rbl_sm002_2 vn_sm002_2 0 sky130_fd_pr__nfet_01v8 L=0.15 W=1 nf=1 ad=0.29 as=0.29 pd=2.58 ps=2.58 nrd=0.29 nrs=0.29 sa=0 sb=0 sd=0 mult=1 m=1
XMP1_sm002_2 rbl_sm002_2 ref_sm002_2 vp_sm002_2 vdd sky130_fd_pr__pfet_01v8 L=0.15 W=2 nf=1 ad=0.58 as=0.58 pd=4.58 ps=4.58 nrd=0.145 nrs=0.145 sa=0 sb=0 sd=0 mult=1 m=1
XMP2_sm002_2 ref_sm002_2 rbl_sm002_2 vp_sm002_2 vdd sky130_fd_pr__pfet_01v8 L=0.15 W=2 nf=1 ad=0.58 as=0.58 pd=4.58 ps=4.58 nrd=0.145 nrs=0.145 sa=0 sb=0 sd=0 mult=1 m=1
XMNF_sm002_2 vn_sm002_2 en 0 0 sky130_fd_pr__nfet_01v8 L=0.15 W=2 nf=1 ad=0.58 as=0.58 pd=4.58 ps=4.58 nrd=0.145 nrs=0.145 sa=0 sb=0 sd=0 mult=1 m=1
XMPH_sm002_2 vp_sm002_2 enb vdd vdd sky130_fd_pr__pfet_01v8 L=0.15 W=4 nf=1 ad=1.16 as=1.16 pd=8.58 ps=8.58 nrd=0.0725 nrs=0.0725 sa=0 sb=0 sd=0 mult=1 m=1
bd_sm002_2 d_sm002_2 0 v=v(rbl_sm002_2)-v(ref_sm002_2)
bdabs_sm002_2 dabs_sm002_2 0 v=abs(v(rbl_sm002_2)-v(ref_sm002_2))

* ---- sm002_3: d = -2 mV, replica 3 ----
spa_sm002_3 pa_m002 rbl_sm002_3 ctl 0 swpre
crbl_sm002_3 rbl_sm002_3 0 {C_RBL}
spr_sm002_3 pref_100 ref_sm002_3 ctl 0 swpre
cref_sm002_3 ref_sm002_3 0 {C_RBL}   $ ASSUMPTION: ideal matched dummy load
XMN1_sm002_3 rbl_sm002_3 ref_sm002_3 vn_sm002_3 0 sky130_fd_pr__nfet_01v8 L=0.15 W=1 nf=1 ad=0.29 as=0.29 pd=2.58 ps=2.58 nrd=0.29 nrs=0.29 sa=0 sb=0 sd=0 mult=1 m=1
XMN2_sm002_3 ref_sm002_3 rbl_sm002_3 vn_sm002_3 0 sky130_fd_pr__nfet_01v8 L=0.15 W=1 nf=1 ad=0.29 as=0.29 pd=2.58 ps=2.58 nrd=0.29 nrs=0.29 sa=0 sb=0 sd=0 mult=1 m=1
XMP1_sm002_3 rbl_sm002_3 ref_sm002_3 vp_sm002_3 vdd sky130_fd_pr__pfet_01v8 L=0.15 W=2 nf=1 ad=0.58 as=0.58 pd=4.58 ps=4.58 nrd=0.145 nrs=0.145 sa=0 sb=0 sd=0 mult=1 m=1
XMP2_sm002_3 ref_sm002_3 rbl_sm002_3 vp_sm002_3 vdd sky130_fd_pr__pfet_01v8 L=0.15 W=2 nf=1 ad=0.58 as=0.58 pd=4.58 ps=4.58 nrd=0.145 nrs=0.145 sa=0 sb=0 sd=0 mult=1 m=1
XMNF_sm002_3 vn_sm002_3 en 0 0 sky130_fd_pr__nfet_01v8 L=0.15 W=2 nf=1 ad=0.58 as=0.58 pd=4.58 ps=4.58 nrd=0.145 nrs=0.145 sa=0 sb=0 sd=0 mult=1 m=1
XMPH_sm002_3 vp_sm002_3 enb vdd vdd sky130_fd_pr__pfet_01v8 L=0.15 W=4 nf=1 ad=1.16 as=1.16 pd=8.58 ps=8.58 nrd=0.0725 nrs=0.0725 sa=0 sb=0 sd=0 mult=1 m=1
bd_sm002_3 d_sm002_3 0 v=v(rbl_sm002_3)-v(ref_sm002_3)
bdabs_sm002_3 dabs_sm002_3 0 v=abs(v(rbl_sm002_3)-v(ref_sm002_3))

* ---- sm002_4: d = -2 mV, replica 4 ----
spa_sm002_4 pa_m002 rbl_sm002_4 ctl 0 swpre
crbl_sm002_4 rbl_sm002_4 0 {C_RBL}
spr_sm002_4 pref_100 ref_sm002_4 ctl 0 swpre
cref_sm002_4 ref_sm002_4 0 {C_RBL}   $ ASSUMPTION: ideal matched dummy load
XMN1_sm002_4 rbl_sm002_4 ref_sm002_4 vn_sm002_4 0 sky130_fd_pr__nfet_01v8 L=0.15 W=1 nf=1 ad=0.29 as=0.29 pd=2.58 ps=2.58 nrd=0.29 nrs=0.29 sa=0 sb=0 sd=0 mult=1 m=1
XMN2_sm002_4 ref_sm002_4 rbl_sm002_4 vn_sm002_4 0 sky130_fd_pr__nfet_01v8 L=0.15 W=1 nf=1 ad=0.29 as=0.29 pd=2.58 ps=2.58 nrd=0.29 nrs=0.29 sa=0 sb=0 sd=0 mult=1 m=1
XMP1_sm002_4 rbl_sm002_4 ref_sm002_4 vp_sm002_4 vdd sky130_fd_pr__pfet_01v8 L=0.15 W=2 nf=1 ad=0.58 as=0.58 pd=4.58 ps=4.58 nrd=0.145 nrs=0.145 sa=0 sb=0 sd=0 mult=1 m=1
XMP2_sm002_4 ref_sm002_4 rbl_sm002_4 vp_sm002_4 vdd sky130_fd_pr__pfet_01v8 L=0.15 W=2 nf=1 ad=0.58 as=0.58 pd=4.58 ps=4.58 nrd=0.145 nrs=0.145 sa=0 sb=0 sd=0 mult=1 m=1
XMNF_sm002_4 vn_sm002_4 en 0 0 sky130_fd_pr__nfet_01v8 L=0.15 W=2 nf=1 ad=0.58 as=0.58 pd=4.58 ps=4.58 nrd=0.145 nrs=0.145 sa=0 sb=0 sd=0 mult=1 m=1
XMPH_sm002_4 vp_sm002_4 enb vdd vdd sky130_fd_pr__pfet_01v8 L=0.15 W=4 nf=1 ad=1.16 as=1.16 pd=8.58 ps=8.58 nrd=0.0725 nrs=0.0725 sa=0 sb=0 sd=0 mult=1 m=1
bd_sm002_4 d_sm002_4 0 v=v(rbl_sm002_4)-v(ref_sm002_4)
bdabs_sm002_4 dabs_sm002_4 0 v=abs(v(rbl_sm002_4)-v(ref_sm002_4))

* ---- sm002_5: d = -2 mV, replica 5 ----
spa_sm002_5 pa_m002 rbl_sm002_5 ctl 0 swpre
crbl_sm002_5 rbl_sm002_5 0 {C_RBL}
spr_sm002_5 pref_100 ref_sm002_5 ctl 0 swpre
cref_sm002_5 ref_sm002_5 0 {C_RBL}   $ ASSUMPTION: ideal matched dummy load
XMN1_sm002_5 rbl_sm002_5 ref_sm002_5 vn_sm002_5 0 sky130_fd_pr__nfet_01v8 L=0.15 W=1 nf=1 ad=0.29 as=0.29 pd=2.58 ps=2.58 nrd=0.29 nrs=0.29 sa=0 sb=0 sd=0 mult=1 m=1
XMN2_sm002_5 ref_sm002_5 rbl_sm002_5 vn_sm002_5 0 sky130_fd_pr__nfet_01v8 L=0.15 W=1 nf=1 ad=0.29 as=0.29 pd=2.58 ps=2.58 nrd=0.29 nrs=0.29 sa=0 sb=0 sd=0 mult=1 m=1
XMP1_sm002_5 rbl_sm002_5 ref_sm002_5 vp_sm002_5 vdd sky130_fd_pr__pfet_01v8 L=0.15 W=2 nf=1 ad=0.58 as=0.58 pd=4.58 ps=4.58 nrd=0.145 nrs=0.145 sa=0 sb=0 sd=0 mult=1 m=1
XMP2_sm002_5 ref_sm002_5 rbl_sm002_5 vp_sm002_5 vdd sky130_fd_pr__pfet_01v8 L=0.15 W=2 nf=1 ad=0.58 as=0.58 pd=4.58 ps=4.58 nrd=0.145 nrs=0.145 sa=0 sb=0 sd=0 mult=1 m=1
XMNF_sm002_5 vn_sm002_5 en 0 0 sky130_fd_pr__nfet_01v8 L=0.15 W=2 nf=1 ad=0.58 as=0.58 pd=4.58 ps=4.58 nrd=0.145 nrs=0.145 sa=0 sb=0 sd=0 mult=1 m=1
XMPH_sm002_5 vp_sm002_5 enb vdd vdd sky130_fd_pr__pfet_01v8 L=0.15 W=4 nf=1 ad=1.16 as=1.16 pd=8.58 ps=8.58 nrd=0.0725 nrs=0.0725 sa=0 sb=0 sd=0 mult=1 m=1
bd_sm002_5 d_sm002_5 0 v=v(rbl_sm002_5)-v(ref_sm002_5)
bdabs_sm002_5 dabs_sm002_5 0 v=abs(v(rbl_sm002_5)-v(ref_sm002_5))

* ---- sp005_0: d = 5 mV, replica 0 ----
spa_sp005_0 pa_p005 rbl_sp005_0 ctl 0 swpre
crbl_sp005_0 rbl_sp005_0 0 {C_RBL}
spr_sp005_0 pref_100 ref_sp005_0 ctl 0 swpre
cref_sp005_0 ref_sp005_0 0 {C_RBL}   $ ASSUMPTION: ideal matched dummy load
XMN1_sp005_0 rbl_sp005_0 ref_sp005_0 vn_sp005_0 0 sky130_fd_pr__nfet_01v8 L=0.15 W=1 nf=1 ad=0.29 as=0.29 pd=2.58 ps=2.58 nrd=0.29 nrs=0.29 sa=0 sb=0 sd=0 mult=1 m=1
XMN2_sp005_0 ref_sp005_0 rbl_sp005_0 vn_sp005_0 0 sky130_fd_pr__nfet_01v8 L=0.15 W=1 nf=1 ad=0.29 as=0.29 pd=2.58 ps=2.58 nrd=0.29 nrs=0.29 sa=0 sb=0 sd=0 mult=1 m=1
XMP1_sp005_0 rbl_sp005_0 ref_sp005_0 vp_sp005_0 vdd sky130_fd_pr__pfet_01v8 L=0.15 W=2 nf=1 ad=0.58 as=0.58 pd=4.58 ps=4.58 nrd=0.145 nrs=0.145 sa=0 sb=0 sd=0 mult=1 m=1
XMP2_sp005_0 ref_sp005_0 rbl_sp005_0 vp_sp005_0 vdd sky130_fd_pr__pfet_01v8 L=0.15 W=2 nf=1 ad=0.58 as=0.58 pd=4.58 ps=4.58 nrd=0.145 nrs=0.145 sa=0 sb=0 sd=0 mult=1 m=1
XMNF_sp005_0 vn_sp005_0 en 0 0 sky130_fd_pr__nfet_01v8 L=0.15 W=2 nf=1 ad=0.58 as=0.58 pd=4.58 ps=4.58 nrd=0.145 nrs=0.145 sa=0 sb=0 sd=0 mult=1 m=1
XMPH_sp005_0 vp_sp005_0 enb vdd vdd sky130_fd_pr__pfet_01v8 L=0.15 W=4 nf=1 ad=1.16 as=1.16 pd=8.58 ps=8.58 nrd=0.0725 nrs=0.0725 sa=0 sb=0 sd=0 mult=1 m=1
bd_sp005_0 d_sp005_0 0 v=v(rbl_sp005_0)-v(ref_sp005_0)
bdabs_sp005_0 dabs_sp005_0 0 v=abs(v(rbl_sp005_0)-v(ref_sp005_0))

* ---- sp005_1: d = 5 mV, replica 1 ----
spa_sp005_1 pa_p005 rbl_sp005_1 ctl 0 swpre
crbl_sp005_1 rbl_sp005_1 0 {C_RBL}
spr_sp005_1 pref_100 ref_sp005_1 ctl 0 swpre
cref_sp005_1 ref_sp005_1 0 {C_RBL}   $ ASSUMPTION: ideal matched dummy load
XMN1_sp005_1 rbl_sp005_1 ref_sp005_1 vn_sp005_1 0 sky130_fd_pr__nfet_01v8 L=0.15 W=1 nf=1 ad=0.29 as=0.29 pd=2.58 ps=2.58 nrd=0.29 nrs=0.29 sa=0 sb=0 sd=0 mult=1 m=1
XMN2_sp005_1 ref_sp005_1 rbl_sp005_1 vn_sp005_1 0 sky130_fd_pr__nfet_01v8 L=0.15 W=1 nf=1 ad=0.29 as=0.29 pd=2.58 ps=2.58 nrd=0.29 nrs=0.29 sa=0 sb=0 sd=0 mult=1 m=1
XMP1_sp005_1 rbl_sp005_1 ref_sp005_1 vp_sp005_1 vdd sky130_fd_pr__pfet_01v8 L=0.15 W=2 nf=1 ad=0.58 as=0.58 pd=4.58 ps=4.58 nrd=0.145 nrs=0.145 sa=0 sb=0 sd=0 mult=1 m=1
XMP2_sp005_1 ref_sp005_1 rbl_sp005_1 vp_sp005_1 vdd sky130_fd_pr__pfet_01v8 L=0.15 W=2 nf=1 ad=0.58 as=0.58 pd=4.58 ps=4.58 nrd=0.145 nrs=0.145 sa=0 sb=0 sd=0 mult=1 m=1
XMNF_sp005_1 vn_sp005_1 en 0 0 sky130_fd_pr__nfet_01v8 L=0.15 W=2 nf=1 ad=0.58 as=0.58 pd=4.58 ps=4.58 nrd=0.145 nrs=0.145 sa=0 sb=0 sd=0 mult=1 m=1
XMPH_sp005_1 vp_sp005_1 enb vdd vdd sky130_fd_pr__pfet_01v8 L=0.15 W=4 nf=1 ad=1.16 as=1.16 pd=8.58 ps=8.58 nrd=0.0725 nrs=0.0725 sa=0 sb=0 sd=0 mult=1 m=1
bd_sp005_1 d_sp005_1 0 v=v(rbl_sp005_1)-v(ref_sp005_1)
bdabs_sp005_1 dabs_sp005_1 0 v=abs(v(rbl_sp005_1)-v(ref_sp005_1))

* ---- sp005_2: d = 5 mV, replica 2 ----
spa_sp005_2 pa_p005 rbl_sp005_2 ctl 0 swpre
crbl_sp005_2 rbl_sp005_2 0 {C_RBL}
spr_sp005_2 pref_100 ref_sp005_2 ctl 0 swpre
cref_sp005_2 ref_sp005_2 0 {C_RBL}   $ ASSUMPTION: ideal matched dummy load
XMN1_sp005_2 rbl_sp005_2 ref_sp005_2 vn_sp005_2 0 sky130_fd_pr__nfet_01v8 L=0.15 W=1 nf=1 ad=0.29 as=0.29 pd=2.58 ps=2.58 nrd=0.29 nrs=0.29 sa=0 sb=0 sd=0 mult=1 m=1
XMN2_sp005_2 ref_sp005_2 rbl_sp005_2 vn_sp005_2 0 sky130_fd_pr__nfet_01v8 L=0.15 W=1 nf=1 ad=0.29 as=0.29 pd=2.58 ps=2.58 nrd=0.29 nrs=0.29 sa=0 sb=0 sd=0 mult=1 m=1
XMP1_sp005_2 rbl_sp005_2 ref_sp005_2 vp_sp005_2 vdd sky130_fd_pr__pfet_01v8 L=0.15 W=2 nf=1 ad=0.58 as=0.58 pd=4.58 ps=4.58 nrd=0.145 nrs=0.145 sa=0 sb=0 sd=0 mult=1 m=1
XMP2_sp005_2 ref_sp005_2 rbl_sp005_2 vp_sp005_2 vdd sky130_fd_pr__pfet_01v8 L=0.15 W=2 nf=1 ad=0.58 as=0.58 pd=4.58 ps=4.58 nrd=0.145 nrs=0.145 sa=0 sb=0 sd=0 mult=1 m=1
XMNF_sp005_2 vn_sp005_2 en 0 0 sky130_fd_pr__nfet_01v8 L=0.15 W=2 nf=1 ad=0.58 as=0.58 pd=4.58 ps=4.58 nrd=0.145 nrs=0.145 sa=0 sb=0 sd=0 mult=1 m=1
XMPH_sp005_2 vp_sp005_2 enb vdd vdd sky130_fd_pr__pfet_01v8 L=0.15 W=4 nf=1 ad=1.16 as=1.16 pd=8.58 ps=8.58 nrd=0.0725 nrs=0.0725 sa=0 sb=0 sd=0 mult=1 m=1
bd_sp005_2 d_sp005_2 0 v=v(rbl_sp005_2)-v(ref_sp005_2)
bdabs_sp005_2 dabs_sp005_2 0 v=abs(v(rbl_sp005_2)-v(ref_sp005_2))

* ---- sp005_3: d = 5 mV, replica 3 ----
spa_sp005_3 pa_p005 rbl_sp005_3 ctl 0 swpre
crbl_sp005_3 rbl_sp005_3 0 {C_RBL}
spr_sp005_3 pref_100 ref_sp005_3 ctl 0 swpre
cref_sp005_3 ref_sp005_3 0 {C_RBL}   $ ASSUMPTION: ideal matched dummy load
XMN1_sp005_3 rbl_sp005_3 ref_sp005_3 vn_sp005_3 0 sky130_fd_pr__nfet_01v8 L=0.15 W=1 nf=1 ad=0.29 as=0.29 pd=2.58 ps=2.58 nrd=0.29 nrs=0.29 sa=0 sb=0 sd=0 mult=1 m=1
XMN2_sp005_3 ref_sp005_3 rbl_sp005_3 vn_sp005_3 0 sky130_fd_pr__nfet_01v8 L=0.15 W=1 nf=1 ad=0.29 as=0.29 pd=2.58 ps=2.58 nrd=0.29 nrs=0.29 sa=0 sb=0 sd=0 mult=1 m=1
XMP1_sp005_3 rbl_sp005_3 ref_sp005_3 vp_sp005_3 vdd sky130_fd_pr__pfet_01v8 L=0.15 W=2 nf=1 ad=0.58 as=0.58 pd=4.58 ps=4.58 nrd=0.145 nrs=0.145 sa=0 sb=0 sd=0 mult=1 m=1
XMP2_sp005_3 ref_sp005_3 rbl_sp005_3 vp_sp005_3 vdd sky130_fd_pr__pfet_01v8 L=0.15 W=2 nf=1 ad=0.58 as=0.58 pd=4.58 ps=4.58 nrd=0.145 nrs=0.145 sa=0 sb=0 sd=0 mult=1 m=1
XMNF_sp005_3 vn_sp005_3 en 0 0 sky130_fd_pr__nfet_01v8 L=0.15 W=2 nf=1 ad=0.58 as=0.58 pd=4.58 ps=4.58 nrd=0.145 nrs=0.145 sa=0 sb=0 sd=0 mult=1 m=1
XMPH_sp005_3 vp_sp005_3 enb vdd vdd sky130_fd_pr__pfet_01v8 L=0.15 W=4 nf=1 ad=1.16 as=1.16 pd=8.58 ps=8.58 nrd=0.0725 nrs=0.0725 sa=0 sb=0 sd=0 mult=1 m=1
bd_sp005_3 d_sp005_3 0 v=v(rbl_sp005_3)-v(ref_sp005_3)
bdabs_sp005_3 dabs_sp005_3 0 v=abs(v(rbl_sp005_3)-v(ref_sp005_3))

* ---- sp005_4: d = 5 mV, replica 4 ----
spa_sp005_4 pa_p005 rbl_sp005_4 ctl 0 swpre
crbl_sp005_4 rbl_sp005_4 0 {C_RBL}
spr_sp005_4 pref_100 ref_sp005_4 ctl 0 swpre
cref_sp005_4 ref_sp005_4 0 {C_RBL}   $ ASSUMPTION: ideal matched dummy load
XMN1_sp005_4 rbl_sp005_4 ref_sp005_4 vn_sp005_4 0 sky130_fd_pr__nfet_01v8 L=0.15 W=1 nf=1 ad=0.29 as=0.29 pd=2.58 ps=2.58 nrd=0.29 nrs=0.29 sa=0 sb=0 sd=0 mult=1 m=1
XMN2_sp005_4 ref_sp005_4 rbl_sp005_4 vn_sp005_4 0 sky130_fd_pr__nfet_01v8 L=0.15 W=1 nf=1 ad=0.29 as=0.29 pd=2.58 ps=2.58 nrd=0.29 nrs=0.29 sa=0 sb=0 sd=0 mult=1 m=1
XMP1_sp005_4 rbl_sp005_4 ref_sp005_4 vp_sp005_4 vdd sky130_fd_pr__pfet_01v8 L=0.15 W=2 nf=1 ad=0.58 as=0.58 pd=4.58 ps=4.58 nrd=0.145 nrs=0.145 sa=0 sb=0 sd=0 mult=1 m=1
XMP2_sp005_4 ref_sp005_4 rbl_sp005_4 vp_sp005_4 vdd sky130_fd_pr__pfet_01v8 L=0.15 W=2 nf=1 ad=0.58 as=0.58 pd=4.58 ps=4.58 nrd=0.145 nrs=0.145 sa=0 sb=0 sd=0 mult=1 m=1
XMNF_sp005_4 vn_sp005_4 en 0 0 sky130_fd_pr__nfet_01v8 L=0.15 W=2 nf=1 ad=0.58 as=0.58 pd=4.58 ps=4.58 nrd=0.145 nrs=0.145 sa=0 sb=0 sd=0 mult=1 m=1
XMPH_sp005_4 vp_sp005_4 enb vdd vdd sky130_fd_pr__pfet_01v8 L=0.15 W=4 nf=1 ad=1.16 as=1.16 pd=8.58 ps=8.58 nrd=0.0725 nrs=0.0725 sa=0 sb=0 sd=0 mult=1 m=1
bd_sp005_4 d_sp005_4 0 v=v(rbl_sp005_4)-v(ref_sp005_4)
bdabs_sp005_4 dabs_sp005_4 0 v=abs(v(rbl_sp005_4)-v(ref_sp005_4))

* ---- sp005_5: d = 5 mV, replica 5 ----
spa_sp005_5 pa_p005 rbl_sp005_5 ctl 0 swpre
crbl_sp005_5 rbl_sp005_5 0 {C_RBL}
spr_sp005_5 pref_100 ref_sp005_5 ctl 0 swpre
cref_sp005_5 ref_sp005_5 0 {C_RBL}   $ ASSUMPTION: ideal matched dummy load
XMN1_sp005_5 rbl_sp005_5 ref_sp005_5 vn_sp005_5 0 sky130_fd_pr__nfet_01v8 L=0.15 W=1 nf=1 ad=0.29 as=0.29 pd=2.58 ps=2.58 nrd=0.29 nrs=0.29 sa=0 sb=0 sd=0 mult=1 m=1
XMN2_sp005_5 ref_sp005_5 rbl_sp005_5 vn_sp005_5 0 sky130_fd_pr__nfet_01v8 L=0.15 W=1 nf=1 ad=0.29 as=0.29 pd=2.58 ps=2.58 nrd=0.29 nrs=0.29 sa=0 sb=0 sd=0 mult=1 m=1
XMP1_sp005_5 rbl_sp005_5 ref_sp005_5 vp_sp005_5 vdd sky130_fd_pr__pfet_01v8 L=0.15 W=2 nf=1 ad=0.58 as=0.58 pd=4.58 ps=4.58 nrd=0.145 nrs=0.145 sa=0 sb=0 sd=0 mult=1 m=1
XMP2_sp005_5 ref_sp005_5 rbl_sp005_5 vp_sp005_5 vdd sky130_fd_pr__pfet_01v8 L=0.15 W=2 nf=1 ad=0.58 as=0.58 pd=4.58 ps=4.58 nrd=0.145 nrs=0.145 sa=0 sb=0 sd=0 mult=1 m=1
XMNF_sp005_5 vn_sp005_5 en 0 0 sky130_fd_pr__nfet_01v8 L=0.15 W=2 nf=1 ad=0.58 as=0.58 pd=4.58 ps=4.58 nrd=0.145 nrs=0.145 sa=0 sb=0 sd=0 mult=1 m=1
XMPH_sp005_5 vp_sp005_5 enb vdd vdd sky130_fd_pr__pfet_01v8 L=0.15 W=4 nf=1 ad=1.16 as=1.16 pd=8.58 ps=8.58 nrd=0.0725 nrs=0.0725 sa=0 sb=0 sd=0 mult=1 m=1
bd_sp005_5 d_sp005_5 0 v=v(rbl_sp005_5)-v(ref_sp005_5)
bdabs_sp005_5 dabs_sp005_5 0 v=abs(v(rbl_sp005_5)-v(ref_sp005_5))

* ---- sm005_0: d = -5 mV, replica 0 ----
spa_sm005_0 pa_m005 rbl_sm005_0 ctl 0 swpre
crbl_sm005_0 rbl_sm005_0 0 {C_RBL}
spr_sm005_0 pref_100 ref_sm005_0 ctl 0 swpre
cref_sm005_0 ref_sm005_0 0 {C_RBL}   $ ASSUMPTION: ideal matched dummy load
XMN1_sm005_0 rbl_sm005_0 ref_sm005_0 vn_sm005_0 0 sky130_fd_pr__nfet_01v8 L=0.15 W=1 nf=1 ad=0.29 as=0.29 pd=2.58 ps=2.58 nrd=0.29 nrs=0.29 sa=0 sb=0 sd=0 mult=1 m=1
XMN2_sm005_0 ref_sm005_0 rbl_sm005_0 vn_sm005_0 0 sky130_fd_pr__nfet_01v8 L=0.15 W=1 nf=1 ad=0.29 as=0.29 pd=2.58 ps=2.58 nrd=0.29 nrs=0.29 sa=0 sb=0 sd=0 mult=1 m=1
XMP1_sm005_0 rbl_sm005_0 ref_sm005_0 vp_sm005_0 vdd sky130_fd_pr__pfet_01v8 L=0.15 W=2 nf=1 ad=0.58 as=0.58 pd=4.58 ps=4.58 nrd=0.145 nrs=0.145 sa=0 sb=0 sd=0 mult=1 m=1
XMP2_sm005_0 ref_sm005_0 rbl_sm005_0 vp_sm005_0 vdd sky130_fd_pr__pfet_01v8 L=0.15 W=2 nf=1 ad=0.58 as=0.58 pd=4.58 ps=4.58 nrd=0.145 nrs=0.145 sa=0 sb=0 sd=0 mult=1 m=1
XMNF_sm005_0 vn_sm005_0 en 0 0 sky130_fd_pr__nfet_01v8 L=0.15 W=2 nf=1 ad=0.58 as=0.58 pd=4.58 ps=4.58 nrd=0.145 nrs=0.145 sa=0 sb=0 sd=0 mult=1 m=1
XMPH_sm005_0 vp_sm005_0 enb vdd vdd sky130_fd_pr__pfet_01v8 L=0.15 W=4 nf=1 ad=1.16 as=1.16 pd=8.58 ps=8.58 nrd=0.0725 nrs=0.0725 sa=0 sb=0 sd=0 mult=1 m=1
bd_sm005_0 d_sm005_0 0 v=v(rbl_sm005_0)-v(ref_sm005_0)
bdabs_sm005_0 dabs_sm005_0 0 v=abs(v(rbl_sm005_0)-v(ref_sm005_0))

* ---- sm005_1: d = -5 mV, replica 1 ----
spa_sm005_1 pa_m005 rbl_sm005_1 ctl 0 swpre
crbl_sm005_1 rbl_sm005_1 0 {C_RBL}
spr_sm005_1 pref_100 ref_sm005_1 ctl 0 swpre
cref_sm005_1 ref_sm005_1 0 {C_RBL}   $ ASSUMPTION: ideal matched dummy load
XMN1_sm005_1 rbl_sm005_1 ref_sm005_1 vn_sm005_1 0 sky130_fd_pr__nfet_01v8 L=0.15 W=1 nf=1 ad=0.29 as=0.29 pd=2.58 ps=2.58 nrd=0.29 nrs=0.29 sa=0 sb=0 sd=0 mult=1 m=1
XMN2_sm005_1 ref_sm005_1 rbl_sm005_1 vn_sm005_1 0 sky130_fd_pr__nfet_01v8 L=0.15 W=1 nf=1 ad=0.29 as=0.29 pd=2.58 ps=2.58 nrd=0.29 nrs=0.29 sa=0 sb=0 sd=0 mult=1 m=1
XMP1_sm005_1 rbl_sm005_1 ref_sm005_1 vp_sm005_1 vdd sky130_fd_pr__pfet_01v8 L=0.15 W=2 nf=1 ad=0.58 as=0.58 pd=4.58 ps=4.58 nrd=0.145 nrs=0.145 sa=0 sb=0 sd=0 mult=1 m=1
XMP2_sm005_1 ref_sm005_1 rbl_sm005_1 vp_sm005_1 vdd sky130_fd_pr__pfet_01v8 L=0.15 W=2 nf=1 ad=0.58 as=0.58 pd=4.58 ps=4.58 nrd=0.145 nrs=0.145 sa=0 sb=0 sd=0 mult=1 m=1
XMNF_sm005_1 vn_sm005_1 en 0 0 sky130_fd_pr__nfet_01v8 L=0.15 W=2 nf=1 ad=0.58 as=0.58 pd=4.58 ps=4.58 nrd=0.145 nrs=0.145 sa=0 sb=0 sd=0 mult=1 m=1
XMPH_sm005_1 vp_sm005_1 enb vdd vdd sky130_fd_pr__pfet_01v8 L=0.15 W=4 nf=1 ad=1.16 as=1.16 pd=8.58 ps=8.58 nrd=0.0725 nrs=0.0725 sa=0 sb=0 sd=0 mult=1 m=1
bd_sm005_1 d_sm005_1 0 v=v(rbl_sm005_1)-v(ref_sm005_1)
bdabs_sm005_1 dabs_sm005_1 0 v=abs(v(rbl_sm005_1)-v(ref_sm005_1))

* ---- sm005_2: d = -5 mV, replica 2 ----
spa_sm005_2 pa_m005 rbl_sm005_2 ctl 0 swpre
crbl_sm005_2 rbl_sm005_2 0 {C_RBL}
spr_sm005_2 pref_100 ref_sm005_2 ctl 0 swpre
cref_sm005_2 ref_sm005_2 0 {C_RBL}   $ ASSUMPTION: ideal matched dummy load
XMN1_sm005_2 rbl_sm005_2 ref_sm005_2 vn_sm005_2 0 sky130_fd_pr__nfet_01v8 L=0.15 W=1 nf=1 ad=0.29 as=0.29 pd=2.58 ps=2.58 nrd=0.29 nrs=0.29 sa=0 sb=0 sd=0 mult=1 m=1
XMN2_sm005_2 ref_sm005_2 rbl_sm005_2 vn_sm005_2 0 sky130_fd_pr__nfet_01v8 L=0.15 W=1 nf=1 ad=0.29 as=0.29 pd=2.58 ps=2.58 nrd=0.29 nrs=0.29 sa=0 sb=0 sd=0 mult=1 m=1
XMP1_sm005_2 rbl_sm005_2 ref_sm005_2 vp_sm005_2 vdd sky130_fd_pr__pfet_01v8 L=0.15 W=2 nf=1 ad=0.58 as=0.58 pd=4.58 ps=4.58 nrd=0.145 nrs=0.145 sa=0 sb=0 sd=0 mult=1 m=1
XMP2_sm005_2 ref_sm005_2 rbl_sm005_2 vp_sm005_2 vdd sky130_fd_pr__pfet_01v8 L=0.15 W=2 nf=1 ad=0.58 as=0.58 pd=4.58 ps=4.58 nrd=0.145 nrs=0.145 sa=0 sb=0 sd=0 mult=1 m=1
XMNF_sm005_2 vn_sm005_2 en 0 0 sky130_fd_pr__nfet_01v8 L=0.15 W=2 nf=1 ad=0.58 as=0.58 pd=4.58 ps=4.58 nrd=0.145 nrs=0.145 sa=0 sb=0 sd=0 mult=1 m=1
XMPH_sm005_2 vp_sm005_2 enb vdd vdd sky130_fd_pr__pfet_01v8 L=0.15 W=4 nf=1 ad=1.16 as=1.16 pd=8.58 ps=8.58 nrd=0.0725 nrs=0.0725 sa=0 sb=0 sd=0 mult=1 m=1
bd_sm005_2 d_sm005_2 0 v=v(rbl_sm005_2)-v(ref_sm005_2)
bdabs_sm005_2 dabs_sm005_2 0 v=abs(v(rbl_sm005_2)-v(ref_sm005_2))

* ---- sm005_3: d = -5 mV, replica 3 ----
spa_sm005_3 pa_m005 rbl_sm005_3 ctl 0 swpre
crbl_sm005_3 rbl_sm005_3 0 {C_RBL}
spr_sm005_3 pref_100 ref_sm005_3 ctl 0 swpre
cref_sm005_3 ref_sm005_3 0 {C_RBL}   $ ASSUMPTION: ideal matched dummy load
XMN1_sm005_3 rbl_sm005_3 ref_sm005_3 vn_sm005_3 0 sky130_fd_pr__nfet_01v8 L=0.15 W=1 nf=1 ad=0.29 as=0.29 pd=2.58 ps=2.58 nrd=0.29 nrs=0.29 sa=0 sb=0 sd=0 mult=1 m=1
XMN2_sm005_3 ref_sm005_3 rbl_sm005_3 vn_sm005_3 0 sky130_fd_pr__nfet_01v8 L=0.15 W=1 nf=1 ad=0.29 as=0.29 pd=2.58 ps=2.58 nrd=0.29 nrs=0.29 sa=0 sb=0 sd=0 mult=1 m=1
XMP1_sm005_3 rbl_sm005_3 ref_sm005_3 vp_sm005_3 vdd sky130_fd_pr__pfet_01v8 L=0.15 W=2 nf=1 ad=0.58 as=0.58 pd=4.58 ps=4.58 nrd=0.145 nrs=0.145 sa=0 sb=0 sd=0 mult=1 m=1
XMP2_sm005_3 ref_sm005_3 rbl_sm005_3 vp_sm005_3 vdd sky130_fd_pr__pfet_01v8 L=0.15 W=2 nf=1 ad=0.58 as=0.58 pd=4.58 ps=4.58 nrd=0.145 nrs=0.145 sa=0 sb=0 sd=0 mult=1 m=1
XMNF_sm005_3 vn_sm005_3 en 0 0 sky130_fd_pr__nfet_01v8 L=0.15 W=2 nf=1 ad=0.58 as=0.58 pd=4.58 ps=4.58 nrd=0.145 nrs=0.145 sa=0 sb=0 sd=0 mult=1 m=1
XMPH_sm005_3 vp_sm005_3 enb vdd vdd sky130_fd_pr__pfet_01v8 L=0.15 W=4 nf=1 ad=1.16 as=1.16 pd=8.58 ps=8.58 nrd=0.0725 nrs=0.0725 sa=0 sb=0 sd=0 mult=1 m=1
bd_sm005_3 d_sm005_3 0 v=v(rbl_sm005_3)-v(ref_sm005_3)
bdabs_sm005_3 dabs_sm005_3 0 v=abs(v(rbl_sm005_3)-v(ref_sm005_3))

* ---- sm005_4: d = -5 mV, replica 4 ----
spa_sm005_4 pa_m005 rbl_sm005_4 ctl 0 swpre
crbl_sm005_4 rbl_sm005_4 0 {C_RBL}
spr_sm005_4 pref_100 ref_sm005_4 ctl 0 swpre
cref_sm005_4 ref_sm005_4 0 {C_RBL}   $ ASSUMPTION: ideal matched dummy load
XMN1_sm005_4 rbl_sm005_4 ref_sm005_4 vn_sm005_4 0 sky130_fd_pr__nfet_01v8 L=0.15 W=1 nf=1 ad=0.29 as=0.29 pd=2.58 ps=2.58 nrd=0.29 nrs=0.29 sa=0 sb=0 sd=0 mult=1 m=1
XMN2_sm005_4 ref_sm005_4 rbl_sm005_4 vn_sm005_4 0 sky130_fd_pr__nfet_01v8 L=0.15 W=1 nf=1 ad=0.29 as=0.29 pd=2.58 ps=2.58 nrd=0.29 nrs=0.29 sa=0 sb=0 sd=0 mult=1 m=1
XMP1_sm005_4 rbl_sm005_4 ref_sm005_4 vp_sm005_4 vdd sky130_fd_pr__pfet_01v8 L=0.15 W=2 nf=1 ad=0.58 as=0.58 pd=4.58 ps=4.58 nrd=0.145 nrs=0.145 sa=0 sb=0 sd=0 mult=1 m=1
XMP2_sm005_4 ref_sm005_4 rbl_sm005_4 vp_sm005_4 vdd sky130_fd_pr__pfet_01v8 L=0.15 W=2 nf=1 ad=0.58 as=0.58 pd=4.58 ps=4.58 nrd=0.145 nrs=0.145 sa=0 sb=0 sd=0 mult=1 m=1
XMNF_sm005_4 vn_sm005_4 en 0 0 sky130_fd_pr__nfet_01v8 L=0.15 W=2 nf=1 ad=0.58 as=0.58 pd=4.58 ps=4.58 nrd=0.145 nrs=0.145 sa=0 sb=0 sd=0 mult=1 m=1
XMPH_sm005_4 vp_sm005_4 enb vdd vdd sky130_fd_pr__pfet_01v8 L=0.15 W=4 nf=1 ad=1.16 as=1.16 pd=8.58 ps=8.58 nrd=0.0725 nrs=0.0725 sa=0 sb=0 sd=0 mult=1 m=1
bd_sm005_4 d_sm005_4 0 v=v(rbl_sm005_4)-v(ref_sm005_4)
bdabs_sm005_4 dabs_sm005_4 0 v=abs(v(rbl_sm005_4)-v(ref_sm005_4))

* ---- sm005_5: d = -5 mV, replica 5 ----
spa_sm005_5 pa_m005 rbl_sm005_5 ctl 0 swpre
crbl_sm005_5 rbl_sm005_5 0 {C_RBL}
spr_sm005_5 pref_100 ref_sm005_5 ctl 0 swpre
cref_sm005_5 ref_sm005_5 0 {C_RBL}   $ ASSUMPTION: ideal matched dummy load
XMN1_sm005_5 rbl_sm005_5 ref_sm005_5 vn_sm005_5 0 sky130_fd_pr__nfet_01v8 L=0.15 W=1 nf=1 ad=0.29 as=0.29 pd=2.58 ps=2.58 nrd=0.29 nrs=0.29 sa=0 sb=0 sd=0 mult=1 m=1
XMN2_sm005_5 ref_sm005_5 rbl_sm005_5 vn_sm005_5 0 sky130_fd_pr__nfet_01v8 L=0.15 W=1 nf=1 ad=0.29 as=0.29 pd=2.58 ps=2.58 nrd=0.29 nrs=0.29 sa=0 sb=0 sd=0 mult=1 m=1
XMP1_sm005_5 rbl_sm005_5 ref_sm005_5 vp_sm005_5 vdd sky130_fd_pr__pfet_01v8 L=0.15 W=2 nf=1 ad=0.58 as=0.58 pd=4.58 ps=4.58 nrd=0.145 nrs=0.145 sa=0 sb=0 sd=0 mult=1 m=1
XMP2_sm005_5 ref_sm005_5 rbl_sm005_5 vp_sm005_5 vdd sky130_fd_pr__pfet_01v8 L=0.15 W=2 nf=1 ad=0.58 as=0.58 pd=4.58 ps=4.58 nrd=0.145 nrs=0.145 sa=0 sb=0 sd=0 mult=1 m=1
XMNF_sm005_5 vn_sm005_5 en 0 0 sky130_fd_pr__nfet_01v8 L=0.15 W=2 nf=1 ad=0.58 as=0.58 pd=4.58 ps=4.58 nrd=0.145 nrs=0.145 sa=0 sb=0 sd=0 mult=1 m=1
XMPH_sm005_5 vp_sm005_5 enb vdd vdd sky130_fd_pr__pfet_01v8 L=0.15 W=4 nf=1 ad=1.16 as=1.16 pd=8.58 ps=8.58 nrd=0.0725 nrs=0.0725 sa=0 sb=0 sd=0 mult=1 m=1
bd_sm005_5 d_sm005_5 0 v=v(rbl_sm005_5)-v(ref_sm005_5)
bdabs_sm005_5 dabs_sm005_5 0 v=abs(v(rbl_sm005_5)-v(ref_sm005_5))

* ---- sp010_0: d = 10 mV, replica 0 ----
spa_sp010_0 pa_p010 rbl_sp010_0 ctl 0 swpre
crbl_sp010_0 rbl_sp010_0 0 {C_RBL}
spr_sp010_0 pref_100 ref_sp010_0 ctl 0 swpre
cref_sp010_0 ref_sp010_0 0 {C_RBL}   $ ASSUMPTION: ideal matched dummy load
XMN1_sp010_0 rbl_sp010_0 ref_sp010_0 vn_sp010_0 0 sky130_fd_pr__nfet_01v8 L=0.15 W=1 nf=1 ad=0.29 as=0.29 pd=2.58 ps=2.58 nrd=0.29 nrs=0.29 sa=0 sb=0 sd=0 mult=1 m=1
XMN2_sp010_0 ref_sp010_0 rbl_sp010_0 vn_sp010_0 0 sky130_fd_pr__nfet_01v8 L=0.15 W=1 nf=1 ad=0.29 as=0.29 pd=2.58 ps=2.58 nrd=0.29 nrs=0.29 sa=0 sb=0 sd=0 mult=1 m=1
XMP1_sp010_0 rbl_sp010_0 ref_sp010_0 vp_sp010_0 vdd sky130_fd_pr__pfet_01v8 L=0.15 W=2 nf=1 ad=0.58 as=0.58 pd=4.58 ps=4.58 nrd=0.145 nrs=0.145 sa=0 sb=0 sd=0 mult=1 m=1
XMP2_sp010_0 ref_sp010_0 rbl_sp010_0 vp_sp010_0 vdd sky130_fd_pr__pfet_01v8 L=0.15 W=2 nf=1 ad=0.58 as=0.58 pd=4.58 ps=4.58 nrd=0.145 nrs=0.145 sa=0 sb=0 sd=0 mult=1 m=1
XMNF_sp010_0 vn_sp010_0 en 0 0 sky130_fd_pr__nfet_01v8 L=0.15 W=2 nf=1 ad=0.58 as=0.58 pd=4.58 ps=4.58 nrd=0.145 nrs=0.145 sa=0 sb=0 sd=0 mult=1 m=1
XMPH_sp010_0 vp_sp010_0 enb vdd vdd sky130_fd_pr__pfet_01v8 L=0.15 W=4 nf=1 ad=1.16 as=1.16 pd=8.58 ps=8.58 nrd=0.0725 nrs=0.0725 sa=0 sb=0 sd=0 mult=1 m=1
bd_sp010_0 d_sp010_0 0 v=v(rbl_sp010_0)-v(ref_sp010_0)
bdabs_sp010_0 dabs_sp010_0 0 v=abs(v(rbl_sp010_0)-v(ref_sp010_0))

* ---- sp010_1: d = 10 mV, replica 1 ----
spa_sp010_1 pa_p010 rbl_sp010_1 ctl 0 swpre
crbl_sp010_1 rbl_sp010_1 0 {C_RBL}
spr_sp010_1 pref_100 ref_sp010_1 ctl 0 swpre
cref_sp010_1 ref_sp010_1 0 {C_RBL}   $ ASSUMPTION: ideal matched dummy load
XMN1_sp010_1 rbl_sp010_1 ref_sp010_1 vn_sp010_1 0 sky130_fd_pr__nfet_01v8 L=0.15 W=1 nf=1 ad=0.29 as=0.29 pd=2.58 ps=2.58 nrd=0.29 nrs=0.29 sa=0 sb=0 sd=0 mult=1 m=1
XMN2_sp010_1 ref_sp010_1 rbl_sp010_1 vn_sp010_1 0 sky130_fd_pr__nfet_01v8 L=0.15 W=1 nf=1 ad=0.29 as=0.29 pd=2.58 ps=2.58 nrd=0.29 nrs=0.29 sa=0 sb=0 sd=0 mult=1 m=1
XMP1_sp010_1 rbl_sp010_1 ref_sp010_1 vp_sp010_1 vdd sky130_fd_pr__pfet_01v8 L=0.15 W=2 nf=1 ad=0.58 as=0.58 pd=4.58 ps=4.58 nrd=0.145 nrs=0.145 sa=0 sb=0 sd=0 mult=1 m=1
XMP2_sp010_1 ref_sp010_1 rbl_sp010_1 vp_sp010_1 vdd sky130_fd_pr__pfet_01v8 L=0.15 W=2 nf=1 ad=0.58 as=0.58 pd=4.58 ps=4.58 nrd=0.145 nrs=0.145 sa=0 sb=0 sd=0 mult=1 m=1
XMNF_sp010_1 vn_sp010_1 en 0 0 sky130_fd_pr__nfet_01v8 L=0.15 W=2 nf=1 ad=0.58 as=0.58 pd=4.58 ps=4.58 nrd=0.145 nrs=0.145 sa=0 sb=0 sd=0 mult=1 m=1
XMPH_sp010_1 vp_sp010_1 enb vdd vdd sky130_fd_pr__pfet_01v8 L=0.15 W=4 nf=1 ad=1.16 as=1.16 pd=8.58 ps=8.58 nrd=0.0725 nrs=0.0725 sa=0 sb=0 sd=0 mult=1 m=1
bd_sp010_1 d_sp010_1 0 v=v(rbl_sp010_1)-v(ref_sp010_1)
bdabs_sp010_1 dabs_sp010_1 0 v=abs(v(rbl_sp010_1)-v(ref_sp010_1))

* ---- sp010_2: d = 10 mV, replica 2 ----
spa_sp010_2 pa_p010 rbl_sp010_2 ctl 0 swpre
crbl_sp010_2 rbl_sp010_2 0 {C_RBL}
spr_sp010_2 pref_100 ref_sp010_2 ctl 0 swpre
cref_sp010_2 ref_sp010_2 0 {C_RBL}   $ ASSUMPTION: ideal matched dummy load
XMN1_sp010_2 rbl_sp010_2 ref_sp010_2 vn_sp010_2 0 sky130_fd_pr__nfet_01v8 L=0.15 W=1 nf=1 ad=0.29 as=0.29 pd=2.58 ps=2.58 nrd=0.29 nrs=0.29 sa=0 sb=0 sd=0 mult=1 m=1
XMN2_sp010_2 ref_sp010_2 rbl_sp010_2 vn_sp010_2 0 sky130_fd_pr__nfet_01v8 L=0.15 W=1 nf=1 ad=0.29 as=0.29 pd=2.58 ps=2.58 nrd=0.29 nrs=0.29 sa=0 sb=0 sd=0 mult=1 m=1
XMP1_sp010_2 rbl_sp010_2 ref_sp010_2 vp_sp010_2 vdd sky130_fd_pr__pfet_01v8 L=0.15 W=2 nf=1 ad=0.58 as=0.58 pd=4.58 ps=4.58 nrd=0.145 nrs=0.145 sa=0 sb=0 sd=0 mult=1 m=1
XMP2_sp010_2 ref_sp010_2 rbl_sp010_2 vp_sp010_2 vdd sky130_fd_pr__pfet_01v8 L=0.15 W=2 nf=1 ad=0.58 as=0.58 pd=4.58 ps=4.58 nrd=0.145 nrs=0.145 sa=0 sb=0 sd=0 mult=1 m=1
XMNF_sp010_2 vn_sp010_2 en 0 0 sky130_fd_pr__nfet_01v8 L=0.15 W=2 nf=1 ad=0.58 as=0.58 pd=4.58 ps=4.58 nrd=0.145 nrs=0.145 sa=0 sb=0 sd=0 mult=1 m=1
XMPH_sp010_2 vp_sp010_2 enb vdd vdd sky130_fd_pr__pfet_01v8 L=0.15 W=4 nf=1 ad=1.16 as=1.16 pd=8.58 ps=8.58 nrd=0.0725 nrs=0.0725 sa=0 sb=0 sd=0 mult=1 m=1
bd_sp010_2 d_sp010_2 0 v=v(rbl_sp010_2)-v(ref_sp010_2)
bdabs_sp010_2 dabs_sp010_2 0 v=abs(v(rbl_sp010_2)-v(ref_sp010_2))

* ---- sp010_3: d = 10 mV, replica 3 ----
spa_sp010_3 pa_p010 rbl_sp010_3 ctl 0 swpre
crbl_sp010_3 rbl_sp010_3 0 {C_RBL}
spr_sp010_3 pref_100 ref_sp010_3 ctl 0 swpre
cref_sp010_3 ref_sp010_3 0 {C_RBL}   $ ASSUMPTION: ideal matched dummy load
XMN1_sp010_3 rbl_sp010_3 ref_sp010_3 vn_sp010_3 0 sky130_fd_pr__nfet_01v8 L=0.15 W=1 nf=1 ad=0.29 as=0.29 pd=2.58 ps=2.58 nrd=0.29 nrs=0.29 sa=0 sb=0 sd=0 mult=1 m=1
XMN2_sp010_3 ref_sp010_3 rbl_sp010_3 vn_sp010_3 0 sky130_fd_pr__nfet_01v8 L=0.15 W=1 nf=1 ad=0.29 as=0.29 pd=2.58 ps=2.58 nrd=0.29 nrs=0.29 sa=0 sb=0 sd=0 mult=1 m=1
XMP1_sp010_3 rbl_sp010_3 ref_sp010_3 vp_sp010_3 vdd sky130_fd_pr__pfet_01v8 L=0.15 W=2 nf=1 ad=0.58 as=0.58 pd=4.58 ps=4.58 nrd=0.145 nrs=0.145 sa=0 sb=0 sd=0 mult=1 m=1
XMP2_sp010_3 ref_sp010_3 rbl_sp010_3 vp_sp010_3 vdd sky130_fd_pr__pfet_01v8 L=0.15 W=2 nf=1 ad=0.58 as=0.58 pd=4.58 ps=4.58 nrd=0.145 nrs=0.145 sa=0 sb=0 sd=0 mult=1 m=1
XMNF_sp010_3 vn_sp010_3 en 0 0 sky130_fd_pr__nfet_01v8 L=0.15 W=2 nf=1 ad=0.58 as=0.58 pd=4.58 ps=4.58 nrd=0.145 nrs=0.145 sa=0 sb=0 sd=0 mult=1 m=1
XMPH_sp010_3 vp_sp010_3 enb vdd vdd sky130_fd_pr__pfet_01v8 L=0.15 W=4 nf=1 ad=1.16 as=1.16 pd=8.58 ps=8.58 nrd=0.0725 nrs=0.0725 sa=0 sb=0 sd=0 mult=1 m=1
bd_sp010_3 d_sp010_3 0 v=v(rbl_sp010_3)-v(ref_sp010_3)
bdabs_sp010_3 dabs_sp010_3 0 v=abs(v(rbl_sp010_3)-v(ref_sp010_3))

* ---- sp010_4: d = 10 mV, replica 4 ----
spa_sp010_4 pa_p010 rbl_sp010_4 ctl 0 swpre
crbl_sp010_4 rbl_sp010_4 0 {C_RBL}
spr_sp010_4 pref_100 ref_sp010_4 ctl 0 swpre
cref_sp010_4 ref_sp010_4 0 {C_RBL}   $ ASSUMPTION: ideal matched dummy load
XMN1_sp010_4 rbl_sp010_4 ref_sp010_4 vn_sp010_4 0 sky130_fd_pr__nfet_01v8 L=0.15 W=1 nf=1 ad=0.29 as=0.29 pd=2.58 ps=2.58 nrd=0.29 nrs=0.29 sa=0 sb=0 sd=0 mult=1 m=1
XMN2_sp010_4 ref_sp010_4 rbl_sp010_4 vn_sp010_4 0 sky130_fd_pr__nfet_01v8 L=0.15 W=1 nf=1 ad=0.29 as=0.29 pd=2.58 ps=2.58 nrd=0.29 nrs=0.29 sa=0 sb=0 sd=0 mult=1 m=1
XMP1_sp010_4 rbl_sp010_4 ref_sp010_4 vp_sp010_4 vdd sky130_fd_pr__pfet_01v8 L=0.15 W=2 nf=1 ad=0.58 as=0.58 pd=4.58 ps=4.58 nrd=0.145 nrs=0.145 sa=0 sb=0 sd=0 mult=1 m=1
XMP2_sp010_4 ref_sp010_4 rbl_sp010_4 vp_sp010_4 vdd sky130_fd_pr__pfet_01v8 L=0.15 W=2 nf=1 ad=0.58 as=0.58 pd=4.58 ps=4.58 nrd=0.145 nrs=0.145 sa=0 sb=0 sd=0 mult=1 m=1
XMNF_sp010_4 vn_sp010_4 en 0 0 sky130_fd_pr__nfet_01v8 L=0.15 W=2 nf=1 ad=0.58 as=0.58 pd=4.58 ps=4.58 nrd=0.145 nrs=0.145 sa=0 sb=0 sd=0 mult=1 m=1
XMPH_sp010_4 vp_sp010_4 enb vdd vdd sky130_fd_pr__pfet_01v8 L=0.15 W=4 nf=1 ad=1.16 as=1.16 pd=8.58 ps=8.58 nrd=0.0725 nrs=0.0725 sa=0 sb=0 sd=0 mult=1 m=1
bd_sp010_4 d_sp010_4 0 v=v(rbl_sp010_4)-v(ref_sp010_4)
bdabs_sp010_4 dabs_sp010_4 0 v=abs(v(rbl_sp010_4)-v(ref_sp010_4))

* ---- sp010_5: d = 10 mV, replica 5 ----
spa_sp010_5 pa_p010 rbl_sp010_5 ctl 0 swpre
crbl_sp010_5 rbl_sp010_5 0 {C_RBL}
spr_sp010_5 pref_100 ref_sp010_5 ctl 0 swpre
cref_sp010_5 ref_sp010_5 0 {C_RBL}   $ ASSUMPTION: ideal matched dummy load
XMN1_sp010_5 rbl_sp010_5 ref_sp010_5 vn_sp010_5 0 sky130_fd_pr__nfet_01v8 L=0.15 W=1 nf=1 ad=0.29 as=0.29 pd=2.58 ps=2.58 nrd=0.29 nrs=0.29 sa=0 sb=0 sd=0 mult=1 m=1
XMN2_sp010_5 ref_sp010_5 rbl_sp010_5 vn_sp010_5 0 sky130_fd_pr__nfet_01v8 L=0.15 W=1 nf=1 ad=0.29 as=0.29 pd=2.58 ps=2.58 nrd=0.29 nrs=0.29 sa=0 sb=0 sd=0 mult=1 m=1
XMP1_sp010_5 rbl_sp010_5 ref_sp010_5 vp_sp010_5 vdd sky130_fd_pr__pfet_01v8 L=0.15 W=2 nf=1 ad=0.58 as=0.58 pd=4.58 ps=4.58 nrd=0.145 nrs=0.145 sa=0 sb=0 sd=0 mult=1 m=1
XMP2_sp010_5 ref_sp010_5 rbl_sp010_5 vp_sp010_5 vdd sky130_fd_pr__pfet_01v8 L=0.15 W=2 nf=1 ad=0.58 as=0.58 pd=4.58 ps=4.58 nrd=0.145 nrs=0.145 sa=0 sb=0 sd=0 mult=1 m=1
XMNF_sp010_5 vn_sp010_5 en 0 0 sky130_fd_pr__nfet_01v8 L=0.15 W=2 nf=1 ad=0.58 as=0.58 pd=4.58 ps=4.58 nrd=0.145 nrs=0.145 sa=0 sb=0 sd=0 mult=1 m=1
XMPH_sp010_5 vp_sp010_5 enb vdd vdd sky130_fd_pr__pfet_01v8 L=0.15 W=4 nf=1 ad=1.16 as=1.16 pd=8.58 ps=8.58 nrd=0.0725 nrs=0.0725 sa=0 sb=0 sd=0 mult=1 m=1
bd_sp010_5 d_sp010_5 0 v=v(rbl_sp010_5)-v(ref_sp010_5)
bdabs_sp010_5 dabs_sp010_5 0 v=abs(v(rbl_sp010_5)-v(ref_sp010_5))

* ---- sm010_0: d = -10 mV, replica 0 ----
spa_sm010_0 pa_m010 rbl_sm010_0 ctl 0 swpre
crbl_sm010_0 rbl_sm010_0 0 {C_RBL}
spr_sm010_0 pref_100 ref_sm010_0 ctl 0 swpre
cref_sm010_0 ref_sm010_0 0 {C_RBL}   $ ASSUMPTION: ideal matched dummy load
XMN1_sm010_0 rbl_sm010_0 ref_sm010_0 vn_sm010_0 0 sky130_fd_pr__nfet_01v8 L=0.15 W=1 nf=1 ad=0.29 as=0.29 pd=2.58 ps=2.58 nrd=0.29 nrs=0.29 sa=0 sb=0 sd=0 mult=1 m=1
XMN2_sm010_0 ref_sm010_0 rbl_sm010_0 vn_sm010_0 0 sky130_fd_pr__nfet_01v8 L=0.15 W=1 nf=1 ad=0.29 as=0.29 pd=2.58 ps=2.58 nrd=0.29 nrs=0.29 sa=0 sb=0 sd=0 mult=1 m=1
XMP1_sm010_0 rbl_sm010_0 ref_sm010_0 vp_sm010_0 vdd sky130_fd_pr__pfet_01v8 L=0.15 W=2 nf=1 ad=0.58 as=0.58 pd=4.58 ps=4.58 nrd=0.145 nrs=0.145 sa=0 sb=0 sd=0 mult=1 m=1
XMP2_sm010_0 ref_sm010_0 rbl_sm010_0 vp_sm010_0 vdd sky130_fd_pr__pfet_01v8 L=0.15 W=2 nf=1 ad=0.58 as=0.58 pd=4.58 ps=4.58 nrd=0.145 nrs=0.145 sa=0 sb=0 sd=0 mult=1 m=1
XMNF_sm010_0 vn_sm010_0 en 0 0 sky130_fd_pr__nfet_01v8 L=0.15 W=2 nf=1 ad=0.58 as=0.58 pd=4.58 ps=4.58 nrd=0.145 nrs=0.145 sa=0 sb=0 sd=0 mult=1 m=1
XMPH_sm010_0 vp_sm010_0 enb vdd vdd sky130_fd_pr__pfet_01v8 L=0.15 W=4 nf=1 ad=1.16 as=1.16 pd=8.58 ps=8.58 nrd=0.0725 nrs=0.0725 sa=0 sb=0 sd=0 mult=1 m=1
bd_sm010_0 d_sm010_0 0 v=v(rbl_sm010_0)-v(ref_sm010_0)
bdabs_sm010_0 dabs_sm010_0 0 v=abs(v(rbl_sm010_0)-v(ref_sm010_0))

* ---- sm010_1: d = -10 mV, replica 1 ----
spa_sm010_1 pa_m010 rbl_sm010_1 ctl 0 swpre
crbl_sm010_1 rbl_sm010_1 0 {C_RBL}
spr_sm010_1 pref_100 ref_sm010_1 ctl 0 swpre
cref_sm010_1 ref_sm010_1 0 {C_RBL}   $ ASSUMPTION: ideal matched dummy load
XMN1_sm010_1 rbl_sm010_1 ref_sm010_1 vn_sm010_1 0 sky130_fd_pr__nfet_01v8 L=0.15 W=1 nf=1 ad=0.29 as=0.29 pd=2.58 ps=2.58 nrd=0.29 nrs=0.29 sa=0 sb=0 sd=0 mult=1 m=1
XMN2_sm010_1 ref_sm010_1 rbl_sm010_1 vn_sm010_1 0 sky130_fd_pr__nfet_01v8 L=0.15 W=1 nf=1 ad=0.29 as=0.29 pd=2.58 ps=2.58 nrd=0.29 nrs=0.29 sa=0 sb=0 sd=0 mult=1 m=1
XMP1_sm010_1 rbl_sm010_1 ref_sm010_1 vp_sm010_1 vdd sky130_fd_pr__pfet_01v8 L=0.15 W=2 nf=1 ad=0.58 as=0.58 pd=4.58 ps=4.58 nrd=0.145 nrs=0.145 sa=0 sb=0 sd=0 mult=1 m=1
XMP2_sm010_1 ref_sm010_1 rbl_sm010_1 vp_sm010_1 vdd sky130_fd_pr__pfet_01v8 L=0.15 W=2 nf=1 ad=0.58 as=0.58 pd=4.58 ps=4.58 nrd=0.145 nrs=0.145 sa=0 sb=0 sd=0 mult=1 m=1
XMNF_sm010_1 vn_sm010_1 en 0 0 sky130_fd_pr__nfet_01v8 L=0.15 W=2 nf=1 ad=0.58 as=0.58 pd=4.58 ps=4.58 nrd=0.145 nrs=0.145 sa=0 sb=0 sd=0 mult=1 m=1
XMPH_sm010_1 vp_sm010_1 enb vdd vdd sky130_fd_pr__pfet_01v8 L=0.15 W=4 nf=1 ad=1.16 as=1.16 pd=8.58 ps=8.58 nrd=0.0725 nrs=0.0725 sa=0 sb=0 sd=0 mult=1 m=1
bd_sm010_1 d_sm010_1 0 v=v(rbl_sm010_1)-v(ref_sm010_1)
bdabs_sm010_1 dabs_sm010_1 0 v=abs(v(rbl_sm010_1)-v(ref_sm010_1))

* ---- sm010_2: d = -10 mV, replica 2 ----
spa_sm010_2 pa_m010 rbl_sm010_2 ctl 0 swpre
crbl_sm010_2 rbl_sm010_2 0 {C_RBL}
spr_sm010_2 pref_100 ref_sm010_2 ctl 0 swpre
cref_sm010_2 ref_sm010_2 0 {C_RBL}   $ ASSUMPTION: ideal matched dummy load
XMN1_sm010_2 rbl_sm010_2 ref_sm010_2 vn_sm010_2 0 sky130_fd_pr__nfet_01v8 L=0.15 W=1 nf=1 ad=0.29 as=0.29 pd=2.58 ps=2.58 nrd=0.29 nrs=0.29 sa=0 sb=0 sd=0 mult=1 m=1
XMN2_sm010_2 ref_sm010_2 rbl_sm010_2 vn_sm010_2 0 sky130_fd_pr__nfet_01v8 L=0.15 W=1 nf=1 ad=0.29 as=0.29 pd=2.58 ps=2.58 nrd=0.29 nrs=0.29 sa=0 sb=0 sd=0 mult=1 m=1
XMP1_sm010_2 rbl_sm010_2 ref_sm010_2 vp_sm010_2 vdd sky130_fd_pr__pfet_01v8 L=0.15 W=2 nf=1 ad=0.58 as=0.58 pd=4.58 ps=4.58 nrd=0.145 nrs=0.145 sa=0 sb=0 sd=0 mult=1 m=1
XMP2_sm010_2 ref_sm010_2 rbl_sm010_2 vp_sm010_2 vdd sky130_fd_pr__pfet_01v8 L=0.15 W=2 nf=1 ad=0.58 as=0.58 pd=4.58 ps=4.58 nrd=0.145 nrs=0.145 sa=0 sb=0 sd=0 mult=1 m=1
XMNF_sm010_2 vn_sm010_2 en 0 0 sky130_fd_pr__nfet_01v8 L=0.15 W=2 nf=1 ad=0.58 as=0.58 pd=4.58 ps=4.58 nrd=0.145 nrs=0.145 sa=0 sb=0 sd=0 mult=1 m=1
XMPH_sm010_2 vp_sm010_2 enb vdd vdd sky130_fd_pr__pfet_01v8 L=0.15 W=4 nf=1 ad=1.16 as=1.16 pd=8.58 ps=8.58 nrd=0.0725 nrs=0.0725 sa=0 sb=0 sd=0 mult=1 m=1
bd_sm010_2 d_sm010_2 0 v=v(rbl_sm010_2)-v(ref_sm010_2)
bdabs_sm010_2 dabs_sm010_2 0 v=abs(v(rbl_sm010_2)-v(ref_sm010_2))

* ---- sm010_3: d = -10 mV, replica 3 ----
spa_sm010_3 pa_m010 rbl_sm010_3 ctl 0 swpre
crbl_sm010_3 rbl_sm010_3 0 {C_RBL}
spr_sm010_3 pref_100 ref_sm010_3 ctl 0 swpre
cref_sm010_3 ref_sm010_3 0 {C_RBL}   $ ASSUMPTION: ideal matched dummy load
XMN1_sm010_3 rbl_sm010_3 ref_sm010_3 vn_sm010_3 0 sky130_fd_pr__nfet_01v8 L=0.15 W=1 nf=1 ad=0.29 as=0.29 pd=2.58 ps=2.58 nrd=0.29 nrs=0.29 sa=0 sb=0 sd=0 mult=1 m=1
XMN2_sm010_3 ref_sm010_3 rbl_sm010_3 vn_sm010_3 0 sky130_fd_pr__nfet_01v8 L=0.15 W=1 nf=1 ad=0.29 as=0.29 pd=2.58 ps=2.58 nrd=0.29 nrs=0.29 sa=0 sb=0 sd=0 mult=1 m=1
XMP1_sm010_3 rbl_sm010_3 ref_sm010_3 vp_sm010_3 vdd sky130_fd_pr__pfet_01v8 L=0.15 W=2 nf=1 ad=0.58 as=0.58 pd=4.58 ps=4.58 nrd=0.145 nrs=0.145 sa=0 sb=0 sd=0 mult=1 m=1
XMP2_sm010_3 ref_sm010_3 rbl_sm010_3 vp_sm010_3 vdd sky130_fd_pr__pfet_01v8 L=0.15 W=2 nf=1 ad=0.58 as=0.58 pd=4.58 ps=4.58 nrd=0.145 nrs=0.145 sa=0 sb=0 sd=0 mult=1 m=1
XMNF_sm010_3 vn_sm010_3 en 0 0 sky130_fd_pr__nfet_01v8 L=0.15 W=2 nf=1 ad=0.58 as=0.58 pd=4.58 ps=4.58 nrd=0.145 nrs=0.145 sa=0 sb=0 sd=0 mult=1 m=1
XMPH_sm010_3 vp_sm010_3 enb vdd vdd sky130_fd_pr__pfet_01v8 L=0.15 W=4 nf=1 ad=1.16 as=1.16 pd=8.58 ps=8.58 nrd=0.0725 nrs=0.0725 sa=0 sb=0 sd=0 mult=1 m=1
bd_sm010_3 d_sm010_3 0 v=v(rbl_sm010_3)-v(ref_sm010_3)
bdabs_sm010_3 dabs_sm010_3 0 v=abs(v(rbl_sm010_3)-v(ref_sm010_3))

* ---- sm010_4: d = -10 mV, replica 4 ----
spa_sm010_4 pa_m010 rbl_sm010_4 ctl 0 swpre
crbl_sm010_4 rbl_sm010_4 0 {C_RBL}
spr_sm010_4 pref_100 ref_sm010_4 ctl 0 swpre
cref_sm010_4 ref_sm010_4 0 {C_RBL}   $ ASSUMPTION: ideal matched dummy load
XMN1_sm010_4 rbl_sm010_4 ref_sm010_4 vn_sm010_4 0 sky130_fd_pr__nfet_01v8 L=0.15 W=1 nf=1 ad=0.29 as=0.29 pd=2.58 ps=2.58 nrd=0.29 nrs=0.29 sa=0 sb=0 sd=0 mult=1 m=1
XMN2_sm010_4 ref_sm010_4 rbl_sm010_4 vn_sm010_4 0 sky130_fd_pr__nfet_01v8 L=0.15 W=1 nf=1 ad=0.29 as=0.29 pd=2.58 ps=2.58 nrd=0.29 nrs=0.29 sa=0 sb=0 sd=0 mult=1 m=1
XMP1_sm010_4 rbl_sm010_4 ref_sm010_4 vp_sm010_4 vdd sky130_fd_pr__pfet_01v8 L=0.15 W=2 nf=1 ad=0.58 as=0.58 pd=4.58 ps=4.58 nrd=0.145 nrs=0.145 sa=0 sb=0 sd=0 mult=1 m=1
XMP2_sm010_4 ref_sm010_4 rbl_sm010_4 vp_sm010_4 vdd sky130_fd_pr__pfet_01v8 L=0.15 W=2 nf=1 ad=0.58 as=0.58 pd=4.58 ps=4.58 nrd=0.145 nrs=0.145 sa=0 sb=0 sd=0 mult=1 m=1
XMNF_sm010_4 vn_sm010_4 en 0 0 sky130_fd_pr__nfet_01v8 L=0.15 W=2 nf=1 ad=0.58 as=0.58 pd=4.58 ps=4.58 nrd=0.145 nrs=0.145 sa=0 sb=0 sd=0 mult=1 m=1
XMPH_sm010_4 vp_sm010_4 enb vdd vdd sky130_fd_pr__pfet_01v8 L=0.15 W=4 nf=1 ad=1.16 as=1.16 pd=8.58 ps=8.58 nrd=0.0725 nrs=0.0725 sa=0 sb=0 sd=0 mult=1 m=1
bd_sm010_4 d_sm010_4 0 v=v(rbl_sm010_4)-v(ref_sm010_4)
bdabs_sm010_4 dabs_sm010_4 0 v=abs(v(rbl_sm010_4)-v(ref_sm010_4))

* ---- sm010_5: d = -10 mV, replica 5 ----
spa_sm010_5 pa_m010 rbl_sm010_5 ctl 0 swpre
crbl_sm010_5 rbl_sm010_5 0 {C_RBL}
spr_sm010_5 pref_100 ref_sm010_5 ctl 0 swpre
cref_sm010_5 ref_sm010_5 0 {C_RBL}   $ ASSUMPTION: ideal matched dummy load
XMN1_sm010_5 rbl_sm010_5 ref_sm010_5 vn_sm010_5 0 sky130_fd_pr__nfet_01v8 L=0.15 W=1 nf=1 ad=0.29 as=0.29 pd=2.58 ps=2.58 nrd=0.29 nrs=0.29 sa=0 sb=0 sd=0 mult=1 m=1
XMN2_sm010_5 ref_sm010_5 rbl_sm010_5 vn_sm010_5 0 sky130_fd_pr__nfet_01v8 L=0.15 W=1 nf=1 ad=0.29 as=0.29 pd=2.58 ps=2.58 nrd=0.29 nrs=0.29 sa=0 sb=0 sd=0 mult=1 m=1
XMP1_sm010_5 rbl_sm010_5 ref_sm010_5 vp_sm010_5 vdd sky130_fd_pr__pfet_01v8 L=0.15 W=2 nf=1 ad=0.58 as=0.58 pd=4.58 ps=4.58 nrd=0.145 nrs=0.145 sa=0 sb=0 sd=0 mult=1 m=1
XMP2_sm010_5 ref_sm010_5 rbl_sm010_5 vp_sm010_5 vdd sky130_fd_pr__pfet_01v8 L=0.15 W=2 nf=1 ad=0.58 as=0.58 pd=4.58 ps=4.58 nrd=0.145 nrs=0.145 sa=0 sb=0 sd=0 mult=1 m=1
XMNF_sm010_5 vn_sm010_5 en 0 0 sky130_fd_pr__nfet_01v8 L=0.15 W=2 nf=1 ad=0.58 as=0.58 pd=4.58 ps=4.58 nrd=0.145 nrs=0.145 sa=0 sb=0 sd=0 mult=1 m=1
XMPH_sm010_5 vp_sm010_5 enb vdd vdd sky130_fd_pr__pfet_01v8 L=0.15 W=4 nf=1 ad=1.16 as=1.16 pd=8.58 ps=8.58 nrd=0.0725 nrs=0.0725 sa=0 sb=0 sd=0 mult=1 m=1
bd_sm010_5 d_sm010_5 0 v=v(rbl_sm010_5)-v(ref_sm010_5)
bdabs_sm010_5 dabs_sm010_5 0 v=abs(v(rbl_sm010_5)-v(ref_sm010_5))

* ---- sp015_0: d = 15 mV, replica 0 ----
spa_sp015_0 pa_p015 rbl_sp015_0 ctl 0 swpre
crbl_sp015_0 rbl_sp015_0 0 {C_RBL}
spr_sp015_0 pref_100 ref_sp015_0 ctl 0 swpre
cref_sp015_0 ref_sp015_0 0 {C_RBL}   $ ASSUMPTION: ideal matched dummy load
XMN1_sp015_0 rbl_sp015_0 ref_sp015_0 vn_sp015_0 0 sky130_fd_pr__nfet_01v8 L=0.15 W=1 nf=1 ad=0.29 as=0.29 pd=2.58 ps=2.58 nrd=0.29 nrs=0.29 sa=0 sb=0 sd=0 mult=1 m=1
XMN2_sp015_0 ref_sp015_0 rbl_sp015_0 vn_sp015_0 0 sky130_fd_pr__nfet_01v8 L=0.15 W=1 nf=1 ad=0.29 as=0.29 pd=2.58 ps=2.58 nrd=0.29 nrs=0.29 sa=0 sb=0 sd=0 mult=1 m=1
XMP1_sp015_0 rbl_sp015_0 ref_sp015_0 vp_sp015_0 vdd sky130_fd_pr__pfet_01v8 L=0.15 W=2 nf=1 ad=0.58 as=0.58 pd=4.58 ps=4.58 nrd=0.145 nrs=0.145 sa=0 sb=0 sd=0 mult=1 m=1
XMP2_sp015_0 ref_sp015_0 rbl_sp015_0 vp_sp015_0 vdd sky130_fd_pr__pfet_01v8 L=0.15 W=2 nf=1 ad=0.58 as=0.58 pd=4.58 ps=4.58 nrd=0.145 nrs=0.145 sa=0 sb=0 sd=0 mult=1 m=1
XMNF_sp015_0 vn_sp015_0 en 0 0 sky130_fd_pr__nfet_01v8 L=0.15 W=2 nf=1 ad=0.58 as=0.58 pd=4.58 ps=4.58 nrd=0.145 nrs=0.145 sa=0 sb=0 sd=0 mult=1 m=1
XMPH_sp015_0 vp_sp015_0 enb vdd vdd sky130_fd_pr__pfet_01v8 L=0.15 W=4 nf=1 ad=1.16 as=1.16 pd=8.58 ps=8.58 nrd=0.0725 nrs=0.0725 sa=0 sb=0 sd=0 mult=1 m=1
bd_sp015_0 d_sp015_0 0 v=v(rbl_sp015_0)-v(ref_sp015_0)
bdabs_sp015_0 dabs_sp015_0 0 v=abs(v(rbl_sp015_0)-v(ref_sp015_0))

* ---- sp015_1: d = 15 mV, replica 1 ----
spa_sp015_1 pa_p015 rbl_sp015_1 ctl 0 swpre
crbl_sp015_1 rbl_sp015_1 0 {C_RBL}
spr_sp015_1 pref_100 ref_sp015_1 ctl 0 swpre
cref_sp015_1 ref_sp015_1 0 {C_RBL}   $ ASSUMPTION: ideal matched dummy load
XMN1_sp015_1 rbl_sp015_1 ref_sp015_1 vn_sp015_1 0 sky130_fd_pr__nfet_01v8 L=0.15 W=1 nf=1 ad=0.29 as=0.29 pd=2.58 ps=2.58 nrd=0.29 nrs=0.29 sa=0 sb=0 sd=0 mult=1 m=1
XMN2_sp015_1 ref_sp015_1 rbl_sp015_1 vn_sp015_1 0 sky130_fd_pr__nfet_01v8 L=0.15 W=1 nf=1 ad=0.29 as=0.29 pd=2.58 ps=2.58 nrd=0.29 nrs=0.29 sa=0 sb=0 sd=0 mult=1 m=1
XMP1_sp015_1 rbl_sp015_1 ref_sp015_1 vp_sp015_1 vdd sky130_fd_pr__pfet_01v8 L=0.15 W=2 nf=1 ad=0.58 as=0.58 pd=4.58 ps=4.58 nrd=0.145 nrs=0.145 sa=0 sb=0 sd=0 mult=1 m=1
XMP2_sp015_1 ref_sp015_1 rbl_sp015_1 vp_sp015_1 vdd sky130_fd_pr__pfet_01v8 L=0.15 W=2 nf=1 ad=0.58 as=0.58 pd=4.58 ps=4.58 nrd=0.145 nrs=0.145 sa=0 sb=0 sd=0 mult=1 m=1
XMNF_sp015_1 vn_sp015_1 en 0 0 sky130_fd_pr__nfet_01v8 L=0.15 W=2 nf=1 ad=0.58 as=0.58 pd=4.58 ps=4.58 nrd=0.145 nrs=0.145 sa=0 sb=0 sd=0 mult=1 m=1
XMPH_sp015_1 vp_sp015_1 enb vdd vdd sky130_fd_pr__pfet_01v8 L=0.15 W=4 nf=1 ad=1.16 as=1.16 pd=8.58 ps=8.58 nrd=0.0725 nrs=0.0725 sa=0 sb=0 sd=0 mult=1 m=1
bd_sp015_1 d_sp015_1 0 v=v(rbl_sp015_1)-v(ref_sp015_1)
bdabs_sp015_1 dabs_sp015_1 0 v=abs(v(rbl_sp015_1)-v(ref_sp015_1))

* ---- sp015_2: d = 15 mV, replica 2 ----
spa_sp015_2 pa_p015 rbl_sp015_2 ctl 0 swpre
crbl_sp015_2 rbl_sp015_2 0 {C_RBL}
spr_sp015_2 pref_100 ref_sp015_2 ctl 0 swpre
cref_sp015_2 ref_sp015_2 0 {C_RBL}   $ ASSUMPTION: ideal matched dummy load
XMN1_sp015_2 rbl_sp015_2 ref_sp015_2 vn_sp015_2 0 sky130_fd_pr__nfet_01v8 L=0.15 W=1 nf=1 ad=0.29 as=0.29 pd=2.58 ps=2.58 nrd=0.29 nrs=0.29 sa=0 sb=0 sd=0 mult=1 m=1
XMN2_sp015_2 ref_sp015_2 rbl_sp015_2 vn_sp015_2 0 sky130_fd_pr__nfet_01v8 L=0.15 W=1 nf=1 ad=0.29 as=0.29 pd=2.58 ps=2.58 nrd=0.29 nrs=0.29 sa=0 sb=0 sd=0 mult=1 m=1
XMP1_sp015_2 rbl_sp015_2 ref_sp015_2 vp_sp015_2 vdd sky130_fd_pr__pfet_01v8 L=0.15 W=2 nf=1 ad=0.58 as=0.58 pd=4.58 ps=4.58 nrd=0.145 nrs=0.145 sa=0 sb=0 sd=0 mult=1 m=1
XMP2_sp015_2 ref_sp015_2 rbl_sp015_2 vp_sp015_2 vdd sky130_fd_pr__pfet_01v8 L=0.15 W=2 nf=1 ad=0.58 as=0.58 pd=4.58 ps=4.58 nrd=0.145 nrs=0.145 sa=0 sb=0 sd=0 mult=1 m=1
XMNF_sp015_2 vn_sp015_2 en 0 0 sky130_fd_pr__nfet_01v8 L=0.15 W=2 nf=1 ad=0.58 as=0.58 pd=4.58 ps=4.58 nrd=0.145 nrs=0.145 sa=0 sb=0 sd=0 mult=1 m=1
XMPH_sp015_2 vp_sp015_2 enb vdd vdd sky130_fd_pr__pfet_01v8 L=0.15 W=4 nf=1 ad=1.16 as=1.16 pd=8.58 ps=8.58 nrd=0.0725 nrs=0.0725 sa=0 sb=0 sd=0 mult=1 m=1
bd_sp015_2 d_sp015_2 0 v=v(rbl_sp015_2)-v(ref_sp015_2)
bdabs_sp015_2 dabs_sp015_2 0 v=abs(v(rbl_sp015_2)-v(ref_sp015_2))

* ---- sp015_3: d = 15 mV, replica 3 ----
spa_sp015_3 pa_p015 rbl_sp015_3 ctl 0 swpre
crbl_sp015_3 rbl_sp015_3 0 {C_RBL}
spr_sp015_3 pref_100 ref_sp015_3 ctl 0 swpre
cref_sp015_3 ref_sp015_3 0 {C_RBL}   $ ASSUMPTION: ideal matched dummy load
XMN1_sp015_3 rbl_sp015_3 ref_sp015_3 vn_sp015_3 0 sky130_fd_pr__nfet_01v8 L=0.15 W=1 nf=1 ad=0.29 as=0.29 pd=2.58 ps=2.58 nrd=0.29 nrs=0.29 sa=0 sb=0 sd=0 mult=1 m=1
XMN2_sp015_3 ref_sp015_3 rbl_sp015_3 vn_sp015_3 0 sky130_fd_pr__nfet_01v8 L=0.15 W=1 nf=1 ad=0.29 as=0.29 pd=2.58 ps=2.58 nrd=0.29 nrs=0.29 sa=0 sb=0 sd=0 mult=1 m=1
XMP1_sp015_3 rbl_sp015_3 ref_sp015_3 vp_sp015_3 vdd sky130_fd_pr__pfet_01v8 L=0.15 W=2 nf=1 ad=0.58 as=0.58 pd=4.58 ps=4.58 nrd=0.145 nrs=0.145 sa=0 sb=0 sd=0 mult=1 m=1
XMP2_sp015_3 ref_sp015_3 rbl_sp015_3 vp_sp015_3 vdd sky130_fd_pr__pfet_01v8 L=0.15 W=2 nf=1 ad=0.58 as=0.58 pd=4.58 ps=4.58 nrd=0.145 nrs=0.145 sa=0 sb=0 sd=0 mult=1 m=1
XMNF_sp015_3 vn_sp015_3 en 0 0 sky130_fd_pr__nfet_01v8 L=0.15 W=2 nf=1 ad=0.58 as=0.58 pd=4.58 ps=4.58 nrd=0.145 nrs=0.145 sa=0 sb=0 sd=0 mult=1 m=1
XMPH_sp015_3 vp_sp015_3 enb vdd vdd sky130_fd_pr__pfet_01v8 L=0.15 W=4 nf=1 ad=1.16 as=1.16 pd=8.58 ps=8.58 nrd=0.0725 nrs=0.0725 sa=0 sb=0 sd=0 mult=1 m=1
bd_sp015_3 d_sp015_3 0 v=v(rbl_sp015_3)-v(ref_sp015_3)
bdabs_sp015_3 dabs_sp015_3 0 v=abs(v(rbl_sp015_3)-v(ref_sp015_3))

* ---- sp015_4: d = 15 mV, replica 4 ----
spa_sp015_4 pa_p015 rbl_sp015_4 ctl 0 swpre
crbl_sp015_4 rbl_sp015_4 0 {C_RBL}
spr_sp015_4 pref_100 ref_sp015_4 ctl 0 swpre
cref_sp015_4 ref_sp015_4 0 {C_RBL}   $ ASSUMPTION: ideal matched dummy load
XMN1_sp015_4 rbl_sp015_4 ref_sp015_4 vn_sp015_4 0 sky130_fd_pr__nfet_01v8 L=0.15 W=1 nf=1 ad=0.29 as=0.29 pd=2.58 ps=2.58 nrd=0.29 nrs=0.29 sa=0 sb=0 sd=0 mult=1 m=1
XMN2_sp015_4 ref_sp015_4 rbl_sp015_4 vn_sp015_4 0 sky130_fd_pr__nfet_01v8 L=0.15 W=1 nf=1 ad=0.29 as=0.29 pd=2.58 ps=2.58 nrd=0.29 nrs=0.29 sa=0 sb=0 sd=0 mult=1 m=1
XMP1_sp015_4 rbl_sp015_4 ref_sp015_4 vp_sp015_4 vdd sky130_fd_pr__pfet_01v8 L=0.15 W=2 nf=1 ad=0.58 as=0.58 pd=4.58 ps=4.58 nrd=0.145 nrs=0.145 sa=0 sb=0 sd=0 mult=1 m=1
XMP2_sp015_4 ref_sp015_4 rbl_sp015_4 vp_sp015_4 vdd sky130_fd_pr__pfet_01v8 L=0.15 W=2 nf=1 ad=0.58 as=0.58 pd=4.58 ps=4.58 nrd=0.145 nrs=0.145 sa=0 sb=0 sd=0 mult=1 m=1
XMNF_sp015_4 vn_sp015_4 en 0 0 sky130_fd_pr__nfet_01v8 L=0.15 W=2 nf=1 ad=0.58 as=0.58 pd=4.58 ps=4.58 nrd=0.145 nrs=0.145 sa=0 sb=0 sd=0 mult=1 m=1
XMPH_sp015_4 vp_sp015_4 enb vdd vdd sky130_fd_pr__pfet_01v8 L=0.15 W=4 nf=1 ad=1.16 as=1.16 pd=8.58 ps=8.58 nrd=0.0725 nrs=0.0725 sa=0 sb=0 sd=0 mult=1 m=1
bd_sp015_4 d_sp015_4 0 v=v(rbl_sp015_4)-v(ref_sp015_4)
bdabs_sp015_4 dabs_sp015_4 0 v=abs(v(rbl_sp015_4)-v(ref_sp015_4))

* ---- sp015_5: d = 15 mV, replica 5 ----
spa_sp015_5 pa_p015 rbl_sp015_5 ctl 0 swpre
crbl_sp015_5 rbl_sp015_5 0 {C_RBL}
spr_sp015_5 pref_100 ref_sp015_5 ctl 0 swpre
cref_sp015_5 ref_sp015_5 0 {C_RBL}   $ ASSUMPTION: ideal matched dummy load
XMN1_sp015_5 rbl_sp015_5 ref_sp015_5 vn_sp015_5 0 sky130_fd_pr__nfet_01v8 L=0.15 W=1 nf=1 ad=0.29 as=0.29 pd=2.58 ps=2.58 nrd=0.29 nrs=0.29 sa=0 sb=0 sd=0 mult=1 m=1
XMN2_sp015_5 ref_sp015_5 rbl_sp015_5 vn_sp015_5 0 sky130_fd_pr__nfet_01v8 L=0.15 W=1 nf=1 ad=0.29 as=0.29 pd=2.58 ps=2.58 nrd=0.29 nrs=0.29 sa=0 sb=0 sd=0 mult=1 m=1
XMP1_sp015_5 rbl_sp015_5 ref_sp015_5 vp_sp015_5 vdd sky130_fd_pr__pfet_01v8 L=0.15 W=2 nf=1 ad=0.58 as=0.58 pd=4.58 ps=4.58 nrd=0.145 nrs=0.145 sa=0 sb=0 sd=0 mult=1 m=1
XMP2_sp015_5 ref_sp015_5 rbl_sp015_5 vp_sp015_5 vdd sky130_fd_pr__pfet_01v8 L=0.15 W=2 nf=1 ad=0.58 as=0.58 pd=4.58 ps=4.58 nrd=0.145 nrs=0.145 sa=0 sb=0 sd=0 mult=1 m=1
XMNF_sp015_5 vn_sp015_5 en 0 0 sky130_fd_pr__nfet_01v8 L=0.15 W=2 nf=1 ad=0.58 as=0.58 pd=4.58 ps=4.58 nrd=0.145 nrs=0.145 sa=0 sb=0 sd=0 mult=1 m=1
XMPH_sp015_5 vp_sp015_5 enb vdd vdd sky130_fd_pr__pfet_01v8 L=0.15 W=4 nf=1 ad=1.16 as=1.16 pd=8.58 ps=8.58 nrd=0.0725 nrs=0.0725 sa=0 sb=0 sd=0 mult=1 m=1
bd_sp015_5 d_sp015_5 0 v=v(rbl_sp015_5)-v(ref_sp015_5)
bdabs_sp015_5 dabs_sp015_5 0 v=abs(v(rbl_sp015_5)-v(ref_sp015_5))

* ---- sm015_0: d = -15 mV, replica 0 ----
spa_sm015_0 pa_m015 rbl_sm015_0 ctl 0 swpre
crbl_sm015_0 rbl_sm015_0 0 {C_RBL}
spr_sm015_0 pref_100 ref_sm015_0 ctl 0 swpre
cref_sm015_0 ref_sm015_0 0 {C_RBL}   $ ASSUMPTION: ideal matched dummy load
XMN1_sm015_0 rbl_sm015_0 ref_sm015_0 vn_sm015_0 0 sky130_fd_pr__nfet_01v8 L=0.15 W=1 nf=1 ad=0.29 as=0.29 pd=2.58 ps=2.58 nrd=0.29 nrs=0.29 sa=0 sb=0 sd=0 mult=1 m=1
XMN2_sm015_0 ref_sm015_0 rbl_sm015_0 vn_sm015_0 0 sky130_fd_pr__nfet_01v8 L=0.15 W=1 nf=1 ad=0.29 as=0.29 pd=2.58 ps=2.58 nrd=0.29 nrs=0.29 sa=0 sb=0 sd=0 mult=1 m=1
XMP1_sm015_0 rbl_sm015_0 ref_sm015_0 vp_sm015_0 vdd sky130_fd_pr__pfet_01v8 L=0.15 W=2 nf=1 ad=0.58 as=0.58 pd=4.58 ps=4.58 nrd=0.145 nrs=0.145 sa=0 sb=0 sd=0 mult=1 m=1
XMP2_sm015_0 ref_sm015_0 rbl_sm015_0 vp_sm015_0 vdd sky130_fd_pr__pfet_01v8 L=0.15 W=2 nf=1 ad=0.58 as=0.58 pd=4.58 ps=4.58 nrd=0.145 nrs=0.145 sa=0 sb=0 sd=0 mult=1 m=1
XMNF_sm015_0 vn_sm015_0 en 0 0 sky130_fd_pr__nfet_01v8 L=0.15 W=2 nf=1 ad=0.58 as=0.58 pd=4.58 ps=4.58 nrd=0.145 nrs=0.145 sa=0 sb=0 sd=0 mult=1 m=1
XMPH_sm015_0 vp_sm015_0 enb vdd vdd sky130_fd_pr__pfet_01v8 L=0.15 W=4 nf=1 ad=1.16 as=1.16 pd=8.58 ps=8.58 nrd=0.0725 nrs=0.0725 sa=0 sb=0 sd=0 mult=1 m=1
bd_sm015_0 d_sm015_0 0 v=v(rbl_sm015_0)-v(ref_sm015_0)
bdabs_sm015_0 dabs_sm015_0 0 v=abs(v(rbl_sm015_0)-v(ref_sm015_0))

* ---- sm015_1: d = -15 mV, replica 1 ----
spa_sm015_1 pa_m015 rbl_sm015_1 ctl 0 swpre
crbl_sm015_1 rbl_sm015_1 0 {C_RBL}
spr_sm015_1 pref_100 ref_sm015_1 ctl 0 swpre
cref_sm015_1 ref_sm015_1 0 {C_RBL}   $ ASSUMPTION: ideal matched dummy load
XMN1_sm015_1 rbl_sm015_1 ref_sm015_1 vn_sm015_1 0 sky130_fd_pr__nfet_01v8 L=0.15 W=1 nf=1 ad=0.29 as=0.29 pd=2.58 ps=2.58 nrd=0.29 nrs=0.29 sa=0 sb=0 sd=0 mult=1 m=1
XMN2_sm015_1 ref_sm015_1 rbl_sm015_1 vn_sm015_1 0 sky130_fd_pr__nfet_01v8 L=0.15 W=1 nf=1 ad=0.29 as=0.29 pd=2.58 ps=2.58 nrd=0.29 nrs=0.29 sa=0 sb=0 sd=0 mult=1 m=1
XMP1_sm015_1 rbl_sm015_1 ref_sm015_1 vp_sm015_1 vdd sky130_fd_pr__pfet_01v8 L=0.15 W=2 nf=1 ad=0.58 as=0.58 pd=4.58 ps=4.58 nrd=0.145 nrs=0.145 sa=0 sb=0 sd=0 mult=1 m=1
XMP2_sm015_1 ref_sm015_1 rbl_sm015_1 vp_sm015_1 vdd sky130_fd_pr__pfet_01v8 L=0.15 W=2 nf=1 ad=0.58 as=0.58 pd=4.58 ps=4.58 nrd=0.145 nrs=0.145 sa=0 sb=0 sd=0 mult=1 m=1
XMNF_sm015_1 vn_sm015_1 en 0 0 sky130_fd_pr__nfet_01v8 L=0.15 W=2 nf=1 ad=0.58 as=0.58 pd=4.58 ps=4.58 nrd=0.145 nrs=0.145 sa=0 sb=0 sd=0 mult=1 m=1
XMPH_sm015_1 vp_sm015_1 enb vdd vdd sky130_fd_pr__pfet_01v8 L=0.15 W=4 nf=1 ad=1.16 as=1.16 pd=8.58 ps=8.58 nrd=0.0725 nrs=0.0725 sa=0 sb=0 sd=0 mult=1 m=1
bd_sm015_1 d_sm015_1 0 v=v(rbl_sm015_1)-v(ref_sm015_1)
bdabs_sm015_1 dabs_sm015_1 0 v=abs(v(rbl_sm015_1)-v(ref_sm015_1))

* ---- sm015_2: d = -15 mV, replica 2 ----
spa_sm015_2 pa_m015 rbl_sm015_2 ctl 0 swpre
crbl_sm015_2 rbl_sm015_2 0 {C_RBL}
spr_sm015_2 pref_100 ref_sm015_2 ctl 0 swpre
cref_sm015_2 ref_sm015_2 0 {C_RBL}   $ ASSUMPTION: ideal matched dummy load
XMN1_sm015_2 rbl_sm015_2 ref_sm015_2 vn_sm015_2 0 sky130_fd_pr__nfet_01v8 L=0.15 W=1 nf=1 ad=0.29 as=0.29 pd=2.58 ps=2.58 nrd=0.29 nrs=0.29 sa=0 sb=0 sd=0 mult=1 m=1
XMN2_sm015_2 ref_sm015_2 rbl_sm015_2 vn_sm015_2 0 sky130_fd_pr__nfet_01v8 L=0.15 W=1 nf=1 ad=0.29 as=0.29 pd=2.58 ps=2.58 nrd=0.29 nrs=0.29 sa=0 sb=0 sd=0 mult=1 m=1
XMP1_sm015_2 rbl_sm015_2 ref_sm015_2 vp_sm015_2 vdd sky130_fd_pr__pfet_01v8 L=0.15 W=2 nf=1 ad=0.58 as=0.58 pd=4.58 ps=4.58 nrd=0.145 nrs=0.145 sa=0 sb=0 sd=0 mult=1 m=1
XMP2_sm015_2 ref_sm015_2 rbl_sm015_2 vp_sm015_2 vdd sky130_fd_pr__pfet_01v8 L=0.15 W=2 nf=1 ad=0.58 as=0.58 pd=4.58 ps=4.58 nrd=0.145 nrs=0.145 sa=0 sb=0 sd=0 mult=1 m=1
XMNF_sm015_2 vn_sm015_2 en 0 0 sky130_fd_pr__nfet_01v8 L=0.15 W=2 nf=1 ad=0.58 as=0.58 pd=4.58 ps=4.58 nrd=0.145 nrs=0.145 sa=0 sb=0 sd=0 mult=1 m=1
XMPH_sm015_2 vp_sm015_2 enb vdd vdd sky130_fd_pr__pfet_01v8 L=0.15 W=4 nf=1 ad=1.16 as=1.16 pd=8.58 ps=8.58 nrd=0.0725 nrs=0.0725 sa=0 sb=0 sd=0 mult=1 m=1
bd_sm015_2 d_sm015_2 0 v=v(rbl_sm015_2)-v(ref_sm015_2)
bdabs_sm015_2 dabs_sm015_2 0 v=abs(v(rbl_sm015_2)-v(ref_sm015_2))

* ---- sm015_3: d = -15 mV, replica 3 ----
spa_sm015_3 pa_m015 rbl_sm015_3 ctl 0 swpre
crbl_sm015_3 rbl_sm015_3 0 {C_RBL}
spr_sm015_3 pref_100 ref_sm015_3 ctl 0 swpre
cref_sm015_3 ref_sm015_3 0 {C_RBL}   $ ASSUMPTION: ideal matched dummy load
XMN1_sm015_3 rbl_sm015_3 ref_sm015_3 vn_sm015_3 0 sky130_fd_pr__nfet_01v8 L=0.15 W=1 nf=1 ad=0.29 as=0.29 pd=2.58 ps=2.58 nrd=0.29 nrs=0.29 sa=0 sb=0 sd=0 mult=1 m=1
XMN2_sm015_3 ref_sm015_3 rbl_sm015_3 vn_sm015_3 0 sky130_fd_pr__nfet_01v8 L=0.15 W=1 nf=1 ad=0.29 as=0.29 pd=2.58 ps=2.58 nrd=0.29 nrs=0.29 sa=0 sb=0 sd=0 mult=1 m=1
XMP1_sm015_3 rbl_sm015_3 ref_sm015_3 vp_sm015_3 vdd sky130_fd_pr__pfet_01v8 L=0.15 W=2 nf=1 ad=0.58 as=0.58 pd=4.58 ps=4.58 nrd=0.145 nrs=0.145 sa=0 sb=0 sd=0 mult=1 m=1
XMP2_sm015_3 ref_sm015_3 rbl_sm015_3 vp_sm015_3 vdd sky130_fd_pr__pfet_01v8 L=0.15 W=2 nf=1 ad=0.58 as=0.58 pd=4.58 ps=4.58 nrd=0.145 nrs=0.145 sa=0 sb=0 sd=0 mult=1 m=1
XMNF_sm015_3 vn_sm015_3 en 0 0 sky130_fd_pr__nfet_01v8 L=0.15 W=2 nf=1 ad=0.58 as=0.58 pd=4.58 ps=4.58 nrd=0.145 nrs=0.145 sa=0 sb=0 sd=0 mult=1 m=1
XMPH_sm015_3 vp_sm015_3 enb vdd vdd sky130_fd_pr__pfet_01v8 L=0.15 W=4 nf=1 ad=1.16 as=1.16 pd=8.58 ps=8.58 nrd=0.0725 nrs=0.0725 sa=0 sb=0 sd=0 mult=1 m=1
bd_sm015_3 d_sm015_3 0 v=v(rbl_sm015_3)-v(ref_sm015_3)
bdabs_sm015_3 dabs_sm015_3 0 v=abs(v(rbl_sm015_3)-v(ref_sm015_3))

* ---- sm015_4: d = -15 mV, replica 4 ----
spa_sm015_4 pa_m015 rbl_sm015_4 ctl 0 swpre
crbl_sm015_4 rbl_sm015_4 0 {C_RBL}
spr_sm015_4 pref_100 ref_sm015_4 ctl 0 swpre
cref_sm015_4 ref_sm015_4 0 {C_RBL}   $ ASSUMPTION: ideal matched dummy load
XMN1_sm015_4 rbl_sm015_4 ref_sm015_4 vn_sm015_4 0 sky130_fd_pr__nfet_01v8 L=0.15 W=1 nf=1 ad=0.29 as=0.29 pd=2.58 ps=2.58 nrd=0.29 nrs=0.29 sa=0 sb=0 sd=0 mult=1 m=1
XMN2_sm015_4 ref_sm015_4 rbl_sm015_4 vn_sm015_4 0 sky130_fd_pr__nfet_01v8 L=0.15 W=1 nf=1 ad=0.29 as=0.29 pd=2.58 ps=2.58 nrd=0.29 nrs=0.29 sa=0 sb=0 sd=0 mult=1 m=1
XMP1_sm015_4 rbl_sm015_4 ref_sm015_4 vp_sm015_4 vdd sky130_fd_pr__pfet_01v8 L=0.15 W=2 nf=1 ad=0.58 as=0.58 pd=4.58 ps=4.58 nrd=0.145 nrs=0.145 sa=0 sb=0 sd=0 mult=1 m=1
XMP2_sm015_4 ref_sm015_4 rbl_sm015_4 vp_sm015_4 vdd sky130_fd_pr__pfet_01v8 L=0.15 W=2 nf=1 ad=0.58 as=0.58 pd=4.58 ps=4.58 nrd=0.145 nrs=0.145 sa=0 sb=0 sd=0 mult=1 m=1
XMNF_sm015_4 vn_sm015_4 en 0 0 sky130_fd_pr__nfet_01v8 L=0.15 W=2 nf=1 ad=0.58 as=0.58 pd=4.58 ps=4.58 nrd=0.145 nrs=0.145 sa=0 sb=0 sd=0 mult=1 m=1
XMPH_sm015_4 vp_sm015_4 enb vdd vdd sky130_fd_pr__pfet_01v8 L=0.15 W=4 nf=1 ad=1.16 as=1.16 pd=8.58 ps=8.58 nrd=0.0725 nrs=0.0725 sa=0 sb=0 sd=0 mult=1 m=1
bd_sm015_4 d_sm015_4 0 v=v(rbl_sm015_4)-v(ref_sm015_4)
bdabs_sm015_4 dabs_sm015_4 0 v=abs(v(rbl_sm015_4)-v(ref_sm015_4))

* ---- sm015_5: d = -15 mV, replica 5 ----
spa_sm015_5 pa_m015 rbl_sm015_5 ctl 0 swpre
crbl_sm015_5 rbl_sm015_5 0 {C_RBL}
spr_sm015_5 pref_100 ref_sm015_5 ctl 0 swpre
cref_sm015_5 ref_sm015_5 0 {C_RBL}   $ ASSUMPTION: ideal matched dummy load
XMN1_sm015_5 rbl_sm015_5 ref_sm015_5 vn_sm015_5 0 sky130_fd_pr__nfet_01v8 L=0.15 W=1 nf=1 ad=0.29 as=0.29 pd=2.58 ps=2.58 nrd=0.29 nrs=0.29 sa=0 sb=0 sd=0 mult=1 m=1
XMN2_sm015_5 ref_sm015_5 rbl_sm015_5 vn_sm015_5 0 sky130_fd_pr__nfet_01v8 L=0.15 W=1 nf=1 ad=0.29 as=0.29 pd=2.58 ps=2.58 nrd=0.29 nrs=0.29 sa=0 sb=0 sd=0 mult=1 m=1
XMP1_sm015_5 rbl_sm015_5 ref_sm015_5 vp_sm015_5 vdd sky130_fd_pr__pfet_01v8 L=0.15 W=2 nf=1 ad=0.58 as=0.58 pd=4.58 ps=4.58 nrd=0.145 nrs=0.145 sa=0 sb=0 sd=0 mult=1 m=1
XMP2_sm015_5 ref_sm015_5 rbl_sm015_5 vp_sm015_5 vdd sky130_fd_pr__pfet_01v8 L=0.15 W=2 nf=1 ad=0.58 as=0.58 pd=4.58 ps=4.58 nrd=0.145 nrs=0.145 sa=0 sb=0 sd=0 mult=1 m=1
XMNF_sm015_5 vn_sm015_5 en 0 0 sky130_fd_pr__nfet_01v8 L=0.15 W=2 nf=1 ad=0.58 as=0.58 pd=4.58 ps=4.58 nrd=0.145 nrs=0.145 sa=0 sb=0 sd=0 mult=1 m=1
XMPH_sm015_5 vp_sm015_5 enb vdd vdd sky130_fd_pr__pfet_01v8 L=0.15 W=4 nf=1 ad=1.16 as=1.16 pd=8.58 ps=8.58 nrd=0.0725 nrs=0.0725 sa=0 sb=0 sd=0 mult=1 m=1
bd_sm015_5 d_sm015_5 0 v=v(rbl_sm015_5)-v(ref_sm015_5)
bdabs_sm015_5 dabs_sm015_5 0 v=abs(v(rbl_sm015_5)-v(ref_sm015_5))

* ---- sp020_0: d = 20 mV, replica 0 ----
spa_sp020_0 pa_p020 rbl_sp020_0 ctl 0 swpre
crbl_sp020_0 rbl_sp020_0 0 {C_RBL}
spr_sp020_0 pref_100 ref_sp020_0 ctl 0 swpre
cref_sp020_0 ref_sp020_0 0 {C_RBL}   $ ASSUMPTION: ideal matched dummy load
XMN1_sp020_0 rbl_sp020_0 ref_sp020_0 vn_sp020_0 0 sky130_fd_pr__nfet_01v8 L=0.15 W=1 nf=1 ad=0.29 as=0.29 pd=2.58 ps=2.58 nrd=0.29 nrs=0.29 sa=0 sb=0 sd=0 mult=1 m=1
XMN2_sp020_0 ref_sp020_0 rbl_sp020_0 vn_sp020_0 0 sky130_fd_pr__nfet_01v8 L=0.15 W=1 nf=1 ad=0.29 as=0.29 pd=2.58 ps=2.58 nrd=0.29 nrs=0.29 sa=0 sb=0 sd=0 mult=1 m=1
XMP1_sp020_0 rbl_sp020_0 ref_sp020_0 vp_sp020_0 vdd sky130_fd_pr__pfet_01v8 L=0.15 W=2 nf=1 ad=0.58 as=0.58 pd=4.58 ps=4.58 nrd=0.145 nrs=0.145 sa=0 sb=0 sd=0 mult=1 m=1
XMP2_sp020_0 ref_sp020_0 rbl_sp020_0 vp_sp020_0 vdd sky130_fd_pr__pfet_01v8 L=0.15 W=2 nf=1 ad=0.58 as=0.58 pd=4.58 ps=4.58 nrd=0.145 nrs=0.145 sa=0 sb=0 sd=0 mult=1 m=1
XMNF_sp020_0 vn_sp020_0 en 0 0 sky130_fd_pr__nfet_01v8 L=0.15 W=2 nf=1 ad=0.58 as=0.58 pd=4.58 ps=4.58 nrd=0.145 nrs=0.145 sa=0 sb=0 sd=0 mult=1 m=1
XMPH_sp020_0 vp_sp020_0 enb vdd vdd sky130_fd_pr__pfet_01v8 L=0.15 W=4 nf=1 ad=1.16 as=1.16 pd=8.58 ps=8.58 nrd=0.0725 nrs=0.0725 sa=0 sb=0 sd=0 mult=1 m=1
bd_sp020_0 d_sp020_0 0 v=v(rbl_sp020_0)-v(ref_sp020_0)
bdabs_sp020_0 dabs_sp020_0 0 v=abs(v(rbl_sp020_0)-v(ref_sp020_0))

* ---- sp020_1: d = 20 mV, replica 1 ----
spa_sp020_1 pa_p020 rbl_sp020_1 ctl 0 swpre
crbl_sp020_1 rbl_sp020_1 0 {C_RBL}
spr_sp020_1 pref_100 ref_sp020_1 ctl 0 swpre
cref_sp020_1 ref_sp020_1 0 {C_RBL}   $ ASSUMPTION: ideal matched dummy load
XMN1_sp020_1 rbl_sp020_1 ref_sp020_1 vn_sp020_1 0 sky130_fd_pr__nfet_01v8 L=0.15 W=1 nf=1 ad=0.29 as=0.29 pd=2.58 ps=2.58 nrd=0.29 nrs=0.29 sa=0 sb=0 sd=0 mult=1 m=1
XMN2_sp020_1 ref_sp020_1 rbl_sp020_1 vn_sp020_1 0 sky130_fd_pr__nfet_01v8 L=0.15 W=1 nf=1 ad=0.29 as=0.29 pd=2.58 ps=2.58 nrd=0.29 nrs=0.29 sa=0 sb=0 sd=0 mult=1 m=1
XMP1_sp020_1 rbl_sp020_1 ref_sp020_1 vp_sp020_1 vdd sky130_fd_pr__pfet_01v8 L=0.15 W=2 nf=1 ad=0.58 as=0.58 pd=4.58 ps=4.58 nrd=0.145 nrs=0.145 sa=0 sb=0 sd=0 mult=1 m=1
XMP2_sp020_1 ref_sp020_1 rbl_sp020_1 vp_sp020_1 vdd sky130_fd_pr__pfet_01v8 L=0.15 W=2 nf=1 ad=0.58 as=0.58 pd=4.58 ps=4.58 nrd=0.145 nrs=0.145 sa=0 sb=0 sd=0 mult=1 m=1
XMNF_sp020_1 vn_sp020_1 en 0 0 sky130_fd_pr__nfet_01v8 L=0.15 W=2 nf=1 ad=0.58 as=0.58 pd=4.58 ps=4.58 nrd=0.145 nrs=0.145 sa=0 sb=0 sd=0 mult=1 m=1
XMPH_sp020_1 vp_sp020_1 enb vdd vdd sky130_fd_pr__pfet_01v8 L=0.15 W=4 nf=1 ad=1.16 as=1.16 pd=8.58 ps=8.58 nrd=0.0725 nrs=0.0725 sa=0 sb=0 sd=0 mult=1 m=1
bd_sp020_1 d_sp020_1 0 v=v(rbl_sp020_1)-v(ref_sp020_1)
bdabs_sp020_1 dabs_sp020_1 0 v=abs(v(rbl_sp020_1)-v(ref_sp020_1))

* ---- sp020_2: d = 20 mV, replica 2 ----
spa_sp020_2 pa_p020 rbl_sp020_2 ctl 0 swpre
crbl_sp020_2 rbl_sp020_2 0 {C_RBL}
spr_sp020_2 pref_100 ref_sp020_2 ctl 0 swpre
cref_sp020_2 ref_sp020_2 0 {C_RBL}   $ ASSUMPTION: ideal matched dummy load
XMN1_sp020_2 rbl_sp020_2 ref_sp020_2 vn_sp020_2 0 sky130_fd_pr__nfet_01v8 L=0.15 W=1 nf=1 ad=0.29 as=0.29 pd=2.58 ps=2.58 nrd=0.29 nrs=0.29 sa=0 sb=0 sd=0 mult=1 m=1
XMN2_sp020_2 ref_sp020_2 rbl_sp020_2 vn_sp020_2 0 sky130_fd_pr__nfet_01v8 L=0.15 W=1 nf=1 ad=0.29 as=0.29 pd=2.58 ps=2.58 nrd=0.29 nrs=0.29 sa=0 sb=0 sd=0 mult=1 m=1
XMP1_sp020_2 rbl_sp020_2 ref_sp020_2 vp_sp020_2 vdd sky130_fd_pr__pfet_01v8 L=0.15 W=2 nf=1 ad=0.58 as=0.58 pd=4.58 ps=4.58 nrd=0.145 nrs=0.145 sa=0 sb=0 sd=0 mult=1 m=1
XMP2_sp020_2 ref_sp020_2 rbl_sp020_2 vp_sp020_2 vdd sky130_fd_pr__pfet_01v8 L=0.15 W=2 nf=1 ad=0.58 as=0.58 pd=4.58 ps=4.58 nrd=0.145 nrs=0.145 sa=0 sb=0 sd=0 mult=1 m=1
XMNF_sp020_2 vn_sp020_2 en 0 0 sky130_fd_pr__nfet_01v8 L=0.15 W=2 nf=1 ad=0.58 as=0.58 pd=4.58 ps=4.58 nrd=0.145 nrs=0.145 sa=0 sb=0 sd=0 mult=1 m=1
XMPH_sp020_2 vp_sp020_2 enb vdd vdd sky130_fd_pr__pfet_01v8 L=0.15 W=4 nf=1 ad=1.16 as=1.16 pd=8.58 ps=8.58 nrd=0.0725 nrs=0.0725 sa=0 sb=0 sd=0 mult=1 m=1
bd_sp020_2 d_sp020_2 0 v=v(rbl_sp020_2)-v(ref_sp020_2)
bdabs_sp020_2 dabs_sp020_2 0 v=abs(v(rbl_sp020_2)-v(ref_sp020_2))

* ---- sp020_3: d = 20 mV, replica 3 ----
spa_sp020_3 pa_p020 rbl_sp020_3 ctl 0 swpre
crbl_sp020_3 rbl_sp020_3 0 {C_RBL}
spr_sp020_3 pref_100 ref_sp020_3 ctl 0 swpre
cref_sp020_3 ref_sp020_3 0 {C_RBL}   $ ASSUMPTION: ideal matched dummy load
XMN1_sp020_3 rbl_sp020_3 ref_sp020_3 vn_sp020_3 0 sky130_fd_pr__nfet_01v8 L=0.15 W=1 nf=1 ad=0.29 as=0.29 pd=2.58 ps=2.58 nrd=0.29 nrs=0.29 sa=0 sb=0 sd=0 mult=1 m=1
XMN2_sp020_3 ref_sp020_3 rbl_sp020_3 vn_sp020_3 0 sky130_fd_pr__nfet_01v8 L=0.15 W=1 nf=1 ad=0.29 as=0.29 pd=2.58 ps=2.58 nrd=0.29 nrs=0.29 sa=0 sb=0 sd=0 mult=1 m=1
XMP1_sp020_3 rbl_sp020_3 ref_sp020_3 vp_sp020_3 vdd sky130_fd_pr__pfet_01v8 L=0.15 W=2 nf=1 ad=0.58 as=0.58 pd=4.58 ps=4.58 nrd=0.145 nrs=0.145 sa=0 sb=0 sd=0 mult=1 m=1
XMP2_sp020_3 ref_sp020_3 rbl_sp020_3 vp_sp020_3 vdd sky130_fd_pr__pfet_01v8 L=0.15 W=2 nf=1 ad=0.58 as=0.58 pd=4.58 ps=4.58 nrd=0.145 nrs=0.145 sa=0 sb=0 sd=0 mult=1 m=1
XMNF_sp020_3 vn_sp020_3 en 0 0 sky130_fd_pr__nfet_01v8 L=0.15 W=2 nf=1 ad=0.58 as=0.58 pd=4.58 ps=4.58 nrd=0.145 nrs=0.145 sa=0 sb=0 sd=0 mult=1 m=1
XMPH_sp020_3 vp_sp020_3 enb vdd vdd sky130_fd_pr__pfet_01v8 L=0.15 W=4 nf=1 ad=1.16 as=1.16 pd=8.58 ps=8.58 nrd=0.0725 nrs=0.0725 sa=0 sb=0 sd=0 mult=1 m=1
bd_sp020_3 d_sp020_3 0 v=v(rbl_sp020_3)-v(ref_sp020_3)
bdabs_sp020_3 dabs_sp020_3 0 v=abs(v(rbl_sp020_3)-v(ref_sp020_3))

* ---- sp020_4: d = 20 mV, replica 4 ----
spa_sp020_4 pa_p020 rbl_sp020_4 ctl 0 swpre
crbl_sp020_4 rbl_sp020_4 0 {C_RBL}
spr_sp020_4 pref_100 ref_sp020_4 ctl 0 swpre
cref_sp020_4 ref_sp020_4 0 {C_RBL}   $ ASSUMPTION: ideal matched dummy load
XMN1_sp020_4 rbl_sp020_4 ref_sp020_4 vn_sp020_4 0 sky130_fd_pr__nfet_01v8 L=0.15 W=1 nf=1 ad=0.29 as=0.29 pd=2.58 ps=2.58 nrd=0.29 nrs=0.29 sa=0 sb=0 sd=0 mult=1 m=1
XMN2_sp020_4 ref_sp020_4 rbl_sp020_4 vn_sp020_4 0 sky130_fd_pr__nfet_01v8 L=0.15 W=1 nf=1 ad=0.29 as=0.29 pd=2.58 ps=2.58 nrd=0.29 nrs=0.29 sa=0 sb=0 sd=0 mult=1 m=1
XMP1_sp020_4 rbl_sp020_4 ref_sp020_4 vp_sp020_4 vdd sky130_fd_pr__pfet_01v8 L=0.15 W=2 nf=1 ad=0.58 as=0.58 pd=4.58 ps=4.58 nrd=0.145 nrs=0.145 sa=0 sb=0 sd=0 mult=1 m=1
XMP2_sp020_4 ref_sp020_4 rbl_sp020_4 vp_sp020_4 vdd sky130_fd_pr__pfet_01v8 L=0.15 W=2 nf=1 ad=0.58 as=0.58 pd=4.58 ps=4.58 nrd=0.145 nrs=0.145 sa=0 sb=0 sd=0 mult=1 m=1
XMNF_sp020_4 vn_sp020_4 en 0 0 sky130_fd_pr__nfet_01v8 L=0.15 W=2 nf=1 ad=0.58 as=0.58 pd=4.58 ps=4.58 nrd=0.145 nrs=0.145 sa=0 sb=0 sd=0 mult=1 m=1
XMPH_sp020_4 vp_sp020_4 enb vdd vdd sky130_fd_pr__pfet_01v8 L=0.15 W=4 nf=1 ad=1.16 as=1.16 pd=8.58 ps=8.58 nrd=0.0725 nrs=0.0725 sa=0 sb=0 sd=0 mult=1 m=1
bd_sp020_4 d_sp020_4 0 v=v(rbl_sp020_4)-v(ref_sp020_4)
bdabs_sp020_4 dabs_sp020_4 0 v=abs(v(rbl_sp020_4)-v(ref_sp020_4))

* ---- sp020_5: d = 20 mV, replica 5 ----
spa_sp020_5 pa_p020 rbl_sp020_5 ctl 0 swpre
crbl_sp020_5 rbl_sp020_5 0 {C_RBL}
spr_sp020_5 pref_100 ref_sp020_5 ctl 0 swpre
cref_sp020_5 ref_sp020_5 0 {C_RBL}   $ ASSUMPTION: ideal matched dummy load
XMN1_sp020_5 rbl_sp020_5 ref_sp020_5 vn_sp020_5 0 sky130_fd_pr__nfet_01v8 L=0.15 W=1 nf=1 ad=0.29 as=0.29 pd=2.58 ps=2.58 nrd=0.29 nrs=0.29 sa=0 sb=0 sd=0 mult=1 m=1
XMN2_sp020_5 ref_sp020_5 rbl_sp020_5 vn_sp020_5 0 sky130_fd_pr__nfet_01v8 L=0.15 W=1 nf=1 ad=0.29 as=0.29 pd=2.58 ps=2.58 nrd=0.29 nrs=0.29 sa=0 sb=0 sd=0 mult=1 m=1
XMP1_sp020_5 rbl_sp020_5 ref_sp020_5 vp_sp020_5 vdd sky130_fd_pr__pfet_01v8 L=0.15 W=2 nf=1 ad=0.58 as=0.58 pd=4.58 ps=4.58 nrd=0.145 nrs=0.145 sa=0 sb=0 sd=0 mult=1 m=1
XMP2_sp020_5 ref_sp020_5 rbl_sp020_5 vp_sp020_5 vdd sky130_fd_pr__pfet_01v8 L=0.15 W=2 nf=1 ad=0.58 as=0.58 pd=4.58 ps=4.58 nrd=0.145 nrs=0.145 sa=0 sb=0 sd=0 mult=1 m=1
XMNF_sp020_5 vn_sp020_5 en 0 0 sky130_fd_pr__nfet_01v8 L=0.15 W=2 nf=1 ad=0.58 as=0.58 pd=4.58 ps=4.58 nrd=0.145 nrs=0.145 sa=0 sb=0 sd=0 mult=1 m=1
XMPH_sp020_5 vp_sp020_5 enb vdd vdd sky130_fd_pr__pfet_01v8 L=0.15 W=4 nf=1 ad=1.16 as=1.16 pd=8.58 ps=8.58 nrd=0.0725 nrs=0.0725 sa=0 sb=0 sd=0 mult=1 m=1
bd_sp020_5 d_sp020_5 0 v=v(rbl_sp020_5)-v(ref_sp020_5)
bdabs_sp020_5 dabs_sp020_5 0 v=abs(v(rbl_sp020_5)-v(ref_sp020_5))

* ---- sm020_0: d = -20 mV, replica 0 ----
spa_sm020_0 pa_m020 rbl_sm020_0 ctl 0 swpre
crbl_sm020_0 rbl_sm020_0 0 {C_RBL}
spr_sm020_0 pref_100 ref_sm020_0 ctl 0 swpre
cref_sm020_0 ref_sm020_0 0 {C_RBL}   $ ASSUMPTION: ideal matched dummy load
XMN1_sm020_0 rbl_sm020_0 ref_sm020_0 vn_sm020_0 0 sky130_fd_pr__nfet_01v8 L=0.15 W=1 nf=1 ad=0.29 as=0.29 pd=2.58 ps=2.58 nrd=0.29 nrs=0.29 sa=0 sb=0 sd=0 mult=1 m=1
XMN2_sm020_0 ref_sm020_0 rbl_sm020_0 vn_sm020_0 0 sky130_fd_pr__nfet_01v8 L=0.15 W=1 nf=1 ad=0.29 as=0.29 pd=2.58 ps=2.58 nrd=0.29 nrs=0.29 sa=0 sb=0 sd=0 mult=1 m=1
XMP1_sm020_0 rbl_sm020_0 ref_sm020_0 vp_sm020_0 vdd sky130_fd_pr__pfet_01v8 L=0.15 W=2 nf=1 ad=0.58 as=0.58 pd=4.58 ps=4.58 nrd=0.145 nrs=0.145 sa=0 sb=0 sd=0 mult=1 m=1
XMP2_sm020_0 ref_sm020_0 rbl_sm020_0 vp_sm020_0 vdd sky130_fd_pr__pfet_01v8 L=0.15 W=2 nf=1 ad=0.58 as=0.58 pd=4.58 ps=4.58 nrd=0.145 nrs=0.145 sa=0 sb=0 sd=0 mult=1 m=1
XMNF_sm020_0 vn_sm020_0 en 0 0 sky130_fd_pr__nfet_01v8 L=0.15 W=2 nf=1 ad=0.58 as=0.58 pd=4.58 ps=4.58 nrd=0.145 nrs=0.145 sa=0 sb=0 sd=0 mult=1 m=1
XMPH_sm020_0 vp_sm020_0 enb vdd vdd sky130_fd_pr__pfet_01v8 L=0.15 W=4 nf=1 ad=1.16 as=1.16 pd=8.58 ps=8.58 nrd=0.0725 nrs=0.0725 sa=0 sb=0 sd=0 mult=1 m=1
bd_sm020_0 d_sm020_0 0 v=v(rbl_sm020_0)-v(ref_sm020_0)
bdabs_sm020_0 dabs_sm020_0 0 v=abs(v(rbl_sm020_0)-v(ref_sm020_0))

* ---- sm020_1: d = -20 mV, replica 1 ----
spa_sm020_1 pa_m020 rbl_sm020_1 ctl 0 swpre
crbl_sm020_1 rbl_sm020_1 0 {C_RBL}
spr_sm020_1 pref_100 ref_sm020_1 ctl 0 swpre
cref_sm020_1 ref_sm020_1 0 {C_RBL}   $ ASSUMPTION: ideal matched dummy load
XMN1_sm020_1 rbl_sm020_1 ref_sm020_1 vn_sm020_1 0 sky130_fd_pr__nfet_01v8 L=0.15 W=1 nf=1 ad=0.29 as=0.29 pd=2.58 ps=2.58 nrd=0.29 nrs=0.29 sa=0 sb=0 sd=0 mult=1 m=1
XMN2_sm020_1 ref_sm020_1 rbl_sm020_1 vn_sm020_1 0 sky130_fd_pr__nfet_01v8 L=0.15 W=1 nf=1 ad=0.29 as=0.29 pd=2.58 ps=2.58 nrd=0.29 nrs=0.29 sa=0 sb=0 sd=0 mult=1 m=1
XMP1_sm020_1 rbl_sm020_1 ref_sm020_1 vp_sm020_1 vdd sky130_fd_pr__pfet_01v8 L=0.15 W=2 nf=1 ad=0.58 as=0.58 pd=4.58 ps=4.58 nrd=0.145 nrs=0.145 sa=0 sb=0 sd=0 mult=1 m=1
XMP2_sm020_1 ref_sm020_1 rbl_sm020_1 vp_sm020_1 vdd sky130_fd_pr__pfet_01v8 L=0.15 W=2 nf=1 ad=0.58 as=0.58 pd=4.58 ps=4.58 nrd=0.145 nrs=0.145 sa=0 sb=0 sd=0 mult=1 m=1
XMNF_sm020_1 vn_sm020_1 en 0 0 sky130_fd_pr__nfet_01v8 L=0.15 W=2 nf=1 ad=0.58 as=0.58 pd=4.58 ps=4.58 nrd=0.145 nrs=0.145 sa=0 sb=0 sd=0 mult=1 m=1
XMPH_sm020_1 vp_sm020_1 enb vdd vdd sky130_fd_pr__pfet_01v8 L=0.15 W=4 nf=1 ad=1.16 as=1.16 pd=8.58 ps=8.58 nrd=0.0725 nrs=0.0725 sa=0 sb=0 sd=0 mult=1 m=1
bd_sm020_1 d_sm020_1 0 v=v(rbl_sm020_1)-v(ref_sm020_1)
bdabs_sm020_1 dabs_sm020_1 0 v=abs(v(rbl_sm020_1)-v(ref_sm020_1))

* ---- sm020_2: d = -20 mV, replica 2 ----
spa_sm020_2 pa_m020 rbl_sm020_2 ctl 0 swpre
crbl_sm020_2 rbl_sm020_2 0 {C_RBL}
spr_sm020_2 pref_100 ref_sm020_2 ctl 0 swpre
cref_sm020_2 ref_sm020_2 0 {C_RBL}   $ ASSUMPTION: ideal matched dummy load
XMN1_sm020_2 rbl_sm020_2 ref_sm020_2 vn_sm020_2 0 sky130_fd_pr__nfet_01v8 L=0.15 W=1 nf=1 ad=0.29 as=0.29 pd=2.58 ps=2.58 nrd=0.29 nrs=0.29 sa=0 sb=0 sd=0 mult=1 m=1
XMN2_sm020_2 ref_sm020_2 rbl_sm020_2 vn_sm020_2 0 sky130_fd_pr__nfet_01v8 L=0.15 W=1 nf=1 ad=0.29 as=0.29 pd=2.58 ps=2.58 nrd=0.29 nrs=0.29 sa=0 sb=0 sd=0 mult=1 m=1
XMP1_sm020_2 rbl_sm020_2 ref_sm020_2 vp_sm020_2 vdd sky130_fd_pr__pfet_01v8 L=0.15 W=2 nf=1 ad=0.58 as=0.58 pd=4.58 ps=4.58 nrd=0.145 nrs=0.145 sa=0 sb=0 sd=0 mult=1 m=1
XMP2_sm020_2 ref_sm020_2 rbl_sm020_2 vp_sm020_2 vdd sky130_fd_pr__pfet_01v8 L=0.15 W=2 nf=1 ad=0.58 as=0.58 pd=4.58 ps=4.58 nrd=0.145 nrs=0.145 sa=0 sb=0 sd=0 mult=1 m=1
XMNF_sm020_2 vn_sm020_2 en 0 0 sky130_fd_pr__nfet_01v8 L=0.15 W=2 nf=1 ad=0.58 as=0.58 pd=4.58 ps=4.58 nrd=0.145 nrs=0.145 sa=0 sb=0 sd=0 mult=1 m=1
XMPH_sm020_2 vp_sm020_2 enb vdd vdd sky130_fd_pr__pfet_01v8 L=0.15 W=4 nf=1 ad=1.16 as=1.16 pd=8.58 ps=8.58 nrd=0.0725 nrs=0.0725 sa=0 sb=0 sd=0 mult=1 m=1
bd_sm020_2 d_sm020_2 0 v=v(rbl_sm020_2)-v(ref_sm020_2)
bdabs_sm020_2 dabs_sm020_2 0 v=abs(v(rbl_sm020_2)-v(ref_sm020_2))

* ---- sm020_3: d = -20 mV, replica 3 ----
spa_sm020_3 pa_m020 rbl_sm020_3 ctl 0 swpre
crbl_sm020_3 rbl_sm020_3 0 {C_RBL}
spr_sm020_3 pref_100 ref_sm020_3 ctl 0 swpre
cref_sm020_3 ref_sm020_3 0 {C_RBL}   $ ASSUMPTION: ideal matched dummy load
XMN1_sm020_3 rbl_sm020_3 ref_sm020_3 vn_sm020_3 0 sky130_fd_pr__nfet_01v8 L=0.15 W=1 nf=1 ad=0.29 as=0.29 pd=2.58 ps=2.58 nrd=0.29 nrs=0.29 sa=0 sb=0 sd=0 mult=1 m=1
XMN2_sm020_3 ref_sm020_3 rbl_sm020_3 vn_sm020_3 0 sky130_fd_pr__nfet_01v8 L=0.15 W=1 nf=1 ad=0.29 as=0.29 pd=2.58 ps=2.58 nrd=0.29 nrs=0.29 sa=0 sb=0 sd=0 mult=1 m=1
XMP1_sm020_3 rbl_sm020_3 ref_sm020_3 vp_sm020_3 vdd sky130_fd_pr__pfet_01v8 L=0.15 W=2 nf=1 ad=0.58 as=0.58 pd=4.58 ps=4.58 nrd=0.145 nrs=0.145 sa=0 sb=0 sd=0 mult=1 m=1
XMP2_sm020_3 ref_sm020_3 rbl_sm020_3 vp_sm020_3 vdd sky130_fd_pr__pfet_01v8 L=0.15 W=2 nf=1 ad=0.58 as=0.58 pd=4.58 ps=4.58 nrd=0.145 nrs=0.145 sa=0 sb=0 sd=0 mult=1 m=1
XMNF_sm020_3 vn_sm020_3 en 0 0 sky130_fd_pr__nfet_01v8 L=0.15 W=2 nf=1 ad=0.58 as=0.58 pd=4.58 ps=4.58 nrd=0.145 nrs=0.145 sa=0 sb=0 sd=0 mult=1 m=1
XMPH_sm020_3 vp_sm020_3 enb vdd vdd sky130_fd_pr__pfet_01v8 L=0.15 W=4 nf=1 ad=1.16 as=1.16 pd=8.58 ps=8.58 nrd=0.0725 nrs=0.0725 sa=0 sb=0 sd=0 mult=1 m=1
bd_sm020_3 d_sm020_3 0 v=v(rbl_sm020_3)-v(ref_sm020_3)
bdabs_sm020_3 dabs_sm020_3 0 v=abs(v(rbl_sm020_3)-v(ref_sm020_3))

* ---- sm020_4: d = -20 mV, replica 4 ----
spa_sm020_4 pa_m020 rbl_sm020_4 ctl 0 swpre
crbl_sm020_4 rbl_sm020_4 0 {C_RBL}
spr_sm020_4 pref_100 ref_sm020_4 ctl 0 swpre
cref_sm020_4 ref_sm020_4 0 {C_RBL}   $ ASSUMPTION: ideal matched dummy load
XMN1_sm020_4 rbl_sm020_4 ref_sm020_4 vn_sm020_4 0 sky130_fd_pr__nfet_01v8 L=0.15 W=1 nf=1 ad=0.29 as=0.29 pd=2.58 ps=2.58 nrd=0.29 nrs=0.29 sa=0 sb=0 sd=0 mult=1 m=1
XMN2_sm020_4 ref_sm020_4 rbl_sm020_4 vn_sm020_4 0 sky130_fd_pr__nfet_01v8 L=0.15 W=1 nf=1 ad=0.29 as=0.29 pd=2.58 ps=2.58 nrd=0.29 nrs=0.29 sa=0 sb=0 sd=0 mult=1 m=1
XMP1_sm020_4 rbl_sm020_4 ref_sm020_4 vp_sm020_4 vdd sky130_fd_pr__pfet_01v8 L=0.15 W=2 nf=1 ad=0.58 as=0.58 pd=4.58 ps=4.58 nrd=0.145 nrs=0.145 sa=0 sb=0 sd=0 mult=1 m=1
XMP2_sm020_4 ref_sm020_4 rbl_sm020_4 vp_sm020_4 vdd sky130_fd_pr__pfet_01v8 L=0.15 W=2 nf=1 ad=0.58 as=0.58 pd=4.58 ps=4.58 nrd=0.145 nrs=0.145 sa=0 sb=0 sd=0 mult=1 m=1
XMNF_sm020_4 vn_sm020_4 en 0 0 sky130_fd_pr__nfet_01v8 L=0.15 W=2 nf=1 ad=0.58 as=0.58 pd=4.58 ps=4.58 nrd=0.145 nrs=0.145 sa=0 sb=0 sd=0 mult=1 m=1
XMPH_sm020_4 vp_sm020_4 enb vdd vdd sky130_fd_pr__pfet_01v8 L=0.15 W=4 nf=1 ad=1.16 as=1.16 pd=8.58 ps=8.58 nrd=0.0725 nrs=0.0725 sa=0 sb=0 sd=0 mult=1 m=1
bd_sm020_4 d_sm020_4 0 v=v(rbl_sm020_4)-v(ref_sm020_4)
bdabs_sm020_4 dabs_sm020_4 0 v=abs(v(rbl_sm020_4)-v(ref_sm020_4))

* ---- sm020_5: d = -20 mV, replica 5 ----
spa_sm020_5 pa_m020 rbl_sm020_5 ctl 0 swpre
crbl_sm020_5 rbl_sm020_5 0 {C_RBL}
spr_sm020_5 pref_100 ref_sm020_5 ctl 0 swpre
cref_sm020_5 ref_sm020_5 0 {C_RBL}   $ ASSUMPTION: ideal matched dummy load
XMN1_sm020_5 rbl_sm020_5 ref_sm020_5 vn_sm020_5 0 sky130_fd_pr__nfet_01v8 L=0.15 W=1 nf=1 ad=0.29 as=0.29 pd=2.58 ps=2.58 nrd=0.29 nrs=0.29 sa=0 sb=0 sd=0 mult=1 m=1
XMN2_sm020_5 ref_sm020_5 rbl_sm020_5 vn_sm020_5 0 sky130_fd_pr__nfet_01v8 L=0.15 W=1 nf=1 ad=0.29 as=0.29 pd=2.58 ps=2.58 nrd=0.29 nrs=0.29 sa=0 sb=0 sd=0 mult=1 m=1
XMP1_sm020_5 rbl_sm020_5 ref_sm020_5 vp_sm020_5 vdd sky130_fd_pr__pfet_01v8 L=0.15 W=2 nf=1 ad=0.58 as=0.58 pd=4.58 ps=4.58 nrd=0.145 nrs=0.145 sa=0 sb=0 sd=0 mult=1 m=1
XMP2_sm020_5 ref_sm020_5 rbl_sm020_5 vp_sm020_5 vdd sky130_fd_pr__pfet_01v8 L=0.15 W=2 nf=1 ad=0.58 as=0.58 pd=4.58 ps=4.58 nrd=0.145 nrs=0.145 sa=0 sb=0 sd=0 mult=1 m=1
XMNF_sm020_5 vn_sm020_5 en 0 0 sky130_fd_pr__nfet_01v8 L=0.15 W=2 nf=1 ad=0.58 as=0.58 pd=4.58 ps=4.58 nrd=0.145 nrs=0.145 sa=0 sb=0 sd=0 mult=1 m=1
XMPH_sm020_5 vp_sm020_5 enb vdd vdd sky130_fd_pr__pfet_01v8 L=0.15 W=4 nf=1 ad=1.16 as=1.16 pd=8.58 ps=8.58 nrd=0.0725 nrs=0.0725 sa=0 sb=0 sd=0 mult=1 m=1
bd_sm020_5 d_sm020_5 0 v=v(rbl_sm020_5)-v(ref_sm020_5)
bdabs_sm020_5 dabs_sm020_5 0 v=abs(v(rbl_sm020_5)-v(ref_sm020_5))

* ---- sp030_0: d = 30 mV, replica 0 ----
spa_sp030_0 pa_p030 rbl_sp030_0 ctl 0 swpre
crbl_sp030_0 rbl_sp030_0 0 {C_RBL}
spr_sp030_0 pref_100 ref_sp030_0 ctl 0 swpre
cref_sp030_0 ref_sp030_0 0 {C_RBL}   $ ASSUMPTION: ideal matched dummy load
XMN1_sp030_0 rbl_sp030_0 ref_sp030_0 vn_sp030_0 0 sky130_fd_pr__nfet_01v8 L=0.15 W=1 nf=1 ad=0.29 as=0.29 pd=2.58 ps=2.58 nrd=0.29 nrs=0.29 sa=0 sb=0 sd=0 mult=1 m=1
XMN2_sp030_0 ref_sp030_0 rbl_sp030_0 vn_sp030_0 0 sky130_fd_pr__nfet_01v8 L=0.15 W=1 nf=1 ad=0.29 as=0.29 pd=2.58 ps=2.58 nrd=0.29 nrs=0.29 sa=0 sb=0 sd=0 mult=1 m=1
XMP1_sp030_0 rbl_sp030_0 ref_sp030_0 vp_sp030_0 vdd sky130_fd_pr__pfet_01v8 L=0.15 W=2 nf=1 ad=0.58 as=0.58 pd=4.58 ps=4.58 nrd=0.145 nrs=0.145 sa=0 sb=0 sd=0 mult=1 m=1
XMP2_sp030_0 ref_sp030_0 rbl_sp030_0 vp_sp030_0 vdd sky130_fd_pr__pfet_01v8 L=0.15 W=2 nf=1 ad=0.58 as=0.58 pd=4.58 ps=4.58 nrd=0.145 nrs=0.145 sa=0 sb=0 sd=0 mult=1 m=1
XMNF_sp030_0 vn_sp030_0 en 0 0 sky130_fd_pr__nfet_01v8 L=0.15 W=2 nf=1 ad=0.58 as=0.58 pd=4.58 ps=4.58 nrd=0.145 nrs=0.145 sa=0 sb=0 sd=0 mult=1 m=1
XMPH_sp030_0 vp_sp030_0 enb vdd vdd sky130_fd_pr__pfet_01v8 L=0.15 W=4 nf=1 ad=1.16 as=1.16 pd=8.58 ps=8.58 nrd=0.0725 nrs=0.0725 sa=0 sb=0 sd=0 mult=1 m=1
bd_sp030_0 d_sp030_0 0 v=v(rbl_sp030_0)-v(ref_sp030_0)
bdabs_sp030_0 dabs_sp030_0 0 v=abs(v(rbl_sp030_0)-v(ref_sp030_0))

* ---- sp030_1: d = 30 mV, replica 1 ----
spa_sp030_1 pa_p030 rbl_sp030_1 ctl 0 swpre
crbl_sp030_1 rbl_sp030_1 0 {C_RBL}
spr_sp030_1 pref_100 ref_sp030_1 ctl 0 swpre
cref_sp030_1 ref_sp030_1 0 {C_RBL}   $ ASSUMPTION: ideal matched dummy load
XMN1_sp030_1 rbl_sp030_1 ref_sp030_1 vn_sp030_1 0 sky130_fd_pr__nfet_01v8 L=0.15 W=1 nf=1 ad=0.29 as=0.29 pd=2.58 ps=2.58 nrd=0.29 nrs=0.29 sa=0 sb=0 sd=0 mult=1 m=1
XMN2_sp030_1 ref_sp030_1 rbl_sp030_1 vn_sp030_1 0 sky130_fd_pr__nfet_01v8 L=0.15 W=1 nf=1 ad=0.29 as=0.29 pd=2.58 ps=2.58 nrd=0.29 nrs=0.29 sa=0 sb=0 sd=0 mult=1 m=1
XMP1_sp030_1 rbl_sp030_1 ref_sp030_1 vp_sp030_1 vdd sky130_fd_pr__pfet_01v8 L=0.15 W=2 nf=1 ad=0.58 as=0.58 pd=4.58 ps=4.58 nrd=0.145 nrs=0.145 sa=0 sb=0 sd=0 mult=1 m=1
XMP2_sp030_1 ref_sp030_1 rbl_sp030_1 vp_sp030_1 vdd sky130_fd_pr__pfet_01v8 L=0.15 W=2 nf=1 ad=0.58 as=0.58 pd=4.58 ps=4.58 nrd=0.145 nrs=0.145 sa=0 sb=0 sd=0 mult=1 m=1
XMNF_sp030_1 vn_sp030_1 en 0 0 sky130_fd_pr__nfet_01v8 L=0.15 W=2 nf=1 ad=0.58 as=0.58 pd=4.58 ps=4.58 nrd=0.145 nrs=0.145 sa=0 sb=0 sd=0 mult=1 m=1
XMPH_sp030_1 vp_sp030_1 enb vdd vdd sky130_fd_pr__pfet_01v8 L=0.15 W=4 nf=1 ad=1.16 as=1.16 pd=8.58 ps=8.58 nrd=0.0725 nrs=0.0725 sa=0 sb=0 sd=0 mult=1 m=1
bd_sp030_1 d_sp030_1 0 v=v(rbl_sp030_1)-v(ref_sp030_1)
bdabs_sp030_1 dabs_sp030_1 0 v=abs(v(rbl_sp030_1)-v(ref_sp030_1))

* ---- sp030_2: d = 30 mV, replica 2 ----
spa_sp030_2 pa_p030 rbl_sp030_2 ctl 0 swpre
crbl_sp030_2 rbl_sp030_2 0 {C_RBL}
spr_sp030_2 pref_100 ref_sp030_2 ctl 0 swpre
cref_sp030_2 ref_sp030_2 0 {C_RBL}   $ ASSUMPTION: ideal matched dummy load
XMN1_sp030_2 rbl_sp030_2 ref_sp030_2 vn_sp030_2 0 sky130_fd_pr__nfet_01v8 L=0.15 W=1 nf=1 ad=0.29 as=0.29 pd=2.58 ps=2.58 nrd=0.29 nrs=0.29 sa=0 sb=0 sd=0 mult=1 m=1
XMN2_sp030_2 ref_sp030_2 rbl_sp030_2 vn_sp030_2 0 sky130_fd_pr__nfet_01v8 L=0.15 W=1 nf=1 ad=0.29 as=0.29 pd=2.58 ps=2.58 nrd=0.29 nrs=0.29 sa=0 sb=0 sd=0 mult=1 m=1
XMP1_sp030_2 rbl_sp030_2 ref_sp030_2 vp_sp030_2 vdd sky130_fd_pr__pfet_01v8 L=0.15 W=2 nf=1 ad=0.58 as=0.58 pd=4.58 ps=4.58 nrd=0.145 nrs=0.145 sa=0 sb=0 sd=0 mult=1 m=1
XMP2_sp030_2 ref_sp030_2 rbl_sp030_2 vp_sp030_2 vdd sky130_fd_pr__pfet_01v8 L=0.15 W=2 nf=1 ad=0.58 as=0.58 pd=4.58 ps=4.58 nrd=0.145 nrs=0.145 sa=0 sb=0 sd=0 mult=1 m=1
XMNF_sp030_2 vn_sp030_2 en 0 0 sky130_fd_pr__nfet_01v8 L=0.15 W=2 nf=1 ad=0.58 as=0.58 pd=4.58 ps=4.58 nrd=0.145 nrs=0.145 sa=0 sb=0 sd=0 mult=1 m=1
XMPH_sp030_2 vp_sp030_2 enb vdd vdd sky130_fd_pr__pfet_01v8 L=0.15 W=4 nf=1 ad=1.16 as=1.16 pd=8.58 ps=8.58 nrd=0.0725 nrs=0.0725 sa=0 sb=0 sd=0 mult=1 m=1
bd_sp030_2 d_sp030_2 0 v=v(rbl_sp030_2)-v(ref_sp030_2)
bdabs_sp030_2 dabs_sp030_2 0 v=abs(v(rbl_sp030_2)-v(ref_sp030_2))

* ---- sp030_3: d = 30 mV, replica 3 ----
spa_sp030_3 pa_p030 rbl_sp030_3 ctl 0 swpre
crbl_sp030_3 rbl_sp030_3 0 {C_RBL}
spr_sp030_3 pref_100 ref_sp030_3 ctl 0 swpre
cref_sp030_3 ref_sp030_3 0 {C_RBL}   $ ASSUMPTION: ideal matched dummy load
XMN1_sp030_3 rbl_sp030_3 ref_sp030_3 vn_sp030_3 0 sky130_fd_pr__nfet_01v8 L=0.15 W=1 nf=1 ad=0.29 as=0.29 pd=2.58 ps=2.58 nrd=0.29 nrs=0.29 sa=0 sb=0 sd=0 mult=1 m=1
XMN2_sp030_3 ref_sp030_3 rbl_sp030_3 vn_sp030_3 0 sky130_fd_pr__nfet_01v8 L=0.15 W=1 nf=1 ad=0.29 as=0.29 pd=2.58 ps=2.58 nrd=0.29 nrs=0.29 sa=0 sb=0 sd=0 mult=1 m=1
XMP1_sp030_3 rbl_sp030_3 ref_sp030_3 vp_sp030_3 vdd sky130_fd_pr__pfet_01v8 L=0.15 W=2 nf=1 ad=0.58 as=0.58 pd=4.58 ps=4.58 nrd=0.145 nrs=0.145 sa=0 sb=0 sd=0 mult=1 m=1
XMP2_sp030_3 ref_sp030_3 rbl_sp030_3 vp_sp030_3 vdd sky130_fd_pr__pfet_01v8 L=0.15 W=2 nf=1 ad=0.58 as=0.58 pd=4.58 ps=4.58 nrd=0.145 nrs=0.145 sa=0 sb=0 sd=0 mult=1 m=1
XMNF_sp030_3 vn_sp030_3 en 0 0 sky130_fd_pr__nfet_01v8 L=0.15 W=2 nf=1 ad=0.58 as=0.58 pd=4.58 ps=4.58 nrd=0.145 nrs=0.145 sa=0 sb=0 sd=0 mult=1 m=1
XMPH_sp030_3 vp_sp030_3 enb vdd vdd sky130_fd_pr__pfet_01v8 L=0.15 W=4 nf=1 ad=1.16 as=1.16 pd=8.58 ps=8.58 nrd=0.0725 nrs=0.0725 sa=0 sb=0 sd=0 mult=1 m=1
bd_sp030_3 d_sp030_3 0 v=v(rbl_sp030_3)-v(ref_sp030_3)
bdabs_sp030_3 dabs_sp030_3 0 v=abs(v(rbl_sp030_3)-v(ref_sp030_3))

* ---- sp030_4: d = 30 mV, replica 4 ----
spa_sp030_4 pa_p030 rbl_sp030_4 ctl 0 swpre
crbl_sp030_4 rbl_sp030_4 0 {C_RBL}
spr_sp030_4 pref_100 ref_sp030_4 ctl 0 swpre
cref_sp030_4 ref_sp030_4 0 {C_RBL}   $ ASSUMPTION: ideal matched dummy load
XMN1_sp030_4 rbl_sp030_4 ref_sp030_4 vn_sp030_4 0 sky130_fd_pr__nfet_01v8 L=0.15 W=1 nf=1 ad=0.29 as=0.29 pd=2.58 ps=2.58 nrd=0.29 nrs=0.29 sa=0 sb=0 sd=0 mult=1 m=1
XMN2_sp030_4 ref_sp030_4 rbl_sp030_4 vn_sp030_4 0 sky130_fd_pr__nfet_01v8 L=0.15 W=1 nf=1 ad=0.29 as=0.29 pd=2.58 ps=2.58 nrd=0.29 nrs=0.29 sa=0 sb=0 sd=0 mult=1 m=1
XMP1_sp030_4 rbl_sp030_4 ref_sp030_4 vp_sp030_4 vdd sky130_fd_pr__pfet_01v8 L=0.15 W=2 nf=1 ad=0.58 as=0.58 pd=4.58 ps=4.58 nrd=0.145 nrs=0.145 sa=0 sb=0 sd=0 mult=1 m=1
XMP2_sp030_4 ref_sp030_4 rbl_sp030_4 vp_sp030_4 vdd sky130_fd_pr__pfet_01v8 L=0.15 W=2 nf=1 ad=0.58 as=0.58 pd=4.58 ps=4.58 nrd=0.145 nrs=0.145 sa=0 sb=0 sd=0 mult=1 m=1
XMNF_sp030_4 vn_sp030_4 en 0 0 sky130_fd_pr__nfet_01v8 L=0.15 W=2 nf=1 ad=0.58 as=0.58 pd=4.58 ps=4.58 nrd=0.145 nrs=0.145 sa=0 sb=0 sd=0 mult=1 m=1
XMPH_sp030_4 vp_sp030_4 enb vdd vdd sky130_fd_pr__pfet_01v8 L=0.15 W=4 nf=1 ad=1.16 as=1.16 pd=8.58 ps=8.58 nrd=0.0725 nrs=0.0725 sa=0 sb=0 sd=0 mult=1 m=1
bd_sp030_4 d_sp030_4 0 v=v(rbl_sp030_4)-v(ref_sp030_4)
bdabs_sp030_4 dabs_sp030_4 0 v=abs(v(rbl_sp030_4)-v(ref_sp030_4))

* ---- sp030_5: d = 30 mV, replica 5 ----
spa_sp030_5 pa_p030 rbl_sp030_5 ctl 0 swpre
crbl_sp030_5 rbl_sp030_5 0 {C_RBL}
spr_sp030_5 pref_100 ref_sp030_5 ctl 0 swpre
cref_sp030_5 ref_sp030_5 0 {C_RBL}   $ ASSUMPTION: ideal matched dummy load
XMN1_sp030_5 rbl_sp030_5 ref_sp030_5 vn_sp030_5 0 sky130_fd_pr__nfet_01v8 L=0.15 W=1 nf=1 ad=0.29 as=0.29 pd=2.58 ps=2.58 nrd=0.29 nrs=0.29 sa=0 sb=0 sd=0 mult=1 m=1
XMN2_sp030_5 ref_sp030_5 rbl_sp030_5 vn_sp030_5 0 sky130_fd_pr__nfet_01v8 L=0.15 W=1 nf=1 ad=0.29 as=0.29 pd=2.58 ps=2.58 nrd=0.29 nrs=0.29 sa=0 sb=0 sd=0 mult=1 m=1
XMP1_sp030_5 rbl_sp030_5 ref_sp030_5 vp_sp030_5 vdd sky130_fd_pr__pfet_01v8 L=0.15 W=2 nf=1 ad=0.58 as=0.58 pd=4.58 ps=4.58 nrd=0.145 nrs=0.145 sa=0 sb=0 sd=0 mult=1 m=1
XMP2_sp030_5 ref_sp030_5 rbl_sp030_5 vp_sp030_5 vdd sky130_fd_pr__pfet_01v8 L=0.15 W=2 nf=1 ad=0.58 as=0.58 pd=4.58 ps=4.58 nrd=0.145 nrs=0.145 sa=0 sb=0 sd=0 mult=1 m=1
XMNF_sp030_5 vn_sp030_5 en 0 0 sky130_fd_pr__nfet_01v8 L=0.15 W=2 nf=1 ad=0.58 as=0.58 pd=4.58 ps=4.58 nrd=0.145 nrs=0.145 sa=0 sb=0 sd=0 mult=1 m=1
XMPH_sp030_5 vp_sp030_5 enb vdd vdd sky130_fd_pr__pfet_01v8 L=0.15 W=4 nf=1 ad=1.16 as=1.16 pd=8.58 ps=8.58 nrd=0.0725 nrs=0.0725 sa=0 sb=0 sd=0 mult=1 m=1
bd_sp030_5 d_sp030_5 0 v=v(rbl_sp030_5)-v(ref_sp030_5)
bdabs_sp030_5 dabs_sp030_5 0 v=abs(v(rbl_sp030_5)-v(ref_sp030_5))

* ---- sm030_0: d = -30 mV, replica 0 ----
spa_sm030_0 pa_m030 rbl_sm030_0 ctl 0 swpre
crbl_sm030_0 rbl_sm030_0 0 {C_RBL}
spr_sm030_0 pref_100 ref_sm030_0 ctl 0 swpre
cref_sm030_0 ref_sm030_0 0 {C_RBL}   $ ASSUMPTION: ideal matched dummy load
XMN1_sm030_0 rbl_sm030_0 ref_sm030_0 vn_sm030_0 0 sky130_fd_pr__nfet_01v8 L=0.15 W=1 nf=1 ad=0.29 as=0.29 pd=2.58 ps=2.58 nrd=0.29 nrs=0.29 sa=0 sb=0 sd=0 mult=1 m=1
XMN2_sm030_0 ref_sm030_0 rbl_sm030_0 vn_sm030_0 0 sky130_fd_pr__nfet_01v8 L=0.15 W=1 nf=1 ad=0.29 as=0.29 pd=2.58 ps=2.58 nrd=0.29 nrs=0.29 sa=0 sb=0 sd=0 mult=1 m=1
XMP1_sm030_0 rbl_sm030_0 ref_sm030_0 vp_sm030_0 vdd sky130_fd_pr__pfet_01v8 L=0.15 W=2 nf=1 ad=0.58 as=0.58 pd=4.58 ps=4.58 nrd=0.145 nrs=0.145 sa=0 sb=0 sd=0 mult=1 m=1
XMP2_sm030_0 ref_sm030_0 rbl_sm030_0 vp_sm030_0 vdd sky130_fd_pr__pfet_01v8 L=0.15 W=2 nf=1 ad=0.58 as=0.58 pd=4.58 ps=4.58 nrd=0.145 nrs=0.145 sa=0 sb=0 sd=0 mult=1 m=1
XMNF_sm030_0 vn_sm030_0 en 0 0 sky130_fd_pr__nfet_01v8 L=0.15 W=2 nf=1 ad=0.58 as=0.58 pd=4.58 ps=4.58 nrd=0.145 nrs=0.145 sa=0 sb=0 sd=0 mult=1 m=1
XMPH_sm030_0 vp_sm030_0 enb vdd vdd sky130_fd_pr__pfet_01v8 L=0.15 W=4 nf=1 ad=1.16 as=1.16 pd=8.58 ps=8.58 nrd=0.0725 nrs=0.0725 sa=0 sb=0 sd=0 mult=1 m=1
bd_sm030_0 d_sm030_0 0 v=v(rbl_sm030_0)-v(ref_sm030_0)
bdabs_sm030_0 dabs_sm030_0 0 v=abs(v(rbl_sm030_0)-v(ref_sm030_0))

* ---- sm030_1: d = -30 mV, replica 1 ----
spa_sm030_1 pa_m030 rbl_sm030_1 ctl 0 swpre
crbl_sm030_1 rbl_sm030_1 0 {C_RBL}
spr_sm030_1 pref_100 ref_sm030_1 ctl 0 swpre
cref_sm030_1 ref_sm030_1 0 {C_RBL}   $ ASSUMPTION: ideal matched dummy load
XMN1_sm030_1 rbl_sm030_1 ref_sm030_1 vn_sm030_1 0 sky130_fd_pr__nfet_01v8 L=0.15 W=1 nf=1 ad=0.29 as=0.29 pd=2.58 ps=2.58 nrd=0.29 nrs=0.29 sa=0 sb=0 sd=0 mult=1 m=1
XMN2_sm030_1 ref_sm030_1 rbl_sm030_1 vn_sm030_1 0 sky130_fd_pr__nfet_01v8 L=0.15 W=1 nf=1 ad=0.29 as=0.29 pd=2.58 ps=2.58 nrd=0.29 nrs=0.29 sa=0 sb=0 sd=0 mult=1 m=1
XMP1_sm030_1 rbl_sm030_1 ref_sm030_1 vp_sm030_1 vdd sky130_fd_pr__pfet_01v8 L=0.15 W=2 nf=1 ad=0.58 as=0.58 pd=4.58 ps=4.58 nrd=0.145 nrs=0.145 sa=0 sb=0 sd=0 mult=1 m=1
XMP2_sm030_1 ref_sm030_1 rbl_sm030_1 vp_sm030_1 vdd sky130_fd_pr__pfet_01v8 L=0.15 W=2 nf=1 ad=0.58 as=0.58 pd=4.58 ps=4.58 nrd=0.145 nrs=0.145 sa=0 sb=0 sd=0 mult=1 m=1
XMNF_sm030_1 vn_sm030_1 en 0 0 sky130_fd_pr__nfet_01v8 L=0.15 W=2 nf=1 ad=0.58 as=0.58 pd=4.58 ps=4.58 nrd=0.145 nrs=0.145 sa=0 sb=0 sd=0 mult=1 m=1
XMPH_sm030_1 vp_sm030_1 enb vdd vdd sky130_fd_pr__pfet_01v8 L=0.15 W=4 nf=1 ad=1.16 as=1.16 pd=8.58 ps=8.58 nrd=0.0725 nrs=0.0725 sa=0 sb=0 sd=0 mult=1 m=1
bd_sm030_1 d_sm030_1 0 v=v(rbl_sm030_1)-v(ref_sm030_1)
bdabs_sm030_1 dabs_sm030_1 0 v=abs(v(rbl_sm030_1)-v(ref_sm030_1))

* ---- sm030_2: d = -30 mV, replica 2 ----
spa_sm030_2 pa_m030 rbl_sm030_2 ctl 0 swpre
crbl_sm030_2 rbl_sm030_2 0 {C_RBL}
spr_sm030_2 pref_100 ref_sm030_2 ctl 0 swpre
cref_sm030_2 ref_sm030_2 0 {C_RBL}   $ ASSUMPTION: ideal matched dummy load
XMN1_sm030_2 rbl_sm030_2 ref_sm030_2 vn_sm030_2 0 sky130_fd_pr__nfet_01v8 L=0.15 W=1 nf=1 ad=0.29 as=0.29 pd=2.58 ps=2.58 nrd=0.29 nrs=0.29 sa=0 sb=0 sd=0 mult=1 m=1
XMN2_sm030_2 ref_sm030_2 rbl_sm030_2 vn_sm030_2 0 sky130_fd_pr__nfet_01v8 L=0.15 W=1 nf=1 ad=0.29 as=0.29 pd=2.58 ps=2.58 nrd=0.29 nrs=0.29 sa=0 sb=0 sd=0 mult=1 m=1
XMP1_sm030_2 rbl_sm030_2 ref_sm030_2 vp_sm030_2 vdd sky130_fd_pr__pfet_01v8 L=0.15 W=2 nf=1 ad=0.58 as=0.58 pd=4.58 ps=4.58 nrd=0.145 nrs=0.145 sa=0 sb=0 sd=0 mult=1 m=1
XMP2_sm030_2 ref_sm030_2 rbl_sm030_2 vp_sm030_2 vdd sky130_fd_pr__pfet_01v8 L=0.15 W=2 nf=1 ad=0.58 as=0.58 pd=4.58 ps=4.58 nrd=0.145 nrs=0.145 sa=0 sb=0 sd=0 mult=1 m=1
XMNF_sm030_2 vn_sm030_2 en 0 0 sky130_fd_pr__nfet_01v8 L=0.15 W=2 nf=1 ad=0.58 as=0.58 pd=4.58 ps=4.58 nrd=0.145 nrs=0.145 sa=0 sb=0 sd=0 mult=1 m=1
XMPH_sm030_2 vp_sm030_2 enb vdd vdd sky130_fd_pr__pfet_01v8 L=0.15 W=4 nf=1 ad=1.16 as=1.16 pd=8.58 ps=8.58 nrd=0.0725 nrs=0.0725 sa=0 sb=0 sd=0 mult=1 m=1
bd_sm030_2 d_sm030_2 0 v=v(rbl_sm030_2)-v(ref_sm030_2)
bdabs_sm030_2 dabs_sm030_2 0 v=abs(v(rbl_sm030_2)-v(ref_sm030_2))

* ---- sm030_3: d = -30 mV, replica 3 ----
spa_sm030_3 pa_m030 rbl_sm030_3 ctl 0 swpre
crbl_sm030_3 rbl_sm030_3 0 {C_RBL}
spr_sm030_3 pref_100 ref_sm030_3 ctl 0 swpre
cref_sm030_3 ref_sm030_3 0 {C_RBL}   $ ASSUMPTION: ideal matched dummy load
XMN1_sm030_3 rbl_sm030_3 ref_sm030_3 vn_sm030_3 0 sky130_fd_pr__nfet_01v8 L=0.15 W=1 nf=1 ad=0.29 as=0.29 pd=2.58 ps=2.58 nrd=0.29 nrs=0.29 sa=0 sb=0 sd=0 mult=1 m=1
XMN2_sm030_3 ref_sm030_3 rbl_sm030_3 vn_sm030_3 0 sky130_fd_pr__nfet_01v8 L=0.15 W=1 nf=1 ad=0.29 as=0.29 pd=2.58 ps=2.58 nrd=0.29 nrs=0.29 sa=0 sb=0 sd=0 mult=1 m=1
XMP1_sm030_3 rbl_sm030_3 ref_sm030_3 vp_sm030_3 vdd sky130_fd_pr__pfet_01v8 L=0.15 W=2 nf=1 ad=0.58 as=0.58 pd=4.58 ps=4.58 nrd=0.145 nrs=0.145 sa=0 sb=0 sd=0 mult=1 m=1
XMP2_sm030_3 ref_sm030_3 rbl_sm030_3 vp_sm030_3 vdd sky130_fd_pr__pfet_01v8 L=0.15 W=2 nf=1 ad=0.58 as=0.58 pd=4.58 ps=4.58 nrd=0.145 nrs=0.145 sa=0 sb=0 sd=0 mult=1 m=1
XMNF_sm030_3 vn_sm030_3 en 0 0 sky130_fd_pr__nfet_01v8 L=0.15 W=2 nf=1 ad=0.58 as=0.58 pd=4.58 ps=4.58 nrd=0.145 nrs=0.145 sa=0 sb=0 sd=0 mult=1 m=1
XMPH_sm030_3 vp_sm030_3 enb vdd vdd sky130_fd_pr__pfet_01v8 L=0.15 W=4 nf=1 ad=1.16 as=1.16 pd=8.58 ps=8.58 nrd=0.0725 nrs=0.0725 sa=0 sb=0 sd=0 mult=1 m=1
bd_sm030_3 d_sm030_3 0 v=v(rbl_sm030_3)-v(ref_sm030_3)
bdabs_sm030_3 dabs_sm030_3 0 v=abs(v(rbl_sm030_3)-v(ref_sm030_3))

* ---- sm030_4: d = -30 mV, replica 4 ----
spa_sm030_4 pa_m030 rbl_sm030_4 ctl 0 swpre
crbl_sm030_4 rbl_sm030_4 0 {C_RBL}
spr_sm030_4 pref_100 ref_sm030_4 ctl 0 swpre
cref_sm030_4 ref_sm030_4 0 {C_RBL}   $ ASSUMPTION: ideal matched dummy load
XMN1_sm030_4 rbl_sm030_4 ref_sm030_4 vn_sm030_4 0 sky130_fd_pr__nfet_01v8 L=0.15 W=1 nf=1 ad=0.29 as=0.29 pd=2.58 ps=2.58 nrd=0.29 nrs=0.29 sa=0 sb=0 sd=0 mult=1 m=1
XMN2_sm030_4 ref_sm030_4 rbl_sm030_4 vn_sm030_4 0 sky130_fd_pr__nfet_01v8 L=0.15 W=1 nf=1 ad=0.29 as=0.29 pd=2.58 ps=2.58 nrd=0.29 nrs=0.29 sa=0 sb=0 sd=0 mult=1 m=1
XMP1_sm030_4 rbl_sm030_4 ref_sm030_4 vp_sm030_4 vdd sky130_fd_pr__pfet_01v8 L=0.15 W=2 nf=1 ad=0.58 as=0.58 pd=4.58 ps=4.58 nrd=0.145 nrs=0.145 sa=0 sb=0 sd=0 mult=1 m=1
XMP2_sm030_4 ref_sm030_4 rbl_sm030_4 vp_sm030_4 vdd sky130_fd_pr__pfet_01v8 L=0.15 W=2 nf=1 ad=0.58 as=0.58 pd=4.58 ps=4.58 nrd=0.145 nrs=0.145 sa=0 sb=0 sd=0 mult=1 m=1
XMNF_sm030_4 vn_sm030_4 en 0 0 sky130_fd_pr__nfet_01v8 L=0.15 W=2 nf=1 ad=0.58 as=0.58 pd=4.58 ps=4.58 nrd=0.145 nrs=0.145 sa=0 sb=0 sd=0 mult=1 m=1
XMPH_sm030_4 vp_sm030_4 enb vdd vdd sky130_fd_pr__pfet_01v8 L=0.15 W=4 nf=1 ad=1.16 as=1.16 pd=8.58 ps=8.58 nrd=0.0725 nrs=0.0725 sa=0 sb=0 sd=0 mult=1 m=1
bd_sm030_4 d_sm030_4 0 v=v(rbl_sm030_4)-v(ref_sm030_4)
bdabs_sm030_4 dabs_sm030_4 0 v=abs(v(rbl_sm030_4)-v(ref_sm030_4))

* ---- sm030_5: d = -30 mV, replica 5 ----
spa_sm030_5 pa_m030 rbl_sm030_5 ctl 0 swpre
crbl_sm030_5 rbl_sm030_5 0 {C_RBL}
spr_sm030_5 pref_100 ref_sm030_5 ctl 0 swpre
cref_sm030_5 ref_sm030_5 0 {C_RBL}   $ ASSUMPTION: ideal matched dummy load
XMN1_sm030_5 rbl_sm030_5 ref_sm030_5 vn_sm030_5 0 sky130_fd_pr__nfet_01v8 L=0.15 W=1 nf=1 ad=0.29 as=0.29 pd=2.58 ps=2.58 nrd=0.29 nrs=0.29 sa=0 sb=0 sd=0 mult=1 m=1
XMN2_sm030_5 ref_sm030_5 rbl_sm030_5 vn_sm030_5 0 sky130_fd_pr__nfet_01v8 L=0.15 W=1 nf=1 ad=0.29 as=0.29 pd=2.58 ps=2.58 nrd=0.29 nrs=0.29 sa=0 sb=0 sd=0 mult=1 m=1
XMP1_sm030_5 rbl_sm030_5 ref_sm030_5 vp_sm030_5 vdd sky130_fd_pr__pfet_01v8 L=0.15 W=2 nf=1 ad=0.58 as=0.58 pd=4.58 ps=4.58 nrd=0.145 nrs=0.145 sa=0 sb=0 sd=0 mult=1 m=1
XMP2_sm030_5 ref_sm030_5 rbl_sm030_5 vp_sm030_5 vdd sky130_fd_pr__pfet_01v8 L=0.15 W=2 nf=1 ad=0.58 as=0.58 pd=4.58 ps=4.58 nrd=0.145 nrs=0.145 sa=0 sb=0 sd=0 mult=1 m=1
XMNF_sm030_5 vn_sm030_5 en 0 0 sky130_fd_pr__nfet_01v8 L=0.15 W=2 nf=1 ad=0.58 as=0.58 pd=4.58 ps=4.58 nrd=0.145 nrs=0.145 sa=0 sb=0 sd=0 mult=1 m=1
XMPH_sm030_5 vp_sm030_5 enb vdd vdd sky130_fd_pr__pfet_01v8 L=0.15 W=4 nf=1 ad=1.16 as=1.16 pd=8.58 ps=8.58 nrd=0.0725 nrs=0.0725 sa=0 sb=0 sd=0 mult=1 m=1
bd_sm030_5 d_sm030_5 0 v=v(rbl_sm030_5)-v(ref_sm030_5)
bdabs_sm030_5 dabs_sm030_5 0 v=abs(v(rbl_sm030_5)-v(ref_sm030_5))

* ---- sp040_0: d = 40 mV, replica 0 ----
spa_sp040_0 pa_p040 rbl_sp040_0 ctl 0 swpre
crbl_sp040_0 rbl_sp040_0 0 {C_RBL}
spr_sp040_0 pref_100 ref_sp040_0 ctl 0 swpre
cref_sp040_0 ref_sp040_0 0 {C_RBL}   $ ASSUMPTION: ideal matched dummy load
XMN1_sp040_0 rbl_sp040_0 ref_sp040_0 vn_sp040_0 0 sky130_fd_pr__nfet_01v8 L=0.15 W=1 nf=1 ad=0.29 as=0.29 pd=2.58 ps=2.58 nrd=0.29 nrs=0.29 sa=0 sb=0 sd=0 mult=1 m=1
XMN2_sp040_0 ref_sp040_0 rbl_sp040_0 vn_sp040_0 0 sky130_fd_pr__nfet_01v8 L=0.15 W=1 nf=1 ad=0.29 as=0.29 pd=2.58 ps=2.58 nrd=0.29 nrs=0.29 sa=0 sb=0 sd=0 mult=1 m=1
XMP1_sp040_0 rbl_sp040_0 ref_sp040_0 vp_sp040_0 vdd sky130_fd_pr__pfet_01v8 L=0.15 W=2 nf=1 ad=0.58 as=0.58 pd=4.58 ps=4.58 nrd=0.145 nrs=0.145 sa=0 sb=0 sd=0 mult=1 m=1
XMP2_sp040_0 ref_sp040_0 rbl_sp040_0 vp_sp040_0 vdd sky130_fd_pr__pfet_01v8 L=0.15 W=2 nf=1 ad=0.58 as=0.58 pd=4.58 ps=4.58 nrd=0.145 nrs=0.145 sa=0 sb=0 sd=0 mult=1 m=1
XMNF_sp040_0 vn_sp040_0 en 0 0 sky130_fd_pr__nfet_01v8 L=0.15 W=2 nf=1 ad=0.58 as=0.58 pd=4.58 ps=4.58 nrd=0.145 nrs=0.145 sa=0 sb=0 sd=0 mult=1 m=1
XMPH_sp040_0 vp_sp040_0 enb vdd vdd sky130_fd_pr__pfet_01v8 L=0.15 W=4 nf=1 ad=1.16 as=1.16 pd=8.58 ps=8.58 nrd=0.0725 nrs=0.0725 sa=0 sb=0 sd=0 mult=1 m=1
bd_sp040_0 d_sp040_0 0 v=v(rbl_sp040_0)-v(ref_sp040_0)
bdabs_sp040_0 dabs_sp040_0 0 v=abs(v(rbl_sp040_0)-v(ref_sp040_0))

* ---- sp040_1: d = 40 mV, replica 1 ----
spa_sp040_1 pa_p040 rbl_sp040_1 ctl 0 swpre
crbl_sp040_1 rbl_sp040_1 0 {C_RBL}
spr_sp040_1 pref_100 ref_sp040_1 ctl 0 swpre
cref_sp040_1 ref_sp040_1 0 {C_RBL}   $ ASSUMPTION: ideal matched dummy load
XMN1_sp040_1 rbl_sp040_1 ref_sp040_1 vn_sp040_1 0 sky130_fd_pr__nfet_01v8 L=0.15 W=1 nf=1 ad=0.29 as=0.29 pd=2.58 ps=2.58 nrd=0.29 nrs=0.29 sa=0 sb=0 sd=0 mult=1 m=1
XMN2_sp040_1 ref_sp040_1 rbl_sp040_1 vn_sp040_1 0 sky130_fd_pr__nfet_01v8 L=0.15 W=1 nf=1 ad=0.29 as=0.29 pd=2.58 ps=2.58 nrd=0.29 nrs=0.29 sa=0 sb=0 sd=0 mult=1 m=1
XMP1_sp040_1 rbl_sp040_1 ref_sp040_1 vp_sp040_1 vdd sky130_fd_pr__pfet_01v8 L=0.15 W=2 nf=1 ad=0.58 as=0.58 pd=4.58 ps=4.58 nrd=0.145 nrs=0.145 sa=0 sb=0 sd=0 mult=1 m=1
XMP2_sp040_1 ref_sp040_1 rbl_sp040_1 vp_sp040_1 vdd sky130_fd_pr__pfet_01v8 L=0.15 W=2 nf=1 ad=0.58 as=0.58 pd=4.58 ps=4.58 nrd=0.145 nrs=0.145 sa=0 sb=0 sd=0 mult=1 m=1
XMNF_sp040_1 vn_sp040_1 en 0 0 sky130_fd_pr__nfet_01v8 L=0.15 W=2 nf=1 ad=0.58 as=0.58 pd=4.58 ps=4.58 nrd=0.145 nrs=0.145 sa=0 sb=0 sd=0 mult=1 m=1
XMPH_sp040_1 vp_sp040_1 enb vdd vdd sky130_fd_pr__pfet_01v8 L=0.15 W=4 nf=1 ad=1.16 as=1.16 pd=8.58 ps=8.58 nrd=0.0725 nrs=0.0725 sa=0 sb=0 sd=0 mult=1 m=1
bd_sp040_1 d_sp040_1 0 v=v(rbl_sp040_1)-v(ref_sp040_1)
bdabs_sp040_1 dabs_sp040_1 0 v=abs(v(rbl_sp040_1)-v(ref_sp040_1))

* ---- sp040_2: d = 40 mV, replica 2 ----
spa_sp040_2 pa_p040 rbl_sp040_2 ctl 0 swpre
crbl_sp040_2 rbl_sp040_2 0 {C_RBL}
spr_sp040_2 pref_100 ref_sp040_2 ctl 0 swpre
cref_sp040_2 ref_sp040_2 0 {C_RBL}   $ ASSUMPTION: ideal matched dummy load
XMN1_sp040_2 rbl_sp040_2 ref_sp040_2 vn_sp040_2 0 sky130_fd_pr__nfet_01v8 L=0.15 W=1 nf=1 ad=0.29 as=0.29 pd=2.58 ps=2.58 nrd=0.29 nrs=0.29 sa=0 sb=0 sd=0 mult=1 m=1
XMN2_sp040_2 ref_sp040_2 rbl_sp040_2 vn_sp040_2 0 sky130_fd_pr__nfet_01v8 L=0.15 W=1 nf=1 ad=0.29 as=0.29 pd=2.58 ps=2.58 nrd=0.29 nrs=0.29 sa=0 sb=0 sd=0 mult=1 m=1
XMP1_sp040_2 rbl_sp040_2 ref_sp040_2 vp_sp040_2 vdd sky130_fd_pr__pfet_01v8 L=0.15 W=2 nf=1 ad=0.58 as=0.58 pd=4.58 ps=4.58 nrd=0.145 nrs=0.145 sa=0 sb=0 sd=0 mult=1 m=1
XMP2_sp040_2 ref_sp040_2 rbl_sp040_2 vp_sp040_2 vdd sky130_fd_pr__pfet_01v8 L=0.15 W=2 nf=1 ad=0.58 as=0.58 pd=4.58 ps=4.58 nrd=0.145 nrs=0.145 sa=0 sb=0 sd=0 mult=1 m=1
XMNF_sp040_2 vn_sp040_2 en 0 0 sky130_fd_pr__nfet_01v8 L=0.15 W=2 nf=1 ad=0.58 as=0.58 pd=4.58 ps=4.58 nrd=0.145 nrs=0.145 sa=0 sb=0 sd=0 mult=1 m=1
XMPH_sp040_2 vp_sp040_2 enb vdd vdd sky130_fd_pr__pfet_01v8 L=0.15 W=4 nf=1 ad=1.16 as=1.16 pd=8.58 ps=8.58 nrd=0.0725 nrs=0.0725 sa=0 sb=0 sd=0 mult=1 m=1
bd_sp040_2 d_sp040_2 0 v=v(rbl_sp040_2)-v(ref_sp040_2)
bdabs_sp040_2 dabs_sp040_2 0 v=abs(v(rbl_sp040_2)-v(ref_sp040_2))

* ---- sp040_3: d = 40 mV, replica 3 ----
spa_sp040_3 pa_p040 rbl_sp040_3 ctl 0 swpre
crbl_sp040_3 rbl_sp040_3 0 {C_RBL}
spr_sp040_3 pref_100 ref_sp040_3 ctl 0 swpre
cref_sp040_3 ref_sp040_3 0 {C_RBL}   $ ASSUMPTION: ideal matched dummy load
XMN1_sp040_3 rbl_sp040_3 ref_sp040_3 vn_sp040_3 0 sky130_fd_pr__nfet_01v8 L=0.15 W=1 nf=1 ad=0.29 as=0.29 pd=2.58 ps=2.58 nrd=0.29 nrs=0.29 sa=0 sb=0 sd=0 mult=1 m=1
XMN2_sp040_3 ref_sp040_3 rbl_sp040_3 vn_sp040_3 0 sky130_fd_pr__nfet_01v8 L=0.15 W=1 nf=1 ad=0.29 as=0.29 pd=2.58 ps=2.58 nrd=0.29 nrs=0.29 sa=0 sb=0 sd=0 mult=1 m=1
XMP1_sp040_3 rbl_sp040_3 ref_sp040_3 vp_sp040_3 vdd sky130_fd_pr__pfet_01v8 L=0.15 W=2 nf=1 ad=0.58 as=0.58 pd=4.58 ps=4.58 nrd=0.145 nrs=0.145 sa=0 sb=0 sd=0 mult=1 m=1
XMP2_sp040_3 ref_sp040_3 rbl_sp040_3 vp_sp040_3 vdd sky130_fd_pr__pfet_01v8 L=0.15 W=2 nf=1 ad=0.58 as=0.58 pd=4.58 ps=4.58 nrd=0.145 nrs=0.145 sa=0 sb=0 sd=0 mult=1 m=1
XMNF_sp040_3 vn_sp040_3 en 0 0 sky130_fd_pr__nfet_01v8 L=0.15 W=2 nf=1 ad=0.58 as=0.58 pd=4.58 ps=4.58 nrd=0.145 nrs=0.145 sa=0 sb=0 sd=0 mult=1 m=1
XMPH_sp040_3 vp_sp040_3 enb vdd vdd sky130_fd_pr__pfet_01v8 L=0.15 W=4 nf=1 ad=1.16 as=1.16 pd=8.58 ps=8.58 nrd=0.0725 nrs=0.0725 sa=0 sb=0 sd=0 mult=1 m=1
bd_sp040_3 d_sp040_3 0 v=v(rbl_sp040_3)-v(ref_sp040_3)
bdabs_sp040_3 dabs_sp040_3 0 v=abs(v(rbl_sp040_3)-v(ref_sp040_3))

* ---- sp040_4: d = 40 mV, replica 4 ----
spa_sp040_4 pa_p040 rbl_sp040_4 ctl 0 swpre
crbl_sp040_4 rbl_sp040_4 0 {C_RBL}
spr_sp040_4 pref_100 ref_sp040_4 ctl 0 swpre
cref_sp040_4 ref_sp040_4 0 {C_RBL}   $ ASSUMPTION: ideal matched dummy load
XMN1_sp040_4 rbl_sp040_4 ref_sp040_4 vn_sp040_4 0 sky130_fd_pr__nfet_01v8 L=0.15 W=1 nf=1 ad=0.29 as=0.29 pd=2.58 ps=2.58 nrd=0.29 nrs=0.29 sa=0 sb=0 sd=0 mult=1 m=1
XMN2_sp040_4 ref_sp040_4 rbl_sp040_4 vn_sp040_4 0 sky130_fd_pr__nfet_01v8 L=0.15 W=1 nf=1 ad=0.29 as=0.29 pd=2.58 ps=2.58 nrd=0.29 nrs=0.29 sa=0 sb=0 sd=0 mult=1 m=1
XMP1_sp040_4 rbl_sp040_4 ref_sp040_4 vp_sp040_4 vdd sky130_fd_pr__pfet_01v8 L=0.15 W=2 nf=1 ad=0.58 as=0.58 pd=4.58 ps=4.58 nrd=0.145 nrs=0.145 sa=0 sb=0 sd=0 mult=1 m=1
XMP2_sp040_4 ref_sp040_4 rbl_sp040_4 vp_sp040_4 vdd sky130_fd_pr__pfet_01v8 L=0.15 W=2 nf=1 ad=0.58 as=0.58 pd=4.58 ps=4.58 nrd=0.145 nrs=0.145 sa=0 sb=0 sd=0 mult=1 m=1
XMNF_sp040_4 vn_sp040_4 en 0 0 sky130_fd_pr__nfet_01v8 L=0.15 W=2 nf=1 ad=0.58 as=0.58 pd=4.58 ps=4.58 nrd=0.145 nrs=0.145 sa=0 sb=0 sd=0 mult=1 m=1
XMPH_sp040_4 vp_sp040_4 enb vdd vdd sky130_fd_pr__pfet_01v8 L=0.15 W=4 nf=1 ad=1.16 as=1.16 pd=8.58 ps=8.58 nrd=0.0725 nrs=0.0725 sa=0 sb=0 sd=0 mult=1 m=1
bd_sp040_4 d_sp040_4 0 v=v(rbl_sp040_4)-v(ref_sp040_4)
bdabs_sp040_4 dabs_sp040_4 0 v=abs(v(rbl_sp040_4)-v(ref_sp040_4))

* ---- sp040_5: d = 40 mV, replica 5 ----
spa_sp040_5 pa_p040 rbl_sp040_5 ctl 0 swpre
crbl_sp040_5 rbl_sp040_5 0 {C_RBL}
spr_sp040_5 pref_100 ref_sp040_5 ctl 0 swpre
cref_sp040_5 ref_sp040_5 0 {C_RBL}   $ ASSUMPTION: ideal matched dummy load
XMN1_sp040_5 rbl_sp040_5 ref_sp040_5 vn_sp040_5 0 sky130_fd_pr__nfet_01v8 L=0.15 W=1 nf=1 ad=0.29 as=0.29 pd=2.58 ps=2.58 nrd=0.29 nrs=0.29 sa=0 sb=0 sd=0 mult=1 m=1
XMN2_sp040_5 ref_sp040_5 rbl_sp040_5 vn_sp040_5 0 sky130_fd_pr__nfet_01v8 L=0.15 W=1 nf=1 ad=0.29 as=0.29 pd=2.58 ps=2.58 nrd=0.29 nrs=0.29 sa=0 sb=0 sd=0 mult=1 m=1
XMP1_sp040_5 rbl_sp040_5 ref_sp040_5 vp_sp040_5 vdd sky130_fd_pr__pfet_01v8 L=0.15 W=2 nf=1 ad=0.58 as=0.58 pd=4.58 ps=4.58 nrd=0.145 nrs=0.145 sa=0 sb=0 sd=0 mult=1 m=1
XMP2_sp040_5 ref_sp040_5 rbl_sp040_5 vp_sp040_5 vdd sky130_fd_pr__pfet_01v8 L=0.15 W=2 nf=1 ad=0.58 as=0.58 pd=4.58 ps=4.58 nrd=0.145 nrs=0.145 sa=0 sb=0 sd=0 mult=1 m=1
XMNF_sp040_5 vn_sp040_5 en 0 0 sky130_fd_pr__nfet_01v8 L=0.15 W=2 nf=1 ad=0.58 as=0.58 pd=4.58 ps=4.58 nrd=0.145 nrs=0.145 sa=0 sb=0 sd=0 mult=1 m=1
XMPH_sp040_5 vp_sp040_5 enb vdd vdd sky130_fd_pr__pfet_01v8 L=0.15 W=4 nf=1 ad=1.16 as=1.16 pd=8.58 ps=8.58 nrd=0.0725 nrs=0.0725 sa=0 sb=0 sd=0 mult=1 m=1
bd_sp040_5 d_sp040_5 0 v=v(rbl_sp040_5)-v(ref_sp040_5)
bdabs_sp040_5 dabs_sp040_5 0 v=abs(v(rbl_sp040_5)-v(ref_sp040_5))

* ---- sm040_0: d = -40 mV, replica 0 ----
spa_sm040_0 pa_m040 rbl_sm040_0 ctl 0 swpre
crbl_sm040_0 rbl_sm040_0 0 {C_RBL}
spr_sm040_0 pref_100 ref_sm040_0 ctl 0 swpre
cref_sm040_0 ref_sm040_0 0 {C_RBL}   $ ASSUMPTION: ideal matched dummy load
XMN1_sm040_0 rbl_sm040_0 ref_sm040_0 vn_sm040_0 0 sky130_fd_pr__nfet_01v8 L=0.15 W=1 nf=1 ad=0.29 as=0.29 pd=2.58 ps=2.58 nrd=0.29 nrs=0.29 sa=0 sb=0 sd=0 mult=1 m=1
XMN2_sm040_0 ref_sm040_0 rbl_sm040_0 vn_sm040_0 0 sky130_fd_pr__nfet_01v8 L=0.15 W=1 nf=1 ad=0.29 as=0.29 pd=2.58 ps=2.58 nrd=0.29 nrs=0.29 sa=0 sb=0 sd=0 mult=1 m=1
XMP1_sm040_0 rbl_sm040_0 ref_sm040_0 vp_sm040_0 vdd sky130_fd_pr__pfet_01v8 L=0.15 W=2 nf=1 ad=0.58 as=0.58 pd=4.58 ps=4.58 nrd=0.145 nrs=0.145 sa=0 sb=0 sd=0 mult=1 m=1
XMP2_sm040_0 ref_sm040_0 rbl_sm040_0 vp_sm040_0 vdd sky130_fd_pr__pfet_01v8 L=0.15 W=2 nf=1 ad=0.58 as=0.58 pd=4.58 ps=4.58 nrd=0.145 nrs=0.145 sa=0 sb=0 sd=0 mult=1 m=1
XMNF_sm040_0 vn_sm040_0 en 0 0 sky130_fd_pr__nfet_01v8 L=0.15 W=2 nf=1 ad=0.58 as=0.58 pd=4.58 ps=4.58 nrd=0.145 nrs=0.145 sa=0 sb=0 sd=0 mult=1 m=1
XMPH_sm040_0 vp_sm040_0 enb vdd vdd sky130_fd_pr__pfet_01v8 L=0.15 W=4 nf=1 ad=1.16 as=1.16 pd=8.58 ps=8.58 nrd=0.0725 nrs=0.0725 sa=0 sb=0 sd=0 mult=1 m=1
bd_sm040_0 d_sm040_0 0 v=v(rbl_sm040_0)-v(ref_sm040_0)
bdabs_sm040_0 dabs_sm040_0 0 v=abs(v(rbl_sm040_0)-v(ref_sm040_0))

* ---- sm040_1: d = -40 mV, replica 1 ----
spa_sm040_1 pa_m040 rbl_sm040_1 ctl 0 swpre
crbl_sm040_1 rbl_sm040_1 0 {C_RBL}
spr_sm040_1 pref_100 ref_sm040_1 ctl 0 swpre
cref_sm040_1 ref_sm040_1 0 {C_RBL}   $ ASSUMPTION: ideal matched dummy load
XMN1_sm040_1 rbl_sm040_1 ref_sm040_1 vn_sm040_1 0 sky130_fd_pr__nfet_01v8 L=0.15 W=1 nf=1 ad=0.29 as=0.29 pd=2.58 ps=2.58 nrd=0.29 nrs=0.29 sa=0 sb=0 sd=0 mult=1 m=1
XMN2_sm040_1 ref_sm040_1 rbl_sm040_1 vn_sm040_1 0 sky130_fd_pr__nfet_01v8 L=0.15 W=1 nf=1 ad=0.29 as=0.29 pd=2.58 ps=2.58 nrd=0.29 nrs=0.29 sa=0 sb=0 sd=0 mult=1 m=1
XMP1_sm040_1 rbl_sm040_1 ref_sm040_1 vp_sm040_1 vdd sky130_fd_pr__pfet_01v8 L=0.15 W=2 nf=1 ad=0.58 as=0.58 pd=4.58 ps=4.58 nrd=0.145 nrs=0.145 sa=0 sb=0 sd=0 mult=1 m=1
XMP2_sm040_1 ref_sm040_1 rbl_sm040_1 vp_sm040_1 vdd sky130_fd_pr__pfet_01v8 L=0.15 W=2 nf=1 ad=0.58 as=0.58 pd=4.58 ps=4.58 nrd=0.145 nrs=0.145 sa=0 sb=0 sd=0 mult=1 m=1
XMNF_sm040_1 vn_sm040_1 en 0 0 sky130_fd_pr__nfet_01v8 L=0.15 W=2 nf=1 ad=0.58 as=0.58 pd=4.58 ps=4.58 nrd=0.145 nrs=0.145 sa=0 sb=0 sd=0 mult=1 m=1
XMPH_sm040_1 vp_sm040_1 enb vdd vdd sky130_fd_pr__pfet_01v8 L=0.15 W=4 nf=1 ad=1.16 as=1.16 pd=8.58 ps=8.58 nrd=0.0725 nrs=0.0725 sa=0 sb=0 sd=0 mult=1 m=1
bd_sm040_1 d_sm040_1 0 v=v(rbl_sm040_1)-v(ref_sm040_1)
bdabs_sm040_1 dabs_sm040_1 0 v=abs(v(rbl_sm040_1)-v(ref_sm040_1))

* ---- sm040_2: d = -40 mV, replica 2 ----
spa_sm040_2 pa_m040 rbl_sm040_2 ctl 0 swpre
crbl_sm040_2 rbl_sm040_2 0 {C_RBL}
spr_sm040_2 pref_100 ref_sm040_2 ctl 0 swpre
cref_sm040_2 ref_sm040_2 0 {C_RBL}   $ ASSUMPTION: ideal matched dummy load
XMN1_sm040_2 rbl_sm040_2 ref_sm040_2 vn_sm040_2 0 sky130_fd_pr__nfet_01v8 L=0.15 W=1 nf=1 ad=0.29 as=0.29 pd=2.58 ps=2.58 nrd=0.29 nrs=0.29 sa=0 sb=0 sd=0 mult=1 m=1
XMN2_sm040_2 ref_sm040_2 rbl_sm040_2 vn_sm040_2 0 sky130_fd_pr__nfet_01v8 L=0.15 W=1 nf=1 ad=0.29 as=0.29 pd=2.58 ps=2.58 nrd=0.29 nrs=0.29 sa=0 sb=0 sd=0 mult=1 m=1
XMP1_sm040_2 rbl_sm040_2 ref_sm040_2 vp_sm040_2 vdd sky130_fd_pr__pfet_01v8 L=0.15 W=2 nf=1 ad=0.58 as=0.58 pd=4.58 ps=4.58 nrd=0.145 nrs=0.145 sa=0 sb=0 sd=0 mult=1 m=1
XMP2_sm040_2 ref_sm040_2 rbl_sm040_2 vp_sm040_2 vdd sky130_fd_pr__pfet_01v8 L=0.15 W=2 nf=1 ad=0.58 as=0.58 pd=4.58 ps=4.58 nrd=0.145 nrs=0.145 sa=0 sb=0 sd=0 mult=1 m=1
XMNF_sm040_2 vn_sm040_2 en 0 0 sky130_fd_pr__nfet_01v8 L=0.15 W=2 nf=1 ad=0.58 as=0.58 pd=4.58 ps=4.58 nrd=0.145 nrs=0.145 sa=0 sb=0 sd=0 mult=1 m=1
XMPH_sm040_2 vp_sm040_2 enb vdd vdd sky130_fd_pr__pfet_01v8 L=0.15 W=4 nf=1 ad=1.16 as=1.16 pd=8.58 ps=8.58 nrd=0.0725 nrs=0.0725 sa=0 sb=0 sd=0 mult=1 m=1
bd_sm040_2 d_sm040_2 0 v=v(rbl_sm040_2)-v(ref_sm040_2)
bdabs_sm040_2 dabs_sm040_2 0 v=abs(v(rbl_sm040_2)-v(ref_sm040_2))

* ---- sm040_3: d = -40 mV, replica 3 ----
spa_sm040_3 pa_m040 rbl_sm040_3 ctl 0 swpre
crbl_sm040_3 rbl_sm040_3 0 {C_RBL}
spr_sm040_3 pref_100 ref_sm040_3 ctl 0 swpre
cref_sm040_3 ref_sm040_3 0 {C_RBL}   $ ASSUMPTION: ideal matched dummy load
XMN1_sm040_3 rbl_sm040_3 ref_sm040_3 vn_sm040_3 0 sky130_fd_pr__nfet_01v8 L=0.15 W=1 nf=1 ad=0.29 as=0.29 pd=2.58 ps=2.58 nrd=0.29 nrs=0.29 sa=0 sb=0 sd=0 mult=1 m=1
XMN2_sm040_3 ref_sm040_3 rbl_sm040_3 vn_sm040_3 0 sky130_fd_pr__nfet_01v8 L=0.15 W=1 nf=1 ad=0.29 as=0.29 pd=2.58 ps=2.58 nrd=0.29 nrs=0.29 sa=0 sb=0 sd=0 mult=1 m=1
XMP1_sm040_3 rbl_sm040_3 ref_sm040_3 vp_sm040_3 vdd sky130_fd_pr__pfet_01v8 L=0.15 W=2 nf=1 ad=0.58 as=0.58 pd=4.58 ps=4.58 nrd=0.145 nrs=0.145 sa=0 sb=0 sd=0 mult=1 m=1
XMP2_sm040_3 ref_sm040_3 rbl_sm040_3 vp_sm040_3 vdd sky130_fd_pr__pfet_01v8 L=0.15 W=2 nf=1 ad=0.58 as=0.58 pd=4.58 ps=4.58 nrd=0.145 nrs=0.145 sa=0 sb=0 sd=0 mult=1 m=1
XMNF_sm040_3 vn_sm040_3 en 0 0 sky130_fd_pr__nfet_01v8 L=0.15 W=2 nf=1 ad=0.58 as=0.58 pd=4.58 ps=4.58 nrd=0.145 nrs=0.145 sa=0 sb=0 sd=0 mult=1 m=1
XMPH_sm040_3 vp_sm040_3 enb vdd vdd sky130_fd_pr__pfet_01v8 L=0.15 W=4 nf=1 ad=1.16 as=1.16 pd=8.58 ps=8.58 nrd=0.0725 nrs=0.0725 sa=0 sb=0 sd=0 mult=1 m=1
bd_sm040_3 d_sm040_3 0 v=v(rbl_sm040_3)-v(ref_sm040_3)
bdabs_sm040_3 dabs_sm040_3 0 v=abs(v(rbl_sm040_3)-v(ref_sm040_3))

* ---- sm040_4: d = -40 mV, replica 4 ----
spa_sm040_4 pa_m040 rbl_sm040_4 ctl 0 swpre
crbl_sm040_4 rbl_sm040_4 0 {C_RBL}
spr_sm040_4 pref_100 ref_sm040_4 ctl 0 swpre
cref_sm040_4 ref_sm040_4 0 {C_RBL}   $ ASSUMPTION: ideal matched dummy load
XMN1_sm040_4 rbl_sm040_4 ref_sm040_4 vn_sm040_4 0 sky130_fd_pr__nfet_01v8 L=0.15 W=1 nf=1 ad=0.29 as=0.29 pd=2.58 ps=2.58 nrd=0.29 nrs=0.29 sa=0 sb=0 sd=0 mult=1 m=1
XMN2_sm040_4 ref_sm040_4 rbl_sm040_4 vn_sm040_4 0 sky130_fd_pr__nfet_01v8 L=0.15 W=1 nf=1 ad=0.29 as=0.29 pd=2.58 ps=2.58 nrd=0.29 nrs=0.29 sa=0 sb=0 sd=0 mult=1 m=1
XMP1_sm040_4 rbl_sm040_4 ref_sm040_4 vp_sm040_4 vdd sky130_fd_pr__pfet_01v8 L=0.15 W=2 nf=1 ad=0.58 as=0.58 pd=4.58 ps=4.58 nrd=0.145 nrs=0.145 sa=0 sb=0 sd=0 mult=1 m=1
XMP2_sm040_4 ref_sm040_4 rbl_sm040_4 vp_sm040_4 vdd sky130_fd_pr__pfet_01v8 L=0.15 W=2 nf=1 ad=0.58 as=0.58 pd=4.58 ps=4.58 nrd=0.145 nrs=0.145 sa=0 sb=0 sd=0 mult=1 m=1
XMNF_sm040_4 vn_sm040_4 en 0 0 sky130_fd_pr__nfet_01v8 L=0.15 W=2 nf=1 ad=0.58 as=0.58 pd=4.58 ps=4.58 nrd=0.145 nrs=0.145 sa=0 sb=0 sd=0 mult=1 m=1
XMPH_sm040_4 vp_sm040_4 enb vdd vdd sky130_fd_pr__pfet_01v8 L=0.15 W=4 nf=1 ad=1.16 as=1.16 pd=8.58 ps=8.58 nrd=0.0725 nrs=0.0725 sa=0 sb=0 sd=0 mult=1 m=1
bd_sm040_4 d_sm040_4 0 v=v(rbl_sm040_4)-v(ref_sm040_4)
bdabs_sm040_4 dabs_sm040_4 0 v=abs(v(rbl_sm040_4)-v(ref_sm040_4))

* ---- sm040_5: d = -40 mV, replica 5 ----
spa_sm040_5 pa_m040 rbl_sm040_5 ctl 0 swpre
crbl_sm040_5 rbl_sm040_5 0 {C_RBL}
spr_sm040_5 pref_100 ref_sm040_5 ctl 0 swpre
cref_sm040_5 ref_sm040_5 0 {C_RBL}   $ ASSUMPTION: ideal matched dummy load
XMN1_sm040_5 rbl_sm040_5 ref_sm040_5 vn_sm040_5 0 sky130_fd_pr__nfet_01v8 L=0.15 W=1 nf=1 ad=0.29 as=0.29 pd=2.58 ps=2.58 nrd=0.29 nrs=0.29 sa=0 sb=0 sd=0 mult=1 m=1
XMN2_sm040_5 ref_sm040_5 rbl_sm040_5 vn_sm040_5 0 sky130_fd_pr__nfet_01v8 L=0.15 W=1 nf=1 ad=0.29 as=0.29 pd=2.58 ps=2.58 nrd=0.29 nrs=0.29 sa=0 sb=0 sd=0 mult=1 m=1
XMP1_sm040_5 rbl_sm040_5 ref_sm040_5 vp_sm040_5 vdd sky130_fd_pr__pfet_01v8 L=0.15 W=2 nf=1 ad=0.58 as=0.58 pd=4.58 ps=4.58 nrd=0.145 nrs=0.145 sa=0 sb=0 sd=0 mult=1 m=1
XMP2_sm040_5 ref_sm040_5 rbl_sm040_5 vp_sm040_5 vdd sky130_fd_pr__pfet_01v8 L=0.15 W=2 nf=1 ad=0.58 as=0.58 pd=4.58 ps=4.58 nrd=0.145 nrs=0.145 sa=0 sb=0 sd=0 mult=1 m=1
XMNF_sm040_5 vn_sm040_5 en 0 0 sky130_fd_pr__nfet_01v8 L=0.15 W=2 nf=1 ad=0.58 as=0.58 pd=4.58 ps=4.58 nrd=0.145 nrs=0.145 sa=0 sb=0 sd=0 mult=1 m=1
XMPH_sm040_5 vp_sm040_5 enb vdd vdd sky130_fd_pr__pfet_01v8 L=0.15 W=4 nf=1 ad=1.16 as=1.16 pd=8.58 ps=8.58 nrd=0.0725 nrs=0.0725 sa=0 sb=0 sd=0 mult=1 m=1
bd_sm040_5 d_sm040_5 0 v=v(rbl_sm040_5)-v(ref_sm040_5)
bdabs_sm040_5 dabs_sm040_5 0 v=abs(v(rbl_sm040_5)-v(ref_sm040_5))

* ---- sp050_0: d = 50 mV, replica 0 ----
spa_sp050_0 pa_p050 rbl_sp050_0 ctl 0 swpre
crbl_sp050_0 rbl_sp050_0 0 {C_RBL}
spr_sp050_0 pref_100 ref_sp050_0 ctl 0 swpre
cref_sp050_0 ref_sp050_0 0 {C_RBL}   $ ASSUMPTION: ideal matched dummy load
XMN1_sp050_0 rbl_sp050_0 ref_sp050_0 vn_sp050_0 0 sky130_fd_pr__nfet_01v8 L=0.15 W=1 nf=1 ad=0.29 as=0.29 pd=2.58 ps=2.58 nrd=0.29 nrs=0.29 sa=0 sb=0 sd=0 mult=1 m=1
XMN2_sp050_0 ref_sp050_0 rbl_sp050_0 vn_sp050_0 0 sky130_fd_pr__nfet_01v8 L=0.15 W=1 nf=1 ad=0.29 as=0.29 pd=2.58 ps=2.58 nrd=0.29 nrs=0.29 sa=0 sb=0 sd=0 mult=1 m=1
XMP1_sp050_0 rbl_sp050_0 ref_sp050_0 vp_sp050_0 vdd sky130_fd_pr__pfet_01v8 L=0.15 W=2 nf=1 ad=0.58 as=0.58 pd=4.58 ps=4.58 nrd=0.145 nrs=0.145 sa=0 sb=0 sd=0 mult=1 m=1
XMP2_sp050_0 ref_sp050_0 rbl_sp050_0 vp_sp050_0 vdd sky130_fd_pr__pfet_01v8 L=0.15 W=2 nf=1 ad=0.58 as=0.58 pd=4.58 ps=4.58 nrd=0.145 nrs=0.145 sa=0 sb=0 sd=0 mult=1 m=1
XMNF_sp050_0 vn_sp050_0 en 0 0 sky130_fd_pr__nfet_01v8 L=0.15 W=2 nf=1 ad=0.58 as=0.58 pd=4.58 ps=4.58 nrd=0.145 nrs=0.145 sa=0 sb=0 sd=0 mult=1 m=1
XMPH_sp050_0 vp_sp050_0 enb vdd vdd sky130_fd_pr__pfet_01v8 L=0.15 W=4 nf=1 ad=1.16 as=1.16 pd=8.58 ps=8.58 nrd=0.0725 nrs=0.0725 sa=0 sb=0 sd=0 mult=1 m=1
bd_sp050_0 d_sp050_0 0 v=v(rbl_sp050_0)-v(ref_sp050_0)
bdabs_sp050_0 dabs_sp050_0 0 v=abs(v(rbl_sp050_0)-v(ref_sp050_0))

* ---- sp050_1: d = 50 mV, replica 1 ----
spa_sp050_1 pa_p050 rbl_sp050_1 ctl 0 swpre
crbl_sp050_1 rbl_sp050_1 0 {C_RBL}
spr_sp050_1 pref_100 ref_sp050_1 ctl 0 swpre
cref_sp050_1 ref_sp050_1 0 {C_RBL}   $ ASSUMPTION: ideal matched dummy load
XMN1_sp050_1 rbl_sp050_1 ref_sp050_1 vn_sp050_1 0 sky130_fd_pr__nfet_01v8 L=0.15 W=1 nf=1 ad=0.29 as=0.29 pd=2.58 ps=2.58 nrd=0.29 nrs=0.29 sa=0 sb=0 sd=0 mult=1 m=1
XMN2_sp050_1 ref_sp050_1 rbl_sp050_1 vn_sp050_1 0 sky130_fd_pr__nfet_01v8 L=0.15 W=1 nf=1 ad=0.29 as=0.29 pd=2.58 ps=2.58 nrd=0.29 nrs=0.29 sa=0 sb=0 sd=0 mult=1 m=1
XMP1_sp050_1 rbl_sp050_1 ref_sp050_1 vp_sp050_1 vdd sky130_fd_pr__pfet_01v8 L=0.15 W=2 nf=1 ad=0.58 as=0.58 pd=4.58 ps=4.58 nrd=0.145 nrs=0.145 sa=0 sb=0 sd=0 mult=1 m=1
XMP2_sp050_1 ref_sp050_1 rbl_sp050_1 vp_sp050_1 vdd sky130_fd_pr__pfet_01v8 L=0.15 W=2 nf=1 ad=0.58 as=0.58 pd=4.58 ps=4.58 nrd=0.145 nrs=0.145 sa=0 sb=0 sd=0 mult=1 m=1
XMNF_sp050_1 vn_sp050_1 en 0 0 sky130_fd_pr__nfet_01v8 L=0.15 W=2 nf=1 ad=0.58 as=0.58 pd=4.58 ps=4.58 nrd=0.145 nrs=0.145 sa=0 sb=0 sd=0 mult=1 m=1
XMPH_sp050_1 vp_sp050_1 enb vdd vdd sky130_fd_pr__pfet_01v8 L=0.15 W=4 nf=1 ad=1.16 as=1.16 pd=8.58 ps=8.58 nrd=0.0725 nrs=0.0725 sa=0 sb=0 sd=0 mult=1 m=1
bd_sp050_1 d_sp050_1 0 v=v(rbl_sp050_1)-v(ref_sp050_1)
bdabs_sp050_1 dabs_sp050_1 0 v=abs(v(rbl_sp050_1)-v(ref_sp050_1))

* ---- sp050_2: d = 50 mV, replica 2 ----
spa_sp050_2 pa_p050 rbl_sp050_2 ctl 0 swpre
crbl_sp050_2 rbl_sp050_2 0 {C_RBL}
spr_sp050_2 pref_100 ref_sp050_2 ctl 0 swpre
cref_sp050_2 ref_sp050_2 0 {C_RBL}   $ ASSUMPTION: ideal matched dummy load
XMN1_sp050_2 rbl_sp050_2 ref_sp050_2 vn_sp050_2 0 sky130_fd_pr__nfet_01v8 L=0.15 W=1 nf=1 ad=0.29 as=0.29 pd=2.58 ps=2.58 nrd=0.29 nrs=0.29 sa=0 sb=0 sd=0 mult=1 m=1
XMN2_sp050_2 ref_sp050_2 rbl_sp050_2 vn_sp050_2 0 sky130_fd_pr__nfet_01v8 L=0.15 W=1 nf=1 ad=0.29 as=0.29 pd=2.58 ps=2.58 nrd=0.29 nrs=0.29 sa=0 sb=0 sd=0 mult=1 m=1
XMP1_sp050_2 rbl_sp050_2 ref_sp050_2 vp_sp050_2 vdd sky130_fd_pr__pfet_01v8 L=0.15 W=2 nf=1 ad=0.58 as=0.58 pd=4.58 ps=4.58 nrd=0.145 nrs=0.145 sa=0 sb=0 sd=0 mult=1 m=1
XMP2_sp050_2 ref_sp050_2 rbl_sp050_2 vp_sp050_2 vdd sky130_fd_pr__pfet_01v8 L=0.15 W=2 nf=1 ad=0.58 as=0.58 pd=4.58 ps=4.58 nrd=0.145 nrs=0.145 sa=0 sb=0 sd=0 mult=1 m=1
XMNF_sp050_2 vn_sp050_2 en 0 0 sky130_fd_pr__nfet_01v8 L=0.15 W=2 nf=1 ad=0.58 as=0.58 pd=4.58 ps=4.58 nrd=0.145 nrs=0.145 sa=0 sb=0 sd=0 mult=1 m=1
XMPH_sp050_2 vp_sp050_2 enb vdd vdd sky130_fd_pr__pfet_01v8 L=0.15 W=4 nf=1 ad=1.16 as=1.16 pd=8.58 ps=8.58 nrd=0.0725 nrs=0.0725 sa=0 sb=0 sd=0 mult=1 m=1
bd_sp050_2 d_sp050_2 0 v=v(rbl_sp050_2)-v(ref_sp050_2)
bdabs_sp050_2 dabs_sp050_2 0 v=abs(v(rbl_sp050_2)-v(ref_sp050_2))

* ---- sp050_3: d = 50 mV, replica 3 ----
spa_sp050_3 pa_p050 rbl_sp050_3 ctl 0 swpre
crbl_sp050_3 rbl_sp050_3 0 {C_RBL}
spr_sp050_3 pref_100 ref_sp050_3 ctl 0 swpre
cref_sp050_3 ref_sp050_3 0 {C_RBL}   $ ASSUMPTION: ideal matched dummy load
XMN1_sp050_3 rbl_sp050_3 ref_sp050_3 vn_sp050_3 0 sky130_fd_pr__nfet_01v8 L=0.15 W=1 nf=1 ad=0.29 as=0.29 pd=2.58 ps=2.58 nrd=0.29 nrs=0.29 sa=0 sb=0 sd=0 mult=1 m=1
XMN2_sp050_3 ref_sp050_3 rbl_sp050_3 vn_sp050_3 0 sky130_fd_pr__nfet_01v8 L=0.15 W=1 nf=1 ad=0.29 as=0.29 pd=2.58 ps=2.58 nrd=0.29 nrs=0.29 sa=0 sb=0 sd=0 mult=1 m=1
XMP1_sp050_3 rbl_sp050_3 ref_sp050_3 vp_sp050_3 vdd sky130_fd_pr__pfet_01v8 L=0.15 W=2 nf=1 ad=0.58 as=0.58 pd=4.58 ps=4.58 nrd=0.145 nrs=0.145 sa=0 sb=0 sd=0 mult=1 m=1
XMP2_sp050_3 ref_sp050_3 rbl_sp050_3 vp_sp050_3 vdd sky130_fd_pr__pfet_01v8 L=0.15 W=2 nf=1 ad=0.58 as=0.58 pd=4.58 ps=4.58 nrd=0.145 nrs=0.145 sa=0 sb=0 sd=0 mult=1 m=1
XMNF_sp050_3 vn_sp050_3 en 0 0 sky130_fd_pr__nfet_01v8 L=0.15 W=2 nf=1 ad=0.58 as=0.58 pd=4.58 ps=4.58 nrd=0.145 nrs=0.145 sa=0 sb=0 sd=0 mult=1 m=1
XMPH_sp050_3 vp_sp050_3 enb vdd vdd sky130_fd_pr__pfet_01v8 L=0.15 W=4 nf=1 ad=1.16 as=1.16 pd=8.58 ps=8.58 nrd=0.0725 nrs=0.0725 sa=0 sb=0 sd=0 mult=1 m=1
bd_sp050_3 d_sp050_3 0 v=v(rbl_sp050_3)-v(ref_sp050_3)
bdabs_sp050_3 dabs_sp050_3 0 v=abs(v(rbl_sp050_3)-v(ref_sp050_3))

* ---- sp050_4: d = 50 mV, replica 4 ----
spa_sp050_4 pa_p050 rbl_sp050_4 ctl 0 swpre
crbl_sp050_4 rbl_sp050_4 0 {C_RBL}
spr_sp050_4 pref_100 ref_sp050_4 ctl 0 swpre
cref_sp050_4 ref_sp050_4 0 {C_RBL}   $ ASSUMPTION: ideal matched dummy load
XMN1_sp050_4 rbl_sp050_4 ref_sp050_4 vn_sp050_4 0 sky130_fd_pr__nfet_01v8 L=0.15 W=1 nf=1 ad=0.29 as=0.29 pd=2.58 ps=2.58 nrd=0.29 nrs=0.29 sa=0 sb=0 sd=0 mult=1 m=1
XMN2_sp050_4 ref_sp050_4 rbl_sp050_4 vn_sp050_4 0 sky130_fd_pr__nfet_01v8 L=0.15 W=1 nf=1 ad=0.29 as=0.29 pd=2.58 ps=2.58 nrd=0.29 nrs=0.29 sa=0 sb=0 sd=0 mult=1 m=1
XMP1_sp050_4 rbl_sp050_4 ref_sp050_4 vp_sp050_4 vdd sky130_fd_pr__pfet_01v8 L=0.15 W=2 nf=1 ad=0.58 as=0.58 pd=4.58 ps=4.58 nrd=0.145 nrs=0.145 sa=0 sb=0 sd=0 mult=1 m=1
XMP2_sp050_4 ref_sp050_4 rbl_sp050_4 vp_sp050_4 vdd sky130_fd_pr__pfet_01v8 L=0.15 W=2 nf=1 ad=0.58 as=0.58 pd=4.58 ps=4.58 nrd=0.145 nrs=0.145 sa=0 sb=0 sd=0 mult=1 m=1
XMNF_sp050_4 vn_sp050_4 en 0 0 sky130_fd_pr__nfet_01v8 L=0.15 W=2 nf=1 ad=0.58 as=0.58 pd=4.58 ps=4.58 nrd=0.145 nrs=0.145 sa=0 sb=0 sd=0 mult=1 m=1
XMPH_sp050_4 vp_sp050_4 enb vdd vdd sky130_fd_pr__pfet_01v8 L=0.15 W=4 nf=1 ad=1.16 as=1.16 pd=8.58 ps=8.58 nrd=0.0725 nrs=0.0725 sa=0 sb=0 sd=0 mult=1 m=1
bd_sp050_4 d_sp050_4 0 v=v(rbl_sp050_4)-v(ref_sp050_4)
bdabs_sp050_4 dabs_sp050_4 0 v=abs(v(rbl_sp050_4)-v(ref_sp050_4))

* ---- sp050_5: d = 50 mV, replica 5 ----
spa_sp050_5 pa_p050 rbl_sp050_5 ctl 0 swpre
crbl_sp050_5 rbl_sp050_5 0 {C_RBL}
spr_sp050_5 pref_100 ref_sp050_5 ctl 0 swpre
cref_sp050_5 ref_sp050_5 0 {C_RBL}   $ ASSUMPTION: ideal matched dummy load
XMN1_sp050_5 rbl_sp050_5 ref_sp050_5 vn_sp050_5 0 sky130_fd_pr__nfet_01v8 L=0.15 W=1 nf=1 ad=0.29 as=0.29 pd=2.58 ps=2.58 nrd=0.29 nrs=0.29 sa=0 sb=0 sd=0 mult=1 m=1
XMN2_sp050_5 ref_sp050_5 rbl_sp050_5 vn_sp050_5 0 sky130_fd_pr__nfet_01v8 L=0.15 W=1 nf=1 ad=0.29 as=0.29 pd=2.58 ps=2.58 nrd=0.29 nrs=0.29 sa=0 sb=0 sd=0 mult=1 m=1
XMP1_sp050_5 rbl_sp050_5 ref_sp050_5 vp_sp050_5 vdd sky130_fd_pr__pfet_01v8 L=0.15 W=2 nf=1 ad=0.58 as=0.58 pd=4.58 ps=4.58 nrd=0.145 nrs=0.145 sa=0 sb=0 sd=0 mult=1 m=1
XMP2_sp050_5 ref_sp050_5 rbl_sp050_5 vp_sp050_5 vdd sky130_fd_pr__pfet_01v8 L=0.15 W=2 nf=1 ad=0.58 as=0.58 pd=4.58 ps=4.58 nrd=0.145 nrs=0.145 sa=0 sb=0 sd=0 mult=1 m=1
XMNF_sp050_5 vn_sp050_5 en 0 0 sky130_fd_pr__nfet_01v8 L=0.15 W=2 nf=1 ad=0.58 as=0.58 pd=4.58 ps=4.58 nrd=0.145 nrs=0.145 sa=0 sb=0 sd=0 mult=1 m=1
XMPH_sp050_5 vp_sp050_5 enb vdd vdd sky130_fd_pr__pfet_01v8 L=0.15 W=4 nf=1 ad=1.16 as=1.16 pd=8.58 ps=8.58 nrd=0.0725 nrs=0.0725 sa=0 sb=0 sd=0 mult=1 m=1
bd_sp050_5 d_sp050_5 0 v=v(rbl_sp050_5)-v(ref_sp050_5)
bdabs_sp050_5 dabs_sp050_5 0 v=abs(v(rbl_sp050_5)-v(ref_sp050_5))

* ---- sm050_0: d = -50 mV, replica 0 ----
spa_sm050_0 pa_m050 rbl_sm050_0 ctl 0 swpre
crbl_sm050_0 rbl_sm050_0 0 {C_RBL}
spr_sm050_0 pref_100 ref_sm050_0 ctl 0 swpre
cref_sm050_0 ref_sm050_0 0 {C_RBL}   $ ASSUMPTION: ideal matched dummy load
XMN1_sm050_0 rbl_sm050_0 ref_sm050_0 vn_sm050_0 0 sky130_fd_pr__nfet_01v8 L=0.15 W=1 nf=1 ad=0.29 as=0.29 pd=2.58 ps=2.58 nrd=0.29 nrs=0.29 sa=0 sb=0 sd=0 mult=1 m=1
XMN2_sm050_0 ref_sm050_0 rbl_sm050_0 vn_sm050_0 0 sky130_fd_pr__nfet_01v8 L=0.15 W=1 nf=1 ad=0.29 as=0.29 pd=2.58 ps=2.58 nrd=0.29 nrs=0.29 sa=0 sb=0 sd=0 mult=1 m=1
XMP1_sm050_0 rbl_sm050_0 ref_sm050_0 vp_sm050_0 vdd sky130_fd_pr__pfet_01v8 L=0.15 W=2 nf=1 ad=0.58 as=0.58 pd=4.58 ps=4.58 nrd=0.145 nrs=0.145 sa=0 sb=0 sd=0 mult=1 m=1
XMP2_sm050_0 ref_sm050_0 rbl_sm050_0 vp_sm050_0 vdd sky130_fd_pr__pfet_01v8 L=0.15 W=2 nf=1 ad=0.58 as=0.58 pd=4.58 ps=4.58 nrd=0.145 nrs=0.145 sa=0 sb=0 sd=0 mult=1 m=1
XMNF_sm050_0 vn_sm050_0 en 0 0 sky130_fd_pr__nfet_01v8 L=0.15 W=2 nf=1 ad=0.58 as=0.58 pd=4.58 ps=4.58 nrd=0.145 nrs=0.145 sa=0 sb=0 sd=0 mult=1 m=1
XMPH_sm050_0 vp_sm050_0 enb vdd vdd sky130_fd_pr__pfet_01v8 L=0.15 W=4 nf=1 ad=1.16 as=1.16 pd=8.58 ps=8.58 nrd=0.0725 nrs=0.0725 sa=0 sb=0 sd=0 mult=1 m=1
bd_sm050_0 d_sm050_0 0 v=v(rbl_sm050_0)-v(ref_sm050_0)
bdabs_sm050_0 dabs_sm050_0 0 v=abs(v(rbl_sm050_0)-v(ref_sm050_0))

* ---- sm050_1: d = -50 mV, replica 1 ----
spa_sm050_1 pa_m050 rbl_sm050_1 ctl 0 swpre
crbl_sm050_1 rbl_sm050_1 0 {C_RBL}
spr_sm050_1 pref_100 ref_sm050_1 ctl 0 swpre
cref_sm050_1 ref_sm050_1 0 {C_RBL}   $ ASSUMPTION: ideal matched dummy load
XMN1_sm050_1 rbl_sm050_1 ref_sm050_1 vn_sm050_1 0 sky130_fd_pr__nfet_01v8 L=0.15 W=1 nf=1 ad=0.29 as=0.29 pd=2.58 ps=2.58 nrd=0.29 nrs=0.29 sa=0 sb=0 sd=0 mult=1 m=1
XMN2_sm050_1 ref_sm050_1 rbl_sm050_1 vn_sm050_1 0 sky130_fd_pr__nfet_01v8 L=0.15 W=1 nf=1 ad=0.29 as=0.29 pd=2.58 ps=2.58 nrd=0.29 nrs=0.29 sa=0 sb=0 sd=0 mult=1 m=1
XMP1_sm050_1 rbl_sm050_1 ref_sm050_1 vp_sm050_1 vdd sky130_fd_pr__pfet_01v8 L=0.15 W=2 nf=1 ad=0.58 as=0.58 pd=4.58 ps=4.58 nrd=0.145 nrs=0.145 sa=0 sb=0 sd=0 mult=1 m=1
XMP2_sm050_1 ref_sm050_1 rbl_sm050_1 vp_sm050_1 vdd sky130_fd_pr__pfet_01v8 L=0.15 W=2 nf=1 ad=0.58 as=0.58 pd=4.58 ps=4.58 nrd=0.145 nrs=0.145 sa=0 sb=0 sd=0 mult=1 m=1
XMNF_sm050_1 vn_sm050_1 en 0 0 sky130_fd_pr__nfet_01v8 L=0.15 W=2 nf=1 ad=0.58 as=0.58 pd=4.58 ps=4.58 nrd=0.145 nrs=0.145 sa=0 sb=0 sd=0 mult=1 m=1
XMPH_sm050_1 vp_sm050_1 enb vdd vdd sky130_fd_pr__pfet_01v8 L=0.15 W=4 nf=1 ad=1.16 as=1.16 pd=8.58 ps=8.58 nrd=0.0725 nrs=0.0725 sa=0 sb=0 sd=0 mult=1 m=1
bd_sm050_1 d_sm050_1 0 v=v(rbl_sm050_1)-v(ref_sm050_1)
bdabs_sm050_1 dabs_sm050_1 0 v=abs(v(rbl_sm050_1)-v(ref_sm050_1))

* ---- sm050_2: d = -50 mV, replica 2 ----
spa_sm050_2 pa_m050 rbl_sm050_2 ctl 0 swpre
crbl_sm050_2 rbl_sm050_2 0 {C_RBL}
spr_sm050_2 pref_100 ref_sm050_2 ctl 0 swpre
cref_sm050_2 ref_sm050_2 0 {C_RBL}   $ ASSUMPTION: ideal matched dummy load
XMN1_sm050_2 rbl_sm050_2 ref_sm050_2 vn_sm050_2 0 sky130_fd_pr__nfet_01v8 L=0.15 W=1 nf=1 ad=0.29 as=0.29 pd=2.58 ps=2.58 nrd=0.29 nrs=0.29 sa=0 sb=0 sd=0 mult=1 m=1
XMN2_sm050_2 ref_sm050_2 rbl_sm050_2 vn_sm050_2 0 sky130_fd_pr__nfet_01v8 L=0.15 W=1 nf=1 ad=0.29 as=0.29 pd=2.58 ps=2.58 nrd=0.29 nrs=0.29 sa=0 sb=0 sd=0 mult=1 m=1
XMP1_sm050_2 rbl_sm050_2 ref_sm050_2 vp_sm050_2 vdd sky130_fd_pr__pfet_01v8 L=0.15 W=2 nf=1 ad=0.58 as=0.58 pd=4.58 ps=4.58 nrd=0.145 nrs=0.145 sa=0 sb=0 sd=0 mult=1 m=1
XMP2_sm050_2 ref_sm050_2 rbl_sm050_2 vp_sm050_2 vdd sky130_fd_pr__pfet_01v8 L=0.15 W=2 nf=1 ad=0.58 as=0.58 pd=4.58 ps=4.58 nrd=0.145 nrs=0.145 sa=0 sb=0 sd=0 mult=1 m=1
XMNF_sm050_2 vn_sm050_2 en 0 0 sky130_fd_pr__nfet_01v8 L=0.15 W=2 nf=1 ad=0.58 as=0.58 pd=4.58 ps=4.58 nrd=0.145 nrs=0.145 sa=0 sb=0 sd=0 mult=1 m=1
XMPH_sm050_2 vp_sm050_2 enb vdd vdd sky130_fd_pr__pfet_01v8 L=0.15 W=4 nf=1 ad=1.16 as=1.16 pd=8.58 ps=8.58 nrd=0.0725 nrs=0.0725 sa=0 sb=0 sd=0 mult=1 m=1
bd_sm050_2 d_sm050_2 0 v=v(rbl_sm050_2)-v(ref_sm050_2)
bdabs_sm050_2 dabs_sm050_2 0 v=abs(v(rbl_sm050_2)-v(ref_sm050_2))

* ---- sm050_3: d = -50 mV, replica 3 ----
spa_sm050_3 pa_m050 rbl_sm050_3 ctl 0 swpre
crbl_sm050_3 rbl_sm050_3 0 {C_RBL}
spr_sm050_3 pref_100 ref_sm050_3 ctl 0 swpre
cref_sm050_3 ref_sm050_3 0 {C_RBL}   $ ASSUMPTION: ideal matched dummy load
XMN1_sm050_3 rbl_sm050_3 ref_sm050_3 vn_sm050_3 0 sky130_fd_pr__nfet_01v8 L=0.15 W=1 nf=1 ad=0.29 as=0.29 pd=2.58 ps=2.58 nrd=0.29 nrs=0.29 sa=0 sb=0 sd=0 mult=1 m=1
XMN2_sm050_3 ref_sm050_3 rbl_sm050_3 vn_sm050_3 0 sky130_fd_pr__nfet_01v8 L=0.15 W=1 nf=1 ad=0.29 as=0.29 pd=2.58 ps=2.58 nrd=0.29 nrs=0.29 sa=0 sb=0 sd=0 mult=1 m=1
XMP1_sm050_3 rbl_sm050_3 ref_sm050_3 vp_sm050_3 vdd sky130_fd_pr__pfet_01v8 L=0.15 W=2 nf=1 ad=0.58 as=0.58 pd=4.58 ps=4.58 nrd=0.145 nrs=0.145 sa=0 sb=0 sd=0 mult=1 m=1
XMP2_sm050_3 ref_sm050_3 rbl_sm050_3 vp_sm050_3 vdd sky130_fd_pr__pfet_01v8 L=0.15 W=2 nf=1 ad=0.58 as=0.58 pd=4.58 ps=4.58 nrd=0.145 nrs=0.145 sa=0 sb=0 sd=0 mult=1 m=1
XMNF_sm050_3 vn_sm050_3 en 0 0 sky130_fd_pr__nfet_01v8 L=0.15 W=2 nf=1 ad=0.58 as=0.58 pd=4.58 ps=4.58 nrd=0.145 nrs=0.145 sa=0 sb=0 sd=0 mult=1 m=1
XMPH_sm050_3 vp_sm050_3 enb vdd vdd sky130_fd_pr__pfet_01v8 L=0.15 W=4 nf=1 ad=1.16 as=1.16 pd=8.58 ps=8.58 nrd=0.0725 nrs=0.0725 sa=0 sb=0 sd=0 mult=1 m=1
bd_sm050_3 d_sm050_3 0 v=v(rbl_sm050_3)-v(ref_sm050_3)
bdabs_sm050_3 dabs_sm050_3 0 v=abs(v(rbl_sm050_3)-v(ref_sm050_3))

* ---- sm050_4: d = -50 mV, replica 4 ----
spa_sm050_4 pa_m050 rbl_sm050_4 ctl 0 swpre
crbl_sm050_4 rbl_sm050_4 0 {C_RBL}
spr_sm050_4 pref_100 ref_sm050_4 ctl 0 swpre
cref_sm050_4 ref_sm050_4 0 {C_RBL}   $ ASSUMPTION: ideal matched dummy load
XMN1_sm050_4 rbl_sm050_4 ref_sm050_4 vn_sm050_4 0 sky130_fd_pr__nfet_01v8 L=0.15 W=1 nf=1 ad=0.29 as=0.29 pd=2.58 ps=2.58 nrd=0.29 nrs=0.29 sa=0 sb=0 sd=0 mult=1 m=1
XMN2_sm050_4 ref_sm050_4 rbl_sm050_4 vn_sm050_4 0 sky130_fd_pr__nfet_01v8 L=0.15 W=1 nf=1 ad=0.29 as=0.29 pd=2.58 ps=2.58 nrd=0.29 nrs=0.29 sa=0 sb=0 sd=0 mult=1 m=1
XMP1_sm050_4 rbl_sm050_4 ref_sm050_4 vp_sm050_4 vdd sky130_fd_pr__pfet_01v8 L=0.15 W=2 nf=1 ad=0.58 as=0.58 pd=4.58 ps=4.58 nrd=0.145 nrs=0.145 sa=0 sb=0 sd=0 mult=1 m=1
XMP2_sm050_4 ref_sm050_4 rbl_sm050_4 vp_sm050_4 vdd sky130_fd_pr__pfet_01v8 L=0.15 W=2 nf=1 ad=0.58 as=0.58 pd=4.58 ps=4.58 nrd=0.145 nrs=0.145 sa=0 sb=0 sd=0 mult=1 m=1
XMNF_sm050_4 vn_sm050_4 en 0 0 sky130_fd_pr__nfet_01v8 L=0.15 W=2 nf=1 ad=0.58 as=0.58 pd=4.58 ps=4.58 nrd=0.145 nrs=0.145 sa=0 sb=0 sd=0 mult=1 m=1
XMPH_sm050_4 vp_sm050_4 enb vdd vdd sky130_fd_pr__pfet_01v8 L=0.15 W=4 nf=1 ad=1.16 as=1.16 pd=8.58 ps=8.58 nrd=0.0725 nrs=0.0725 sa=0 sb=0 sd=0 mult=1 m=1
bd_sm050_4 d_sm050_4 0 v=v(rbl_sm050_4)-v(ref_sm050_4)
bdabs_sm050_4 dabs_sm050_4 0 v=abs(v(rbl_sm050_4)-v(ref_sm050_4))

* ---- sm050_5: d = -50 mV, replica 5 ----
spa_sm050_5 pa_m050 rbl_sm050_5 ctl 0 swpre
crbl_sm050_5 rbl_sm050_5 0 {C_RBL}
spr_sm050_5 pref_100 ref_sm050_5 ctl 0 swpre
cref_sm050_5 ref_sm050_5 0 {C_RBL}   $ ASSUMPTION: ideal matched dummy load
XMN1_sm050_5 rbl_sm050_5 ref_sm050_5 vn_sm050_5 0 sky130_fd_pr__nfet_01v8 L=0.15 W=1 nf=1 ad=0.29 as=0.29 pd=2.58 ps=2.58 nrd=0.29 nrs=0.29 sa=0 sb=0 sd=0 mult=1 m=1
XMN2_sm050_5 ref_sm050_5 rbl_sm050_5 vn_sm050_5 0 sky130_fd_pr__nfet_01v8 L=0.15 W=1 nf=1 ad=0.29 as=0.29 pd=2.58 ps=2.58 nrd=0.29 nrs=0.29 sa=0 sb=0 sd=0 mult=1 m=1
XMP1_sm050_5 rbl_sm050_5 ref_sm050_5 vp_sm050_5 vdd sky130_fd_pr__pfet_01v8 L=0.15 W=2 nf=1 ad=0.58 as=0.58 pd=4.58 ps=4.58 nrd=0.145 nrs=0.145 sa=0 sb=0 sd=0 mult=1 m=1
XMP2_sm050_5 ref_sm050_5 rbl_sm050_5 vp_sm050_5 vdd sky130_fd_pr__pfet_01v8 L=0.15 W=2 nf=1 ad=0.58 as=0.58 pd=4.58 ps=4.58 nrd=0.145 nrs=0.145 sa=0 sb=0 sd=0 mult=1 m=1
XMNF_sm050_5 vn_sm050_5 en 0 0 sky130_fd_pr__nfet_01v8 L=0.15 W=2 nf=1 ad=0.58 as=0.58 pd=4.58 ps=4.58 nrd=0.145 nrs=0.145 sa=0 sb=0 sd=0 mult=1 m=1
XMPH_sm050_5 vp_sm050_5 enb vdd vdd sky130_fd_pr__pfet_01v8 L=0.15 W=4 nf=1 ad=1.16 as=1.16 pd=8.58 ps=8.58 nrd=0.0725 nrs=0.0725 sa=0 sb=0 sd=0 mult=1 m=1
bd_sm050_5 d_sm050_5 0 v=v(rbl_sm050_5)-v(ref_sm050_5)
bdabs_sm050_5 dabs_sm050_5 0 v=abs(v(rbl_sm050_5)-v(ref_sm050_5))

* ---- sp060_0: d = 60 mV, replica 0 ----
spa_sp060_0 pa_p060 rbl_sp060_0 ctl 0 swpre
crbl_sp060_0 rbl_sp060_0 0 {C_RBL}
spr_sp060_0 pref_100 ref_sp060_0 ctl 0 swpre
cref_sp060_0 ref_sp060_0 0 {C_RBL}   $ ASSUMPTION: ideal matched dummy load
XMN1_sp060_0 rbl_sp060_0 ref_sp060_0 vn_sp060_0 0 sky130_fd_pr__nfet_01v8 L=0.15 W=1 nf=1 ad=0.29 as=0.29 pd=2.58 ps=2.58 nrd=0.29 nrs=0.29 sa=0 sb=0 sd=0 mult=1 m=1
XMN2_sp060_0 ref_sp060_0 rbl_sp060_0 vn_sp060_0 0 sky130_fd_pr__nfet_01v8 L=0.15 W=1 nf=1 ad=0.29 as=0.29 pd=2.58 ps=2.58 nrd=0.29 nrs=0.29 sa=0 sb=0 sd=0 mult=1 m=1
XMP1_sp060_0 rbl_sp060_0 ref_sp060_0 vp_sp060_0 vdd sky130_fd_pr__pfet_01v8 L=0.15 W=2 nf=1 ad=0.58 as=0.58 pd=4.58 ps=4.58 nrd=0.145 nrs=0.145 sa=0 sb=0 sd=0 mult=1 m=1
XMP2_sp060_0 ref_sp060_0 rbl_sp060_0 vp_sp060_0 vdd sky130_fd_pr__pfet_01v8 L=0.15 W=2 nf=1 ad=0.58 as=0.58 pd=4.58 ps=4.58 nrd=0.145 nrs=0.145 sa=0 sb=0 sd=0 mult=1 m=1
XMNF_sp060_0 vn_sp060_0 en 0 0 sky130_fd_pr__nfet_01v8 L=0.15 W=2 nf=1 ad=0.58 as=0.58 pd=4.58 ps=4.58 nrd=0.145 nrs=0.145 sa=0 sb=0 sd=0 mult=1 m=1
XMPH_sp060_0 vp_sp060_0 enb vdd vdd sky130_fd_pr__pfet_01v8 L=0.15 W=4 nf=1 ad=1.16 as=1.16 pd=8.58 ps=8.58 nrd=0.0725 nrs=0.0725 sa=0 sb=0 sd=0 mult=1 m=1
bd_sp060_0 d_sp060_0 0 v=v(rbl_sp060_0)-v(ref_sp060_0)
bdabs_sp060_0 dabs_sp060_0 0 v=abs(v(rbl_sp060_0)-v(ref_sp060_0))

* ---- sp060_1: d = 60 mV, replica 1 ----
spa_sp060_1 pa_p060 rbl_sp060_1 ctl 0 swpre
crbl_sp060_1 rbl_sp060_1 0 {C_RBL}
spr_sp060_1 pref_100 ref_sp060_1 ctl 0 swpre
cref_sp060_1 ref_sp060_1 0 {C_RBL}   $ ASSUMPTION: ideal matched dummy load
XMN1_sp060_1 rbl_sp060_1 ref_sp060_1 vn_sp060_1 0 sky130_fd_pr__nfet_01v8 L=0.15 W=1 nf=1 ad=0.29 as=0.29 pd=2.58 ps=2.58 nrd=0.29 nrs=0.29 sa=0 sb=0 sd=0 mult=1 m=1
XMN2_sp060_1 ref_sp060_1 rbl_sp060_1 vn_sp060_1 0 sky130_fd_pr__nfet_01v8 L=0.15 W=1 nf=1 ad=0.29 as=0.29 pd=2.58 ps=2.58 nrd=0.29 nrs=0.29 sa=0 sb=0 sd=0 mult=1 m=1
XMP1_sp060_1 rbl_sp060_1 ref_sp060_1 vp_sp060_1 vdd sky130_fd_pr__pfet_01v8 L=0.15 W=2 nf=1 ad=0.58 as=0.58 pd=4.58 ps=4.58 nrd=0.145 nrs=0.145 sa=0 sb=0 sd=0 mult=1 m=1
XMP2_sp060_1 ref_sp060_1 rbl_sp060_1 vp_sp060_1 vdd sky130_fd_pr__pfet_01v8 L=0.15 W=2 nf=1 ad=0.58 as=0.58 pd=4.58 ps=4.58 nrd=0.145 nrs=0.145 sa=0 sb=0 sd=0 mult=1 m=1
XMNF_sp060_1 vn_sp060_1 en 0 0 sky130_fd_pr__nfet_01v8 L=0.15 W=2 nf=1 ad=0.58 as=0.58 pd=4.58 ps=4.58 nrd=0.145 nrs=0.145 sa=0 sb=0 sd=0 mult=1 m=1
XMPH_sp060_1 vp_sp060_1 enb vdd vdd sky130_fd_pr__pfet_01v8 L=0.15 W=4 nf=1 ad=1.16 as=1.16 pd=8.58 ps=8.58 nrd=0.0725 nrs=0.0725 sa=0 sb=0 sd=0 mult=1 m=1
bd_sp060_1 d_sp060_1 0 v=v(rbl_sp060_1)-v(ref_sp060_1)
bdabs_sp060_1 dabs_sp060_1 0 v=abs(v(rbl_sp060_1)-v(ref_sp060_1))

* ---- sp060_2: d = 60 mV, replica 2 ----
spa_sp060_2 pa_p060 rbl_sp060_2 ctl 0 swpre
crbl_sp060_2 rbl_sp060_2 0 {C_RBL}
spr_sp060_2 pref_100 ref_sp060_2 ctl 0 swpre
cref_sp060_2 ref_sp060_2 0 {C_RBL}   $ ASSUMPTION: ideal matched dummy load
XMN1_sp060_2 rbl_sp060_2 ref_sp060_2 vn_sp060_2 0 sky130_fd_pr__nfet_01v8 L=0.15 W=1 nf=1 ad=0.29 as=0.29 pd=2.58 ps=2.58 nrd=0.29 nrs=0.29 sa=0 sb=0 sd=0 mult=1 m=1
XMN2_sp060_2 ref_sp060_2 rbl_sp060_2 vn_sp060_2 0 sky130_fd_pr__nfet_01v8 L=0.15 W=1 nf=1 ad=0.29 as=0.29 pd=2.58 ps=2.58 nrd=0.29 nrs=0.29 sa=0 sb=0 sd=0 mult=1 m=1
XMP1_sp060_2 rbl_sp060_2 ref_sp060_2 vp_sp060_2 vdd sky130_fd_pr__pfet_01v8 L=0.15 W=2 nf=1 ad=0.58 as=0.58 pd=4.58 ps=4.58 nrd=0.145 nrs=0.145 sa=0 sb=0 sd=0 mult=1 m=1
XMP2_sp060_2 ref_sp060_2 rbl_sp060_2 vp_sp060_2 vdd sky130_fd_pr__pfet_01v8 L=0.15 W=2 nf=1 ad=0.58 as=0.58 pd=4.58 ps=4.58 nrd=0.145 nrs=0.145 sa=0 sb=0 sd=0 mult=1 m=1
XMNF_sp060_2 vn_sp060_2 en 0 0 sky130_fd_pr__nfet_01v8 L=0.15 W=2 nf=1 ad=0.58 as=0.58 pd=4.58 ps=4.58 nrd=0.145 nrs=0.145 sa=0 sb=0 sd=0 mult=1 m=1
XMPH_sp060_2 vp_sp060_2 enb vdd vdd sky130_fd_pr__pfet_01v8 L=0.15 W=4 nf=1 ad=1.16 as=1.16 pd=8.58 ps=8.58 nrd=0.0725 nrs=0.0725 sa=0 sb=0 sd=0 mult=1 m=1
bd_sp060_2 d_sp060_2 0 v=v(rbl_sp060_2)-v(ref_sp060_2)
bdabs_sp060_2 dabs_sp060_2 0 v=abs(v(rbl_sp060_2)-v(ref_sp060_2))

* ---- sp060_3: d = 60 mV, replica 3 ----
spa_sp060_3 pa_p060 rbl_sp060_3 ctl 0 swpre
crbl_sp060_3 rbl_sp060_3 0 {C_RBL}
spr_sp060_3 pref_100 ref_sp060_3 ctl 0 swpre
cref_sp060_3 ref_sp060_3 0 {C_RBL}   $ ASSUMPTION: ideal matched dummy load
XMN1_sp060_3 rbl_sp060_3 ref_sp060_3 vn_sp060_3 0 sky130_fd_pr__nfet_01v8 L=0.15 W=1 nf=1 ad=0.29 as=0.29 pd=2.58 ps=2.58 nrd=0.29 nrs=0.29 sa=0 sb=0 sd=0 mult=1 m=1
XMN2_sp060_3 ref_sp060_3 rbl_sp060_3 vn_sp060_3 0 sky130_fd_pr__nfet_01v8 L=0.15 W=1 nf=1 ad=0.29 as=0.29 pd=2.58 ps=2.58 nrd=0.29 nrs=0.29 sa=0 sb=0 sd=0 mult=1 m=1
XMP1_sp060_3 rbl_sp060_3 ref_sp060_3 vp_sp060_3 vdd sky130_fd_pr__pfet_01v8 L=0.15 W=2 nf=1 ad=0.58 as=0.58 pd=4.58 ps=4.58 nrd=0.145 nrs=0.145 sa=0 sb=0 sd=0 mult=1 m=1
XMP2_sp060_3 ref_sp060_3 rbl_sp060_3 vp_sp060_3 vdd sky130_fd_pr__pfet_01v8 L=0.15 W=2 nf=1 ad=0.58 as=0.58 pd=4.58 ps=4.58 nrd=0.145 nrs=0.145 sa=0 sb=0 sd=0 mult=1 m=1
XMNF_sp060_3 vn_sp060_3 en 0 0 sky130_fd_pr__nfet_01v8 L=0.15 W=2 nf=1 ad=0.58 as=0.58 pd=4.58 ps=4.58 nrd=0.145 nrs=0.145 sa=0 sb=0 sd=0 mult=1 m=1
XMPH_sp060_3 vp_sp060_3 enb vdd vdd sky130_fd_pr__pfet_01v8 L=0.15 W=4 nf=1 ad=1.16 as=1.16 pd=8.58 ps=8.58 nrd=0.0725 nrs=0.0725 sa=0 sb=0 sd=0 mult=1 m=1
bd_sp060_3 d_sp060_3 0 v=v(rbl_sp060_3)-v(ref_sp060_3)
bdabs_sp060_3 dabs_sp060_3 0 v=abs(v(rbl_sp060_3)-v(ref_sp060_3))

* ---- sp060_4: d = 60 mV, replica 4 ----
spa_sp060_4 pa_p060 rbl_sp060_4 ctl 0 swpre
crbl_sp060_4 rbl_sp060_4 0 {C_RBL}
spr_sp060_4 pref_100 ref_sp060_4 ctl 0 swpre
cref_sp060_4 ref_sp060_4 0 {C_RBL}   $ ASSUMPTION: ideal matched dummy load
XMN1_sp060_4 rbl_sp060_4 ref_sp060_4 vn_sp060_4 0 sky130_fd_pr__nfet_01v8 L=0.15 W=1 nf=1 ad=0.29 as=0.29 pd=2.58 ps=2.58 nrd=0.29 nrs=0.29 sa=0 sb=0 sd=0 mult=1 m=1
XMN2_sp060_4 ref_sp060_4 rbl_sp060_4 vn_sp060_4 0 sky130_fd_pr__nfet_01v8 L=0.15 W=1 nf=1 ad=0.29 as=0.29 pd=2.58 ps=2.58 nrd=0.29 nrs=0.29 sa=0 sb=0 sd=0 mult=1 m=1
XMP1_sp060_4 rbl_sp060_4 ref_sp060_4 vp_sp060_4 vdd sky130_fd_pr__pfet_01v8 L=0.15 W=2 nf=1 ad=0.58 as=0.58 pd=4.58 ps=4.58 nrd=0.145 nrs=0.145 sa=0 sb=0 sd=0 mult=1 m=1
XMP2_sp060_4 ref_sp060_4 rbl_sp060_4 vp_sp060_4 vdd sky130_fd_pr__pfet_01v8 L=0.15 W=2 nf=1 ad=0.58 as=0.58 pd=4.58 ps=4.58 nrd=0.145 nrs=0.145 sa=0 sb=0 sd=0 mult=1 m=1
XMNF_sp060_4 vn_sp060_4 en 0 0 sky130_fd_pr__nfet_01v8 L=0.15 W=2 nf=1 ad=0.58 as=0.58 pd=4.58 ps=4.58 nrd=0.145 nrs=0.145 sa=0 sb=0 sd=0 mult=1 m=1
XMPH_sp060_4 vp_sp060_4 enb vdd vdd sky130_fd_pr__pfet_01v8 L=0.15 W=4 nf=1 ad=1.16 as=1.16 pd=8.58 ps=8.58 nrd=0.0725 nrs=0.0725 sa=0 sb=0 sd=0 mult=1 m=1
bd_sp060_4 d_sp060_4 0 v=v(rbl_sp060_4)-v(ref_sp060_4)
bdabs_sp060_4 dabs_sp060_4 0 v=abs(v(rbl_sp060_4)-v(ref_sp060_4))

* ---- sp060_5: d = 60 mV, replica 5 ----
spa_sp060_5 pa_p060 rbl_sp060_5 ctl 0 swpre
crbl_sp060_5 rbl_sp060_5 0 {C_RBL}
spr_sp060_5 pref_100 ref_sp060_5 ctl 0 swpre
cref_sp060_5 ref_sp060_5 0 {C_RBL}   $ ASSUMPTION: ideal matched dummy load
XMN1_sp060_5 rbl_sp060_5 ref_sp060_5 vn_sp060_5 0 sky130_fd_pr__nfet_01v8 L=0.15 W=1 nf=1 ad=0.29 as=0.29 pd=2.58 ps=2.58 nrd=0.29 nrs=0.29 sa=0 sb=0 sd=0 mult=1 m=1
XMN2_sp060_5 ref_sp060_5 rbl_sp060_5 vn_sp060_5 0 sky130_fd_pr__nfet_01v8 L=0.15 W=1 nf=1 ad=0.29 as=0.29 pd=2.58 ps=2.58 nrd=0.29 nrs=0.29 sa=0 sb=0 sd=0 mult=1 m=1
XMP1_sp060_5 rbl_sp060_5 ref_sp060_5 vp_sp060_5 vdd sky130_fd_pr__pfet_01v8 L=0.15 W=2 nf=1 ad=0.58 as=0.58 pd=4.58 ps=4.58 nrd=0.145 nrs=0.145 sa=0 sb=0 sd=0 mult=1 m=1
XMP2_sp060_5 ref_sp060_5 rbl_sp060_5 vp_sp060_5 vdd sky130_fd_pr__pfet_01v8 L=0.15 W=2 nf=1 ad=0.58 as=0.58 pd=4.58 ps=4.58 nrd=0.145 nrs=0.145 sa=0 sb=0 sd=0 mult=1 m=1
XMNF_sp060_5 vn_sp060_5 en 0 0 sky130_fd_pr__nfet_01v8 L=0.15 W=2 nf=1 ad=0.58 as=0.58 pd=4.58 ps=4.58 nrd=0.145 nrs=0.145 sa=0 sb=0 sd=0 mult=1 m=1
XMPH_sp060_5 vp_sp060_5 enb vdd vdd sky130_fd_pr__pfet_01v8 L=0.15 W=4 nf=1 ad=1.16 as=1.16 pd=8.58 ps=8.58 nrd=0.0725 nrs=0.0725 sa=0 sb=0 sd=0 mult=1 m=1
bd_sp060_5 d_sp060_5 0 v=v(rbl_sp060_5)-v(ref_sp060_5)
bdabs_sp060_5 dabs_sp060_5 0 v=abs(v(rbl_sp060_5)-v(ref_sp060_5))

* ---- sm060_0: d = -60 mV, replica 0 ----
spa_sm060_0 pa_m060 rbl_sm060_0 ctl 0 swpre
crbl_sm060_0 rbl_sm060_0 0 {C_RBL}
spr_sm060_0 pref_100 ref_sm060_0 ctl 0 swpre
cref_sm060_0 ref_sm060_0 0 {C_RBL}   $ ASSUMPTION: ideal matched dummy load
XMN1_sm060_0 rbl_sm060_0 ref_sm060_0 vn_sm060_0 0 sky130_fd_pr__nfet_01v8 L=0.15 W=1 nf=1 ad=0.29 as=0.29 pd=2.58 ps=2.58 nrd=0.29 nrs=0.29 sa=0 sb=0 sd=0 mult=1 m=1
XMN2_sm060_0 ref_sm060_0 rbl_sm060_0 vn_sm060_0 0 sky130_fd_pr__nfet_01v8 L=0.15 W=1 nf=1 ad=0.29 as=0.29 pd=2.58 ps=2.58 nrd=0.29 nrs=0.29 sa=0 sb=0 sd=0 mult=1 m=1
XMP1_sm060_0 rbl_sm060_0 ref_sm060_0 vp_sm060_0 vdd sky130_fd_pr__pfet_01v8 L=0.15 W=2 nf=1 ad=0.58 as=0.58 pd=4.58 ps=4.58 nrd=0.145 nrs=0.145 sa=0 sb=0 sd=0 mult=1 m=1
XMP2_sm060_0 ref_sm060_0 rbl_sm060_0 vp_sm060_0 vdd sky130_fd_pr__pfet_01v8 L=0.15 W=2 nf=1 ad=0.58 as=0.58 pd=4.58 ps=4.58 nrd=0.145 nrs=0.145 sa=0 sb=0 sd=0 mult=1 m=1
XMNF_sm060_0 vn_sm060_0 en 0 0 sky130_fd_pr__nfet_01v8 L=0.15 W=2 nf=1 ad=0.58 as=0.58 pd=4.58 ps=4.58 nrd=0.145 nrs=0.145 sa=0 sb=0 sd=0 mult=1 m=1
XMPH_sm060_0 vp_sm060_0 enb vdd vdd sky130_fd_pr__pfet_01v8 L=0.15 W=4 nf=1 ad=1.16 as=1.16 pd=8.58 ps=8.58 nrd=0.0725 nrs=0.0725 sa=0 sb=0 sd=0 mult=1 m=1
bd_sm060_0 d_sm060_0 0 v=v(rbl_sm060_0)-v(ref_sm060_0)
bdabs_sm060_0 dabs_sm060_0 0 v=abs(v(rbl_sm060_0)-v(ref_sm060_0))

* ---- sm060_1: d = -60 mV, replica 1 ----
spa_sm060_1 pa_m060 rbl_sm060_1 ctl 0 swpre
crbl_sm060_1 rbl_sm060_1 0 {C_RBL}
spr_sm060_1 pref_100 ref_sm060_1 ctl 0 swpre
cref_sm060_1 ref_sm060_1 0 {C_RBL}   $ ASSUMPTION: ideal matched dummy load
XMN1_sm060_1 rbl_sm060_1 ref_sm060_1 vn_sm060_1 0 sky130_fd_pr__nfet_01v8 L=0.15 W=1 nf=1 ad=0.29 as=0.29 pd=2.58 ps=2.58 nrd=0.29 nrs=0.29 sa=0 sb=0 sd=0 mult=1 m=1
XMN2_sm060_1 ref_sm060_1 rbl_sm060_1 vn_sm060_1 0 sky130_fd_pr__nfet_01v8 L=0.15 W=1 nf=1 ad=0.29 as=0.29 pd=2.58 ps=2.58 nrd=0.29 nrs=0.29 sa=0 sb=0 sd=0 mult=1 m=1
XMP1_sm060_1 rbl_sm060_1 ref_sm060_1 vp_sm060_1 vdd sky130_fd_pr__pfet_01v8 L=0.15 W=2 nf=1 ad=0.58 as=0.58 pd=4.58 ps=4.58 nrd=0.145 nrs=0.145 sa=0 sb=0 sd=0 mult=1 m=1
XMP2_sm060_1 ref_sm060_1 rbl_sm060_1 vp_sm060_1 vdd sky130_fd_pr__pfet_01v8 L=0.15 W=2 nf=1 ad=0.58 as=0.58 pd=4.58 ps=4.58 nrd=0.145 nrs=0.145 sa=0 sb=0 sd=0 mult=1 m=1
XMNF_sm060_1 vn_sm060_1 en 0 0 sky130_fd_pr__nfet_01v8 L=0.15 W=2 nf=1 ad=0.58 as=0.58 pd=4.58 ps=4.58 nrd=0.145 nrs=0.145 sa=0 sb=0 sd=0 mult=1 m=1
XMPH_sm060_1 vp_sm060_1 enb vdd vdd sky130_fd_pr__pfet_01v8 L=0.15 W=4 nf=1 ad=1.16 as=1.16 pd=8.58 ps=8.58 nrd=0.0725 nrs=0.0725 sa=0 sb=0 sd=0 mult=1 m=1
bd_sm060_1 d_sm060_1 0 v=v(rbl_sm060_1)-v(ref_sm060_1)
bdabs_sm060_1 dabs_sm060_1 0 v=abs(v(rbl_sm060_1)-v(ref_sm060_1))

* ---- sm060_2: d = -60 mV, replica 2 ----
spa_sm060_2 pa_m060 rbl_sm060_2 ctl 0 swpre
crbl_sm060_2 rbl_sm060_2 0 {C_RBL}
spr_sm060_2 pref_100 ref_sm060_2 ctl 0 swpre
cref_sm060_2 ref_sm060_2 0 {C_RBL}   $ ASSUMPTION: ideal matched dummy load
XMN1_sm060_2 rbl_sm060_2 ref_sm060_2 vn_sm060_2 0 sky130_fd_pr__nfet_01v8 L=0.15 W=1 nf=1 ad=0.29 as=0.29 pd=2.58 ps=2.58 nrd=0.29 nrs=0.29 sa=0 sb=0 sd=0 mult=1 m=1
XMN2_sm060_2 ref_sm060_2 rbl_sm060_2 vn_sm060_2 0 sky130_fd_pr__nfet_01v8 L=0.15 W=1 nf=1 ad=0.29 as=0.29 pd=2.58 ps=2.58 nrd=0.29 nrs=0.29 sa=0 sb=0 sd=0 mult=1 m=1
XMP1_sm060_2 rbl_sm060_2 ref_sm060_2 vp_sm060_2 vdd sky130_fd_pr__pfet_01v8 L=0.15 W=2 nf=1 ad=0.58 as=0.58 pd=4.58 ps=4.58 nrd=0.145 nrs=0.145 sa=0 sb=0 sd=0 mult=1 m=1
XMP2_sm060_2 ref_sm060_2 rbl_sm060_2 vp_sm060_2 vdd sky130_fd_pr__pfet_01v8 L=0.15 W=2 nf=1 ad=0.58 as=0.58 pd=4.58 ps=4.58 nrd=0.145 nrs=0.145 sa=0 sb=0 sd=0 mult=1 m=1
XMNF_sm060_2 vn_sm060_2 en 0 0 sky130_fd_pr__nfet_01v8 L=0.15 W=2 nf=1 ad=0.58 as=0.58 pd=4.58 ps=4.58 nrd=0.145 nrs=0.145 sa=0 sb=0 sd=0 mult=1 m=1
XMPH_sm060_2 vp_sm060_2 enb vdd vdd sky130_fd_pr__pfet_01v8 L=0.15 W=4 nf=1 ad=1.16 as=1.16 pd=8.58 ps=8.58 nrd=0.0725 nrs=0.0725 sa=0 sb=0 sd=0 mult=1 m=1
bd_sm060_2 d_sm060_2 0 v=v(rbl_sm060_2)-v(ref_sm060_2)
bdabs_sm060_2 dabs_sm060_2 0 v=abs(v(rbl_sm060_2)-v(ref_sm060_2))

* ---- sm060_3: d = -60 mV, replica 3 ----
spa_sm060_3 pa_m060 rbl_sm060_3 ctl 0 swpre
crbl_sm060_3 rbl_sm060_3 0 {C_RBL}
spr_sm060_3 pref_100 ref_sm060_3 ctl 0 swpre
cref_sm060_3 ref_sm060_3 0 {C_RBL}   $ ASSUMPTION: ideal matched dummy load
XMN1_sm060_3 rbl_sm060_3 ref_sm060_3 vn_sm060_3 0 sky130_fd_pr__nfet_01v8 L=0.15 W=1 nf=1 ad=0.29 as=0.29 pd=2.58 ps=2.58 nrd=0.29 nrs=0.29 sa=0 sb=0 sd=0 mult=1 m=1
XMN2_sm060_3 ref_sm060_3 rbl_sm060_3 vn_sm060_3 0 sky130_fd_pr__nfet_01v8 L=0.15 W=1 nf=1 ad=0.29 as=0.29 pd=2.58 ps=2.58 nrd=0.29 nrs=0.29 sa=0 sb=0 sd=0 mult=1 m=1
XMP1_sm060_3 rbl_sm060_3 ref_sm060_3 vp_sm060_3 vdd sky130_fd_pr__pfet_01v8 L=0.15 W=2 nf=1 ad=0.58 as=0.58 pd=4.58 ps=4.58 nrd=0.145 nrs=0.145 sa=0 sb=0 sd=0 mult=1 m=1
XMP2_sm060_3 ref_sm060_3 rbl_sm060_3 vp_sm060_3 vdd sky130_fd_pr__pfet_01v8 L=0.15 W=2 nf=1 ad=0.58 as=0.58 pd=4.58 ps=4.58 nrd=0.145 nrs=0.145 sa=0 sb=0 sd=0 mult=1 m=1
XMNF_sm060_3 vn_sm060_3 en 0 0 sky130_fd_pr__nfet_01v8 L=0.15 W=2 nf=1 ad=0.58 as=0.58 pd=4.58 ps=4.58 nrd=0.145 nrs=0.145 sa=0 sb=0 sd=0 mult=1 m=1
XMPH_sm060_3 vp_sm060_3 enb vdd vdd sky130_fd_pr__pfet_01v8 L=0.15 W=4 nf=1 ad=1.16 as=1.16 pd=8.58 ps=8.58 nrd=0.0725 nrs=0.0725 sa=0 sb=0 sd=0 mult=1 m=1
bd_sm060_3 d_sm060_3 0 v=v(rbl_sm060_3)-v(ref_sm060_3)
bdabs_sm060_3 dabs_sm060_3 0 v=abs(v(rbl_sm060_3)-v(ref_sm060_3))

* ---- sm060_4: d = -60 mV, replica 4 ----
spa_sm060_4 pa_m060 rbl_sm060_4 ctl 0 swpre
crbl_sm060_4 rbl_sm060_4 0 {C_RBL}
spr_sm060_4 pref_100 ref_sm060_4 ctl 0 swpre
cref_sm060_4 ref_sm060_4 0 {C_RBL}   $ ASSUMPTION: ideal matched dummy load
XMN1_sm060_4 rbl_sm060_4 ref_sm060_4 vn_sm060_4 0 sky130_fd_pr__nfet_01v8 L=0.15 W=1 nf=1 ad=0.29 as=0.29 pd=2.58 ps=2.58 nrd=0.29 nrs=0.29 sa=0 sb=0 sd=0 mult=1 m=1
XMN2_sm060_4 ref_sm060_4 rbl_sm060_4 vn_sm060_4 0 sky130_fd_pr__nfet_01v8 L=0.15 W=1 nf=1 ad=0.29 as=0.29 pd=2.58 ps=2.58 nrd=0.29 nrs=0.29 sa=0 sb=0 sd=0 mult=1 m=1
XMP1_sm060_4 rbl_sm060_4 ref_sm060_4 vp_sm060_4 vdd sky130_fd_pr__pfet_01v8 L=0.15 W=2 nf=1 ad=0.58 as=0.58 pd=4.58 ps=4.58 nrd=0.145 nrs=0.145 sa=0 sb=0 sd=0 mult=1 m=1
XMP2_sm060_4 ref_sm060_4 rbl_sm060_4 vp_sm060_4 vdd sky130_fd_pr__pfet_01v8 L=0.15 W=2 nf=1 ad=0.58 as=0.58 pd=4.58 ps=4.58 nrd=0.145 nrs=0.145 sa=0 sb=0 sd=0 mult=1 m=1
XMNF_sm060_4 vn_sm060_4 en 0 0 sky130_fd_pr__nfet_01v8 L=0.15 W=2 nf=1 ad=0.58 as=0.58 pd=4.58 ps=4.58 nrd=0.145 nrs=0.145 sa=0 sb=0 sd=0 mult=1 m=1
XMPH_sm060_4 vp_sm060_4 enb vdd vdd sky130_fd_pr__pfet_01v8 L=0.15 W=4 nf=1 ad=1.16 as=1.16 pd=8.58 ps=8.58 nrd=0.0725 nrs=0.0725 sa=0 sb=0 sd=0 mult=1 m=1
bd_sm060_4 d_sm060_4 0 v=v(rbl_sm060_4)-v(ref_sm060_4)
bdabs_sm060_4 dabs_sm060_4 0 v=abs(v(rbl_sm060_4)-v(ref_sm060_4))

* ---- sm060_5: d = -60 mV, replica 5 ----
spa_sm060_5 pa_m060 rbl_sm060_5 ctl 0 swpre
crbl_sm060_5 rbl_sm060_5 0 {C_RBL}
spr_sm060_5 pref_100 ref_sm060_5 ctl 0 swpre
cref_sm060_5 ref_sm060_5 0 {C_RBL}   $ ASSUMPTION: ideal matched dummy load
XMN1_sm060_5 rbl_sm060_5 ref_sm060_5 vn_sm060_5 0 sky130_fd_pr__nfet_01v8 L=0.15 W=1 nf=1 ad=0.29 as=0.29 pd=2.58 ps=2.58 nrd=0.29 nrs=0.29 sa=0 sb=0 sd=0 mult=1 m=1
XMN2_sm060_5 ref_sm060_5 rbl_sm060_5 vn_sm060_5 0 sky130_fd_pr__nfet_01v8 L=0.15 W=1 nf=1 ad=0.29 as=0.29 pd=2.58 ps=2.58 nrd=0.29 nrs=0.29 sa=0 sb=0 sd=0 mult=1 m=1
XMP1_sm060_5 rbl_sm060_5 ref_sm060_5 vp_sm060_5 vdd sky130_fd_pr__pfet_01v8 L=0.15 W=2 nf=1 ad=0.58 as=0.58 pd=4.58 ps=4.58 nrd=0.145 nrs=0.145 sa=0 sb=0 sd=0 mult=1 m=1
XMP2_sm060_5 ref_sm060_5 rbl_sm060_5 vp_sm060_5 vdd sky130_fd_pr__pfet_01v8 L=0.15 W=2 nf=1 ad=0.58 as=0.58 pd=4.58 ps=4.58 nrd=0.145 nrs=0.145 sa=0 sb=0 sd=0 mult=1 m=1
XMNF_sm060_5 vn_sm060_5 en 0 0 sky130_fd_pr__nfet_01v8 L=0.15 W=2 nf=1 ad=0.58 as=0.58 pd=4.58 ps=4.58 nrd=0.145 nrs=0.145 sa=0 sb=0 sd=0 mult=1 m=1
XMPH_sm060_5 vp_sm060_5 enb vdd vdd sky130_fd_pr__pfet_01v8 L=0.15 W=4 nf=1 ad=1.16 as=1.16 pd=8.58 ps=8.58 nrd=0.0725 nrs=0.0725 sa=0 sb=0 sd=0 mult=1 m=1
bd_sm060_5 d_sm060_5 0 v=v(rbl_sm060_5)-v(ref_sm060_5)
bdabs_sm060_5 dabs_sm060_5 0 v=abs(v(rbl_sm060_5)-v(ref_sm060_5))

* ---- sp080_0: d = 80 mV, replica 0 ----
spa_sp080_0 pa_p080 rbl_sp080_0 ctl 0 swpre
crbl_sp080_0 rbl_sp080_0 0 {C_RBL}
spr_sp080_0 pref_100 ref_sp080_0 ctl 0 swpre
cref_sp080_0 ref_sp080_0 0 {C_RBL}   $ ASSUMPTION: ideal matched dummy load
XMN1_sp080_0 rbl_sp080_0 ref_sp080_0 vn_sp080_0 0 sky130_fd_pr__nfet_01v8 L=0.15 W=1 nf=1 ad=0.29 as=0.29 pd=2.58 ps=2.58 nrd=0.29 nrs=0.29 sa=0 sb=0 sd=0 mult=1 m=1
XMN2_sp080_0 ref_sp080_0 rbl_sp080_0 vn_sp080_0 0 sky130_fd_pr__nfet_01v8 L=0.15 W=1 nf=1 ad=0.29 as=0.29 pd=2.58 ps=2.58 nrd=0.29 nrs=0.29 sa=0 sb=0 sd=0 mult=1 m=1
XMP1_sp080_0 rbl_sp080_0 ref_sp080_0 vp_sp080_0 vdd sky130_fd_pr__pfet_01v8 L=0.15 W=2 nf=1 ad=0.58 as=0.58 pd=4.58 ps=4.58 nrd=0.145 nrs=0.145 sa=0 sb=0 sd=0 mult=1 m=1
XMP2_sp080_0 ref_sp080_0 rbl_sp080_0 vp_sp080_0 vdd sky130_fd_pr__pfet_01v8 L=0.15 W=2 nf=1 ad=0.58 as=0.58 pd=4.58 ps=4.58 nrd=0.145 nrs=0.145 sa=0 sb=0 sd=0 mult=1 m=1
XMNF_sp080_0 vn_sp080_0 en 0 0 sky130_fd_pr__nfet_01v8 L=0.15 W=2 nf=1 ad=0.58 as=0.58 pd=4.58 ps=4.58 nrd=0.145 nrs=0.145 sa=0 sb=0 sd=0 mult=1 m=1
XMPH_sp080_0 vp_sp080_0 enb vdd vdd sky130_fd_pr__pfet_01v8 L=0.15 W=4 nf=1 ad=1.16 as=1.16 pd=8.58 ps=8.58 nrd=0.0725 nrs=0.0725 sa=0 sb=0 sd=0 mult=1 m=1
bd_sp080_0 d_sp080_0 0 v=v(rbl_sp080_0)-v(ref_sp080_0)
bdabs_sp080_0 dabs_sp080_0 0 v=abs(v(rbl_sp080_0)-v(ref_sp080_0))

* ---- sp080_1: d = 80 mV, replica 1 ----
spa_sp080_1 pa_p080 rbl_sp080_1 ctl 0 swpre
crbl_sp080_1 rbl_sp080_1 0 {C_RBL}
spr_sp080_1 pref_100 ref_sp080_1 ctl 0 swpre
cref_sp080_1 ref_sp080_1 0 {C_RBL}   $ ASSUMPTION: ideal matched dummy load
XMN1_sp080_1 rbl_sp080_1 ref_sp080_1 vn_sp080_1 0 sky130_fd_pr__nfet_01v8 L=0.15 W=1 nf=1 ad=0.29 as=0.29 pd=2.58 ps=2.58 nrd=0.29 nrs=0.29 sa=0 sb=0 sd=0 mult=1 m=1
XMN2_sp080_1 ref_sp080_1 rbl_sp080_1 vn_sp080_1 0 sky130_fd_pr__nfet_01v8 L=0.15 W=1 nf=1 ad=0.29 as=0.29 pd=2.58 ps=2.58 nrd=0.29 nrs=0.29 sa=0 sb=0 sd=0 mult=1 m=1
XMP1_sp080_1 rbl_sp080_1 ref_sp080_1 vp_sp080_1 vdd sky130_fd_pr__pfet_01v8 L=0.15 W=2 nf=1 ad=0.58 as=0.58 pd=4.58 ps=4.58 nrd=0.145 nrs=0.145 sa=0 sb=0 sd=0 mult=1 m=1
XMP2_sp080_1 ref_sp080_1 rbl_sp080_1 vp_sp080_1 vdd sky130_fd_pr__pfet_01v8 L=0.15 W=2 nf=1 ad=0.58 as=0.58 pd=4.58 ps=4.58 nrd=0.145 nrs=0.145 sa=0 sb=0 sd=0 mult=1 m=1
XMNF_sp080_1 vn_sp080_1 en 0 0 sky130_fd_pr__nfet_01v8 L=0.15 W=2 nf=1 ad=0.58 as=0.58 pd=4.58 ps=4.58 nrd=0.145 nrs=0.145 sa=0 sb=0 sd=0 mult=1 m=1
XMPH_sp080_1 vp_sp080_1 enb vdd vdd sky130_fd_pr__pfet_01v8 L=0.15 W=4 nf=1 ad=1.16 as=1.16 pd=8.58 ps=8.58 nrd=0.0725 nrs=0.0725 sa=0 sb=0 sd=0 mult=1 m=1
bd_sp080_1 d_sp080_1 0 v=v(rbl_sp080_1)-v(ref_sp080_1)
bdabs_sp080_1 dabs_sp080_1 0 v=abs(v(rbl_sp080_1)-v(ref_sp080_1))

* ---- sp080_2: d = 80 mV, replica 2 ----
spa_sp080_2 pa_p080 rbl_sp080_2 ctl 0 swpre
crbl_sp080_2 rbl_sp080_2 0 {C_RBL}
spr_sp080_2 pref_100 ref_sp080_2 ctl 0 swpre
cref_sp080_2 ref_sp080_2 0 {C_RBL}   $ ASSUMPTION: ideal matched dummy load
XMN1_sp080_2 rbl_sp080_2 ref_sp080_2 vn_sp080_2 0 sky130_fd_pr__nfet_01v8 L=0.15 W=1 nf=1 ad=0.29 as=0.29 pd=2.58 ps=2.58 nrd=0.29 nrs=0.29 sa=0 sb=0 sd=0 mult=1 m=1
XMN2_sp080_2 ref_sp080_2 rbl_sp080_2 vn_sp080_2 0 sky130_fd_pr__nfet_01v8 L=0.15 W=1 nf=1 ad=0.29 as=0.29 pd=2.58 ps=2.58 nrd=0.29 nrs=0.29 sa=0 sb=0 sd=0 mult=1 m=1
XMP1_sp080_2 rbl_sp080_2 ref_sp080_2 vp_sp080_2 vdd sky130_fd_pr__pfet_01v8 L=0.15 W=2 nf=1 ad=0.58 as=0.58 pd=4.58 ps=4.58 nrd=0.145 nrs=0.145 sa=0 sb=0 sd=0 mult=1 m=1
XMP2_sp080_2 ref_sp080_2 rbl_sp080_2 vp_sp080_2 vdd sky130_fd_pr__pfet_01v8 L=0.15 W=2 nf=1 ad=0.58 as=0.58 pd=4.58 ps=4.58 nrd=0.145 nrs=0.145 sa=0 sb=0 sd=0 mult=1 m=1
XMNF_sp080_2 vn_sp080_2 en 0 0 sky130_fd_pr__nfet_01v8 L=0.15 W=2 nf=1 ad=0.58 as=0.58 pd=4.58 ps=4.58 nrd=0.145 nrs=0.145 sa=0 sb=0 sd=0 mult=1 m=1
XMPH_sp080_2 vp_sp080_2 enb vdd vdd sky130_fd_pr__pfet_01v8 L=0.15 W=4 nf=1 ad=1.16 as=1.16 pd=8.58 ps=8.58 nrd=0.0725 nrs=0.0725 sa=0 sb=0 sd=0 mult=1 m=1
bd_sp080_2 d_sp080_2 0 v=v(rbl_sp080_2)-v(ref_sp080_2)
bdabs_sp080_2 dabs_sp080_2 0 v=abs(v(rbl_sp080_2)-v(ref_sp080_2))

* ---- sp080_3: d = 80 mV, replica 3 ----
spa_sp080_3 pa_p080 rbl_sp080_3 ctl 0 swpre
crbl_sp080_3 rbl_sp080_3 0 {C_RBL}
spr_sp080_3 pref_100 ref_sp080_3 ctl 0 swpre
cref_sp080_3 ref_sp080_3 0 {C_RBL}   $ ASSUMPTION: ideal matched dummy load
XMN1_sp080_3 rbl_sp080_3 ref_sp080_3 vn_sp080_3 0 sky130_fd_pr__nfet_01v8 L=0.15 W=1 nf=1 ad=0.29 as=0.29 pd=2.58 ps=2.58 nrd=0.29 nrs=0.29 sa=0 sb=0 sd=0 mult=1 m=1
XMN2_sp080_3 ref_sp080_3 rbl_sp080_3 vn_sp080_3 0 sky130_fd_pr__nfet_01v8 L=0.15 W=1 nf=1 ad=0.29 as=0.29 pd=2.58 ps=2.58 nrd=0.29 nrs=0.29 sa=0 sb=0 sd=0 mult=1 m=1
XMP1_sp080_3 rbl_sp080_3 ref_sp080_3 vp_sp080_3 vdd sky130_fd_pr__pfet_01v8 L=0.15 W=2 nf=1 ad=0.58 as=0.58 pd=4.58 ps=4.58 nrd=0.145 nrs=0.145 sa=0 sb=0 sd=0 mult=1 m=1
XMP2_sp080_3 ref_sp080_3 rbl_sp080_3 vp_sp080_3 vdd sky130_fd_pr__pfet_01v8 L=0.15 W=2 nf=1 ad=0.58 as=0.58 pd=4.58 ps=4.58 nrd=0.145 nrs=0.145 sa=0 sb=0 sd=0 mult=1 m=1
XMNF_sp080_3 vn_sp080_3 en 0 0 sky130_fd_pr__nfet_01v8 L=0.15 W=2 nf=1 ad=0.58 as=0.58 pd=4.58 ps=4.58 nrd=0.145 nrs=0.145 sa=0 sb=0 sd=0 mult=1 m=1
XMPH_sp080_3 vp_sp080_3 enb vdd vdd sky130_fd_pr__pfet_01v8 L=0.15 W=4 nf=1 ad=1.16 as=1.16 pd=8.58 ps=8.58 nrd=0.0725 nrs=0.0725 sa=0 sb=0 sd=0 mult=1 m=1
bd_sp080_3 d_sp080_3 0 v=v(rbl_sp080_3)-v(ref_sp080_3)
bdabs_sp080_3 dabs_sp080_3 0 v=abs(v(rbl_sp080_3)-v(ref_sp080_3))

* ---- sp080_4: d = 80 mV, replica 4 ----
spa_sp080_4 pa_p080 rbl_sp080_4 ctl 0 swpre
crbl_sp080_4 rbl_sp080_4 0 {C_RBL}
spr_sp080_4 pref_100 ref_sp080_4 ctl 0 swpre
cref_sp080_4 ref_sp080_4 0 {C_RBL}   $ ASSUMPTION: ideal matched dummy load
XMN1_sp080_4 rbl_sp080_4 ref_sp080_4 vn_sp080_4 0 sky130_fd_pr__nfet_01v8 L=0.15 W=1 nf=1 ad=0.29 as=0.29 pd=2.58 ps=2.58 nrd=0.29 nrs=0.29 sa=0 sb=0 sd=0 mult=1 m=1
XMN2_sp080_4 ref_sp080_4 rbl_sp080_4 vn_sp080_4 0 sky130_fd_pr__nfet_01v8 L=0.15 W=1 nf=1 ad=0.29 as=0.29 pd=2.58 ps=2.58 nrd=0.29 nrs=0.29 sa=0 sb=0 sd=0 mult=1 m=1
XMP1_sp080_4 rbl_sp080_4 ref_sp080_4 vp_sp080_4 vdd sky130_fd_pr__pfet_01v8 L=0.15 W=2 nf=1 ad=0.58 as=0.58 pd=4.58 ps=4.58 nrd=0.145 nrs=0.145 sa=0 sb=0 sd=0 mult=1 m=1
XMP2_sp080_4 ref_sp080_4 rbl_sp080_4 vp_sp080_4 vdd sky130_fd_pr__pfet_01v8 L=0.15 W=2 nf=1 ad=0.58 as=0.58 pd=4.58 ps=4.58 nrd=0.145 nrs=0.145 sa=0 sb=0 sd=0 mult=1 m=1
XMNF_sp080_4 vn_sp080_4 en 0 0 sky130_fd_pr__nfet_01v8 L=0.15 W=2 nf=1 ad=0.58 as=0.58 pd=4.58 ps=4.58 nrd=0.145 nrs=0.145 sa=0 sb=0 sd=0 mult=1 m=1
XMPH_sp080_4 vp_sp080_4 enb vdd vdd sky130_fd_pr__pfet_01v8 L=0.15 W=4 nf=1 ad=1.16 as=1.16 pd=8.58 ps=8.58 nrd=0.0725 nrs=0.0725 sa=0 sb=0 sd=0 mult=1 m=1
bd_sp080_4 d_sp080_4 0 v=v(rbl_sp080_4)-v(ref_sp080_4)
bdabs_sp080_4 dabs_sp080_4 0 v=abs(v(rbl_sp080_4)-v(ref_sp080_4))

* ---- sp080_5: d = 80 mV, replica 5 ----
spa_sp080_5 pa_p080 rbl_sp080_5 ctl 0 swpre
crbl_sp080_5 rbl_sp080_5 0 {C_RBL}
spr_sp080_5 pref_100 ref_sp080_5 ctl 0 swpre
cref_sp080_5 ref_sp080_5 0 {C_RBL}   $ ASSUMPTION: ideal matched dummy load
XMN1_sp080_5 rbl_sp080_5 ref_sp080_5 vn_sp080_5 0 sky130_fd_pr__nfet_01v8 L=0.15 W=1 nf=1 ad=0.29 as=0.29 pd=2.58 ps=2.58 nrd=0.29 nrs=0.29 sa=0 sb=0 sd=0 mult=1 m=1
XMN2_sp080_5 ref_sp080_5 rbl_sp080_5 vn_sp080_5 0 sky130_fd_pr__nfet_01v8 L=0.15 W=1 nf=1 ad=0.29 as=0.29 pd=2.58 ps=2.58 nrd=0.29 nrs=0.29 sa=0 sb=0 sd=0 mult=1 m=1
XMP1_sp080_5 rbl_sp080_5 ref_sp080_5 vp_sp080_5 vdd sky130_fd_pr__pfet_01v8 L=0.15 W=2 nf=1 ad=0.58 as=0.58 pd=4.58 ps=4.58 nrd=0.145 nrs=0.145 sa=0 sb=0 sd=0 mult=1 m=1
XMP2_sp080_5 ref_sp080_5 rbl_sp080_5 vp_sp080_5 vdd sky130_fd_pr__pfet_01v8 L=0.15 W=2 nf=1 ad=0.58 as=0.58 pd=4.58 ps=4.58 nrd=0.145 nrs=0.145 sa=0 sb=0 sd=0 mult=1 m=1
XMNF_sp080_5 vn_sp080_5 en 0 0 sky130_fd_pr__nfet_01v8 L=0.15 W=2 nf=1 ad=0.58 as=0.58 pd=4.58 ps=4.58 nrd=0.145 nrs=0.145 sa=0 sb=0 sd=0 mult=1 m=1
XMPH_sp080_5 vp_sp080_5 enb vdd vdd sky130_fd_pr__pfet_01v8 L=0.15 W=4 nf=1 ad=1.16 as=1.16 pd=8.58 ps=8.58 nrd=0.0725 nrs=0.0725 sa=0 sb=0 sd=0 mult=1 m=1
bd_sp080_5 d_sp080_5 0 v=v(rbl_sp080_5)-v(ref_sp080_5)
bdabs_sp080_5 dabs_sp080_5 0 v=abs(v(rbl_sp080_5)-v(ref_sp080_5))

* ---- sm080_0: d = -80 mV, replica 0 ----
spa_sm080_0 pa_m080 rbl_sm080_0 ctl 0 swpre
crbl_sm080_0 rbl_sm080_0 0 {C_RBL}
spr_sm080_0 pref_100 ref_sm080_0 ctl 0 swpre
cref_sm080_0 ref_sm080_0 0 {C_RBL}   $ ASSUMPTION: ideal matched dummy load
XMN1_sm080_0 rbl_sm080_0 ref_sm080_0 vn_sm080_0 0 sky130_fd_pr__nfet_01v8 L=0.15 W=1 nf=1 ad=0.29 as=0.29 pd=2.58 ps=2.58 nrd=0.29 nrs=0.29 sa=0 sb=0 sd=0 mult=1 m=1
XMN2_sm080_0 ref_sm080_0 rbl_sm080_0 vn_sm080_0 0 sky130_fd_pr__nfet_01v8 L=0.15 W=1 nf=1 ad=0.29 as=0.29 pd=2.58 ps=2.58 nrd=0.29 nrs=0.29 sa=0 sb=0 sd=0 mult=1 m=1
XMP1_sm080_0 rbl_sm080_0 ref_sm080_0 vp_sm080_0 vdd sky130_fd_pr__pfet_01v8 L=0.15 W=2 nf=1 ad=0.58 as=0.58 pd=4.58 ps=4.58 nrd=0.145 nrs=0.145 sa=0 sb=0 sd=0 mult=1 m=1
XMP2_sm080_0 ref_sm080_0 rbl_sm080_0 vp_sm080_0 vdd sky130_fd_pr__pfet_01v8 L=0.15 W=2 nf=1 ad=0.58 as=0.58 pd=4.58 ps=4.58 nrd=0.145 nrs=0.145 sa=0 sb=0 sd=0 mult=1 m=1
XMNF_sm080_0 vn_sm080_0 en 0 0 sky130_fd_pr__nfet_01v8 L=0.15 W=2 nf=1 ad=0.58 as=0.58 pd=4.58 ps=4.58 nrd=0.145 nrs=0.145 sa=0 sb=0 sd=0 mult=1 m=1
XMPH_sm080_0 vp_sm080_0 enb vdd vdd sky130_fd_pr__pfet_01v8 L=0.15 W=4 nf=1 ad=1.16 as=1.16 pd=8.58 ps=8.58 nrd=0.0725 nrs=0.0725 sa=0 sb=0 sd=0 mult=1 m=1
bd_sm080_0 d_sm080_0 0 v=v(rbl_sm080_0)-v(ref_sm080_0)
bdabs_sm080_0 dabs_sm080_0 0 v=abs(v(rbl_sm080_0)-v(ref_sm080_0))

* ---- sm080_1: d = -80 mV, replica 1 ----
spa_sm080_1 pa_m080 rbl_sm080_1 ctl 0 swpre
crbl_sm080_1 rbl_sm080_1 0 {C_RBL}
spr_sm080_1 pref_100 ref_sm080_1 ctl 0 swpre
cref_sm080_1 ref_sm080_1 0 {C_RBL}   $ ASSUMPTION: ideal matched dummy load
XMN1_sm080_1 rbl_sm080_1 ref_sm080_1 vn_sm080_1 0 sky130_fd_pr__nfet_01v8 L=0.15 W=1 nf=1 ad=0.29 as=0.29 pd=2.58 ps=2.58 nrd=0.29 nrs=0.29 sa=0 sb=0 sd=0 mult=1 m=1
XMN2_sm080_1 ref_sm080_1 rbl_sm080_1 vn_sm080_1 0 sky130_fd_pr__nfet_01v8 L=0.15 W=1 nf=1 ad=0.29 as=0.29 pd=2.58 ps=2.58 nrd=0.29 nrs=0.29 sa=0 sb=0 sd=0 mult=1 m=1
XMP1_sm080_1 rbl_sm080_1 ref_sm080_1 vp_sm080_1 vdd sky130_fd_pr__pfet_01v8 L=0.15 W=2 nf=1 ad=0.58 as=0.58 pd=4.58 ps=4.58 nrd=0.145 nrs=0.145 sa=0 sb=0 sd=0 mult=1 m=1
XMP2_sm080_1 ref_sm080_1 rbl_sm080_1 vp_sm080_1 vdd sky130_fd_pr__pfet_01v8 L=0.15 W=2 nf=1 ad=0.58 as=0.58 pd=4.58 ps=4.58 nrd=0.145 nrs=0.145 sa=0 sb=0 sd=0 mult=1 m=1
XMNF_sm080_1 vn_sm080_1 en 0 0 sky130_fd_pr__nfet_01v8 L=0.15 W=2 nf=1 ad=0.58 as=0.58 pd=4.58 ps=4.58 nrd=0.145 nrs=0.145 sa=0 sb=0 sd=0 mult=1 m=1
XMPH_sm080_1 vp_sm080_1 enb vdd vdd sky130_fd_pr__pfet_01v8 L=0.15 W=4 nf=1 ad=1.16 as=1.16 pd=8.58 ps=8.58 nrd=0.0725 nrs=0.0725 sa=0 sb=0 sd=0 mult=1 m=1
bd_sm080_1 d_sm080_1 0 v=v(rbl_sm080_1)-v(ref_sm080_1)
bdabs_sm080_1 dabs_sm080_1 0 v=abs(v(rbl_sm080_1)-v(ref_sm080_1))

* ---- sm080_2: d = -80 mV, replica 2 ----
spa_sm080_2 pa_m080 rbl_sm080_2 ctl 0 swpre
crbl_sm080_2 rbl_sm080_2 0 {C_RBL}
spr_sm080_2 pref_100 ref_sm080_2 ctl 0 swpre
cref_sm080_2 ref_sm080_2 0 {C_RBL}   $ ASSUMPTION: ideal matched dummy load
XMN1_sm080_2 rbl_sm080_2 ref_sm080_2 vn_sm080_2 0 sky130_fd_pr__nfet_01v8 L=0.15 W=1 nf=1 ad=0.29 as=0.29 pd=2.58 ps=2.58 nrd=0.29 nrs=0.29 sa=0 sb=0 sd=0 mult=1 m=1
XMN2_sm080_2 ref_sm080_2 rbl_sm080_2 vn_sm080_2 0 sky130_fd_pr__nfet_01v8 L=0.15 W=1 nf=1 ad=0.29 as=0.29 pd=2.58 ps=2.58 nrd=0.29 nrs=0.29 sa=0 sb=0 sd=0 mult=1 m=1
XMP1_sm080_2 rbl_sm080_2 ref_sm080_2 vp_sm080_2 vdd sky130_fd_pr__pfet_01v8 L=0.15 W=2 nf=1 ad=0.58 as=0.58 pd=4.58 ps=4.58 nrd=0.145 nrs=0.145 sa=0 sb=0 sd=0 mult=1 m=1
XMP2_sm080_2 ref_sm080_2 rbl_sm080_2 vp_sm080_2 vdd sky130_fd_pr__pfet_01v8 L=0.15 W=2 nf=1 ad=0.58 as=0.58 pd=4.58 ps=4.58 nrd=0.145 nrs=0.145 sa=0 sb=0 sd=0 mult=1 m=1
XMNF_sm080_2 vn_sm080_2 en 0 0 sky130_fd_pr__nfet_01v8 L=0.15 W=2 nf=1 ad=0.58 as=0.58 pd=4.58 ps=4.58 nrd=0.145 nrs=0.145 sa=0 sb=0 sd=0 mult=1 m=1
XMPH_sm080_2 vp_sm080_2 enb vdd vdd sky130_fd_pr__pfet_01v8 L=0.15 W=4 nf=1 ad=1.16 as=1.16 pd=8.58 ps=8.58 nrd=0.0725 nrs=0.0725 sa=0 sb=0 sd=0 mult=1 m=1
bd_sm080_2 d_sm080_2 0 v=v(rbl_sm080_2)-v(ref_sm080_2)
bdabs_sm080_2 dabs_sm080_2 0 v=abs(v(rbl_sm080_2)-v(ref_sm080_2))

* ---- sm080_3: d = -80 mV, replica 3 ----
spa_sm080_3 pa_m080 rbl_sm080_3 ctl 0 swpre
crbl_sm080_3 rbl_sm080_3 0 {C_RBL}
spr_sm080_3 pref_100 ref_sm080_3 ctl 0 swpre
cref_sm080_3 ref_sm080_3 0 {C_RBL}   $ ASSUMPTION: ideal matched dummy load
XMN1_sm080_3 rbl_sm080_3 ref_sm080_3 vn_sm080_3 0 sky130_fd_pr__nfet_01v8 L=0.15 W=1 nf=1 ad=0.29 as=0.29 pd=2.58 ps=2.58 nrd=0.29 nrs=0.29 sa=0 sb=0 sd=0 mult=1 m=1
XMN2_sm080_3 ref_sm080_3 rbl_sm080_3 vn_sm080_3 0 sky130_fd_pr__nfet_01v8 L=0.15 W=1 nf=1 ad=0.29 as=0.29 pd=2.58 ps=2.58 nrd=0.29 nrs=0.29 sa=0 sb=0 sd=0 mult=1 m=1
XMP1_sm080_3 rbl_sm080_3 ref_sm080_3 vp_sm080_3 vdd sky130_fd_pr__pfet_01v8 L=0.15 W=2 nf=1 ad=0.58 as=0.58 pd=4.58 ps=4.58 nrd=0.145 nrs=0.145 sa=0 sb=0 sd=0 mult=1 m=1
XMP2_sm080_3 ref_sm080_3 rbl_sm080_3 vp_sm080_3 vdd sky130_fd_pr__pfet_01v8 L=0.15 W=2 nf=1 ad=0.58 as=0.58 pd=4.58 ps=4.58 nrd=0.145 nrs=0.145 sa=0 sb=0 sd=0 mult=1 m=1
XMNF_sm080_3 vn_sm080_3 en 0 0 sky130_fd_pr__nfet_01v8 L=0.15 W=2 nf=1 ad=0.58 as=0.58 pd=4.58 ps=4.58 nrd=0.145 nrs=0.145 sa=0 sb=0 sd=0 mult=1 m=1
XMPH_sm080_3 vp_sm080_3 enb vdd vdd sky130_fd_pr__pfet_01v8 L=0.15 W=4 nf=1 ad=1.16 as=1.16 pd=8.58 ps=8.58 nrd=0.0725 nrs=0.0725 sa=0 sb=0 sd=0 mult=1 m=1
bd_sm080_3 d_sm080_3 0 v=v(rbl_sm080_3)-v(ref_sm080_3)
bdabs_sm080_3 dabs_sm080_3 0 v=abs(v(rbl_sm080_3)-v(ref_sm080_3))

* ---- sm080_4: d = -80 mV, replica 4 ----
spa_sm080_4 pa_m080 rbl_sm080_4 ctl 0 swpre
crbl_sm080_4 rbl_sm080_4 0 {C_RBL}
spr_sm080_4 pref_100 ref_sm080_4 ctl 0 swpre
cref_sm080_4 ref_sm080_4 0 {C_RBL}   $ ASSUMPTION: ideal matched dummy load
XMN1_sm080_4 rbl_sm080_4 ref_sm080_4 vn_sm080_4 0 sky130_fd_pr__nfet_01v8 L=0.15 W=1 nf=1 ad=0.29 as=0.29 pd=2.58 ps=2.58 nrd=0.29 nrs=0.29 sa=0 sb=0 sd=0 mult=1 m=1
XMN2_sm080_4 ref_sm080_4 rbl_sm080_4 vn_sm080_4 0 sky130_fd_pr__nfet_01v8 L=0.15 W=1 nf=1 ad=0.29 as=0.29 pd=2.58 ps=2.58 nrd=0.29 nrs=0.29 sa=0 sb=0 sd=0 mult=1 m=1
XMP1_sm080_4 rbl_sm080_4 ref_sm080_4 vp_sm080_4 vdd sky130_fd_pr__pfet_01v8 L=0.15 W=2 nf=1 ad=0.58 as=0.58 pd=4.58 ps=4.58 nrd=0.145 nrs=0.145 sa=0 sb=0 sd=0 mult=1 m=1
XMP2_sm080_4 ref_sm080_4 rbl_sm080_4 vp_sm080_4 vdd sky130_fd_pr__pfet_01v8 L=0.15 W=2 nf=1 ad=0.58 as=0.58 pd=4.58 ps=4.58 nrd=0.145 nrs=0.145 sa=0 sb=0 sd=0 mult=1 m=1
XMNF_sm080_4 vn_sm080_4 en 0 0 sky130_fd_pr__nfet_01v8 L=0.15 W=2 nf=1 ad=0.58 as=0.58 pd=4.58 ps=4.58 nrd=0.145 nrs=0.145 sa=0 sb=0 sd=0 mult=1 m=1
XMPH_sm080_4 vp_sm080_4 enb vdd vdd sky130_fd_pr__pfet_01v8 L=0.15 W=4 nf=1 ad=1.16 as=1.16 pd=8.58 ps=8.58 nrd=0.0725 nrs=0.0725 sa=0 sb=0 sd=0 mult=1 m=1
bd_sm080_4 d_sm080_4 0 v=v(rbl_sm080_4)-v(ref_sm080_4)
bdabs_sm080_4 dabs_sm080_4 0 v=abs(v(rbl_sm080_4)-v(ref_sm080_4))

* ---- sm080_5: d = -80 mV, replica 5 ----
spa_sm080_5 pa_m080 rbl_sm080_5 ctl 0 swpre
crbl_sm080_5 rbl_sm080_5 0 {C_RBL}
spr_sm080_5 pref_100 ref_sm080_5 ctl 0 swpre
cref_sm080_5 ref_sm080_5 0 {C_RBL}   $ ASSUMPTION: ideal matched dummy load
XMN1_sm080_5 rbl_sm080_5 ref_sm080_5 vn_sm080_5 0 sky130_fd_pr__nfet_01v8 L=0.15 W=1 nf=1 ad=0.29 as=0.29 pd=2.58 ps=2.58 nrd=0.29 nrs=0.29 sa=0 sb=0 sd=0 mult=1 m=1
XMN2_sm080_5 ref_sm080_5 rbl_sm080_5 vn_sm080_5 0 sky130_fd_pr__nfet_01v8 L=0.15 W=1 nf=1 ad=0.29 as=0.29 pd=2.58 ps=2.58 nrd=0.29 nrs=0.29 sa=0 sb=0 sd=0 mult=1 m=1
XMP1_sm080_5 rbl_sm080_5 ref_sm080_5 vp_sm080_5 vdd sky130_fd_pr__pfet_01v8 L=0.15 W=2 nf=1 ad=0.58 as=0.58 pd=4.58 ps=4.58 nrd=0.145 nrs=0.145 sa=0 sb=0 sd=0 mult=1 m=1
XMP2_sm080_5 ref_sm080_5 rbl_sm080_5 vp_sm080_5 vdd sky130_fd_pr__pfet_01v8 L=0.15 W=2 nf=1 ad=0.58 as=0.58 pd=4.58 ps=4.58 nrd=0.145 nrs=0.145 sa=0 sb=0 sd=0 mult=1 m=1
XMNF_sm080_5 vn_sm080_5 en 0 0 sky130_fd_pr__nfet_01v8 L=0.15 W=2 nf=1 ad=0.58 as=0.58 pd=4.58 ps=4.58 nrd=0.145 nrs=0.145 sa=0 sb=0 sd=0 mult=1 m=1
XMPH_sm080_5 vp_sm080_5 enb vdd vdd sky130_fd_pr__pfet_01v8 L=0.15 W=4 nf=1 ad=1.16 as=1.16 pd=8.58 ps=8.58 nrd=0.0725 nrs=0.0725 sa=0 sb=0 sd=0 mult=1 m=1
bd_sm080_5 d_sm080_5 0 v=v(rbl_sm080_5)-v(ref_sm080_5)
bdabs_sm080_5 dabs_sm080_5 0 v=abs(v(rbl_sm080_5)-v(ref_sm080_5))

* ---- sp100_0: d = 100 mV, replica 0 ----
spa_sp100_0 pa_p100 rbl_sp100_0 ctl 0 swpre
crbl_sp100_0 rbl_sp100_0 0 {C_RBL}
spr_sp100_0 pref_100 ref_sp100_0 ctl 0 swpre
cref_sp100_0 ref_sp100_0 0 {C_RBL}   $ ASSUMPTION: ideal matched dummy load
XMN1_sp100_0 rbl_sp100_0 ref_sp100_0 vn_sp100_0 0 sky130_fd_pr__nfet_01v8 L=0.15 W=1 nf=1 ad=0.29 as=0.29 pd=2.58 ps=2.58 nrd=0.29 nrs=0.29 sa=0 sb=0 sd=0 mult=1 m=1
XMN2_sp100_0 ref_sp100_0 rbl_sp100_0 vn_sp100_0 0 sky130_fd_pr__nfet_01v8 L=0.15 W=1 nf=1 ad=0.29 as=0.29 pd=2.58 ps=2.58 nrd=0.29 nrs=0.29 sa=0 sb=0 sd=0 mult=1 m=1
XMP1_sp100_0 rbl_sp100_0 ref_sp100_0 vp_sp100_0 vdd sky130_fd_pr__pfet_01v8 L=0.15 W=2 nf=1 ad=0.58 as=0.58 pd=4.58 ps=4.58 nrd=0.145 nrs=0.145 sa=0 sb=0 sd=0 mult=1 m=1
XMP2_sp100_0 ref_sp100_0 rbl_sp100_0 vp_sp100_0 vdd sky130_fd_pr__pfet_01v8 L=0.15 W=2 nf=1 ad=0.58 as=0.58 pd=4.58 ps=4.58 nrd=0.145 nrs=0.145 sa=0 sb=0 sd=0 mult=1 m=1
XMNF_sp100_0 vn_sp100_0 en 0 0 sky130_fd_pr__nfet_01v8 L=0.15 W=2 nf=1 ad=0.58 as=0.58 pd=4.58 ps=4.58 nrd=0.145 nrs=0.145 sa=0 sb=0 sd=0 mult=1 m=1
XMPH_sp100_0 vp_sp100_0 enb vdd vdd sky130_fd_pr__pfet_01v8 L=0.15 W=4 nf=1 ad=1.16 as=1.16 pd=8.58 ps=8.58 nrd=0.0725 nrs=0.0725 sa=0 sb=0 sd=0 mult=1 m=1
bd_sp100_0 d_sp100_0 0 v=v(rbl_sp100_0)-v(ref_sp100_0)
bdabs_sp100_0 dabs_sp100_0 0 v=abs(v(rbl_sp100_0)-v(ref_sp100_0))

* ---- sp100_1: d = 100 mV, replica 1 ----
spa_sp100_1 pa_p100 rbl_sp100_1 ctl 0 swpre
crbl_sp100_1 rbl_sp100_1 0 {C_RBL}
spr_sp100_1 pref_100 ref_sp100_1 ctl 0 swpre
cref_sp100_1 ref_sp100_1 0 {C_RBL}   $ ASSUMPTION: ideal matched dummy load
XMN1_sp100_1 rbl_sp100_1 ref_sp100_1 vn_sp100_1 0 sky130_fd_pr__nfet_01v8 L=0.15 W=1 nf=1 ad=0.29 as=0.29 pd=2.58 ps=2.58 nrd=0.29 nrs=0.29 sa=0 sb=0 sd=0 mult=1 m=1
XMN2_sp100_1 ref_sp100_1 rbl_sp100_1 vn_sp100_1 0 sky130_fd_pr__nfet_01v8 L=0.15 W=1 nf=1 ad=0.29 as=0.29 pd=2.58 ps=2.58 nrd=0.29 nrs=0.29 sa=0 sb=0 sd=0 mult=1 m=1
XMP1_sp100_1 rbl_sp100_1 ref_sp100_1 vp_sp100_1 vdd sky130_fd_pr__pfet_01v8 L=0.15 W=2 nf=1 ad=0.58 as=0.58 pd=4.58 ps=4.58 nrd=0.145 nrs=0.145 sa=0 sb=0 sd=0 mult=1 m=1
XMP2_sp100_1 ref_sp100_1 rbl_sp100_1 vp_sp100_1 vdd sky130_fd_pr__pfet_01v8 L=0.15 W=2 nf=1 ad=0.58 as=0.58 pd=4.58 ps=4.58 nrd=0.145 nrs=0.145 sa=0 sb=0 sd=0 mult=1 m=1
XMNF_sp100_1 vn_sp100_1 en 0 0 sky130_fd_pr__nfet_01v8 L=0.15 W=2 nf=1 ad=0.58 as=0.58 pd=4.58 ps=4.58 nrd=0.145 nrs=0.145 sa=0 sb=0 sd=0 mult=1 m=1
XMPH_sp100_1 vp_sp100_1 enb vdd vdd sky130_fd_pr__pfet_01v8 L=0.15 W=4 nf=1 ad=1.16 as=1.16 pd=8.58 ps=8.58 nrd=0.0725 nrs=0.0725 sa=0 sb=0 sd=0 mult=1 m=1
bd_sp100_1 d_sp100_1 0 v=v(rbl_sp100_1)-v(ref_sp100_1)
bdabs_sp100_1 dabs_sp100_1 0 v=abs(v(rbl_sp100_1)-v(ref_sp100_1))

* ---- sp100_2: d = 100 mV, replica 2 ----
spa_sp100_2 pa_p100 rbl_sp100_2 ctl 0 swpre
crbl_sp100_2 rbl_sp100_2 0 {C_RBL}
spr_sp100_2 pref_100 ref_sp100_2 ctl 0 swpre
cref_sp100_2 ref_sp100_2 0 {C_RBL}   $ ASSUMPTION: ideal matched dummy load
XMN1_sp100_2 rbl_sp100_2 ref_sp100_2 vn_sp100_2 0 sky130_fd_pr__nfet_01v8 L=0.15 W=1 nf=1 ad=0.29 as=0.29 pd=2.58 ps=2.58 nrd=0.29 nrs=0.29 sa=0 sb=0 sd=0 mult=1 m=1
XMN2_sp100_2 ref_sp100_2 rbl_sp100_2 vn_sp100_2 0 sky130_fd_pr__nfet_01v8 L=0.15 W=1 nf=1 ad=0.29 as=0.29 pd=2.58 ps=2.58 nrd=0.29 nrs=0.29 sa=0 sb=0 sd=0 mult=1 m=1
XMP1_sp100_2 rbl_sp100_2 ref_sp100_2 vp_sp100_2 vdd sky130_fd_pr__pfet_01v8 L=0.15 W=2 nf=1 ad=0.58 as=0.58 pd=4.58 ps=4.58 nrd=0.145 nrs=0.145 sa=0 sb=0 sd=0 mult=1 m=1
XMP2_sp100_2 ref_sp100_2 rbl_sp100_2 vp_sp100_2 vdd sky130_fd_pr__pfet_01v8 L=0.15 W=2 nf=1 ad=0.58 as=0.58 pd=4.58 ps=4.58 nrd=0.145 nrs=0.145 sa=0 sb=0 sd=0 mult=1 m=1
XMNF_sp100_2 vn_sp100_2 en 0 0 sky130_fd_pr__nfet_01v8 L=0.15 W=2 nf=1 ad=0.58 as=0.58 pd=4.58 ps=4.58 nrd=0.145 nrs=0.145 sa=0 sb=0 sd=0 mult=1 m=1
XMPH_sp100_2 vp_sp100_2 enb vdd vdd sky130_fd_pr__pfet_01v8 L=0.15 W=4 nf=1 ad=1.16 as=1.16 pd=8.58 ps=8.58 nrd=0.0725 nrs=0.0725 sa=0 sb=0 sd=0 mult=1 m=1
bd_sp100_2 d_sp100_2 0 v=v(rbl_sp100_2)-v(ref_sp100_2)
bdabs_sp100_2 dabs_sp100_2 0 v=abs(v(rbl_sp100_2)-v(ref_sp100_2))

* ---- sp100_3: d = 100 mV, replica 3 ----
spa_sp100_3 pa_p100 rbl_sp100_3 ctl 0 swpre
crbl_sp100_3 rbl_sp100_3 0 {C_RBL}
spr_sp100_3 pref_100 ref_sp100_3 ctl 0 swpre
cref_sp100_3 ref_sp100_3 0 {C_RBL}   $ ASSUMPTION: ideal matched dummy load
XMN1_sp100_3 rbl_sp100_3 ref_sp100_3 vn_sp100_3 0 sky130_fd_pr__nfet_01v8 L=0.15 W=1 nf=1 ad=0.29 as=0.29 pd=2.58 ps=2.58 nrd=0.29 nrs=0.29 sa=0 sb=0 sd=0 mult=1 m=1
XMN2_sp100_3 ref_sp100_3 rbl_sp100_3 vn_sp100_3 0 sky130_fd_pr__nfet_01v8 L=0.15 W=1 nf=1 ad=0.29 as=0.29 pd=2.58 ps=2.58 nrd=0.29 nrs=0.29 sa=0 sb=0 sd=0 mult=1 m=1
XMP1_sp100_3 rbl_sp100_3 ref_sp100_3 vp_sp100_3 vdd sky130_fd_pr__pfet_01v8 L=0.15 W=2 nf=1 ad=0.58 as=0.58 pd=4.58 ps=4.58 nrd=0.145 nrs=0.145 sa=0 sb=0 sd=0 mult=1 m=1
XMP2_sp100_3 ref_sp100_3 rbl_sp100_3 vp_sp100_3 vdd sky130_fd_pr__pfet_01v8 L=0.15 W=2 nf=1 ad=0.58 as=0.58 pd=4.58 ps=4.58 nrd=0.145 nrs=0.145 sa=0 sb=0 sd=0 mult=1 m=1
XMNF_sp100_3 vn_sp100_3 en 0 0 sky130_fd_pr__nfet_01v8 L=0.15 W=2 nf=1 ad=0.58 as=0.58 pd=4.58 ps=4.58 nrd=0.145 nrs=0.145 sa=0 sb=0 sd=0 mult=1 m=1
XMPH_sp100_3 vp_sp100_3 enb vdd vdd sky130_fd_pr__pfet_01v8 L=0.15 W=4 nf=1 ad=1.16 as=1.16 pd=8.58 ps=8.58 nrd=0.0725 nrs=0.0725 sa=0 sb=0 sd=0 mult=1 m=1
bd_sp100_3 d_sp100_3 0 v=v(rbl_sp100_3)-v(ref_sp100_3)
bdabs_sp100_3 dabs_sp100_3 0 v=abs(v(rbl_sp100_3)-v(ref_sp100_3))

* ---- sp100_4: d = 100 mV, replica 4 ----
spa_sp100_4 pa_p100 rbl_sp100_4 ctl 0 swpre
crbl_sp100_4 rbl_sp100_4 0 {C_RBL}
spr_sp100_4 pref_100 ref_sp100_4 ctl 0 swpre
cref_sp100_4 ref_sp100_4 0 {C_RBL}   $ ASSUMPTION: ideal matched dummy load
XMN1_sp100_4 rbl_sp100_4 ref_sp100_4 vn_sp100_4 0 sky130_fd_pr__nfet_01v8 L=0.15 W=1 nf=1 ad=0.29 as=0.29 pd=2.58 ps=2.58 nrd=0.29 nrs=0.29 sa=0 sb=0 sd=0 mult=1 m=1
XMN2_sp100_4 ref_sp100_4 rbl_sp100_4 vn_sp100_4 0 sky130_fd_pr__nfet_01v8 L=0.15 W=1 nf=1 ad=0.29 as=0.29 pd=2.58 ps=2.58 nrd=0.29 nrs=0.29 sa=0 sb=0 sd=0 mult=1 m=1
XMP1_sp100_4 rbl_sp100_4 ref_sp100_4 vp_sp100_4 vdd sky130_fd_pr__pfet_01v8 L=0.15 W=2 nf=1 ad=0.58 as=0.58 pd=4.58 ps=4.58 nrd=0.145 nrs=0.145 sa=0 sb=0 sd=0 mult=1 m=1
XMP2_sp100_4 ref_sp100_4 rbl_sp100_4 vp_sp100_4 vdd sky130_fd_pr__pfet_01v8 L=0.15 W=2 nf=1 ad=0.58 as=0.58 pd=4.58 ps=4.58 nrd=0.145 nrs=0.145 sa=0 sb=0 sd=0 mult=1 m=1
XMNF_sp100_4 vn_sp100_4 en 0 0 sky130_fd_pr__nfet_01v8 L=0.15 W=2 nf=1 ad=0.58 as=0.58 pd=4.58 ps=4.58 nrd=0.145 nrs=0.145 sa=0 sb=0 sd=0 mult=1 m=1
XMPH_sp100_4 vp_sp100_4 enb vdd vdd sky130_fd_pr__pfet_01v8 L=0.15 W=4 nf=1 ad=1.16 as=1.16 pd=8.58 ps=8.58 nrd=0.0725 nrs=0.0725 sa=0 sb=0 sd=0 mult=1 m=1
bd_sp100_4 d_sp100_4 0 v=v(rbl_sp100_4)-v(ref_sp100_4)
bdabs_sp100_4 dabs_sp100_4 0 v=abs(v(rbl_sp100_4)-v(ref_sp100_4))

* ---- sp100_5: d = 100 mV, replica 5 ----
spa_sp100_5 pa_p100 rbl_sp100_5 ctl 0 swpre
crbl_sp100_5 rbl_sp100_5 0 {C_RBL}
spr_sp100_5 pref_100 ref_sp100_5 ctl 0 swpre
cref_sp100_5 ref_sp100_5 0 {C_RBL}   $ ASSUMPTION: ideal matched dummy load
XMN1_sp100_5 rbl_sp100_5 ref_sp100_5 vn_sp100_5 0 sky130_fd_pr__nfet_01v8 L=0.15 W=1 nf=1 ad=0.29 as=0.29 pd=2.58 ps=2.58 nrd=0.29 nrs=0.29 sa=0 sb=0 sd=0 mult=1 m=1
XMN2_sp100_5 ref_sp100_5 rbl_sp100_5 vn_sp100_5 0 sky130_fd_pr__nfet_01v8 L=0.15 W=1 nf=1 ad=0.29 as=0.29 pd=2.58 ps=2.58 nrd=0.29 nrs=0.29 sa=0 sb=0 sd=0 mult=1 m=1
XMP1_sp100_5 rbl_sp100_5 ref_sp100_5 vp_sp100_5 vdd sky130_fd_pr__pfet_01v8 L=0.15 W=2 nf=1 ad=0.58 as=0.58 pd=4.58 ps=4.58 nrd=0.145 nrs=0.145 sa=0 sb=0 sd=0 mult=1 m=1
XMP2_sp100_5 ref_sp100_5 rbl_sp100_5 vp_sp100_5 vdd sky130_fd_pr__pfet_01v8 L=0.15 W=2 nf=1 ad=0.58 as=0.58 pd=4.58 ps=4.58 nrd=0.145 nrs=0.145 sa=0 sb=0 sd=0 mult=1 m=1
XMNF_sp100_5 vn_sp100_5 en 0 0 sky130_fd_pr__nfet_01v8 L=0.15 W=2 nf=1 ad=0.58 as=0.58 pd=4.58 ps=4.58 nrd=0.145 nrs=0.145 sa=0 sb=0 sd=0 mult=1 m=1
XMPH_sp100_5 vp_sp100_5 enb vdd vdd sky130_fd_pr__pfet_01v8 L=0.15 W=4 nf=1 ad=1.16 as=1.16 pd=8.58 ps=8.58 nrd=0.0725 nrs=0.0725 sa=0 sb=0 sd=0 mult=1 m=1
bd_sp100_5 d_sp100_5 0 v=v(rbl_sp100_5)-v(ref_sp100_5)
bdabs_sp100_5 dabs_sp100_5 0 v=abs(v(rbl_sp100_5)-v(ref_sp100_5))

* ---- sm100_0: d = -100 mV, replica 0 ----
spa_sm100_0 pa_m100 rbl_sm100_0 ctl 0 swpre
crbl_sm100_0 rbl_sm100_0 0 {C_RBL}
spr_sm100_0 pref_100 ref_sm100_0 ctl 0 swpre
cref_sm100_0 ref_sm100_0 0 {C_RBL}   $ ASSUMPTION: ideal matched dummy load
XMN1_sm100_0 rbl_sm100_0 ref_sm100_0 vn_sm100_0 0 sky130_fd_pr__nfet_01v8 L=0.15 W=1 nf=1 ad=0.29 as=0.29 pd=2.58 ps=2.58 nrd=0.29 nrs=0.29 sa=0 sb=0 sd=0 mult=1 m=1
XMN2_sm100_0 ref_sm100_0 rbl_sm100_0 vn_sm100_0 0 sky130_fd_pr__nfet_01v8 L=0.15 W=1 nf=1 ad=0.29 as=0.29 pd=2.58 ps=2.58 nrd=0.29 nrs=0.29 sa=0 sb=0 sd=0 mult=1 m=1
XMP1_sm100_0 rbl_sm100_0 ref_sm100_0 vp_sm100_0 vdd sky130_fd_pr__pfet_01v8 L=0.15 W=2 nf=1 ad=0.58 as=0.58 pd=4.58 ps=4.58 nrd=0.145 nrs=0.145 sa=0 sb=0 sd=0 mult=1 m=1
XMP2_sm100_0 ref_sm100_0 rbl_sm100_0 vp_sm100_0 vdd sky130_fd_pr__pfet_01v8 L=0.15 W=2 nf=1 ad=0.58 as=0.58 pd=4.58 ps=4.58 nrd=0.145 nrs=0.145 sa=0 sb=0 sd=0 mult=1 m=1
XMNF_sm100_0 vn_sm100_0 en 0 0 sky130_fd_pr__nfet_01v8 L=0.15 W=2 nf=1 ad=0.58 as=0.58 pd=4.58 ps=4.58 nrd=0.145 nrs=0.145 sa=0 sb=0 sd=0 mult=1 m=1
XMPH_sm100_0 vp_sm100_0 enb vdd vdd sky130_fd_pr__pfet_01v8 L=0.15 W=4 nf=1 ad=1.16 as=1.16 pd=8.58 ps=8.58 nrd=0.0725 nrs=0.0725 sa=0 sb=0 sd=0 mult=1 m=1
bd_sm100_0 d_sm100_0 0 v=v(rbl_sm100_0)-v(ref_sm100_0)
bdabs_sm100_0 dabs_sm100_0 0 v=abs(v(rbl_sm100_0)-v(ref_sm100_0))

* ---- sm100_1: d = -100 mV, replica 1 ----
spa_sm100_1 pa_m100 rbl_sm100_1 ctl 0 swpre
crbl_sm100_1 rbl_sm100_1 0 {C_RBL}
spr_sm100_1 pref_100 ref_sm100_1 ctl 0 swpre
cref_sm100_1 ref_sm100_1 0 {C_RBL}   $ ASSUMPTION: ideal matched dummy load
XMN1_sm100_1 rbl_sm100_1 ref_sm100_1 vn_sm100_1 0 sky130_fd_pr__nfet_01v8 L=0.15 W=1 nf=1 ad=0.29 as=0.29 pd=2.58 ps=2.58 nrd=0.29 nrs=0.29 sa=0 sb=0 sd=0 mult=1 m=1
XMN2_sm100_1 ref_sm100_1 rbl_sm100_1 vn_sm100_1 0 sky130_fd_pr__nfet_01v8 L=0.15 W=1 nf=1 ad=0.29 as=0.29 pd=2.58 ps=2.58 nrd=0.29 nrs=0.29 sa=0 sb=0 sd=0 mult=1 m=1
XMP1_sm100_1 rbl_sm100_1 ref_sm100_1 vp_sm100_1 vdd sky130_fd_pr__pfet_01v8 L=0.15 W=2 nf=1 ad=0.58 as=0.58 pd=4.58 ps=4.58 nrd=0.145 nrs=0.145 sa=0 sb=0 sd=0 mult=1 m=1
XMP2_sm100_1 ref_sm100_1 rbl_sm100_1 vp_sm100_1 vdd sky130_fd_pr__pfet_01v8 L=0.15 W=2 nf=1 ad=0.58 as=0.58 pd=4.58 ps=4.58 nrd=0.145 nrs=0.145 sa=0 sb=0 sd=0 mult=1 m=1
XMNF_sm100_1 vn_sm100_1 en 0 0 sky130_fd_pr__nfet_01v8 L=0.15 W=2 nf=1 ad=0.58 as=0.58 pd=4.58 ps=4.58 nrd=0.145 nrs=0.145 sa=0 sb=0 sd=0 mult=1 m=1
XMPH_sm100_1 vp_sm100_1 enb vdd vdd sky130_fd_pr__pfet_01v8 L=0.15 W=4 nf=1 ad=1.16 as=1.16 pd=8.58 ps=8.58 nrd=0.0725 nrs=0.0725 sa=0 sb=0 sd=0 mult=1 m=1
bd_sm100_1 d_sm100_1 0 v=v(rbl_sm100_1)-v(ref_sm100_1)
bdabs_sm100_1 dabs_sm100_1 0 v=abs(v(rbl_sm100_1)-v(ref_sm100_1))

* ---- sm100_2: d = -100 mV, replica 2 ----
spa_sm100_2 pa_m100 rbl_sm100_2 ctl 0 swpre
crbl_sm100_2 rbl_sm100_2 0 {C_RBL}
spr_sm100_2 pref_100 ref_sm100_2 ctl 0 swpre
cref_sm100_2 ref_sm100_2 0 {C_RBL}   $ ASSUMPTION: ideal matched dummy load
XMN1_sm100_2 rbl_sm100_2 ref_sm100_2 vn_sm100_2 0 sky130_fd_pr__nfet_01v8 L=0.15 W=1 nf=1 ad=0.29 as=0.29 pd=2.58 ps=2.58 nrd=0.29 nrs=0.29 sa=0 sb=0 sd=0 mult=1 m=1
XMN2_sm100_2 ref_sm100_2 rbl_sm100_2 vn_sm100_2 0 sky130_fd_pr__nfet_01v8 L=0.15 W=1 nf=1 ad=0.29 as=0.29 pd=2.58 ps=2.58 nrd=0.29 nrs=0.29 sa=0 sb=0 sd=0 mult=1 m=1
XMP1_sm100_2 rbl_sm100_2 ref_sm100_2 vp_sm100_2 vdd sky130_fd_pr__pfet_01v8 L=0.15 W=2 nf=1 ad=0.58 as=0.58 pd=4.58 ps=4.58 nrd=0.145 nrs=0.145 sa=0 sb=0 sd=0 mult=1 m=1
XMP2_sm100_2 ref_sm100_2 rbl_sm100_2 vp_sm100_2 vdd sky130_fd_pr__pfet_01v8 L=0.15 W=2 nf=1 ad=0.58 as=0.58 pd=4.58 ps=4.58 nrd=0.145 nrs=0.145 sa=0 sb=0 sd=0 mult=1 m=1
XMNF_sm100_2 vn_sm100_2 en 0 0 sky130_fd_pr__nfet_01v8 L=0.15 W=2 nf=1 ad=0.58 as=0.58 pd=4.58 ps=4.58 nrd=0.145 nrs=0.145 sa=0 sb=0 sd=0 mult=1 m=1
XMPH_sm100_2 vp_sm100_2 enb vdd vdd sky130_fd_pr__pfet_01v8 L=0.15 W=4 nf=1 ad=1.16 as=1.16 pd=8.58 ps=8.58 nrd=0.0725 nrs=0.0725 sa=0 sb=0 sd=0 mult=1 m=1
bd_sm100_2 d_sm100_2 0 v=v(rbl_sm100_2)-v(ref_sm100_2)
bdabs_sm100_2 dabs_sm100_2 0 v=abs(v(rbl_sm100_2)-v(ref_sm100_2))

* ---- sm100_3: d = -100 mV, replica 3 ----
spa_sm100_3 pa_m100 rbl_sm100_3 ctl 0 swpre
crbl_sm100_3 rbl_sm100_3 0 {C_RBL}
spr_sm100_3 pref_100 ref_sm100_3 ctl 0 swpre
cref_sm100_3 ref_sm100_3 0 {C_RBL}   $ ASSUMPTION: ideal matched dummy load
XMN1_sm100_3 rbl_sm100_3 ref_sm100_3 vn_sm100_3 0 sky130_fd_pr__nfet_01v8 L=0.15 W=1 nf=1 ad=0.29 as=0.29 pd=2.58 ps=2.58 nrd=0.29 nrs=0.29 sa=0 sb=0 sd=0 mult=1 m=1
XMN2_sm100_3 ref_sm100_3 rbl_sm100_3 vn_sm100_3 0 sky130_fd_pr__nfet_01v8 L=0.15 W=1 nf=1 ad=0.29 as=0.29 pd=2.58 ps=2.58 nrd=0.29 nrs=0.29 sa=0 sb=0 sd=0 mult=1 m=1
XMP1_sm100_3 rbl_sm100_3 ref_sm100_3 vp_sm100_3 vdd sky130_fd_pr__pfet_01v8 L=0.15 W=2 nf=1 ad=0.58 as=0.58 pd=4.58 ps=4.58 nrd=0.145 nrs=0.145 sa=0 sb=0 sd=0 mult=1 m=1
XMP2_sm100_3 ref_sm100_3 rbl_sm100_3 vp_sm100_3 vdd sky130_fd_pr__pfet_01v8 L=0.15 W=2 nf=1 ad=0.58 as=0.58 pd=4.58 ps=4.58 nrd=0.145 nrs=0.145 sa=0 sb=0 sd=0 mult=1 m=1
XMNF_sm100_3 vn_sm100_3 en 0 0 sky130_fd_pr__nfet_01v8 L=0.15 W=2 nf=1 ad=0.58 as=0.58 pd=4.58 ps=4.58 nrd=0.145 nrs=0.145 sa=0 sb=0 sd=0 mult=1 m=1
XMPH_sm100_3 vp_sm100_3 enb vdd vdd sky130_fd_pr__pfet_01v8 L=0.15 W=4 nf=1 ad=1.16 as=1.16 pd=8.58 ps=8.58 nrd=0.0725 nrs=0.0725 sa=0 sb=0 sd=0 mult=1 m=1
bd_sm100_3 d_sm100_3 0 v=v(rbl_sm100_3)-v(ref_sm100_3)
bdabs_sm100_3 dabs_sm100_3 0 v=abs(v(rbl_sm100_3)-v(ref_sm100_3))

* ---- sm100_4: d = -100 mV, replica 4 ----
spa_sm100_4 pa_m100 rbl_sm100_4 ctl 0 swpre
crbl_sm100_4 rbl_sm100_4 0 {C_RBL}
spr_sm100_4 pref_100 ref_sm100_4 ctl 0 swpre
cref_sm100_4 ref_sm100_4 0 {C_RBL}   $ ASSUMPTION: ideal matched dummy load
XMN1_sm100_4 rbl_sm100_4 ref_sm100_4 vn_sm100_4 0 sky130_fd_pr__nfet_01v8 L=0.15 W=1 nf=1 ad=0.29 as=0.29 pd=2.58 ps=2.58 nrd=0.29 nrs=0.29 sa=0 sb=0 sd=0 mult=1 m=1
XMN2_sm100_4 ref_sm100_4 rbl_sm100_4 vn_sm100_4 0 sky130_fd_pr__nfet_01v8 L=0.15 W=1 nf=1 ad=0.29 as=0.29 pd=2.58 ps=2.58 nrd=0.29 nrs=0.29 sa=0 sb=0 sd=0 mult=1 m=1
XMP1_sm100_4 rbl_sm100_4 ref_sm100_4 vp_sm100_4 vdd sky130_fd_pr__pfet_01v8 L=0.15 W=2 nf=1 ad=0.58 as=0.58 pd=4.58 ps=4.58 nrd=0.145 nrs=0.145 sa=0 sb=0 sd=0 mult=1 m=1
XMP2_sm100_4 ref_sm100_4 rbl_sm100_4 vp_sm100_4 vdd sky130_fd_pr__pfet_01v8 L=0.15 W=2 nf=1 ad=0.58 as=0.58 pd=4.58 ps=4.58 nrd=0.145 nrs=0.145 sa=0 sb=0 sd=0 mult=1 m=1
XMNF_sm100_4 vn_sm100_4 en 0 0 sky130_fd_pr__nfet_01v8 L=0.15 W=2 nf=1 ad=0.58 as=0.58 pd=4.58 ps=4.58 nrd=0.145 nrs=0.145 sa=0 sb=0 sd=0 mult=1 m=1
XMPH_sm100_4 vp_sm100_4 enb vdd vdd sky130_fd_pr__pfet_01v8 L=0.15 W=4 nf=1 ad=1.16 as=1.16 pd=8.58 ps=8.58 nrd=0.0725 nrs=0.0725 sa=0 sb=0 sd=0 mult=1 m=1
bd_sm100_4 d_sm100_4 0 v=v(rbl_sm100_4)-v(ref_sm100_4)
bdabs_sm100_4 dabs_sm100_4 0 v=abs(v(rbl_sm100_4)-v(ref_sm100_4))

* ---- sm100_5: d = -100 mV, replica 5 ----
spa_sm100_5 pa_m100 rbl_sm100_5 ctl 0 swpre
crbl_sm100_5 rbl_sm100_5 0 {C_RBL}
spr_sm100_5 pref_100 ref_sm100_5 ctl 0 swpre
cref_sm100_5 ref_sm100_5 0 {C_RBL}   $ ASSUMPTION: ideal matched dummy load
XMN1_sm100_5 rbl_sm100_5 ref_sm100_5 vn_sm100_5 0 sky130_fd_pr__nfet_01v8 L=0.15 W=1 nf=1 ad=0.29 as=0.29 pd=2.58 ps=2.58 nrd=0.29 nrs=0.29 sa=0 sb=0 sd=0 mult=1 m=1
XMN2_sm100_5 ref_sm100_5 rbl_sm100_5 vn_sm100_5 0 sky130_fd_pr__nfet_01v8 L=0.15 W=1 nf=1 ad=0.29 as=0.29 pd=2.58 ps=2.58 nrd=0.29 nrs=0.29 sa=0 sb=0 sd=0 mult=1 m=1
XMP1_sm100_5 rbl_sm100_5 ref_sm100_5 vp_sm100_5 vdd sky130_fd_pr__pfet_01v8 L=0.15 W=2 nf=1 ad=0.58 as=0.58 pd=4.58 ps=4.58 nrd=0.145 nrs=0.145 sa=0 sb=0 sd=0 mult=1 m=1
XMP2_sm100_5 ref_sm100_5 rbl_sm100_5 vp_sm100_5 vdd sky130_fd_pr__pfet_01v8 L=0.15 W=2 nf=1 ad=0.58 as=0.58 pd=4.58 ps=4.58 nrd=0.145 nrs=0.145 sa=0 sb=0 sd=0 mult=1 m=1
XMNF_sm100_5 vn_sm100_5 en 0 0 sky130_fd_pr__nfet_01v8 L=0.15 W=2 nf=1 ad=0.58 as=0.58 pd=4.58 ps=4.58 nrd=0.145 nrs=0.145 sa=0 sb=0 sd=0 mult=1 m=1
XMPH_sm100_5 vp_sm100_5 enb vdd vdd sky130_fd_pr__pfet_01v8 L=0.15 W=4 nf=1 ad=1.16 as=1.16 pd=8.58 ps=8.58 nrd=0.0725 nrs=0.0725 sa=0 sb=0 sd=0 mult=1 m=1
bd_sm100_5 d_sm100_5 0 v=v(rbl_sm100_5)-v(ref_sm100_5)
bdabs_sm100_5 dabs_sm100_5 0 v=abs(v(rbl_sm100_5)-v(ref_sm100_5))

* ---- sp150_0: d = 150 mV, replica 0 ----
spa_sp150_0 pa_p150 rbl_sp150_0 ctl 0 swpre
crbl_sp150_0 rbl_sp150_0 0 {C_RBL}
spr_sp150_0 pref_100 ref_sp150_0 ctl 0 swpre
cref_sp150_0 ref_sp150_0 0 {C_RBL}   $ ASSUMPTION: ideal matched dummy load
XMN1_sp150_0 rbl_sp150_0 ref_sp150_0 vn_sp150_0 0 sky130_fd_pr__nfet_01v8 L=0.15 W=1 nf=1 ad=0.29 as=0.29 pd=2.58 ps=2.58 nrd=0.29 nrs=0.29 sa=0 sb=0 sd=0 mult=1 m=1
XMN2_sp150_0 ref_sp150_0 rbl_sp150_0 vn_sp150_0 0 sky130_fd_pr__nfet_01v8 L=0.15 W=1 nf=1 ad=0.29 as=0.29 pd=2.58 ps=2.58 nrd=0.29 nrs=0.29 sa=0 sb=0 sd=0 mult=1 m=1
XMP1_sp150_0 rbl_sp150_0 ref_sp150_0 vp_sp150_0 vdd sky130_fd_pr__pfet_01v8 L=0.15 W=2 nf=1 ad=0.58 as=0.58 pd=4.58 ps=4.58 nrd=0.145 nrs=0.145 sa=0 sb=0 sd=0 mult=1 m=1
XMP2_sp150_0 ref_sp150_0 rbl_sp150_0 vp_sp150_0 vdd sky130_fd_pr__pfet_01v8 L=0.15 W=2 nf=1 ad=0.58 as=0.58 pd=4.58 ps=4.58 nrd=0.145 nrs=0.145 sa=0 sb=0 sd=0 mult=1 m=1
XMNF_sp150_0 vn_sp150_0 en 0 0 sky130_fd_pr__nfet_01v8 L=0.15 W=2 nf=1 ad=0.58 as=0.58 pd=4.58 ps=4.58 nrd=0.145 nrs=0.145 sa=0 sb=0 sd=0 mult=1 m=1
XMPH_sp150_0 vp_sp150_0 enb vdd vdd sky130_fd_pr__pfet_01v8 L=0.15 W=4 nf=1 ad=1.16 as=1.16 pd=8.58 ps=8.58 nrd=0.0725 nrs=0.0725 sa=0 sb=0 sd=0 mult=1 m=1
bd_sp150_0 d_sp150_0 0 v=v(rbl_sp150_0)-v(ref_sp150_0)
bdabs_sp150_0 dabs_sp150_0 0 v=abs(v(rbl_sp150_0)-v(ref_sp150_0))

* ---- sp150_1: d = 150 mV, replica 1 ----
spa_sp150_1 pa_p150 rbl_sp150_1 ctl 0 swpre
crbl_sp150_1 rbl_sp150_1 0 {C_RBL}
spr_sp150_1 pref_100 ref_sp150_1 ctl 0 swpre
cref_sp150_1 ref_sp150_1 0 {C_RBL}   $ ASSUMPTION: ideal matched dummy load
XMN1_sp150_1 rbl_sp150_1 ref_sp150_1 vn_sp150_1 0 sky130_fd_pr__nfet_01v8 L=0.15 W=1 nf=1 ad=0.29 as=0.29 pd=2.58 ps=2.58 nrd=0.29 nrs=0.29 sa=0 sb=0 sd=0 mult=1 m=1
XMN2_sp150_1 ref_sp150_1 rbl_sp150_1 vn_sp150_1 0 sky130_fd_pr__nfet_01v8 L=0.15 W=1 nf=1 ad=0.29 as=0.29 pd=2.58 ps=2.58 nrd=0.29 nrs=0.29 sa=0 sb=0 sd=0 mult=1 m=1
XMP1_sp150_1 rbl_sp150_1 ref_sp150_1 vp_sp150_1 vdd sky130_fd_pr__pfet_01v8 L=0.15 W=2 nf=1 ad=0.58 as=0.58 pd=4.58 ps=4.58 nrd=0.145 nrs=0.145 sa=0 sb=0 sd=0 mult=1 m=1
XMP2_sp150_1 ref_sp150_1 rbl_sp150_1 vp_sp150_1 vdd sky130_fd_pr__pfet_01v8 L=0.15 W=2 nf=1 ad=0.58 as=0.58 pd=4.58 ps=4.58 nrd=0.145 nrs=0.145 sa=0 sb=0 sd=0 mult=1 m=1
XMNF_sp150_1 vn_sp150_1 en 0 0 sky130_fd_pr__nfet_01v8 L=0.15 W=2 nf=1 ad=0.58 as=0.58 pd=4.58 ps=4.58 nrd=0.145 nrs=0.145 sa=0 sb=0 sd=0 mult=1 m=1
XMPH_sp150_1 vp_sp150_1 enb vdd vdd sky130_fd_pr__pfet_01v8 L=0.15 W=4 nf=1 ad=1.16 as=1.16 pd=8.58 ps=8.58 nrd=0.0725 nrs=0.0725 sa=0 sb=0 sd=0 mult=1 m=1
bd_sp150_1 d_sp150_1 0 v=v(rbl_sp150_1)-v(ref_sp150_1)
bdabs_sp150_1 dabs_sp150_1 0 v=abs(v(rbl_sp150_1)-v(ref_sp150_1))

* ---- sp150_2: d = 150 mV, replica 2 ----
spa_sp150_2 pa_p150 rbl_sp150_2 ctl 0 swpre
crbl_sp150_2 rbl_sp150_2 0 {C_RBL}
spr_sp150_2 pref_100 ref_sp150_2 ctl 0 swpre
cref_sp150_2 ref_sp150_2 0 {C_RBL}   $ ASSUMPTION: ideal matched dummy load
XMN1_sp150_2 rbl_sp150_2 ref_sp150_2 vn_sp150_2 0 sky130_fd_pr__nfet_01v8 L=0.15 W=1 nf=1 ad=0.29 as=0.29 pd=2.58 ps=2.58 nrd=0.29 nrs=0.29 sa=0 sb=0 sd=0 mult=1 m=1
XMN2_sp150_2 ref_sp150_2 rbl_sp150_2 vn_sp150_2 0 sky130_fd_pr__nfet_01v8 L=0.15 W=1 nf=1 ad=0.29 as=0.29 pd=2.58 ps=2.58 nrd=0.29 nrs=0.29 sa=0 sb=0 sd=0 mult=1 m=1
XMP1_sp150_2 rbl_sp150_2 ref_sp150_2 vp_sp150_2 vdd sky130_fd_pr__pfet_01v8 L=0.15 W=2 nf=1 ad=0.58 as=0.58 pd=4.58 ps=4.58 nrd=0.145 nrs=0.145 sa=0 sb=0 sd=0 mult=1 m=1
XMP2_sp150_2 ref_sp150_2 rbl_sp150_2 vp_sp150_2 vdd sky130_fd_pr__pfet_01v8 L=0.15 W=2 nf=1 ad=0.58 as=0.58 pd=4.58 ps=4.58 nrd=0.145 nrs=0.145 sa=0 sb=0 sd=0 mult=1 m=1
XMNF_sp150_2 vn_sp150_2 en 0 0 sky130_fd_pr__nfet_01v8 L=0.15 W=2 nf=1 ad=0.58 as=0.58 pd=4.58 ps=4.58 nrd=0.145 nrs=0.145 sa=0 sb=0 sd=0 mult=1 m=1
XMPH_sp150_2 vp_sp150_2 enb vdd vdd sky130_fd_pr__pfet_01v8 L=0.15 W=4 nf=1 ad=1.16 as=1.16 pd=8.58 ps=8.58 nrd=0.0725 nrs=0.0725 sa=0 sb=0 sd=0 mult=1 m=1
bd_sp150_2 d_sp150_2 0 v=v(rbl_sp150_2)-v(ref_sp150_2)
bdabs_sp150_2 dabs_sp150_2 0 v=abs(v(rbl_sp150_2)-v(ref_sp150_2))

* ---- sp150_3: d = 150 mV, replica 3 ----
spa_sp150_3 pa_p150 rbl_sp150_3 ctl 0 swpre
crbl_sp150_3 rbl_sp150_3 0 {C_RBL}
spr_sp150_3 pref_100 ref_sp150_3 ctl 0 swpre
cref_sp150_3 ref_sp150_3 0 {C_RBL}   $ ASSUMPTION: ideal matched dummy load
XMN1_sp150_3 rbl_sp150_3 ref_sp150_3 vn_sp150_3 0 sky130_fd_pr__nfet_01v8 L=0.15 W=1 nf=1 ad=0.29 as=0.29 pd=2.58 ps=2.58 nrd=0.29 nrs=0.29 sa=0 sb=0 sd=0 mult=1 m=1
XMN2_sp150_3 ref_sp150_3 rbl_sp150_3 vn_sp150_3 0 sky130_fd_pr__nfet_01v8 L=0.15 W=1 nf=1 ad=0.29 as=0.29 pd=2.58 ps=2.58 nrd=0.29 nrs=0.29 sa=0 sb=0 sd=0 mult=1 m=1
XMP1_sp150_3 rbl_sp150_3 ref_sp150_3 vp_sp150_3 vdd sky130_fd_pr__pfet_01v8 L=0.15 W=2 nf=1 ad=0.58 as=0.58 pd=4.58 ps=4.58 nrd=0.145 nrs=0.145 sa=0 sb=0 sd=0 mult=1 m=1
XMP2_sp150_3 ref_sp150_3 rbl_sp150_3 vp_sp150_3 vdd sky130_fd_pr__pfet_01v8 L=0.15 W=2 nf=1 ad=0.58 as=0.58 pd=4.58 ps=4.58 nrd=0.145 nrs=0.145 sa=0 sb=0 sd=0 mult=1 m=1
XMNF_sp150_3 vn_sp150_3 en 0 0 sky130_fd_pr__nfet_01v8 L=0.15 W=2 nf=1 ad=0.58 as=0.58 pd=4.58 ps=4.58 nrd=0.145 nrs=0.145 sa=0 sb=0 sd=0 mult=1 m=1
XMPH_sp150_3 vp_sp150_3 enb vdd vdd sky130_fd_pr__pfet_01v8 L=0.15 W=4 nf=1 ad=1.16 as=1.16 pd=8.58 ps=8.58 nrd=0.0725 nrs=0.0725 sa=0 sb=0 sd=0 mult=1 m=1
bd_sp150_3 d_sp150_3 0 v=v(rbl_sp150_3)-v(ref_sp150_3)
bdabs_sp150_3 dabs_sp150_3 0 v=abs(v(rbl_sp150_3)-v(ref_sp150_3))

* ---- sp150_4: d = 150 mV, replica 4 ----
spa_sp150_4 pa_p150 rbl_sp150_4 ctl 0 swpre
crbl_sp150_4 rbl_sp150_4 0 {C_RBL}
spr_sp150_4 pref_100 ref_sp150_4 ctl 0 swpre
cref_sp150_4 ref_sp150_4 0 {C_RBL}   $ ASSUMPTION: ideal matched dummy load
XMN1_sp150_4 rbl_sp150_4 ref_sp150_4 vn_sp150_4 0 sky130_fd_pr__nfet_01v8 L=0.15 W=1 nf=1 ad=0.29 as=0.29 pd=2.58 ps=2.58 nrd=0.29 nrs=0.29 sa=0 sb=0 sd=0 mult=1 m=1
XMN2_sp150_4 ref_sp150_4 rbl_sp150_4 vn_sp150_4 0 sky130_fd_pr__nfet_01v8 L=0.15 W=1 nf=1 ad=0.29 as=0.29 pd=2.58 ps=2.58 nrd=0.29 nrs=0.29 sa=0 sb=0 sd=0 mult=1 m=1
XMP1_sp150_4 rbl_sp150_4 ref_sp150_4 vp_sp150_4 vdd sky130_fd_pr__pfet_01v8 L=0.15 W=2 nf=1 ad=0.58 as=0.58 pd=4.58 ps=4.58 nrd=0.145 nrs=0.145 sa=0 sb=0 sd=0 mult=1 m=1
XMP2_sp150_4 ref_sp150_4 rbl_sp150_4 vp_sp150_4 vdd sky130_fd_pr__pfet_01v8 L=0.15 W=2 nf=1 ad=0.58 as=0.58 pd=4.58 ps=4.58 nrd=0.145 nrs=0.145 sa=0 sb=0 sd=0 mult=1 m=1
XMNF_sp150_4 vn_sp150_4 en 0 0 sky130_fd_pr__nfet_01v8 L=0.15 W=2 nf=1 ad=0.58 as=0.58 pd=4.58 ps=4.58 nrd=0.145 nrs=0.145 sa=0 sb=0 sd=0 mult=1 m=1
XMPH_sp150_4 vp_sp150_4 enb vdd vdd sky130_fd_pr__pfet_01v8 L=0.15 W=4 nf=1 ad=1.16 as=1.16 pd=8.58 ps=8.58 nrd=0.0725 nrs=0.0725 sa=0 sb=0 sd=0 mult=1 m=1
bd_sp150_4 d_sp150_4 0 v=v(rbl_sp150_4)-v(ref_sp150_4)
bdabs_sp150_4 dabs_sp150_4 0 v=abs(v(rbl_sp150_4)-v(ref_sp150_4))

* ---- sp150_5: d = 150 mV, replica 5 ----
spa_sp150_5 pa_p150 rbl_sp150_5 ctl 0 swpre
crbl_sp150_5 rbl_sp150_5 0 {C_RBL}
spr_sp150_5 pref_100 ref_sp150_5 ctl 0 swpre
cref_sp150_5 ref_sp150_5 0 {C_RBL}   $ ASSUMPTION: ideal matched dummy load
XMN1_sp150_5 rbl_sp150_5 ref_sp150_5 vn_sp150_5 0 sky130_fd_pr__nfet_01v8 L=0.15 W=1 nf=1 ad=0.29 as=0.29 pd=2.58 ps=2.58 nrd=0.29 nrs=0.29 sa=0 sb=0 sd=0 mult=1 m=1
XMN2_sp150_5 ref_sp150_5 rbl_sp150_5 vn_sp150_5 0 sky130_fd_pr__nfet_01v8 L=0.15 W=1 nf=1 ad=0.29 as=0.29 pd=2.58 ps=2.58 nrd=0.29 nrs=0.29 sa=0 sb=0 sd=0 mult=1 m=1
XMP1_sp150_5 rbl_sp150_5 ref_sp150_5 vp_sp150_5 vdd sky130_fd_pr__pfet_01v8 L=0.15 W=2 nf=1 ad=0.58 as=0.58 pd=4.58 ps=4.58 nrd=0.145 nrs=0.145 sa=0 sb=0 sd=0 mult=1 m=1
XMP2_sp150_5 ref_sp150_5 rbl_sp150_5 vp_sp150_5 vdd sky130_fd_pr__pfet_01v8 L=0.15 W=2 nf=1 ad=0.58 as=0.58 pd=4.58 ps=4.58 nrd=0.145 nrs=0.145 sa=0 sb=0 sd=0 mult=1 m=1
XMNF_sp150_5 vn_sp150_5 en 0 0 sky130_fd_pr__nfet_01v8 L=0.15 W=2 nf=1 ad=0.58 as=0.58 pd=4.58 ps=4.58 nrd=0.145 nrs=0.145 sa=0 sb=0 sd=0 mult=1 m=1
XMPH_sp150_5 vp_sp150_5 enb vdd vdd sky130_fd_pr__pfet_01v8 L=0.15 W=4 nf=1 ad=1.16 as=1.16 pd=8.58 ps=8.58 nrd=0.0725 nrs=0.0725 sa=0 sb=0 sd=0 mult=1 m=1
bd_sp150_5 d_sp150_5 0 v=v(rbl_sp150_5)-v(ref_sp150_5)
bdabs_sp150_5 dabs_sp150_5 0 v=abs(v(rbl_sp150_5)-v(ref_sp150_5))

* ---- sm150_0: d = -150 mV, replica 0 ----
spa_sm150_0 pa_m150 rbl_sm150_0 ctl 0 swpre
crbl_sm150_0 rbl_sm150_0 0 {C_RBL}
spr_sm150_0 pref_100 ref_sm150_0 ctl 0 swpre
cref_sm150_0 ref_sm150_0 0 {C_RBL}   $ ASSUMPTION: ideal matched dummy load
XMN1_sm150_0 rbl_sm150_0 ref_sm150_0 vn_sm150_0 0 sky130_fd_pr__nfet_01v8 L=0.15 W=1 nf=1 ad=0.29 as=0.29 pd=2.58 ps=2.58 nrd=0.29 nrs=0.29 sa=0 sb=0 sd=0 mult=1 m=1
XMN2_sm150_0 ref_sm150_0 rbl_sm150_0 vn_sm150_0 0 sky130_fd_pr__nfet_01v8 L=0.15 W=1 nf=1 ad=0.29 as=0.29 pd=2.58 ps=2.58 nrd=0.29 nrs=0.29 sa=0 sb=0 sd=0 mult=1 m=1
XMP1_sm150_0 rbl_sm150_0 ref_sm150_0 vp_sm150_0 vdd sky130_fd_pr__pfet_01v8 L=0.15 W=2 nf=1 ad=0.58 as=0.58 pd=4.58 ps=4.58 nrd=0.145 nrs=0.145 sa=0 sb=0 sd=0 mult=1 m=1
XMP2_sm150_0 ref_sm150_0 rbl_sm150_0 vp_sm150_0 vdd sky130_fd_pr__pfet_01v8 L=0.15 W=2 nf=1 ad=0.58 as=0.58 pd=4.58 ps=4.58 nrd=0.145 nrs=0.145 sa=0 sb=0 sd=0 mult=1 m=1
XMNF_sm150_0 vn_sm150_0 en 0 0 sky130_fd_pr__nfet_01v8 L=0.15 W=2 nf=1 ad=0.58 as=0.58 pd=4.58 ps=4.58 nrd=0.145 nrs=0.145 sa=0 sb=0 sd=0 mult=1 m=1
XMPH_sm150_0 vp_sm150_0 enb vdd vdd sky130_fd_pr__pfet_01v8 L=0.15 W=4 nf=1 ad=1.16 as=1.16 pd=8.58 ps=8.58 nrd=0.0725 nrs=0.0725 sa=0 sb=0 sd=0 mult=1 m=1
bd_sm150_0 d_sm150_0 0 v=v(rbl_sm150_0)-v(ref_sm150_0)
bdabs_sm150_0 dabs_sm150_0 0 v=abs(v(rbl_sm150_0)-v(ref_sm150_0))

* ---- sm150_1: d = -150 mV, replica 1 ----
spa_sm150_1 pa_m150 rbl_sm150_1 ctl 0 swpre
crbl_sm150_1 rbl_sm150_1 0 {C_RBL}
spr_sm150_1 pref_100 ref_sm150_1 ctl 0 swpre
cref_sm150_1 ref_sm150_1 0 {C_RBL}   $ ASSUMPTION: ideal matched dummy load
XMN1_sm150_1 rbl_sm150_1 ref_sm150_1 vn_sm150_1 0 sky130_fd_pr__nfet_01v8 L=0.15 W=1 nf=1 ad=0.29 as=0.29 pd=2.58 ps=2.58 nrd=0.29 nrs=0.29 sa=0 sb=0 sd=0 mult=1 m=1
XMN2_sm150_1 ref_sm150_1 rbl_sm150_1 vn_sm150_1 0 sky130_fd_pr__nfet_01v8 L=0.15 W=1 nf=1 ad=0.29 as=0.29 pd=2.58 ps=2.58 nrd=0.29 nrs=0.29 sa=0 sb=0 sd=0 mult=1 m=1
XMP1_sm150_1 rbl_sm150_1 ref_sm150_1 vp_sm150_1 vdd sky130_fd_pr__pfet_01v8 L=0.15 W=2 nf=1 ad=0.58 as=0.58 pd=4.58 ps=4.58 nrd=0.145 nrs=0.145 sa=0 sb=0 sd=0 mult=1 m=1
XMP2_sm150_1 ref_sm150_1 rbl_sm150_1 vp_sm150_1 vdd sky130_fd_pr__pfet_01v8 L=0.15 W=2 nf=1 ad=0.58 as=0.58 pd=4.58 ps=4.58 nrd=0.145 nrs=0.145 sa=0 sb=0 sd=0 mult=1 m=1
XMNF_sm150_1 vn_sm150_1 en 0 0 sky130_fd_pr__nfet_01v8 L=0.15 W=2 nf=1 ad=0.58 as=0.58 pd=4.58 ps=4.58 nrd=0.145 nrs=0.145 sa=0 sb=0 sd=0 mult=1 m=1
XMPH_sm150_1 vp_sm150_1 enb vdd vdd sky130_fd_pr__pfet_01v8 L=0.15 W=4 nf=1 ad=1.16 as=1.16 pd=8.58 ps=8.58 nrd=0.0725 nrs=0.0725 sa=0 sb=0 sd=0 mult=1 m=1
bd_sm150_1 d_sm150_1 0 v=v(rbl_sm150_1)-v(ref_sm150_1)
bdabs_sm150_1 dabs_sm150_1 0 v=abs(v(rbl_sm150_1)-v(ref_sm150_1))

* ---- sm150_2: d = -150 mV, replica 2 ----
spa_sm150_2 pa_m150 rbl_sm150_2 ctl 0 swpre
crbl_sm150_2 rbl_sm150_2 0 {C_RBL}
spr_sm150_2 pref_100 ref_sm150_2 ctl 0 swpre
cref_sm150_2 ref_sm150_2 0 {C_RBL}   $ ASSUMPTION: ideal matched dummy load
XMN1_sm150_2 rbl_sm150_2 ref_sm150_2 vn_sm150_2 0 sky130_fd_pr__nfet_01v8 L=0.15 W=1 nf=1 ad=0.29 as=0.29 pd=2.58 ps=2.58 nrd=0.29 nrs=0.29 sa=0 sb=0 sd=0 mult=1 m=1
XMN2_sm150_2 ref_sm150_2 rbl_sm150_2 vn_sm150_2 0 sky130_fd_pr__nfet_01v8 L=0.15 W=1 nf=1 ad=0.29 as=0.29 pd=2.58 ps=2.58 nrd=0.29 nrs=0.29 sa=0 sb=0 sd=0 mult=1 m=1
XMP1_sm150_2 rbl_sm150_2 ref_sm150_2 vp_sm150_2 vdd sky130_fd_pr__pfet_01v8 L=0.15 W=2 nf=1 ad=0.58 as=0.58 pd=4.58 ps=4.58 nrd=0.145 nrs=0.145 sa=0 sb=0 sd=0 mult=1 m=1
XMP2_sm150_2 ref_sm150_2 rbl_sm150_2 vp_sm150_2 vdd sky130_fd_pr__pfet_01v8 L=0.15 W=2 nf=1 ad=0.58 as=0.58 pd=4.58 ps=4.58 nrd=0.145 nrs=0.145 sa=0 sb=0 sd=0 mult=1 m=1
XMNF_sm150_2 vn_sm150_2 en 0 0 sky130_fd_pr__nfet_01v8 L=0.15 W=2 nf=1 ad=0.58 as=0.58 pd=4.58 ps=4.58 nrd=0.145 nrs=0.145 sa=0 sb=0 sd=0 mult=1 m=1
XMPH_sm150_2 vp_sm150_2 enb vdd vdd sky130_fd_pr__pfet_01v8 L=0.15 W=4 nf=1 ad=1.16 as=1.16 pd=8.58 ps=8.58 nrd=0.0725 nrs=0.0725 sa=0 sb=0 sd=0 mult=1 m=1
bd_sm150_2 d_sm150_2 0 v=v(rbl_sm150_2)-v(ref_sm150_2)
bdabs_sm150_2 dabs_sm150_2 0 v=abs(v(rbl_sm150_2)-v(ref_sm150_2))

* ---- sm150_3: d = -150 mV, replica 3 ----
spa_sm150_3 pa_m150 rbl_sm150_3 ctl 0 swpre
crbl_sm150_3 rbl_sm150_3 0 {C_RBL}
spr_sm150_3 pref_100 ref_sm150_3 ctl 0 swpre
cref_sm150_3 ref_sm150_3 0 {C_RBL}   $ ASSUMPTION: ideal matched dummy load
XMN1_sm150_3 rbl_sm150_3 ref_sm150_3 vn_sm150_3 0 sky130_fd_pr__nfet_01v8 L=0.15 W=1 nf=1 ad=0.29 as=0.29 pd=2.58 ps=2.58 nrd=0.29 nrs=0.29 sa=0 sb=0 sd=0 mult=1 m=1
XMN2_sm150_3 ref_sm150_3 rbl_sm150_3 vn_sm150_3 0 sky130_fd_pr__nfet_01v8 L=0.15 W=1 nf=1 ad=0.29 as=0.29 pd=2.58 ps=2.58 nrd=0.29 nrs=0.29 sa=0 sb=0 sd=0 mult=1 m=1
XMP1_sm150_3 rbl_sm150_3 ref_sm150_3 vp_sm150_3 vdd sky130_fd_pr__pfet_01v8 L=0.15 W=2 nf=1 ad=0.58 as=0.58 pd=4.58 ps=4.58 nrd=0.145 nrs=0.145 sa=0 sb=0 sd=0 mult=1 m=1
XMP2_sm150_3 ref_sm150_3 rbl_sm150_3 vp_sm150_3 vdd sky130_fd_pr__pfet_01v8 L=0.15 W=2 nf=1 ad=0.58 as=0.58 pd=4.58 ps=4.58 nrd=0.145 nrs=0.145 sa=0 sb=0 sd=0 mult=1 m=1
XMNF_sm150_3 vn_sm150_3 en 0 0 sky130_fd_pr__nfet_01v8 L=0.15 W=2 nf=1 ad=0.58 as=0.58 pd=4.58 ps=4.58 nrd=0.145 nrs=0.145 sa=0 sb=0 sd=0 mult=1 m=1
XMPH_sm150_3 vp_sm150_3 enb vdd vdd sky130_fd_pr__pfet_01v8 L=0.15 W=4 nf=1 ad=1.16 as=1.16 pd=8.58 ps=8.58 nrd=0.0725 nrs=0.0725 sa=0 sb=0 sd=0 mult=1 m=1
bd_sm150_3 d_sm150_3 0 v=v(rbl_sm150_3)-v(ref_sm150_3)
bdabs_sm150_3 dabs_sm150_3 0 v=abs(v(rbl_sm150_3)-v(ref_sm150_3))

* ---- sm150_4: d = -150 mV, replica 4 ----
spa_sm150_4 pa_m150 rbl_sm150_4 ctl 0 swpre
crbl_sm150_4 rbl_sm150_4 0 {C_RBL}
spr_sm150_4 pref_100 ref_sm150_4 ctl 0 swpre
cref_sm150_4 ref_sm150_4 0 {C_RBL}   $ ASSUMPTION: ideal matched dummy load
XMN1_sm150_4 rbl_sm150_4 ref_sm150_4 vn_sm150_4 0 sky130_fd_pr__nfet_01v8 L=0.15 W=1 nf=1 ad=0.29 as=0.29 pd=2.58 ps=2.58 nrd=0.29 nrs=0.29 sa=0 sb=0 sd=0 mult=1 m=1
XMN2_sm150_4 ref_sm150_4 rbl_sm150_4 vn_sm150_4 0 sky130_fd_pr__nfet_01v8 L=0.15 W=1 nf=1 ad=0.29 as=0.29 pd=2.58 ps=2.58 nrd=0.29 nrs=0.29 sa=0 sb=0 sd=0 mult=1 m=1
XMP1_sm150_4 rbl_sm150_4 ref_sm150_4 vp_sm150_4 vdd sky130_fd_pr__pfet_01v8 L=0.15 W=2 nf=1 ad=0.58 as=0.58 pd=4.58 ps=4.58 nrd=0.145 nrs=0.145 sa=0 sb=0 sd=0 mult=1 m=1
XMP2_sm150_4 ref_sm150_4 rbl_sm150_4 vp_sm150_4 vdd sky130_fd_pr__pfet_01v8 L=0.15 W=2 nf=1 ad=0.58 as=0.58 pd=4.58 ps=4.58 nrd=0.145 nrs=0.145 sa=0 sb=0 sd=0 mult=1 m=1
XMNF_sm150_4 vn_sm150_4 en 0 0 sky130_fd_pr__nfet_01v8 L=0.15 W=2 nf=1 ad=0.58 as=0.58 pd=4.58 ps=4.58 nrd=0.145 nrs=0.145 sa=0 sb=0 sd=0 mult=1 m=1
XMPH_sm150_4 vp_sm150_4 enb vdd vdd sky130_fd_pr__pfet_01v8 L=0.15 W=4 nf=1 ad=1.16 as=1.16 pd=8.58 ps=8.58 nrd=0.0725 nrs=0.0725 sa=0 sb=0 sd=0 mult=1 m=1
bd_sm150_4 d_sm150_4 0 v=v(rbl_sm150_4)-v(ref_sm150_4)
bdabs_sm150_4 dabs_sm150_4 0 v=abs(v(rbl_sm150_4)-v(ref_sm150_4))

* ---- sm150_5: d = -150 mV, replica 5 ----
spa_sm150_5 pa_m150 rbl_sm150_5 ctl 0 swpre
crbl_sm150_5 rbl_sm150_5 0 {C_RBL}
spr_sm150_5 pref_100 ref_sm150_5 ctl 0 swpre
cref_sm150_5 ref_sm150_5 0 {C_RBL}   $ ASSUMPTION: ideal matched dummy load
XMN1_sm150_5 rbl_sm150_5 ref_sm150_5 vn_sm150_5 0 sky130_fd_pr__nfet_01v8 L=0.15 W=1 nf=1 ad=0.29 as=0.29 pd=2.58 ps=2.58 nrd=0.29 nrs=0.29 sa=0 sb=0 sd=0 mult=1 m=1
XMN2_sm150_5 ref_sm150_5 rbl_sm150_5 vn_sm150_5 0 sky130_fd_pr__nfet_01v8 L=0.15 W=1 nf=1 ad=0.29 as=0.29 pd=2.58 ps=2.58 nrd=0.29 nrs=0.29 sa=0 sb=0 sd=0 mult=1 m=1
XMP1_sm150_5 rbl_sm150_5 ref_sm150_5 vp_sm150_5 vdd sky130_fd_pr__pfet_01v8 L=0.15 W=2 nf=1 ad=0.58 as=0.58 pd=4.58 ps=4.58 nrd=0.145 nrs=0.145 sa=0 sb=0 sd=0 mult=1 m=1
XMP2_sm150_5 ref_sm150_5 rbl_sm150_5 vp_sm150_5 vdd sky130_fd_pr__pfet_01v8 L=0.15 W=2 nf=1 ad=0.58 as=0.58 pd=4.58 ps=4.58 nrd=0.145 nrs=0.145 sa=0 sb=0 sd=0 mult=1 m=1
XMNF_sm150_5 vn_sm150_5 en 0 0 sky130_fd_pr__nfet_01v8 L=0.15 W=2 nf=1 ad=0.58 as=0.58 pd=4.58 ps=4.58 nrd=0.145 nrs=0.145 sa=0 sb=0 sd=0 mult=1 m=1
XMPH_sm150_5 vp_sm150_5 enb vdd vdd sky130_fd_pr__pfet_01v8 L=0.15 W=4 nf=1 ad=1.16 as=1.16 pd=8.58 ps=8.58 nrd=0.0725 nrs=0.0725 sa=0 sb=0 sd=0 mult=1 m=1
bd_sm150_5 d_sm150_5 0 v=v(rbl_sm150_5)-v(ref_sm150_5)
bdabs_sm150_5 dabs_sm150_5 0 v=abs(v(rbl_sm150_5)-v(ref_sm150_5))

* initial conditions (tran uic): precharged rails, stored levels, tail nodes
.ic v(rbl_sz000_0)=0.800000 v(ref_sz000_0)=0.930000 v(vn_sz000_0)=0.45 v(vp_sz000_0)=1.35 v(rbl_sz000_1)=0.800000 v(ref_sz000_1)=0.930000
.ic v(vn_sz000_1)=0.45 v(vp_sz000_1)=1.35 v(rbl_sz000_2)=0.800000 v(ref_sz000_2)=0.930000 v(vn_sz000_2)=0.45 v(vp_sz000_2)=1.35
.ic v(rbl_sz000_3)=0.800000 v(ref_sz000_3)=0.930000 v(vn_sz000_3)=0.45 v(vp_sz000_3)=1.35 v(rbl_sz000_4)=0.800000 v(ref_sz000_4)=0.930000
.ic v(vn_sz000_4)=0.45 v(vp_sz000_4)=1.35 v(rbl_sz000_5)=0.800000 v(ref_sz000_5)=0.930000 v(vn_sz000_5)=0.45 v(vp_sz000_5)=1.35
.ic v(rbl_sp002_0)=0.802000 v(ref_sp002_0)=0.930000 v(vn_sp002_0)=0.45 v(vp_sp002_0)=1.35 v(rbl_sp002_1)=0.802000 v(ref_sp002_1)=0.930000
.ic v(vn_sp002_1)=0.45 v(vp_sp002_1)=1.35 v(rbl_sp002_2)=0.802000 v(ref_sp002_2)=0.930000 v(vn_sp002_2)=0.45 v(vp_sp002_2)=1.35
.ic v(rbl_sp002_3)=0.802000 v(ref_sp002_3)=0.930000 v(vn_sp002_3)=0.45 v(vp_sp002_3)=1.35 v(rbl_sp002_4)=0.802000 v(ref_sp002_4)=0.930000
.ic v(vn_sp002_4)=0.45 v(vp_sp002_4)=1.35 v(rbl_sp002_5)=0.802000 v(ref_sp002_5)=0.930000 v(vn_sp002_5)=0.45 v(vp_sp002_5)=1.35
.ic v(rbl_sm002_0)=0.798000 v(ref_sm002_0)=0.930000 v(vn_sm002_0)=0.45 v(vp_sm002_0)=1.35 v(rbl_sm002_1)=0.798000 v(ref_sm002_1)=0.930000
.ic v(vn_sm002_1)=0.45 v(vp_sm002_1)=1.35 v(rbl_sm002_2)=0.798000 v(ref_sm002_2)=0.930000 v(vn_sm002_2)=0.45 v(vp_sm002_2)=1.35
.ic v(rbl_sm002_3)=0.798000 v(ref_sm002_3)=0.930000 v(vn_sm002_3)=0.45 v(vp_sm002_3)=1.35 v(rbl_sm002_4)=0.798000 v(ref_sm002_4)=0.930000
.ic v(vn_sm002_4)=0.45 v(vp_sm002_4)=1.35 v(rbl_sm002_5)=0.798000 v(ref_sm002_5)=0.930000 v(vn_sm002_5)=0.45 v(vp_sm002_5)=1.35
.ic v(rbl_sp005_0)=0.805000 v(ref_sp005_0)=0.930000 v(vn_sp005_0)=0.45 v(vp_sp005_0)=1.35 v(rbl_sp005_1)=0.805000 v(ref_sp005_1)=0.930000
.ic v(vn_sp005_1)=0.45 v(vp_sp005_1)=1.35 v(rbl_sp005_2)=0.805000 v(ref_sp005_2)=0.930000 v(vn_sp005_2)=0.45 v(vp_sp005_2)=1.35
.ic v(rbl_sp005_3)=0.805000 v(ref_sp005_3)=0.930000 v(vn_sp005_3)=0.45 v(vp_sp005_3)=1.35 v(rbl_sp005_4)=0.805000 v(ref_sp005_4)=0.930000
.ic v(vn_sp005_4)=0.45 v(vp_sp005_4)=1.35 v(rbl_sp005_5)=0.805000 v(ref_sp005_5)=0.930000 v(vn_sp005_5)=0.45 v(vp_sp005_5)=1.35
.ic v(rbl_sm005_0)=0.795000 v(ref_sm005_0)=0.930000 v(vn_sm005_0)=0.45 v(vp_sm005_0)=1.35 v(rbl_sm005_1)=0.795000 v(ref_sm005_1)=0.930000
.ic v(vn_sm005_1)=0.45 v(vp_sm005_1)=1.35 v(rbl_sm005_2)=0.795000 v(ref_sm005_2)=0.930000 v(vn_sm005_2)=0.45 v(vp_sm005_2)=1.35
.ic v(rbl_sm005_3)=0.795000 v(ref_sm005_3)=0.930000 v(vn_sm005_3)=0.45 v(vp_sm005_3)=1.35 v(rbl_sm005_4)=0.795000 v(ref_sm005_4)=0.930000
.ic v(vn_sm005_4)=0.45 v(vp_sm005_4)=1.35 v(rbl_sm005_5)=0.795000 v(ref_sm005_5)=0.930000 v(vn_sm005_5)=0.45 v(vp_sm005_5)=1.35
.ic v(rbl_sp010_0)=0.810000 v(ref_sp010_0)=0.930000 v(vn_sp010_0)=0.45 v(vp_sp010_0)=1.35 v(rbl_sp010_1)=0.810000 v(ref_sp010_1)=0.930000
.ic v(vn_sp010_1)=0.45 v(vp_sp010_1)=1.35 v(rbl_sp010_2)=0.810000 v(ref_sp010_2)=0.930000 v(vn_sp010_2)=0.45 v(vp_sp010_2)=1.35
.ic v(rbl_sp010_3)=0.810000 v(ref_sp010_3)=0.930000 v(vn_sp010_3)=0.45 v(vp_sp010_3)=1.35 v(rbl_sp010_4)=0.810000 v(ref_sp010_4)=0.930000
.ic v(vn_sp010_4)=0.45 v(vp_sp010_4)=1.35 v(rbl_sp010_5)=0.810000 v(ref_sp010_5)=0.930000 v(vn_sp010_5)=0.45 v(vp_sp010_5)=1.35
.ic v(rbl_sm010_0)=0.790000 v(ref_sm010_0)=0.930000 v(vn_sm010_0)=0.45 v(vp_sm010_0)=1.35 v(rbl_sm010_1)=0.790000 v(ref_sm010_1)=0.930000
.ic v(vn_sm010_1)=0.45 v(vp_sm010_1)=1.35 v(rbl_sm010_2)=0.790000 v(ref_sm010_2)=0.930000 v(vn_sm010_2)=0.45 v(vp_sm010_2)=1.35
.ic v(rbl_sm010_3)=0.790000 v(ref_sm010_3)=0.930000 v(vn_sm010_3)=0.45 v(vp_sm010_3)=1.35 v(rbl_sm010_4)=0.790000 v(ref_sm010_4)=0.930000
.ic v(vn_sm010_4)=0.45 v(vp_sm010_4)=1.35 v(rbl_sm010_5)=0.790000 v(ref_sm010_5)=0.930000 v(vn_sm010_5)=0.45 v(vp_sm010_5)=1.35
.ic v(rbl_sp015_0)=0.815000 v(ref_sp015_0)=0.930000 v(vn_sp015_0)=0.45 v(vp_sp015_0)=1.35 v(rbl_sp015_1)=0.815000 v(ref_sp015_1)=0.930000
.ic v(vn_sp015_1)=0.45 v(vp_sp015_1)=1.35 v(rbl_sp015_2)=0.815000 v(ref_sp015_2)=0.930000 v(vn_sp015_2)=0.45 v(vp_sp015_2)=1.35
.ic v(rbl_sp015_3)=0.815000 v(ref_sp015_3)=0.930000 v(vn_sp015_3)=0.45 v(vp_sp015_3)=1.35 v(rbl_sp015_4)=0.815000 v(ref_sp015_4)=0.930000
.ic v(vn_sp015_4)=0.45 v(vp_sp015_4)=1.35 v(rbl_sp015_5)=0.815000 v(ref_sp015_5)=0.930000 v(vn_sp015_5)=0.45 v(vp_sp015_5)=1.35
.ic v(rbl_sm015_0)=0.785000 v(ref_sm015_0)=0.930000 v(vn_sm015_0)=0.45 v(vp_sm015_0)=1.35 v(rbl_sm015_1)=0.785000 v(ref_sm015_1)=0.930000
.ic v(vn_sm015_1)=0.45 v(vp_sm015_1)=1.35 v(rbl_sm015_2)=0.785000 v(ref_sm015_2)=0.930000 v(vn_sm015_2)=0.45 v(vp_sm015_2)=1.35
.ic v(rbl_sm015_3)=0.785000 v(ref_sm015_3)=0.930000 v(vn_sm015_3)=0.45 v(vp_sm015_3)=1.35 v(rbl_sm015_4)=0.785000 v(ref_sm015_4)=0.930000
.ic v(vn_sm015_4)=0.45 v(vp_sm015_4)=1.35 v(rbl_sm015_5)=0.785000 v(ref_sm015_5)=0.930000 v(vn_sm015_5)=0.45 v(vp_sm015_5)=1.35
.ic v(rbl_sp020_0)=0.820000 v(ref_sp020_0)=0.930000 v(vn_sp020_0)=0.45 v(vp_sp020_0)=1.35 v(rbl_sp020_1)=0.820000 v(ref_sp020_1)=0.930000
.ic v(vn_sp020_1)=0.45 v(vp_sp020_1)=1.35 v(rbl_sp020_2)=0.820000 v(ref_sp020_2)=0.930000 v(vn_sp020_2)=0.45 v(vp_sp020_2)=1.35
.ic v(rbl_sp020_3)=0.820000 v(ref_sp020_3)=0.930000 v(vn_sp020_3)=0.45 v(vp_sp020_3)=1.35 v(rbl_sp020_4)=0.820000 v(ref_sp020_4)=0.930000
.ic v(vn_sp020_4)=0.45 v(vp_sp020_4)=1.35 v(rbl_sp020_5)=0.820000 v(ref_sp020_5)=0.930000 v(vn_sp020_5)=0.45 v(vp_sp020_5)=1.35
.ic v(rbl_sm020_0)=0.780000 v(ref_sm020_0)=0.930000 v(vn_sm020_0)=0.45 v(vp_sm020_0)=1.35 v(rbl_sm020_1)=0.780000 v(ref_sm020_1)=0.930000
.ic v(vn_sm020_1)=0.45 v(vp_sm020_1)=1.35 v(rbl_sm020_2)=0.780000 v(ref_sm020_2)=0.930000 v(vn_sm020_2)=0.45 v(vp_sm020_2)=1.35
.ic v(rbl_sm020_3)=0.780000 v(ref_sm020_3)=0.930000 v(vn_sm020_3)=0.45 v(vp_sm020_3)=1.35 v(rbl_sm020_4)=0.780000 v(ref_sm020_4)=0.930000
.ic v(vn_sm020_4)=0.45 v(vp_sm020_4)=1.35 v(rbl_sm020_5)=0.780000 v(ref_sm020_5)=0.930000 v(vn_sm020_5)=0.45 v(vp_sm020_5)=1.35
.ic v(rbl_sp030_0)=0.830000 v(ref_sp030_0)=0.930000 v(vn_sp030_0)=0.45 v(vp_sp030_0)=1.35 v(rbl_sp030_1)=0.830000 v(ref_sp030_1)=0.930000
.ic v(vn_sp030_1)=0.45 v(vp_sp030_1)=1.35 v(rbl_sp030_2)=0.830000 v(ref_sp030_2)=0.930000 v(vn_sp030_2)=0.45 v(vp_sp030_2)=1.35
.ic v(rbl_sp030_3)=0.830000 v(ref_sp030_3)=0.930000 v(vn_sp030_3)=0.45 v(vp_sp030_3)=1.35 v(rbl_sp030_4)=0.830000 v(ref_sp030_4)=0.930000
.ic v(vn_sp030_4)=0.45 v(vp_sp030_4)=1.35 v(rbl_sp030_5)=0.830000 v(ref_sp030_5)=0.930000 v(vn_sp030_5)=0.45 v(vp_sp030_5)=1.35
.ic v(rbl_sm030_0)=0.770000 v(ref_sm030_0)=0.930000 v(vn_sm030_0)=0.45 v(vp_sm030_0)=1.35 v(rbl_sm030_1)=0.770000 v(ref_sm030_1)=0.930000
.ic v(vn_sm030_1)=0.45 v(vp_sm030_1)=1.35 v(rbl_sm030_2)=0.770000 v(ref_sm030_2)=0.930000 v(vn_sm030_2)=0.45 v(vp_sm030_2)=1.35
.ic v(rbl_sm030_3)=0.770000 v(ref_sm030_3)=0.930000 v(vn_sm030_3)=0.45 v(vp_sm030_3)=1.35 v(rbl_sm030_4)=0.770000 v(ref_sm030_4)=0.930000
.ic v(vn_sm030_4)=0.45 v(vp_sm030_4)=1.35 v(rbl_sm030_5)=0.770000 v(ref_sm030_5)=0.930000 v(vn_sm030_5)=0.45 v(vp_sm030_5)=1.35
.ic v(rbl_sp040_0)=0.840000 v(ref_sp040_0)=0.930000 v(vn_sp040_0)=0.45 v(vp_sp040_0)=1.35 v(rbl_sp040_1)=0.840000 v(ref_sp040_1)=0.930000
.ic v(vn_sp040_1)=0.45 v(vp_sp040_1)=1.35 v(rbl_sp040_2)=0.840000 v(ref_sp040_2)=0.930000 v(vn_sp040_2)=0.45 v(vp_sp040_2)=1.35
.ic v(rbl_sp040_3)=0.840000 v(ref_sp040_3)=0.930000 v(vn_sp040_3)=0.45 v(vp_sp040_3)=1.35 v(rbl_sp040_4)=0.840000 v(ref_sp040_4)=0.930000
.ic v(vn_sp040_4)=0.45 v(vp_sp040_4)=1.35 v(rbl_sp040_5)=0.840000 v(ref_sp040_5)=0.930000 v(vn_sp040_5)=0.45 v(vp_sp040_5)=1.35
.ic v(rbl_sm040_0)=0.760000 v(ref_sm040_0)=0.930000 v(vn_sm040_0)=0.45 v(vp_sm040_0)=1.35 v(rbl_sm040_1)=0.760000 v(ref_sm040_1)=0.930000
.ic v(vn_sm040_1)=0.45 v(vp_sm040_1)=1.35 v(rbl_sm040_2)=0.760000 v(ref_sm040_2)=0.930000 v(vn_sm040_2)=0.45 v(vp_sm040_2)=1.35
.ic v(rbl_sm040_3)=0.760000 v(ref_sm040_3)=0.930000 v(vn_sm040_3)=0.45 v(vp_sm040_3)=1.35 v(rbl_sm040_4)=0.760000 v(ref_sm040_4)=0.930000
.ic v(vn_sm040_4)=0.45 v(vp_sm040_4)=1.35 v(rbl_sm040_5)=0.760000 v(ref_sm040_5)=0.930000 v(vn_sm040_5)=0.45 v(vp_sm040_5)=1.35
.ic v(rbl_sp050_0)=0.850000 v(ref_sp050_0)=0.930000 v(vn_sp050_0)=0.45 v(vp_sp050_0)=1.35 v(rbl_sp050_1)=0.850000 v(ref_sp050_1)=0.930000
.ic v(vn_sp050_1)=0.45 v(vp_sp050_1)=1.35 v(rbl_sp050_2)=0.850000 v(ref_sp050_2)=0.930000 v(vn_sp050_2)=0.45 v(vp_sp050_2)=1.35
.ic v(rbl_sp050_3)=0.850000 v(ref_sp050_3)=0.930000 v(vn_sp050_3)=0.45 v(vp_sp050_3)=1.35 v(rbl_sp050_4)=0.850000 v(ref_sp050_4)=0.930000
.ic v(vn_sp050_4)=0.45 v(vp_sp050_4)=1.35 v(rbl_sp050_5)=0.850000 v(ref_sp050_5)=0.930000 v(vn_sp050_5)=0.45 v(vp_sp050_5)=1.35
.ic v(rbl_sm050_0)=0.750000 v(ref_sm050_0)=0.930000 v(vn_sm050_0)=0.45 v(vp_sm050_0)=1.35 v(rbl_sm050_1)=0.750000 v(ref_sm050_1)=0.930000
.ic v(vn_sm050_1)=0.45 v(vp_sm050_1)=1.35 v(rbl_sm050_2)=0.750000 v(ref_sm050_2)=0.930000 v(vn_sm050_2)=0.45 v(vp_sm050_2)=1.35
.ic v(rbl_sm050_3)=0.750000 v(ref_sm050_3)=0.930000 v(vn_sm050_3)=0.45 v(vp_sm050_3)=1.35 v(rbl_sm050_4)=0.750000 v(ref_sm050_4)=0.930000
.ic v(vn_sm050_4)=0.45 v(vp_sm050_4)=1.35 v(rbl_sm050_5)=0.750000 v(ref_sm050_5)=0.930000 v(vn_sm050_5)=0.45 v(vp_sm050_5)=1.35
.ic v(rbl_sp060_0)=0.860000 v(ref_sp060_0)=0.930000 v(vn_sp060_0)=0.45 v(vp_sp060_0)=1.35 v(rbl_sp060_1)=0.860000 v(ref_sp060_1)=0.930000
.ic v(vn_sp060_1)=0.45 v(vp_sp060_1)=1.35 v(rbl_sp060_2)=0.860000 v(ref_sp060_2)=0.930000 v(vn_sp060_2)=0.45 v(vp_sp060_2)=1.35
.ic v(rbl_sp060_3)=0.860000 v(ref_sp060_3)=0.930000 v(vn_sp060_3)=0.45 v(vp_sp060_3)=1.35 v(rbl_sp060_4)=0.860000 v(ref_sp060_4)=0.930000
.ic v(vn_sp060_4)=0.45 v(vp_sp060_4)=1.35 v(rbl_sp060_5)=0.860000 v(ref_sp060_5)=0.930000 v(vn_sp060_5)=0.45 v(vp_sp060_5)=1.35
.ic v(rbl_sm060_0)=0.740000 v(ref_sm060_0)=0.930000 v(vn_sm060_0)=0.45 v(vp_sm060_0)=1.35 v(rbl_sm060_1)=0.740000 v(ref_sm060_1)=0.930000
.ic v(vn_sm060_1)=0.45 v(vp_sm060_1)=1.35 v(rbl_sm060_2)=0.740000 v(ref_sm060_2)=0.930000 v(vn_sm060_2)=0.45 v(vp_sm060_2)=1.35
.ic v(rbl_sm060_3)=0.740000 v(ref_sm060_3)=0.930000 v(vn_sm060_3)=0.45 v(vp_sm060_3)=1.35 v(rbl_sm060_4)=0.740000 v(ref_sm060_4)=0.930000
.ic v(vn_sm060_4)=0.45 v(vp_sm060_4)=1.35 v(rbl_sm060_5)=0.740000 v(ref_sm060_5)=0.930000 v(vn_sm060_5)=0.45 v(vp_sm060_5)=1.35
.ic v(rbl_sp080_0)=0.880000 v(ref_sp080_0)=0.930000 v(vn_sp080_0)=0.45 v(vp_sp080_0)=1.35 v(rbl_sp080_1)=0.880000 v(ref_sp080_1)=0.930000
.ic v(vn_sp080_1)=0.45 v(vp_sp080_1)=1.35 v(rbl_sp080_2)=0.880000 v(ref_sp080_2)=0.930000 v(vn_sp080_2)=0.45 v(vp_sp080_2)=1.35
.ic v(rbl_sp080_3)=0.880000 v(ref_sp080_3)=0.930000 v(vn_sp080_3)=0.45 v(vp_sp080_3)=1.35 v(rbl_sp080_4)=0.880000 v(ref_sp080_4)=0.930000
.ic v(vn_sp080_4)=0.45 v(vp_sp080_4)=1.35 v(rbl_sp080_5)=0.880000 v(ref_sp080_5)=0.930000 v(vn_sp080_5)=0.45 v(vp_sp080_5)=1.35
.ic v(rbl_sm080_0)=0.720000 v(ref_sm080_0)=0.930000 v(vn_sm080_0)=0.45 v(vp_sm080_0)=1.35 v(rbl_sm080_1)=0.720000 v(ref_sm080_1)=0.930000
.ic v(vn_sm080_1)=0.45 v(vp_sm080_1)=1.35 v(rbl_sm080_2)=0.720000 v(ref_sm080_2)=0.930000 v(vn_sm080_2)=0.45 v(vp_sm080_2)=1.35
.ic v(rbl_sm080_3)=0.720000 v(ref_sm080_3)=0.930000 v(vn_sm080_3)=0.45 v(vp_sm080_3)=1.35 v(rbl_sm080_4)=0.720000 v(ref_sm080_4)=0.930000
.ic v(vn_sm080_4)=0.45 v(vp_sm080_4)=1.35 v(rbl_sm080_5)=0.720000 v(ref_sm080_5)=0.930000 v(vn_sm080_5)=0.45 v(vp_sm080_5)=1.35
.ic v(rbl_sp100_0)=0.900000 v(ref_sp100_0)=0.930000 v(vn_sp100_0)=0.45 v(vp_sp100_0)=1.35 v(rbl_sp100_1)=0.900000 v(ref_sp100_1)=0.930000
.ic v(vn_sp100_1)=0.45 v(vp_sp100_1)=1.35 v(rbl_sp100_2)=0.900000 v(ref_sp100_2)=0.930000 v(vn_sp100_2)=0.45 v(vp_sp100_2)=1.35
.ic v(rbl_sp100_3)=0.900000 v(ref_sp100_3)=0.930000 v(vn_sp100_3)=0.45 v(vp_sp100_3)=1.35 v(rbl_sp100_4)=0.900000 v(ref_sp100_4)=0.930000
.ic v(vn_sp100_4)=0.45 v(vp_sp100_4)=1.35 v(rbl_sp100_5)=0.900000 v(ref_sp100_5)=0.930000 v(vn_sp100_5)=0.45 v(vp_sp100_5)=1.35
.ic v(rbl_sm100_0)=0.700000 v(ref_sm100_0)=0.930000 v(vn_sm100_0)=0.45 v(vp_sm100_0)=1.35 v(rbl_sm100_1)=0.700000 v(ref_sm100_1)=0.930000
.ic v(vn_sm100_1)=0.45 v(vp_sm100_1)=1.35 v(rbl_sm100_2)=0.700000 v(ref_sm100_2)=0.930000 v(vn_sm100_2)=0.45 v(vp_sm100_2)=1.35
.ic v(rbl_sm100_3)=0.700000 v(ref_sm100_3)=0.930000 v(vn_sm100_3)=0.45 v(vp_sm100_3)=1.35 v(rbl_sm100_4)=0.700000 v(ref_sm100_4)=0.930000
.ic v(vn_sm100_4)=0.45 v(vp_sm100_4)=1.35 v(rbl_sm100_5)=0.700000 v(ref_sm100_5)=0.930000 v(vn_sm100_5)=0.45 v(vp_sm100_5)=1.35
.ic v(rbl_sp150_0)=0.950000 v(ref_sp150_0)=0.930000 v(vn_sp150_0)=0.45 v(vp_sp150_0)=1.35 v(rbl_sp150_1)=0.950000 v(ref_sp150_1)=0.930000
.ic v(vn_sp150_1)=0.45 v(vp_sp150_1)=1.35 v(rbl_sp150_2)=0.950000 v(ref_sp150_2)=0.930000 v(vn_sp150_2)=0.45 v(vp_sp150_2)=1.35
.ic v(rbl_sp150_3)=0.950000 v(ref_sp150_3)=0.930000 v(vn_sp150_3)=0.45 v(vp_sp150_3)=1.35 v(rbl_sp150_4)=0.950000 v(ref_sp150_4)=0.930000
.ic v(vn_sp150_4)=0.45 v(vp_sp150_4)=1.35 v(rbl_sp150_5)=0.950000 v(ref_sp150_5)=0.930000 v(vn_sp150_5)=0.45 v(vp_sp150_5)=1.35
.ic v(rbl_sm150_0)=0.650000 v(ref_sm150_0)=0.930000 v(vn_sm150_0)=0.45 v(vp_sm150_0)=1.35 v(rbl_sm150_1)=0.650000 v(ref_sm150_1)=0.930000
.ic v(vn_sm150_1)=0.45 v(vp_sm150_1)=1.35 v(rbl_sm150_2)=0.650000 v(ref_sm150_2)=0.930000 v(vn_sm150_2)=0.45 v(vp_sm150_2)=1.35
.ic v(rbl_sm150_3)=0.650000 v(ref_sm150_3)=0.930000 v(vn_sm150_3)=0.45 v(vp_sm150_3)=1.35 v(rbl_sm150_4)=0.650000 v(ref_sm150_4)=0.930000
.ic v(vn_sm150_4)=0.45 v(vp_sm150_4)=1.35 v(rbl_sm150_5)=0.650000 v(ref_sm150_5)=0.930000 v(vn_sm150_5)=0.45 v(vp_sm150_5)=1.35
