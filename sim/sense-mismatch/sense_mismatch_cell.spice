* sense_mismatch_cell.spice -- end-to-end (4-row column + latch) Monte Carlo at fs/27 C
* GENERATED by sim/sense-mismatch/gen_sense_mismatch.py (issue #81); do not edit by hand.
*
* PROPOSED/UNRATIFIED SCOPE: corners/temperatures from spec/operating-range-decision-PROPOSED.md.
* CIRCUIT BODY for `klt sim`: no .control/.end; klt appends the .lib (a *_mm mismatch section,
* MC_MM_SWITCH=1), .temp and the per-sample `.options seed` cards.
* Latch/footer/header devices, sizes, timing and bias are those of sim/sense-stage/gen_sense_stage.py.
* Every sky130 FET instance gets its own AGAUSS Vth-mismatch draw (the PDK switch is global per
* section: footer/header/cell devices also carry mismatch, see README).
* Instance kinds: c1_* stored '1', c0_* stored '0'; r<mV> = reference offset; last field = replica
*
* ASSUMPTIONS (labelled; none is a spec value): C_RBL, VRBL, reference level, sense instant,
* latch/footer/header sizes, ideal precharge switch, ideal drivers, ideal matched dummy load.

.param VDD     = 1.8
.param VRBL    = 0.9   $ ASSUMPTION (contract)
.param TEDGE   = 1e-10
.param T_READ  = 1e-08   $ select edge
.param T_PGAP  = 2e-09   $ precharge released this long before T_READ
.param T_EN    = 2e-08   $ ASSUMPTION: latch enable = contract sense instant (T_READ+10n)
.param C_RBL   = 1e-14   $ ASSUMPTION (contract; not extracted)

* ---- shared drivers (ideal) ----
vdd   vdd 0 dc {VDD}
vctl  ctl 0 pwl(0 {VDD} {T_READ-T_PGAP} {VDD} {T_READ-T_PGAP+TEDGE} 0)
ven   en  0 pwl(0 0 {T_EN} 0 {T_EN+TEDGE} {VDD})
venb  enb 0 pwl(0 {VDD} {T_EN} {VDD} {T_EN+TEDGE} 0)
.model swpre sw(vt=0.9 vh=0.1 ron=100 roff=1e12)
.param C_SN    = 6.72741e-16   $ extracted-from-netlist (layout/gain_cell_2t.extract.parasitics.json)
vrwls rwl_sel 0 pwl(0 {VDD} {T_READ} {VDD} {T_READ+TEDGE} 0)
vrwld rwl_des 0 dc {VDD}
vpre  prea 0 dc {VRBL}
vref_050 pref_050 0 dc 0.85   $ reference = VRBL - 0.05 (ASSUMPTION)
vref_100 pref_100 0 dc 0.8   $ reference = VRBL - 0.1 (ASSUMPTION)

* ---- c0_r050_0000_0: cell0 SN = 0.0 V, ref offset 0.05 V, replica 0 ----
spa_c0_r050_0000_0 prea rbl_c0_r050_0000_0 ctl 0 swpre
XMWR_c0_r050_0000_0_0 sn_c0_r050_0000_0_0 0 0 0 sky130_fd_pr__nfet_01v8 L=0.15 W=0.42 nf=1 ad=0.1218 as=0.1218 pd=1.42 ps=1.42 nrd=0.69047619047619  nrs=0.69047619047619 sa=0 sb=0 sd=0 mult=1 m=1
XMRD_c0_r050_0000_0_0 rbl_c0_r050_0000_0 sn_c0_r050_0000_0_0 rwl_sel 0 sky130_fd_pr__nfet_01v8 L=0.15 W=0.42 nf=1 ad=0.1218 as=0.1218 pd=1.42 ps=1.42 nrd=0.69047619047619  nrs=0.69047619047619 sa=0 sb=0 sd=0 mult=1 m=1
csn_c0_r050_0000_0_0 sn_c0_r050_0000_0_0 0 {C_SN}
XMWR_c0_r050_0000_0_1 sn_c0_r050_0000_0_1 0 0 0 sky130_fd_pr__nfet_01v8 L=0.15 W=0.42 nf=1 ad=0.1218 as=0.1218 pd=1.42 ps=1.42 nrd=0.69047619047619  nrs=0.69047619047619 sa=0 sb=0 sd=0 mult=1 m=1
XMRD_c0_r050_0000_0_1 rbl_c0_r050_0000_0 sn_c0_r050_0000_0_1 rwl_des 0 sky130_fd_pr__nfet_01v8 L=0.15 W=0.42 nf=1 ad=0.1218 as=0.1218 pd=1.42 ps=1.42 nrd=0.69047619047619  nrs=0.69047619047619 sa=0 sb=0 sd=0 mult=1 m=1
csn_c0_r050_0000_0_1 sn_c0_r050_0000_0_1 0 {C_SN}
XMWR_c0_r050_0000_0_2 sn_c0_r050_0000_0_2 0 0 0 sky130_fd_pr__nfet_01v8 L=0.15 W=0.42 nf=1 ad=0.1218 as=0.1218 pd=1.42 ps=1.42 nrd=0.69047619047619  nrs=0.69047619047619 sa=0 sb=0 sd=0 mult=1 m=1
XMRD_c0_r050_0000_0_2 rbl_c0_r050_0000_0 sn_c0_r050_0000_0_2 rwl_des 0 sky130_fd_pr__nfet_01v8 L=0.15 W=0.42 nf=1 ad=0.1218 as=0.1218 pd=1.42 ps=1.42 nrd=0.69047619047619  nrs=0.69047619047619 sa=0 sb=0 sd=0 mult=1 m=1
csn_c0_r050_0000_0_2 sn_c0_r050_0000_0_2 0 {C_SN}
XMWR_c0_r050_0000_0_3 sn_c0_r050_0000_0_3 0 0 0 sky130_fd_pr__nfet_01v8 L=0.15 W=0.42 nf=1 ad=0.1218 as=0.1218 pd=1.42 ps=1.42 nrd=0.69047619047619  nrs=0.69047619047619 sa=0 sb=0 sd=0 mult=1 m=1
XMRD_c0_r050_0000_0_3 rbl_c0_r050_0000_0 sn_c0_r050_0000_0_3 rwl_des 0 sky130_fd_pr__nfet_01v8 L=0.15 W=0.42 nf=1 ad=0.1218 as=0.1218 pd=1.42 ps=1.42 nrd=0.69047619047619  nrs=0.69047619047619 sa=0 sb=0 sd=0 mult=1 m=1
csn_c0_r050_0000_0_3 sn_c0_r050_0000_0_3 0 {C_SN}
crbl_c0_r050_0000_0 rbl_c0_r050_0000_0 0 {C_RBL}
spr_c0_r050_0000_0 pref_050 ref_c0_r050_0000_0 ctl 0 swpre
cref_c0_r050_0000_0 ref_c0_r050_0000_0 0 {C_RBL}   $ ASSUMPTION: ideal matched dummy load
XMN1_c0_r050_0000_0 rbl_c0_r050_0000_0 ref_c0_r050_0000_0 vn_c0_r050_0000_0 0 sky130_fd_pr__nfet_01v8 L=0.15 W=1 nf=1 ad=0.29 as=0.29 pd=2.58 ps=2.58 nrd=0.29 nrs=0.29 sa=0 sb=0 sd=0 mult=1 m=1
XMN2_c0_r050_0000_0 ref_c0_r050_0000_0 rbl_c0_r050_0000_0 vn_c0_r050_0000_0 0 sky130_fd_pr__nfet_01v8 L=0.15 W=1 nf=1 ad=0.29 as=0.29 pd=2.58 ps=2.58 nrd=0.29 nrs=0.29 sa=0 sb=0 sd=0 mult=1 m=1
XMP1_c0_r050_0000_0 rbl_c0_r050_0000_0 ref_c0_r050_0000_0 vp_c0_r050_0000_0 vdd sky130_fd_pr__pfet_01v8 L=0.15 W=2 nf=1 ad=0.58 as=0.58 pd=4.58 ps=4.58 nrd=0.145 nrs=0.145 sa=0 sb=0 sd=0 mult=1 m=1
XMP2_c0_r050_0000_0 ref_c0_r050_0000_0 rbl_c0_r050_0000_0 vp_c0_r050_0000_0 vdd sky130_fd_pr__pfet_01v8 L=0.15 W=2 nf=1 ad=0.58 as=0.58 pd=4.58 ps=4.58 nrd=0.145 nrs=0.145 sa=0 sb=0 sd=0 mult=1 m=1
XMNF_c0_r050_0000_0 vn_c0_r050_0000_0 en 0 0 sky130_fd_pr__nfet_01v8 L=0.15 W=2 nf=1 ad=0.58 as=0.58 pd=4.58 ps=4.58 nrd=0.145 nrs=0.145 sa=0 sb=0 sd=0 mult=1 m=1
XMPH_c0_r050_0000_0 vp_c0_r050_0000_0 enb vdd vdd sky130_fd_pr__pfet_01v8 L=0.15 W=4 nf=1 ad=1.16 as=1.16 pd=8.58 ps=8.58 nrd=0.0725 nrs=0.0725 sa=0 sb=0 sd=0 mult=1 m=1
bd_c0_r050_0000_0 d_c0_r050_0000_0 0 v=v(rbl_c0_r050_0000_0)-v(ref_c0_r050_0000_0)
bdabs_c0_r050_0000_0 dabs_c0_r050_0000_0 0 v=abs(v(rbl_c0_r050_0000_0)-v(ref_c0_r050_0000_0))

* ---- c0_r050_0000_1: cell0 SN = 0.0 V, ref offset 0.05 V, replica 1 ----
spa_c0_r050_0000_1 prea rbl_c0_r050_0000_1 ctl 0 swpre
XMWR_c0_r050_0000_1_0 sn_c0_r050_0000_1_0 0 0 0 sky130_fd_pr__nfet_01v8 L=0.15 W=0.42 nf=1 ad=0.1218 as=0.1218 pd=1.42 ps=1.42 nrd=0.69047619047619  nrs=0.69047619047619 sa=0 sb=0 sd=0 mult=1 m=1
XMRD_c0_r050_0000_1_0 rbl_c0_r050_0000_1 sn_c0_r050_0000_1_0 rwl_sel 0 sky130_fd_pr__nfet_01v8 L=0.15 W=0.42 nf=1 ad=0.1218 as=0.1218 pd=1.42 ps=1.42 nrd=0.69047619047619  nrs=0.69047619047619 sa=0 sb=0 sd=0 mult=1 m=1
csn_c0_r050_0000_1_0 sn_c0_r050_0000_1_0 0 {C_SN}
XMWR_c0_r050_0000_1_1 sn_c0_r050_0000_1_1 0 0 0 sky130_fd_pr__nfet_01v8 L=0.15 W=0.42 nf=1 ad=0.1218 as=0.1218 pd=1.42 ps=1.42 nrd=0.69047619047619  nrs=0.69047619047619 sa=0 sb=0 sd=0 mult=1 m=1
XMRD_c0_r050_0000_1_1 rbl_c0_r050_0000_1 sn_c0_r050_0000_1_1 rwl_des 0 sky130_fd_pr__nfet_01v8 L=0.15 W=0.42 nf=1 ad=0.1218 as=0.1218 pd=1.42 ps=1.42 nrd=0.69047619047619  nrs=0.69047619047619 sa=0 sb=0 sd=0 mult=1 m=1
csn_c0_r050_0000_1_1 sn_c0_r050_0000_1_1 0 {C_SN}
XMWR_c0_r050_0000_1_2 sn_c0_r050_0000_1_2 0 0 0 sky130_fd_pr__nfet_01v8 L=0.15 W=0.42 nf=1 ad=0.1218 as=0.1218 pd=1.42 ps=1.42 nrd=0.69047619047619  nrs=0.69047619047619 sa=0 sb=0 sd=0 mult=1 m=1
XMRD_c0_r050_0000_1_2 rbl_c0_r050_0000_1 sn_c0_r050_0000_1_2 rwl_des 0 sky130_fd_pr__nfet_01v8 L=0.15 W=0.42 nf=1 ad=0.1218 as=0.1218 pd=1.42 ps=1.42 nrd=0.69047619047619  nrs=0.69047619047619 sa=0 sb=0 sd=0 mult=1 m=1
csn_c0_r050_0000_1_2 sn_c0_r050_0000_1_2 0 {C_SN}
XMWR_c0_r050_0000_1_3 sn_c0_r050_0000_1_3 0 0 0 sky130_fd_pr__nfet_01v8 L=0.15 W=0.42 nf=1 ad=0.1218 as=0.1218 pd=1.42 ps=1.42 nrd=0.69047619047619  nrs=0.69047619047619 sa=0 sb=0 sd=0 mult=1 m=1
XMRD_c0_r050_0000_1_3 rbl_c0_r050_0000_1 sn_c0_r050_0000_1_3 rwl_des 0 sky130_fd_pr__nfet_01v8 L=0.15 W=0.42 nf=1 ad=0.1218 as=0.1218 pd=1.42 ps=1.42 nrd=0.69047619047619  nrs=0.69047619047619 sa=0 sb=0 sd=0 mult=1 m=1
csn_c0_r050_0000_1_3 sn_c0_r050_0000_1_3 0 {C_SN}
crbl_c0_r050_0000_1 rbl_c0_r050_0000_1 0 {C_RBL}
spr_c0_r050_0000_1 pref_050 ref_c0_r050_0000_1 ctl 0 swpre
cref_c0_r050_0000_1 ref_c0_r050_0000_1 0 {C_RBL}   $ ASSUMPTION: ideal matched dummy load
XMN1_c0_r050_0000_1 rbl_c0_r050_0000_1 ref_c0_r050_0000_1 vn_c0_r050_0000_1 0 sky130_fd_pr__nfet_01v8 L=0.15 W=1 nf=1 ad=0.29 as=0.29 pd=2.58 ps=2.58 nrd=0.29 nrs=0.29 sa=0 sb=0 sd=0 mult=1 m=1
XMN2_c0_r050_0000_1 ref_c0_r050_0000_1 rbl_c0_r050_0000_1 vn_c0_r050_0000_1 0 sky130_fd_pr__nfet_01v8 L=0.15 W=1 nf=1 ad=0.29 as=0.29 pd=2.58 ps=2.58 nrd=0.29 nrs=0.29 sa=0 sb=0 sd=0 mult=1 m=1
XMP1_c0_r050_0000_1 rbl_c0_r050_0000_1 ref_c0_r050_0000_1 vp_c0_r050_0000_1 vdd sky130_fd_pr__pfet_01v8 L=0.15 W=2 nf=1 ad=0.58 as=0.58 pd=4.58 ps=4.58 nrd=0.145 nrs=0.145 sa=0 sb=0 sd=0 mult=1 m=1
XMP2_c0_r050_0000_1 ref_c0_r050_0000_1 rbl_c0_r050_0000_1 vp_c0_r050_0000_1 vdd sky130_fd_pr__pfet_01v8 L=0.15 W=2 nf=1 ad=0.58 as=0.58 pd=4.58 ps=4.58 nrd=0.145 nrs=0.145 sa=0 sb=0 sd=0 mult=1 m=1
XMNF_c0_r050_0000_1 vn_c0_r050_0000_1 en 0 0 sky130_fd_pr__nfet_01v8 L=0.15 W=2 nf=1 ad=0.58 as=0.58 pd=4.58 ps=4.58 nrd=0.145 nrs=0.145 sa=0 sb=0 sd=0 mult=1 m=1
XMPH_c0_r050_0000_1 vp_c0_r050_0000_1 enb vdd vdd sky130_fd_pr__pfet_01v8 L=0.15 W=4 nf=1 ad=1.16 as=1.16 pd=8.58 ps=8.58 nrd=0.0725 nrs=0.0725 sa=0 sb=0 sd=0 mult=1 m=1
bd_c0_r050_0000_1 d_c0_r050_0000_1 0 v=v(rbl_c0_r050_0000_1)-v(ref_c0_r050_0000_1)
bdabs_c0_r050_0000_1 dabs_c0_r050_0000_1 0 v=abs(v(rbl_c0_r050_0000_1)-v(ref_c0_r050_0000_1))

* ---- c0_r050_0000_2: cell0 SN = 0.0 V, ref offset 0.05 V, replica 2 ----
spa_c0_r050_0000_2 prea rbl_c0_r050_0000_2 ctl 0 swpre
XMWR_c0_r050_0000_2_0 sn_c0_r050_0000_2_0 0 0 0 sky130_fd_pr__nfet_01v8 L=0.15 W=0.42 nf=1 ad=0.1218 as=0.1218 pd=1.42 ps=1.42 nrd=0.69047619047619  nrs=0.69047619047619 sa=0 sb=0 sd=0 mult=1 m=1
XMRD_c0_r050_0000_2_0 rbl_c0_r050_0000_2 sn_c0_r050_0000_2_0 rwl_sel 0 sky130_fd_pr__nfet_01v8 L=0.15 W=0.42 nf=1 ad=0.1218 as=0.1218 pd=1.42 ps=1.42 nrd=0.69047619047619  nrs=0.69047619047619 sa=0 sb=0 sd=0 mult=1 m=1
csn_c0_r050_0000_2_0 sn_c0_r050_0000_2_0 0 {C_SN}
XMWR_c0_r050_0000_2_1 sn_c0_r050_0000_2_1 0 0 0 sky130_fd_pr__nfet_01v8 L=0.15 W=0.42 nf=1 ad=0.1218 as=0.1218 pd=1.42 ps=1.42 nrd=0.69047619047619  nrs=0.69047619047619 sa=0 sb=0 sd=0 mult=1 m=1
XMRD_c0_r050_0000_2_1 rbl_c0_r050_0000_2 sn_c0_r050_0000_2_1 rwl_des 0 sky130_fd_pr__nfet_01v8 L=0.15 W=0.42 nf=1 ad=0.1218 as=0.1218 pd=1.42 ps=1.42 nrd=0.69047619047619  nrs=0.69047619047619 sa=0 sb=0 sd=0 mult=1 m=1
csn_c0_r050_0000_2_1 sn_c0_r050_0000_2_1 0 {C_SN}
XMWR_c0_r050_0000_2_2 sn_c0_r050_0000_2_2 0 0 0 sky130_fd_pr__nfet_01v8 L=0.15 W=0.42 nf=1 ad=0.1218 as=0.1218 pd=1.42 ps=1.42 nrd=0.69047619047619  nrs=0.69047619047619 sa=0 sb=0 sd=0 mult=1 m=1
XMRD_c0_r050_0000_2_2 rbl_c0_r050_0000_2 sn_c0_r050_0000_2_2 rwl_des 0 sky130_fd_pr__nfet_01v8 L=0.15 W=0.42 nf=1 ad=0.1218 as=0.1218 pd=1.42 ps=1.42 nrd=0.69047619047619  nrs=0.69047619047619 sa=0 sb=0 sd=0 mult=1 m=1
csn_c0_r050_0000_2_2 sn_c0_r050_0000_2_2 0 {C_SN}
XMWR_c0_r050_0000_2_3 sn_c0_r050_0000_2_3 0 0 0 sky130_fd_pr__nfet_01v8 L=0.15 W=0.42 nf=1 ad=0.1218 as=0.1218 pd=1.42 ps=1.42 nrd=0.69047619047619  nrs=0.69047619047619 sa=0 sb=0 sd=0 mult=1 m=1
XMRD_c0_r050_0000_2_3 rbl_c0_r050_0000_2 sn_c0_r050_0000_2_3 rwl_des 0 sky130_fd_pr__nfet_01v8 L=0.15 W=0.42 nf=1 ad=0.1218 as=0.1218 pd=1.42 ps=1.42 nrd=0.69047619047619  nrs=0.69047619047619 sa=0 sb=0 sd=0 mult=1 m=1
csn_c0_r050_0000_2_3 sn_c0_r050_0000_2_3 0 {C_SN}
crbl_c0_r050_0000_2 rbl_c0_r050_0000_2 0 {C_RBL}
spr_c0_r050_0000_2 pref_050 ref_c0_r050_0000_2 ctl 0 swpre
cref_c0_r050_0000_2 ref_c0_r050_0000_2 0 {C_RBL}   $ ASSUMPTION: ideal matched dummy load
XMN1_c0_r050_0000_2 rbl_c0_r050_0000_2 ref_c0_r050_0000_2 vn_c0_r050_0000_2 0 sky130_fd_pr__nfet_01v8 L=0.15 W=1 nf=1 ad=0.29 as=0.29 pd=2.58 ps=2.58 nrd=0.29 nrs=0.29 sa=0 sb=0 sd=0 mult=1 m=1
XMN2_c0_r050_0000_2 ref_c0_r050_0000_2 rbl_c0_r050_0000_2 vn_c0_r050_0000_2 0 sky130_fd_pr__nfet_01v8 L=0.15 W=1 nf=1 ad=0.29 as=0.29 pd=2.58 ps=2.58 nrd=0.29 nrs=0.29 sa=0 sb=0 sd=0 mult=1 m=1
XMP1_c0_r050_0000_2 rbl_c0_r050_0000_2 ref_c0_r050_0000_2 vp_c0_r050_0000_2 vdd sky130_fd_pr__pfet_01v8 L=0.15 W=2 nf=1 ad=0.58 as=0.58 pd=4.58 ps=4.58 nrd=0.145 nrs=0.145 sa=0 sb=0 sd=0 mult=1 m=1
XMP2_c0_r050_0000_2 ref_c0_r050_0000_2 rbl_c0_r050_0000_2 vp_c0_r050_0000_2 vdd sky130_fd_pr__pfet_01v8 L=0.15 W=2 nf=1 ad=0.58 as=0.58 pd=4.58 ps=4.58 nrd=0.145 nrs=0.145 sa=0 sb=0 sd=0 mult=1 m=1
XMNF_c0_r050_0000_2 vn_c0_r050_0000_2 en 0 0 sky130_fd_pr__nfet_01v8 L=0.15 W=2 nf=1 ad=0.58 as=0.58 pd=4.58 ps=4.58 nrd=0.145 nrs=0.145 sa=0 sb=0 sd=0 mult=1 m=1
XMPH_c0_r050_0000_2 vp_c0_r050_0000_2 enb vdd vdd sky130_fd_pr__pfet_01v8 L=0.15 W=4 nf=1 ad=1.16 as=1.16 pd=8.58 ps=8.58 nrd=0.0725 nrs=0.0725 sa=0 sb=0 sd=0 mult=1 m=1
bd_c0_r050_0000_2 d_c0_r050_0000_2 0 v=v(rbl_c0_r050_0000_2)-v(ref_c0_r050_0000_2)
bdabs_c0_r050_0000_2 dabs_c0_r050_0000_2 0 v=abs(v(rbl_c0_r050_0000_2)-v(ref_c0_r050_0000_2))

* ---- c0_r050_0000_3: cell0 SN = 0.0 V, ref offset 0.05 V, replica 3 ----
spa_c0_r050_0000_3 prea rbl_c0_r050_0000_3 ctl 0 swpre
XMWR_c0_r050_0000_3_0 sn_c0_r050_0000_3_0 0 0 0 sky130_fd_pr__nfet_01v8 L=0.15 W=0.42 nf=1 ad=0.1218 as=0.1218 pd=1.42 ps=1.42 nrd=0.69047619047619  nrs=0.69047619047619 sa=0 sb=0 sd=0 mult=1 m=1
XMRD_c0_r050_0000_3_0 rbl_c0_r050_0000_3 sn_c0_r050_0000_3_0 rwl_sel 0 sky130_fd_pr__nfet_01v8 L=0.15 W=0.42 nf=1 ad=0.1218 as=0.1218 pd=1.42 ps=1.42 nrd=0.69047619047619  nrs=0.69047619047619 sa=0 sb=0 sd=0 mult=1 m=1
csn_c0_r050_0000_3_0 sn_c0_r050_0000_3_0 0 {C_SN}
XMWR_c0_r050_0000_3_1 sn_c0_r050_0000_3_1 0 0 0 sky130_fd_pr__nfet_01v8 L=0.15 W=0.42 nf=1 ad=0.1218 as=0.1218 pd=1.42 ps=1.42 nrd=0.69047619047619  nrs=0.69047619047619 sa=0 sb=0 sd=0 mult=1 m=1
XMRD_c0_r050_0000_3_1 rbl_c0_r050_0000_3 sn_c0_r050_0000_3_1 rwl_des 0 sky130_fd_pr__nfet_01v8 L=0.15 W=0.42 nf=1 ad=0.1218 as=0.1218 pd=1.42 ps=1.42 nrd=0.69047619047619  nrs=0.69047619047619 sa=0 sb=0 sd=0 mult=1 m=1
csn_c0_r050_0000_3_1 sn_c0_r050_0000_3_1 0 {C_SN}
XMWR_c0_r050_0000_3_2 sn_c0_r050_0000_3_2 0 0 0 sky130_fd_pr__nfet_01v8 L=0.15 W=0.42 nf=1 ad=0.1218 as=0.1218 pd=1.42 ps=1.42 nrd=0.69047619047619  nrs=0.69047619047619 sa=0 sb=0 sd=0 mult=1 m=1
XMRD_c0_r050_0000_3_2 rbl_c0_r050_0000_3 sn_c0_r050_0000_3_2 rwl_des 0 sky130_fd_pr__nfet_01v8 L=0.15 W=0.42 nf=1 ad=0.1218 as=0.1218 pd=1.42 ps=1.42 nrd=0.69047619047619  nrs=0.69047619047619 sa=0 sb=0 sd=0 mult=1 m=1
csn_c0_r050_0000_3_2 sn_c0_r050_0000_3_2 0 {C_SN}
XMWR_c0_r050_0000_3_3 sn_c0_r050_0000_3_3 0 0 0 sky130_fd_pr__nfet_01v8 L=0.15 W=0.42 nf=1 ad=0.1218 as=0.1218 pd=1.42 ps=1.42 nrd=0.69047619047619  nrs=0.69047619047619 sa=0 sb=0 sd=0 mult=1 m=1
XMRD_c0_r050_0000_3_3 rbl_c0_r050_0000_3 sn_c0_r050_0000_3_3 rwl_des 0 sky130_fd_pr__nfet_01v8 L=0.15 W=0.42 nf=1 ad=0.1218 as=0.1218 pd=1.42 ps=1.42 nrd=0.69047619047619  nrs=0.69047619047619 sa=0 sb=0 sd=0 mult=1 m=1
csn_c0_r050_0000_3_3 sn_c0_r050_0000_3_3 0 {C_SN}
crbl_c0_r050_0000_3 rbl_c0_r050_0000_3 0 {C_RBL}
spr_c0_r050_0000_3 pref_050 ref_c0_r050_0000_3 ctl 0 swpre
cref_c0_r050_0000_3 ref_c0_r050_0000_3 0 {C_RBL}   $ ASSUMPTION: ideal matched dummy load
XMN1_c0_r050_0000_3 rbl_c0_r050_0000_3 ref_c0_r050_0000_3 vn_c0_r050_0000_3 0 sky130_fd_pr__nfet_01v8 L=0.15 W=1 nf=1 ad=0.29 as=0.29 pd=2.58 ps=2.58 nrd=0.29 nrs=0.29 sa=0 sb=0 sd=0 mult=1 m=1
XMN2_c0_r050_0000_3 ref_c0_r050_0000_3 rbl_c0_r050_0000_3 vn_c0_r050_0000_3 0 sky130_fd_pr__nfet_01v8 L=0.15 W=1 nf=1 ad=0.29 as=0.29 pd=2.58 ps=2.58 nrd=0.29 nrs=0.29 sa=0 sb=0 sd=0 mult=1 m=1
XMP1_c0_r050_0000_3 rbl_c0_r050_0000_3 ref_c0_r050_0000_3 vp_c0_r050_0000_3 vdd sky130_fd_pr__pfet_01v8 L=0.15 W=2 nf=1 ad=0.58 as=0.58 pd=4.58 ps=4.58 nrd=0.145 nrs=0.145 sa=0 sb=0 sd=0 mult=1 m=1
XMP2_c0_r050_0000_3 ref_c0_r050_0000_3 rbl_c0_r050_0000_3 vp_c0_r050_0000_3 vdd sky130_fd_pr__pfet_01v8 L=0.15 W=2 nf=1 ad=0.58 as=0.58 pd=4.58 ps=4.58 nrd=0.145 nrs=0.145 sa=0 sb=0 sd=0 mult=1 m=1
XMNF_c0_r050_0000_3 vn_c0_r050_0000_3 en 0 0 sky130_fd_pr__nfet_01v8 L=0.15 W=2 nf=1 ad=0.58 as=0.58 pd=4.58 ps=4.58 nrd=0.145 nrs=0.145 sa=0 sb=0 sd=0 mult=1 m=1
XMPH_c0_r050_0000_3 vp_c0_r050_0000_3 enb vdd vdd sky130_fd_pr__pfet_01v8 L=0.15 W=4 nf=1 ad=1.16 as=1.16 pd=8.58 ps=8.58 nrd=0.0725 nrs=0.0725 sa=0 sb=0 sd=0 mult=1 m=1
bd_c0_r050_0000_3 d_c0_r050_0000_3 0 v=v(rbl_c0_r050_0000_3)-v(ref_c0_r050_0000_3)
bdabs_c0_r050_0000_3 dabs_c0_r050_0000_3 0 v=abs(v(rbl_c0_r050_0000_3)-v(ref_c0_r050_0000_3))

* ---- c1_r050_0600_0: cell1 SN = 0.6 V, ref offset 0.05 V, replica 0 ----
spa_c1_r050_0600_0 prea rbl_c1_r050_0600_0 ctl 0 swpre
XMWR_c1_r050_0600_0_0 sn_c1_r050_0600_0_0 0 0 0 sky130_fd_pr__nfet_01v8 L=0.15 W=0.42 nf=1 ad=0.1218 as=0.1218 pd=1.42 ps=1.42 nrd=0.69047619047619  nrs=0.69047619047619 sa=0 sb=0 sd=0 mult=1 m=1
XMRD_c1_r050_0600_0_0 rbl_c1_r050_0600_0 sn_c1_r050_0600_0_0 rwl_sel 0 sky130_fd_pr__nfet_01v8 L=0.15 W=0.42 nf=1 ad=0.1218 as=0.1218 pd=1.42 ps=1.42 nrd=0.69047619047619  nrs=0.69047619047619 sa=0 sb=0 sd=0 mult=1 m=1
csn_c1_r050_0600_0_0 sn_c1_r050_0600_0_0 0 {C_SN}
XMWR_c1_r050_0600_0_1 sn_c1_r050_0600_0_1 0 0 0 sky130_fd_pr__nfet_01v8 L=0.15 W=0.42 nf=1 ad=0.1218 as=0.1218 pd=1.42 ps=1.42 nrd=0.69047619047619  nrs=0.69047619047619 sa=0 sb=0 sd=0 mult=1 m=1
XMRD_c1_r050_0600_0_1 rbl_c1_r050_0600_0 sn_c1_r050_0600_0_1 rwl_des 0 sky130_fd_pr__nfet_01v8 L=0.15 W=0.42 nf=1 ad=0.1218 as=0.1218 pd=1.42 ps=1.42 nrd=0.69047619047619  nrs=0.69047619047619 sa=0 sb=0 sd=0 mult=1 m=1
csn_c1_r050_0600_0_1 sn_c1_r050_0600_0_1 0 {C_SN}
XMWR_c1_r050_0600_0_2 sn_c1_r050_0600_0_2 0 0 0 sky130_fd_pr__nfet_01v8 L=0.15 W=0.42 nf=1 ad=0.1218 as=0.1218 pd=1.42 ps=1.42 nrd=0.69047619047619  nrs=0.69047619047619 sa=0 sb=0 sd=0 mult=1 m=1
XMRD_c1_r050_0600_0_2 rbl_c1_r050_0600_0 sn_c1_r050_0600_0_2 rwl_des 0 sky130_fd_pr__nfet_01v8 L=0.15 W=0.42 nf=1 ad=0.1218 as=0.1218 pd=1.42 ps=1.42 nrd=0.69047619047619  nrs=0.69047619047619 sa=0 sb=0 sd=0 mult=1 m=1
csn_c1_r050_0600_0_2 sn_c1_r050_0600_0_2 0 {C_SN}
XMWR_c1_r050_0600_0_3 sn_c1_r050_0600_0_3 0 0 0 sky130_fd_pr__nfet_01v8 L=0.15 W=0.42 nf=1 ad=0.1218 as=0.1218 pd=1.42 ps=1.42 nrd=0.69047619047619  nrs=0.69047619047619 sa=0 sb=0 sd=0 mult=1 m=1
XMRD_c1_r050_0600_0_3 rbl_c1_r050_0600_0 sn_c1_r050_0600_0_3 rwl_des 0 sky130_fd_pr__nfet_01v8 L=0.15 W=0.42 nf=1 ad=0.1218 as=0.1218 pd=1.42 ps=1.42 nrd=0.69047619047619  nrs=0.69047619047619 sa=0 sb=0 sd=0 mult=1 m=1
csn_c1_r050_0600_0_3 sn_c1_r050_0600_0_3 0 {C_SN}
crbl_c1_r050_0600_0 rbl_c1_r050_0600_0 0 {C_RBL}
spr_c1_r050_0600_0 pref_050 ref_c1_r050_0600_0 ctl 0 swpre
cref_c1_r050_0600_0 ref_c1_r050_0600_0 0 {C_RBL}   $ ASSUMPTION: ideal matched dummy load
XMN1_c1_r050_0600_0 rbl_c1_r050_0600_0 ref_c1_r050_0600_0 vn_c1_r050_0600_0 0 sky130_fd_pr__nfet_01v8 L=0.15 W=1 nf=1 ad=0.29 as=0.29 pd=2.58 ps=2.58 nrd=0.29 nrs=0.29 sa=0 sb=0 sd=0 mult=1 m=1
XMN2_c1_r050_0600_0 ref_c1_r050_0600_0 rbl_c1_r050_0600_0 vn_c1_r050_0600_0 0 sky130_fd_pr__nfet_01v8 L=0.15 W=1 nf=1 ad=0.29 as=0.29 pd=2.58 ps=2.58 nrd=0.29 nrs=0.29 sa=0 sb=0 sd=0 mult=1 m=1
XMP1_c1_r050_0600_0 rbl_c1_r050_0600_0 ref_c1_r050_0600_0 vp_c1_r050_0600_0 vdd sky130_fd_pr__pfet_01v8 L=0.15 W=2 nf=1 ad=0.58 as=0.58 pd=4.58 ps=4.58 nrd=0.145 nrs=0.145 sa=0 sb=0 sd=0 mult=1 m=1
XMP2_c1_r050_0600_0 ref_c1_r050_0600_0 rbl_c1_r050_0600_0 vp_c1_r050_0600_0 vdd sky130_fd_pr__pfet_01v8 L=0.15 W=2 nf=1 ad=0.58 as=0.58 pd=4.58 ps=4.58 nrd=0.145 nrs=0.145 sa=0 sb=0 sd=0 mult=1 m=1
XMNF_c1_r050_0600_0 vn_c1_r050_0600_0 en 0 0 sky130_fd_pr__nfet_01v8 L=0.15 W=2 nf=1 ad=0.58 as=0.58 pd=4.58 ps=4.58 nrd=0.145 nrs=0.145 sa=0 sb=0 sd=0 mult=1 m=1
XMPH_c1_r050_0600_0 vp_c1_r050_0600_0 enb vdd vdd sky130_fd_pr__pfet_01v8 L=0.15 W=4 nf=1 ad=1.16 as=1.16 pd=8.58 ps=8.58 nrd=0.0725 nrs=0.0725 sa=0 sb=0 sd=0 mult=1 m=1
bd_c1_r050_0600_0 d_c1_r050_0600_0 0 v=v(rbl_c1_r050_0600_0)-v(ref_c1_r050_0600_0)
bdabs_c1_r050_0600_0 dabs_c1_r050_0600_0 0 v=abs(v(rbl_c1_r050_0600_0)-v(ref_c1_r050_0600_0))

* ---- c1_r050_0600_1: cell1 SN = 0.6 V, ref offset 0.05 V, replica 1 ----
spa_c1_r050_0600_1 prea rbl_c1_r050_0600_1 ctl 0 swpre
XMWR_c1_r050_0600_1_0 sn_c1_r050_0600_1_0 0 0 0 sky130_fd_pr__nfet_01v8 L=0.15 W=0.42 nf=1 ad=0.1218 as=0.1218 pd=1.42 ps=1.42 nrd=0.69047619047619  nrs=0.69047619047619 sa=0 sb=0 sd=0 mult=1 m=1
XMRD_c1_r050_0600_1_0 rbl_c1_r050_0600_1 sn_c1_r050_0600_1_0 rwl_sel 0 sky130_fd_pr__nfet_01v8 L=0.15 W=0.42 nf=1 ad=0.1218 as=0.1218 pd=1.42 ps=1.42 nrd=0.69047619047619  nrs=0.69047619047619 sa=0 sb=0 sd=0 mult=1 m=1
csn_c1_r050_0600_1_0 sn_c1_r050_0600_1_0 0 {C_SN}
XMWR_c1_r050_0600_1_1 sn_c1_r050_0600_1_1 0 0 0 sky130_fd_pr__nfet_01v8 L=0.15 W=0.42 nf=1 ad=0.1218 as=0.1218 pd=1.42 ps=1.42 nrd=0.69047619047619  nrs=0.69047619047619 sa=0 sb=0 sd=0 mult=1 m=1
XMRD_c1_r050_0600_1_1 rbl_c1_r050_0600_1 sn_c1_r050_0600_1_1 rwl_des 0 sky130_fd_pr__nfet_01v8 L=0.15 W=0.42 nf=1 ad=0.1218 as=0.1218 pd=1.42 ps=1.42 nrd=0.69047619047619  nrs=0.69047619047619 sa=0 sb=0 sd=0 mult=1 m=1
csn_c1_r050_0600_1_1 sn_c1_r050_0600_1_1 0 {C_SN}
XMWR_c1_r050_0600_1_2 sn_c1_r050_0600_1_2 0 0 0 sky130_fd_pr__nfet_01v8 L=0.15 W=0.42 nf=1 ad=0.1218 as=0.1218 pd=1.42 ps=1.42 nrd=0.69047619047619  nrs=0.69047619047619 sa=0 sb=0 sd=0 mult=1 m=1
XMRD_c1_r050_0600_1_2 rbl_c1_r050_0600_1 sn_c1_r050_0600_1_2 rwl_des 0 sky130_fd_pr__nfet_01v8 L=0.15 W=0.42 nf=1 ad=0.1218 as=0.1218 pd=1.42 ps=1.42 nrd=0.69047619047619  nrs=0.69047619047619 sa=0 sb=0 sd=0 mult=1 m=1
csn_c1_r050_0600_1_2 sn_c1_r050_0600_1_2 0 {C_SN}
XMWR_c1_r050_0600_1_3 sn_c1_r050_0600_1_3 0 0 0 sky130_fd_pr__nfet_01v8 L=0.15 W=0.42 nf=1 ad=0.1218 as=0.1218 pd=1.42 ps=1.42 nrd=0.69047619047619  nrs=0.69047619047619 sa=0 sb=0 sd=0 mult=1 m=1
XMRD_c1_r050_0600_1_3 rbl_c1_r050_0600_1 sn_c1_r050_0600_1_3 rwl_des 0 sky130_fd_pr__nfet_01v8 L=0.15 W=0.42 nf=1 ad=0.1218 as=0.1218 pd=1.42 ps=1.42 nrd=0.69047619047619  nrs=0.69047619047619 sa=0 sb=0 sd=0 mult=1 m=1
csn_c1_r050_0600_1_3 sn_c1_r050_0600_1_3 0 {C_SN}
crbl_c1_r050_0600_1 rbl_c1_r050_0600_1 0 {C_RBL}
spr_c1_r050_0600_1 pref_050 ref_c1_r050_0600_1 ctl 0 swpre
cref_c1_r050_0600_1 ref_c1_r050_0600_1 0 {C_RBL}   $ ASSUMPTION: ideal matched dummy load
XMN1_c1_r050_0600_1 rbl_c1_r050_0600_1 ref_c1_r050_0600_1 vn_c1_r050_0600_1 0 sky130_fd_pr__nfet_01v8 L=0.15 W=1 nf=1 ad=0.29 as=0.29 pd=2.58 ps=2.58 nrd=0.29 nrs=0.29 sa=0 sb=0 sd=0 mult=1 m=1
XMN2_c1_r050_0600_1 ref_c1_r050_0600_1 rbl_c1_r050_0600_1 vn_c1_r050_0600_1 0 sky130_fd_pr__nfet_01v8 L=0.15 W=1 nf=1 ad=0.29 as=0.29 pd=2.58 ps=2.58 nrd=0.29 nrs=0.29 sa=0 sb=0 sd=0 mult=1 m=1
XMP1_c1_r050_0600_1 rbl_c1_r050_0600_1 ref_c1_r050_0600_1 vp_c1_r050_0600_1 vdd sky130_fd_pr__pfet_01v8 L=0.15 W=2 nf=1 ad=0.58 as=0.58 pd=4.58 ps=4.58 nrd=0.145 nrs=0.145 sa=0 sb=0 sd=0 mult=1 m=1
XMP2_c1_r050_0600_1 ref_c1_r050_0600_1 rbl_c1_r050_0600_1 vp_c1_r050_0600_1 vdd sky130_fd_pr__pfet_01v8 L=0.15 W=2 nf=1 ad=0.58 as=0.58 pd=4.58 ps=4.58 nrd=0.145 nrs=0.145 sa=0 sb=0 sd=0 mult=1 m=1
XMNF_c1_r050_0600_1 vn_c1_r050_0600_1 en 0 0 sky130_fd_pr__nfet_01v8 L=0.15 W=2 nf=1 ad=0.58 as=0.58 pd=4.58 ps=4.58 nrd=0.145 nrs=0.145 sa=0 sb=0 sd=0 mult=1 m=1
XMPH_c1_r050_0600_1 vp_c1_r050_0600_1 enb vdd vdd sky130_fd_pr__pfet_01v8 L=0.15 W=4 nf=1 ad=1.16 as=1.16 pd=8.58 ps=8.58 nrd=0.0725 nrs=0.0725 sa=0 sb=0 sd=0 mult=1 m=1
bd_c1_r050_0600_1 d_c1_r050_0600_1 0 v=v(rbl_c1_r050_0600_1)-v(ref_c1_r050_0600_1)
bdabs_c1_r050_0600_1 dabs_c1_r050_0600_1 0 v=abs(v(rbl_c1_r050_0600_1)-v(ref_c1_r050_0600_1))

* ---- c1_r050_0600_2: cell1 SN = 0.6 V, ref offset 0.05 V, replica 2 ----
spa_c1_r050_0600_2 prea rbl_c1_r050_0600_2 ctl 0 swpre
XMWR_c1_r050_0600_2_0 sn_c1_r050_0600_2_0 0 0 0 sky130_fd_pr__nfet_01v8 L=0.15 W=0.42 nf=1 ad=0.1218 as=0.1218 pd=1.42 ps=1.42 nrd=0.69047619047619  nrs=0.69047619047619 sa=0 sb=0 sd=0 mult=1 m=1
XMRD_c1_r050_0600_2_0 rbl_c1_r050_0600_2 sn_c1_r050_0600_2_0 rwl_sel 0 sky130_fd_pr__nfet_01v8 L=0.15 W=0.42 nf=1 ad=0.1218 as=0.1218 pd=1.42 ps=1.42 nrd=0.69047619047619  nrs=0.69047619047619 sa=0 sb=0 sd=0 mult=1 m=1
csn_c1_r050_0600_2_0 sn_c1_r050_0600_2_0 0 {C_SN}
XMWR_c1_r050_0600_2_1 sn_c1_r050_0600_2_1 0 0 0 sky130_fd_pr__nfet_01v8 L=0.15 W=0.42 nf=1 ad=0.1218 as=0.1218 pd=1.42 ps=1.42 nrd=0.69047619047619  nrs=0.69047619047619 sa=0 sb=0 sd=0 mult=1 m=1
XMRD_c1_r050_0600_2_1 rbl_c1_r050_0600_2 sn_c1_r050_0600_2_1 rwl_des 0 sky130_fd_pr__nfet_01v8 L=0.15 W=0.42 nf=1 ad=0.1218 as=0.1218 pd=1.42 ps=1.42 nrd=0.69047619047619  nrs=0.69047619047619 sa=0 sb=0 sd=0 mult=1 m=1
csn_c1_r050_0600_2_1 sn_c1_r050_0600_2_1 0 {C_SN}
XMWR_c1_r050_0600_2_2 sn_c1_r050_0600_2_2 0 0 0 sky130_fd_pr__nfet_01v8 L=0.15 W=0.42 nf=1 ad=0.1218 as=0.1218 pd=1.42 ps=1.42 nrd=0.69047619047619  nrs=0.69047619047619 sa=0 sb=0 sd=0 mult=1 m=1
XMRD_c1_r050_0600_2_2 rbl_c1_r050_0600_2 sn_c1_r050_0600_2_2 rwl_des 0 sky130_fd_pr__nfet_01v8 L=0.15 W=0.42 nf=1 ad=0.1218 as=0.1218 pd=1.42 ps=1.42 nrd=0.69047619047619  nrs=0.69047619047619 sa=0 sb=0 sd=0 mult=1 m=1
csn_c1_r050_0600_2_2 sn_c1_r050_0600_2_2 0 {C_SN}
XMWR_c1_r050_0600_2_3 sn_c1_r050_0600_2_3 0 0 0 sky130_fd_pr__nfet_01v8 L=0.15 W=0.42 nf=1 ad=0.1218 as=0.1218 pd=1.42 ps=1.42 nrd=0.69047619047619  nrs=0.69047619047619 sa=0 sb=0 sd=0 mult=1 m=1
XMRD_c1_r050_0600_2_3 rbl_c1_r050_0600_2 sn_c1_r050_0600_2_3 rwl_des 0 sky130_fd_pr__nfet_01v8 L=0.15 W=0.42 nf=1 ad=0.1218 as=0.1218 pd=1.42 ps=1.42 nrd=0.69047619047619  nrs=0.69047619047619 sa=0 sb=0 sd=0 mult=1 m=1
csn_c1_r050_0600_2_3 sn_c1_r050_0600_2_3 0 {C_SN}
crbl_c1_r050_0600_2 rbl_c1_r050_0600_2 0 {C_RBL}
spr_c1_r050_0600_2 pref_050 ref_c1_r050_0600_2 ctl 0 swpre
cref_c1_r050_0600_2 ref_c1_r050_0600_2 0 {C_RBL}   $ ASSUMPTION: ideal matched dummy load
XMN1_c1_r050_0600_2 rbl_c1_r050_0600_2 ref_c1_r050_0600_2 vn_c1_r050_0600_2 0 sky130_fd_pr__nfet_01v8 L=0.15 W=1 nf=1 ad=0.29 as=0.29 pd=2.58 ps=2.58 nrd=0.29 nrs=0.29 sa=0 sb=0 sd=0 mult=1 m=1
XMN2_c1_r050_0600_2 ref_c1_r050_0600_2 rbl_c1_r050_0600_2 vn_c1_r050_0600_2 0 sky130_fd_pr__nfet_01v8 L=0.15 W=1 nf=1 ad=0.29 as=0.29 pd=2.58 ps=2.58 nrd=0.29 nrs=0.29 sa=0 sb=0 sd=0 mult=1 m=1
XMP1_c1_r050_0600_2 rbl_c1_r050_0600_2 ref_c1_r050_0600_2 vp_c1_r050_0600_2 vdd sky130_fd_pr__pfet_01v8 L=0.15 W=2 nf=1 ad=0.58 as=0.58 pd=4.58 ps=4.58 nrd=0.145 nrs=0.145 sa=0 sb=0 sd=0 mult=1 m=1
XMP2_c1_r050_0600_2 ref_c1_r050_0600_2 rbl_c1_r050_0600_2 vp_c1_r050_0600_2 vdd sky130_fd_pr__pfet_01v8 L=0.15 W=2 nf=1 ad=0.58 as=0.58 pd=4.58 ps=4.58 nrd=0.145 nrs=0.145 sa=0 sb=0 sd=0 mult=1 m=1
XMNF_c1_r050_0600_2 vn_c1_r050_0600_2 en 0 0 sky130_fd_pr__nfet_01v8 L=0.15 W=2 nf=1 ad=0.58 as=0.58 pd=4.58 ps=4.58 nrd=0.145 nrs=0.145 sa=0 sb=0 sd=0 mult=1 m=1
XMPH_c1_r050_0600_2 vp_c1_r050_0600_2 enb vdd vdd sky130_fd_pr__pfet_01v8 L=0.15 W=4 nf=1 ad=1.16 as=1.16 pd=8.58 ps=8.58 nrd=0.0725 nrs=0.0725 sa=0 sb=0 sd=0 mult=1 m=1
bd_c1_r050_0600_2 d_c1_r050_0600_2 0 v=v(rbl_c1_r050_0600_2)-v(ref_c1_r050_0600_2)
bdabs_c1_r050_0600_2 dabs_c1_r050_0600_2 0 v=abs(v(rbl_c1_r050_0600_2)-v(ref_c1_r050_0600_2))

* ---- c1_r050_0600_3: cell1 SN = 0.6 V, ref offset 0.05 V, replica 3 ----
spa_c1_r050_0600_3 prea rbl_c1_r050_0600_3 ctl 0 swpre
XMWR_c1_r050_0600_3_0 sn_c1_r050_0600_3_0 0 0 0 sky130_fd_pr__nfet_01v8 L=0.15 W=0.42 nf=1 ad=0.1218 as=0.1218 pd=1.42 ps=1.42 nrd=0.69047619047619  nrs=0.69047619047619 sa=0 sb=0 sd=0 mult=1 m=1
XMRD_c1_r050_0600_3_0 rbl_c1_r050_0600_3 sn_c1_r050_0600_3_0 rwl_sel 0 sky130_fd_pr__nfet_01v8 L=0.15 W=0.42 nf=1 ad=0.1218 as=0.1218 pd=1.42 ps=1.42 nrd=0.69047619047619  nrs=0.69047619047619 sa=0 sb=0 sd=0 mult=1 m=1
csn_c1_r050_0600_3_0 sn_c1_r050_0600_3_0 0 {C_SN}
XMWR_c1_r050_0600_3_1 sn_c1_r050_0600_3_1 0 0 0 sky130_fd_pr__nfet_01v8 L=0.15 W=0.42 nf=1 ad=0.1218 as=0.1218 pd=1.42 ps=1.42 nrd=0.69047619047619  nrs=0.69047619047619 sa=0 sb=0 sd=0 mult=1 m=1
XMRD_c1_r050_0600_3_1 rbl_c1_r050_0600_3 sn_c1_r050_0600_3_1 rwl_des 0 sky130_fd_pr__nfet_01v8 L=0.15 W=0.42 nf=1 ad=0.1218 as=0.1218 pd=1.42 ps=1.42 nrd=0.69047619047619  nrs=0.69047619047619 sa=0 sb=0 sd=0 mult=1 m=1
csn_c1_r050_0600_3_1 sn_c1_r050_0600_3_1 0 {C_SN}
XMWR_c1_r050_0600_3_2 sn_c1_r050_0600_3_2 0 0 0 sky130_fd_pr__nfet_01v8 L=0.15 W=0.42 nf=1 ad=0.1218 as=0.1218 pd=1.42 ps=1.42 nrd=0.69047619047619  nrs=0.69047619047619 sa=0 sb=0 sd=0 mult=1 m=1
XMRD_c1_r050_0600_3_2 rbl_c1_r050_0600_3 sn_c1_r050_0600_3_2 rwl_des 0 sky130_fd_pr__nfet_01v8 L=0.15 W=0.42 nf=1 ad=0.1218 as=0.1218 pd=1.42 ps=1.42 nrd=0.69047619047619  nrs=0.69047619047619 sa=0 sb=0 sd=0 mult=1 m=1
csn_c1_r050_0600_3_2 sn_c1_r050_0600_3_2 0 {C_SN}
XMWR_c1_r050_0600_3_3 sn_c1_r050_0600_3_3 0 0 0 sky130_fd_pr__nfet_01v8 L=0.15 W=0.42 nf=1 ad=0.1218 as=0.1218 pd=1.42 ps=1.42 nrd=0.69047619047619  nrs=0.69047619047619 sa=0 sb=0 sd=0 mult=1 m=1
XMRD_c1_r050_0600_3_3 rbl_c1_r050_0600_3 sn_c1_r050_0600_3_3 rwl_des 0 sky130_fd_pr__nfet_01v8 L=0.15 W=0.42 nf=1 ad=0.1218 as=0.1218 pd=1.42 ps=1.42 nrd=0.69047619047619  nrs=0.69047619047619 sa=0 sb=0 sd=0 mult=1 m=1
csn_c1_r050_0600_3_3 sn_c1_r050_0600_3_3 0 {C_SN}
crbl_c1_r050_0600_3 rbl_c1_r050_0600_3 0 {C_RBL}
spr_c1_r050_0600_3 pref_050 ref_c1_r050_0600_3 ctl 0 swpre
cref_c1_r050_0600_3 ref_c1_r050_0600_3 0 {C_RBL}   $ ASSUMPTION: ideal matched dummy load
XMN1_c1_r050_0600_3 rbl_c1_r050_0600_3 ref_c1_r050_0600_3 vn_c1_r050_0600_3 0 sky130_fd_pr__nfet_01v8 L=0.15 W=1 nf=1 ad=0.29 as=0.29 pd=2.58 ps=2.58 nrd=0.29 nrs=0.29 sa=0 sb=0 sd=0 mult=1 m=1
XMN2_c1_r050_0600_3 ref_c1_r050_0600_3 rbl_c1_r050_0600_3 vn_c1_r050_0600_3 0 sky130_fd_pr__nfet_01v8 L=0.15 W=1 nf=1 ad=0.29 as=0.29 pd=2.58 ps=2.58 nrd=0.29 nrs=0.29 sa=0 sb=0 sd=0 mult=1 m=1
XMP1_c1_r050_0600_3 rbl_c1_r050_0600_3 ref_c1_r050_0600_3 vp_c1_r050_0600_3 vdd sky130_fd_pr__pfet_01v8 L=0.15 W=2 nf=1 ad=0.58 as=0.58 pd=4.58 ps=4.58 nrd=0.145 nrs=0.145 sa=0 sb=0 sd=0 mult=1 m=1
XMP2_c1_r050_0600_3 ref_c1_r050_0600_3 rbl_c1_r050_0600_3 vp_c1_r050_0600_3 vdd sky130_fd_pr__pfet_01v8 L=0.15 W=2 nf=1 ad=0.58 as=0.58 pd=4.58 ps=4.58 nrd=0.145 nrs=0.145 sa=0 sb=0 sd=0 mult=1 m=1
XMNF_c1_r050_0600_3 vn_c1_r050_0600_3 en 0 0 sky130_fd_pr__nfet_01v8 L=0.15 W=2 nf=1 ad=0.58 as=0.58 pd=4.58 ps=4.58 nrd=0.145 nrs=0.145 sa=0 sb=0 sd=0 mult=1 m=1
XMPH_c1_r050_0600_3 vp_c1_r050_0600_3 enb vdd vdd sky130_fd_pr__pfet_01v8 L=0.15 W=4 nf=1 ad=1.16 as=1.16 pd=8.58 ps=8.58 nrd=0.0725 nrs=0.0725 sa=0 sb=0 sd=0 mult=1 m=1
bd_c1_r050_0600_3 d_c1_r050_0600_3 0 v=v(rbl_c1_r050_0600_3)-v(ref_c1_r050_0600_3)
bdabs_c1_r050_0600_3 dabs_c1_r050_0600_3 0 v=abs(v(rbl_c1_r050_0600_3)-v(ref_c1_r050_0600_3))

* ---- c1_r050_0650_0: cell1 SN = 0.65 V, ref offset 0.05 V, replica 0 ----
spa_c1_r050_0650_0 prea rbl_c1_r050_0650_0 ctl 0 swpre
XMWR_c1_r050_0650_0_0 sn_c1_r050_0650_0_0 0 0 0 sky130_fd_pr__nfet_01v8 L=0.15 W=0.42 nf=1 ad=0.1218 as=0.1218 pd=1.42 ps=1.42 nrd=0.69047619047619  nrs=0.69047619047619 sa=0 sb=0 sd=0 mult=1 m=1
XMRD_c1_r050_0650_0_0 rbl_c1_r050_0650_0 sn_c1_r050_0650_0_0 rwl_sel 0 sky130_fd_pr__nfet_01v8 L=0.15 W=0.42 nf=1 ad=0.1218 as=0.1218 pd=1.42 ps=1.42 nrd=0.69047619047619  nrs=0.69047619047619 sa=0 sb=0 sd=0 mult=1 m=1
csn_c1_r050_0650_0_0 sn_c1_r050_0650_0_0 0 {C_SN}
XMWR_c1_r050_0650_0_1 sn_c1_r050_0650_0_1 0 0 0 sky130_fd_pr__nfet_01v8 L=0.15 W=0.42 nf=1 ad=0.1218 as=0.1218 pd=1.42 ps=1.42 nrd=0.69047619047619  nrs=0.69047619047619 sa=0 sb=0 sd=0 mult=1 m=1
XMRD_c1_r050_0650_0_1 rbl_c1_r050_0650_0 sn_c1_r050_0650_0_1 rwl_des 0 sky130_fd_pr__nfet_01v8 L=0.15 W=0.42 nf=1 ad=0.1218 as=0.1218 pd=1.42 ps=1.42 nrd=0.69047619047619  nrs=0.69047619047619 sa=0 sb=0 sd=0 mult=1 m=1
csn_c1_r050_0650_0_1 sn_c1_r050_0650_0_1 0 {C_SN}
XMWR_c1_r050_0650_0_2 sn_c1_r050_0650_0_2 0 0 0 sky130_fd_pr__nfet_01v8 L=0.15 W=0.42 nf=1 ad=0.1218 as=0.1218 pd=1.42 ps=1.42 nrd=0.69047619047619  nrs=0.69047619047619 sa=0 sb=0 sd=0 mult=1 m=1
XMRD_c1_r050_0650_0_2 rbl_c1_r050_0650_0 sn_c1_r050_0650_0_2 rwl_des 0 sky130_fd_pr__nfet_01v8 L=0.15 W=0.42 nf=1 ad=0.1218 as=0.1218 pd=1.42 ps=1.42 nrd=0.69047619047619  nrs=0.69047619047619 sa=0 sb=0 sd=0 mult=1 m=1
csn_c1_r050_0650_0_2 sn_c1_r050_0650_0_2 0 {C_SN}
XMWR_c1_r050_0650_0_3 sn_c1_r050_0650_0_3 0 0 0 sky130_fd_pr__nfet_01v8 L=0.15 W=0.42 nf=1 ad=0.1218 as=0.1218 pd=1.42 ps=1.42 nrd=0.69047619047619  nrs=0.69047619047619 sa=0 sb=0 sd=0 mult=1 m=1
XMRD_c1_r050_0650_0_3 rbl_c1_r050_0650_0 sn_c1_r050_0650_0_3 rwl_des 0 sky130_fd_pr__nfet_01v8 L=0.15 W=0.42 nf=1 ad=0.1218 as=0.1218 pd=1.42 ps=1.42 nrd=0.69047619047619  nrs=0.69047619047619 sa=0 sb=0 sd=0 mult=1 m=1
csn_c1_r050_0650_0_3 sn_c1_r050_0650_0_3 0 {C_SN}
crbl_c1_r050_0650_0 rbl_c1_r050_0650_0 0 {C_RBL}
spr_c1_r050_0650_0 pref_050 ref_c1_r050_0650_0 ctl 0 swpre
cref_c1_r050_0650_0 ref_c1_r050_0650_0 0 {C_RBL}   $ ASSUMPTION: ideal matched dummy load
XMN1_c1_r050_0650_0 rbl_c1_r050_0650_0 ref_c1_r050_0650_0 vn_c1_r050_0650_0 0 sky130_fd_pr__nfet_01v8 L=0.15 W=1 nf=1 ad=0.29 as=0.29 pd=2.58 ps=2.58 nrd=0.29 nrs=0.29 sa=0 sb=0 sd=0 mult=1 m=1
XMN2_c1_r050_0650_0 ref_c1_r050_0650_0 rbl_c1_r050_0650_0 vn_c1_r050_0650_0 0 sky130_fd_pr__nfet_01v8 L=0.15 W=1 nf=1 ad=0.29 as=0.29 pd=2.58 ps=2.58 nrd=0.29 nrs=0.29 sa=0 sb=0 sd=0 mult=1 m=1
XMP1_c1_r050_0650_0 rbl_c1_r050_0650_0 ref_c1_r050_0650_0 vp_c1_r050_0650_0 vdd sky130_fd_pr__pfet_01v8 L=0.15 W=2 nf=1 ad=0.58 as=0.58 pd=4.58 ps=4.58 nrd=0.145 nrs=0.145 sa=0 sb=0 sd=0 mult=1 m=1
XMP2_c1_r050_0650_0 ref_c1_r050_0650_0 rbl_c1_r050_0650_0 vp_c1_r050_0650_0 vdd sky130_fd_pr__pfet_01v8 L=0.15 W=2 nf=1 ad=0.58 as=0.58 pd=4.58 ps=4.58 nrd=0.145 nrs=0.145 sa=0 sb=0 sd=0 mult=1 m=1
XMNF_c1_r050_0650_0 vn_c1_r050_0650_0 en 0 0 sky130_fd_pr__nfet_01v8 L=0.15 W=2 nf=1 ad=0.58 as=0.58 pd=4.58 ps=4.58 nrd=0.145 nrs=0.145 sa=0 sb=0 sd=0 mult=1 m=1
XMPH_c1_r050_0650_0 vp_c1_r050_0650_0 enb vdd vdd sky130_fd_pr__pfet_01v8 L=0.15 W=4 nf=1 ad=1.16 as=1.16 pd=8.58 ps=8.58 nrd=0.0725 nrs=0.0725 sa=0 sb=0 sd=0 mult=1 m=1
bd_c1_r050_0650_0 d_c1_r050_0650_0 0 v=v(rbl_c1_r050_0650_0)-v(ref_c1_r050_0650_0)
bdabs_c1_r050_0650_0 dabs_c1_r050_0650_0 0 v=abs(v(rbl_c1_r050_0650_0)-v(ref_c1_r050_0650_0))

* ---- c1_r050_0650_1: cell1 SN = 0.65 V, ref offset 0.05 V, replica 1 ----
spa_c1_r050_0650_1 prea rbl_c1_r050_0650_1 ctl 0 swpre
XMWR_c1_r050_0650_1_0 sn_c1_r050_0650_1_0 0 0 0 sky130_fd_pr__nfet_01v8 L=0.15 W=0.42 nf=1 ad=0.1218 as=0.1218 pd=1.42 ps=1.42 nrd=0.69047619047619  nrs=0.69047619047619 sa=0 sb=0 sd=0 mult=1 m=1
XMRD_c1_r050_0650_1_0 rbl_c1_r050_0650_1 sn_c1_r050_0650_1_0 rwl_sel 0 sky130_fd_pr__nfet_01v8 L=0.15 W=0.42 nf=1 ad=0.1218 as=0.1218 pd=1.42 ps=1.42 nrd=0.69047619047619  nrs=0.69047619047619 sa=0 sb=0 sd=0 mult=1 m=1
csn_c1_r050_0650_1_0 sn_c1_r050_0650_1_0 0 {C_SN}
XMWR_c1_r050_0650_1_1 sn_c1_r050_0650_1_1 0 0 0 sky130_fd_pr__nfet_01v8 L=0.15 W=0.42 nf=1 ad=0.1218 as=0.1218 pd=1.42 ps=1.42 nrd=0.69047619047619  nrs=0.69047619047619 sa=0 sb=0 sd=0 mult=1 m=1
XMRD_c1_r050_0650_1_1 rbl_c1_r050_0650_1 sn_c1_r050_0650_1_1 rwl_des 0 sky130_fd_pr__nfet_01v8 L=0.15 W=0.42 nf=1 ad=0.1218 as=0.1218 pd=1.42 ps=1.42 nrd=0.69047619047619  nrs=0.69047619047619 sa=0 sb=0 sd=0 mult=1 m=1
csn_c1_r050_0650_1_1 sn_c1_r050_0650_1_1 0 {C_SN}
XMWR_c1_r050_0650_1_2 sn_c1_r050_0650_1_2 0 0 0 sky130_fd_pr__nfet_01v8 L=0.15 W=0.42 nf=1 ad=0.1218 as=0.1218 pd=1.42 ps=1.42 nrd=0.69047619047619  nrs=0.69047619047619 sa=0 sb=0 sd=0 mult=1 m=1
XMRD_c1_r050_0650_1_2 rbl_c1_r050_0650_1 sn_c1_r050_0650_1_2 rwl_des 0 sky130_fd_pr__nfet_01v8 L=0.15 W=0.42 nf=1 ad=0.1218 as=0.1218 pd=1.42 ps=1.42 nrd=0.69047619047619  nrs=0.69047619047619 sa=0 sb=0 sd=0 mult=1 m=1
csn_c1_r050_0650_1_2 sn_c1_r050_0650_1_2 0 {C_SN}
XMWR_c1_r050_0650_1_3 sn_c1_r050_0650_1_3 0 0 0 sky130_fd_pr__nfet_01v8 L=0.15 W=0.42 nf=1 ad=0.1218 as=0.1218 pd=1.42 ps=1.42 nrd=0.69047619047619  nrs=0.69047619047619 sa=0 sb=0 sd=0 mult=1 m=1
XMRD_c1_r050_0650_1_3 rbl_c1_r050_0650_1 sn_c1_r050_0650_1_3 rwl_des 0 sky130_fd_pr__nfet_01v8 L=0.15 W=0.42 nf=1 ad=0.1218 as=0.1218 pd=1.42 ps=1.42 nrd=0.69047619047619  nrs=0.69047619047619 sa=0 sb=0 sd=0 mult=1 m=1
csn_c1_r050_0650_1_3 sn_c1_r050_0650_1_3 0 {C_SN}
crbl_c1_r050_0650_1 rbl_c1_r050_0650_1 0 {C_RBL}
spr_c1_r050_0650_1 pref_050 ref_c1_r050_0650_1 ctl 0 swpre
cref_c1_r050_0650_1 ref_c1_r050_0650_1 0 {C_RBL}   $ ASSUMPTION: ideal matched dummy load
XMN1_c1_r050_0650_1 rbl_c1_r050_0650_1 ref_c1_r050_0650_1 vn_c1_r050_0650_1 0 sky130_fd_pr__nfet_01v8 L=0.15 W=1 nf=1 ad=0.29 as=0.29 pd=2.58 ps=2.58 nrd=0.29 nrs=0.29 sa=0 sb=0 sd=0 mult=1 m=1
XMN2_c1_r050_0650_1 ref_c1_r050_0650_1 rbl_c1_r050_0650_1 vn_c1_r050_0650_1 0 sky130_fd_pr__nfet_01v8 L=0.15 W=1 nf=1 ad=0.29 as=0.29 pd=2.58 ps=2.58 nrd=0.29 nrs=0.29 sa=0 sb=0 sd=0 mult=1 m=1
XMP1_c1_r050_0650_1 rbl_c1_r050_0650_1 ref_c1_r050_0650_1 vp_c1_r050_0650_1 vdd sky130_fd_pr__pfet_01v8 L=0.15 W=2 nf=1 ad=0.58 as=0.58 pd=4.58 ps=4.58 nrd=0.145 nrs=0.145 sa=0 sb=0 sd=0 mult=1 m=1
XMP2_c1_r050_0650_1 ref_c1_r050_0650_1 rbl_c1_r050_0650_1 vp_c1_r050_0650_1 vdd sky130_fd_pr__pfet_01v8 L=0.15 W=2 nf=1 ad=0.58 as=0.58 pd=4.58 ps=4.58 nrd=0.145 nrs=0.145 sa=0 sb=0 sd=0 mult=1 m=1
XMNF_c1_r050_0650_1 vn_c1_r050_0650_1 en 0 0 sky130_fd_pr__nfet_01v8 L=0.15 W=2 nf=1 ad=0.58 as=0.58 pd=4.58 ps=4.58 nrd=0.145 nrs=0.145 sa=0 sb=0 sd=0 mult=1 m=1
XMPH_c1_r050_0650_1 vp_c1_r050_0650_1 enb vdd vdd sky130_fd_pr__pfet_01v8 L=0.15 W=4 nf=1 ad=1.16 as=1.16 pd=8.58 ps=8.58 nrd=0.0725 nrs=0.0725 sa=0 sb=0 sd=0 mult=1 m=1
bd_c1_r050_0650_1 d_c1_r050_0650_1 0 v=v(rbl_c1_r050_0650_1)-v(ref_c1_r050_0650_1)
bdabs_c1_r050_0650_1 dabs_c1_r050_0650_1 0 v=abs(v(rbl_c1_r050_0650_1)-v(ref_c1_r050_0650_1))

* ---- c1_r050_0650_2: cell1 SN = 0.65 V, ref offset 0.05 V, replica 2 ----
spa_c1_r050_0650_2 prea rbl_c1_r050_0650_2 ctl 0 swpre
XMWR_c1_r050_0650_2_0 sn_c1_r050_0650_2_0 0 0 0 sky130_fd_pr__nfet_01v8 L=0.15 W=0.42 nf=1 ad=0.1218 as=0.1218 pd=1.42 ps=1.42 nrd=0.69047619047619  nrs=0.69047619047619 sa=0 sb=0 sd=0 mult=1 m=1
XMRD_c1_r050_0650_2_0 rbl_c1_r050_0650_2 sn_c1_r050_0650_2_0 rwl_sel 0 sky130_fd_pr__nfet_01v8 L=0.15 W=0.42 nf=1 ad=0.1218 as=0.1218 pd=1.42 ps=1.42 nrd=0.69047619047619  nrs=0.69047619047619 sa=0 sb=0 sd=0 mult=1 m=1
csn_c1_r050_0650_2_0 sn_c1_r050_0650_2_0 0 {C_SN}
XMWR_c1_r050_0650_2_1 sn_c1_r050_0650_2_1 0 0 0 sky130_fd_pr__nfet_01v8 L=0.15 W=0.42 nf=1 ad=0.1218 as=0.1218 pd=1.42 ps=1.42 nrd=0.69047619047619  nrs=0.69047619047619 sa=0 sb=0 sd=0 mult=1 m=1
XMRD_c1_r050_0650_2_1 rbl_c1_r050_0650_2 sn_c1_r050_0650_2_1 rwl_des 0 sky130_fd_pr__nfet_01v8 L=0.15 W=0.42 nf=1 ad=0.1218 as=0.1218 pd=1.42 ps=1.42 nrd=0.69047619047619  nrs=0.69047619047619 sa=0 sb=0 sd=0 mult=1 m=1
csn_c1_r050_0650_2_1 sn_c1_r050_0650_2_1 0 {C_SN}
XMWR_c1_r050_0650_2_2 sn_c1_r050_0650_2_2 0 0 0 sky130_fd_pr__nfet_01v8 L=0.15 W=0.42 nf=1 ad=0.1218 as=0.1218 pd=1.42 ps=1.42 nrd=0.69047619047619  nrs=0.69047619047619 sa=0 sb=0 sd=0 mult=1 m=1
XMRD_c1_r050_0650_2_2 rbl_c1_r050_0650_2 sn_c1_r050_0650_2_2 rwl_des 0 sky130_fd_pr__nfet_01v8 L=0.15 W=0.42 nf=1 ad=0.1218 as=0.1218 pd=1.42 ps=1.42 nrd=0.69047619047619  nrs=0.69047619047619 sa=0 sb=0 sd=0 mult=1 m=1
csn_c1_r050_0650_2_2 sn_c1_r050_0650_2_2 0 {C_SN}
XMWR_c1_r050_0650_2_3 sn_c1_r050_0650_2_3 0 0 0 sky130_fd_pr__nfet_01v8 L=0.15 W=0.42 nf=1 ad=0.1218 as=0.1218 pd=1.42 ps=1.42 nrd=0.69047619047619  nrs=0.69047619047619 sa=0 sb=0 sd=0 mult=1 m=1
XMRD_c1_r050_0650_2_3 rbl_c1_r050_0650_2 sn_c1_r050_0650_2_3 rwl_des 0 sky130_fd_pr__nfet_01v8 L=0.15 W=0.42 nf=1 ad=0.1218 as=0.1218 pd=1.42 ps=1.42 nrd=0.69047619047619  nrs=0.69047619047619 sa=0 sb=0 sd=0 mult=1 m=1
csn_c1_r050_0650_2_3 sn_c1_r050_0650_2_3 0 {C_SN}
crbl_c1_r050_0650_2 rbl_c1_r050_0650_2 0 {C_RBL}
spr_c1_r050_0650_2 pref_050 ref_c1_r050_0650_2 ctl 0 swpre
cref_c1_r050_0650_2 ref_c1_r050_0650_2 0 {C_RBL}   $ ASSUMPTION: ideal matched dummy load
XMN1_c1_r050_0650_2 rbl_c1_r050_0650_2 ref_c1_r050_0650_2 vn_c1_r050_0650_2 0 sky130_fd_pr__nfet_01v8 L=0.15 W=1 nf=1 ad=0.29 as=0.29 pd=2.58 ps=2.58 nrd=0.29 nrs=0.29 sa=0 sb=0 sd=0 mult=1 m=1
XMN2_c1_r050_0650_2 ref_c1_r050_0650_2 rbl_c1_r050_0650_2 vn_c1_r050_0650_2 0 sky130_fd_pr__nfet_01v8 L=0.15 W=1 nf=1 ad=0.29 as=0.29 pd=2.58 ps=2.58 nrd=0.29 nrs=0.29 sa=0 sb=0 sd=0 mult=1 m=1
XMP1_c1_r050_0650_2 rbl_c1_r050_0650_2 ref_c1_r050_0650_2 vp_c1_r050_0650_2 vdd sky130_fd_pr__pfet_01v8 L=0.15 W=2 nf=1 ad=0.58 as=0.58 pd=4.58 ps=4.58 nrd=0.145 nrs=0.145 sa=0 sb=0 sd=0 mult=1 m=1
XMP2_c1_r050_0650_2 ref_c1_r050_0650_2 rbl_c1_r050_0650_2 vp_c1_r050_0650_2 vdd sky130_fd_pr__pfet_01v8 L=0.15 W=2 nf=1 ad=0.58 as=0.58 pd=4.58 ps=4.58 nrd=0.145 nrs=0.145 sa=0 sb=0 sd=0 mult=1 m=1
XMNF_c1_r050_0650_2 vn_c1_r050_0650_2 en 0 0 sky130_fd_pr__nfet_01v8 L=0.15 W=2 nf=1 ad=0.58 as=0.58 pd=4.58 ps=4.58 nrd=0.145 nrs=0.145 sa=0 sb=0 sd=0 mult=1 m=1
XMPH_c1_r050_0650_2 vp_c1_r050_0650_2 enb vdd vdd sky130_fd_pr__pfet_01v8 L=0.15 W=4 nf=1 ad=1.16 as=1.16 pd=8.58 ps=8.58 nrd=0.0725 nrs=0.0725 sa=0 sb=0 sd=0 mult=1 m=1
bd_c1_r050_0650_2 d_c1_r050_0650_2 0 v=v(rbl_c1_r050_0650_2)-v(ref_c1_r050_0650_2)
bdabs_c1_r050_0650_2 dabs_c1_r050_0650_2 0 v=abs(v(rbl_c1_r050_0650_2)-v(ref_c1_r050_0650_2))

* ---- c1_r050_0650_3: cell1 SN = 0.65 V, ref offset 0.05 V, replica 3 ----
spa_c1_r050_0650_3 prea rbl_c1_r050_0650_3 ctl 0 swpre
XMWR_c1_r050_0650_3_0 sn_c1_r050_0650_3_0 0 0 0 sky130_fd_pr__nfet_01v8 L=0.15 W=0.42 nf=1 ad=0.1218 as=0.1218 pd=1.42 ps=1.42 nrd=0.69047619047619  nrs=0.69047619047619 sa=0 sb=0 sd=0 mult=1 m=1
XMRD_c1_r050_0650_3_0 rbl_c1_r050_0650_3 sn_c1_r050_0650_3_0 rwl_sel 0 sky130_fd_pr__nfet_01v8 L=0.15 W=0.42 nf=1 ad=0.1218 as=0.1218 pd=1.42 ps=1.42 nrd=0.69047619047619  nrs=0.69047619047619 sa=0 sb=0 sd=0 mult=1 m=1
csn_c1_r050_0650_3_0 sn_c1_r050_0650_3_0 0 {C_SN}
XMWR_c1_r050_0650_3_1 sn_c1_r050_0650_3_1 0 0 0 sky130_fd_pr__nfet_01v8 L=0.15 W=0.42 nf=1 ad=0.1218 as=0.1218 pd=1.42 ps=1.42 nrd=0.69047619047619  nrs=0.69047619047619 sa=0 sb=0 sd=0 mult=1 m=1
XMRD_c1_r050_0650_3_1 rbl_c1_r050_0650_3 sn_c1_r050_0650_3_1 rwl_des 0 sky130_fd_pr__nfet_01v8 L=0.15 W=0.42 nf=1 ad=0.1218 as=0.1218 pd=1.42 ps=1.42 nrd=0.69047619047619  nrs=0.69047619047619 sa=0 sb=0 sd=0 mult=1 m=1
csn_c1_r050_0650_3_1 sn_c1_r050_0650_3_1 0 {C_SN}
XMWR_c1_r050_0650_3_2 sn_c1_r050_0650_3_2 0 0 0 sky130_fd_pr__nfet_01v8 L=0.15 W=0.42 nf=1 ad=0.1218 as=0.1218 pd=1.42 ps=1.42 nrd=0.69047619047619  nrs=0.69047619047619 sa=0 sb=0 sd=0 mult=1 m=1
XMRD_c1_r050_0650_3_2 rbl_c1_r050_0650_3 sn_c1_r050_0650_3_2 rwl_des 0 sky130_fd_pr__nfet_01v8 L=0.15 W=0.42 nf=1 ad=0.1218 as=0.1218 pd=1.42 ps=1.42 nrd=0.69047619047619  nrs=0.69047619047619 sa=0 sb=0 sd=0 mult=1 m=1
csn_c1_r050_0650_3_2 sn_c1_r050_0650_3_2 0 {C_SN}
XMWR_c1_r050_0650_3_3 sn_c1_r050_0650_3_3 0 0 0 sky130_fd_pr__nfet_01v8 L=0.15 W=0.42 nf=1 ad=0.1218 as=0.1218 pd=1.42 ps=1.42 nrd=0.69047619047619  nrs=0.69047619047619 sa=0 sb=0 sd=0 mult=1 m=1
XMRD_c1_r050_0650_3_3 rbl_c1_r050_0650_3 sn_c1_r050_0650_3_3 rwl_des 0 sky130_fd_pr__nfet_01v8 L=0.15 W=0.42 nf=1 ad=0.1218 as=0.1218 pd=1.42 ps=1.42 nrd=0.69047619047619  nrs=0.69047619047619 sa=0 sb=0 sd=0 mult=1 m=1
csn_c1_r050_0650_3_3 sn_c1_r050_0650_3_3 0 {C_SN}
crbl_c1_r050_0650_3 rbl_c1_r050_0650_3 0 {C_RBL}
spr_c1_r050_0650_3 pref_050 ref_c1_r050_0650_3 ctl 0 swpre
cref_c1_r050_0650_3 ref_c1_r050_0650_3 0 {C_RBL}   $ ASSUMPTION: ideal matched dummy load
XMN1_c1_r050_0650_3 rbl_c1_r050_0650_3 ref_c1_r050_0650_3 vn_c1_r050_0650_3 0 sky130_fd_pr__nfet_01v8 L=0.15 W=1 nf=1 ad=0.29 as=0.29 pd=2.58 ps=2.58 nrd=0.29 nrs=0.29 sa=0 sb=0 sd=0 mult=1 m=1
XMN2_c1_r050_0650_3 ref_c1_r050_0650_3 rbl_c1_r050_0650_3 vn_c1_r050_0650_3 0 sky130_fd_pr__nfet_01v8 L=0.15 W=1 nf=1 ad=0.29 as=0.29 pd=2.58 ps=2.58 nrd=0.29 nrs=0.29 sa=0 sb=0 sd=0 mult=1 m=1
XMP1_c1_r050_0650_3 rbl_c1_r050_0650_3 ref_c1_r050_0650_3 vp_c1_r050_0650_3 vdd sky130_fd_pr__pfet_01v8 L=0.15 W=2 nf=1 ad=0.58 as=0.58 pd=4.58 ps=4.58 nrd=0.145 nrs=0.145 sa=0 sb=0 sd=0 mult=1 m=1
XMP2_c1_r050_0650_3 ref_c1_r050_0650_3 rbl_c1_r050_0650_3 vp_c1_r050_0650_3 vdd sky130_fd_pr__pfet_01v8 L=0.15 W=2 nf=1 ad=0.58 as=0.58 pd=4.58 ps=4.58 nrd=0.145 nrs=0.145 sa=0 sb=0 sd=0 mult=1 m=1
XMNF_c1_r050_0650_3 vn_c1_r050_0650_3 en 0 0 sky130_fd_pr__nfet_01v8 L=0.15 W=2 nf=1 ad=0.58 as=0.58 pd=4.58 ps=4.58 nrd=0.145 nrs=0.145 sa=0 sb=0 sd=0 mult=1 m=1
XMPH_c1_r050_0650_3 vp_c1_r050_0650_3 enb vdd vdd sky130_fd_pr__pfet_01v8 L=0.15 W=4 nf=1 ad=1.16 as=1.16 pd=8.58 ps=8.58 nrd=0.0725 nrs=0.0725 sa=0 sb=0 sd=0 mult=1 m=1
bd_c1_r050_0650_3 d_c1_r050_0650_3 0 v=v(rbl_c1_r050_0650_3)-v(ref_c1_r050_0650_3)
bdabs_c1_r050_0650_3 dabs_c1_r050_0650_3 0 v=abs(v(rbl_c1_r050_0650_3)-v(ref_c1_r050_0650_3))

* ---- c1_r050_0700_0: cell1 SN = 0.7 V, ref offset 0.05 V, replica 0 ----
spa_c1_r050_0700_0 prea rbl_c1_r050_0700_0 ctl 0 swpre
XMWR_c1_r050_0700_0_0 sn_c1_r050_0700_0_0 0 0 0 sky130_fd_pr__nfet_01v8 L=0.15 W=0.42 nf=1 ad=0.1218 as=0.1218 pd=1.42 ps=1.42 nrd=0.69047619047619  nrs=0.69047619047619 sa=0 sb=0 sd=0 mult=1 m=1
XMRD_c1_r050_0700_0_0 rbl_c1_r050_0700_0 sn_c1_r050_0700_0_0 rwl_sel 0 sky130_fd_pr__nfet_01v8 L=0.15 W=0.42 nf=1 ad=0.1218 as=0.1218 pd=1.42 ps=1.42 nrd=0.69047619047619  nrs=0.69047619047619 sa=0 sb=0 sd=0 mult=1 m=1
csn_c1_r050_0700_0_0 sn_c1_r050_0700_0_0 0 {C_SN}
XMWR_c1_r050_0700_0_1 sn_c1_r050_0700_0_1 0 0 0 sky130_fd_pr__nfet_01v8 L=0.15 W=0.42 nf=1 ad=0.1218 as=0.1218 pd=1.42 ps=1.42 nrd=0.69047619047619  nrs=0.69047619047619 sa=0 sb=0 sd=0 mult=1 m=1
XMRD_c1_r050_0700_0_1 rbl_c1_r050_0700_0 sn_c1_r050_0700_0_1 rwl_des 0 sky130_fd_pr__nfet_01v8 L=0.15 W=0.42 nf=1 ad=0.1218 as=0.1218 pd=1.42 ps=1.42 nrd=0.69047619047619  nrs=0.69047619047619 sa=0 sb=0 sd=0 mult=1 m=1
csn_c1_r050_0700_0_1 sn_c1_r050_0700_0_1 0 {C_SN}
XMWR_c1_r050_0700_0_2 sn_c1_r050_0700_0_2 0 0 0 sky130_fd_pr__nfet_01v8 L=0.15 W=0.42 nf=1 ad=0.1218 as=0.1218 pd=1.42 ps=1.42 nrd=0.69047619047619  nrs=0.69047619047619 sa=0 sb=0 sd=0 mult=1 m=1
XMRD_c1_r050_0700_0_2 rbl_c1_r050_0700_0 sn_c1_r050_0700_0_2 rwl_des 0 sky130_fd_pr__nfet_01v8 L=0.15 W=0.42 nf=1 ad=0.1218 as=0.1218 pd=1.42 ps=1.42 nrd=0.69047619047619  nrs=0.69047619047619 sa=0 sb=0 sd=0 mult=1 m=1
csn_c1_r050_0700_0_2 sn_c1_r050_0700_0_2 0 {C_SN}
XMWR_c1_r050_0700_0_3 sn_c1_r050_0700_0_3 0 0 0 sky130_fd_pr__nfet_01v8 L=0.15 W=0.42 nf=1 ad=0.1218 as=0.1218 pd=1.42 ps=1.42 nrd=0.69047619047619  nrs=0.69047619047619 sa=0 sb=0 sd=0 mult=1 m=1
XMRD_c1_r050_0700_0_3 rbl_c1_r050_0700_0 sn_c1_r050_0700_0_3 rwl_des 0 sky130_fd_pr__nfet_01v8 L=0.15 W=0.42 nf=1 ad=0.1218 as=0.1218 pd=1.42 ps=1.42 nrd=0.69047619047619  nrs=0.69047619047619 sa=0 sb=0 sd=0 mult=1 m=1
csn_c1_r050_0700_0_3 sn_c1_r050_0700_0_3 0 {C_SN}
crbl_c1_r050_0700_0 rbl_c1_r050_0700_0 0 {C_RBL}
spr_c1_r050_0700_0 pref_050 ref_c1_r050_0700_0 ctl 0 swpre
cref_c1_r050_0700_0 ref_c1_r050_0700_0 0 {C_RBL}   $ ASSUMPTION: ideal matched dummy load
XMN1_c1_r050_0700_0 rbl_c1_r050_0700_0 ref_c1_r050_0700_0 vn_c1_r050_0700_0 0 sky130_fd_pr__nfet_01v8 L=0.15 W=1 nf=1 ad=0.29 as=0.29 pd=2.58 ps=2.58 nrd=0.29 nrs=0.29 sa=0 sb=0 sd=0 mult=1 m=1
XMN2_c1_r050_0700_0 ref_c1_r050_0700_0 rbl_c1_r050_0700_0 vn_c1_r050_0700_0 0 sky130_fd_pr__nfet_01v8 L=0.15 W=1 nf=1 ad=0.29 as=0.29 pd=2.58 ps=2.58 nrd=0.29 nrs=0.29 sa=0 sb=0 sd=0 mult=1 m=1
XMP1_c1_r050_0700_0 rbl_c1_r050_0700_0 ref_c1_r050_0700_0 vp_c1_r050_0700_0 vdd sky130_fd_pr__pfet_01v8 L=0.15 W=2 nf=1 ad=0.58 as=0.58 pd=4.58 ps=4.58 nrd=0.145 nrs=0.145 sa=0 sb=0 sd=0 mult=1 m=1
XMP2_c1_r050_0700_0 ref_c1_r050_0700_0 rbl_c1_r050_0700_0 vp_c1_r050_0700_0 vdd sky130_fd_pr__pfet_01v8 L=0.15 W=2 nf=1 ad=0.58 as=0.58 pd=4.58 ps=4.58 nrd=0.145 nrs=0.145 sa=0 sb=0 sd=0 mult=1 m=1
XMNF_c1_r050_0700_0 vn_c1_r050_0700_0 en 0 0 sky130_fd_pr__nfet_01v8 L=0.15 W=2 nf=1 ad=0.58 as=0.58 pd=4.58 ps=4.58 nrd=0.145 nrs=0.145 sa=0 sb=0 sd=0 mult=1 m=1
XMPH_c1_r050_0700_0 vp_c1_r050_0700_0 enb vdd vdd sky130_fd_pr__pfet_01v8 L=0.15 W=4 nf=1 ad=1.16 as=1.16 pd=8.58 ps=8.58 nrd=0.0725 nrs=0.0725 sa=0 sb=0 sd=0 mult=1 m=1
bd_c1_r050_0700_0 d_c1_r050_0700_0 0 v=v(rbl_c1_r050_0700_0)-v(ref_c1_r050_0700_0)
bdabs_c1_r050_0700_0 dabs_c1_r050_0700_0 0 v=abs(v(rbl_c1_r050_0700_0)-v(ref_c1_r050_0700_0))

* ---- c1_r050_0700_1: cell1 SN = 0.7 V, ref offset 0.05 V, replica 1 ----
spa_c1_r050_0700_1 prea rbl_c1_r050_0700_1 ctl 0 swpre
XMWR_c1_r050_0700_1_0 sn_c1_r050_0700_1_0 0 0 0 sky130_fd_pr__nfet_01v8 L=0.15 W=0.42 nf=1 ad=0.1218 as=0.1218 pd=1.42 ps=1.42 nrd=0.69047619047619  nrs=0.69047619047619 sa=0 sb=0 sd=0 mult=1 m=1
XMRD_c1_r050_0700_1_0 rbl_c1_r050_0700_1 sn_c1_r050_0700_1_0 rwl_sel 0 sky130_fd_pr__nfet_01v8 L=0.15 W=0.42 nf=1 ad=0.1218 as=0.1218 pd=1.42 ps=1.42 nrd=0.69047619047619  nrs=0.69047619047619 sa=0 sb=0 sd=0 mult=1 m=1
csn_c1_r050_0700_1_0 sn_c1_r050_0700_1_0 0 {C_SN}
XMWR_c1_r050_0700_1_1 sn_c1_r050_0700_1_1 0 0 0 sky130_fd_pr__nfet_01v8 L=0.15 W=0.42 nf=1 ad=0.1218 as=0.1218 pd=1.42 ps=1.42 nrd=0.69047619047619  nrs=0.69047619047619 sa=0 sb=0 sd=0 mult=1 m=1
XMRD_c1_r050_0700_1_1 rbl_c1_r050_0700_1 sn_c1_r050_0700_1_1 rwl_des 0 sky130_fd_pr__nfet_01v8 L=0.15 W=0.42 nf=1 ad=0.1218 as=0.1218 pd=1.42 ps=1.42 nrd=0.69047619047619  nrs=0.69047619047619 sa=0 sb=0 sd=0 mult=1 m=1
csn_c1_r050_0700_1_1 sn_c1_r050_0700_1_1 0 {C_SN}
XMWR_c1_r050_0700_1_2 sn_c1_r050_0700_1_2 0 0 0 sky130_fd_pr__nfet_01v8 L=0.15 W=0.42 nf=1 ad=0.1218 as=0.1218 pd=1.42 ps=1.42 nrd=0.69047619047619  nrs=0.69047619047619 sa=0 sb=0 sd=0 mult=1 m=1
XMRD_c1_r050_0700_1_2 rbl_c1_r050_0700_1 sn_c1_r050_0700_1_2 rwl_des 0 sky130_fd_pr__nfet_01v8 L=0.15 W=0.42 nf=1 ad=0.1218 as=0.1218 pd=1.42 ps=1.42 nrd=0.69047619047619  nrs=0.69047619047619 sa=0 sb=0 sd=0 mult=1 m=1
csn_c1_r050_0700_1_2 sn_c1_r050_0700_1_2 0 {C_SN}
XMWR_c1_r050_0700_1_3 sn_c1_r050_0700_1_3 0 0 0 sky130_fd_pr__nfet_01v8 L=0.15 W=0.42 nf=1 ad=0.1218 as=0.1218 pd=1.42 ps=1.42 nrd=0.69047619047619  nrs=0.69047619047619 sa=0 sb=0 sd=0 mult=1 m=1
XMRD_c1_r050_0700_1_3 rbl_c1_r050_0700_1 sn_c1_r050_0700_1_3 rwl_des 0 sky130_fd_pr__nfet_01v8 L=0.15 W=0.42 nf=1 ad=0.1218 as=0.1218 pd=1.42 ps=1.42 nrd=0.69047619047619  nrs=0.69047619047619 sa=0 sb=0 sd=0 mult=1 m=1
csn_c1_r050_0700_1_3 sn_c1_r050_0700_1_3 0 {C_SN}
crbl_c1_r050_0700_1 rbl_c1_r050_0700_1 0 {C_RBL}
spr_c1_r050_0700_1 pref_050 ref_c1_r050_0700_1 ctl 0 swpre
cref_c1_r050_0700_1 ref_c1_r050_0700_1 0 {C_RBL}   $ ASSUMPTION: ideal matched dummy load
XMN1_c1_r050_0700_1 rbl_c1_r050_0700_1 ref_c1_r050_0700_1 vn_c1_r050_0700_1 0 sky130_fd_pr__nfet_01v8 L=0.15 W=1 nf=1 ad=0.29 as=0.29 pd=2.58 ps=2.58 nrd=0.29 nrs=0.29 sa=0 sb=0 sd=0 mult=1 m=1
XMN2_c1_r050_0700_1 ref_c1_r050_0700_1 rbl_c1_r050_0700_1 vn_c1_r050_0700_1 0 sky130_fd_pr__nfet_01v8 L=0.15 W=1 nf=1 ad=0.29 as=0.29 pd=2.58 ps=2.58 nrd=0.29 nrs=0.29 sa=0 sb=0 sd=0 mult=1 m=1
XMP1_c1_r050_0700_1 rbl_c1_r050_0700_1 ref_c1_r050_0700_1 vp_c1_r050_0700_1 vdd sky130_fd_pr__pfet_01v8 L=0.15 W=2 nf=1 ad=0.58 as=0.58 pd=4.58 ps=4.58 nrd=0.145 nrs=0.145 sa=0 sb=0 sd=0 mult=1 m=1
XMP2_c1_r050_0700_1 ref_c1_r050_0700_1 rbl_c1_r050_0700_1 vp_c1_r050_0700_1 vdd sky130_fd_pr__pfet_01v8 L=0.15 W=2 nf=1 ad=0.58 as=0.58 pd=4.58 ps=4.58 nrd=0.145 nrs=0.145 sa=0 sb=0 sd=0 mult=1 m=1
XMNF_c1_r050_0700_1 vn_c1_r050_0700_1 en 0 0 sky130_fd_pr__nfet_01v8 L=0.15 W=2 nf=1 ad=0.58 as=0.58 pd=4.58 ps=4.58 nrd=0.145 nrs=0.145 sa=0 sb=0 sd=0 mult=1 m=1
XMPH_c1_r050_0700_1 vp_c1_r050_0700_1 enb vdd vdd sky130_fd_pr__pfet_01v8 L=0.15 W=4 nf=1 ad=1.16 as=1.16 pd=8.58 ps=8.58 nrd=0.0725 nrs=0.0725 sa=0 sb=0 sd=0 mult=1 m=1
bd_c1_r050_0700_1 d_c1_r050_0700_1 0 v=v(rbl_c1_r050_0700_1)-v(ref_c1_r050_0700_1)
bdabs_c1_r050_0700_1 dabs_c1_r050_0700_1 0 v=abs(v(rbl_c1_r050_0700_1)-v(ref_c1_r050_0700_1))

* ---- c1_r050_0700_2: cell1 SN = 0.7 V, ref offset 0.05 V, replica 2 ----
spa_c1_r050_0700_2 prea rbl_c1_r050_0700_2 ctl 0 swpre
XMWR_c1_r050_0700_2_0 sn_c1_r050_0700_2_0 0 0 0 sky130_fd_pr__nfet_01v8 L=0.15 W=0.42 nf=1 ad=0.1218 as=0.1218 pd=1.42 ps=1.42 nrd=0.69047619047619  nrs=0.69047619047619 sa=0 sb=0 sd=0 mult=1 m=1
XMRD_c1_r050_0700_2_0 rbl_c1_r050_0700_2 sn_c1_r050_0700_2_0 rwl_sel 0 sky130_fd_pr__nfet_01v8 L=0.15 W=0.42 nf=1 ad=0.1218 as=0.1218 pd=1.42 ps=1.42 nrd=0.69047619047619  nrs=0.69047619047619 sa=0 sb=0 sd=0 mult=1 m=1
csn_c1_r050_0700_2_0 sn_c1_r050_0700_2_0 0 {C_SN}
XMWR_c1_r050_0700_2_1 sn_c1_r050_0700_2_1 0 0 0 sky130_fd_pr__nfet_01v8 L=0.15 W=0.42 nf=1 ad=0.1218 as=0.1218 pd=1.42 ps=1.42 nrd=0.69047619047619  nrs=0.69047619047619 sa=0 sb=0 sd=0 mult=1 m=1
XMRD_c1_r050_0700_2_1 rbl_c1_r050_0700_2 sn_c1_r050_0700_2_1 rwl_des 0 sky130_fd_pr__nfet_01v8 L=0.15 W=0.42 nf=1 ad=0.1218 as=0.1218 pd=1.42 ps=1.42 nrd=0.69047619047619  nrs=0.69047619047619 sa=0 sb=0 sd=0 mult=1 m=1
csn_c1_r050_0700_2_1 sn_c1_r050_0700_2_1 0 {C_SN}
XMWR_c1_r050_0700_2_2 sn_c1_r050_0700_2_2 0 0 0 sky130_fd_pr__nfet_01v8 L=0.15 W=0.42 nf=1 ad=0.1218 as=0.1218 pd=1.42 ps=1.42 nrd=0.69047619047619  nrs=0.69047619047619 sa=0 sb=0 sd=0 mult=1 m=1
XMRD_c1_r050_0700_2_2 rbl_c1_r050_0700_2 sn_c1_r050_0700_2_2 rwl_des 0 sky130_fd_pr__nfet_01v8 L=0.15 W=0.42 nf=1 ad=0.1218 as=0.1218 pd=1.42 ps=1.42 nrd=0.69047619047619  nrs=0.69047619047619 sa=0 sb=0 sd=0 mult=1 m=1
csn_c1_r050_0700_2_2 sn_c1_r050_0700_2_2 0 {C_SN}
XMWR_c1_r050_0700_2_3 sn_c1_r050_0700_2_3 0 0 0 sky130_fd_pr__nfet_01v8 L=0.15 W=0.42 nf=1 ad=0.1218 as=0.1218 pd=1.42 ps=1.42 nrd=0.69047619047619  nrs=0.69047619047619 sa=0 sb=0 sd=0 mult=1 m=1
XMRD_c1_r050_0700_2_3 rbl_c1_r050_0700_2 sn_c1_r050_0700_2_3 rwl_des 0 sky130_fd_pr__nfet_01v8 L=0.15 W=0.42 nf=1 ad=0.1218 as=0.1218 pd=1.42 ps=1.42 nrd=0.69047619047619  nrs=0.69047619047619 sa=0 sb=0 sd=0 mult=1 m=1
csn_c1_r050_0700_2_3 sn_c1_r050_0700_2_3 0 {C_SN}
crbl_c1_r050_0700_2 rbl_c1_r050_0700_2 0 {C_RBL}
spr_c1_r050_0700_2 pref_050 ref_c1_r050_0700_2 ctl 0 swpre
cref_c1_r050_0700_2 ref_c1_r050_0700_2 0 {C_RBL}   $ ASSUMPTION: ideal matched dummy load
XMN1_c1_r050_0700_2 rbl_c1_r050_0700_2 ref_c1_r050_0700_2 vn_c1_r050_0700_2 0 sky130_fd_pr__nfet_01v8 L=0.15 W=1 nf=1 ad=0.29 as=0.29 pd=2.58 ps=2.58 nrd=0.29 nrs=0.29 sa=0 sb=0 sd=0 mult=1 m=1
XMN2_c1_r050_0700_2 ref_c1_r050_0700_2 rbl_c1_r050_0700_2 vn_c1_r050_0700_2 0 sky130_fd_pr__nfet_01v8 L=0.15 W=1 nf=1 ad=0.29 as=0.29 pd=2.58 ps=2.58 nrd=0.29 nrs=0.29 sa=0 sb=0 sd=0 mult=1 m=1
XMP1_c1_r050_0700_2 rbl_c1_r050_0700_2 ref_c1_r050_0700_2 vp_c1_r050_0700_2 vdd sky130_fd_pr__pfet_01v8 L=0.15 W=2 nf=1 ad=0.58 as=0.58 pd=4.58 ps=4.58 nrd=0.145 nrs=0.145 sa=0 sb=0 sd=0 mult=1 m=1
XMP2_c1_r050_0700_2 ref_c1_r050_0700_2 rbl_c1_r050_0700_2 vp_c1_r050_0700_2 vdd sky130_fd_pr__pfet_01v8 L=0.15 W=2 nf=1 ad=0.58 as=0.58 pd=4.58 ps=4.58 nrd=0.145 nrs=0.145 sa=0 sb=0 sd=0 mult=1 m=1
XMNF_c1_r050_0700_2 vn_c1_r050_0700_2 en 0 0 sky130_fd_pr__nfet_01v8 L=0.15 W=2 nf=1 ad=0.58 as=0.58 pd=4.58 ps=4.58 nrd=0.145 nrs=0.145 sa=0 sb=0 sd=0 mult=1 m=1
XMPH_c1_r050_0700_2 vp_c1_r050_0700_2 enb vdd vdd sky130_fd_pr__pfet_01v8 L=0.15 W=4 nf=1 ad=1.16 as=1.16 pd=8.58 ps=8.58 nrd=0.0725 nrs=0.0725 sa=0 sb=0 sd=0 mult=1 m=1
bd_c1_r050_0700_2 d_c1_r050_0700_2 0 v=v(rbl_c1_r050_0700_2)-v(ref_c1_r050_0700_2)
bdabs_c1_r050_0700_2 dabs_c1_r050_0700_2 0 v=abs(v(rbl_c1_r050_0700_2)-v(ref_c1_r050_0700_2))

* ---- c1_r050_0700_3: cell1 SN = 0.7 V, ref offset 0.05 V, replica 3 ----
spa_c1_r050_0700_3 prea rbl_c1_r050_0700_3 ctl 0 swpre
XMWR_c1_r050_0700_3_0 sn_c1_r050_0700_3_0 0 0 0 sky130_fd_pr__nfet_01v8 L=0.15 W=0.42 nf=1 ad=0.1218 as=0.1218 pd=1.42 ps=1.42 nrd=0.69047619047619  nrs=0.69047619047619 sa=0 sb=0 sd=0 mult=1 m=1
XMRD_c1_r050_0700_3_0 rbl_c1_r050_0700_3 sn_c1_r050_0700_3_0 rwl_sel 0 sky130_fd_pr__nfet_01v8 L=0.15 W=0.42 nf=1 ad=0.1218 as=0.1218 pd=1.42 ps=1.42 nrd=0.69047619047619  nrs=0.69047619047619 sa=0 sb=0 sd=0 mult=1 m=1
csn_c1_r050_0700_3_0 sn_c1_r050_0700_3_0 0 {C_SN}
XMWR_c1_r050_0700_3_1 sn_c1_r050_0700_3_1 0 0 0 sky130_fd_pr__nfet_01v8 L=0.15 W=0.42 nf=1 ad=0.1218 as=0.1218 pd=1.42 ps=1.42 nrd=0.69047619047619  nrs=0.69047619047619 sa=0 sb=0 sd=0 mult=1 m=1
XMRD_c1_r050_0700_3_1 rbl_c1_r050_0700_3 sn_c1_r050_0700_3_1 rwl_des 0 sky130_fd_pr__nfet_01v8 L=0.15 W=0.42 nf=1 ad=0.1218 as=0.1218 pd=1.42 ps=1.42 nrd=0.69047619047619  nrs=0.69047619047619 sa=0 sb=0 sd=0 mult=1 m=1
csn_c1_r050_0700_3_1 sn_c1_r050_0700_3_1 0 {C_SN}
XMWR_c1_r050_0700_3_2 sn_c1_r050_0700_3_2 0 0 0 sky130_fd_pr__nfet_01v8 L=0.15 W=0.42 nf=1 ad=0.1218 as=0.1218 pd=1.42 ps=1.42 nrd=0.69047619047619  nrs=0.69047619047619 sa=0 sb=0 sd=0 mult=1 m=1
XMRD_c1_r050_0700_3_2 rbl_c1_r050_0700_3 sn_c1_r050_0700_3_2 rwl_des 0 sky130_fd_pr__nfet_01v8 L=0.15 W=0.42 nf=1 ad=0.1218 as=0.1218 pd=1.42 ps=1.42 nrd=0.69047619047619  nrs=0.69047619047619 sa=0 sb=0 sd=0 mult=1 m=1
csn_c1_r050_0700_3_2 sn_c1_r050_0700_3_2 0 {C_SN}
XMWR_c1_r050_0700_3_3 sn_c1_r050_0700_3_3 0 0 0 sky130_fd_pr__nfet_01v8 L=0.15 W=0.42 nf=1 ad=0.1218 as=0.1218 pd=1.42 ps=1.42 nrd=0.69047619047619  nrs=0.69047619047619 sa=0 sb=0 sd=0 mult=1 m=1
XMRD_c1_r050_0700_3_3 rbl_c1_r050_0700_3 sn_c1_r050_0700_3_3 rwl_des 0 sky130_fd_pr__nfet_01v8 L=0.15 W=0.42 nf=1 ad=0.1218 as=0.1218 pd=1.42 ps=1.42 nrd=0.69047619047619  nrs=0.69047619047619 sa=0 sb=0 sd=0 mult=1 m=1
csn_c1_r050_0700_3_3 sn_c1_r050_0700_3_3 0 {C_SN}
crbl_c1_r050_0700_3 rbl_c1_r050_0700_3 0 {C_RBL}
spr_c1_r050_0700_3 pref_050 ref_c1_r050_0700_3 ctl 0 swpre
cref_c1_r050_0700_3 ref_c1_r050_0700_3 0 {C_RBL}   $ ASSUMPTION: ideal matched dummy load
XMN1_c1_r050_0700_3 rbl_c1_r050_0700_3 ref_c1_r050_0700_3 vn_c1_r050_0700_3 0 sky130_fd_pr__nfet_01v8 L=0.15 W=1 nf=1 ad=0.29 as=0.29 pd=2.58 ps=2.58 nrd=0.29 nrs=0.29 sa=0 sb=0 sd=0 mult=1 m=1
XMN2_c1_r050_0700_3 ref_c1_r050_0700_3 rbl_c1_r050_0700_3 vn_c1_r050_0700_3 0 sky130_fd_pr__nfet_01v8 L=0.15 W=1 nf=1 ad=0.29 as=0.29 pd=2.58 ps=2.58 nrd=0.29 nrs=0.29 sa=0 sb=0 sd=0 mult=1 m=1
XMP1_c1_r050_0700_3 rbl_c1_r050_0700_3 ref_c1_r050_0700_3 vp_c1_r050_0700_3 vdd sky130_fd_pr__pfet_01v8 L=0.15 W=2 nf=1 ad=0.58 as=0.58 pd=4.58 ps=4.58 nrd=0.145 nrs=0.145 sa=0 sb=0 sd=0 mult=1 m=1
XMP2_c1_r050_0700_3 ref_c1_r050_0700_3 rbl_c1_r050_0700_3 vp_c1_r050_0700_3 vdd sky130_fd_pr__pfet_01v8 L=0.15 W=2 nf=1 ad=0.58 as=0.58 pd=4.58 ps=4.58 nrd=0.145 nrs=0.145 sa=0 sb=0 sd=0 mult=1 m=1
XMNF_c1_r050_0700_3 vn_c1_r050_0700_3 en 0 0 sky130_fd_pr__nfet_01v8 L=0.15 W=2 nf=1 ad=0.58 as=0.58 pd=4.58 ps=4.58 nrd=0.145 nrs=0.145 sa=0 sb=0 sd=0 mult=1 m=1
XMPH_c1_r050_0700_3 vp_c1_r050_0700_3 enb vdd vdd sky130_fd_pr__pfet_01v8 L=0.15 W=4 nf=1 ad=1.16 as=1.16 pd=8.58 ps=8.58 nrd=0.0725 nrs=0.0725 sa=0 sb=0 sd=0 mult=1 m=1
bd_c1_r050_0700_3 d_c1_r050_0700_3 0 v=v(rbl_c1_r050_0700_3)-v(ref_c1_r050_0700_3)
bdabs_c1_r050_0700_3 dabs_c1_r050_0700_3 0 v=abs(v(rbl_c1_r050_0700_3)-v(ref_c1_r050_0700_3))

* ---- c1_r050_0750_0: cell1 SN = 0.75 V, ref offset 0.05 V, replica 0 ----
spa_c1_r050_0750_0 prea rbl_c1_r050_0750_0 ctl 0 swpre
XMWR_c1_r050_0750_0_0 sn_c1_r050_0750_0_0 0 0 0 sky130_fd_pr__nfet_01v8 L=0.15 W=0.42 nf=1 ad=0.1218 as=0.1218 pd=1.42 ps=1.42 nrd=0.69047619047619  nrs=0.69047619047619 sa=0 sb=0 sd=0 mult=1 m=1
XMRD_c1_r050_0750_0_0 rbl_c1_r050_0750_0 sn_c1_r050_0750_0_0 rwl_sel 0 sky130_fd_pr__nfet_01v8 L=0.15 W=0.42 nf=1 ad=0.1218 as=0.1218 pd=1.42 ps=1.42 nrd=0.69047619047619  nrs=0.69047619047619 sa=0 sb=0 sd=0 mult=1 m=1
csn_c1_r050_0750_0_0 sn_c1_r050_0750_0_0 0 {C_SN}
XMWR_c1_r050_0750_0_1 sn_c1_r050_0750_0_1 0 0 0 sky130_fd_pr__nfet_01v8 L=0.15 W=0.42 nf=1 ad=0.1218 as=0.1218 pd=1.42 ps=1.42 nrd=0.69047619047619  nrs=0.69047619047619 sa=0 sb=0 sd=0 mult=1 m=1
XMRD_c1_r050_0750_0_1 rbl_c1_r050_0750_0 sn_c1_r050_0750_0_1 rwl_des 0 sky130_fd_pr__nfet_01v8 L=0.15 W=0.42 nf=1 ad=0.1218 as=0.1218 pd=1.42 ps=1.42 nrd=0.69047619047619  nrs=0.69047619047619 sa=0 sb=0 sd=0 mult=1 m=1
csn_c1_r050_0750_0_1 sn_c1_r050_0750_0_1 0 {C_SN}
XMWR_c1_r050_0750_0_2 sn_c1_r050_0750_0_2 0 0 0 sky130_fd_pr__nfet_01v8 L=0.15 W=0.42 nf=1 ad=0.1218 as=0.1218 pd=1.42 ps=1.42 nrd=0.69047619047619  nrs=0.69047619047619 sa=0 sb=0 sd=0 mult=1 m=1
XMRD_c1_r050_0750_0_2 rbl_c1_r050_0750_0 sn_c1_r050_0750_0_2 rwl_des 0 sky130_fd_pr__nfet_01v8 L=0.15 W=0.42 nf=1 ad=0.1218 as=0.1218 pd=1.42 ps=1.42 nrd=0.69047619047619  nrs=0.69047619047619 sa=0 sb=0 sd=0 mult=1 m=1
csn_c1_r050_0750_0_2 sn_c1_r050_0750_0_2 0 {C_SN}
XMWR_c1_r050_0750_0_3 sn_c1_r050_0750_0_3 0 0 0 sky130_fd_pr__nfet_01v8 L=0.15 W=0.42 nf=1 ad=0.1218 as=0.1218 pd=1.42 ps=1.42 nrd=0.69047619047619  nrs=0.69047619047619 sa=0 sb=0 sd=0 mult=1 m=1
XMRD_c1_r050_0750_0_3 rbl_c1_r050_0750_0 sn_c1_r050_0750_0_3 rwl_des 0 sky130_fd_pr__nfet_01v8 L=0.15 W=0.42 nf=1 ad=0.1218 as=0.1218 pd=1.42 ps=1.42 nrd=0.69047619047619  nrs=0.69047619047619 sa=0 sb=0 sd=0 mult=1 m=1
csn_c1_r050_0750_0_3 sn_c1_r050_0750_0_3 0 {C_SN}
crbl_c1_r050_0750_0 rbl_c1_r050_0750_0 0 {C_RBL}
spr_c1_r050_0750_0 pref_050 ref_c1_r050_0750_0 ctl 0 swpre
cref_c1_r050_0750_0 ref_c1_r050_0750_0 0 {C_RBL}   $ ASSUMPTION: ideal matched dummy load
XMN1_c1_r050_0750_0 rbl_c1_r050_0750_0 ref_c1_r050_0750_0 vn_c1_r050_0750_0 0 sky130_fd_pr__nfet_01v8 L=0.15 W=1 nf=1 ad=0.29 as=0.29 pd=2.58 ps=2.58 nrd=0.29 nrs=0.29 sa=0 sb=0 sd=0 mult=1 m=1
XMN2_c1_r050_0750_0 ref_c1_r050_0750_0 rbl_c1_r050_0750_0 vn_c1_r050_0750_0 0 sky130_fd_pr__nfet_01v8 L=0.15 W=1 nf=1 ad=0.29 as=0.29 pd=2.58 ps=2.58 nrd=0.29 nrs=0.29 sa=0 sb=0 sd=0 mult=1 m=1
XMP1_c1_r050_0750_0 rbl_c1_r050_0750_0 ref_c1_r050_0750_0 vp_c1_r050_0750_0 vdd sky130_fd_pr__pfet_01v8 L=0.15 W=2 nf=1 ad=0.58 as=0.58 pd=4.58 ps=4.58 nrd=0.145 nrs=0.145 sa=0 sb=0 sd=0 mult=1 m=1
XMP2_c1_r050_0750_0 ref_c1_r050_0750_0 rbl_c1_r050_0750_0 vp_c1_r050_0750_0 vdd sky130_fd_pr__pfet_01v8 L=0.15 W=2 nf=1 ad=0.58 as=0.58 pd=4.58 ps=4.58 nrd=0.145 nrs=0.145 sa=0 sb=0 sd=0 mult=1 m=1
XMNF_c1_r050_0750_0 vn_c1_r050_0750_0 en 0 0 sky130_fd_pr__nfet_01v8 L=0.15 W=2 nf=1 ad=0.58 as=0.58 pd=4.58 ps=4.58 nrd=0.145 nrs=0.145 sa=0 sb=0 sd=0 mult=1 m=1
XMPH_c1_r050_0750_0 vp_c1_r050_0750_0 enb vdd vdd sky130_fd_pr__pfet_01v8 L=0.15 W=4 nf=1 ad=1.16 as=1.16 pd=8.58 ps=8.58 nrd=0.0725 nrs=0.0725 sa=0 sb=0 sd=0 mult=1 m=1
bd_c1_r050_0750_0 d_c1_r050_0750_0 0 v=v(rbl_c1_r050_0750_0)-v(ref_c1_r050_0750_0)
bdabs_c1_r050_0750_0 dabs_c1_r050_0750_0 0 v=abs(v(rbl_c1_r050_0750_0)-v(ref_c1_r050_0750_0))

* ---- c1_r050_0750_1: cell1 SN = 0.75 V, ref offset 0.05 V, replica 1 ----
spa_c1_r050_0750_1 prea rbl_c1_r050_0750_1 ctl 0 swpre
XMWR_c1_r050_0750_1_0 sn_c1_r050_0750_1_0 0 0 0 sky130_fd_pr__nfet_01v8 L=0.15 W=0.42 nf=1 ad=0.1218 as=0.1218 pd=1.42 ps=1.42 nrd=0.69047619047619  nrs=0.69047619047619 sa=0 sb=0 sd=0 mult=1 m=1
XMRD_c1_r050_0750_1_0 rbl_c1_r050_0750_1 sn_c1_r050_0750_1_0 rwl_sel 0 sky130_fd_pr__nfet_01v8 L=0.15 W=0.42 nf=1 ad=0.1218 as=0.1218 pd=1.42 ps=1.42 nrd=0.69047619047619  nrs=0.69047619047619 sa=0 sb=0 sd=0 mult=1 m=1
csn_c1_r050_0750_1_0 sn_c1_r050_0750_1_0 0 {C_SN}
XMWR_c1_r050_0750_1_1 sn_c1_r050_0750_1_1 0 0 0 sky130_fd_pr__nfet_01v8 L=0.15 W=0.42 nf=1 ad=0.1218 as=0.1218 pd=1.42 ps=1.42 nrd=0.69047619047619  nrs=0.69047619047619 sa=0 sb=0 sd=0 mult=1 m=1
XMRD_c1_r050_0750_1_1 rbl_c1_r050_0750_1 sn_c1_r050_0750_1_1 rwl_des 0 sky130_fd_pr__nfet_01v8 L=0.15 W=0.42 nf=1 ad=0.1218 as=0.1218 pd=1.42 ps=1.42 nrd=0.69047619047619  nrs=0.69047619047619 sa=0 sb=0 sd=0 mult=1 m=1
csn_c1_r050_0750_1_1 sn_c1_r050_0750_1_1 0 {C_SN}
XMWR_c1_r050_0750_1_2 sn_c1_r050_0750_1_2 0 0 0 sky130_fd_pr__nfet_01v8 L=0.15 W=0.42 nf=1 ad=0.1218 as=0.1218 pd=1.42 ps=1.42 nrd=0.69047619047619  nrs=0.69047619047619 sa=0 sb=0 sd=0 mult=1 m=1
XMRD_c1_r050_0750_1_2 rbl_c1_r050_0750_1 sn_c1_r050_0750_1_2 rwl_des 0 sky130_fd_pr__nfet_01v8 L=0.15 W=0.42 nf=1 ad=0.1218 as=0.1218 pd=1.42 ps=1.42 nrd=0.69047619047619  nrs=0.69047619047619 sa=0 sb=0 sd=0 mult=1 m=1
csn_c1_r050_0750_1_2 sn_c1_r050_0750_1_2 0 {C_SN}
XMWR_c1_r050_0750_1_3 sn_c1_r050_0750_1_3 0 0 0 sky130_fd_pr__nfet_01v8 L=0.15 W=0.42 nf=1 ad=0.1218 as=0.1218 pd=1.42 ps=1.42 nrd=0.69047619047619  nrs=0.69047619047619 sa=0 sb=0 sd=0 mult=1 m=1
XMRD_c1_r050_0750_1_3 rbl_c1_r050_0750_1 sn_c1_r050_0750_1_3 rwl_des 0 sky130_fd_pr__nfet_01v8 L=0.15 W=0.42 nf=1 ad=0.1218 as=0.1218 pd=1.42 ps=1.42 nrd=0.69047619047619  nrs=0.69047619047619 sa=0 sb=0 sd=0 mult=1 m=1
csn_c1_r050_0750_1_3 sn_c1_r050_0750_1_3 0 {C_SN}
crbl_c1_r050_0750_1 rbl_c1_r050_0750_1 0 {C_RBL}
spr_c1_r050_0750_1 pref_050 ref_c1_r050_0750_1 ctl 0 swpre
cref_c1_r050_0750_1 ref_c1_r050_0750_1 0 {C_RBL}   $ ASSUMPTION: ideal matched dummy load
XMN1_c1_r050_0750_1 rbl_c1_r050_0750_1 ref_c1_r050_0750_1 vn_c1_r050_0750_1 0 sky130_fd_pr__nfet_01v8 L=0.15 W=1 nf=1 ad=0.29 as=0.29 pd=2.58 ps=2.58 nrd=0.29 nrs=0.29 sa=0 sb=0 sd=0 mult=1 m=1
XMN2_c1_r050_0750_1 ref_c1_r050_0750_1 rbl_c1_r050_0750_1 vn_c1_r050_0750_1 0 sky130_fd_pr__nfet_01v8 L=0.15 W=1 nf=1 ad=0.29 as=0.29 pd=2.58 ps=2.58 nrd=0.29 nrs=0.29 sa=0 sb=0 sd=0 mult=1 m=1
XMP1_c1_r050_0750_1 rbl_c1_r050_0750_1 ref_c1_r050_0750_1 vp_c1_r050_0750_1 vdd sky130_fd_pr__pfet_01v8 L=0.15 W=2 nf=1 ad=0.58 as=0.58 pd=4.58 ps=4.58 nrd=0.145 nrs=0.145 sa=0 sb=0 sd=0 mult=1 m=1
XMP2_c1_r050_0750_1 ref_c1_r050_0750_1 rbl_c1_r050_0750_1 vp_c1_r050_0750_1 vdd sky130_fd_pr__pfet_01v8 L=0.15 W=2 nf=1 ad=0.58 as=0.58 pd=4.58 ps=4.58 nrd=0.145 nrs=0.145 sa=0 sb=0 sd=0 mult=1 m=1
XMNF_c1_r050_0750_1 vn_c1_r050_0750_1 en 0 0 sky130_fd_pr__nfet_01v8 L=0.15 W=2 nf=1 ad=0.58 as=0.58 pd=4.58 ps=4.58 nrd=0.145 nrs=0.145 sa=0 sb=0 sd=0 mult=1 m=1
XMPH_c1_r050_0750_1 vp_c1_r050_0750_1 enb vdd vdd sky130_fd_pr__pfet_01v8 L=0.15 W=4 nf=1 ad=1.16 as=1.16 pd=8.58 ps=8.58 nrd=0.0725 nrs=0.0725 sa=0 sb=0 sd=0 mult=1 m=1
bd_c1_r050_0750_1 d_c1_r050_0750_1 0 v=v(rbl_c1_r050_0750_1)-v(ref_c1_r050_0750_1)
bdabs_c1_r050_0750_1 dabs_c1_r050_0750_1 0 v=abs(v(rbl_c1_r050_0750_1)-v(ref_c1_r050_0750_1))

* ---- c1_r050_0750_2: cell1 SN = 0.75 V, ref offset 0.05 V, replica 2 ----
spa_c1_r050_0750_2 prea rbl_c1_r050_0750_2 ctl 0 swpre
XMWR_c1_r050_0750_2_0 sn_c1_r050_0750_2_0 0 0 0 sky130_fd_pr__nfet_01v8 L=0.15 W=0.42 nf=1 ad=0.1218 as=0.1218 pd=1.42 ps=1.42 nrd=0.69047619047619  nrs=0.69047619047619 sa=0 sb=0 sd=0 mult=1 m=1
XMRD_c1_r050_0750_2_0 rbl_c1_r050_0750_2 sn_c1_r050_0750_2_0 rwl_sel 0 sky130_fd_pr__nfet_01v8 L=0.15 W=0.42 nf=1 ad=0.1218 as=0.1218 pd=1.42 ps=1.42 nrd=0.69047619047619  nrs=0.69047619047619 sa=0 sb=0 sd=0 mult=1 m=1
csn_c1_r050_0750_2_0 sn_c1_r050_0750_2_0 0 {C_SN}
XMWR_c1_r050_0750_2_1 sn_c1_r050_0750_2_1 0 0 0 sky130_fd_pr__nfet_01v8 L=0.15 W=0.42 nf=1 ad=0.1218 as=0.1218 pd=1.42 ps=1.42 nrd=0.69047619047619  nrs=0.69047619047619 sa=0 sb=0 sd=0 mult=1 m=1
XMRD_c1_r050_0750_2_1 rbl_c1_r050_0750_2 sn_c1_r050_0750_2_1 rwl_des 0 sky130_fd_pr__nfet_01v8 L=0.15 W=0.42 nf=1 ad=0.1218 as=0.1218 pd=1.42 ps=1.42 nrd=0.69047619047619  nrs=0.69047619047619 sa=0 sb=0 sd=0 mult=1 m=1
csn_c1_r050_0750_2_1 sn_c1_r050_0750_2_1 0 {C_SN}
XMWR_c1_r050_0750_2_2 sn_c1_r050_0750_2_2 0 0 0 sky130_fd_pr__nfet_01v8 L=0.15 W=0.42 nf=1 ad=0.1218 as=0.1218 pd=1.42 ps=1.42 nrd=0.69047619047619  nrs=0.69047619047619 sa=0 sb=0 sd=0 mult=1 m=1
XMRD_c1_r050_0750_2_2 rbl_c1_r050_0750_2 sn_c1_r050_0750_2_2 rwl_des 0 sky130_fd_pr__nfet_01v8 L=0.15 W=0.42 nf=1 ad=0.1218 as=0.1218 pd=1.42 ps=1.42 nrd=0.69047619047619  nrs=0.69047619047619 sa=0 sb=0 sd=0 mult=1 m=1
csn_c1_r050_0750_2_2 sn_c1_r050_0750_2_2 0 {C_SN}
XMWR_c1_r050_0750_2_3 sn_c1_r050_0750_2_3 0 0 0 sky130_fd_pr__nfet_01v8 L=0.15 W=0.42 nf=1 ad=0.1218 as=0.1218 pd=1.42 ps=1.42 nrd=0.69047619047619  nrs=0.69047619047619 sa=0 sb=0 sd=0 mult=1 m=1
XMRD_c1_r050_0750_2_3 rbl_c1_r050_0750_2 sn_c1_r050_0750_2_3 rwl_des 0 sky130_fd_pr__nfet_01v8 L=0.15 W=0.42 nf=1 ad=0.1218 as=0.1218 pd=1.42 ps=1.42 nrd=0.69047619047619  nrs=0.69047619047619 sa=0 sb=0 sd=0 mult=1 m=1
csn_c1_r050_0750_2_3 sn_c1_r050_0750_2_3 0 {C_SN}
crbl_c1_r050_0750_2 rbl_c1_r050_0750_2 0 {C_RBL}
spr_c1_r050_0750_2 pref_050 ref_c1_r050_0750_2 ctl 0 swpre
cref_c1_r050_0750_2 ref_c1_r050_0750_2 0 {C_RBL}   $ ASSUMPTION: ideal matched dummy load
XMN1_c1_r050_0750_2 rbl_c1_r050_0750_2 ref_c1_r050_0750_2 vn_c1_r050_0750_2 0 sky130_fd_pr__nfet_01v8 L=0.15 W=1 nf=1 ad=0.29 as=0.29 pd=2.58 ps=2.58 nrd=0.29 nrs=0.29 sa=0 sb=0 sd=0 mult=1 m=1
XMN2_c1_r050_0750_2 ref_c1_r050_0750_2 rbl_c1_r050_0750_2 vn_c1_r050_0750_2 0 sky130_fd_pr__nfet_01v8 L=0.15 W=1 nf=1 ad=0.29 as=0.29 pd=2.58 ps=2.58 nrd=0.29 nrs=0.29 sa=0 sb=0 sd=0 mult=1 m=1
XMP1_c1_r050_0750_2 rbl_c1_r050_0750_2 ref_c1_r050_0750_2 vp_c1_r050_0750_2 vdd sky130_fd_pr__pfet_01v8 L=0.15 W=2 nf=1 ad=0.58 as=0.58 pd=4.58 ps=4.58 nrd=0.145 nrs=0.145 sa=0 sb=0 sd=0 mult=1 m=1
XMP2_c1_r050_0750_2 ref_c1_r050_0750_2 rbl_c1_r050_0750_2 vp_c1_r050_0750_2 vdd sky130_fd_pr__pfet_01v8 L=0.15 W=2 nf=1 ad=0.58 as=0.58 pd=4.58 ps=4.58 nrd=0.145 nrs=0.145 sa=0 sb=0 sd=0 mult=1 m=1
XMNF_c1_r050_0750_2 vn_c1_r050_0750_2 en 0 0 sky130_fd_pr__nfet_01v8 L=0.15 W=2 nf=1 ad=0.58 as=0.58 pd=4.58 ps=4.58 nrd=0.145 nrs=0.145 sa=0 sb=0 sd=0 mult=1 m=1
XMPH_c1_r050_0750_2 vp_c1_r050_0750_2 enb vdd vdd sky130_fd_pr__pfet_01v8 L=0.15 W=4 nf=1 ad=1.16 as=1.16 pd=8.58 ps=8.58 nrd=0.0725 nrs=0.0725 sa=0 sb=0 sd=0 mult=1 m=1
bd_c1_r050_0750_2 d_c1_r050_0750_2 0 v=v(rbl_c1_r050_0750_2)-v(ref_c1_r050_0750_2)
bdabs_c1_r050_0750_2 dabs_c1_r050_0750_2 0 v=abs(v(rbl_c1_r050_0750_2)-v(ref_c1_r050_0750_2))

* ---- c1_r050_0750_3: cell1 SN = 0.75 V, ref offset 0.05 V, replica 3 ----
spa_c1_r050_0750_3 prea rbl_c1_r050_0750_3 ctl 0 swpre
XMWR_c1_r050_0750_3_0 sn_c1_r050_0750_3_0 0 0 0 sky130_fd_pr__nfet_01v8 L=0.15 W=0.42 nf=1 ad=0.1218 as=0.1218 pd=1.42 ps=1.42 nrd=0.69047619047619  nrs=0.69047619047619 sa=0 sb=0 sd=0 mult=1 m=1
XMRD_c1_r050_0750_3_0 rbl_c1_r050_0750_3 sn_c1_r050_0750_3_0 rwl_sel 0 sky130_fd_pr__nfet_01v8 L=0.15 W=0.42 nf=1 ad=0.1218 as=0.1218 pd=1.42 ps=1.42 nrd=0.69047619047619  nrs=0.69047619047619 sa=0 sb=0 sd=0 mult=1 m=1
csn_c1_r050_0750_3_0 sn_c1_r050_0750_3_0 0 {C_SN}
XMWR_c1_r050_0750_3_1 sn_c1_r050_0750_3_1 0 0 0 sky130_fd_pr__nfet_01v8 L=0.15 W=0.42 nf=1 ad=0.1218 as=0.1218 pd=1.42 ps=1.42 nrd=0.69047619047619  nrs=0.69047619047619 sa=0 sb=0 sd=0 mult=1 m=1
XMRD_c1_r050_0750_3_1 rbl_c1_r050_0750_3 sn_c1_r050_0750_3_1 rwl_des 0 sky130_fd_pr__nfet_01v8 L=0.15 W=0.42 nf=1 ad=0.1218 as=0.1218 pd=1.42 ps=1.42 nrd=0.69047619047619  nrs=0.69047619047619 sa=0 sb=0 sd=0 mult=1 m=1
csn_c1_r050_0750_3_1 sn_c1_r050_0750_3_1 0 {C_SN}
XMWR_c1_r050_0750_3_2 sn_c1_r050_0750_3_2 0 0 0 sky130_fd_pr__nfet_01v8 L=0.15 W=0.42 nf=1 ad=0.1218 as=0.1218 pd=1.42 ps=1.42 nrd=0.69047619047619  nrs=0.69047619047619 sa=0 sb=0 sd=0 mult=1 m=1
XMRD_c1_r050_0750_3_2 rbl_c1_r050_0750_3 sn_c1_r050_0750_3_2 rwl_des 0 sky130_fd_pr__nfet_01v8 L=0.15 W=0.42 nf=1 ad=0.1218 as=0.1218 pd=1.42 ps=1.42 nrd=0.69047619047619  nrs=0.69047619047619 sa=0 sb=0 sd=0 mult=1 m=1
csn_c1_r050_0750_3_2 sn_c1_r050_0750_3_2 0 {C_SN}
XMWR_c1_r050_0750_3_3 sn_c1_r050_0750_3_3 0 0 0 sky130_fd_pr__nfet_01v8 L=0.15 W=0.42 nf=1 ad=0.1218 as=0.1218 pd=1.42 ps=1.42 nrd=0.69047619047619  nrs=0.69047619047619 sa=0 sb=0 sd=0 mult=1 m=1
XMRD_c1_r050_0750_3_3 rbl_c1_r050_0750_3 sn_c1_r050_0750_3_3 rwl_des 0 sky130_fd_pr__nfet_01v8 L=0.15 W=0.42 nf=1 ad=0.1218 as=0.1218 pd=1.42 ps=1.42 nrd=0.69047619047619  nrs=0.69047619047619 sa=0 sb=0 sd=0 mult=1 m=1
csn_c1_r050_0750_3_3 sn_c1_r050_0750_3_3 0 {C_SN}
crbl_c1_r050_0750_3 rbl_c1_r050_0750_3 0 {C_RBL}
spr_c1_r050_0750_3 pref_050 ref_c1_r050_0750_3 ctl 0 swpre
cref_c1_r050_0750_3 ref_c1_r050_0750_3 0 {C_RBL}   $ ASSUMPTION: ideal matched dummy load
XMN1_c1_r050_0750_3 rbl_c1_r050_0750_3 ref_c1_r050_0750_3 vn_c1_r050_0750_3 0 sky130_fd_pr__nfet_01v8 L=0.15 W=1 nf=1 ad=0.29 as=0.29 pd=2.58 ps=2.58 nrd=0.29 nrs=0.29 sa=0 sb=0 sd=0 mult=1 m=1
XMN2_c1_r050_0750_3 ref_c1_r050_0750_3 rbl_c1_r050_0750_3 vn_c1_r050_0750_3 0 sky130_fd_pr__nfet_01v8 L=0.15 W=1 nf=1 ad=0.29 as=0.29 pd=2.58 ps=2.58 nrd=0.29 nrs=0.29 sa=0 sb=0 sd=0 mult=1 m=1
XMP1_c1_r050_0750_3 rbl_c1_r050_0750_3 ref_c1_r050_0750_3 vp_c1_r050_0750_3 vdd sky130_fd_pr__pfet_01v8 L=0.15 W=2 nf=1 ad=0.58 as=0.58 pd=4.58 ps=4.58 nrd=0.145 nrs=0.145 sa=0 sb=0 sd=0 mult=1 m=1
XMP2_c1_r050_0750_3 ref_c1_r050_0750_3 rbl_c1_r050_0750_3 vp_c1_r050_0750_3 vdd sky130_fd_pr__pfet_01v8 L=0.15 W=2 nf=1 ad=0.58 as=0.58 pd=4.58 ps=4.58 nrd=0.145 nrs=0.145 sa=0 sb=0 sd=0 mult=1 m=1
XMNF_c1_r050_0750_3 vn_c1_r050_0750_3 en 0 0 sky130_fd_pr__nfet_01v8 L=0.15 W=2 nf=1 ad=0.58 as=0.58 pd=4.58 ps=4.58 nrd=0.145 nrs=0.145 sa=0 sb=0 sd=0 mult=1 m=1
XMPH_c1_r050_0750_3 vp_c1_r050_0750_3 enb vdd vdd sky130_fd_pr__pfet_01v8 L=0.15 W=4 nf=1 ad=1.16 as=1.16 pd=8.58 ps=8.58 nrd=0.0725 nrs=0.0725 sa=0 sb=0 sd=0 mult=1 m=1
bd_c1_r050_0750_3 d_c1_r050_0750_3 0 v=v(rbl_c1_r050_0750_3)-v(ref_c1_r050_0750_3)
bdabs_c1_r050_0750_3 dabs_c1_r050_0750_3 0 v=abs(v(rbl_c1_r050_0750_3)-v(ref_c1_r050_0750_3))

* ---- c1_r050_0800_0: cell1 SN = 0.8 V, ref offset 0.05 V, replica 0 ----
spa_c1_r050_0800_0 prea rbl_c1_r050_0800_0 ctl 0 swpre
XMWR_c1_r050_0800_0_0 sn_c1_r050_0800_0_0 0 0 0 sky130_fd_pr__nfet_01v8 L=0.15 W=0.42 nf=1 ad=0.1218 as=0.1218 pd=1.42 ps=1.42 nrd=0.69047619047619  nrs=0.69047619047619 sa=0 sb=0 sd=0 mult=1 m=1
XMRD_c1_r050_0800_0_0 rbl_c1_r050_0800_0 sn_c1_r050_0800_0_0 rwl_sel 0 sky130_fd_pr__nfet_01v8 L=0.15 W=0.42 nf=1 ad=0.1218 as=0.1218 pd=1.42 ps=1.42 nrd=0.69047619047619  nrs=0.69047619047619 sa=0 sb=0 sd=0 mult=1 m=1
csn_c1_r050_0800_0_0 sn_c1_r050_0800_0_0 0 {C_SN}
XMWR_c1_r050_0800_0_1 sn_c1_r050_0800_0_1 0 0 0 sky130_fd_pr__nfet_01v8 L=0.15 W=0.42 nf=1 ad=0.1218 as=0.1218 pd=1.42 ps=1.42 nrd=0.69047619047619  nrs=0.69047619047619 sa=0 sb=0 sd=0 mult=1 m=1
XMRD_c1_r050_0800_0_1 rbl_c1_r050_0800_0 sn_c1_r050_0800_0_1 rwl_des 0 sky130_fd_pr__nfet_01v8 L=0.15 W=0.42 nf=1 ad=0.1218 as=0.1218 pd=1.42 ps=1.42 nrd=0.69047619047619  nrs=0.69047619047619 sa=0 sb=0 sd=0 mult=1 m=1
csn_c1_r050_0800_0_1 sn_c1_r050_0800_0_1 0 {C_SN}
XMWR_c1_r050_0800_0_2 sn_c1_r050_0800_0_2 0 0 0 sky130_fd_pr__nfet_01v8 L=0.15 W=0.42 nf=1 ad=0.1218 as=0.1218 pd=1.42 ps=1.42 nrd=0.69047619047619  nrs=0.69047619047619 sa=0 sb=0 sd=0 mult=1 m=1
XMRD_c1_r050_0800_0_2 rbl_c1_r050_0800_0 sn_c1_r050_0800_0_2 rwl_des 0 sky130_fd_pr__nfet_01v8 L=0.15 W=0.42 nf=1 ad=0.1218 as=0.1218 pd=1.42 ps=1.42 nrd=0.69047619047619  nrs=0.69047619047619 sa=0 sb=0 sd=0 mult=1 m=1
csn_c1_r050_0800_0_2 sn_c1_r050_0800_0_2 0 {C_SN}
XMWR_c1_r050_0800_0_3 sn_c1_r050_0800_0_3 0 0 0 sky130_fd_pr__nfet_01v8 L=0.15 W=0.42 nf=1 ad=0.1218 as=0.1218 pd=1.42 ps=1.42 nrd=0.69047619047619  nrs=0.69047619047619 sa=0 sb=0 sd=0 mult=1 m=1
XMRD_c1_r050_0800_0_3 rbl_c1_r050_0800_0 sn_c1_r050_0800_0_3 rwl_des 0 sky130_fd_pr__nfet_01v8 L=0.15 W=0.42 nf=1 ad=0.1218 as=0.1218 pd=1.42 ps=1.42 nrd=0.69047619047619  nrs=0.69047619047619 sa=0 sb=0 sd=0 mult=1 m=1
csn_c1_r050_0800_0_3 sn_c1_r050_0800_0_3 0 {C_SN}
crbl_c1_r050_0800_0 rbl_c1_r050_0800_0 0 {C_RBL}
spr_c1_r050_0800_0 pref_050 ref_c1_r050_0800_0 ctl 0 swpre
cref_c1_r050_0800_0 ref_c1_r050_0800_0 0 {C_RBL}   $ ASSUMPTION: ideal matched dummy load
XMN1_c1_r050_0800_0 rbl_c1_r050_0800_0 ref_c1_r050_0800_0 vn_c1_r050_0800_0 0 sky130_fd_pr__nfet_01v8 L=0.15 W=1 nf=1 ad=0.29 as=0.29 pd=2.58 ps=2.58 nrd=0.29 nrs=0.29 sa=0 sb=0 sd=0 mult=1 m=1
XMN2_c1_r050_0800_0 ref_c1_r050_0800_0 rbl_c1_r050_0800_0 vn_c1_r050_0800_0 0 sky130_fd_pr__nfet_01v8 L=0.15 W=1 nf=1 ad=0.29 as=0.29 pd=2.58 ps=2.58 nrd=0.29 nrs=0.29 sa=0 sb=0 sd=0 mult=1 m=1
XMP1_c1_r050_0800_0 rbl_c1_r050_0800_0 ref_c1_r050_0800_0 vp_c1_r050_0800_0 vdd sky130_fd_pr__pfet_01v8 L=0.15 W=2 nf=1 ad=0.58 as=0.58 pd=4.58 ps=4.58 nrd=0.145 nrs=0.145 sa=0 sb=0 sd=0 mult=1 m=1
XMP2_c1_r050_0800_0 ref_c1_r050_0800_0 rbl_c1_r050_0800_0 vp_c1_r050_0800_0 vdd sky130_fd_pr__pfet_01v8 L=0.15 W=2 nf=1 ad=0.58 as=0.58 pd=4.58 ps=4.58 nrd=0.145 nrs=0.145 sa=0 sb=0 sd=0 mult=1 m=1
XMNF_c1_r050_0800_0 vn_c1_r050_0800_0 en 0 0 sky130_fd_pr__nfet_01v8 L=0.15 W=2 nf=1 ad=0.58 as=0.58 pd=4.58 ps=4.58 nrd=0.145 nrs=0.145 sa=0 sb=0 sd=0 mult=1 m=1
XMPH_c1_r050_0800_0 vp_c1_r050_0800_0 enb vdd vdd sky130_fd_pr__pfet_01v8 L=0.15 W=4 nf=1 ad=1.16 as=1.16 pd=8.58 ps=8.58 nrd=0.0725 nrs=0.0725 sa=0 sb=0 sd=0 mult=1 m=1
bd_c1_r050_0800_0 d_c1_r050_0800_0 0 v=v(rbl_c1_r050_0800_0)-v(ref_c1_r050_0800_0)
bdabs_c1_r050_0800_0 dabs_c1_r050_0800_0 0 v=abs(v(rbl_c1_r050_0800_0)-v(ref_c1_r050_0800_0))

* ---- c1_r050_0800_1: cell1 SN = 0.8 V, ref offset 0.05 V, replica 1 ----
spa_c1_r050_0800_1 prea rbl_c1_r050_0800_1 ctl 0 swpre
XMWR_c1_r050_0800_1_0 sn_c1_r050_0800_1_0 0 0 0 sky130_fd_pr__nfet_01v8 L=0.15 W=0.42 nf=1 ad=0.1218 as=0.1218 pd=1.42 ps=1.42 nrd=0.69047619047619  nrs=0.69047619047619 sa=0 sb=0 sd=0 mult=1 m=1
XMRD_c1_r050_0800_1_0 rbl_c1_r050_0800_1 sn_c1_r050_0800_1_0 rwl_sel 0 sky130_fd_pr__nfet_01v8 L=0.15 W=0.42 nf=1 ad=0.1218 as=0.1218 pd=1.42 ps=1.42 nrd=0.69047619047619  nrs=0.69047619047619 sa=0 sb=0 sd=0 mult=1 m=1
csn_c1_r050_0800_1_0 sn_c1_r050_0800_1_0 0 {C_SN}
XMWR_c1_r050_0800_1_1 sn_c1_r050_0800_1_1 0 0 0 sky130_fd_pr__nfet_01v8 L=0.15 W=0.42 nf=1 ad=0.1218 as=0.1218 pd=1.42 ps=1.42 nrd=0.69047619047619  nrs=0.69047619047619 sa=0 sb=0 sd=0 mult=1 m=1
XMRD_c1_r050_0800_1_1 rbl_c1_r050_0800_1 sn_c1_r050_0800_1_1 rwl_des 0 sky130_fd_pr__nfet_01v8 L=0.15 W=0.42 nf=1 ad=0.1218 as=0.1218 pd=1.42 ps=1.42 nrd=0.69047619047619  nrs=0.69047619047619 sa=0 sb=0 sd=0 mult=1 m=1
csn_c1_r050_0800_1_1 sn_c1_r050_0800_1_1 0 {C_SN}
XMWR_c1_r050_0800_1_2 sn_c1_r050_0800_1_2 0 0 0 sky130_fd_pr__nfet_01v8 L=0.15 W=0.42 nf=1 ad=0.1218 as=0.1218 pd=1.42 ps=1.42 nrd=0.69047619047619  nrs=0.69047619047619 sa=0 sb=0 sd=0 mult=1 m=1
XMRD_c1_r050_0800_1_2 rbl_c1_r050_0800_1 sn_c1_r050_0800_1_2 rwl_des 0 sky130_fd_pr__nfet_01v8 L=0.15 W=0.42 nf=1 ad=0.1218 as=0.1218 pd=1.42 ps=1.42 nrd=0.69047619047619  nrs=0.69047619047619 sa=0 sb=0 sd=0 mult=1 m=1
csn_c1_r050_0800_1_2 sn_c1_r050_0800_1_2 0 {C_SN}
XMWR_c1_r050_0800_1_3 sn_c1_r050_0800_1_3 0 0 0 sky130_fd_pr__nfet_01v8 L=0.15 W=0.42 nf=1 ad=0.1218 as=0.1218 pd=1.42 ps=1.42 nrd=0.69047619047619  nrs=0.69047619047619 sa=0 sb=0 sd=0 mult=1 m=1
XMRD_c1_r050_0800_1_3 rbl_c1_r050_0800_1 sn_c1_r050_0800_1_3 rwl_des 0 sky130_fd_pr__nfet_01v8 L=0.15 W=0.42 nf=1 ad=0.1218 as=0.1218 pd=1.42 ps=1.42 nrd=0.69047619047619  nrs=0.69047619047619 sa=0 sb=0 sd=0 mult=1 m=1
csn_c1_r050_0800_1_3 sn_c1_r050_0800_1_3 0 {C_SN}
crbl_c1_r050_0800_1 rbl_c1_r050_0800_1 0 {C_RBL}
spr_c1_r050_0800_1 pref_050 ref_c1_r050_0800_1 ctl 0 swpre
cref_c1_r050_0800_1 ref_c1_r050_0800_1 0 {C_RBL}   $ ASSUMPTION: ideal matched dummy load
XMN1_c1_r050_0800_1 rbl_c1_r050_0800_1 ref_c1_r050_0800_1 vn_c1_r050_0800_1 0 sky130_fd_pr__nfet_01v8 L=0.15 W=1 nf=1 ad=0.29 as=0.29 pd=2.58 ps=2.58 nrd=0.29 nrs=0.29 sa=0 sb=0 sd=0 mult=1 m=1
XMN2_c1_r050_0800_1 ref_c1_r050_0800_1 rbl_c1_r050_0800_1 vn_c1_r050_0800_1 0 sky130_fd_pr__nfet_01v8 L=0.15 W=1 nf=1 ad=0.29 as=0.29 pd=2.58 ps=2.58 nrd=0.29 nrs=0.29 sa=0 sb=0 sd=0 mult=1 m=1
XMP1_c1_r050_0800_1 rbl_c1_r050_0800_1 ref_c1_r050_0800_1 vp_c1_r050_0800_1 vdd sky130_fd_pr__pfet_01v8 L=0.15 W=2 nf=1 ad=0.58 as=0.58 pd=4.58 ps=4.58 nrd=0.145 nrs=0.145 sa=0 sb=0 sd=0 mult=1 m=1
XMP2_c1_r050_0800_1 ref_c1_r050_0800_1 rbl_c1_r050_0800_1 vp_c1_r050_0800_1 vdd sky130_fd_pr__pfet_01v8 L=0.15 W=2 nf=1 ad=0.58 as=0.58 pd=4.58 ps=4.58 nrd=0.145 nrs=0.145 sa=0 sb=0 sd=0 mult=1 m=1
XMNF_c1_r050_0800_1 vn_c1_r050_0800_1 en 0 0 sky130_fd_pr__nfet_01v8 L=0.15 W=2 nf=1 ad=0.58 as=0.58 pd=4.58 ps=4.58 nrd=0.145 nrs=0.145 sa=0 sb=0 sd=0 mult=1 m=1
XMPH_c1_r050_0800_1 vp_c1_r050_0800_1 enb vdd vdd sky130_fd_pr__pfet_01v8 L=0.15 W=4 nf=1 ad=1.16 as=1.16 pd=8.58 ps=8.58 nrd=0.0725 nrs=0.0725 sa=0 sb=0 sd=0 mult=1 m=1
bd_c1_r050_0800_1 d_c1_r050_0800_1 0 v=v(rbl_c1_r050_0800_1)-v(ref_c1_r050_0800_1)
bdabs_c1_r050_0800_1 dabs_c1_r050_0800_1 0 v=abs(v(rbl_c1_r050_0800_1)-v(ref_c1_r050_0800_1))

* ---- c1_r050_0800_2: cell1 SN = 0.8 V, ref offset 0.05 V, replica 2 ----
spa_c1_r050_0800_2 prea rbl_c1_r050_0800_2 ctl 0 swpre
XMWR_c1_r050_0800_2_0 sn_c1_r050_0800_2_0 0 0 0 sky130_fd_pr__nfet_01v8 L=0.15 W=0.42 nf=1 ad=0.1218 as=0.1218 pd=1.42 ps=1.42 nrd=0.69047619047619  nrs=0.69047619047619 sa=0 sb=0 sd=0 mult=1 m=1
XMRD_c1_r050_0800_2_0 rbl_c1_r050_0800_2 sn_c1_r050_0800_2_0 rwl_sel 0 sky130_fd_pr__nfet_01v8 L=0.15 W=0.42 nf=1 ad=0.1218 as=0.1218 pd=1.42 ps=1.42 nrd=0.69047619047619  nrs=0.69047619047619 sa=0 sb=0 sd=0 mult=1 m=1
csn_c1_r050_0800_2_0 sn_c1_r050_0800_2_0 0 {C_SN}
XMWR_c1_r050_0800_2_1 sn_c1_r050_0800_2_1 0 0 0 sky130_fd_pr__nfet_01v8 L=0.15 W=0.42 nf=1 ad=0.1218 as=0.1218 pd=1.42 ps=1.42 nrd=0.69047619047619  nrs=0.69047619047619 sa=0 sb=0 sd=0 mult=1 m=1
XMRD_c1_r050_0800_2_1 rbl_c1_r050_0800_2 sn_c1_r050_0800_2_1 rwl_des 0 sky130_fd_pr__nfet_01v8 L=0.15 W=0.42 nf=1 ad=0.1218 as=0.1218 pd=1.42 ps=1.42 nrd=0.69047619047619  nrs=0.69047619047619 sa=0 sb=0 sd=0 mult=1 m=1
csn_c1_r050_0800_2_1 sn_c1_r050_0800_2_1 0 {C_SN}
XMWR_c1_r050_0800_2_2 sn_c1_r050_0800_2_2 0 0 0 sky130_fd_pr__nfet_01v8 L=0.15 W=0.42 nf=1 ad=0.1218 as=0.1218 pd=1.42 ps=1.42 nrd=0.69047619047619  nrs=0.69047619047619 sa=0 sb=0 sd=0 mult=1 m=1
XMRD_c1_r050_0800_2_2 rbl_c1_r050_0800_2 sn_c1_r050_0800_2_2 rwl_des 0 sky130_fd_pr__nfet_01v8 L=0.15 W=0.42 nf=1 ad=0.1218 as=0.1218 pd=1.42 ps=1.42 nrd=0.69047619047619  nrs=0.69047619047619 sa=0 sb=0 sd=0 mult=1 m=1
csn_c1_r050_0800_2_2 sn_c1_r050_0800_2_2 0 {C_SN}
XMWR_c1_r050_0800_2_3 sn_c1_r050_0800_2_3 0 0 0 sky130_fd_pr__nfet_01v8 L=0.15 W=0.42 nf=1 ad=0.1218 as=0.1218 pd=1.42 ps=1.42 nrd=0.69047619047619  nrs=0.69047619047619 sa=0 sb=0 sd=0 mult=1 m=1
XMRD_c1_r050_0800_2_3 rbl_c1_r050_0800_2 sn_c1_r050_0800_2_3 rwl_des 0 sky130_fd_pr__nfet_01v8 L=0.15 W=0.42 nf=1 ad=0.1218 as=0.1218 pd=1.42 ps=1.42 nrd=0.69047619047619  nrs=0.69047619047619 sa=0 sb=0 sd=0 mult=1 m=1
csn_c1_r050_0800_2_3 sn_c1_r050_0800_2_3 0 {C_SN}
crbl_c1_r050_0800_2 rbl_c1_r050_0800_2 0 {C_RBL}
spr_c1_r050_0800_2 pref_050 ref_c1_r050_0800_2 ctl 0 swpre
cref_c1_r050_0800_2 ref_c1_r050_0800_2 0 {C_RBL}   $ ASSUMPTION: ideal matched dummy load
XMN1_c1_r050_0800_2 rbl_c1_r050_0800_2 ref_c1_r050_0800_2 vn_c1_r050_0800_2 0 sky130_fd_pr__nfet_01v8 L=0.15 W=1 nf=1 ad=0.29 as=0.29 pd=2.58 ps=2.58 nrd=0.29 nrs=0.29 sa=0 sb=0 sd=0 mult=1 m=1
XMN2_c1_r050_0800_2 ref_c1_r050_0800_2 rbl_c1_r050_0800_2 vn_c1_r050_0800_2 0 sky130_fd_pr__nfet_01v8 L=0.15 W=1 nf=1 ad=0.29 as=0.29 pd=2.58 ps=2.58 nrd=0.29 nrs=0.29 sa=0 sb=0 sd=0 mult=1 m=1
XMP1_c1_r050_0800_2 rbl_c1_r050_0800_2 ref_c1_r050_0800_2 vp_c1_r050_0800_2 vdd sky130_fd_pr__pfet_01v8 L=0.15 W=2 nf=1 ad=0.58 as=0.58 pd=4.58 ps=4.58 nrd=0.145 nrs=0.145 sa=0 sb=0 sd=0 mult=1 m=1
XMP2_c1_r050_0800_2 ref_c1_r050_0800_2 rbl_c1_r050_0800_2 vp_c1_r050_0800_2 vdd sky130_fd_pr__pfet_01v8 L=0.15 W=2 nf=1 ad=0.58 as=0.58 pd=4.58 ps=4.58 nrd=0.145 nrs=0.145 sa=0 sb=0 sd=0 mult=1 m=1
XMNF_c1_r050_0800_2 vn_c1_r050_0800_2 en 0 0 sky130_fd_pr__nfet_01v8 L=0.15 W=2 nf=1 ad=0.58 as=0.58 pd=4.58 ps=4.58 nrd=0.145 nrs=0.145 sa=0 sb=0 sd=0 mult=1 m=1
XMPH_c1_r050_0800_2 vp_c1_r050_0800_2 enb vdd vdd sky130_fd_pr__pfet_01v8 L=0.15 W=4 nf=1 ad=1.16 as=1.16 pd=8.58 ps=8.58 nrd=0.0725 nrs=0.0725 sa=0 sb=0 sd=0 mult=1 m=1
bd_c1_r050_0800_2 d_c1_r050_0800_2 0 v=v(rbl_c1_r050_0800_2)-v(ref_c1_r050_0800_2)
bdabs_c1_r050_0800_2 dabs_c1_r050_0800_2 0 v=abs(v(rbl_c1_r050_0800_2)-v(ref_c1_r050_0800_2))

* ---- c1_r050_0800_3: cell1 SN = 0.8 V, ref offset 0.05 V, replica 3 ----
spa_c1_r050_0800_3 prea rbl_c1_r050_0800_3 ctl 0 swpre
XMWR_c1_r050_0800_3_0 sn_c1_r050_0800_3_0 0 0 0 sky130_fd_pr__nfet_01v8 L=0.15 W=0.42 nf=1 ad=0.1218 as=0.1218 pd=1.42 ps=1.42 nrd=0.69047619047619  nrs=0.69047619047619 sa=0 sb=0 sd=0 mult=1 m=1
XMRD_c1_r050_0800_3_0 rbl_c1_r050_0800_3 sn_c1_r050_0800_3_0 rwl_sel 0 sky130_fd_pr__nfet_01v8 L=0.15 W=0.42 nf=1 ad=0.1218 as=0.1218 pd=1.42 ps=1.42 nrd=0.69047619047619  nrs=0.69047619047619 sa=0 sb=0 sd=0 mult=1 m=1
csn_c1_r050_0800_3_0 sn_c1_r050_0800_3_0 0 {C_SN}
XMWR_c1_r050_0800_3_1 sn_c1_r050_0800_3_1 0 0 0 sky130_fd_pr__nfet_01v8 L=0.15 W=0.42 nf=1 ad=0.1218 as=0.1218 pd=1.42 ps=1.42 nrd=0.69047619047619  nrs=0.69047619047619 sa=0 sb=0 sd=0 mult=1 m=1
XMRD_c1_r050_0800_3_1 rbl_c1_r050_0800_3 sn_c1_r050_0800_3_1 rwl_des 0 sky130_fd_pr__nfet_01v8 L=0.15 W=0.42 nf=1 ad=0.1218 as=0.1218 pd=1.42 ps=1.42 nrd=0.69047619047619  nrs=0.69047619047619 sa=0 sb=0 sd=0 mult=1 m=1
csn_c1_r050_0800_3_1 sn_c1_r050_0800_3_1 0 {C_SN}
XMWR_c1_r050_0800_3_2 sn_c1_r050_0800_3_2 0 0 0 sky130_fd_pr__nfet_01v8 L=0.15 W=0.42 nf=1 ad=0.1218 as=0.1218 pd=1.42 ps=1.42 nrd=0.69047619047619  nrs=0.69047619047619 sa=0 sb=0 sd=0 mult=1 m=1
XMRD_c1_r050_0800_3_2 rbl_c1_r050_0800_3 sn_c1_r050_0800_3_2 rwl_des 0 sky130_fd_pr__nfet_01v8 L=0.15 W=0.42 nf=1 ad=0.1218 as=0.1218 pd=1.42 ps=1.42 nrd=0.69047619047619  nrs=0.69047619047619 sa=0 sb=0 sd=0 mult=1 m=1
csn_c1_r050_0800_3_2 sn_c1_r050_0800_3_2 0 {C_SN}
XMWR_c1_r050_0800_3_3 sn_c1_r050_0800_3_3 0 0 0 sky130_fd_pr__nfet_01v8 L=0.15 W=0.42 nf=1 ad=0.1218 as=0.1218 pd=1.42 ps=1.42 nrd=0.69047619047619  nrs=0.69047619047619 sa=0 sb=0 sd=0 mult=1 m=1
XMRD_c1_r050_0800_3_3 rbl_c1_r050_0800_3 sn_c1_r050_0800_3_3 rwl_des 0 sky130_fd_pr__nfet_01v8 L=0.15 W=0.42 nf=1 ad=0.1218 as=0.1218 pd=1.42 ps=1.42 nrd=0.69047619047619  nrs=0.69047619047619 sa=0 sb=0 sd=0 mult=1 m=1
csn_c1_r050_0800_3_3 sn_c1_r050_0800_3_3 0 {C_SN}
crbl_c1_r050_0800_3 rbl_c1_r050_0800_3 0 {C_RBL}
spr_c1_r050_0800_3 pref_050 ref_c1_r050_0800_3 ctl 0 swpre
cref_c1_r050_0800_3 ref_c1_r050_0800_3 0 {C_RBL}   $ ASSUMPTION: ideal matched dummy load
XMN1_c1_r050_0800_3 rbl_c1_r050_0800_3 ref_c1_r050_0800_3 vn_c1_r050_0800_3 0 sky130_fd_pr__nfet_01v8 L=0.15 W=1 nf=1 ad=0.29 as=0.29 pd=2.58 ps=2.58 nrd=0.29 nrs=0.29 sa=0 sb=0 sd=0 mult=1 m=1
XMN2_c1_r050_0800_3 ref_c1_r050_0800_3 rbl_c1_r050_0800_3 vn_c1_r050_0800_3 0 sky130_fd_pr__nfet_01v8 L=0.15 W=1 nf=1 ad=0.29 as=0.29 pd=2.58 ps=2.58 nrd=0.29 nrs=0.29 sa=0 sb=0 sd=0 mult=1 m=1
XMP1_c1_r050_0800_3 rbl_c1_r050_0800_3 ref_c1_r050_0800_3 vp_c1_r050_0800_3 vdd sky130_fd_pr__pfet_01v8 L=0.15 W=2 nf=1 ad=0.58 as=0.58 pd=4.58 ps=4.58 nrd=0.145 nrs=0.145 sa=0 sb=0 sd=0 mult=1 m=1
XMP2_c1_r050_0800_3 ref_c1_r050_0800_3 rbl_c1_r050_0800_3 vp_c1_r050_0800_3 vdd sky130_fd_pr__pfet_01v8 L=0.15 W=2 nf=1 ad=0.58 as=0.58 pd=4.58 ps=4.58 nrd=0.145 nrs=0.145 sa=0 sb=0 sd=0 mult=1 m=1
XMNF_c1_r050_0800_3 vn_c1_r050_0800_3 en 0 0 sky130_fd_pr__nfet_01v8 L=0.15 W=2 nf=1 ad=0.58 as=0.58 pd=4.58 ps=4.58 nrd=0.145 nrs=0.145 sa=0 sb=0 sd=0 mult=1 m=1
XMPH_c1_r050_0800_3 vp_c1_r050_0800_3 enb vdd vdd sky130_fd_pr__pfet_01v8 L=0.15 W=4 nf=1 ad=1.16 as=1.16 pd=8.58 ps=8.58 nrd=0.0725 nrs=0.0725 sa=0 sb=0 sd=0 mult=1 m=1
bd_c1_r050_0800_3 d_c1_r050_0800_3 0 v=v(rbl_c1_r050_0800_3)-v(ref_c1_r050_0800_3)
bdabs_c1_r050_0800_3 dabs_c1_r050_0800_3 0 v=abs(v(rbl_c1_r050_0800_3)-v(ref_c1_r050_0800_3))

* ---- c1_r050_0850_0: cell1 SN = 0.85 V, ref offset 0.05 V, replica 0 ----
spa_c1_r050_0850_0 prea rbl_c1_r050_0850_0 ctl 0 swpre
XMWR_c1_r050_0850_0_0 sn_c1_r050_0850_0_0 0 0 0 sky130_fd_pr__nfet_01v8 L=0.15 W=0.42 nf=1 ad=0.1218 as=0.1218 pd=1.42 ps=1.42 nrd=0.69047619047619  nrs=0.69047619047619 sa=0 sb=0 sd=0 mult=1 m=1
XMRD_c1_r050_0850_0_0 rbl_c1_r050_0850_0 sn_c1_r050_0850_0_0 rwl_sel 0 sky130_fd_pr__nfet_01v8 L=0.15 W=0.42 nf=1 ad=0.1218 as=0.1218 pd=1.42 ps=1.42 nrd=0.69047619047619  nrs=0.69047619047619 sa=0 sb=0 sd=0 mult=1 m=1
csn_c1_r050_0850_0_0 sn_c1_r050_0850_0_0 0 {C_SN}
XMWR_c1_r050_0850_0_1 sn_c1_r050_0850_0_1 0 0 0 sky130_fd_pr__nfet_01v8 L=0.15 W=0.42 nf=1 ad=0.1218 as=0.1218 pd=1.42 ps=1.42 nrd=0.69047619047619  nrs=0.69047619047619 sa=0 sb=0 sd=0 mult=1 m=1
XMRD_c1_r050_0850_0_1 rbl_c1_r050_0850_0 sn_c1_r050_0850_0_1 rwl_des 0 sky130_fd_pr__nfet_01v8 L=0.15 W=0.42 nf=1 ad=0.1218 as=0.1218 pd=1.42 ps=1.42 nrd=0.69047619047619  nrs=0.69047619047619 sa=0 sb=0 sd=0 mult=1 m=1
csn_c1_r050_0850_0_1 sn_c1_r050_0850_0_1 0 {C_SN}
XMWR_c1_r050_0850_0_2 sn_c1_r050_0850_0_2 0 0 0 sky130_fd_pr__nfet_01v8 L=0.15 W=0.42 nf=1 ad=0.1218 as=0.1218 pd=1.42 ps=1.42 nrd=0.69047619047619  nrs=0.69047619047619 sa=0 sb=0 sd=0 mult=1 m=1
XMRD_c1_r050_0850_0_2 rbl_c1_r050_0850_0 sn_c1_r050_0850_0_2 rwl_des 0 sky130_fd_pr__nfet_01v8 L=0.15 W=0.42 nf=1 ad=0.1218 as=0.1218 pd=1.42 ps=1.42 nrd=0.69047619047619  nrs=0.69047619047619 sa=0 sb=0 sd=0 mult=1 m=1
csn_c1_r050_0850_0_2 sn_c1_r050_0850_0_2 0 {C_SN}
XMWR_c1_r050_0850_0_3 sn_c1_r050_0850_0_3 0 0 0 sky130_fd_pr__nfet_01v8 L=0.15 W=0.42 nf=1 ad=0.1218 as=0.1218 pd=1.42 ps=1.42 nrd=0.69047619047619  nrs=0.69047619047619 sa=0 sb=0 sd=0 mult=1 m=1
XMRD_c1_r050_0850_0_3 rbl_c1_r050_0850_0 sn_c1_r050_0850_0_3 rwl_des 0 sky130_fd_pr__nfet_01v8 L=0.15 W=0.42 nf=1 ad=0.1218 as=0.1218 pd=1.42 ps=1.42 nrd=0.69047619047619  nrs=0.69047619047619 sa=0 sb=0 sd=0 mult=1 m=1
csn_c1_r050_0850_0_3 sn_c1_r050_0850_0_3 0 {C_SN}
crbl_c1_r050_0850_0 rbl_c1_r050_0850_0 0 {C_RBL}
spr_c1_r050_0850_0 pref_050 ref_c1_r050_0850_0 ctl 0 swpre
cref_c1_r050_0850_0 ref_c1_r050_0850_0 0 {C_RBL}   $ ASSUMPTION: ideal matched dummy load
XMN1_c1_r050_0850_0 rbl_c1_r050_0850_0 ref_c1_r050_0850_0 vn_c1_r050_0850_0 0 sky130_fd_pr__nfet_01v8 L=0.15 W=1 nf=1 ad=0.29 as=0.29 pd=2.58 ps=2.58 nrd=0.29 nrs=0.29 sa=0 sb=0 sd=0 mult=1 m=1
XMN2_c1_r050_0850_0 ref_c1_r050_0850_0 rbl_c1_r050_0850_0 vn_c1_r050_0850_0 0 sky130_fd_pr__nfet_01v8 L=0.15 W=1 nf=1 ad=0.29 as=0.29 pd=2.58 ps=2.58 nrd=0.29 nrs=0.29 sa=0 sb=0 sd=0 mult=1 m=1
XMP1_c1_r050_0850_0 rbl_c1_r050_0850_0 ref_c1_r050_0850_0 vp_c1_r050_0850_0 vdd sky130_fd_pr__pfet_01v8 L=0.15 W=2 nf=1 ad=0.58 as=0.58 pd=4.58 ps=4.58 nrd=0.145 nrs=0.145 sa=0 sb=0 sd=0 mult=1 m=1
XMP2_c1_r050_0850_0 ref_c1_r050_0850_0 rbl_c1_r050_0850_0 vp_c1_r050_0850_0 vdd sky130_fd_pr__pfet_01v8 L=0.15 W=2 nf=1 ad=0.58 as=0.58 pd=4.58 ps=4.58 nrd=0.145 nrs=0.145 sa=0 sb=0 sd=0 mult=1 m=1
XMNF_c1_r050_0850_0 vn_c1_r050_0850_0 en 0 0 sky130_fd_pr__nfet_01v8 L=0.15 W=2 nf=1 ad=0.58 as=0.58 pd=4.58 ps=4.58 nrd=0.145 nrs=0.145 sa=0 sb=0 sd=0 mult=1 m=1
XMPH_c1_r050_0850_0 vp_c1_r050_0850_0 enb vdd vdd sky130_fd_pr__pfet_01v8 L=0.15 W=4 nf=1 ad=1.16 as=1.16 pd=8.58 ps=8.58 nrd=0.0725 nrs=0.0725 sa=0 sb=0 sd=0 mult=1 m=1
bd_c1_r050_0850_0 d_c1_r050_0850_0 0 v=v(rbl_c1_r050_0850_0)-v(ref_c1_r050_0850_0)
bdabs_c1_r050_0850_0 dabs_c1_r050_0850_0 0 v=abs(v(rbl_c1_r050_0850_0)-v(ref_c1_r050_0850_0))

* ---- c1_r050_0850_1: cell1 SN = 0.85 V, ref offset 0.05 V, replica 1 ----
spa_c1_r050_0850_1 prea rbl_c1_r050_0850_1 ctl 0 swpre
XMWR_c1_r050_0850_1_0 sn_c1_r050_0850_1_0 0 0 0 sky130_fd_pr__nfet_01v8 L=0.15 W=0.42 nf=1 ad=0.1218 as=0.1218 pd=1.42 ps=1.42 nrd=0.69047619047619  nrs=0.69047619047619 sa=0 sb=0 sd=0 mult=1 m=1
XMRD_c1_r050_0850_1_0 rbl_c1_r050_0850_1 sn_c1_r050_0850_1_0 rwl_sel 0 sky130_fd_pr__nfet_01v8 L=0.15 W=0.42 nf=1 ad=0.1218 as=0.1218 pd=1.42 ps=1.42 nrd=0.69047619047619  nrs=0.69047619047619 sa=0 sb=0 sd=0 mult=1 m=1
csn_c1_r050_0850_1_0 sn_c1_r050_0850_1_0 0 {C_SN}
XMWR_c1_r050_0850_1_1 sn_c1_r050_0850_1_1 0 0 0 sky130_fd_pr__nfet_01v8 L=0.15 W=0.42 nf=1 ad=0.1218 as=0.1218 pd=1.42 ps=1.42 nrd=0.69047619047619  nrs=0.69047619047619 sa=0 sb=0 sd=0 mult=1 m=1
XMRD_c1_r050_0850_1_1 rbl_c1_r050_0850_1 sn_c1_r050_0850_1_1 rwl_des 0 sky130_fd_pr__nfet_01v8 L=0.15 W=0.42 nf=1 ad=0.1218 as=0.1218 pd=1.42 ps=1.42 nrd=0.69047619047619  nrs=0.69047619047619 sa=0 sb=0 sd=0 mult=1 m=1
csn_c1_r050_0850_1_1 sn_c1_r050_0850_1_1 0 {C_SN}
XMWR_c1_r050_0850_1_2 sn_c1_r050_0850_1_2 0 0 0 sky130_fd_pr__nfet_01v8 L=0.15 W=0.42 nf=1 ad=0.1218 as=0.1218 pd=1.42 ps=1.42 nrd=0.69047619047619  nrs=0.69047619047619 sa=0 sb=0 sd=0 mult=1 m=1
XMRD_c1_r050_0850_1_2 rbl_c1_r050_0850_1 sn_c1_r050_0850_1_2 rwl_des 0 sky130_fd_pr__nfet_01v8 L=0.15 W=0.42 nf=1 ad=0.1218 as=0.1218 pd=1.42 ps=1.42 nrd=0.69047619047619  nrs=0.69047619047619 sa=0 sb=0 sd=0 mult=1 m=1
csn_c1_r050_0850_1_2 sn_c1_r050_0850_1_2 0 {C_SN}
XMWR_c1_r050_0850_1_3 sn_c1_r050_0850_1_3 0 0 0 sky130_fd_pr__nfet_01v8 L=0.15 W=0.42 nf=1 ad=0.1218 as=0.1218 pd=1.42 ps=1.42 nrd=0.69047619047619  nrs=0.69047619047619 sa=0 sb=0 sd=0 mult=1 m=1
XMRD_c1_r050_0850_1_3 rbl_c1_r050_0850_1 sn_c1_r050_0850_1_3 rwl_des 0 sky130_fd_pr__nfet_01v8 L=0.15 W=0.42 nf=1 ad=0.1218 as=0.1218 pd=1.42 ps=1.42 nrd=0.69047619047619  nrs=0.69047619047619 sa=0 sb=0 sd=0 mult=1 m=1
csn_c1_r050_0850_1_3 sn_c1_r050_0850_1_3 0 {C_SN}
crbl_c1_r050_0850_1 rbl_c1_r050_0850_1 0 {C_RBL}
spr_c1_r050_0850_1 pref_050 ref_c1_r050_0850_1 ctl 0 swpre
cref_c1_r050_0850_1 ref_c1_r050_0850_1 0 {C_RBL}   $ ASSUMPTION: ideal matched dummy load
XMN1_c1_r050_0850_1 rbl_c1_r050_0850_1 ref_c1_r050_0850_1 vn_c1_r050_0850_1 0 sky130_fd_pr__nfet_01v8 L=0.15 W=1 nf=1 ad=0.29 as=0.29 pd=2.58 ps=2.58 nrd=0.29 nrs=0.29 sa=0 sb=0 sd=0 mult=1 m=1
XMN2_c1_r050_0850_1 ref_c1_r050_0850_1 rbl_c1_r050_0850_1 vn_c1_r050_0850_1 0 sky130_fd_pr__nfet_01v8 L=0.15 W=1 nf=1 ad=0.29 as=0.29 pd=2.58 ps=2.58 nrd=0.29 nrs=0.29 sa=0 sb=0 sd=0 mult=1 m=1
XMP1_c1_r050_0850_1 rbl_c1_r050_0850_1 ref_c1_r050_0850_1 vp_c1_r050_0850_1 vdd sky130_fd_pr__pfet_01v8 L=0.15 W=2 nf=1 ad=0.58 as=0.58 pd=4.58 ps=4.58 nrd=0.145 nrs=0.145 sa=0 sb=0 sd=0 mult=1 m=1
XMP2_c1_r050_0850_1 ref_c1_r050_0850_1 rbl_c1_r050_0850_1 vp_c1_r050_0850_1 vdd sky130_fd_pr__pfet_01v8 L=0.15 W=2 nf=1 ad=0.58 as=0.58 pd=4.58 ps=4.58 nrd=0.145 nrs=0.145 sa=0 sb=0 sd=0 mult=1 m=1
XMNF_c1_r050_0850_1 vn_c1_r050_0850_1 en 0 0 sky130_fd_pr__nfet_01v8 L=0.15 W=2 nf=1 ad=0.58 as=0.58 pd=4.58 ps=4.58 nrd=0.145 nrs=0.145 sa=0 sb=0 sd=0 mult=1 m=1
XMPH_c1_r050_0850_1 vp_c1_r050_0850_1 enb vdd vdd sky130_fd_pr__pfet_01v8 L=0.15 W=4 nf=1 ad=1.16 as=1.16 pd=8.58 ps=8.58 nrd=0.0725 nrs=0.0725 sa=0 sb=0 sd=0 mult=1 m=1
bd_c1_r050_0850_1 d_c1_r050_0850_1 0 v=v(rbl_c1_r050_0850_1)-v(ref_c1_r050_0850_1)
bdabs_c1_r050_0850_1 dabs_c1_r050_0850_1 0 v=abs(v(rbl_c1_r050_0850_1)-v(ref_c1_r050_0850_1))

* ---- c1_r050_0850_2: cell1 SN = 0.85 V, ref offset 0.05 V, replica 2 ----
spa_c1_r050_0850_2 prea rbl_c1_r050_0850_2 ctl 0 swpre
XMWR_c1_r050_0850_2_0 sn_c1_r050_0850_2_0 0 0 0 sky130_fd_pr__nfet_01v8 L=0.15 W=0.42 nf=1 ad=0.1218 as=0.1218 pd=1.42 ps=1.42 nrd=0.69047619047619  nrs=0.69047619047619 sa=0 sb=0 sd=0 mult=1 m=1
XMRD_c1_r050_0850_2_0 rbl_c1_r050_0850_2 sn_c1_r050_0850_2_0 rwl_sel 0 sky130_fd_pr__nfet_01v8 L=0.15 W=0.42 nf=1 ad=0.1218 as=0.1218 pd=1.42 ps=1.42 nrd=0.69047619047619  nrs=0.69047619047619 sa=0 sb=0 sd=0 mult=1 m=1
csn_c1_r050_0850_2_0 sn_c1_r050_0850_2_0 0 {C_SN}
XMWR_c1_r050_0850_2_1 sn_c1_r050_0850_2_1 0 0 0 sky130_fd_pr__nfet_01v8 L=0.15 W=0.42 nf=1 ad=0.1218 as=0.1218 pd=1.42 ps=1.42 nrd=0.69047619047619  nrs=0.69047619047619 sa=0 sb=0 sd=0 mult=1 m=1
XMRD_c1_r050_0850_2_1 rbl_c1_r050_0850_2 sn_c1_r050_0850_2_1 rwl_des 0 sky130_fd_pr__nfet_01v8 L=0.15 W=0.42 nf=1 ad=0.1218 as=0.1218 pd=1.42 ps=1.42 nrd=0.69047619047619  nrs=0.69047619047619 sa=0 sb=0 sd=0 mult=1 m=1
csn_c1_r050_0850_2_1 sn_c1_r050_0850_2_1 0 {C_SN}
XMWR_c1_r050_0850_2_2 sn_c1_r050_0850_2_2 0 0 0 sky130_fd_pr__nfet_01v8 L=0.15 W=0.42 nf=1 ad=0.1218 as=0.1218 pd=1.42 ps=1.42 nrd=0.69047619047619  nrs=0.69047619047619 sa=0 sb=0 sd=0 mult=1 m=1
XMRD_c1_r050_0850_2_2 rbl_c1_r050_0850_2 sn_c1_r050_0850_2_2 rwl_des 0 sky130_fd_pr__nfet_01v8 L=0.15 W=0.42 nf=1 ad=0.1218 as=0.1218 pd=1.42 ps=1.42 nrd=0.69047619047619  nrs=0.69047619047619 sa=0 sb=0 sd=0 mult=1 m=1
csn_c1_r050_0850_2_2 sn_c1_r050_0850_2_2 0 {C_SN}
XMWR_c1_r050_0850_2_3 sn_c1_r050_0850_2_3 0 0 0 sky130_fd_pr__nfet_01v8 L=0.15 W=0.42 nf=1 ad=0.1218 as=0.1218 pd=1.42 ps=1.42 nrd=0.69047619047619  nrs=0.69047619047619 sa=0 sb=0 sd=0 mult=1 m=1
XMRD_c1_r050_0850_2_3 rbl_c1_r050_0850_2 sn_c1_r050_0850_2_3 rwl_des 0 sky130_fd_pr__nfet_01v8 L=0.15 W=0.42 nf=1 ad=0.1218 as=0.1218 pd=1.42 ps=1.42 nrd=0.69047619047619  nrs=0.69047619047619 sa=0 sb=0 sd=0 mult=1 m=1
csn_c1_r050_0850_2_3 sn_c1_r050_0850_2_3 0 {C_SN}
crbl_c1_r050_0850_2 rbl_c1_r050_0850_2 0 {C_RBL}
spr_c1_r050_0850_2 pref_050 ref_c1_r050_0850_2 ctl 0 swpre
cref_c1_r050_0850_2 ref_c1_r050_0850_2 0 {C_RBL}   $ ASSUMPTION: ideal matched dummy load
XMN1_c1_r050_0850_2 rbl_c1_r050_0850_2 ref_c1_r050_0850_2 vn_c1_r050_0850_2 0 sky130_fd_pr__nfet_01v8 L=0.15 W=1 nf=1 ad=0.29 as=0.29 pd=2.58 ps=2.58 nrd=0.29 nrs=0.29 sa=0 sb=0 sd=0 mult=1 m=1
XMN2_c1_r050_0850_2 ref_c1_r050_0850_2 rbl_c1_r050_0850_2 vn_c1_r050_0850_2 0 sky130_fd_pr__nfet_01v8 L=0.15 W=1 nf=1 ad=0.29 as=0.29 pd=2.58 ps=2.58 nrd=0.29 nrs=0.29 sa=0 sb=0 sd=0 mult=1 m=1
XMP1_c1_r050_0850_2 rbl_c1_r050_0850_2 ref_c1_r050_0850_2 vp_c1_r050_0850_2 vdd sky130_fd_pr__pfet_01v8 L=0.15 W=2 nf=1 ad=0.58 as=0.58 pd=4.58 ps=4.58 nrd=0.145 nrs=0.145 sa=0 sb=0 sd=0 mult=1 m=1
XMP2_c1_r050_0850_2 ref_c1_r050_0850_2 rbl_c1_r050_0850_2 vp_c1_r050_0850_2 vdd sky130_fd_pr__pfet_01v8 L=0.15 W=2 nf=1 ad=0.58 as=0.58 pd=4.58 ps=4.58 nrd=0.145 nrs=0.145 sa=0 sb=0 sd=0 mult=1 m=1
XMNF_c1_r050_0850_2 vn_c1_r050_0850_2 en 0 0 sky130_fd_pr__nfet_01v8 L=0.15 W=2 nf=1 ad=0.58 as=0.58 pd=4.58 ps=4.58 nrd=0.145 nrs=0.145 sa=0 sb=0 sd=0 mult=1 m=1
XMPH_c1_r050_0850_2 vp_c1_r050_0850_2 enb vdd vdd sky130_fd_pr__pfet_01v8 L=0.15 W=4 nf=1 ad=1.16 as=1.16 pd=8.58 ps=8.58 nrd=0.0725 nrs=0.0725 sa=0 sb=0 sd=0 mult=1 m=1
bd_c1_r050_0850_2 d_c1_r050_0850_2 0 v=v(rbl_c1_r050_0850_2)-v(ref_c1_r050_0850_2)
bdabs_c1_r050_0850_2 dabs_c1_r050_0850_2 0 v=abs(v(rbl_c1_r050_0850_2)-v(ref_c1_r050_0850_2))

* ---- c1_r050_0850_3: cell1 SN = 0.85 V, ref offset 0.05 V, replica 3 ----
spa_c1_r050_0850_3 prea rbl_c1_r050_0850_3 ctl 0 swpre
XMWR_c1_r050_0850_3_0 sn_c1_r050_0850_3_0 0 0 0 sky130_fd_pr__nfet_01v8 L=0.15 W=0.42 nf=1 ad=0.1218 as=0.1218 pd=1.42 ps=1.42 nrd=0.69047619047619  nrs=0.69047619047619 sa=0 sb=0 sd=0 mult=1 m=1
XMRD_c1_r050_0850_3_0 rbl_c1_r050_0850_3 sn_c1_r050_0850_3_0 rwl_sel 0 sky130_fd_pr__nfet_01v8 L=0.15 W=0.42 nf=1 ad=0.1218 as=0.1218 pd=1.42 ps=1.42 nrd=0.69047619047619  nrs=0.69047619047619 sa=0 sb=0 sd=0 mult=1 m=1
csn_c1_r050_0850_3_0 sn_c1_r050_0850_3_0 0 {C_SN}
XMWR_c1_r050_0850_3_1 sn_c1_r050_0850_3_1 0 0 0 sky130_fd_pr__nfet_01v8 L=0.15 W=0.42 nf=1 ad=0.1218 as=0.1218 pd=1.42 ps=1.42 nrd=0.69047619047619  nrs=0.69047619047619 sa=0 sb=0 sd=0 mult=1 m=1
XMRD_c1_r050_0850_3_1 rbl_c1_r050_0850_3 sn_c1_r050_0850_3_1 rwl_des 0 sky130_fd_pr__nfet_01v8 L=0.15 W=0.42 nf=1 ad=0.1218 as=0.1218 pd=1.42 ps=1.42 nrd=0.69047619047619  nrs=0.69047619047619 sa=0 sb=0 sd=0 mult=1 m=1
csn_c1_r050_0850_3_1 sn_c1_r050_0850_3_1 0 {C_SN}
XMWR_c1_r050_0850_3_2 sn_c1_r050_0850_3_2 0 0 0 sky130_fd_pr__nfet_01v8 L=0.15 W=0.42 nf=1 ad=0.1218 as=0.1218 pd=1.42 ps=1.42 nrd=0.69047619047619  nrs=0.69047619047619 sa=0 sb=0 sd=0 mult=1 m=1
XMRD_c1_r050_0850_3_2 rbl_c1_r050_0850_3 sn_c1_r050_0850_3_2 rwl_des 0 sky130_fd_pr__nfet_01v8 L=0.15 W=0.42 nf=1 ad=0.1218 as=0.1218 pd=1.42 ps=1.42 nrd=0.69047619047619  nrs=0.69047619047619 sa=0 sb=0 sd=0 mult=1 m=1
csn_c1_r050_0850_3_2 sn_c1_r050_0850_3_2 0 {C_SN}
XMWR_c1_r050_0850_3_3 sn_c1_r050_0850_3_3 0 0 0 sky130_fd_pr__nfet_01v8 L=0.15 W=0.42 nf=1 ad=0.1218 as=0.1218 pd=1.42 ps=1.42 nrd=0.69047619047619  nrs=0.69047619047619 sa=0 sb=0 sd=0 mult=1 m=1
XMRD_c1_r050_0850_3_3 rbl_c1_r050_0850_3 sn_c1_r050_0850_3_3 rwl_des 0 sky130_fd_pr__nfet_01v8 L=0.15 W=0.42 nf=1 ad=0.1218 as=0.1218 pd=1.42 ps=1.42 nrd=0.69047619047619  nrs=0.69047619047619 sa=0 sb=0 sd=0 mult=1 m=1
csn_c1_r050_0850_3_3 sn_c1_r050_0850_3_3 0 {C_SN}
crbl_c1_r050_0850_3 rbl_c1_r050_0850_3 0 {C_RBL}
spr_c1_r050_0850_3 pref_050 ref_c1_r050_0850_3 ctl 0 swpre
cref_c1_r050_0850_3 ref_c1_r050_0850_3 0 {C_RBL}   $ ASSUMPTION: ideal matched dummy load
XMN1_c1_r050_0850_3 rbl_c1_r050_0850_3 ref_c1_r050_0850_3 vn_c1_r050_0850_3 0 sky130_fd_pr__nfet_01v8 L=0.15 W=1 nf=1 ad=0.29 as=0.29 pd=2.58 ps=2.58 nrd=0.29 nrs=0.29 sa=0 sb=0 sd=0 mult=1 m=1
XMN2_c1_r050_0850_3 ref_c1_r050_0850_3 rbl_c1_r050_0850_3 vn_c1_r050_0850_3 0 sky130_fd_pr__nfet_01v8 L=0.15 W=1 nf=1 ad=0.29 as=0.29 pd=2.58 ps=2.58 nrd=0.29 nrs=0.29 sa=0 sb=0 sd=0 mult=1 m=1
XMP1_c1_r050_0850_3 rbl_c1_r050_0850_3 ref_c1_r050_0850_3 vp_c1_r050_0850_3 vdd sky130_fd_pr__pfet_01v8 L=0.15 W=2 nf=1 ad=0.58 as=0.58 pd=4.58 ps=4.58 nrd=0.145 nrs=0.145 sa=0 sb=0 sd=0 mult=1 m=1
XMP2_c1_r050_0850_3 ref_c1_r050_0850_3 rbl_c1_r050_0850_3 vp_c1_r050_0850_3 vdd sky130_fd_pr__pfet_01v8 L=0.15 W=2 nf=1 ad=0.58 as=0.58 pd=4.58 ps=4.58 nrd=0.145 nrs=0.145 sa=0 sb=0 sd=0 mult=1 m=1
XMNF_c1_r050_0850_3 vn_c1_r050_0850_3 en 0 0 sky130_fd_pr__nfet_01v8 L=0.15 W=2 nf=1 ad=0.58 as=0.58 pd=4.58 ps=4.58 nrd=0.145 nrs=0.145 sa=0 sb=0 sd=0 mult=1 m=1
XMPH_c1_r050_0850_3 vp_c1_r050_0850_3 enb vdd vdd sky130_fd_pr__pfet_01v8 L=0.15 W=4 nf=1 ad=1.16 as=1.16 pd=8.58 ps=8.58 nrd=0.0725 nrs=0.0725 sa=0 sb=0 sd=0 mult=1 m=1
bd_c1_r050_0850_3 d_c1_r050_0850_3 0 v=v(rbl_c1_r050_0850_3)-v(ref_c1_r050_0850_3)
bdabs_c1_r050_0850_3 dabs_c1_r050_0850_3 0 v=abs(v(rbl_c1_r050_0850_3)-v(ref_c1_r050_0850_3))

* ---- c1_r050_0900_0: cell1 SN = 0.9 V, ref offset 0.05 V, replica 0 ----
spa_c1_r050_0900_0 prea rbl_c1_r050_0900_0 ctl 0 swpre
XMWR_c1_r050_0900_0_0 sn_c1_r050_0900_0_0 0 0 0 sky130_fd_pr__nfet_01v8 L=0.15 W=0.42 nf=1 ad=0.1218 as=0.1218 pd=1.42 ps=1.42 nrd=0.69047619047619  nrs=0.69047619047619 sa=0 sb=0 sd=0 mult=1 m=1
XMRD_c1_r050_0900_0_0 rbl_c1_r050_0900_0 sn_c1_r050_0900_0_0 rwl_sel 0 sky130_fd_pr__nfet_01v8 L=0.15 W=0.42 nf=1 ad=0.1218 as=0.1218 pd=1.42 ps=1.42 nrd=0.69047619047619  nrs=0.69047619047619 sa=0 sb=0 sd=0 mult=1 m=1
csn_c1_r050_0900_0_0 sn_c1_r050_0900_0_0 0 {C_SN}
XMWR_c1_r050_0900_0_1 sn_c1_r050_0900_0_1 0 0 0 sky130_fd_pr__nfet_01v8 L=0.15 W=0.42 nf=1 ad=0.1218 as=0.1218 pd=1.42 ps=1.42 nrd=0.69047619047619  nrs=0.69047619047619 sa=0 sb=0 sd=0 mult=1 m=1
XMRD_c1_r050_0900_0_1 rbl_c1_r050_0900_0 sn_c1_r050_0900_0_1 rwl_des 0 sky130_fd_pr__nfet_01v8 L=0.15 W=0.42 nf=1 ad=0.1218 as=0.1218 pd=1.42 ps=1.42 nrd=0.69047619047619  nrs=0.69047619047619 sa=0 sb=0 sd=0 mult=1 m=1
csn_c1_r050_0900_0_1 sn_c1_r050_0900_0_1 0 {C_SN}
XMWR_c1_r050_0900_0_2 sn_c1_r050_0900_0_2 0 0 0 sky130_fd_pr__nfet_01v8 L=0.15 W=0.42 nf=1 ad=0.1218 as=0.1218 pd=1.42 ps=1.42 nrd=0.69047619047619  nrs=0.69047619047619 sa=0 sb=0 sd=0 mult=1 m=1
XMRD_c1_r050_0900_0_2 rbl_c1_r050_0900_0 sn_c1_r050_0900_0_2 rwl_des 0 sky130_fd_pr__nfet_01v8 L=0.15 W=0.42 nf=1 ad=0.1218 as=0.1218 pd=1.42 ps=1.42 nrd=0.69047619047619  nrs=0.69047619047619 sa=0 sb=0 sd=0 mult=1 m=1
csn_c1_r050_0900_0_2 sn_c1_r050_0900_0_2 0 {C_SN}
XMWR_c1_r050_0900_0_3 sn_c1_r050_0900_0_3 0 0 0 sky130_fd_pr__nfet_01v8 L=0.15 W=0.42 nf=1 ad=0.1218 as=0.1218 pd=1.42 ps=1.42 nrd=0.69047619047619  nrs=0.69047619047619 sa=0 sb=0 sd=0 mult=1 m=1
XMRD_c1_r050_0900_0_3 rbl_c1_r050_0900_0 sn_c1_r050_0900_0_3 rwl_des 0 sky130_fd_pr__nfet_01v8 L=0.15 W=0.42 nf=1 ad=0.1218 as=0.1218 pd=1.42 ps=1.42 nrd=0.69047619047619  nrs=0.69047619047619 sa=0 sb=0 sd=0 mult=1 m=1
csn_c1_r050_0900_0_3 sn_c1_r050_0900_0_3 0 {C_SN}
crbl_c1_r050_0900_0 rbl_c1_r050_0900_0 0 {C_RBL}
spr_c1_r050_0900_0 pref_050 ref_c1_r050_0900_0 ctl 0 swpre
cref_c1_r050_0900_0 ref_c1_r050_0900_0 0 {C_RBL}   $ ASSUMPTION: ideal matched dummy load
XMN1_c1_r050_0900_0 rbl_c1_r050_0900_0 ref_c1_r050_0900_0 vn_c1_r050_0900_0 0 sky130_fd_pr__nfet_01v8 L=0.15 W=1 nf=1 ad=0.29 as=0.29 pd=2.58 ps=2.58 nrd=0.29 nrs=0.29 sa=0 sb=0 sd=0 mult=1 m=1
XMN2_c1_r050_0900_0 ref_c1_r050_0900_0 rbl_c1_r050_0900_0 vn_c1_r050_0900_0 0 sky130_fd_pr__nfet_01v8 L=0.15 W=1 nf=1 ad=0.29 as=0.29 pd=2.58 ps=2.58 nrd=0.29 nrs=0.29 sa=0 sb=0 sd=0 mult=1 m=1
XMP1_c1_r050_0900_0 rbl_c1_r050_0900_0 ref_c1_r050_0900_0 vp_c1_r050_0900_0 vdd sky130_fd_pr__pfet_01v8 L=0.15 W=2 nf=1 ad=0.58 as=0.58 pd=4.58 ps=4.58 nrd=0.145 nrs=0.145 sa=0 sb=0 sd=0 mult=1 m=1
XMP2_c1_r050_0900_0 ref_c1_r050_0900_0 rbl_c1_r050_0900_0 vp_c1_r050_0900_0 vdd sky130_fd_pr__pfet_01v8 L=0.15 W=2 nf=1 ad=0.58 as=0.58 pd=4.58 ps=4.58 nrd=0.145 nrs=0.145 sa=0 sb=0 sd=0 mult=1 m=1
XMNF_c1_r050_0900_0 vn_c1_r050_0900_0 en 0 0 sky130_fd_pr__nfet_01v8 L=0.15 W=2 nf=1 ad=0.58 as=0.58 pd=4.58 ps=4.58 nrd=0.145 nrs=0.145 sa=0 sb=0 sd=0 mult=1 m=1
XMPH_c1_r050_0900_0 vp_c1_r050_0900_0 enb vdd vdd sky130_fd_pr__pfet_01v8 L=0.15 W=4 nf=1 ad=1.16 as=1.16 pd=8.58 ps=8.58 nrd=0.0725 nrs=0.0725 sa=0 sb=0 sd=0 mult=1 m=1
bd_c1_r050_0900_0 d_c1_r050_0900_0 0 v=v(rbl_c1_r050_0900_0)-v(ref_c1_r050_0900_0)
bdabs_c1_r050_0900_0 dabs_c1_r050_0900_0 0 v=abs(v(rbl_c1_r050_0900_0)-v(ref_c1_r050_0900_0))

* ---- c1_r050_0900_1: cell1 SN = 0.9 V, ref offset 0.05 V, replica 1 ----
spa_c1_r050_0900_1 prea rbl_c1_r050_0900_1 ctl 0 swpre
XMWR_c1_r050_0900_1_0 sn_c1_r050_0900_1_0 0 0 0 sky130_fd_pr__nfet_01v8 L=0.15 W=0.42 nf=1 ad=0.1218 as=0.1218 pd=1.42 ps=1.42 nrd=0.69047619047619  nrs=0.69047619047619 sa=0 sb=0 sd=0 mult=1 m=1
XMRD_c1_r050_0900_1_0 rbl_c1_r050_0900_1 sn_c1_r050_0900_1_0 rwl_sel 0 sky130_fd_pr__nfet_01v8 L=0.15 W=0.42 nf=1 ad=0.1218 as=0.1218 pd=1.42 ps=1.42 nrd=0.69047619047619  nrs=0.69047619047619 sa=0 sb=0 sd=0 mult=1 m=1
csn_c1_r050_0900_1_0 sn_c1_r050_0900_1_0 0 {C_SN}
XMWR_c1_r050_0900_1_1 sn_c1_r050_0900_1_1 0 0 0 sky130_fd_pr__nfet_01v8 L=0.15 W=0.42 nf=1 ad=0.1218 as=0.1218 pd=1.42 ps=1.42 nrd=0.69047619047619  nrs=0.69047619047619 sa=0 sb=0 sd=0 mult=1 m=1
XMRD_c1_r050_0900_1_1 rbl_c1_r050_0900_1 sn_c1_r050_0900_1_1 rwl_des 0 sky130_fd_pr__nfet_01v8 L=0.15 W=0.42 nf=1 ad=0.1218 as=0.1218 pd=1.42 ps=1.42 nrd=0.69047619047619  nrs=0.69047619047619 sa=0 sb=0 sd=0 mult=1 m=1
csn_c1_r050_0900_1_1 sn_c1_r050_0900_1_1 0 {C_SN}
XMWR_c1_r050_0900_1_2 sn_c1_r050_0900_1_2 0 0 0 sky130_fd_pr__nfet_01v8 L=0.15 W=0.42 nf=1 ad=0.1218 as=0.1218 pd=1.42 ps=1.42 nrd=0.69047619047619  nrs=0.69047619047619 sa=0 sb=0 sd=0 mult=1 m=1
XMRD_c1_r050_0900_1_2 rbl_c1_r050_0900_1 sn_c1_r050_0900_1_2 rwl_des 0 sky130_fd_pr__nfet_01v8 L=0.15 W=0.42 nf=1 ad=0.1218 as=0.1218 pd=1.42 ps=1.42 nrd=0.69047619047619  nrs=0.69047619047619 sa=0 sb=0 sd=0 mult=1 m=1
csn_c1_r050_0900_1_2 sn_c1_r050_0900_1_2 0 {C_SN}
XMWR_c1_r050_0900_1_3 sn_c1_r050_0900_1_3 0 0 0 sky130_fd_pr__nfet_01v8 L=0.15 W=0.42 nf=1 ad=0.1218 as=0.1218 pd=1.42 ps=1.42 nrd=0.69047619047619  nrs=0.69047619047619 sa=0 sb=0 sd=0 mult=1 m=1
XMRD_c1_r050_0900_1_3 rbl_c1_r050_0900_1 sn_c1_r050_0900_1_3 rwl_des 0 sky130_fd_pr__nfet_01v8 L=0.15 W=0.42 nf=1 ad=0.1218 as=0.1218 pd=1.42 ps=1.42 nrd=0.69047619047619  nrs=0.69047619047619 sa=0 sb=0 sd=0 mult=1 m=1
csn_c1_r050_0900_1_3 sn_c1_r050_0900_1_3 0 {C_SN}
crbl_c1_r050_0900_1 rbl_c1_r050_0900_1 0 {C_RBL}
spr_c1_r050_0900_1 pref_050 ref_c1_r050_0900_1 ctl 0 swpre
cref_c1_r050_0900_1 ref_c1_r050_0900_1 0 {C_RBL}   $ ASSUMPTION: ideal matched dummy load
XMN1_c1_r050_0900_1 rbl_c1_r050_0900_1 ref_c1_r050_0900_1 vn_c1_r050_0900_1 0 sky130_fd_pr__nfet_01v8 L=0.15 W=1 nf=1 ad=0.29 as=0.29 pd=2.58 ps=2.58 nrd=0.29 nrs=0.29 sa=0 sb=0 sd=0 mult=1 m=1
XMN2_c1_r050_0900_1 ref_c1_r050_0900_1 rbl_c1_r050_0900_1 vn_c1_r050_0900_1 0 sky130_fd_pr__nfet_01v8 L=0.15 W=1 nf=1 ad=0.29 as=0.29 pd=2.58 ps=2.58 nrd=0.29 nrs=0.29 sa=0 sb=0 sd=0 mult=1 m=1
XMP1_c1_r050_0900_1 rbl_c1_r050_0900_1 ref_c1_r050_0900_1 vp_c1_r050_0900_1 vdd sky130_fd_pr__pfet_01v8 L=0.15 W=2 nf=1 ad=0.58 as=0.58 pd=4.58 ps=4.58 nrd=0.145 nrs=0.145 sa=0 sb=0 sd=0 mult=1 m=1
XMP2_c1_r050_0900_1 ref_c1_r050_0900_1 rbl_c1_r050_0900_1 vp_c1_r050_0900_1 vdd sky130_fd_pr__pfet_01v8 L=0.15 W=2 nf=1 ad=0.58 as=0.58 pd=4.58 ps=4.58 nrd=0.145 nrs=0.145 sa=0 sb=0 sd=0 mult=1 m=1
XMNF_c1_r050_0900_1 vn_c1_r050_0900_1 en 0 0 sky130_fd_pr__nfet_01v8 L=0.15 W=2 nf=1 ad=0.58 as=0.58 pd=4.58 ps=4.58 nrd=0.145 nrs=0.145 sa=0 sb=0 sd=0 mult=1 m=1
XMPH_c1_r050_0900_1 vp_c1_r050_0900_1 enb vdd vdd sky130_fd_pr__pfet_01v8 L=0.15 W=4 nf=1 ad=1.16 as=1.16 pd=8.58 ps=8.58 nrd=0.0725 nrs=0.0725 sa=0 sb=0 sd=0 mult=1 m=1
bd_c1_r050_0900_1 d_c1_r050_0900_1 0 v=v(rbl_c1_r050_0900_1)-v(ref_c1_r050_0900_1)
bdabs_c1_r050_0900_1 dabs_c1_r050_0900_1 0 v=abs(v(rbl_c1_r050_0900_1)-v(ref_c1_r050_0900_1))

* ---- c1_r050_0900_2: cell1 SN = 0.9 V, ref offset 0.05 V, replica 2 ----
spa_c1_r050_0900_2 prea rbl_c1_r050_0900_2 ctl 0 swpre
XMWR_c1_r050_0900_2_0 sn_c1_r050_0900_2_0 0 0 0 sky130_fd_pr__nfet_01v8 L=0.15 W=0.42 nf=1 ad=0.1218 as=0.1218 pd=1.42 ps=1.42 nrd=0.69047619047619  nrs=0.69047619047619 sa=0 sb=0 sd=0 mult=1 m=1
XMRD_c1_r050_0900_2_0 rbl_c1_r050_0900_2 sn_c1_r050_0900_2_0 rwl_sel 0 sky130_fd_pr__nfet_01v8 L=0.15 W=0.42 nf=1 ad=0.1218 as=0.1218 pd=1.42 ps=1.42 nrd=0.69047619047619  nrs=0.69047619047619 sa=0 sb=0 sd=0 mult=1 m=1
csn_c1_r050_0900_2_0 sn_c1_r050_0900_2_0 0 {C_SN}
XMWR_c1_r050_0900_2_1 sn_c1_r050_0900_2_1 0 0 0 sky130_fd_pr__nfet_01v8 L=0.15 W=0.42 nf=1 ad=0.1218 as=0.1218 pd=1.42 ps=1.42 nrd=0.69047619047619  nrs=0.69047619047619 sa=0 sb=0 sd=0 mult=1 m=1
XMRD_c1_r050_0900_2_1 rbl_c1_r050_0900_2 sn_c1_r050_0900_2_1 rwl_des 0 sky130_fd_pr__nfet_01v8 L=0.15 W=0.42 nf=1 ad=0.1218 as=0.1218 pd=1.42 ps=1.42 nrd=0.69047619047619  nrs=0.69047619047619 sa=0 sb=0 sd=0 mult=1 m=1
csn_c1_r050_0900_2_1 sn_c1_r050_0900_2_1 0 {C_SN}
XMWR_c1_r050_0900_2_2 sn_c1_r050_0900_2_2 0 0 0 sky130_fd_pr__nfet_01v8 L=0.15 W=0.42 nf=1 ad=0.1218 as=0.1218 pd=1.42 ps=1.42 nrd=0.69047619047619  nrs=0.69047619047619 sa=0 sb=0 sd=0 mult=1 m=1
XMRD_c1_r050_0900_2_2 rbl_c1_r050_0900_2 sn_c1_r050_0900_2_2 rwl_des 0 sky130_fd_pr__nfet_01v8 L=0.15 W=0.42 nf=1 ad=0.1218 as=0.1218 pd=1.42 ps=1.42 nrd=0.69047619047619  nrs=0.69047619047619 sa=0 sb=0 sd=0 mult=1 m=1
csn_c1_r050_0900_2_2 sn_c1_r050_0900_2_2 0 {C_SN}
XMWR_c1_r050_0900_2_3 sn_c1_r050_0900_2_3 0 0 0 sky130_fd_pr__nfet_01v8 L=0.15 W=0.42 nf=1 ad=0.1218 as=0.1218 pd=1.42 ps=1.42 nrd=0.69047619047619  nrs=0.69047619047619 sa=0 sb=0 sd=0 mult=1 m=1
XMRD_c1_r050_0900_2_3 rbl_c1_r050_0900_2 sn_c1_r050_0900_2_3 rwl_des 0 sky130_fd_pr__nfet_01v8 L=0.15 W=0.42 nf=1 ad=0.1218 as=0.1218 pd=1.42 ps=1.42 nrd=0.69047619047619  nrs=0.69047619047619 sa=0 sb=0 sd=0 mult=1 m=1
csn_c1_r050_0900_2_3 sn_c1_r050_0900_2_3 0 {C_SN}
crbl_c1_r050_0900_2 rbl_c1_r050_0900_2 0 {C_RBL}
spr_c1_r050_0900_2 pref_050 ref_c1_r050_0900_2 ctl 0 swpre
cref_c1_r050_0900_2 ref_c1_r050_0900_2 0 {C_RBL}   $ ASSUMPTION: ideal matched dummy load
XMN1_c1_r050_0900_2 rbl_c1_r050_0900_2 ref_c1_r050_0900_2 vn_c1_r050_0900_2 0 sky130_fd_pr__nfet_01v8 L=0.15 W=1 nf=1 ad=0.29 as=0.29 pd=2.58 ps=2.58 nrd=0.29 nrs=0.29 sa=0 sb=0 sd=0 mult=1 m=1
XMN2_c1_r050_0900_2 ref_c1_r050_0900_2 rbl_c1_r050_0900_2 vn_c1_r050_0900_2 0 sky130_fd_pr__nfet_01v8 L=0.15 W=1 nf=1 ad=0.29 as=0.29 pd=2.58 ps=2.58 nrd=0.29 nrs=0.29 sa=0 sb=0 sd=0 mult=1 m=1
XMP1_c1_r050_0900_2 rbl_c1_r050_0900_2 ref_c1_r050_0900_2 vp_c1_r050_0900_2 vdd sky130_fd_pr__pfet_01v8 L=0.15 W=2 nf=1 ad=0.58 as=0.58 pd=4.58 ps=4.58 nrd=0.145 nrs=0.145 sa=0 sb=0 sd=0 mult=1 m=1
XMP2_c1_r050_0900_2 ref_c1_r050_0900_2 rbl_c1_r050_0900_2 vp_c1_r050_0900_2 vdd sky130_fd_pr__pfet_01v8 L=0.15 W=2 nf=1 ad=0.58 as=0.58 pd=4.58 ps=4.58 nrd=0.145 nrs=0.145 sa=0 sb=0 sd=0 mult=1 m=1
XMNF_c1_r050_0900_2 vn_c1_r050_0900_2 en 0 0 sky130_fd_pr__nfet_01v8 L=0.15 W=2 nf=1 ad=0.58 as=0.58 pd=4.58 ps=4.58 nrd=0.145 nrs=0.145 sa=0 sb=0 sd=0 mult=1 m=1
XMPH_c1_r050_0900_2 vp_c1_r050_0900_2 enb vdd vdd sky130_fd_pr__pfet_01v8 L=0.15 W=4 nf=1 ad=1.16 as=1.16 pd=8.58 ps=8.58 nrd=0.0725 nrs=0.0725 sa=0 sb=0 sd=0 mult=1 m=1
bd_c1_r050_0900_2 d_c1_r050_0900_2 0 v=v(rbl_c1_r050_0900_2)-v(ref_c1_r050_0900_2)
bdabs_c1_r050_0900_2 dabs_c1_r050_0900_2 0 v=abs(v(rbl_c1_r050_0900_2)-v(ref_c1_r050_0900_2))

* ---- c1_r050_0900_3: cell1 SN = 0.9 V, ref offset 0.05 V, replica 3 ----
spa_c1_r050_0900_3 prea rbl_c1_r050_0900_3 ctl 0 swpre
XMWR_c1_r050_0900_3_0 sn_c1_r050_0900_3_0 0 0 0 sky130_fd_pr__nfet_01v8 L=0.15 W=0.42 nf=1 ad=0.1218 as=0.1218 pd=1.42 ps=1.42 nrd=0.69047619047619  nrs=0.69047619047619 sa=0 sb=0 sd=0 mult=1 m=1
XMRD_c1_r050_0900_3_0 rbl_c1_r050_0900_3 sn_c1_r050_0900_3_0 rwl_sel 0 sky130_fd_pr__nfet_01v8 L=0.15 W=0.42 nf=1 ad=0.1218 as=0.1218 pd=1.42 ps=1.42 nrd=0.69047619047619  nrs=0.69047619047619 sa=0 sb=0 sd=0 mult=1 m=1
csn_c1_r050_0900_3_0 sn_c1_r050_0900_3_0 0 {C_SN}
XMWR_c1_r050_0900_3_1 sn_c1_r050_0900_3_1 0 0 0 sky130_fd_pr__nfet_01v8 L=0.15 W=0.42 nf=1 ad=0.1218 as=0.1218 pd=1.42 ps=1.42 nrd=0.69047619047619  nrs=0.69047619047619 sa=0 sb=0 sd=0 mult=1 m=1
XMRD_c1_r050_0900_3_1 rbl_c1_r050_0900_3 sn_c1_r050_0900_3_1 rwl_des 0 sky130_fd_pr__nfet_01v8 L=0.15 W=0.42 nf=1 ad=0.1218 as=0.1218 pd=1.42 ps=1.42 nrd=0.69047619047619  nrs=0.69047619047619 sa=0 sb=0 sd=0 mult=1 m=1
csn_c1_r050_0900_3_1 sn_c1_r050_0900_3_1 0 {C_SN}
XMWR_c1_r050_0900_3_2 sn_c1_r050_0900_3_2 0 0 0 sky130_fd_pr__nfet_01v8 L=0.15 W=0.42 nf=1 ad=0.1218 as=0.1218 pd=1.42 ps=1.42 nrd=0.69047619047619  nrs=0.69047619047619 sa=0 sb=0 sd=0 mult=1 m=1
XMRD_c1_r050_0900_3_2 rbl_c1_r050_0900_3 sn_c1_r050_0900_3_2 rwl_des 0 sky130_fd_pr__nfet_01v8 L=0.15 W=0.42 nf=1 ad=0.1218 as=0.1218 pd=1.42 ps=1.42 nrd=0.69047619047619  nrs=0.69047619047619 sa=0 sb=0 sd=0 mult=1 m=1
csn_c1_r050_0900_3_2 sn_c1_r050_0900_3_2 0 {C_SN}
XMWR_c1_r050_0900_3_3 sn_c1_r050_0900_3_3 0 0 0 sky130_fd_pr__nfet_01v8 L=0.15 W=0.42 nf=1 ad=0.1218 as=0.1218 pd=1.42 ps=1.42 nrd=0.69047619047619  nrs=0.69047619047619 sa=0 sb=0 sd=0 mult=1 m=1
XMRD_c1_r050_0900_3_3 rbl_c1_r050_0900_3 sn_c1_r050_0900_3_3 rwl_des 0 sky130_fd_pr__nfet_01v8 L=0.15 W=0.42 nf=1 ad=0.1218 as=0.1218 pd=1.42 ps=1.42 nrd=0.69047619047619  nrs=0.69047619047619 sa=0 sb=0 sd=0 mult=1 m=1
csn_c1_r050_0900_3_3 sn_c1_r050_0900_3_3 0 {C_SN}
crbl_c1_r050_0900_3 rbl_c1_r050_0900_3 0 {C_RBL}
spr_c1_r050_0900_3 pref_050 ref_c1_r050_0900_3 ctl 0 swpre
cref_c1_r050_0900_3 ref_c1_r050_0900_3 0 {C_RBL}   $ ASSUMPTION: ideal matched dummy load
XMN1_c1_r050_0900_3 rbl_c1_r050_0900_3 ref_c1_r050_0900_3 vn_c1_r050_0900_3 0 sky130_fd_pr__nfet_01v8 L=0.15 W=1 nf=1 ad=0.29 as=0.29 pd=2.58 ps=2.58 nrd=0.29 nrs=0.29 sa=0 sb=0 sd=0 mult=1 m=1
XMN2_c1_r050_0900_3 ref_c1_r050_0900_3 rbl_c1_r050_0900_3 vn_c1_r050_0900_3 0 sky130_fd_pr__nfet_01v8 L=0.15 W=1 nf=1 ad=0.29 as=0.29 pd=2.58 ps=2.58 nrd=0.29 nrs=0.29 sa=0 sb=0 sd=0 mult=1 m=1
XMP1_c1_r050_0900_3 rbl_c1_r050_0900_3 ref_c1_r050_0900_3 vp_c1_r050_0900_3 vdd sky130_fd_pr__pfet_01v8 L=0.15 W=2 nf=1 ad=0.58 as=0.58 pd=4.58 ps=4.58 nrd=0.145 nrs=0.145 sa=0 sb=0 sd=0 mult=1 m=1
XMP2_c1_r050_0900_3 ref_c1_r050_0900_3 rbl_c1_r050_0900_3 vp_c1_r050_0900_3 vdd sky130_fd_pr__pfet_01v8 L=0.15 W=2 nf=1 ad=0.58 as=0.58 pd=4.58 ps=4.58 nrd=0.145 nrs=0.145 sa=0 sb=0 sd=0 mult=1 m=1
XMNF_c1_r050_0900_3 vn_c1_r050_0900_3 en 0 0 sky130_fd_pr__nfet_01v8 L=0.15 W=2 nf=1 ad=0.58 as=0.58 pd=4.58 ps=4.58 nrd=0.145 nrs=0.145 sa=0 sb=0 sd=0 mult=1 m=1
XMPH_c1_r050_0900_3 vp_c1_r050_0900_3 enb vdd vdd sky130_fd_pr__pfet_01v8 L=0.15 W=4 nf=1 ad=1.16 as=1.16 pd=8.58 ps=8.58 nrd=0.0725 nrs=0.0725 sa=0 sb=0 sd=0 mult=1 m=1
bd_c1_r050_0900_3 d_c1_r050_0900_3 0 v=v(rbl_c1_r050_0900_3)-v(ref_c1_r050_0900_3)
bdabs_c1_r050_0900_3 dabs_c1_r050_0900_3 0 v=abs(v(rbl_c1_r050_0900_3)-v(ref_c1_r050_0900_3))

* ---- c1_r050_0950_0: cell1 SN = 0.95 V, ref offset 0.05 V, replica 0 ----
spa_c1_r050_0950_0 prea rbl_c1_r050_0950_0 ctl 0 swpre
XMWR_c1_r050_0950_0_0 sn_c1_r050_0950_0_0 0 0 0 sky130_fd_pr__nfet_01v8 L=0.15 W=0.42 nf=1 ad=0.1218 as=0.1218 pd=1.42 ps=1.42 nrd=0.69047619047619  nrs=0.69047619047619 sa=0 sb=0 sd=0 mult=1 m=1
XMRD_c1_r050_0950_0_0 rbl_c1_r050_0950_0 sn_c1_r050_0950_0_0 rwl_sel 0 sky130_fd_pr__nfet_01v8 L=0.15 W=0.42 nf=1 ad=0.1218 as=0.1218 pd=1.42 ps=1.42 nrd=0.69047619047619  nrs=0.69047619047619 sa=0 sb=0 sd=0 mult=1 m=1
csn_c1_r050_0950_0_0 sn_c1_r050_0950_0_0 0 {C_SN}
XMWR_c1_r050_0950_0_1 sn_c1_r050_0950_0_1 0 0 0 sky130_fd_pr__nfet_01v8 L=0.15 W=0.42 nf=1 ad=0.1218 as=0.1218 pd=1.42 ps=1.42 nrd=0.69047619047619  nrs=0.69047619047619 sa=0 sb=0 sd=0 mult=1 m=1
XMRD_c1_r050_0950_0_1 rbl_c1_r050_0950_0 sn_c1_r050_0950_0_1 rwl_des 0 sky130_fd_pr__nfet_01v8 L=0.15 W=0.42 nf=1 ad=0.1218 as=0.1218 pd=1.42 ps=1.42 nrd=0.69047619047619  nrs=0.69047619047619 sa=0 sb=0 sd=0 mult=1 m=1
csn_c1_r050_0950_0_1 sn_c1_r050_0950_0_1 0 {C_SN}
XMWR_c1_r050_0950_0_2 sn_c1_r050_0950_0_2 0 0 0 sky130_fd_pr__nfet_01v8 L=0.15 W=0.42 nf=1 ad=0.1218 as=0.1218 pd=1.42 ps=1.42 nrd=0.69047619047619  nrs=0.69047619047619 sa=0 sb=0 sd=0 mult=1 m=1
XMRD_c1_r050_0950_0_2 rbl_c1_r050_0950_0 sn_c1_r050_0950_0_2 rwl_des 0 sky130_fd_pr__nfet_01v8 L=0.15 W=0.42 nf=1 ad=0.1218 as=0.1218 pd=1.42 ps=1.42 nrd=0.69047619047619  nrs=0.69047619047619 sa=0 sb=0 sd=0 mult=1 m=1
csn_c1_r050_0950_0_2 sn_c1_r050_0950_0_2 0 {C_SN}
XMWR_c1_r050_0950_0_3 sn_c1_r050_0950_0_3 0 0 0 sky130_fd_pr__nfet_01v8 L=0.15 W=0.42 nf=1 ad=0.1218 as=0.1218 pd=1.42 ps=1.42 nrd=0.69047619047619  nrs=0.69047619047619 sa=0 sb=0 sd=0 mult=1 m=1
XMRD_c1_r050_0950_0_3 rbl_c1_r050_0950_0 sn_c1_r050_0950_0_3 rwl_des 0 sky130_fd_pr__nfet_01v8 L=0.15 W=0.42 nf=1 ad=0.1218 as=0.1218 pd=1.42 ps=1.42 nrd=0.69047619047619  nrs=0.69047619047619 sa=0 sb=0 sd=0 mult=1 m=1
csn_c1_r050_0950_0_3 sn_c1_r050_0950_0_3 0 {C_SN}
crbl_c1_r050_0950_0 rbl_c1_r050_0950_0 0 {C_RBL}
spr_c1_r050_0950_0 pref_050 ref_c1_r050_0950_0 ctl 0 swpre
cref_c1_r050_0950_0 ref_c1_r050_0950_0 0 {C_RBL}   $ ASSUMPTION: ideal matched dummy load
XMN1_c1_r050_0950_0 rbl_c1_r050_0950_0 ref_c1_r050_0950_0 vn_c1_r050_0950_0 0 sky130_fd_pr__nfet_01v8 L=0.15 W=1 nf=1 ad=0.29 as=0.29 pd=2.58 ps=2.58 nrd=0.29 nrs=0.29 sa=0 sb=0 sd=0 mult=1 m=1
XMN2_c1_r050_0950_0 ref_c1_r050_0950_0 rbl_c1_r050_0950_0 vn_c1_r050_0950_0 0 sky130_fd_pr__nfet_01v8 L=0.15 W=1 nf=1 ad=0.29 as=0.29 pd=2.58 ps=2.58 nrd=0.29 nrs=0.29 sa=0 sb=0 sd=0 mult=1 m=1
XMP1_c1_r050_0950_0 rbl_c1_r050_0950_0 ref_c1_r050_0950_0 vp_c1_r050_0950_0 vdd sky130_fd_pr__pfet_01v8 L=0.15 W=2 nf=1 ad=0.58 as=0.58 pd=4.58 ps=4.58 nrd=0.145 nrs=0.145 sa=0 sb=0 sd=0 mult=1 m=1
XMP2_c1_r050_0950_0 ref_c1_r050_0950_0 rbl_c1_r050_0950_0 vp_c1_r050_0950_0 vdd sky130_fd_pr__pfet_01v8 L=0.15 W=2 nf=1 ad=0.58 as=0.58 pd=4.58 ps=4.58 nrd=0.145 nrs=0.145 sa=0 sb=0 sd=0 mult=1 m=1
XMNF_c1_r050_0950_0 vn_c1_r050_0950_0 en 0 0 sky130_fd_pr__nfet_01v8 L=0.15 W=2 nf=1 ad=0.58 as=0.58 pd=4.58 ps=4.58 nrd=0.145 nrs=0.145 sa=0 sb=0 sd=0 mult=1 m=1
XMPH_c1_r050_0950_0 vp_c1_r050_0950_0 enb vdd vdd sky130_fd_pr__pfet_01v8 L=0.15 W=4 nf=1 ad=1.16 as=1.16 pd=8.58 ps=8.58 nrd=0.0725 nrs=0.0725 sa=0 sb=0 sd=0 mult=1 m=1
bd_c1_r050_0950_0 d_c1_r050_0950_0 0 v=v(rbl_c1_r050_0950_0)-v(ref_c1_r050_0950_0)
bdabs_c1_r050_0950_0 dabs_c1_r050_0950_0 0 v=abs(v(rbl_c1_r050_0950_0)-v(ref_c1_r050_0950_0))

* ---- c1_r050_0950_1: cell1 SN = 0.95 V, ref offset 0.05 V, replica 1 ----
spa_c1_r050_0950_1 prea rbl_c1_r050_0950_1 ctl 0 swpre
XMWR_c1_r050_0950_1_0 sn_c1_r050_0950_1_0 0 0 0 sky130_fd_pr__nfet_01v8 L=0.15 W=0.42 nf=1 ad=0.1218 as=0.1218 pd=1.42 ps=1.42 nrd=0.69047619047619  nrs=0.69047619047619 sa=0 sb=0 sd=0 mult=1 m=1
XMRD_c1_r050_0950_1_0 rbl_c1_r050_0950_1 sn_c1_r050_0950_1_0 rwl_sel 0 sky130_fd_pr__nfet_01v8 L=0.15 W=0.42 nf=1 ad=0.1218 as=0.1218 pd=1.42 ps=1.42 nrd=0.69047619047619  nrs=0.69047619047619 sa=0 sb=0 sd=0 mult=1 m=1
csn_c1_r050_0950_1_0 sn_c1_r050_0950_1_0 0 {C_SN}
XMWR_c1_r050_0950_1_1 sn_c1_r050_0950_1_1 0 0 0 sky130_fd_pr__nfet_01v8 L=0.15 W=0.42 nf=1 ad=0.1218 as=0.1218 pd=1.42 ps=1.42 nrd=0.69047619047619  nrs=0.69047619047619 sa=0 sb=0 sd=0 mult=1 m=1
XMRD_c1_r050_0950_1_1 rbl_c1_r050_0950_1 sn_c1_r050_0950_1_1 rwl_des 0 sky130_fd_pr__nfet_01v8 L=0.15 W=0.42 nf=1 ad=0.1218 as=0.1218 pd=1.42 ps=1.42 nrd=0.69047619047619  nrs=0.69047619047619 sa=0 sb=0 sd=0 mult=1 m=1
csn_c1_r050_0950_1_1 sn_c1_r050_0950_1_1 0 {C_SN}
XMWR_c1_r050_0950_1_2 sn_c1_r050_0950_1_2 0 0 0 sky130_fd_pr__nfet_01v8 L=0.15 W=0.42 nf=1 ad=0.1218 as=0.1218 pd=1.42 ps=1.42 nrd=0.69047619047619  nrs=0.69047619047619 sa=0 sb=0 sd=0 mult=1 m=1
XMRD_c1_r050_0950_1_2 rbl_c1_r050_0950_1 sn_c1_r050_0950_1_2 rwl_des 0 sky130_fd_pr__nfet_01v8 L=0.15 W=0.42 nf=1 ad=0.1218 as=0.1218 pd=1.42 ps=1.42 nrd=0.69047619047619  nrs=0.69047619047619 sa=0 sb=0 sd=0 mult=1 m=1
csn_c1_r050_0950_1_2 sn_c1_r050_0950_1_2 0 {C_SN}
XMWR_c1_r050_0950_1_3 sn_c1_r050_0950_1_3 0 0 0 sky130_fd_pr__nfet_01v8 L=0.15 W=0.42 nf=1 ad=0.1218 as=0.1218 pd=1.42 ps=1.42 nrd=0.69047619047619  nrs=0.69047619047619 sa=0 sb=0 sd=0 mult=1 m=1
XMRD_c1_r050_0950_1_3 rbl_c1_r050_0950_1 sn_c1_r050_0950_1_3 rwl_des 0 sky130_fd_pr__nfet_01v8 L=0.15 W=0.42 nf=1 ad=0.1218 as=0.1218 pd=1.42 ps=1.42 nrd=0.69047619047619  nrs=0.69047619047619 sa=0 sb=0 sd=0 mult=1 m=1
csn_c1_r050_0950_1_3 sn_c1_r050_0950_1_3 0 {C_SN}
crbl_c1_r050_0950_1 rbl_c1_r050_0950_1 0 {C_RBL}
spr_c1_r050_0950_1 pref_050 ref_c1_r050_0950_1 ctl 0 swpre
cref_c1_r050_0950_1 ref_c1_r050_0950_1 0 {C_RBL}   $ ASSUMPTION: ideal matched dummy load
XMN1_c1_r050_0950_1 rbl_c1_r050_0950_1 ref_c1_r050_0950_1 vn_c1_r050_0950_1 0 sky130_fd_pr__nfet_01v8 L=0.15 W=1 nf=1 ad=0.29 as=0.29 pd=2.58 ps=2.58 nrd=0.29 nrs=0.29 sa=0 sb=0 sd=0 mult=1 m=1
XMN2_c1_r050_0950_1 ref_c1_r050_0950_1 rbl_c1_r050_0950_1 vn_c1_r050_0950_1 0 sky130_fd_pr__nfet_01v8 L=0.15 W=1 nf=1 ad=0.29 as=0.29 pd=2.58 ps=2.58 nrd=0.29 nrs=0.29 sa=0 sb=0 sd=0 mult=1 m=1
XMP1_c1_r050_0950_1 rbl_c1_r050_0950_1 ref_c1_r050_0950_1 vp_c1_r050_0950_1 vdd sky130_fd_pr__pfet_01v8 L=0.15 W=2 nf=1 ad=0.58 as=0.58 pd=4.58 ps=4.58 nrd=0.145 nrs=0.145 sa=0 sb=0 sd=0 mult=1 m=1
XMP2_c1_r050_0950_1 ref_c1_r050_0950_1 rbl_c1_r050_0950_1 vp_c1_r050_0950_1 vdd sky130_fd_pr__pfet_01v8 L=0.15 W=2 nf=1 ad=0.58 as=0.58 pd=4.58 ps=4.58 nrd=0.145 nrs=0.145 sa=0 sb=0 sd=0 mult=1 m=1
XMNF_c1_r050_0950_1 vn_c1_r050_0950_1 en 0 0 sky130_fd_pr__nfet_01v8 L=0.15 W=2 nf=1 ad=0.58 as=0.58 pd=4.58 ps=4.58 nrd=0.145 nrs=0.145 sa=0 sb=0 sd=0 mult=1 m=1
XMPH_c1_r050_0950_1 vp_c1_r050_0950_1 enb vdd vdd sky130_fd_pr__pfet_01v8 L=0.15 W=4 nf=1 ad=1.16 as=1.16 pd=8.58 ps=8.58 nrd=0.0725 nrs=0.0725 sa=0 sb=0 sd=0 mult=1 m=1
bd_c1_r050_0950_1 d_c1_r050_0950_1 0 v=v(rbl_c1_r050_0950_1)-v(ref_c1_r050_0950_1)
bdabs_c1_r050_0950_1 dabs_c1_r050_0950_1 0 v=abs(v(rbl_c1_r050_0950_1)-v(ref_c1_r050_0950_1))

* ---- c1_r050_0950_2: cell1 SN = 0.95 V, ref offset 0.05 V, replica 2 ----
spa_c1_r050_0950_2 prea rbl_c1_r050_0950_2 ctl 0 swpre
XMWR_c1_r050_0950_2_0 sn_c1_r050_0950_2_0 0 0 0 sky130_fd_pr__nfet_01v8 L=0.15 W=0.42 nf=1 ad=0.1218 as=0.1218 pd=1.42 ps=1.42 nrd=0.69047619047619  nrs=0.69047619047619 sa=0 sb=0 sd=0 mult=1 m=1
XMRD_c1_r050_0950_2_0 rbl_c1_r050_0950_2 sn_c1_r050_0950_2_0 rwl_sel 0 sky130_fd_pr__nfet_01v8 L=0.15 W=0.42 nf=1 ad=0.1218 as=0.1218 pd=1.42 ps=1.42 nrd=0.69047619047619  nrs=0.69047619047619 sa=0 sb=0 sd=0 mult=1 m=1
csn_c1_r050_0950_2_0 sn_c1_r050_0950_2_0 0 {C_SN}
XMWR_c1_r050_0950_2_1 sn_c1_r050_0950_2_1 0 0 0 sky130_fd_pr__nfet_01v8 L=0.15 W=0.42 nf=1 ad=0.1218 as=0.1218 pd=1.42 ps=1.42 nrd=0.69047619047619  nrs=0.69047619047619 sa=0 sb=0 sd=0 mult=1 m=1
XMRD_c1_r050_0950_2_1 rbl_c1_r050_0950_2 sn_c1_r050_0950_2_1 rwl_des 0 sky130_fd_pr__nfet_01v8 L=0.15 W=0.42 nf=1 ad=0.1218 as=0.1218 pd=1.42 ps=1.42 nrd=0.69047619047619  nrs=0.69047619047619 sa=0 sb=0 sd=0 mult=1 m=1
csn_c1_r050_0950_2_1 sn_c1_r050_0950_2_1 0 {C_SN}
XMWR_c1_r050_0950_2_2 sn_c1_r050_0950_2_2 0 0 0 sky130_fd_pr__nfet_01v8 L=0.15 W=0.42 nf=1 ad=0.1218 as=0.1218 pd=1.42 ps=1.42 nrd=0.69047619047619  nrs=0.69047619047619 sa=0 sb=0 sd=0 mult=1 m=1
XMRD_c1_r050_0950_2_2 rbl_c1_r050_0950_2 sn_c1_r050_0950_2_2 rwl_des 0 sky130_fd_pr__nfet_01v8 L=0.15 W=0.42 nf=1 ad=0.1218 as=0.1218 pd=1.42 ps=1.42 nrd=0.69047619047619  nrs=0.69047619047619 sa=0 sb=0 sd=0 mult=1 m=1
csn_c1_r050_0950_2_2 sn_c1_r050_0950_2_2 0 {C_SN}
XMWR_c1_r050_0950_2_3 sn_c1_r050_0950_2_3 0 0 0 sky130_fd_pr__nfet_01v8 L=0.15 W=0.42 nf=1 ad=0.1218 as=0.1218 pd=1.42 ps=1.42 nrd=0.69047619047619  nrs=0.69047619047619 sa=0 sb=0 sd=0 mult=1 m=1
XMRD_c1_r050_0950_2_3 rbl_c1_r050_0950_2 sn_c1_r050_0950_2_3 rwl_des 0 sky130_fd_pr__nfet_01v8 L=0.15 W=0.42 nf=1 ad=0.1218 as=0.1218 pd=1.42 ps=1.42 nrd=0.69047619047619  nrs=0.69047619047619 sa=0 sb=0 sd=0 mult=1 m=1
csn_c1_r050_0950_2_3 sn_c1_r050_0950_2_3 0 {C_SN}
crbl_c1_r050_0950_2 rbl_c1_r050_0950_2 0 {C_RBL}
spr_c1_r050_0950_2 pref_050 ref_c1_r050_0950_2 ctl 0 swpre
cref_c1_r050_0950_2 ref_c1_r050_0950_2 0 {C_RBL}   $ ASSUMPTION: ideal matched dummy load
XMN1_c1_r050_0950_2 rbl_c1_r050_0950_2 ref_c1_r050_0950_2 vn_c1_r050_0950_2 0 sky130_fd_pr__nfet_01v8 L=0.15 W=1 nf=1 ad=0.29 as=0.29 pd=2.58 ps=2.58 nrd=0.29 nrs=0.29 sa=0 sb=0 sd=0 mult=1 m=1
XMN2_c1_r050_0950_2 ref_c1_r050_0950_2 rbl_c1_r050_0950_2 vn_c1_r050_0950_2 0 sky130_fd_pr__nfet_01v8 L=0.15 W=1 nf=1 ad=0.29 as=0.29 pd=2.58 ps=2.58 nrd=0.29 nrs=0.29 sa=0 sb=0 sd=0 mult=1 m=1
XMP1_c1_r050_0950_2 rbl_c1_r050_0950_2 ref_c1_r050_0950_2 vp_c1_r050_0950_2 vdd sky130_fd_pr__pfet_01v8 L=0.15 W=2 nf=1 ad=0.58 as=0.58 pd=4.58 ps=4.58 nrd=0.145 nrs=0.145 sa=0 sb=0 sd=0 mult=1 m=1
XMP2_c1_r050_0950_2 ref_c1_r050_0950_2 rbl_c1_r050_0950_2 vp_c1_r050_0950_2 vdd sky130_fd_pr__pfet_01v8 L=0.15 W=2 nf=1 ad=0.58 as=0.58 pd=4.58 ps=4.58 nrd=0.145 nrs=0.145 sa=0 sb=0 sd=0 mult=1 m=1
XMNF_c1_r050_0950_2 vn_c1_r050_0950_2 en 0 0 sky130_fd_pr__nfet_01v8 L=0.15 W=2 nf=1 ad=0.58 as=0.58 pd=4.58 ps=4.58 nrd=0.145 nrs=0.145 sa=0 sb=0 sd=0 mult=1 m=1
XMPH_c1_r050_0950_2 vp_c1_r050_0950_2 enb vdd vdd sky130_fd_pr__pfet_01v8 L=0.15 W=4 nf=1 ad=1.16 as=1.16 pd=8.58 ps=8.58 nrd=0.0725 nrs=0.0725 sa=0 sb=0 sd=0 mult=1 m=1
bd_c1_r050_0950_2 d_c1_r050_0950_2 0 v=v(rbl_c1_r050_0950_2)-v(ref_c1_r050_0950_2)
bdabs_c1_r050_0950_2 dabs_c1_r050_0950_2 0 v=abs(v(rbl_c1_r050_0950_2)-v(ref_c1_r050_0950_2))

* ---- c1_r050_0950_3: cell1 SN = 0.95 V, ref offset 0.05 V, replica 3 ----
spa_c1_r050_0950_3 prea rbl_c1_r050_0950_3 ctl 0 swpre
XMWR_c1_r050_0950_3_0 sn_c1_r050_0950_3_0 0 0 0 sky130_fd_pr__nfet_01v8 L=0.15 W=0.42 nf=1 ad=0.1218 as=0.1218 pd=1.42 ps=1.42 nrd=0.69047619047619  nrs=0.69047619047619 sa=0 sb=0 sd=0 mult=1 m=1
XMRD_c1_r050_0950_3_0 rbl_c1_r050_0950_3 sn_c1_r050_0950_3_0 rwl_sel 0 sky130_fd_pr__nfet_01v8 L=0.15 W=0.42 nf=1 ad=0.1218 as=0.1218 pd=1.42 ps=1.42 nrd=0.69047619047619  nrs=0.69047619047619 sa=0 sb=0 sd=0 mult=1 m=1
csn_c1_r050_0950_3_0 sn_c1_r050_0950_3_0 0 {C_SN}
XMWR_c1_r050_0950_3_1 sn_c1_r050_0950_3_1 0 0 0 sky130_fd_pr__nfet_01v8 L=0.15 W=0.42 nf=1 ad=0.1218 as=0.1218 pd=1.42 ps=1.42 nrd=0.69047619047619  nrs=0.69047619047619 sa=0 sb=0 sd=0 mult=1 m=1
XMRD_c1_r050_0950_3_1 rbl_c1_r050_0950_3 sn_c1_r050_0950_3_1 rwl_des 0 sky130_fd_pr__nfet_01v8 L=0.15 W=0.42 nf=1 ad=0.1218 as=0.1218 pd=1.42 ps=1.42 nrd=0.69047619047619  nrs=0.69047619047619 sa=0 sb=0 sd=0 mult=1 m=1
csn_c1_r050_0950_3_1 sn_c1_r050_0950_3_1 0 {C_SN}
XMWR_c1_r050_0950_3_2 sn_c1_r050_0950_3_2 0 0 0 sky130_fd_pr__nfet_01v8 L=0.15 W=0.42 nf=1 ad=0.1218 as=0.1218 pd=1.42 ps=1.42 nrd=0.69047619047619  nrs=0.69047619047619 sa=0 sb=0 sd=0 mult=1 m=1
XMRD_c1_r050_0950_3_2 rbl_c1_r050_0950_3 sn_c1_r050_0950_3_2 rwl_des 0 sky130_fd_pr__nfet_01v8 L=0.15 W=0.42 nf=1 ad=0.1218 as=0.1218 pd=1.42 ps=1.42 nrd=0.69047619047619  nrs=0.69047619047619 sa=0 sb=0 sd=0 mult=1 m=1
csn_c1_r050_0950_3_2 sn_c1_r050_0950_3_2 0 {C_SN}
XMWR_c1_r050_0950_3_3 sn_c1_r050_0950_3_3 0 0 0 sky130_fd_pr__nfet_01v8 L=0.15 W=0.42 nf=1 ad=0.1218 as=0.1218 pd=1.42 ps=1.42 nrd=0.69047619047619  nrs=0.69047619047619 sa=0 sb=0 sd=0 mult=1 m=1
XMRD_c1_r050_0950_3_3 rbl_c1_r050_0950_3 sn_c1_r050_0950_3_3 rwl_des 0 sky130_fd_pr__nfet_01v8 L=0.15 W=0.42 nf=1 ad=0.1218 as=0.1218 pd=1.42 ps=1.42 nrd=0.69047619047619  nrs=0.69047619047619 sa=0 sb=0 sd=0 mult=1 m=1
csn_c1_r050_0950_3_3 sn_c1_r050_0950_3_3 0 {C_SN}
crbl_c1_r050_0950_3 rbl_c1_r050_0950_3 0 {C_RBL}
spr_c1_r050_0950_3 pref_050 ref_c1_r050_0950_3 ctl 0 swpre
cref_c1_r050_0950_3 ref_c1_r050_0950_3 0 {C_RBL}   $ ASSUMPTION: ideal matched dummy load
XMN1_c1_r050_0950_3 rbl_c1_r050_0950_3 ref_c1_r050_0950_3 vn_c1_r050_0950_3 0 sky130_fd_pr__nfet_01v8 L=0.15 W=1 nf=1 ad=0.29 as=0.29 pd=2.58 ps=2.58 nrd=0.29 nrs=0.29 sa=0 sb=0 sd=0 mult=1 m=1
XMN2_c1_r050_0950_3 ref_c1_r050_0950_3 rbl_c1_r050_0950_3 vn_c1_r050_0950_3 0 sky130_fd_pr__nfet_01v8 L=0.15 W=1 nf=1 ad=0.29 as=0.29 pd=2.58 ps=2.58 nrd=0.29 nrs=0.29 sa=0 sb=0 sd=0 mult=1 m=1
XMP1_c1_r050_0950_3 rbl_c1_r050_0950_3 ref_c1_r050_0950_3 vp_c1_r050_0950_3 vdd sky130_fd_pr__pfet_01v8 L=0.15 W=2 nf=1 ad=0.58 as=0.58 pd=4.58 ps=4.58 nrd=0.145 nrs=0.145 sa=0 sb=0 sd=0 mult=1 m=1
XMP2_c1_r050_0950_3 ref_c1_r050_0950_3 rbl_c1_r050_0950_3 vp_c1_r050_0950_3 vdd sky130_fd_pr__pfet_01v8 L=0.15 W=2 nf=1 ad=0.58 as=0.58 pd=4.58 ps=4.58 nrd=0.145 nrs=0.145 sa=0 sb=0 sd=0 mult=1 m=1
XMNF_c1_r050_0950_3 vn_c1_r050_0950_3 en 0 0 sky130_fd_pr__nfet_01v8 L=0.15 W=2 nf=1 ad=0.58 as=0.58 pd=4.58 ps=4.58 nrd=0.145 nrs=0.145 sa=0 sb=0 sd=0 mult=1 m=1
XMPH_c1_r050_0950_3 vp_c1_r050_0950_3 enb vdd vdd sky130_fd_pr__pfet_01v8 L=0.15 W=4 nf=1 ad=1.16 as=1.16 pd=8.58 ps=8.58 nrd=0.0725 nrs=0.0725 sa=0 sb=0 sd=0 mult=1 m=1
bd_c1_r050_0950_3 d_c1_r050_0950_3 0 v=v(rbl_c1_r050_0950_3)-v(ref_c1_r050_0950_3)
bdabs_c1_r050_0950_3 dabs_c1_r050_0950_3 0 v=abs(v(rbl_c1_r050_0950_3)-v(ref_c1_r050_0950_3))

* ---- c1_r050_1000_0: cell1 SN = 1.0 V, ref offset 0.05 V, replica 0 ----
spa_c1_r050_1000_0 prea rbl_c1_r050_1000_0 ctl 0 swpre
XMWR_c1_r050_1000_0_0 sn_c1_r050_1000_0_0 0 0 0 sky130_fd_pr__nfet_01v8 L=0.15 W=0.42 nf=1 ad=0.1218 as=0.1218 pd=1.42 ps=1.42 nrd=0.69047619047619  nrs=0.69047619047619 sa=0 sb=0 sd=0 mult=1 m=1
XMRD_c1_r050_1000_0_0 rbl_c1_r050_1000_0 sn_c1_r050_1000_0_0 rwl_sel 0 sky130_fd_pr__nfet_01v8 L=0.15 W=0.42 nf=1 ad=0.1218 as=0.1218 pd=1.42 ps=1.42 nrd=0.69047619047619  nrs=0.69047619047619 sa=0 sb=0 sd=0 mult=1 m=1
csn_c1_r050_1000_0_0 sn_c1_r050_1000_0_0 0 {C_SN}
XMWR_c1_r050_1000_0_1 sn_c1_r050_1000_0_1 0 0 0 sky130_fd_pr__nfet_01v8 L=0.15 W=0.42 nf=1 ad=0.1218 as=0.1218 pd=1.42 ps=1.42 nrd=0.69047619047619  nrs=0.69047619047619 sa=0 sb=0 sd=0 mult=1 m=1
XMRD_c1_r050_1000_0_1 rbl_c1_r050_1000_0 sn_c1_r050_1000_0_1 rwl_des 0 sky130_fd_pr__nfet_01v8 L=0.15 W=0.42 nf=1 ad=0.1218 as=0.1218 pd=1.42 ps=1.42 nrd=0.69047619047619  nrs=0.69047619047619 sa=0 sb=0 sd=0 mult=1 m=1
csn_c1_r050_1000_0_1 sn_c1_r050_1000_0_1 0 {C_SN}
XMWR_c1_r050_1000_0_2 sn_c1_r050_1000_0_2 0 0 0 sky130_fd_pr__nfet_01v8 L=0.15 W=0.42 nf=1 ad=0.1218 as=0.1218 pd=1.42 ps=1.42 nrd=0.69047619047619  nrs=0.69047619047619 sa=0 sb=0 sd=0 mult=1 m=1
XMRD_c1_r050_1000_0_2 rbl_c1_r050_1000_0 sn_c1_r050_1000_0_2 rwl_des 0 sky130_fd_pr__nfet_01v8 L=0.15 W=0.42 nf=1 ad=0.1218 as=0.1218 pd=1.42 ps=1.42 nrd=0.69047619047619  nrs=0.69047619047619 sa=0 sb=0 sd=0 mult=1 m=1
csn_c1_r050_1000_0_2 sn_c1_r050_1000_0_2 0 {C_SN}
XMWR_c1_r050_1000_0_3 sn_c1_r050_1000_0_3 0 0 0 sky130_fd_pr__nfet_01v8 L=0.15 W=0.42 nf=1 ad=0.1218 as=0.1218 pd=1.42 ps=1.42 nrd=0.69047619047619  nrs=0.69047619047619 sa=0 sb=0 sd=0 mult=1 m=1
XMRD_c1_r050_1000_0_3 rbl_c1_r050_1000_0 sn_c1_r050_1000_0_3 rwl_des 0 sky130_fd_pr__nfet_01v8 L=0.15 W=0.42 nf=1 ad=0.1218 as=0.1218 pd=1.42 ps=1.42 nrd=0.69047619047619  nrs=0.69047619047619 sa=0 sb=0 sd=0 mult=1 m=1
csn_c1_r050_1000_0_3 sn_c1_r050_1000_0_3 0 {C_SN}
crbl_c1_r050_1000_0 rbl_c1_r050_1000_0 0 {C_RBL}
spr_c1_r050_1000_0 pref_050 ref_c1_r050_1000_0 ctl 0 swpre
cref_c1_r050_1000_0 ref_c1_r050_1000_0 0 {C_RBL}   $ ASSUMPTION: ideal matched dummy load
XMN1_c1_r050_1000_0 rbl_c1_r050_1000_0 ref_c1_r050_1000_0 vn_c1_r050_1000_0 0 sky130_fd_pr__nfet_01v8 L=0.15 W=1 nf=1 ad=0.29 as=0.29 pd=2.58 ps=2.58 nrd=0.29 nrs=0.29 sa=0 sb=0 sd=0 mult=1 m=1
XMN2_c1_r050_1000_0 ref_c1_r050_1000_0 rbl_c1_r050_1000_0 vn_c1_r050_1000_0 0 sky130_fd_pr__nfet_01v8 L=0.15 W=1 nf=1 ad=0.29 as=0.29 pd=2.58 ps=2.58 nrd=0.29 nrs=0.29 sa=0 sb=0 sd=0 mult=1 m=1
XMP1_c1_r050_1000_0 rbl_c1_r050_1000_0 ref_c1_r050_1000_0 vp_c1_r050_1000_0 vdd sky130_fd_pr__pfet_01v8 L=0.15 W=2 nf=1 ad=0.58 as=0.58 pd=4.58 ps=4.58 nrd=0.145 nrs=0.145 sa=0 sb=0 sd=0 mult=1 m=1
XMP2_c1_r050_1000_0 ref_c1_r050_1000_0 rbl_c1_r050_1000_0 vp_c1_r050_1000_0 vdd sky130_fd_pr__pfet_01v8 L=0.15 W=2 nf=1 ad=0.58 as=0.58 pd=4.58 ps=4.58 nrd=0.145 nrs=0.145 sa=0 sb=0 sd=0 mult=1 m=1
XMNF_c1_r050_1000_0 vn_c1_r050_1000_0 en 0 0 sky130_fd_pr__nfet_01v8 L=0.15 W=2 nf=1 ad=0.58 as=0.58 pd=4.58 ps=4.58 nrd=0.145 nrs=0.145 sa=0 sb=0 sd=0 mult=1 m=1
XMPH_c1_r050_1000_0 vp_c1_r050_1000_0 enb vdd vdd sky130_fd_pr__pfet_01v8 L=0.15 W=4 nf=1 ad=1.16 as=1.16 pd=8.58 ps=8.58 nrd=0.0725 nrs=0.0725 sa=0 sb=0 sd=0 mult=1 m=1
bd_c1_r050_1000_0 d_c1_r050_1000_0 0 v=v(rbl_c1_r050_1000_0)-v(ref_c1_r050_1000_0)
bdabs_c1_r050_1000_0 dabs_c1_r050_1000_0 0 v=abs(v(rbl_c1_r050_1000_0)-v(ref_c1_r050_1000_0))

* ---- c1_r050_1000_1: cell1 SN = 1.0 V, ref offset 0.05 V, replica 1 ----
spa_c1_r050_1000_1 prea rbl_c1_r050_1000_1 ctl 0 swpre
XMWR_c1_r050_1000_1_0 sn_c1_r050_1000_1_0 0 0 0 sky130_fd_pr__nfet_01v8 L=0.15 W=0.42 nf=1 ad=0.1218 as=0.1218 pd=1.42 ps=1.42 nrd=0.69047619047619  nrs=0.69047619047619 sa=0 sb=0 sd=0 mult=1 m=1
XMRD_c1_r050_1000_1_0 rbl_c1_r050_1000_1 sn_c1_r050_1000_1_0 rwl_sel 0 sky130_fd_pr__nfet_01v8 L=0.15 W=0.42 nf=1 ad=0.1218 as=0.1218 pd=1.42 ps=1.42 nrd=0.69047619047619  nrs=0.69047619047619 sa=0 sb=0 sd=0 mult=1 m=1
csn_c1_r050_1000_1_0 sn_c1_r050_1000_1_0 0 {C_SN}
XMWR_c1_r050_1000_1_1 sn_c1_r050_1000_1_1 0 0 0 sky130_fd_pr__nfet_01v8 L=0.15 W=0.42 nf=1 ad=0.1218 as=0.1218 pd=1.42 ps=1.42 nrd=0.69047619047619  nrs=0.69047619047619 sa=0 sb=0 sd=0 mult=1 m=1
XMRD_c1_r050_1000_1_1 rbl_c1_r050_1000_1 sn_c1_r050_1000_1_1 rwl_des 0 sky130_fd_pr__nfet_01v8 L=0.15 W=0.42 nf=1 ad=0.1218 as=0.1218 pd=1.42 ps=1.42 nrd=0.69047619047619  nrs=0.69047619047619 sa=0 sb=0 sd=0 mult=1 m=1
csn_c1_r050_1000_1_1 sn_c1_r050_1000_1_1 0 {C_SN}
XMWR_c1_r050_1000_1_2 sn_c1_r050_1000_1_2 0 0 0 sky130_fd_pr__nfet_01v8 L=0.15 W=0.42 nf=1 ad=0.1218 as=0.1218 pd=1.42 ps=1.42 nrd=0.69047619047619  nrs=0.69047619047619 sa=0 sb=0 sd=0 mult=1 m=1
XMRD_c1_r050_1000_1_2 rbl_c1_r050_1000_1 sn_c1_r050_1000_1_2 rwl_des 0 sky130_fd_pr__nfet_01v8 L=0.15 W=0.42 nf=1 ad=0.1218 as=0.1218 pd=1.42 ps=1.42 nrd=0.69047619047619  nrs=0.69047619047619 sa=0 sb=0 sd=0 mult=1 m=1
csn_c1_r050_1000_1_2 sn_c1_r050_1000_1_2 0 {C_SN}
XMWR_c1_r050_1000_1_3 sn_c1_r050_1000_1_3 0 0 0 sky130_fd_pr__nfet_01v8 L=0.15 W=0.42 nf=1 ad=0.1218 as=0.1218 pd=1.42 ps=1.42 nrd=0.69047619047619  nrs=0.69047619047619 sa=0 sb=0 sd=0 mult=1 m=1
XMRD_c1_r050_1000_1_3 rbl_c1_r050_1000_1 sn_c1_r050_1000_1_3 rwl_des 0 sky130_fd_pr__nfet_01v8 L=0.15 W=0.42 nf=1 ad=0.1218 as=0.1218 pd=1.42 ps=1.42 nrd=0.69047619047619  nrs=0.69047619047619 sa=0 sb=0 sd=0 mult=1 m=1
csn_c1_r050_1000_1_3 sn_c1_r050_1000_1_3 0 {C_SN}
crbl_c1_r050_1000_1 rbl_c1_r050_1000_1 0 {C_RBL}
spr_c1_r050_1000_1 pref_050 ref_c1_r050_1000_1 ctl 0 swpre
cref_c1_r050_1000_1 ref_c1_r050_1000_1 0 {C_RBL}   $ ASSUMPTION: ideal matched dummy load
XMN1_c1_r050_1000_1 rbl_c1_r050_1000_1 ref_c1_r050_1000_1 vn_c1_r050_1000_1 0 sky130_fd_pr__nfet_01v8 L=0.15 W=1 nf=1 ad=0.29 as=0.29 pd=2.58 ps=2.58 nrd=0.29 nrs=0.29 sa=0 sb=0 sd=0 mult=1 m=1
XMN2_c1_r050_1000_1 ref_c1_r050_1000_1 rbl_c1_r050_1000_1 vn_c1_r050_1000_1 0 sky130_fd_pr__nfet_01v8 L=0.15 W=1 nf=1 ad=0.29 as=0.29 pd=2.58 ps=2.58 nrd=0.29 nrs=0.29 sa=0 sb=0 sd=0 mult=1 m=1
XMP1_c1_r050_1000_1 rbl_c1_r050_1000_1 ref_c1_r050_1000_1 vp_c1_r050_1000_1 vdd sky130_fd_pr__pfet_01v8 L=0.15 W=2 nf=1 ad=0.58 as=0.58 pd=4.58 ps=4.58 nrd=0.145 nrs=0.145 sa=0 sb=0 sd=0 mult=1 m=1
XMP2_c1_r050_1000_1 ref_c1_r050_1000_1 rbl_c1_r050_1000_1 vp_c1_r050_1000_1 vdd sky130_fd_pr__pfet_01v8 L=0.15 W=2 nf=1 ad=0.58 as=0.58 pd=4.58 ps=4.58 nrd=0.145 nrs=0.145 sa=0 sb=0 sd=0 mult=1 m=1
XMNF_c1_r050_1000_1 vn_c1_r050_1000_1 en 0 0 sky130_fd_pr__nfet_01v8 L=0.15 W=2 nf=1 ad=0.58 as=0.58 pd=4.58 ps=4.58 nrd=0.145 nrs=0.145 sa=0 sb=0 sd=0 mult=1 m=1
XMPH_c1_r050_1000_1 vp_c1_r050_1000_1 enb vdd vdd sky130_fd_pr__pfet_01v8 L=0.15 W=4 nf=1 ad=1.16 as=1.16 pd=8.58 ps=8.58 nrd=0.0725 nrs=0.0725 sa=0 sb=0 sd=0 mult=1 m=1
bd_c1_r050_1000_1 d_c1_r050_1000_1 0 v=v(rbl_c1_r050_1000_1)-v(ref_c1_r050_1000_1)
bdabs_c1_r050_1000_1 dabs_c1_r050_1000_1 0 v=abs(v(rbl_c1_r050_1000_1)-v(ref_c1_r050_1000_1))

* ---- c1_r050_1000_2: cell1 SN = 1.0 V, ref offset 0.05 V, replica 2 ----
spa_c1_r050_1000_2 prea rbl_c1_r050_1000_2 ctl 0 swpre
XMWR_c1_r050_1000_2_0 sn_c1_r050_1000_2_0 0 0 0 sky130_fd_pr__nfet_01v8 L=0.15 W=0.42 nf=1 ad=0.1218 as=0.1218 pd=1.42 ps=1.42 nrd=0.69047619047619  nrs=0.69047619047619 sa=0 sb=0 sd=0 mult=1 m=1
XMRD_c1_r050_1000_2_0 rbl_c1_r050_1000_2 sn_c1_r050_1000_2_0 rwl_sel 0 sky130_fd_pr__nfet_01v8 L=0.15 W=0.42 nf=1 ad=0.1218 as=0.1218 pd=1.42 ps=1.42 nrd=0.69047619047619  nrs=0.69047619047619 sa=0 sb=0 sd=0 mult=1 m=1
csn_c1_r050_1000_2_0 sn_c1_r050_1000_2_0 0 {C_SN}
XMWR_c1_r050_1000_2_1 sn_c1_r050_1000_2_1 0 0 0 sky130_fd_pr__nfet_01v8 L=0.15 W=0.42 nf=1 ad=0.1218 as=0.1218 pd=1.42 ps=1.42 nrd=0.69047619047619  nrs=0.69047619047619 sa=0 sb=0 sd=0 mult=1 m=1
XMRD_c1_r050_1000_2_1 rbl_c1_r050_1000_2 sn_c1_r050_1000_2_1 rwl_des 0 sky130_fd_pr__nfet_01v8 L=0.15 W=0.42 nf=1 ad=0.1218 as=0.1218 pd=1.42 ps=1.42 nrd=0.69047619047619  nrs=0.69047619047619 sa=0 sb=0 sd=0 mult=1 m=1
csn_c1_r050_1000_2_1 sn_c1_r050_1000_2_1 0 {C_SN}
XMWR_c1_r050_1000_2_2 sn_c1_r050_1000_2_2 0 0 0 sky130_fd_pr__nfet_01v8 L=0.15 W=0.42 nf=1 ad=0.1218 as=0.1218 pd=1.42 ps=1.42 nrd=0.69047619047619  nrs=0.69047619047619 sa=0 sb=0 sd=0 mult=1 m=1
XMRD_c1_r050_1000_2_2 rbl_c1_r050_1000_2 sn_c1_r050_1000_2_2 rwl_des 0 sky130_fd_pr__nfet_01v8 L=0.15 W=0.42 nf=1 ad=0.1218 as=0.1218 pd=1.42 ps=1.42 nrd=0.69047619047619  nrs=0.69047619047619 sa=0 sb=0 sd=0 mult=1 m=1
csn_c1_r050_1000_2_2 sn_c1_r050_1000_2_2 0 {C_SN}
XMWR_c1_r050_1000_2_3 sn_c1_r050_1000_2_3 0 0 0 sky130_fd_pr__nfet_01v8 L=0.15 W=0.42 nf=1 ad=0.1218 as=0.1218 pd=1.42 ps=1.42 nrd=0.69047619047619  nrs=0.69047619047619 sa=0 sb=0 sd=0 mult=1 m=1
XMRD_c1_r050_1000_2_3 rbl_c1_r050_1000_2 sn_c1_r050_1000_2_3 rwl_des 0 sky130_fd_pr__nfet_01v8 L=0.15 W=0.42 nf=1 ad=0.1218 as=0.1218 pd=1.42 ps=1.42 nrd=0.69047619047619  nrs=0.69047619047619 sa=0 sb=0 sd=0 mult=1 m=1
csn_c1_r050_1000_2_3 sn_c1_r050_1000_2_3 0 {C_SN}
crbl_c1_r050_1000_2 rbl_c1_r050_1000_2 0 {C_RBL}
spr_c1_r050_1000_2 pref_050 ref_c1_r050_1000_2 ctl 0 swpre
cref_c1_r050_1000_2 ref_c1_r050_1000_2 0 {C_RBL}   $ ASSUMPTION: ideal matched dummy load
XMN1_c1_r050_1000_2 rbl_c1_r050_1000_2 ref_c1_r050_1000_2 vn_c1_r050_1000_2 0 sky130_fd_pr__nfet_01v8 L=0.15 W=1 nf=1 ad=0.29 as=0.29 pd=2.58 ps=2.58 nrd=0.29 nrs=0.29 sa=0 sb=0 sd=0 mult=1 m=1
XMN2_c1_r050_1000_2 ref_c1_r050_1000_2 rbl_c1_r050_1000_2 vn_c1_r050_1000_2 0 sky130_fd_pr__nfet_01v8 L=0.15 W=1 nf=1 ad=0.29 as=0.29 pd=2.58 ps=2.58 nrd=0.29 nrs=0.29 sa=0 sb=0 sd=0 mult=1 m=1
XMP1_c1_r050_1000_2 rbl_c1_r050_1000_2 ref_c1_r050_1000_2 vp_c1_r050_1000_2 vdd sky130_fd_pr__pfet_01v8 L=0.15 W=2 nf=1 ad=0.58 as=0.58 pd=4.58 ps=4.58 nrd=0.145 nrs=0.145 sa=0 sb=0 sd=0 mult=1 m=1
XMP2_c1_r050_1000_2 ref_c1_r050_1000_2 rbl_c1_r050_1000_2 vp_c1_r050_1000_2 vdd sky130_fd_pr__pfet_01v8 L=0.15 W=2 nf=1 ad=0.58 as=0.58 pd=4.58 ps=4.58 nrd=0.145 nrs=0.145 sa=0 sb=0 sd=0 mult=1 m=1
XMNF_c1_r050_1000_2 vn_c1_r050_1000_2 en 0 0 sky130_fd_pr__nfet_01v8 L=0.15 W=2 nf=1 ad=0.58 as=0.58 pd=4.58 ps=4.58 nrd=0.145 nrs=0.145 sa=0 sb=0 sd=0 mult=1 m=1
XMPH_c1_r050_1000_2 vp_c1_r050_1000_2 enb vdd vdd sky130_fd_pr__pfet_01v8 L=0.15 W=4 nf=1 ad=1.16 as=1.16 pd=8.58 ps=8.58 nrd=0.0725 nrs=0.0725 sa=0 sb=0 sd=0 mult=1 m=1
bd_c1_r050_1000_2 d_c1_r050_1000_2 0 v=v(rbl_c1_r050_1000_2)-v(ref_c1_r050_1000_2)
bdabs_c1_r050_1000_2 dabs_c1_r050_1000_2 0 v=abs(v(rbl_c1_r050_1000_2)-v(ref_c1_r050_1000_2))

* ---- c1_r050_1000_3: cell1 SN = 1.0 V, ref offset 0.05 V, replica 3 ----
spa_c1_r050_1000_3 prea rbl_c1_r050_1000_3 ctl 0 swpre
XMWR_c1_r050_1000_3_0 sn_c1_r050_1000_3_0 0 0 0 sky130_fd_pr__nfet_01v8 L=0.15 W=0.42 nf=1 ad=0.1218 as=0.1218 pd=1.42 ps=1.42 nrd=0.69047619047619  nrs=0.69047619047619 sa=0 sb=0 sd=0 mult=1 m=1
XMRD_c1_r050_1000_3_0 rbl_c1_r050_1000_3 sn_c1_r050_1000_3_0 rwl_sel 0 sky130_fd_pr__nfet_01v8 L=0.15 W=0.42 nf=1 ad=0.1218 as=0.1218 pd=1.42 ps=1.42 nrd=0.69047619047619  nrs=0.69047619047619 sa=0 sb=0 sd=0 mult=1 m=1
csn_c1_r050_1000_3_0 sn_c1_r050_1000_3_0 0 {C_SN}
XMWR_c1_r050_1000_3_1 sn_c1_r050_1000_3_1 0 0 0 sky130_fd_pr__nfet_01v8 L=0.15 W=0.42 nf=1 ad=0.1218 as=0.1218 pd=1.42 ps=1.42 nrd=0.69047619047619  nrs=0.69047619047619 sa=0 sb=0 sd=0 mult=1 m=1
XMRD_c1_r050_1000_3_1 rbl_c1_r050_1000_3 sn_c1_r050_1000_3_1 rwl_des 0 sky130_fd_pr__nfet_01v8 L=0.15 W=0.42 nf=1 ad=0.1218 as=0.1218 pd=1.42 ps=1.42 nrd=0.69047619047619  nrs=0.69047619047619 sa=0 sb=0 sd=0 mult=1 m=1
csn_c1_r050_1000_3_1 sn_c1_r050_1000_3_1 0 {C_SN}
XMWR_c1_r050_1000_3_2 sn_c1_r050_1000_3_2 0 0 0 sky130_fd_pr__nfet_01v8 L=0.15 W=0.42 nf=1 ad=0.1218 as=0.1218 pd=1.42 ps=1.42 nrd=0.69047619047619  nrs=0.69047619047619 sa=0 sb=0 sd=0 mult=1 m=1
XMRD_c1_r050_1000_3_2 rbl_c1_r050_1000_3 sn_c1_r050_1000_3_2 rwl_des 0 sky130_fd_pr__nfet_01v8 L=0.15 W=0.42 nf=1 ad=0.1218 as=0.1218 pd=1.42 ps=1.42 nrd=0.69047619047619  nrs=0.69047619047619 sa=0 sb=0 sd=0 mult=1 m=1
csn_c1_r050_1000_3_2 sn_c1_r050_1000_3_2 0 {C_SN}
XMWR_c1_r050_1000_3_3 sn_c1_r050_1000_3_3 0 0 0 sky130_fd_pr__nfet_01v8 L=0.15 W=0.42 nf=1 ad=0.1218 as=0.1218 pd=1.42 ps=1.42 nrd=0.69047619047619  nrs=0.69047619047619 sa=0 sb=0 sd=0 mult=1 m=1
XMRD_c1_r050_1000_3_3 rbl_c1_r050_1000_3 sn_c1_r050_1000_3_3 rwl_des 0 sky130_fd_pr__nfet_01v8 L=0.15 W=0.42 nf=1 ad=0.1218 as=0.1218 pd=1.42 ps=1.42 nrd=0.69047619047619  nrs=0.69047619047619 sa=0 sb=0 sd=0 mult=1 m=1
csn_c1_r050_1000_3_3 sn_c1_r050_1000_3_3 0 {C_SN}
crbl_c1_r050_1000_3 rbl_c1_r050_1000_3 0 {C_RBL}
spr_c1_r050_1000_3 pref_050 ref_c1_r050_1000_3 ctl 0 swpre
cref_c1_r050_1000_3 ref_c1_r050_1000_3 0 {C_RBL}   $ ASSUMPTION: ideal matched dummy load
XMN1_c1_r050_1000_3 rbl_c1_r050_1000_3 ref_c1_r050_1000_3 vn_c1_r050_1000_3 0 sky130_fd_pr__nfet_01v8 L=0.15 W=1 nf=1 ad=0.29 as=0.29 pd=2.58 ps=2.58 nrd=0.29 nrs=0.29 sa=0 sb=0 sd=0 mult=1 m=1
XMN2_c1_r050_1000_3 ref_c1_r050_1000_3 rbl_c1_r050_1000_3 vn_c1_r050_1000_3 0 sky130_fd_pr__nfet_01v8 L=0.15 W=1 nf=1 ad=0.29 as=0.29 pd=2.58 ps=2.58 nrd=0.29 nrs=0.29 sa=0 sb=0 sd=0 mult=1 m=1
XMP1_c1_r050_1000_3 rbl_c1_r050_1000_3 ref_c1_r050_1000_3 vp_c1_r050_1000_3 vdd sky130_fd_pr__pfet_01v8 L=0.15 W=2 nf=1 ad=0.58 as=0.58 pd=4.58 ps=4.58 nrd=0.145 nrs=0.145 sa=0 sb=0 sd=0 mult=1 m=1
XMP2_c1_r050_1000_3 ref_c1_r050_1000_3 rbl_c1_r050_1000_3 vp_c1_r050_1000_3 vdd sky130_fd_pr__pfet_01v8 L=0.15 W=2 nf=1 ad=0.58 as=0.58 pd=4.58 ps=4.58 nrd=0.145 nrs=0.145 sa=0 sb=0 sd=0 mult=1 m=1
XMNF_c1_r050_1000_3 vn_c1_r050_1000_3 en 0 0 sky130_fd_pr__nfet_01v8 L=0.15 W=2 nf=1 ad=0.58 as=0.58 pd=4.58 ps=4.58 nrd=0.145 nrs=0.145 sa=0 sb=0 sd=0 mult=1 m=1
XMPH_c1_r050_1000_3 vp_c1_r050_1000_3 enb vdd vdd sky130_fd_pr__pfet_01v8 L=0.15 W=4 nf=1 ad=1.16 as=1.16 pd=8.58 ps=8.58 nrd=0.0725 nrs=0.0725 sa=0 sb=0 sd=0 mult=1 m=1
bd_c1_r050_1000_3 d_c1_r050_1000_3 0 v=v(rbl_c1_r050_1000_3)-v(ref_c1_r050_1000_3)
bdabs_c1_r050_1000_3 dabs_c1_r050_1000_3 0 v=abs(v(rbl_c1_r050_1000_3)-v(ref_c1_r050_1000_3))

* ---- c0_r100_0000_0: cell0 SN = 0.0 V, ref offset 0.1 V, replica 0 ----
spa_c0_r100_0000_0 prea rbl_c0_r100_0000_0 ctl 0 swpre
XMWR_c0_r100_0000_0_0 sn_c0_r100_0000_0_0 0 0 0 sky130_fd_pr__nfet_01v8 L=0.15 W=0.42 nf=1 ad=0.1218 as=0.1218 pd=1.42 ps=1.42 nrd=0.69047619047619  nrs=0.69047619047619 sa=0 sb=0 sd=0 mult=1 m=1
XMRD_c0_r100_0000_0_0 rbl_c0_r100_0000_0 sn_c0_r100_0000_0_0 rwl_sel 0 sky130_fd_pr__nfet_01v8 L=0.15 W=0.42 nf=1 ad=0.1218 as=0.1218 pd=1.42 ps=1.42 nrd=0.69047619047619  nrs=0.69047619047619 sa=0 sb=0 sd=0 mult=1 m=1
csn_c0_r100_0000_0_0 sn_c0_r100_0000_0_0 0 {C_SN}
XMWR_c0_r100_0000_0_1 sn_c0_r100_0000_0_1 0 0 0 sky130_fd_pr__nfet_01v8 L=0.15 W=0.42 nf=1 ad=0.1218 as=0.1218 pd=1.42 ps=1.42 nrd=0.69047619047619  nrs=0.69047619047619 sa=0 sb=0 sd=0 mult=1 m=1
XMRD_c0_r100_0000_0_1 rbl_c0_r100_0000_0 sn_c0_r100_0000_0_1 rwl_des 0 sky130_fd_pr__nfet_01v8 L=0.15 W=0.42 nf=1 ad=0.1218 as=0.1218 pd=1.42 ps=1.42 nrd=0.69047619047619  nrs=0.69047619047619 sa=0 sb=0 sd=0 mult=1 m=1
csn_c0_r100_0000_0_1 sn_c0_r100_0000_0_1 0 {C_SN}
XMWR_c0_r100_0000_0_2 sn_c0_r100_0000_0_2 0 0 0 sky130_fd_pr__nfet_01v8 L=0.15 W=0.42 nf=1 ad=0.1218 as=0.1218 pd=1.42 ps=1.42 nrd=0.69047619047619  nrs=0.69047619047619 sa=0 sb=0 sd=0 mult=1 m=1
XMRD_c0_r100_0000_0_2 rbl_c0_r100_0000_0 sn_c0_r100_0000_0_2 rwl_des 0 sky130_fd_pr__nfet_01v8 L=0.15 W=0.42 nf=1 ad=0.1218 as=0.1218 pd=1.42 ps=1.42 nrd=0.69047619047619  nrs=0.69047619047619 sa=0 sb=0 sd=0 mult=1 m=1
csn_c0_r100_0000_0_2 sn_c0_r100_0000_0_2 0 {C_SN}
XMWR_c0_r100_0000_0_3 sn_c0_r100_0000_0_3 0 0 0 sky130_fd_pr__nfet_01v8 L=0.15 W=0.42 nf=1 ad=0.1218 as=0.1218 pd=1.42 ps=1.42 nrd=0.69047619047619  nrs=0.69047619047619 sa=0 sb=0 sd=0 mult=1 m=1
XMRD_c0_r100_0000_0_3 rbl_c0_r100_0000_0 sn_c0_r100_0000_0_3 rwl_des 0 sky130_fd_pr__nfet_01v8 L=0.15 W=0.42 nf=1 ad=0.1218 as=0.1218 pd=1.42 ps=1.42 nrd=0.69047619047619  nrs=0.69047619047619 sa=0 sb=0 sd=0 mult=1 m=1
csn_c0_r100_0000_0_3 sn_c0_r100_0000_0_3 0 {C_SN}
crbl_c0_r100_0000_0 rbl_c0_r100_0000_0 0 {C_RBL}
spr_c0_r100_0000_0 pref_100 ref_c0_r100_0000_0 ctl 0 swpre
cref_c0_r100_0000_0 ref_c0_r100_0000_0 0 {C_RBL}   $ ASSUMPTION: ideal matched dummy load
XMN1_c0_r100_0000_0 rbl_c0_r100_0000_0 ref_c0_r100_0000_0 vn_c0_r100_0000_0 0 sky130_fd_pr__nfet_01v8 L=0.15 W=1 nf=1 ad=0.29 as=0.29 pd=2.58 ps=2.58 nrd=0.29 nrs=0.29 sa=0 sb=0 sd=0 mult=1 m=1
XMN2_c0_r100_0000_0 ref_c0_r100_0000_0 rbl_c0_r100_0000_0 vn_c0_r100_0000_0 0 sky130_fd_pr__nfet_01v8 L=0.15 W=1 nf=1 ad=0.29 as=0.29 pd=2.58 ps=2.58 nrd=0.29 nrs=0.29 sa=0 sb=0 sd=0 mult=1 m=1
XMP1_c0_r100_0000_0 rbl_c0_r100_0000_0 ref_c0_r100_0000_0 vp_c0_r100_0000_0 vdd sky130_fd_pr__pfet_01v8 L=0.15 W=2 nf=1 ad=0.58 as=0.58 pd=4.58 ps=4.58 nrd=0.145 nrs=0.145 sa=0 sb=0 sd=0 mult=1 m=1
XMP2_c0_r100_0000_0 ref_c0_r100_0000_0 rbl_c0_r100_0000_0 vp_c0_r100_0000_0 vdd sky130_fd_pr__pfet_01v8 L=0.15 W=2 nf=1 ad=0.58 as=0.58 pd=4.58 ps=4.58 nrd=0.145 nrs=0.145 sa=0 sb=0 sd=0 mult=1 m=1
XMNF_c0_r100_0000_0 vn_c0_r100_0000_0 en 0 0 sky130_fd_pr__nfet_01v8 L=0.15 W=2 nf=1 ad=0.58 as=0.58 pd=4.58 ps=4.58 nrd=0.145 nrs=0.145 sa=0 sb=0 sd=0 mult=1 m=1
XMPH_c0_r100_0000_0 vp_c0_r100_0000_0 enb vdd vdd sky130_fd_pr__pfet_01v8 L=0.15 W=4 nf=1 ad=1.16 as=1.16 pd=8.58 ps=8.58 nrd=0.0725 nrs=0.0725 sa=0 sb=0 sd=0 mult=1 m=1
bd_c0_r100_0000_0 d_c0_r100_0000_0 0 v=v(rbl_c0_r100_0000_0)-v(ref_c0_r100_0000_0)
bdabs_c0_r100_0000_0 dabs_c0_r100_0000_0 0 v=abs(v(rbl_c0_r100_0000_0)-v(ref_c0_r100_0000_0))

* ---- c0_r100_0000_1: cell0 SN = 0.0 V, ref offset 0.1 V, replica 1 ----
spa_c0_r100_0000_1 prea rbl_c0_r100_0000_1 ctl 0 swpre
XMWR_c0_r100_0000_1_0 sn_c0_r100_0000_1_0 0 0 0 sky130_fd_pr__nfet_01v8 L=0.15 W=0.42 nf=1 ad=0.1218 as=0.1218 pd=1.42 ps=1.42 nrd=0.69047619047619  nrs=0.69047619047619 sa=0 sb=0 sd=0 mult=1 m=1
XMRD_c0_r100_0000_1_0 rbl_c0_r100_0000_1 sn_c0_r100_0000_1_0 rwl_sel 0 sky130_fd_pr__nfet_01v8 L=0.15 W=0.42 nf=1 ad=0.1218 as=0.1218 pd=1.42 ps=1.42 nrd=0.69047619047619  nrs=0.69047619047619 sa=0 sb=0 sd=0 mult=1 m=1
csn_c0_r100_0000_1_0 sn_c0_r100_0000_1_0 0 {C_SN}
XMWR_c0_r100_0000_1_1 sn_c0_r100_0000_1_1 0 0 0 sky130_fd_pr__nfet_01v8 L=0.15 W=0.42 nf=1 ad=0.1218 as=0.1218 pd=1.42 ps=1.42 nrd=0.69047619047619  nrs=0.69047619047619 sa=0 sb=0 sd=0 mult=1 m=1
XMRD_c0_r100_0000_1_1 rbl_c0_r100_0000_1 sn_c0_r100_0000_1_1 rwl_des 0 sky130_fd_pr__nfet_01v8 L=0.15 W=0.42 nf=1 ad=0.1218 as=0.1218 pd=1.42 ps=1.42 nrd=0.69047619047619  nrs=0.69047619047619 sa=0 sb=0 sd=0 mult=1 m=1
csn_c0_r100_0000_1_1 sn_c0_r100_0000_1_1 0 {C_SN}
XMWR_c0_r100_0000_1_2 sn_c0_r100_0000_1_2 0 0 0 sky130_fd_pr__nfet_01v8 L=0.15 W=0.42 nf=1 ad=0.1218 as=0.1218 pd=1.42 ps=1.42 nrd=0.69047619047619  nrs=0.69047619047619 sa=0 sb=0 sd=0 mult=1 m=1
XMRD_c0_r100_0000_1_2 rbl_c0_r100_0000_1 sn_c0_r100_0000_1_2 rwl_des 0 sky130_fd_pr__nfet_01v8 L=0.15 W=0.42 nf=1 ad=0.1218 as=0.1218 pd=1.42 ps=1.42 nrd=0.69047619047619  nrs=0.69047619047619 sa=0 sb=0 sd=0 mult=1 m=1
csn_c0_r100_0000_1_2 sn_c0_r100_0000_1_2 0 {C_SN}
XMWR_c0_r100_0000_1_3 sn_c0_r100_0000_1_3 0 0 0 sky130_fd_pr__nfet_01v8 L=0.15 W=0.42 nf=1 ad=0.1218 as=0.1218 pd=1.42 ps=1.42 nrd=0.69047619047619  nrs=0.69047619047619 sa=0 sb=0 sd=0 mult=1 m=1
XMRD_c0_r100_0000_1_3 rbl_c0_r100_0000_1 sn_c0_r100_0000_1_3 rwl_des 0 sky130_fd_pr__nfet_01v8 L=0.15 W=0.42 nf=1 ad=0.1218 as=0.1218 pd=1.42 ps=1.42 nrd=0.69047619047619  nrs=0.69047619047619 sa=0 sb=0 sd=0 mult=1 m=1
csn_c0_r100_0000_1_3 sn_c0_r100_0000_1_3 0 {C_SN}
crbl_c0_r100_0000_1 rbl_c0_r100_0000_1 0 {C_RBL}
spr_c0_r100_0000_1 pref_100 ref_c0_r100_0000_1 ctl 0 swpre
cref_c0_r100_0000_1 ref_c0_r100_0000_1 0 {C_RBL}   $ ASSUMPTION: ideal matched dummy load
XMN1_c0_r100_0000_1 rbl_c0_r100_0000_1 ref_c0_r100_0000_1 vn_c0_r100_0000_1 0 sky130_fd_pr__nfet_01v8 L=0.15 W=1 nf=1 ad=0.29 as=0.29 pd=2.58 ps=2.58 nrd=0.29 nrs=0.29 sa=0 sb=0 sd=0 mult=1 m=1
XMN2_c0_r100_0000_1 ref_c0_r100_0000_1 rbl_c0_r100_0000_1 vn_c0_r100_0000_1 0 sky130_fd_pr__nfet_01v8 L=0.15 W=1 nf=1 ad=0.29 as=0.29 pd=2.58 ps=2.58 nrd=0.29 nrs=0.29 sa=0 sb=0 sd=0 mult=1 m=1
XMP1_c0_r100_0000_1 rbl_c0_r100_0000_1 ref_c0_r100_0000_1 vp_c0_r100_0000_1 vdd sky130_fd_pr__pfet_01v8 L=0.15 W=2 nf=1 ad=0.58 as=0.58 pd=4.58 ps=4.58 nrd=0.145 nrs=0.145 sa=0 sb=0 sd=0 mult=1 m=1
XMP2_c0_r100_0000_1 ref_c0_r100_0000_1 rbl_c0_r100_0000_1 vp_c0_r100_0000_1 vdd sky130_fd_pr__pfet_01v8 L=0.15 W=2 nf=1 ad=0.58 as=0.58 pd=4.58 ps=4.58 nrd=0.145 nrs=0.145 sa=0 sb=0 sd=0 mult=1 m=1
XMNF_c0_r100_0000_1 vn_c0_r100_0000_1 en 0 0 sky130_fd_pr__nfet_01v8 L=0.15 W=2 nf=1 ad=0.58 as=0.58 pd=4.58 ps=4.58 nrd=0.145 nrs=0.145 sa=0 sb=0 sd=0 mult=1 m=1
XMPH_c0_r100_0000_1 vp_c0_r100_0000_1 enb vdd vdd sky130_fd_pr__pfet_01v8 L=0.15 W=4 nf=1 ad=1.16 as=1.16 pd=8.58 ps=8.58 nrd=0.0725 nrs=0.0725 sa=0 sb=0 sd=0 mult=1 m=1
bd_c0_r100_0000_1 d_c0_r100_0000_1 0 v=v(rbl_c0_r100_0000_1)-v(ref_c0_r100_0000_1)
bdabs_c0_r100_0000_1 dabs_c0_r100_0000_1 0 v=abs(v(rbl_c0_r100_0000_1)-v(ref_c0_r100_0000_1))

* ---- c0_r100_0000_2: cell0 SN = 0.0 V, ref offset 0.1 V, replica 2 ----
spa_c0_r100_0000_2 prea rbl_c0_r100_0000_2 ctl 0 swpre
XMWR_c0_r100_0000_2_0 sn_c0_r100_0000_2_0 0 0 0 sky130_fd_pr__nfet_01v8 L=0.15 W=0.42 nf=1 ad=0.1218 as=0.1218 pd=1.42 ps=1.42 nrd=0.69047619047619  nrs=0.69047619047619 sa=0 sb=0 sd=0 mult=1 m=1
XMRD_c0_r100_0000_2_0 rbl_c0_r100_0000_2 sn_c0_r100_0000_2_0 rwl_sel 0 sky130_fd_pr__nfet_01v8 L=0.15 W=0.42 nf=1 ad=0.1218 as=0.1218 pd=1.42 ps=1.42 nrd=0.69047619047619  nrs=0.69047619047619 sa=0 sb=0 sd=0 mult=1 m=1
csn_c0_r100_0000_2_0 sn_c0_r100_0000_2_0 0 {C_SN}
XMWR_c0_r100_0000_2_1 sn_c0_r100_0000_2_1 0 0 0 sky130_fd_pr__nfet_01v8 L=0.15 W=0.42 nf=1 ad=0.1218 as=0.1218 pd=1.42 ps=1.42 nrd=0.69047619047619  nrs=0.69047619047619 sa=0 sb=0 sd=0 mult=1 m=1
XMRD_c0_r100_0000_2_1 rbl_c0_r100_0000_2 sn_c0_r100_0000_2_1 rwl_des 0 sky130_fd_pr__nfet_01v8 L=0.15 W=0.42 nf=1 ad=0.1218 as=0.1218 pd=1.42 ps=1.42 nrd=0.69047619047619  nrs=0.69047619047619 sa=0 sb=0 sd=0 mult=1 m=1
csn_c0_r100_0000_2_1 sn_c0_r100_0000_2_1 0 {C_SN}
XMWR_c0_r100_0000_2_2 sn_c0_r100_0000_2_2 0 0 0 sky130_fd_pr__nfet_01v8 L=0.15 W=0.42 nf=1 ad=0.1218 as=0.1218 pd=1.42 ps=1.42 nrd=0.69047619047619  nrs=0.69047619047619 sa=0 sb=0 sd=0 mult=1 m=1
XMRD_c0_r100_0000_2_2 rbl_c0_r100_0000_2 sn_c0_r100_0000_2_2 rwl_des 0 sky130_fd_pr__nfet_01v8 L=0.15 W=0.42 nf=1 ad=0.1218 as=0.1218 pd=1.42 ps=1.42 nrd=0.69047619047619  nrs=0.69047619047619 sa=0 sb=0 sd=0 mult=1 m=1
csn_c0_r100_0000_2_2 sn_c0_r100_0000_2_2 0 {C_SN}
XMWR_c0_r100_0000_2_3 sn_c0_r100_0000_2_3 0 0 0 sky130_fd_pr__nfet_01v8 L=0.15 W=0.42 nf=1 ad=0.1218 as=0.1218 pd=1.42 ps=1.42 nrd=0.69047619047619  nrs=0.69047619047619 sa=0 sb=0 sd=0 mult=1 m=1
XMRD_c0_r100_0000_2_3 rbl_c0_r100_0000_2 sn_c0_r100_0000_2_3 rwl_des 0 sky130_fd_pr__nfet_01v8 L=0.15 W=0.42 nf=1 ad=0.1218 as=0.1218 pd=1.42 ps=1.42 nrd=0.69047619047619  nrs=0.69047619047619 sa=0 sb=0 sd=0 mult=1 m=1
csn_c0_r100_0000_2_3 sn_c0_r100_0000_2_3 0 {C_SN}
crbl_c0_r100_0000_2 rbl_c0_r100_0000_2 0 {C_RBL}
spr_c0_r100_0000_2 pref_100 ref_c0_r100_0000_2 ctl 0 swpre
cref_c0_r100_0000_2 ref_c0_r100_0000_2 0 {C_RBL}   $ ASSUMPTION: ideal matched dummy load
XMN1_c0_r100_0000_2 rbl_c0_r100_0000_2 ref_c0_r100_0000_2 vn_c0_r100_0000_2 0 sky130_fd_pr__nfet_01v8 L=0.15 W=1 nf=1 ad=0.29 as=0.29 pd=2.58 ps=2.58 nrd=0.29 nrs=0.29 sa=0 sb=0 sd=0 mult=1 m=1
XMN2_c0_r100_0000_2 ref_c0_r100_0000_2 rbl_c0_r100_0000_2 vn_c0_r100_0000_2 0 sky130_fd_pr__nfet_01v8 L=0.15 W=1 nf=1 ad=0.29 as=0.29 pd=2.58 ps=2.58 nrd=0.29 nrs=0.29 sa=0 sb=0 sd=0 mult=1 m=1
XMP1_c0_r100_0000_2 rbl_c0_r100_0000_2 ref_c0_r100_0000_2 vp_c0_r100_0000_2 vdd sky130_fd_pr__pfet_01v8 L=0.15 W=2 nf=1 ad=0.58 as=0.58 pd=4.58 ps=4.58 nrd=0.145 nrs=0.145 sa=0 sb=0 sd=0 mult=1 m=1
XMP2_c0_r100_0000_2 ref_c0_r100_0000_2 rbl_c0_r100_0000_2 vp_c0_r100_0000_2 vdd sky130_fd_pr__pfet_01v8 L=0.15 W=2 nf=1 ad=0.58 as=0.58 pd=4.58 ps=4.58 nrd=0.145 nrs=0.145 sa=0 sb=0 sd=0 mult=1 m=1
XMNF_c0_r100_0000_2 vn_c0_r100_0000_2 en 0 0 sky130_fd_pr__nfet_01v8 L=0.15 W=2 nf=1 ad=0.58 as=0.58 pd=4.58 ps=4.58 nrd=0.145 nrs=0.145 sa=0 sb=0 sd=0 mult=1 m=1
XMPH_c0_r100_0000_2 vp_c0_r100_0000_2 enb vdd vdd sky130_fd_pr__pfet_01v8 L=0.15 W=4 nf=1 ad=1.16 as=1.16 pd=8.58 ps=8.58 nrd=0.0725 nrs=0.0725 sa=0 sb=0 sd=0 mult=1 m=1
bd_c0_r100_0000_2 d_c0_r100_0000_2 0 v=v(rbl_c0_r100_0000_2)-v(ref_c0_r100_0000_2)
bdabs_c0_r100_0000_2 dabs_c0_r100_0000_2 0 v=abs(v(rbl_c0_r100_0000_2)-v(ref_c0_r100_0000_2))

* ---- c0_r100_0000_3: cell0 SN = 0.0 V, ref offset 0.1 V, replica 3 ----
spa_c0_r100_0000_3 prea rbl_c0_r100_0000_3 ctl 0 swpre
XMWR_c0_r100_0000_3_0 sn_c0_r100_0000_3_0 0 0 0 sky130_fd_pr__nfet_01v8 L=0.15 W=0.42 nf=1 ad=0.1218 as=0.1218 pd=1.42 ps=1.42 nrd=0.69047619047619  nrs=0.69047619047619 sa=0 sb=0 sd=0 mult=1 m=1
XMRD_c0_r100_0000_3_0 rbl_c0_r100_0000_3 sn_c0_r100_0000_3_0 rwl_sel 0 sky130_fd_pr__nfet_01v8 L=0.15 W=0.42 nf=1 ad=0.1218 as=0.1218 pd=1.42 ps=1.42 nrd=0.69047619047619  nrs=0.69047619047619 sa=0 sb=0 sd=0 mult=1 m=1
csn_c0_r100_0000_3_0 sn_c0_r100_0000_3_0 0 {C_SN}
XMWR_c0_r100_0000_3_1 sn_c0_r100_0000_3_1 0 0 0 sky130_fd_pr__nfet_01v8 L=0.15 W=0.42 nf=1 ad=0.1218 as=0.1218 pd=1.42 ps=1.42 nrd=0.69047619047619  nrs=0.69047619047619 sa=0 sb=0 sd=0 mult=1 m=1
XMRD_c0_r100_0000_3_1 rbl_c0_r100_0000_3 sn_c0_r100_0000_3_1 rwl_des 0 sky130_fd_pr__nfet_01v8 L=0.15 W=0.42 nf=1 ad=0.1218 as=0.1218 pd=1.42 ps=1.42 nrd=0.69047619047619  nrs=0.69047619047619 sa=0 sb=0 sd=0 mult=1 m=1
csn_c0_r100_0000_3_1 sn_c0_r100_0000_3_1 0 {C_SN}
XMWR_c0_r100_0000_3_2 sn_c0_r100_0000_3_2 0 0 0 sky130_fd_pr__nfet_01v8 L=0.15 W=0.42 nf=1 ad=0.1218 as=0.1218 pd=1.42 ps=1.42 nrd=0.69047619047619  nrs=0.69047619047619 sa=0 sb=0 sd=0 mult=1 m=1
XMRD_c0_r100_0000_3_2 rbl_c0_r100_0000_3 sn_c0_r100_0000_3_2 rwl_des 0 sky130_fd_pr__nfet_01v8 L=0.15 W=0.42 nf=1 ad=0.1218 as=0.1218 pd=1.42 ps=1.42 nrd=0.69047619047619  nrs=0.69047619047619 sa=0 sb=0 sd=0 mult=1 m=1
csn_c0_r100_0000_3_2 sn_c0_r100_0000_3_2 0 {C_SN}
XMWR_c0_r100_0000_3_3 sn_c0_r100_0000_3_3 0 0 0 sky130_fd_pr__nfet_01v8 L=0.15 W=0.42 nf=1 ad=0.1218 as=0.1218 pd=1.42 ps=1.42 nrd=0.69047619047619  nrs=0.69047619047619 sa=0 sb=0 sd=0 mult=1 m=1
XMRD_c0_r100_0000_3_3 rbl_c0_r100_0000_3 sn_c0_r100_0000_3_3 rwl_des 0 sky130_fd_pr__nfet_01v8 L=0.15 W=0.42 nf=1 ad=0.1218 as=0.1218 pd=1.42 ps=1.42 nrd=0.69047619047619  nrs=0.69047619047619 sa=0 sb=0 sd=0 mult=1 m=1
csn_c0_r100_0000_3_3 sn_c0_r100_0000_3_3 0 {C_SN}
crbl_c0_r100_0000_3 rbl_c0_r100_0000_3 0 {C_RBL}
spr_c0_r100_0000_3 pref_100 ref_c0_r100_0000_3 ctl 0 swpre
cref_c0_r100_0000_3 ref_c0_r100_0000_3 0 {C_RBL}   $ ASSUMPTION: ideal matched dummy load
XMN1_c0_r100_0000_3 rbl_c0_r100_0000_3 ref_c0_r100_0000_3 vn_c0_r100_0000_3 0 sky130_fd_pr__nfet_01v8 L=0.15 W=1 nf=1 ad=0.29 as=0.29 pd=2.58 ps=2.58 nrd=0.29 nrs=0.29 sa=0 sb=0 sd=0 mult=1 m=1
XMN2_c0_r100_0000_3 ref_c0_r100_0000_3 rbl_c0_r100_0000_3 vn_c0_r100_0000_3 0 sky130_fd_pr__nfet_01v8 L=0.15 W=1 nf=1 ad=0.29 as=0.29 pd=2.58 ps=2.58 nrd=0.29 nrs=0.29 sa=0 sb=0 sd=0 mult=1 m=1
XMP1_c0_r100_0000_3 rbl_c0_r100_0000_3 ref_c0_r100_0000_3 vp_c0_r100_0000_3 vdd sky130_fd_pr__pfet_01v8 L=0.15 W=2 nf=1 ad=0.58 as=0.58 pd=4.58 ps=4.58 nrd=0.145 nrs=0.145 sa=0 sb=0 sd=0 mult=1 m=1
XMP2_c0_r100_0000_3 ref_c0_r100_0000_3 rbl_c0_r100_0000_3 vp_c0_r100_0000_3 vdd sky130_fd_pr__pfet_01v8 L=0.15 W=2 nf=1 ad=0.58 as=0.58 pd=4.58 ps=4.58 nrd=0.145 nrs=0.145 sa=0 sb=0 sd=0 mult=1 m=1
XMNF_c0_r100_0000_3 vn_c0_r100_0000_3 en 0 0 sky130_fd_pr__nfet_01v8 L=0.15 W=2 nf=1 ad=0.58 as=0.58 pd=4.58 ps=4.58 nrd=0.145 nrs=0.145 sa=0 sb=0 sd=0 mult=1 m=1
XMPH_c0_r100_0000_3 vp_c0_r100_0000_3 enb vdd vdd sky130_fd_pr__pfet_01v8 L=0.15 W=4 nf=1 ad=1.16 as=1.16 pd=8.58 ps=8.58 nrd=0.0725 nrs=0.0725 sa=0 sb=0 sd=0 mult=1 m=1
bd_c0_r100_0000_3 d_c0_r100_0000_3 0 v=v(rbl_c0_r100_0000_3)-v(ref_c0_r100_0000_3)
bdabs_c0_r100_0000_3 dabs_c0_r100_0000_3 0 v=abs(v(rbl_c0_r100_0000_3)-v(ref_c0_r100_0000_3))

* ---- c1_r100_0600_0: cell1 SN = 0.6 V, ref offset 0.1 V, replica 0 ----
spa_c1_r100_0600_0 prea rbl_c1_r100_0600_0 ctl 0 swpre
XMWR_c1_r100_0600_0_0 sn_c1_r100_0600_0_0 0 0 0 sky130_fd_pr__nfet_01v8 L=0.15 W=0.42 nf=1 ad=0.1218 as=0.1218 pd=1.42 ps=1.42 nrd=0.69047619047619  nrs=0.69047619047619 sa=0 sb=0 sd=0 mult=1 m=1
XMRD_c1_r100_0600_0_0 rbl_c1_r100_0600_0 sn_c1_r100_0600_0_0 rwl_sel 0 sky130_fd_pr__nfet_01v8 L=0.15 W=0.42 nf=1 ad=0.1218 as=0.1218 pd=1.42 ps=1.42 nrd=0.69047619047619  nrs=0.69047619047619 sa=0 sb=0 sd=0 mult=1 m=1
csn_c1_r100_0600_0_0 sn_c1_r100_0600_0_0 0 {C_SN}
XMWR_c1_r100_0600_0_1 sn_c1_r100_0600_0_1 0 0 0 sky130_fd_pr__nfet_01v8 L=0.15 W=0.42 nf=1 ad=0.1218 as=0.1218 pd=1.42 ps=1.42 nrd=0.69047619047619  nrs=0.69047619047619 sa=0 sb=0 sd=0 mult=1 m=1
XMRD_c1_r100_0600_0_1 rbl_c1_r100_0600_0 sn_c1_r100_0600_0_1 rwl_des 0 sky130_fd_pr__nfet_01v8 L=0.15 W=0.42 nf=1 ad=0.1218 as=0.1218 pd=1.42 ps=1.42 nrd=0.69047619047619  nrs=0.69047619047619 sa=0 sb=0 sd=0 mult=1 m=1
csn_c1_r100_0600_0_1 sn_c1_r100_0600_0_1 0 {C_SN}
XMWR_c1_r100_0600_0_2 sn_c1_r100_0600_0_2 0 0 0 sky130_fd_pr__nfet_01v8 L=0.15 W=0.42 nf=1 ad=0.1218 as=0.1218 pd=1.42 ps=1.42 nrd=0.69047619047619  nrs=0.69047619047619 sa=0 sb=0 sd=0 mult=1 m=1
XMRD_c1_r100_0600_0_2 rbl_c1_r100_0600_0 sn_c1_r100_0600_0_2 rwl_des 0 sky130_fd_pr__nfet_01v8 L=0.15 W=0.42 nf=1 ad=0.1218 as=0.1218 pd=1.42 ps=1.42 nrd=0.69047619047619  nrs=0.69047619047619 sa=0 sb=0 sd=0 mult=1 m=1
csn_c1_r100_0600_0_2 sn_c1_r100_0600_0_2 0 {C_SN}
XMWR_c1_r100_0600_0_3 sn_c1_r100_0600_0_3 0 0 0 sky130_fd_pr__nfet_01v8 L=0.15 W=0.42 nf=1 ad=0.1218 as=0.1218 pd=1.42 ps=1.42 nrd=0.69047619047619  nrs=0.69047619047619 sa=0 sb=0 sd=0 mult=1 m=1
XMRD_c1_r100_0600_0_3 rbl_c1_r100_0600_0 sn_c1_r100_0600_0_3 rwl_des 0 sky130_fd_pr__nfet_01v8 L=0.15 W=0.42 nf=1 ad=0.1218 as=0.1218 pd=1.42 ps=1.42 nrd=0.69047619047619  nrs=0.69047619047619 sa=0 sb=0 sd=0 mult=1 m=1
csn_c1_r100_0600_0_3 sn_c1_r100_0600_0_3 0 {C_SN}
crbl_c1_r100_0600_0 rbl_c1_r100_0600_0 0 {C_RBL}
spr_c1_r100_0600_0 pref_100 ref_c1_r100_0600_0 ctl 0 swpre
cref_c1_r100_0600_0 ref_c1_r100_0600_0 0 {C_RBL}   $ ASSUMPTION: ideal matched dummy load
XMN1_c1_r100_0600_0 rbl_c1_r100_0600_0 ref_c1_r100_0600_0 vn_c1_r100_0600_0 0 sky130_fd_pr__nfet_01v8 L=0.15 W=1 nf=1 ad=0.29 as=0.29 pd=2.58 ps=2.58 nrd=0.29 nrs=0.29 sa=0 sb=0 sd=0 mult=1 m=1
XMN2_c1_r100_0600_0 ref_c1_r100_0600_0 rbl_c1_r100_0600_0 vn_c1_r100_0600_0 0 sky130_fd_pr__nfet_01v8 L=0.15 W=1 nf=1 ad=0.29 as=0.29 pd=2.58 ps=2.58 nrd=0.29 nrs=0.29 sa=0 sb=0 sd=0 mult=1 m=1
XMP1_c1_r100_0600_0 rbl_c1_r100_0600_0 ref_c1_r100_0600_0 vp_c1_r100_0600_0 vdd sky130_fd_pr__pfet_01v8 L=0.15 W=2 nf=1 ad=0.58 as=0.58 pd=4.58 ps=4.58 nrd=0.145 nrs=0.145 sa=0 sb=0 sd=0 mult=1 m=1
XMP2_c1_r100_0600_0 ref_c1_r100_0600_0 rbl_c1_r100_0600_0 vp_c1_r100_0600_0 vdd sky130_fd_pr__pfet_01v8 L=0.15 W=2 nf=1 ad=0.58 as=0.58 pd=4.58 ps=4.58 nrd=0.145 nrs=0.145 sa=0 sb=0 sd=0 mult=1 m=1
XMNF_c1_r100_0600_0 vn_c1_r100_0600_0 en 0 0 sky130_fd_pr__nfet_01v8 L=0.15 W=2 nf=1 ad=0.58 as=0.58 pd=4.58 ps=4.58 nrd=0.145 nrs=0.145 sa=0 sb=0 sd=0 mult=1 m=1
XMPH_c1_r100_0600_0 vp_c1_r100_0600_0 enb vdd vdd sky130_fd_pr__pfet_01v8 L=0.15 W=4 nf=1 ad=1.16 as=1.16 pd=8.58 ps=8.58 nrd=0.0725 nrs=0.0725 sa=0 sb=0 sd=0 mult=1 m=1
bd_c1_r100_0600_0 d_c1_r100_0600_0 0 v=v(rbl_c1_r100_0600_0)-v(ref_c1_r100_0600_0)
bdabs_c1_r100_0600_0 dabs_c1_r100_0600_0 0 v=abs(v(rbl_c1_r100_0600_0)-v(ref_c1_r100_0600_0))

* ---- c1_r100_0600_1: cell1 SN = 0.6 V, ref offset 0.1 V, replica 1 ----
spa_c1_r100_0600_1 prea rbl_c1_r100_0600_1 ctl 0 swpre
XMWR_c1_r100_0600_1_0 sn_c1_r100_0600_1_0 0 0 0 sky130_fd_pr__nfet_01v8 L=0.15 W=0.42 nf=1 ad=0.1218 as=0.1218 pd=1.42 ps=1.42 nrd=0.69047619047619  nrs=0.69047619047619 sa=0 sb=0 sd=0 mult=1 m=1
XMRD_c1_r100_0600_1_0 rbl_c1_r100_0600_1 sn_c1_r100_0600_1_0 rwl_sel 0 sky130_fd_pr__nfet_01v8 L=0.15 W=0.42 nf=1 ad=0.1218 as=0.1218 pd=1.42 ps=1.42 nrd=0.69047619047619  nrs=0.69047619047619 sa=0 sb=0 sd=0 mult=1 m=1
csn_c1_r100_0600_1_0 sn_c1_r100_0600_1_0 0 {C_SN}
XMWR_c1_r100_0600_1_1 sn_c1_r100_0600_1_1 0 0 0 sky130_fd_pr__nfet_01v8 L=0.15 W=0.42 nf=1 ad=0.1218 as=0.1218 pd=1.42 ps=1.42 nrd=0.69047619047619  nrs=0.69047619047619 sa=0 sb=0 sd=0 mult=1 m=1
XMRD_c1_r100_0600_1_1 rbl_c1_r100_0600_1 sn_c1_r100_0600_1_1 rwl_des 0 sky130_fd_pr__nfet_01v8 L=0.15 W=0.42 nf=1 ad=0.1218 as=0.1218 pd=1.42 ps=1.42 nrd=0.69047619047619  nrs=0.69047619047619 sa=0 sb=0 sd=0 mult=1 m=1
csn_c1_r100_0600_1_1 sn_c1_r100_0600_1_1 0 {C_SN}
XMWR_c1_r100_0600_1_2 sn_c1_r100_0600_1_2 0 0 0 sky130_fd_pr__nfet_01v8 L=0.15 W=0.42 nf=1 ad=0.1218 as=0.1218 pd=1.42 ps=1.42 nrd=0.69047619047619  nrs=0.69047619047619 sa=0 sb=0 sd=0 mult=1 m=1
XMRD_c1_r100_0600_1_2 rbl_c1_r100_0600_1 sn_c1_r100_0600_1_2 rwl_des 0 sky130_fd_pr__nfet_01v8 L=0.15 W=0.42 nf=1 ad=0.1218 as=0.1218 pd=1.42 ps=1.42 nrd=0.69047619047619  nrs=0.69047619047619 sa=0 sb=0 sd=0 mult=1 m=1
csn_c1_r100_0600_1_2 sn_c1_r100_0600_1_2 0 {C_SN}
XMWR_c1_r100_0600_1_3 sn_c1_r100_0600_1_3 0 0 0 sky130_fd_pr__nfet_01v8 L=0.15 W=0.42 nf=1 ad=0.1218 as=0.1218 pd=1.42 ps=1.42 nrd=0.69047619047619  nrs=0.69047619047619 sa=0 sb=0 sd=0 mult=1 m=1
XMRD_c1_r100_0600_1_3 rbl_c1_r100_0600_1 sn_c1_r100_0600_1_3 rwl_des 0 sky130_fd_pr__nfet_01v8 L=0.15 W=0.42 nf=1 ad=0.1218 as=0.1218 pd=1.42 ps=1.42 nrd=0.69047619047619  nrs=0.69047619047619 sa=0 sb=0 sd=0 mult=1 m=1
csn_c1_r100_0600_1_3 sn_c1_r100_0600_1_3 0 {C_SN}
crbl_c1_r100_0600_1 rbl_c1_r100_0600_1 0 {C_RBL}
spr_c1_r100_0600_1 pref_100 ref_c1_r100_0600_1 ctl 0 swpre
cref_c1_r100_0600_1 ref_c1_r100_0600_1 0 {C_RBL}   $ ASSUMPTION: ideal matched dummy load
XMN1_c1_r100_0600_1 rbl_c1_r100_0600_1 ref_c1_r100_0600_1 vn_c1_r100_0600_1 0 sky130_fd_pr__nfet_01v8 L=0.15 W=1 nf=1 ad=0.29 as=0.29 pd=2.58 ps=2.58 nrd=0.29 nrs=0.29 sa=0 sb=0 sd=0 mult=1 m=1
XMN2_c1_r100_0600_1 ref_c1_r100_0600_1 rbl_c1_r100_0600_1 vn_c1_r100_0600_1 0 sky130_fd_pr__nfet_01v8 L=0.15 W=1 nf=1 ad=0.29 as=0.29 pd=2.58 ps=2.58 nrd=0.29 nrs=0.29 sa=0 sb=0 sd=0 mult=1 m=1
XMP1_c1_r100_0600_1 rbl_c1_r100_0600_1 ref_c1_r100_0600_1 vp_c1_r100_0600_1 vdd sky130_fd_pr__pfet_01v8 L=0.15 W=2 nf=1 ad=0.58 as=0.58 pd=4.58 ps=4.58 nrd=0.145 nrs=0.145 sa=0 sb=0 sd=0 mult=1 m=1
XMP2_c1_r100_0600_1 ref_c1_r100_0600_1 rbl_c1_r100_0600_1 vp_c1_r100_0600_1 vdd sky130_fd_pr__pfet_01v8 L=0.15 W=2 nf=1 ad=0.58 as=0.58 pd=4.58 ps=4.58 nrd=0.145 nrs=0.145 sa=0 sb=0 sd=0 mult=1 m=1
XMNF_c1_r100_0600_1 vn_c1_r100_0600_1 en 0 0 sky130_fd_pr__nfet_01v8 L=0.15 W=2 nf=1 ad=0.58 as=0.58 pd=4.58 ps=4.58 nrd=0.145 nrs=0.145 sa=0 sb=0 sd=0 mult=1 m=1
XMPH_c1_r100_0600_1 vp_c1_r100_0600_1 enb vdd vdd sky130_fd_pr__pfet_01v8 L=0.15 W=4 nf=1 ad=1.16 as=1.16 pd=8.58 ps=8.58 nrd=0.0725 nrs=0.0725 sa=0 sb=0 sd=0 mult=1 m=1
bd_c1_r100_0600_1 d_c1_r100_0600_1 0 v=v(rbl_c1_r100_0600_1)-v(ref_c1_r100_0600_1)
bdabs_c1_r100_0600_1 dabs_c1_r100_0600_1 0 v=abs(v(rbl_c1_r100_0600_1)-v(ref_c1_r100_0600_1))

* ---- c1_r100_0600_2: cell1 SN = 0.6 V, ref offset 0.1 V, replica 2 ----
spa_c1_r100_0600_2 prea rbl_c1_r100_0600_2 ctl 0 swpre
XMWR_c1_r100_0600_2_0 sn_c1_r100_0600_2_0 0 0 0 sky130_fd_pr__nfet_01v8 L=0.15 W=0.42 nf=1 ad=0.1218 as=0.1218 pd=1.42 ps=1.42 nrd=0.69047619047619  nrs=0.69047619047619 sa=0 sb=0 sd=0 mult=1 m=1
XMRD_c1_r100_0600_2_0 rbl_c1_r100_0600_2 sn_c1_r100_0600_2_0 rwl_sel 0 sky130_fd_pr__nfet_01v8 L=0.15 W=0.42 nf=1 ad=0.1218 as=0.1218 pd=1.42 ps=1.42 nrd=0.69047619047619  nrs=0.69047619047619 sa=0 sb=0 sd=0 mult=1 m=1
csn_c1_r100_0600_2_0 sn_c1_r100_0600_2_0 0 {C_SN}
XMWR_c1_r100_0600_2_1 sn_c1_r100_0600_2_1 0 0 0 sky130_fd_pr__nfet_01v8 L=0.15 W=0.42 nf=1 ad=0.1218 as=0.1218 pd=1.42 ps=1.42 nrd=0.69047619047619  nrs=0.69047619047619 sa=0 sb=0 sd=0 mult=1 m=1
XMRD_c1_r100_0600_2_1 rbl_c1_r100_0600_2 sn_c1_r100_0600_2_1 rwl_des 0 sky130_fd_pr__nfet_01v8 L=0.15 W=0.42 nf=1 ad=0.1218 as=0.1218 pd=1.42 ps=1.42 nrd=0.69047619047619  nrs=0.69047619047619 sa=0 sb=0 sd=0 mult=1 m=1
csn_c1_r100_0600_2_1 sn_c1_r100_0600_2_1 0 {C_SN}
XMWR_c1_r100_0600_2_2 sn_c1_r100_0600_2_2 0 0 0 sky130_fd_pr__nfet_01v8 L=0.15 W=0.42 nf=1 ad=0.1218 as=0.1218 pd=1.42 ps=1.42 nrd=0.69047619047619  nrs=0.69047619047619 sa=0 sb=0 sd=0 mult=1 m=1
XMRD_c1_r100_0600_2_2 rbl_c1_r100_0600_2 sn_c1_r100_0600_2_2 rwl_des 0 sky130_fd_pr__nfet_01v8 L=0.15 W=0.42 nf=1 ad=0.1218 as=0.1218 pd=1.42 ps=1.42 nrd=0.69047619047619  nrs=0.69047619047619 sa=0 sb=0 sd=0 mult=1 m=1
csn_c1_r100_0600_2_2 sn_c1_r100_0600_2_2 0 {C_SN}
XMWR_c1_r100_0600_2_3 sn_c1_r100_0600_2_3 0 0 0 sky130_fd_pr__nfet_01v8 L=0.15 W=0.42 nf=1 ad=0.1218 as=0.1218 pd=1.42 ps=1.42 nrd=0.69047619047619  nrs=0.69047619047619 sa=0 sb=0 sd=0 mult=1 m=1
XMRD_c1_r100_0600_2_3 rbl_c1_r100_0600_2 sn_c1_r100_0600_2_3 rwl_des 0 sky130_fd_pr__nfet_01v8 L=0.15 W=0.42 nf=1 ad=0.1218 as=0.1218 pd=1.42 ps=1.42 nrd=0.69047619047619  nrs=0.69047619047619 sa=0 sb=0 sd=0 mult=1 m=1
csn_c1_r100_0600_2_3 sn_c1_r100_0600_2_3 0 {C_SN}
crbl_c1_r100_0600_2 rbl_c1_r100_0600_2 0 {C_RBL}
spr_c1_r100_0600_2 pref_100 ref_c1_r100_0600_2 ctl 0 swpre
cref_c1_r100_0600_2 ref_c1_r100_0600_2 0 {C_RBL}   $ ASSUMPTION: ideal matched dummy load
XMN1_c1_r100_0600_2 rbl_c1_r100_0600_2 ref_c1_r100_0600_2 vn_c1_r100_0600_2 0 sky130_fd_pr__nfet_01v8 L=0.15 W=1 nf=1 ad=0.29 as=0.29 pd=2.58 ps=2.58 nrd=0.29 nrs=0.29 sa=0 sb=0 sd=0 mult=1 m=1
XMN2_c1_r100_0600_2 ref_c1_r100_0600_2 rbl_c1_r100_0600_2 vn_c1_r100_0600_2 0 sky130_fd_pr__nfet_01v8 L=0.15 W=1 nf=1 ad=0.29 as=0.29 pd=2.58 ps=2.58 nrd=0.29 nrs=0.29 sa=0 sb=0 sd=0 mult=1 m=1
XMP1_c1_r100_0600_2 rbl_c1_r100_0600_2 ref_c1_r100_0600_2 vp_c1_r100_0600_2 vdd sky130_fd_pr__pfet_01v8 L=0.15 W=2 nf=1 ad=0.58 as=0.58 pd=4.58 ps=4.58 nrd=0.145 nrs=0.145 sa=0 sb=0 sd=0 mult=1 m=1
XMP2_c1_r100_0600_2 ref_c1_r100_0600_2 rbl_c1_r100_0600_2 vp_c1_r100_0600_2 vdd sky130_fd_pr__pfet_01v8 L=0.15 W=2 nf=1 ad=0.58 as=0.58 pd=4.58 ps=4.58 nrd=0.145 nrs=0.145 sa=0 sb=0 sd=0 mult=1 m=1
XMNF_c1_r100_0600_2 vn_c1_r100_0600_2 en 0 0 sky130_fd_pr__nfet_01v8 L=0.15 W=2 nf=1 ad=0.58 as=0.58 pd=4.58 ps=4.58 nrd=0.145 nrs=0.145 sa=0 sb=0 sd=0 mult=1 m=1
XMPH_c1_r100_0600_2 vp_c1_r100_0600_2 enb vdd vdd sky130_fd_pr__pfet_01v8 L=0.15 W=4 nf=1 ad=1.16 as=1.16 pd=8.58 ps=8.58 nrd=0.0725 nrs=0.0725 sa=0 sb=0 sd=0 mult=1 m=1
bd_c1_r100_0600_2 d_c1_r100_0600_2 0 v=v(rbl_c1_r100_0600_2)-v(ref_c1_r100_0600_2)
bdabs_c1_r100_0600_2 dabs_c1_r100_0600_2 0 v=abs(v(rbl_c1_r100_0600_2)-v(ref_c1_r100_0600_2))

* ---- c1_r100_0600_3: cell1 SN = 0.6 V, ref offset 0.1 V, replica 3 ----
spa_c1_r100_0600_3 prea rbl_c1_r100_0600_3 ctl 0 swpre
XMWR_c1_r100_0600_3_0 sn_c1_r100_0600_3_0 0 0 0 sky130_fd_pr__nfet_01v8 L=0.15 W=0.42 nf=1 ad=0.1218 as=0.1218 pd=1.42 ps=1.42 nrd=0.69047619047619  nrs=0.69047619047619 sa=0 sb=0 sd=0 mult=1 m=1
XMRD_c1_r100_0600_3_0 rbl_c1_r100_0600_3 sn_c1_r100_0600_3_0 rwl_sel 0 sky130_fd_pr__nfet_01v8 L=0.15 W=0.42 nf=1 ad=0.1218 as=0.1218 pd=1.42 ps=1.42 nrd=0.69047619047619  nrs=0.69047619047619 sa=0 sb=0 sd=0 mult=1 m=1
csn_c1_r100_0600_3_0 sn_c1_r100_0600_3_0 0 {C_SN}
XMWR_c1_r100_0600_3_1 sn_c1_r100_0600_3_1 0 0 0 sky130_fd_pr__nfet_01v8 L=0.15 W=0.42 nf=1 ad=0.1218 as=0.1218 pd=1.42 ps=1.42 nrd=0.69047619047619  nrs=0.69047619047619 sa=0 sb=0 sd=0 mult=1 m=1
XMRD_c1_r100_0600_3_1 rbl_c1_r100_0600_3 sn_c1_r100_0600_3_1 rwl_des 0 sky130_fd_pr__nfet_01v8 L=0.15 W=0.42 nf=1 ad=0.1218 as=0.1218 pd=1.42 ps=1.42 nrd=0.69047619047619  nrs=0.69047619047619 sa=0 sb=0 sd=0 mult=1 m=1
csn_c1_r100_0600_3_1 sn_c1_r100_0600_3_1 0 {C_SN}
XMWR_c1_r100_0600_3_2 sn_c1_r100_0600_3_2 0 0 0 sky130_fd_pr__nfet_01v8 L=0.15 W=0.42 nf=1 ad=0.1218 as=0.1218 pd=1.42 ps=1.42 nrd=0.69047619047619  nrs=0.69047619047619 sa=0 sb=0 sd=0 mult=1 m=1
XMRD_c1_r100_0600_3_2 rbl_c1_r100_0600_3 sn_c1_r100_0600_3_2 rwl_des 0 sky130_fd_pr__nfet_01v8 L=0.15 W=0.42 nf=1 ad=0.1218 as=0.1218 pd=1.42 ps=1.42 nrd=0.69047619047619  nrs=0.69047619047619 sa=0 sb=0 sd=0 mult=1 m=1
csn_c1_r100_0600_3_2 sn_c1_r100_0600_3_2 0 {C_SN}
XMWR_c1_r100_0600_3_3 sn_c1_r100_0600_3_3 0 0 0 sky130_fd_pr__nfet_01v8 L=0.15 W=0.42 nf=1 ad=0.1218 as=0.1218 pd=1.42 ps=1.42 nrd=0.69047619047619  nrs=0.69047619047619 sa=0 sb=0 sd=0 mult=1 m=1
XMRD_c1_r100_0600_3_3 rbl_c1_r100_0600_3 sn_c1_r100_0600_3_3 rwl_des 0 sky130_fd_pr__nfet_01v8 L=0.15 W=0.42 nf=1 ad=0.1218 as=0.1218 pd=1.42 ps=1.42 nrd=0.69047619047619  nrs=0.69047619047619 sa=0 sb=0 sd=0 mult=1 m=1
csn_c1_r100_0600_3_3 sn_c1_r100_0600_3_3 0 {C_SN}
crbl_c1_r100_0600_3 rbl_c1_r100_0600_3 0 {C_RBL}
spr_c1_r100_0600_3 pref_100 ref_c1_r100_0600_3 ctl 0 swpre
cref_c1_r100_0600_3 ref_c1_r100_0600_3 0 {C_RBL}   $ ASSUMPTION: ideal matched dummy load
XMN1_c1_r100_0600_3 rbl_c1_r100_0600_3 ref_c1_r100_0600_3 vn_c1_r100_0600_3 0 sky130_fd_pr__nfet_01v8 L=0.15 W=1 nf=1 ad=0.29 as=0.29 pd=2.58 ps=2.58 nrd=0.29 nrs=0.29 sa=0 sb=0 sd=0 mult=1 m=1
XMN2_c1_r100_0600_3 ref_c1_r100_0600_3 rbl_c1_r100_0600_3 vn_c1_r100_0600_3 0 sky130_fd_pr__nfet_01v8 L=0.15 W=1 nf=1 ad=0.29 as=0.29 pd=2.58 ps=2.58 nrd=0.29 nrs=0.29 sa=0 sb=0 sd=0 mult=1 m=1
XMP1_c1_r100_0600_3 rbl_c1_r100_0600_3 ref_c1_r100_0600_3 vp_c1_r100_0600_3 vdd sky130_fd_pr__pfet_01v8 L=0.15 W=2 nf=1 ad=0.58 as=0.58 pd=4.58 ps=4.58 nrd=0.145 nrs=0.145 sa=0 sb=0 sd=0 mult=1 m=1
XMP2_c1_r100_0600_3 ref_c1_r100_0600_3 rbl_c1_r100_0600_3 vp_c1_r100_0600_3 vdd sky130_fd_pr__pfet_01v8 L=0.15 W=2 nf=1 ad=0.58 as=0.58 pd=4.58 ps=4.58 nrd=0.145 nrs=0.145 sa=0 sb=0 sd=0 mult=1 m=1
XMNF_c1_r100_0600_3 vn_c1_r100_0600_3 en 0 0 sky130_fd_pr__nfet_01v8 L=0.15 W=2 nf=1 ad=0.58 as=0.58 pd=4.58 ps=4.58 nrd=0.145 nrs=0.145 sa=0 sb=0 sd=0 mult=1 m=1
XMPH_c1_r100_0600_3 vp_c1_r100_0600_3 enb vdd vdd sky130_fd_pr__pfet_01v8 L=0.15 W=4 nf=1 ad=1.16 as=1.16 pd=8.58 ps=8.58 nrd=0.0725 nrs=0.0725 sa=0 sb=0 sd=0 mult=1 m=1
bd_c1_r100_0600_3 d_c1_r100_0600_3 0 v=v(rbl_c1_r100_0600_3)-v(ref_c1_r100_0600_3)
bdabs_c1_r100_0600_3 dabs_c1_r100_0600_3 0 v=abs(v(rbl_c1_r100_0600_3)-v(ref_c1_r100_0600_3))

* ---- c1_r100_0650_0: cell1 SN = 0.65 V, ref offset 0.1 V, replica 0 ----
spa_c1_r100_0650_0 prea rbl_c1_r100_0650_0 ctl 0 swpre
XMWR_c1_r100_0650_0_0 sn_c1_r100_0650_0_0 0 0 0 sky130_fd_pr__nfet_01v8 L=0.15 W=0.42 nf=1 ad=0.1218 as=0.1218 pd=1.42 ps=1.42 nrd=0.69047619047619  nrs=0.69047619047619 sa=0 sb=0 sd=0 mult=1 m=1
XMRD_c1_r100_0650_0_0 rbl_c1_r100_0650_0 sn_c1_r100_0650_0_0 rwl_sel 0 sky130_fd_pr__nfet_01v8 L=0.15 W=0.42 nf=1 ad=0.1218 as=0.1218 pd=1.42 ps=1.42 nrd=0.69047619047619  nrs=0.69047619047619 sa=0 sb=0 sd=0 mult=1 m=1
csn_c1_r100_0650_0_0 sn_c1_r100_0650_0_0 0 {C_SN}
XMWR_c1_r100_0650_0_1 sn_c1_r100_0650_0_1 0 0 0 sky130_fd_pr__nfet_01v8 L=0.15 W=0.42 nf=1 ad=0.1218 as=0.1218 pd=1.42 ps=1.42 nrd=0.69047619047619  nrs=0.69047619047619 sa=0 sb=0 sd=0 mult=1 m=1
XMRD_c1_r100_0650_0_1 rbl_c1_r100_0650_0 sn_c1_r100_0650_0_1 rwl_des 0 sky130_fd_pr__nfet_01v8 L=0.15 W=0.42 nf=1 ad=0.1218 as=0.1218 pd=1.42 ps=1.42 nrd=0.69047619047619  nrs=0.69047619047619 sa=0 sb=0 sd=0 mult=1 m=1
csn_c1_r100_0650_0_1 sn_c1_r100_0650_0_1 0 {C_SN}
XMWR_c1_r100_0650_0_2 sn_c1_r100_0650_0_2 0 0 0 sky130_fd_pr__nfet_01v8 L=0.15 W=0.42 nf=1 ad=0.1218 as=0.1218 pd=1.42 ps=1.42 nrd=0.69047619047619  nrs=0.69047619047619 sa=0 sb=0 sd=0 mult=1 m=1
XMRD_c1_r100_0650_0_2 rbl_c1_r100_0650_0 sn_c1_r100_0650_0_2 rwl_des 0 sky130_fd_pr__nfet_01v8 L=0.15 W=0.42 nf=1 ad=0.1218 as=0.1218 pd=1.42 ps=1.42 nrd=0.69047619047619  nrs=0.69047619047619 sa=0 sb=0 sd=0 mult=1 m=1
csn_c1_r100_0650_0_2 sn_c1_r100_0650_0_2 0 {C_SN}
XMWR_c1_r100_0650_0_3 sn_c1_r100_0650_0_3 0 0 0 sky130_fd_pr__nfet_01v8 L=0.15 W=0.42 nf=1 ad=0.1218 as=0.1218 pd=1.42 ps=1.42 nrd=0.69047619047619  nrs=0.69047619047619 sa=0 sb=0 sd=0 mult=1 m=1
XMRD_c1_r100_0650_0_3 rbl_c1_r100_0650_0 sn_c1_r100_0650_0_3 rwl_des 0 sky130_fd_pr__nfet_01v8 L=0.15 W=0.42 nf=1 ad=0.1218 as=0.1218 pd=1.42 ps=1.42 nrd=0.69047619047619  nrs=0.69047619047619 sa=0 sb=0 sd=0 mult=1 m=1
csn_c1_r100_0650_0_3 sn_c1_r100_0650_0_3 0 {C_SN}
crbl_c1_r100_0650_0 rbl_c1_r100_0650_0 0 {C_RBL}
spr_c1_r100_0650_0 pref_100 ref_c1_r100_0650_0 ctl 0 swpre
cref_c1_r100_0650_0 ref_c1_r100_0650_0 0 {C_RBL}   $ ASSUMPTION: ideal matched dummy load
XMN1_c1_r100_0650_0 rbl_c1_r100_0650_0 ref_c1_r100_0650_0 vn_c1_r100_0650_0 0 sky130_fd_pr__nfet_01v8 L=0.15 W=1 nf=1 ad=0.29 as=0.29 pd=2.58 ps=2.58 nrd=0.29 nrs=0.29 sa=0 sb=0 sd=0 mult=1 m=1
XMN2_c1_r100_0650_0 ref_c1_r100_0650_0 rbl_c1_r100_0650_0 vn_c1_r100_0650_0 0 sky130_fd_pr__nfet_01v8 L=0.15 W=1 nf=1 ad=0.29 as=0.29 pd=2.58 ps=2.58 nrd=0.29 nrs=0.29 sa=0 sb=0 sd=0 mult=1 m=1
XMP1_c1_r100_0650_0 rbl_c1_r100_0650_0 ref_c1_r100_0650_0 vp_c1_r100_0650_0 vdd sky130_fd_pr__pfet_01v8 L=0.15 W=2 nf=1 ad=0.58 as=0.58 pd=4.58 ps=4.58 nrd=0.145 nrs=0.145 sa=0 sb=0 sd=0 mult=1 m=1
XMP2_c1_r100_0650_0 ref_c1_r100_0650_0 rbl_c1_r100_0650_0 vp_c1_r100_0650_0 vdd sky130_fd_pr__pfet_01v8 L=0.15 W=2 nf=1 ad=0.58 as=0.58 pd=4.58 ps=4.58 nrd=0.145 nrs=0.145 sa=0 sb=0 sd=0 mult=1 m=1
XMNF_c1_r100_0650_0 vn_c1_r100_0650_0 en 0 0 sky130_fd_pr__nfet_01v8 L=0.15 W=2 nf=1 ad=0.58 as=0.58 pd=4.58 ps=4.58 nrd=0.145 nrs=0.145 sa=0 sb=0 sd=0 mult=1 m=1
XMPH_c1_r100_0650_0 vp_c1_r100_0650_0 enb vdd vdd sky130_fd_pr__pfet_01v8 L=0.15 W=4 nf=1 ad=1.16 as=1.16 pd=8.58 ps=8.58 nrd=0.0725 nrs=0.0725 sa=0 sb=0 sd=0 mult=1 m=1
bd_c1_r100_0650_0 d_c1_r100_0650_0 0 v=v(rbl_c1_r100_0650_0)-v(ref_c1_r100_0650_0)
bdabs_c1_r100_0650_0 dabs_c1_r100_0650_0 0 v=abs(v(rbl_c1_r100_0650_0)-v(ref_c1_r100_0650_0))

* ---- c1_r100_0650_1: cell1 SN = 0.65 V, ref offset 0.1 V, replica 1 ----
spa_c1_r100_0650_1 prea rbl_c1_r100_0650_1 ctl 0 swpre
XMWR_c1_r100_0650_1_0 sn_c1_r100_0650_1_0 0 0 0 sky130_fd_pr__nfet_01v8 L=0.15 W=0.42 nf=1 ad=0.1218 as=0.1218 pd=1.42 ps=1.42 nrd=0.69047619047619  nrs=0.69047619047619 sa=0 sb=0 sd=0 mult=1 m=1
XMRD_c1_r100_0650_1_0 rbl_c1_r100_0650_1 sn_c1_r100_0650_1_0 rwl_sel 0 sky130_fd_pr__nfet_01v8 L=0.15 W=0.42 nf=1 ad=0.1218 as=0.1218 pd=1.42 ps=1.42 nrd=0.69047619047619  nrs=0.69047619047619 sa=0 sb=0 sd=0 mult=1 m=1
csn_c1_r100_0650_1_0 sn_c1_r100_0650_1_0 0 {C_SN}
XMWR_c1_r100_0650_1_1 sn_c1_r100_0650_1_1 0 0 0 sky130_fd_pr__nfet_01v8 L=0.15 W=0.42 nf=1 ad=0.1218 as=0.1218 pd=1.42 ps=1.42 nrd=0.69047619047619  nrs=0.69047619047619 sa=0 sb=0 sd=0 mult=1 m=1
XMRD_c1_r100_0650_1_1 rbl_c1_r100_0650_1 sn_c1_r100_0650_1_1 rwl_des 0 sky130_fd_pr__nfet_01v8 L=0.15 W=0.42 nf=1 ad=0.1218 as=0.1218 pd=1.42 ps=1.42 nrd=0.69047619047619  nrs=0.69047619047619 sa=0 sb=0 sd=0 mult=1 m=1
csn_c1_r100_0650_1_1 sn_c1_r100_0650_1_1 0 {C_SN}
XMWR_c1_r100_0650_1_2 sn_c1_r100_0650_1_2 0 0 0 sky130_fd_pr__nfet_01v8 L=0.15 W=0.42 nf=1 ad=0.1218 as=0.1218 pd=1.42 ps=1.42 nrd=0.69047619047619  nrs=0.69047619047619 sa=0 sb=0 sd=0 mult=1 m=1
XMRD_c1_r100_0650_1_2 rbl_c1_r100_0650_1 sn_c1_r100_0650_1_2 rwl_des 0 sky130_fd_pr__nfet_01v8 L=0.15 W=0.42 nf=1 ad=0.1218 as=0.1218 pd=1.42 ps=1.42 nrd=0.69047619047619  nrs=0.69047619047619 sa=0 sb=0 sd=0 mult=1 m=1
csn_c1_r100_0650_1_2 sn_c1_r100_0650_1_2 0 {C_SN}
XMWR_c1_r100_0650_1_3 sn_c1_r100_0650_1_3 0 0 0 sky130_fd_pr__nfet_01v8 L=0.15 W=0.42 nf=1 ad=0.1218 as=0.1218 pd=1.42 ps=1.42 nrd=0.69047619047619  nrs=0.69047619047619 sa=0 sb=0 sd=0 mult=1 m=1
XMRD_c1_r100_0650_1_3 rbl_c1_r100_0650_1 sn_c1_r100_0650_1_3 rwl_des 0 sky130_fd_pr__nfet_01v8 L=0.15 W=0.42 nf=1 ad=0.1218 as=0.1218 pd=1.42 ps=1.42 nrd=0.69047619047619  nrs=0.69047619047619 sa=0 sb=0 sd=0 mult=1 m=1
csn_c1_r100_0650_1_3 sn_c1_r100_0650_1_3 0 {C_SN}
crbl_c1_r100_0650_1 rbl_c1_r100_0650_1 0 {C_RBL}
spr_c1_r100_0650_1 pref_100 ref_c1_r100_0650_1 ctl 0 swpre
cref_c1_r100_0650_1 ref_c1_r100_0650_1 0 {C_RBL}   $ ASSUMPTION: ideal matched dummy load
XMN1_c1_r100_0650_1 rbl_c1_r100_0650_1 ref_c1_r100_0650_1 vn_c1_r100_0650_1 0 sky130_fd_pr__nfet_01v8 L=0.15 W=1 nf=1 ad=0.29 as=0.29 pd=2.58 ps=2.58 nrd=0.29 nrs=0.29 sa=0 sb=0 sd=0 mult=1 m=1
XMN2_c1_r100_0650_1 ref_c1_r100_0650_1 rbl_c1_r100_0650_1 vn_c1_r100_0650_1 0 sky130_fd_pr__nfet_01v8 L=0.15 W=1 nf=1 ad=0.29 as=0.29 pd=2.58 ps=2.58 nrd=0.29 nrs=0.29 sa=0 sb=0 sd=0 mult=1 m=1
XMP1_c1_r100_0650_1 rbl_c1_r100_0650_1 ref_c1_r100_0650_1 vp_c1_r100_0650_1 vdd sky130_fd_pr__pfet_01v8 L=0.15 W=2 nf=1 ad=0.58 as=0.58 pd=4.58 ps=4.58 nrd=0.145 nrs=0.145 sa=0 sb=0 sd=0 mult=1 m=1
XMP2_c1_r100_0650_1 ref_c1_r100_0650_1 rbl_c1_r100_0650_1 vp_c1_r100_0650_1 vdd sky130_fd_pr__pfet_01v8 L=0.15 W=2 nf=1 ad=0.58 as=0.58 pd=4.58 ps=4.58 nrd=0.145 nrs=0.145 sa=0 sb=0 sd=0 mult=1 m=1
XMNF_c1_r100_0650_1 vn_c1_r100_0650_1 en 0 0 sky130_fd_pr__nfet_01v8 L=0.15 W=2 nf=1 ad=0.58 as=0.58 pd=4.58 ps=4.58 nrd=0.145 nrs=0.145 sa=0 sb=0 sd=0 mult=1 m=1
XMPH_c1_r100_0650_1 vp_c1_r100_0650_1 enb vdd vdd sky130_fd_pr__pfet_01v8 L=0.15 W=4 nf=1 ad=1.16 as=1.16 pd=8.58 ps=8.58 nrd=0.0725 nrs=0.0725 sa=0 sb=0 sd=0 mult=1 m=1
bd_c1_r100_0650_1 d_c1_r100_0650_1 0 v=v(rbl_c1_r100_0650_1)-v(ref_c1_r100_0650_1)
bdabs_c1_r100_0650_1 dabs_c1_r100_0650_1 0 v=abs(v(rbl_c1_r100_0650_1)-v(ref_c1_r100_0650_1))

* ---- c1_r100_0650_2: cell1 SN = 0.65 V, ref offset 0.1 V, replica 2 ----
spa_c1_r100_0650_2 prea rbl_c1_r100_0650_2 ctl 0 swpre
XMWR_c1_r100_0650_2_0 sn_c1_r100_0650_2_0 0 0 0 sky130_fd_pr__nfet_01v8 L=0.15 W=0.42 nf=1 ad=0.1218 as=0.1218 pd=1.42 ps=1.42 nrd=0.69047619047619  nrs=0.69047619047619 sa=0 sb=0 sd=0 mult=1 m=1
XMRD_c1_r100_0650_2_0 rbl_c1_r100_0650_2 sn_c1_r100_0650_2_0 rwl_sel 0 sky130_fd_pr__nfet_01v8 L=0.15 W=0.42 nf=1 ad=0.1218 as=0.1218 pd=1.42 ps=1.42 nrd=0.69047619047619  nrs=0.69047619047619 sa=0 sb=0 sd=0 mult=1 m=1
csn_c1_r100_0650_2_0 sn_c1_r100_0650_2_0 0 {C_SN}
XMWR_c1_r100_0650_2_1 sn_c1_r100_0650_2_1 0 0 0 sky130_fd_pr__nfet_01v8 L=0.15 W=0.42 nf=1 ad=0.1218 as=0.1218 pd=1.42 ps=1.42 nrd=0.69047619047619  nrs=0.69047619047619 sa=0 sb=0 sd=0 mult=1 m=1
XMRD_c1_r100_0650_2_1 rbl_c1_r100_0650_2 sn_c1_r100_0650_2_1 rwl_des 0 sky130_fd_pr__nfet_01v8 L=0.15 W=0.42 nf=1 ad=0.1218 as=0.1218 pd=1.42 ps=1.42 nrd=0.69047619047619  nrs=0.69047619047619 sa=0 sb=0 sd=0 mult=1 m=1
csn_c1_r100_0650_2_1 sn_c1_r100_0650_2_1 0 {C_SN}
XMWR_c1_r100_0650_2_2 sn_c1_r100_0650_2_2 0 0 0 sky130_fd_pr__nfet_01v8 L=0.15 W=0.42 nf=1 ad=0.1218 as=0.1218 pd=1.42 ps=1.42 nrd=0.69047619047619  nrs=0.69047619047619 sa=0 sb=0 sd=0 mult=1 m=1
XMRD_c1_r100_0650_2_2 rbl_c1_r100_0650_2 sn_c1_r100_0650_2_2 rwl_des 0 sky130_fd_pr__nfet_01v8 L=0.15 W=0.42 nf=1 ad=0.1218 as=0.1218 pd=1.42 ps=1.42 nrd=0.69047619047619  nrs=0.69047619047619 sa=0 sb=0 sd=0 mult=1 m=1
csn_c1_r100_0650_2_2 sn_c1_r100_0650_2_2 0 {C_SN}
XMWR_c1_r100_0650_2_3 sn_c1_r100_0650_2_3 0 0 0 sky130_fd_pr__nfet_01v8 L=0.15 W=0.42 nf=1 ad=0.1218 as=0.1218 pd=1.42 ps=1.42 nrd=0.69047619047619  nrs=0.69047619047619 sa=0 sb=0 sd=0 mult=1 m=1
XMRD_c1_r100_0650_2_3 rbl_c1_r100_0650_2 sn_c1_r100_0650_2_3 rwl_des 0 sky130_fd_pr__nfet_01v8 L=0.15 W=0.42 nf=1 ad=0.1218 as=0.1218 pd=1.42 ps=1.42 nrd=0.69047619047619  nrs=0.69047619047619 sa=0 sb=0 sd=0 mult=1 m=1
csn_c1_r100_0650_2_3 sn_c1_r100_0650_2_3 0 {C_SN}
crbl_c1_r100_0650_2 rbl_c1_r100_0650_2 0 {C_RBL}
spr_c1_r100_0650_2 pref_100 ref_c1_r100_0650_2 ctl 0 swpre
cref_c1_r100_0650_2 ref_c1_r100_0650_2 0 {C_RBL}   $ ASSUMPTION: ideal matched dummy load
XMN1_c1_r100_0650_2 rbl_c1_r100_0650_2 ref_c1_r100_0650_2 vn_c1_r100_0650_2 0 sky130_fd_pr__nfet_01v8 L=0.15 W=1 nf=1 ad=0.29 as=0.29 pd=2.58 ps=2.58 nrd=0.29 nrs=0.29 sa=0 sb=0 sd=0 mult=1 m=1
XMN2_c1_r100_0650_2 ref_c1_r100_0650_2 rbl_c1_r100_0650_2 vn_c1_r100_0650_2 0 sky130_fd_pr__nfet_01v8 L=0.15 W=1 nf=1 ad=0.29 as=0.29 pd=2.58 ps=2.58 nrd=0.29 nrs=0.29 sa=0 sb=0 sd=0 mult=1 m=1
XMP1_c1_r100_0650_2 rbl_c1_r100_0650_2 ref_c1_r100_0650_2 vp_c1_r100_0650_2 vdd sky130_fd_pr__pfet_01v8 L=0.15 W=2 nf=1 ad=0.58 as=0.58 pd=4.58 ps=4.58 nrd=0.145 nrs=0.145 sa=0 sb=0 sd=0 mult=1 m=1
XMP2_c1_r100_0650_2 ref_c1_r100_0650_2 rbl_c1_r100_0650_2 vp_c1_r100_0650_2 vdd sky130_fd_pr__pfet_01v8 L=0.15 W=2 nf=1 ad=0.58 as=0.58 pd=4.58 ps=4.58 nrd=0.145 nrs=0.145 sa=0 sb=0 sd=0 mult=1 m=1
XMNF_c1_r100_0650_2 vn_c1_r100_0650_2 en 0 0 sky130_fd_pr__nfet_01v8 L=0.15 W=2 nf=1 ad=0.58 as=0.58 pd=4.58 ps=4.58 nrd=0.145 nrs=0.145 sa=0 sb=0 sd=0 mult=1 m=1
XMPH_c1_r100_0650_2 vp_c1_r100_0650_2 enb vdd vdd sky130_fd_pr__pfet_01v8 L=0.15 W=4 nf=1 ad=1.16 as=1.16 pd=8.58 ps=8.58 nrd=0.0725 nrs=0.0725 sa=0 sb=0 sd=0 mult=1 m=1
bd_c1_r100_0650_2 d_c1_r100_0650_2 0 v=v(rbl_c1_r100_0650_2)-v(ref_c1_r100_0650_2)
bdabs_c1_r100_0650_2 dabs_c1_r100_0650_2 0 v=abs(v(rbl_c1_r100_0650_2)-v(ref_c1_r100_0650_2))

* ---- c1_r100_0650_3: cell1 SN = 0.65 V, ref offset 0.1 V, replica 3 ----
spa_c1_r100_0650_3 prea rbl_c1_r100_0650_3 ctl 0 swpre
XMWR_c1_r100_0650_3_0 sn_c1_r100_0650_3_0 0 0 0 sky130_fd_pr__nfet_01v8 L=0.15 W=0.42 nf=1 ad=0.1218 as=0.1218 pd=1.42 ps=1.42 nrd=0.69047619047619  nrs=0.69047619047619 sa=0 sb=0 sd=0 mult=1 m=1
XMRD_c1_r100_0650_3_0 rbl_c1_r100_0650_3 sn_c1_r100_0650_3_0 rwl_sel 0 sky130_fd_pr__nfet_01v8 L=0.15 W=0.42 nf=1 ad=0.1218 as=0.1218 pd=1.42 ps=1.42 nrd=0.69047619047619  nrs=0.69047619047619 sa=0 sb=0 sd=0 mult=1 m=1
csn_c1_r100_0650_3_0 sn_c1_r100_0650_3_0 0 {C_SN}
XMWR_c1_r100_0650_3_1 sn_c1_r100_0650_3_1 0 0 0 sky130_fd_pr__nfet_01v8 L=0.15 W=0.42 nf=1 ad=0.1218 as=0.1218 pd=1.42 ps=1.42 nrd=0.69047619047619  nrs=0.69047619047619 sa=0 sb=0 sd=0 mult=1 m=1
XMRD_c1_r100_0650_3_1 rbl_c1_r100_0650_3 sn_c1_r100_0650_3_1 rwl_des 0 sky130_fd_pr__nfet_01v8 L=0.15 W=0.42 nf=1 ad=0.1218 as=0.1218 pd=1.42 ps=1.42 nrd=0.69047619047619  nrs=0.69047619047619 sa=0 sb=0 sd=0 mult=1 m=1
csn_c1_r100_0650_3_1 sn_c1_r100_0650_3_1 0 {C_SN}
XMWR_c1_r100_0650_3_2 sn_c1_r100_0650_3_2 0 0 0 sky130_fd_pr__nfet_01v8 L=0.15 W=0.42 nf=1 ad=0.1218 as=0.1218 pd=1.42 ps=1.42 nrd=0.69047619047619  nrs=0.69047619047619 sa=0 sb=0 sd=0 mult=1 m=1
XMRD_c1_r100_0650_3_2 rbl_c1_r100_0650_3 sn_c1_r100_0650_3_2 rwl_des 0 sky130_fd_pr__nfet_01v8 L=0.15 W=0.42 nf=1 ad=0.1218 as=0.1218 pd=1.42 ps=1.42 nrd=0.69047619047619  nrs=0.69047619047619 sa=0 sb=0 sd=0 mult=1 m=1
csn_c1_r100_0650_3_2 sn_c1_r100_0650_3_2 0 {C_SN}
XMWR_c1_r100_0650_3_3 sn_c1_r100_0650_3_3 0 0 0 sky130_fd_pr__nfet_01v8 L=0.15 W=0.42 nf=1 ad=0.1218 as=0.1218 pd=1.42 ps=1.42 nrd=0.69047619047619  nrs=0.69047619047619 sa=0 sb=0 sd=0 mult=1 m=1
XMRD_c1_r100_0650_3_3 rbl_c1_r100_0650_3 sn_c1_r100_0650_3_3 rwl_des 0 sky130_fd_pr__nfet_01v8 L=0.15 W=0.42 nf=1 ad=0.1218 as=0.1218 pd=1.42 ps=1.42 nrd=0.69047619047619  nrs=0.69047619047619 sa=0 sb=0 sd=0 mult=1 m=1
csn_c1_r100_0650_3_3 sn_c1_r100_0650_3_3 0 {C_SN}
crbl_c1_r100_0650_3 rbl_c1_r100_0650_3 0 {C_RBL}
spr_c1_r100_0650_3 pref_100 ref_c1_r100_0650_3 ctl 0 swpre
cref_c1_r100_0650_3 ref_c1_r100_0650_3 0 {C_RBL}   $ ASSUMPTION: ideal matched dummy load
XMN1_c1_r100_0650_3 rbl_c1_r100_0650_3 ref_c1_r100_0650_3 vn_c1_r100_0650_3 0 sky130_fd_pr__nfet_01v8 L=0.15 W=1 nf=1 ad=0.29 as=0.29 pd=2.58 ps=2.58 nrd=0.29 nrs=0.29 sa=0 sb=0 sd=0 mult=1 m=1
XMN2_c1_r100_0650_3 ref_c1_r100_0650_3 rbl_c1_r100_0650_3 vn_c1_r100_0650_3 0 sky130_fd_pr__nfet_01v8 L=0.15 W=1 nf=1 ad=0.29 as=0.29 pd=2.58 ps=2.58 nrd=0.29 nrs=0.29 sa=0 sb=0 sd=0 mult=1 m=1
XMP1_c1_r100_0650_3 rbl_c1_r100_0650_3 ref_c1_r100_0650_3 vp_c1_r100_0650_3 vdd sky130_fd_pr__pfet_01v8 L=0.15 W=2 nf=1 ad=0.58 as=0.58 pd=4.58 ps=4.58 nrd=0.145 nrs=0.145 sa=0 sb=0 sd=0 mult=1 m=1
XMP2_c1_r100_0650_3 ref_c1_r100_0650_3 rbl_c1_r100_0650_3 vp_c1_r100_0650_3 vdd sky130_fd_pr__pfet_01v8 L=0.15 W=2 nf=1 ad=0.58 as=0.58 pd=4.58 ps=4.58 nrd=0.145 nrs=0.145 sa=0 sb=0 sd=0 mult=1 m=1
XMNF_c1_r100_0650_3 vn_c1_r100_0650_3 en 0 0 sky130_fd_pr__nfet_01v8 L=0.15 W=2 nf=1 ad=0.58 as=0.58 pd=4.58 ps=4.58 nrd=0.145 nrs=0.145 sa=0 sb=0 sd=0 mult=1 m=1
XMPH_c1_r100_0650_3 vp_c1_r100_0650_3 enb vdd vdd sky130_fd_pr__pfet_01v8 L=0.15 W=4 nf=1 ad=1.16 as=1.16 pd=8.58 ps=8.58 nrd=0.0725 nrs=0.0725 sa=0 sb=0 sd=0 mult=1 m=1
bd_c1_r100_0650_3 d_c1_r100_0650_3 0 v=v(rbl_c1_r100_0650_3)-v(ref_c1_r100_0650_3)
bdabs_c1_r100_0650_3 dabs_c1_r100_0650_3 0 v=abs(v(rbl_c1_r100_0650_3)-v(ref_c1_r100_0650_3))

* ---- c1_r100_0700_0: cell1 SN = 0.7 V, ref offset 0.1 V, replica 0 ----
spa_c1_r100_0700_0 prea rbl_c1_r100_0700_0 ctl 0 swpre
XMWR_c1_r100_0700_0_0 sn_c1_r100_0700_0_0 0 0 0 sky130_fd_pr__nfet_01v8 L=0.15 W=0.42 nf=1 ad=0.1218 as=0.1218 pd=1.42 ps=1.42 nrd=0.69047619047619  nrs=0.69047619047619 sa=0 sb=0 sd=0 mult=1 m=1
XMRD_c1_r100_0700_0_0 rbl_c1_r100_0700_0 sn_c1_r100_0700_0_0 rwl_sel 0 sky130_fd_pr__nfet_01v8 L=0.15 W=0.42 nf=1 ad=0.1218 as=0.1218 pd=1.42 ps=1.42 nrd=0.69047619047619  nrs=0.69047619047619 sa=0 sb=0 sd=0 mult=1 m=1
csn_c1_r100_0700_0_0 sn_c1_r100_0700_0_0 0 {C_SN}
XMWR_c1_r100_0700_0_1 sn_c1_r100_0700_0_1 0 0 0 sky130_fd_pr__nfet_01v8 L=0.15 W=0.42 nf=1 ad=0.1218 as=0.1218 pd=1.42 ps=1.42 nrd=0.69047619047619  nrs=0.69047619047619 sa=0 sb=0 sd=0 mult=1 m=1
XMRD_c1_r100_0700_0_1 rbl_c1_r100_0700_0 sn_c1_r100_0700_0_1 rwl_des 0 sky130_fd_pr__nfet_01v8 L=0.15 W=0.42 nf=1 ad=0.1218 as=0.1218 pd=1.42 ps=1.42 nrd=0.69047619047619  nrs=0.69047619047619 sa=0 sb=0 sd=0 mult=1 m=1
csn_c1_r100_0700_0_1 sn_c1_r100_0700_0_1 0 {C_SN}
XMWR_c1_r100_0700_0_2 sn_c1_r100_0700_0_2 0 0 0 sky130_fd_pr__nfet_01v8 L=0.15 W=0.42 nf=1 ad=0.1218 as=0.1218 pd=1.42 ps=1.42 nrd=0.69047619047619  nrs=0.69047619047619 sa=0 sb=0 sd=0 mult=1 m=1
XMRD_c1_r100_0700_0_2 rbl_c1_r100_0700_0 sn_c1_r100_0700_0_2 rwl_des 0 sky130_fd_pr__nfet_01v8 L=0.15 W=0.42 nf=1 ad=0.1218 as=0.1218 pd=1.42 ps=1.42 nrd=0.69047619047619  nrs=0.69047619047619 sa=0 sb=0 sd=0 mult=1 m=1
csn_c1_r100_0700_0_2 sn_c1_r100_0700_0_2 0 {C_SN}
XMWR_c1_r100_0700_0_3 sn_c1_r100_0700_0_3 0 0 0 sky130_fd_pr__nfet_01v8 L=0.15 W=0.42 nf=1 ad=0.1218 as=0.1218 pd=1.42 ps=1.42 nrd=0.69047619047619  nrs=0.69047619047619 sa=0 sb=0 sd=0 mult=1 m=1
XMRD_c1_r100_0700_0_3 rbl_c1_r100_0700_0 sn_c1_r100_0700_0_3 rwl_des 0 sky130_fd_pr__nfet_01v8 L=0.15 W=0.42 nf=1 ad=0.1218 as=0.1218 pd=1.42 ps=1.42 nrd=0.69047619047619  nrs=0.69047619047619 sa=0 sb=0 sd=0 mult=1 m=1
csn_c1_r100_0700_0_3 sn_c1_r100_0700_0_3 0 {C_SN}
crbl_c1_r100_0700_0 rbl_c1_r100_0700_0 0 {C_RBL}
spr_c1_r100_0700_0 pref_100 ref_c1_r100_0700_0 ctl 0 swpre
cref_c1_r100_0700_0 ref_c1_r100_0700_0 0 {C_RBL}   $ ASSUMPTION: ideal matched dummy load
XMN1_c1_r100_0700_0 rbl_c1_r100_0700_0 ref_c1_r100_0700_0 vn_c1_r100_0700_0 0 sky130_fd_pr__nfet_01v8 L=0.15 W=1 nf=1 ad=0.29 as=0.29 pd=2.58 ps=2.58 nrd=0.29 nrs=0.29 sa=0 sb=0 sd=0 mult=1 m=1
XMN2_c1_r100_0700_0 ref_c1_r100_0700_0 rbl_c1_r100_0700_0 vn_c1_r100_0700_0 0 sky130_fd_pr__nfet_01v8 L=0.15 W=1 nf=1 ad=0.29 as=0.29 pd=2.58 ps=2.58 nrd=0.29 nrs=0.29 sa=0 sb=0 sd=0 mult=1 m=1
XMP1_c1_r100_0700_0 rbl_c1_r100_0700_0 ref_c1_r100_0700_0 vp_c1_r100_0700_0 vdd sky130_fd_pr__pfet_01v8 L=0.15 W=2 nf=1 ad=0.58 as=0.58 pd=4.58 ps=4.58 nrd=0.145 nrs=0.145 sa=0 sb=0 sd=0 mult=1 m=1
XMP2_c1_r100_0700_0 ref_c1_r100_0700_0 rbl_c1_r100_0700_0 vp_c1_r100_0700_0 vdd sky130_fd_pr__pfet_01v8 L=0.15 W=2 nf=1 ad=0.58 as=0.58 pd=4.58 ps=4.58 nrd=0.145 nrs=0.145 sa=0 sb=0 sd=0 mult=1 m=1
XMNF_c1_r100_0700_0 vn_c1_r100_0700_0 en 0 0 sky130_fd_pr__nfet_01v8 L=0.15 W=2 nf=1 ad=0.58 as=0.58 pd=4.58 ps=4.58 nrd=0.145 nrs=0.145 sa=0 sb=0 sd=0 mult=1 m=1
XMPH_c1_r100_0700_0 vp_c1_r100_0700_0 enb vdd vdd sky130_fd_pr__pfet_01v8 L=0.15 W=4 nf=1 ad=1.16 as=1.16 pd=8.58 ps=8.58 nrd=0.0725 nrs=0.0725 sa=0 sb=0 sd=0 mult=1 m=1
bd_c1_r100_0700_0 d_c1_r100_0700_0 0 v=v(rbl_c1_r100_0700_0)-v(ref_c1_r100_0700_0)
bdabs_c1_r100_0700_0 dabs_c1_r100_0700_0 0 v=abs(v(rbl_c1_r100_0700_0)-v(ref_c1_r100_0700_0))

* ---- c1_r100_0700_1: cell1 SN = 0.7 V, ref offset 0.1 V, replica 1 ----
spa_c1_r100_0700_1 prea rbl_c1_r100_0700_1 ctl 0 swpre
XMWR_c1_r100_0700_1_0 sn_c1_r100_0700_1_0 0 0 0 sky130_fd_pr__nfet_01v8 L=0.15 W=0.42 nf=1 ad=0.1218 as=0.1218 pd=1.42 ps=1.42 nrd=0.69047619047619  nrs=0.69047619047619 sa=0 sb=0 sd=0 mult=1 m=1
XMRD_c1_r100_0700_1_0 rbl_c1_r100_0700_1 sn_c1_r100_0700_1_0 rwl_sel 0 sky130_fd_pr__nfet_01v8 L=0.15 W=0.42 nf=1 ad=0.1218 as=0.1218 pd=1.42 ps=1.42 nrd=0.69047619047619  nrs=0.69047619047619 sa=0 sb=0 sd=0 mult=1 m=1
csn_c1_r100_0700_1_0 sn_c1_r100_0700_1_0 0 {C_SN}
XMWR_c1_r100_0700_1_1 sn_c1_r100_0700_1_1 0 0 0 sky130_fd_pr__nfet_01v8 L=0.15 W=0.42 nf=1 ad=0.1218 as=0.1218 pd=1.42 ps=1.42 nrd=0.69047619047619  nrs=0.69047619047619 sa=0 sb=0 sd=0 mult=1 m=1
XMRD_c1_r100_0700_1_1 rbl_c1_r100_0700_1 sn_c1_r100_0700_1_1 rwl_des 0 sky130_fd_pr__nfet_01v8 L=0.15 W=0.42 nf=1 ad=0.1218 as=0.1218 pd=1.42 ps=1.42 nrd=0.69047619047619  nrs=0.69047619047619 sa=0 sb=0 sd=0 mult=1 m=1
csn_c1_r100_0700_1_1 sn_c1_r100_0700_1_1 0 {C_SN}
XMWR_c1_r100_0700_1_2 sn_c1_r100_0700_1_2 0 0 0 sky130_fd_pr__nfet_01v8 L=0.15 W=0.42 nf=1 ad=0.1218 as=0.1218 pd=1.42 ps=1.42 nrd=0.69047619047619  nrs=0.69047619047619 sa=0 sb=0 sd=0 mult=1 m=1
XMRD_c1_r100_0700_1_2 rbl_c1_r100_0700_1 sn_c1_r100_0700_1_2 rwl_des 0 sky130_fd_pr__nfet_01v8 L=0.15 W=0.42 nf=1 ad=0.1218 as=0.1218 pd=1.42 ps=1.42 nrd=0.69047619047619  nrs=0.69047619047619 sa=0 sb=0 sd=0 mult=1 m=1
csn_c1_r100_0700_1_2 sn_c1_r100_0700_1_2 0 {C_SN}
XMWR_c1_r100_0700_1_3 sn_c1_r100_0700_1_3 0 0 0 sky130_fd_pr__nfet_01v8 L=0.15 W=0.42 nf=1 ad=0.1218 as=0.1218 pd=1.42 ps=1.42 nrd=0.69047619047619  nrs=0.69047619047619 sa=0 sb=0 sd=0 mult=1 m=1
XMRD_c1_r100_0700_1_3 rbl_c1_r100_0700_1 sn_c1_r100_0700_1_3 rwl_des 0 sky130_fd_pr__nfet_01v8 L=0.15 W=0.42 nf=1 ad=0.1218 as=0.1218 pd=1.42 ps=1.42 nrd=0.69047619047619  nrs=0.69047619047619 sa=0 sb=0 sd=0 mult=1 m=1
csn_c1_r100_0700_1_3 sn_c1_r100_0700_1_3 0 {C_SN}
crbl_c1_r100_0700_1 rbl_c1_r100_0700_1 0 {C_RBL}
spr_c1_r100_0700_1 pref_100 ref_c1_r100_0700_1 ctl 0 swpre
cref_c1_r100_0700_1 ref_c1_r100_0700_1 0 {C_RBL}   $ ASSUMPTION: ideal matched dummy load
XMN1_c1_r100_0700_1 rbl_c1_r100_0700_1 ref_c1_r100_0700_1 vn_c1_r100_0700_1 0 sky130_fd_pr__nfet_01v8 L=0.15 W=1 nf=1 ad=0.29 as=0.29 pd=2.58 ps=2.58 nrd=0.29 nrs=0.29 sa=0 sb=0 sd=0 mult=1 m=1
XMN2_c1_r100_0700_1 ref_c1_r100_0700_1 rbl_c1_r100_0700_1 vn_c1_r100_0700_1 0 sky130_fd_pr__nfet_01v8 L=0.15 W=1 nf=1 ad=0.29 as=0.29 pd=2.58 ps=2.58 nrd=0.29 nrs=0.29 sa=0 sb=0 sd=0 mult=1 m=1
XMP1_c1_r100_0700_1 rbl_c1_r100_0700_1 ref_c1_r100_0700_1 vp_c1_r100_0700_1 vdd sky130_fd_pr__pfet_01v8 L=0.15 W=2 nf=1 ad=0.58 as=0.58 pd=4.58 ps=4.58 nrd=0.145 nrs=0.145 sa=0 sb=0 sd=0 mult=1 m=1
XMP2_c1_r100_0700_1 ref_c1_r100_0700_1 rbl_c1_r100_0700_1 vp_c1_r100_0700_1 vdd sky130_fd_pr__pfet_01v8 L=0.15 W=2 nf=1 ad=0.58 as=0.58 pd=4.58 ps=4.58 nrd=0.145 nrs=0.145 sa=0 sb=0 sd=0 mult=1 m=1
XMNF_c1_r100_0700_1 vn_c1_r100_0700_1 en 0 0 sky130_fd_pr__nfet_01v8 L=0.15 W=2 nf=1 ad=0.58 as=0.58 pd=4.58 ps=4.58 nrd=0.145 nrs=0.145 sa=0 sb=0 sd=0 mult=1 m=1
XMPH_c1_r100_0700_1 vp_c1_r100_0700_1 enb vdd vdd sky130_fd_pr__pfet_01v8 L=0.15 W=4 nf=1 ad=1.16 as=1.16 pd=8.58 ps=8.58 nrd=0.0725 nrs=0.0725 sa=0 sb=0 sd=0 mult=1 m=1
bd_c1_r100_0700_1 d_c1_r100_0700_1 0 v=v(rbl_c1_r100_0700_1)-v(ref_c1_r100_0700_1)
bdabs_c1_r100_0700_1 dabs_c1_r100_0700_1 0 v=abs(v(rbl_c1_r100_0700_1)-v(ref_c1_r100_0700_1))

* ---- c1_r100_0700_2: cell1 SN = 0.7 V, ref offset 0.1 V, replica 2 ----
spa_c1_r100_0700_2 prea rbl_c1_r100_0700_2 ctl 0 swpre
XMWR_c1_r100_0700_2_0 sn_c1_r100_0700_2_0 0 0 0 sky130_fd_pr__nfet_01v8 L=0.15 W=0.42 nf=1 ad=0.1218 as=0.1218 pd=1.42 ps=1.42 nrd=0.69047619047619  nrs=0.69047619047619 sa=0 sb=0 sd=0 mult=1 m=1
XMRD_c1_r100_0700_2_0 rbl_c1_r100_0700_2 sn_c1_r100_0700_2_0 rwl_sel 0 sky130_fd_pr__nfet_01v8 L=0.15 W=0.42 nf=1 ad=0.1218 as=0.1218 pd=1.42 ps=1.42 nrd=0.69047619047619  nrs=0.69047619047619 sa=0 sb=0 sd=0 mult=1 m=1
csn_c1_r100_0700_2_0 sn_c1_r100_0700_2_0 0 {C_SN}
XMWR_c1_r100_0700_2_1 sn_c1_r100_0700_2_1 0 0 0 sky130_fd_pr__nfet_01v8 L=0.15 W=0.42 nf=1 ad=0.1218 as=0.1218 pd=1.42 ps=1.42 nrd=0.69047619047619  nrs=0.69047619047619 sa=0 sb=0 sd=0 mult=1 m=1
XMRD_c1_r100_0700_2_1 rbl_c1_r100_0700_2 sn_c1_r100_0700_2_1 rwl_des 0 sky130_fd_pr__nfet_01v8 L=0.15 W=0.42 nf=1 ad=0.1218 as=0.1218 pd=1.42 ps=1.42 nrd=0.69047619047619  nrs=0.69047619047619 sa=0 sb=0 sd=0 mult=1 m=1
csn_c1_r100_0700_2_1 sn_c1_r100_0700_2_1 0 {C_SN}
XMWR_c1_r100_0700_2_2 sn_c1_r100_0700_2_2 0 0 0 sky130_fd_pr__nfet_01v8 L=0.15 W=0.42 nf=1 ad=0.1218 as=0.1218 pd=1.42 ps=1.42 nrd=0.69047619047619  nrs=0.69047619047619 sa=0 sb=0 sd=0 mult=1 m=1
XMRD_c1_r100_0700_2_2 rbl_c1_r100_0700_2 sn_c1_r100_0700_2_2 rwl_des 0 sky130_fd_pr__nfet_01v8 L=0.15 W=0.42 nf=1 ad=0.1218 as=0.1218 pd=1.42 ps=1.42 nrd=0.69047619047619  nrs=0.69047619047619 sa=0 sb=0 sd=0 mult=1 m=1
csn_c1_r100_0700_2_2 sn_c1_r100_0700_2_2 0 {C_SN}
XMWR_c1_r100_0700_2_3 sn_c1_r100_0700_2_3 0 0 0 sky130_fd_pr__nfet_01v8 L=0.15 W=0.42 nf=1 ad=0.1218 as=0.1218 pd=1.42 ps=1.42 nrd=0.69047619047619  nrs=0.69047619047619 sa=0 sb=0 sd=0 mult=1 m=1
XMRD_c1_r100_0700_2_3 rbl_c1_r100_0700_2 sn_c1_r100_0700_2_3 rwl_des 0 sky130_fd_pr__nfet_01v8 L=0.15 W=0.42 nf=1 ad=0.1218 as=0.1218 pd=1.42 ps=1.42 nrd=0.69047619047619  nrs=0.69047619047619 sa=0 sb=0 sd=0 mult=1 m=1
csn_c1_r100_0700_2_3 sn_c1_r100_0700_2_3 0 {C_SN}
crbl_c1_r100_0700_2 rbl_c1_r100_0700_2 0 {C_RBL}
spr_c1_r100_0700_2 pref_100 ref_c1_r100_0700_2 ctl 0 swpre
cref_c1_r100_0700_2 ref_c1_r100_0700_2 0 {C_RBL}   $ ASSUMPTION: ideal matched dummy load
XMN1_c1_r100_0700_2 rbl_c1_r100_0700_2 ref_c1_r100_0700_2 vn_c1_r100_0700_2 0 sky130_fd_pr__nfet_01v8 L=0.15 W=1 nf=1 ad=0.29 as=0.29 pd=2.58 ps=2.58 nrd=0.29 nrs=0.29 sa=0 sb=0 sd=0 mult=1 m=1
XMN2_c1_r100_0700_2 ref_c1_r100_0700_2 rbl_c1_r100_0700_2 vn_c1_r100_0700_2 0 sky130_fd_pr__nfet_01v8 L=0.15 W=1 nf=1 ad=0.29 as=0.29 pd=2.58 ps=2.58 nrd=0.29 nrs=0.29 sa=0 sb=0 sd=0 mult=1 m=1
XMP1_c1_r100_0700_2 rbl_c1_r100_0700_2 ref_c1_r100_0700_2 vp_c1_r100_0700_2 vdd sky130_fd_pr__pfet_01v8 L=0.15 W=2 nf=1 ad=0.58 as=0.58 pd=4.58 ps=4.58 nrd=0.145 nrs=0.145 sa=0 sb=0 sd=0 mult=1 m=1
XMP2_c1_r100_0700_2 ref_c1_r100_0700_2 rbl_c1_r100_0700_2 vp_c1_r100_0700_2 vdd sky130_fd_pr__pfet_01v8 L=0.15 W=2 nf=1 ad=0.58 as=0.58 pd=4.58 ps=4.58 nrd=0.145 nrs=0.145 sa=0 sb=0 sd=0 mult=1 m=1
XMNF_c1_r100_0700_2 vn_c1_r100_0700_2 en 0 0 sky130_fd_pr__nfet_01v8 L=0.15 W=2 nf=1 ad=0.58 as=0.58 pd=4.58 ps=4.58 nrd=0.145 nrs=0.145 sa=0 sb=0 sd=0 mult=1 m=1
XMPH_c1_r100_0700_2 vp_c1_r100_0700_2 enb vdd vdd sky130_fd_pr__pfet_01v8 L=0.15 W=4 nf=1 ad=1.16 as=1.16 pd=8.58 ps=8.58 nrd=0.0725 nrs=0.0725 sa=0 sb=0 sd=0 mult=1 m=1
bd_c1_r100_0700_2 d_c1_r100_0700_2 0 v=v(rbl_c1_r100_0700_2)-v(ref_c1_r100_0700_2)
bdabs_c1_r100_0700_2 dabs_c1_r100_0700_2 0 v=abs(v(rbl_c1_r100_0700_2)-v(ref_c1_r100_0700_2))

* ---- c1_r100_0700_3: cell1 SN = 0.7 V, ref offset 0.1 V, replica 3 ----
spa_c1_r100_0700_3 prea rbl_c1_r100_0700_3 ctl 0 swpre
XMWR_c1_r100_0700_3_0 sn_c1_r100_0700_3_0 0 0 0 sky130_fd_pr__nfet_01v8 L=0.15 W=0.42 nf=1 ad=0.1218 as=0.1218 pd=1.42 ps=1.42 nrd=0.69047619047619  nrs=0.69047619047619 sa=0 sb=0 sd=0 mult=1 m=1
XMRD_c1_r100_0700_3_0 rbl_c1_r100_0700_3 sn_c1_r100_0700_3_0 rwl_sel 0 sky130_fd_pr__nfet_01v8 L=0.15 W=0.42 nf=1 ad=0.1218 as=0.1218 pd=1.42 ps=1.42 nrd=0.69047619047619  nrs=0.69047619047619 sa=0 sb=0 sd=0 mult=1 m=1
csn_c1_r100_0700_3_0 sn_c1_r100_0700_3_0 0 {C_SN}
XMWR_c1_r100_0700_3_1 sn_c1_r100_0700_3_1 0 0 0 sky130_fd_pr__nfet_01v8 L=0.15 W=0.42 nf=1 ad=0.1218 as=0.1218 pd=1.42 ps=1.42 nrd=0.69047619047619  nrs=0.69047619047619 sa=0 sb=0 sd=0 mult=1 m=1
XMRD_c1_r100_0700_3_1 rbl_c1_r100_0700_3 sn_c1_r100_0700_3_1 rwl_des 0 sky130_fd_pr__nfet_01v8 L=0.15 W=0.42 nf=1 ad=0.1218 as=0.1218 pd=1.42 ps=1.42 nrd=0.69047619047619  nrs=0.69047619047619 sa=0 sb=0 sd=0 mult=1 m=1
csn_c1_r100_0700_3_1 sn_c1_r100_0700_3_1 0 {C_SN}
XMWR_c1_r100_0700_3_2 sn_c1_r100_0700_3_2 0 0 0 sky130_fd_pr__nfet_01v8 L=0.15 W=0.42 nf=1 ad=0.1218 as=0.1218 pd=1.42 ps=1.42 nrd=0.69047619047619  nrs=0.69047619047619 sa=0 sb=0 sd=0 mult=1 m=1
XMRD_c1_r100_0700_3_2 rbl_c1_r100_0700_3 sn_c1_r100_0700_3_2 rwl_des 0 sky130_fd_pr__nfet_01v8 L=0.15 W=0.42 nf=1 ad=0.1218 as=0.1218 pd=1.42 ps=1.42 nrd=0.69047619047619  nrs=0.69047619047619 sa=0 sb=0 sd=0 mult=1 m=1
csn_c1_r100_0700_3_2 sn_c1_r100_0700_3_2 0 {C_SN}
XMWR_c1_r100_0700_3_3 sn_c1_r100_0700_3_3 0 0 0 sky130_fd_pr__nfet_01v8 L=0.15 W=0.42 nf=1 ad=0.1218 as=0.1218 pd=1.42 ps=1.42 nrd=0.69047619047619  nrs=0.69047619047619 sa=0 sb=0 sd=0 mult=1 m=1
XMRD_c1_r100_0700_3_3 rbl_c1_r100_0700_3 sn_c1_r100_0700_3_3 rwl_des 0 sky130_fd_pr__nfet_01v8 L=0.15 W=0.42 nf=1 ad=0.1218 as=0.1218 pd=1.42 ps=1.42 nrd=0.69047619047619  nrs=0.69047619047619 sa=0 sb=0 sd=0 mult=1 m=1
csn_c1_r100_0700_3_3 sn_c1_r100_0700_3_3 0 {C_SN}
crbl_c1_r100_0700_3 rbl_c1_r100_0700_3 0 {C_RBL}
spr_c1_r100_0700_3 pref_100 ref_c1_r100_0700_3 ctl 0 swpre
cref_c1_r100_0700_3 ref_c1_r100_0700_3 0 {C_RBL}   $ ASSUMPTION: ideal matched dummy load
XMN1_c1_r100_0700_3 rbl_c1_r100_0700_3 ref_c1_r100_0700_3 vn_c1_r100_0700_3 0 sky130_fd_pr__nfet_01v8 L=0.15 W=1 nf=1 ad=0.29 as=0.29 pd=2.58 ps=2.58 nrd=0.29 nrs=0.29 sa=0 sb=0 sd=0 mult=1 m=1
XMN2_c1_r100_0700_3 ref_c1_r100_0700_3 rbl_c1_r100_0700_3 vn_c1_r100_0700_3 0 sky130_fd_pr__nfet_01v8 L=0.15 W=1 nf=1 ad=0.29 as=0.29 pd=2.58 ps=2.58 nrd=0.29 nrs=0.29 sa=0 sb=0 sd=0 mult=1 m=1
XMP1_c1_r100_0700_3 rbl_c1_r100_0700_3 ref_c1_r100_0700_3 vp_c1_r100_0700_3 vdd sky130_fd_pr__pfet_01v8 L=0.15 W=2 nf=1 ad=0.58 as=0.58 pd=4.58 ps=4.58 nrd=0.145 nrs=0.145 sa=0 sb=0 sd=0 mult=1 m=1
XMP2_c1_r100_0700_3 ref_c1_r100_0700_3 rbl_c1_r100_0700_3 vp_c1_r100_0700_3 vdd sky130_fd_pr__pfet_01v8 L=0.15 W=2 nf=1 ad=0.58 as=0.58 pd=4.58 ps=4.58 nrd=0.145 nrs=0.145 sa=0 sb=0 sd=0 mult=1 m=1
XMNF_c1_r100_0700_3 vn_c1_r100_0700_3 en 0 0 sky130_fd_pr__nfet_01v8 L=0.15 W=2 nf=1 ad=0.58 as=0.58 pd=4.58 ps=4.58 nrd=0.145 nrs=0.145 sa=0 sb=0 sd=0 mult=1 m=1
XMPH_c1_r100_0700_3 vp_c1_r100_0700_3 enb vdd vdd sky130_fd_pr__pfet_01v8 L=0.15 W=4 nf=1 ad=1.16 as=1.16 pd=8.58 ps=8.58 nrd=0.0725 nrs=0.0725 sa=0 sb=0 sd=0 mult=1 m=1
bd_c1_r100_0700_3 d_c1_r100_0700_3 0 v=v(rbl_c1_r100_0700_3)-v(ref_c1_r100_0700_3)
bdabs_c1_r100_0700_3 dabs_c1_r100_0700_3 0 v=abs(v(rbl_c1_r100_0700_3)-v(ref_c1_r100_0700_3))

* ---- c1_r100_0750_0: cell1 SN = 0.75 V, ref offset 0.1 V, replica 0 ----
spa_c1_r100_0750_0 prea rbl_c1_r100_0750_0 ctl 0 swpre
XMWR_c1_r100_0750_0_0 sn_c1_r100_0750_0_0 0 0 0 sky130_fd_pr__nfet_01v8 L=0.15 W=0.42 nf=1 ad=0.1218 as=0.1218 pd=1.42 ps=1.42 nrd=0.69047619047619  nrs=0.69047619047619 sa=0 sb=0 sd=0 mult=1 m=1
XMRD_c1_r100_0750_0_0 rbl_c1_r100_0750_0 sn_c1_r100_0750_0_0 rwl_sel 0 sky130_fd_pr__nfet_01v8 L=0.15 W=0.42 nf=1 ad=0.1218 as=0.1218 pd=1.42 ps=1.42 nrd=0.69047619047619  nrs=0.69047619047619 sa=0 sb=0 sd=0 mult=1 m=1
csn_c1_r100_0750_0_0 sn_c1_r100_0750_0_0 0 {C_SN}
XMWR_c1_r100_0750_0_1 sn_c1_r100_0750_0_1 0 0 0 sky130_fd_pr__nfet_01v8 L=0.15 W=0.42 nf=1 ad=0.1218 as=0.1218 pd=1.42 ps=1.42 nrd=0.69047619047619  nrs=0.69047619047619 sa=0 sb=0 sd=0 mult=1 m=1
XMRD_c1_r100_0750_0_1 rbl_c1_r100_0750_0 sn_c1_r100_0750_0_1 rwl_des 0 sky130_fd_pr__nfet_01v8 L=0.15 W=0.42 nf=1 ad=0.1218 as=0.1218 pd=1.42 ps=1.42 nrd=0.69047619047619  nrs=0.69047619047619 sa=0 sb=0 sd=0 mult=1 m=1
csn_c1_r100_0750_0_1 sn_c1_r100_0750_0_1 0 {C_SN}
XMWR_c1_r100_0750_0_2 sn_c1_r100_0750_0_2 0 0 0 sky130_fd_pr__nfet_01v8 L=0.15 W=0.42 nf=1 ad=0.1218 as=0.1218 pd=1.42 ps=1.42 nrd=0.69047619047619  nrs=0.69047619047619 sa=0 sb=0 sd=0 mult=1 m=1
XMRD_c1_r100_0750_0_2 rbl_c1_r100_0750_0 sn_c1_r100_0750_0_2 rwl_des 0 sky130_fd_pr__nfet_01v8 L=0.15 W=0.42 nf=1 ad=0.1218 as=0.1218 pd=1.42 ps=1.42 nrd=0.69047619047619  nrs=0.69047619047619 sa=0 sb=0 sd=0 mult=1 m=1
csn_c1_r100_0750_0_2 sn_c1_r100_0750_0_2 0 {C_SN}
XMWR_c1_r100_0750_0_3 sn_c1_r100_0750_0_3 0 0 0 sky130_fd_pr__nfet_01v8 L=0.15 W=0.42 nf=1 ad=0.1218 as=0.1218 pd=1.42 ps=1.42 nrd=0.69047619047619  nrs=0.69047619047619 sa=0 sb=0 sd=0 mult=1 m=1
XMRD_c1_r100_0750_0_3 rbl_c1_r100_0750_0 sn_c1_r100_0750_0_3 rwl_des 0 sky130_fd_pr__nfet_01v8 L=0.15 W=0.42 nf=1 ad=0.1218 as=0.1218 pd=1.42 ps=1.42 nrd=0.69047619047619  nrs=0.69047619047619 sa=0 sb=0 sd=0 mult=1 m=1
csn_c1_r100_0750_0_3 sn_c1_r100_0750_0_3 0 {C_SN}
crbl_c1_r100_0750_0 rbl_c1_r100_0750_0 0 {C_RBL}
spr_c1_r100_0750_0 pref_100 ref_c1_r100_0750_0 ctl 0 swpre
cref_c1_r100_0750_0 ref_c1_r100_0750_0 0 {C_RBL}   $ ASSUMPTION: ideal matched dummy load
XMN1_c1_r100_0750_0 rbl_c1_r100_0750_0 ref_c1_r100_0750_0 vn_c1_r100_0750_0 0 sky130_fd_pr__nfet_01v8 L=0.15 W=1 nf=1 ad=0.29 as=0.29 pd=2.58 ps=2.58 nrd=0.29 nrs=0.29 sa=0 sb=0 sd=0 mult=1 m=1
XMN2_c1_r100_0750_0 ref_c1_r100_0750_0 rbl_c1_r100_0750_0 vn_c1_r100_0750_0 0 sky130_fd_pr__nfet_01v8 L=0.15 W=1 nf=1 ad=0.29 as=0.29 pd=2.58 ps=2.58 nrd=0.29 nrs=0.29 sa=0 sb=0 sd=0 mult=1 m=1
XMP1_c1_r100_0750_0 rbl_c1_r100_0750_0 ref_c1_r100_0750_0 vp_c1_r100_0750_0 vdd sky130_fd_pr__pfet_01v8 L=0.15 W=2 nf=1 ad=0.58 as=0.58 pd=4.58 ps=4.58 nrd=0.145 nrs=0.145 sa=0 sb=0 sd=0 mult=1 m=1
XMP2_c1_r100_0750_0 ref_c1_r100_0750_0 rbl_c1_r100_0750_0 vp_c1_r100_0750_0 vdd sky130_fd_pr__pfet_01v8 L=0.15 W=2 nf=1 ad=0.58 as=0.58 pd=4.58 ps=4.58 nrd=0.145 nrs=0.145 sa=0 sb=0 sd=0 mult=1 m=1
XMNF_c1_r100_0750_0 vn_c1_r100_0750_0 en 0 0 sky130_fd_pr__nfet_01v8 L=0.15 W=2 nf=1 ad=0.58 as=0.58 pd=4.58 ps=4.58 nrd=0.145 nrs=0.145 sa=0 sb=0 sd=0 mult=1 m=1
XMPH_c1_r100_0750_0 vp_c1_r100_0750_0 enb vdd vdd sky130_fd_pr__pfet_01v8 L=0.15 W=4 nf=1 ad=1.16 as=1.16 pd=8.58 ps=8.58 nrd=0.0725 nrs=0.0725 sa=0 sb=0 sd=0 mult=1 m=1
bd_c1_r100_0750_0 d_c1_r100_0750_0 0 v=v(rbl_c1_r100_0750_0)-v(ref_c1_r100_0750_0)
bdabs_c1_r100_0750_0 dabs_c1_r100_0750_0 0 v=abs(v(rbl_c1_r100_0750_0)-v(ref_c1_r100_0750_0))

* ---- c1_r100_0750_1: cell1 SN = 0.75 V, ref offset 0.1 V, replica 1 ----
spa_c1_r100_0750_1 prea rbl_c1_r100_0750_1 ctl 0 swpre
XMWR_c1_r100_0750_1_0 sn_c1_r100_0750_1_0 0 0 0 sky130_fd_pr__nfet_01v8 L=0.15 W=0.42 nf=1 ad=0.1218 as=0.1218 pd=1.42 ps=1.42 nrd=0.69047619047619  nrs=0.69047619047619 sa=0 sb=0 sd=0 mult=1 m=1
XMRD_c1_r100_0750_1_0 rbl_c1_r100_0750_1 sn_c1_r100_0750_1_0 rwl_sel 0 sky130_fd_pr__nfet_01v8 L=0.15 W=0.42 nf=1 ad=0.1218 as=0.1218 pd=1.42 ps=1.42 nrd=0.69047619047619  nrs=0.69047619047619 sa=0 sb=0 sd=0 mult=1 m=1
csn_c1_r100_0750_1_0 sn_c1_r100_0750_1_0 0 {C_SN}
XMWR_c1_r100_0750_1_1 sn_c1_r100_0750_1_1 0 0 0 sky130_fd_pr__nfet_01v8 L=0.15 W=0.42 nf=1 ad=0.1218 as=0.1218 pd=1.42 ps=1.42 nrd=0.69047619047619  nrs=0.69047619047619 sa=0 sb=0 sd=0 mult=1 m=1
XMRD_c1_r100_0750_1_1 rbl_c1_r100_0750_1 sn_c1_r100_0750_1_1 rwl_des 0 sky130_fd_pr__nfet_01v8 L=0.15 W=0.42 nf=1 ad=0.1218 as=0.1218 pd=1.42 ps=1.42 nrd=0.69047619047619  nrs=0.69047619047619 sa=0 sb=0 sd=0 mult=1 m=1
csn_c1_r100_0750_1_1 sn_c1_r100_0750_1_1 0 {C_SN}
XMWR_c1_r100_0750_1_2 sn_c1_r100_0750_1_2 0 0 0 sky130_fd_pr__nfet_01v8 L=0.15 W=0.42 nf=1 ad=0.1218 as=0.1218 pd=1.42 ps=1.42 nrd=0.69047619047619  nrs=0.69047619047619 sa=0 sb=0 sd=0 mult=1 m=1
XMRD_c1_r100_0750_1_2 rbl_c1_r100_0750_1 sn_c1_r100_0750_1_2 rwl_des 0 sky130_fd_pr__nfet_01v8 L=0.15 W=0.42 nf=1 ad=0.1218 as=0.1218 pd=1.42 ps=1.42 nrd=0.69047619047619  nrs=0.69047619047619 sa=0 sb=0 sd=0 mult=1 m=1
csn_c1_r100_0750_1_2 sn_c1_r100_0750_1_2 0 {C_SN}
XMWR_c1_r100_0750_1_3 sn_c1_r100_0750_1_3 0 0 0 sky130_fd_pr__nfet_01v8 L=0.15 W=0.42 nf=1 ad=0.1218 as=0.1218 pd=1.42 ps=1.42 nrd=0.69047619047619  nrs=0.69047619047619 sa=0 sb=0 sd=0 mult=1 m=1
XMRD_c1_r100_0750_1_3 rbl_c1_r100_0750_1 sn_c1_r100_0750_1_3 rwl_des 0 sky130_fd_pr__nfet_01v8 L=0.15 W=0.42 nf=1 ad=0.1218 as=0.1218 pd=1.42 ps=1.42 nrd=0.69047619047619  nrs=0.69047619047619 sa=0 sb=0 sd=0 mult=1 m=1
csn_c1_r100_0750_1_3 sn_c1_r100_0750_1_3 0 {C_SN}
crbl_c1_r100_0750_1 rbl_c1_r100_0750_1 0 {C_RBL}
spr_c1_r100_0750_1 pref_100 ref_c1_r100_0750_1 ctl 0 swpre
cref_c1_r100_0750_1 ref_c1_r100_0750_1 0 {C_RBL}   $ ASSUMPTION: ideal matched dummy load
XMN1_c1_r100_0750_1 rbl_c1_r100_0750_1 ref_c1_r100_0750_1 vn_c1_r100_0750_1 0 sky130_fd_pr__nfet_01v8 L=0.15 W=1 nf=1 ad=0.29 as=0.29 pd=2.58 ps=2.58 nrd=0.29 nrs=0.29 sa=0 sb=0 sd=0 mult=1 m=1
XMN2_c1_r100_0750_1 ref_c1_r100_0750_1 rbl_c1_r100_0750_1 vn_c1_r100_0750_1 0 sky130_fd_pr__nfet_01v8 L=0.15 W=1 nf=1 ad=0.29 as=0.29 pd=2.58 ps=2.58 nrd=0.29 nrs=0.29 sa=0 sb=0 sd=0 mult=1 m=1
XMP1_c1_r100_0750_1 rbl_c1_r100_0750_1 ref_c1_r100_0750_1 vp_c1_r100_0750_1 vdd sky130_fd_pr__pfet_01v8 L=0.15 W=2 nf=1 ad=0.58 as=0.58 pd=4.58 ps=4.58 nrd=0.145 nrs=0.145 sa=0 sb=0 sd=0 mult=1 m=1
XMP2_c1_r100_0750_1 ref_c1_r100_0750_1 rbl_c1_r100_0750_1 vp_c1_r100_0750_1 vdd sky130_fd_pr__pfet_01v8 L=0.15 W=2 nf=1 ad=0.58 as=0.58 pd=4.58 ps=4.58 nrd=0.145 nrs=0.145 sa=0 sb=0 sd=0 mult=1 m=1
XMNF_c1_r100_0750_1 vn_c1_r100_0750_1 en 0 0 sky130_fd_pr__nfet_01v8 L=0.15 W=2 nf=1 ad=0.58 as=0.58 pd=4.58 ps=4.58 nrd=0.145 nrs=0.145 sa=0 sb=0 sd=0 mult=1 m=1
XMPH_c1_r100_0750_1 vp_c1_r100_0750_1 enb vdd vdd sky130_fd_pr__pfet_01v8 L=0.15 W=4 nf=1 ad=1.16 as=1.16 pd=8.58 ps=8.58 nrd=0.0725 nrs=0.0725 sa=0 sb=0 sd=0 mult=1 m=1
bd_c1_r100_0750_1 d_c1_r100_0750_1 0 v=v(rbl_c1_r100_0750_1)-v(ref_c1_r100_0750_1)
bdabs_c1_r100_0750_1 dabs_c1_r100_0750_1 0 v=abs(v(rbl_c1_r100_0750_1)-v(ref_c1_r100_0750_1))

* ---- c1_r100_0750_2: cell1 SN = 0.75 V, ref offset 0.1 V, replica 2 ----
spa_c1_r100_0750_2 prea rbl_c1_r100_0750_2 ctl 0 swpre
XMWR_c1_r100_0750_2_0 sn_c1_r100_0750_2_0 0 0 0 sky130_fd_pr__nfet_01v8 L=0.15 W=0.42 nf=1 ad=0.1218 as=0.1218 pd=1.42 ps=1.42 nrd=0.69047619047619  nrs=0.69047619047619 sa=0 sb=0 sd=0 mult=1 m=1
XMRD_c1_r100_0750_2_0 rbl_c1_r100_0750_2 sn_c1_r100_0750_2_0 rwl_sel 0 sky130_fd_pr__nfet_01v8 L=0.15 W=0.42 nf=1 ad=0.1218 as=0.1218 pd=1.42 ps=1.42 nrd=0.69047619047619  nrs=0.69047619047619 sa=0 sb=0 sd=0 mult=1 m=1
csn_c1_r100_0750_2_0 sn_c1_r100_0750_2_0 0 {C_SN}
XMWR_c1_r100_0750_2_1 sn_c1_r100_0750_2_1 0 0 0 sky130_fd_pr__nfet_01v8 L=0.15 W=0.42 nf=1 ad=0.1218 as=0.1218 pd=1.42 ps=1.42 nrd=0.69047619047619  nrs=0.69047619047619 sa=0 sb=0 sd=0 mult=1 m=1
XMRD_c1_r100_0750_2_1 rbl_c1_r100_0750_2 sn_c1_r100_0750_2_1 rwl_des 0 sky130_fd_pr__nfet_01v8 L=0.15 W=0.42 nf=1 ad=0.1218 as=0.1218 pd=1.42 ps=1.42 nrd=0.69047619047619  nrs=0.69047619047619 sa=0 sb=0 sd=0 mult=1 m=1
csn_c1_r100_0750_2_1 sn_c1_r100_0750_2_1 0 {C_SN}
XMWR_c1_r100_0750_2_2 sn_c1_r100_0750_2_2 0 0 0 sky130_fd_pr__nfet_01v8 L=0.15 W=0.42 nf=1 ad=0.1218 as=0.1218 pd=1.42 ps=1.42 nrd=0.69047619047619  nrs=0.69047619047619 sa=0 sb=0 sd=0 mult=1 m=1
XMRD_c1_r100_0750_2_2 rbl_c1_r100_0750_2 sn_c1_r100_0750_2_2 rwl_des 0 sky130_fd_pr__nfet_01v8 L=0.15 W=0.42 nf=1 ad=0.1218 as=0.1218 pd=1.42 ps=1.42 nrd=0.69047619047619  nrs=0.69047619047619 sa=0 sb=0 sd=0 mult=1 m=1
csn_c1_r100_0750_2_2 sn_c1_r100_0750_2_2 0 {C_SN}
XMWR_c1_r100_0750_2_3 sn_c1_r100_0750_2_3 0 0 0 sky130_fd_pr__nfet_01v8 L=0.15 W=0.42 nf=1 ad=0.1218 as=0.1218 pd=1.42 ps=1.42 nrd=0.69047619047619  nrs=0.69047619047619 sa=0 sb=0 sd=0 mult=1 m=1
XMRD_c1_r100_0750_2_3 rbl_c1_r100_0750_2 sn_c1_r100_0750_2_3 rwl_des 0 sky130_fd_pr__nfet_01v8 L=0.15 W=0.42 nf=1 ad=0.1218 as=0.1218 pd=1.42 ps=1.42 nrd=0.69047619047619  nrs=0.69047619047619 sa=0 sb=0 sd=0 mult=1 m=1
csn_c1_r100_0750_2_3 sn_c1_r100_0750_2_3 0 {C_SN}
crbl_c1_r100_0750_2 rbl_c1_r100_0750_2 0 {C_RBL}
spr_c1_r100_0750_2 pref_100 ref_c1_r100_0750_2 ctl 0 swpre
cref_c1_r100_0750_2 ref_c1_r100_0750_2 0 {C_RBL}   $ ASSUMPTION: ideal matched dummy load
XMN1_c1_r100_0750_2 rbl_c1_r100_0750_2 ref_c1_r100_0750_2 vn_c1_r100_0750_2 0 sky130_fd_pr__nfet_01v8 L=0.15 W=1 nf=1 ad=0.29 as=0.29 pd=2.58 ps=2.58 nrd=0.29 nrs=0.29 sa=0 sb=0 sd=0 mult=1 m=1
XMN2_c1_r100_0750_2 ref_c1_r100_0750_2 rbl_c1_r100_0750_2 vn_c1_r100_0750_2 0 sky130_fd_pr__nfet_01v8 L=0.15 W=1 nf=1 ad=0.29 as=0.29 pd=2.58 ps=2.58 nrd=0.29 nrs=0.29 sa=0 sb=0 sd=0 mult=1 m=1
XMP1_c1_r100_0750_2 rbl_c1_r100_0750_2 ref_c1_r100_0750_2 vp_c1_r100_0750_2 vdd sky130_fd_pr__pfet_01v8 L=0.15 W=2 nf=1 ad=0.58 as=0.58 pd=4.58 ps=4.58 nrd=0.145 nrs=0.145 sa=0 sb=0 sd=0 mult=1 m=1
XMP2_c1_r100_0750_2 ref_c1_r100_0750_2 rbl_c1_r100_0750_2 vp_c1_r100_0750_2 vdd sky130_fd_pr__pfet_01v8 L=0.15 W=2 nf=1 ad=0.58 as=0.58 pd=4.58 ps=4.58 nrd=0.145 nrs=0.145 sa=0 sb=0 sd=0 mult=1 m=1
XMNF_c1_r100_0750_2 vn_c1_r100_0750_2 en 0 0 sky130_fd_pr__nfet_01v8 L=0.15 W=2 nf=1 ad=0.58 as=0.58 pd=4.58 ps=4.58 nrd=0.145 nrs=0.145 sa=0 sb=0 sd=0 mult=1 m=1
XMPH_c1_r100_0750_2 vp_c1_r100_0750_2 enb vdd vdd sky130_fd_pr__pfet_01v8 L=0.15 W=4 nf=1 ad=1.16 as=1.16 pd=8.58 ps=8.58 nrd=0.0725 nrs=0.0725 sa=0 sb=0 sd=0 mult=1 m=1
bd_c1_r100_0750_2 d_c1_r100_0750_2 0 v=v(rbl_c1_r100_0750_2)-v(ref_c1_r100_0750_2)
bdabs_c1_r100_0750_2 dabs_c1_r100_0750_2 0 v=abs(v(rbl_c1_r100_0750_2)-v(ref_c1_r100_0750_2))

* ---- c1_r100_0750_3: cell1 SN = 0.75 V, ref offset 0.1 V, replica 3 ----
spa_c1_r100_0750_3 prea rbl_c1_r100_0750_3 ctl 0 swpre
XMWR_c1_r100_0750_3_0 sn_c1_r100_0750_3_0 0 0 0 sky130_fd_pr__nfet_01v8 L=0.15 W=0.42 nf=1 ad=0.1218 as=0.1218 pd=1.42 ps=1.42 nrd=0.69047619047619  nrs=0.69047619047619 sa=0 sb=0 sd=0 mult=1 m=1
XMRD_c1_r100_0750_3_0 rbl_c1_r100_0750_3 sn_c1_r100_0750_3_0 rwl_sel 0 sky130_fd_pr__nfet_01v8 L=0.15 W=0.42 nf=1 ad=0.1218 as=0.1218 pd=1.42 ps=1.42 nrd=0.69047619047619  nrs=0.69047619047619 sa=0 sb=0 sd=0 mult=1 m=1
csn_c1_r100_0750_3_0 sn_c1_r100_0750_3_0 0 {C_SN}
XMWR_c1_r100_0750_3_1 sn_c1_r100_0750_3_1 0 0 0 sky130_fd_pr__nfet_01v8 L=0.15 W=0.42 nf=1 ad=0.1218 as=0.1218 pd=1.42 ps=1.42 nrd=0.69047619047619  nrs=0.69047619047619 sa=0 sb=0 sd=0 mult=1 m=1
XMRD_c1_r100_0750_3_1 rbl_c1_r100_0750_3 sn_c1_r100_0750_3_1 rwl_des 0 sky130_fd_pr__nfet_01v8 L=0.15 W=0.42 nf=1 ad=0.1218 as=0.1218 pd=1.42 ps=1.42 nrd=0.69047619047619  nrs=0.69047619047619 sa=0 sb=0 sd=0 mult=1 m=1
csn_c1_r100_0750_3_1 sn_c1_r100_0750_3_1 0 {C_SN}
XMWR_c1_r100_0750_3_2 sn_c1_r100_0750_3_2 0 0 0 sky130_fd_pr__nfet_01v8 L=0.15 W=0.42 nf=1 ad=0.1218 as=0.1218 pd=1.42 ps=1.42 nrd=0.69047619047619  nrs=0.69047619047619 sa=0 sb=0 sd=0 mult=1 m=1
XMRD_c1_r100_0750_3_2 rbl_c1_r100_0750_3 sn_c1_r100_0750_3_2 rwl_des 0 sky130_fd_pr__nfet_01v8 L=0.15 W=0.42 nf=1 ad=0.1218 as=0.1218 pd=1.42 ps=1.42 nrd=0.69047619047619  nrs=0.69047619047619 sa=0 sb=0 sd=0 mult=1 m=1
csn_c1_r100_0750_3_2 sn_c1_r100_0750_3_2 0 {C_SN}
XMWR_c1_r100_0750_3_3 sn_c1_r100_0750_3_3 0 0 0 sky130_fd_pr__nfet_01v8 L=0.15 W=0.42 nf=1 ad=0.1218 as=0.1218 pd=1.42 ps=1.42 nrd=0.69047619047619  nrs=0.69047619047619 sa=0 sb=0 sd=0 mult=1 m=1
XMRD_c1_r100_0750_3_3 rbl_c1_r100_0750_3 sn_c1_r100_0750_3_3 rwl_des 0 sky130_fd_pr__nfet_01v8 L=0.15 W=0.42 nf=1 ad=0.1218 as=0.1218 pd=1.42 ps=1.42 nrd=0.69047619047619  nrs=0.69047619047619 sa=0 sb=0 sd=0 mult=1 m=1
csn_c1_r100_0750_3_3 sn_c1_r100_0750_3_3 0 {C_SN}
crbl_c1_r100_0750_3 rbl_c1_r100_0750_3 0 {C_RBL}
spr_c1_r100_0750_3 pref_100 ref_c1_r100_0750_3 ctl 0 swpre
cref_c1_r100_0750_3 ref_c1_r100_0750_3 0 {C_RBL}   $ ASSUMPTION: ideal matched dummy load
XMN1_c1_r100_0750_3 rbl_c1_r100_0750_3 ref_c1_r100_0750_3 vn_c1_r100_0750_3 0 sky130_fd_pr__nfet_01v8 L=0.15 W=1 nf=1 ad=0.29 as=0.29 pd=2.58 ps=2.58 nrd=0.29 nrs=0.29 sa=0 sb=0 sd=0 mult=1 m=1
XMN2_c1_r100_0750_3 ref_c1_r100_0750_3 rbl_c1_r100_0750_3 vn_c1_r100_0750_3 0 sky130_fd_pr__nfet_01v8 L=0.15 W=1 nf=1 ad=0.29 as=0.29 pd=2.58 ps=2.58 nrd=0.29 nrs=0.29 sa=0 sb=0 sd=0 mult=1 m=1
XMP1_c1_r100_0750_3 rbl_c1_r100_0750_3 ref_c1_r100_0750_3 vp_c1_r100_0750_3 vdd sky130_fd_pr__pfet_01v8 L=0.15 W=2 nf=1 ad=0.58 as=0.58 pd=4.58 ps=4.58 nrd=0.145 nrs=0.145 sa=0 sb=0 sd=0 mult=1 m=1
XMP2_c1_r100_0750_3 ref_c1_r100_0750_3 rbl_c1_r100_0750_3 vp_c1_r100_0750_3 vdd sky130_fd_pr__pfet_01v8 L=0.15 W=2 nf=1 ad=0.58 as=0.58 pd=4.58 ps=4.58 nrd=0.145 nrs=0.145 sa=0 sb=0 sd=0 mult=1 m=1
XMNF_c1_r100_0750_3 vn_c1_r100_0750_3 en 0 0 sky130_fd_pr__nfet_01v8 L=0.15 W=2 nf=1 ad=0.58 as=0.58 pd=4.58 ps=4.58 nrd=0.145 nrs=0.145 sa=0 sb=0 sd=0 mult=1 m=1
XMPH_c1_r100_0750_3 vp_c1_r100_0750_3 enb vdd vdd sky130_fd_pr__pfet_01v8 L=0.15 W=4 nf=1 ad=1.16 as=1.16 pd=8.58 ps=8.58 nrd=0.0725 nrs=0.0725 sa=0 sb=0 sd=0 mult=1 m=1
bd_c1_r100_0750_3 d_c1_r100_0750_3 0 v=v(rbl_c1_r100_0750_3)-v(ref_c1_r100_0750_3)
bdabs_c1_r100_0750_3 dabs_c1_r100_0750_3 0 v=abs(v(rbl_c1_r100_0750_3)-v(ref_c1_r100_0750_3))

* ---- c1_r100_0800_0: cell1 SN = 0.8 V, ref offset 0.1 V, replica 0 ----
spa_c1_r100_0800_0 prea rbl_c1_r100_0800_0 ctl 0 swpre
XMWR_c1_r100_0800_0_0 sn_c1_r100_0800_0_0 0 0 0 sky130_fd_pr__nfet_01v8 L=0.15 W=0.42 nf=1 ad=0.1218 as=0.1218 pd=1.42 ps=1.42 nrd=0.69047619047619  nrs=0.69047619047619 sa=0 sb=0 sd=0 mult=1 m=1
XMRD_c1_r100_0800_0_0 rbl_c1_r100_0800_0 sn_c1_r100_0800_0_0 rwl_sel 0 sky130_fd_pr__nfet_01v8 L=0.15 W=0.42 nf=1 ad=0.1218 as=0.1218 pd=1.42 ps=1.42 nrd=0.69047619047619  nrs=0.69047619047619 sa=0 sb=0 sd=0 mult=1 m=1
csn_c1_r100_0800_0_0 sn_c1_r100_0800_0_0 0 {C_SN}
XMWR_c1_r100_0800_0_1 sn_c1_r100_0800_0_1 0 0 0 sky130_fd_pr__nfet_01v8 L=0.15 W=0.42 nf=1 ad=0.1218 as=0.1218 pd=1.42 ps=1.42 nrd=0.69047619047619  nrs=0.69047619047619 sa=0 sb=0 sd=0 mult=1 m=1
XMRD_c1_r100_0800_0_1 rbl_c1_r100_0800_0 sn_c1_r100_0800_0_1 rwl_des 0 sky130_fd_pr__nfet_01v8 L=0.15 W=0.42 nf=1 ad=0.1218 as=0.1218 pd=1.42 ps=1.42 nrd=0.69047619047619  nrs=0.69047619047619 sa=0 sb=0 sd=0 mult=1 m=1
csn_c1_r100_0800_0_1 sn_c1_r100_0800_0_1 0 {C_SN}
XMWR_c1_r100_0800_0_2 sn_c1_r100_0800_0_2 0 0 0 sky130_fd_pr__nfet_01v8 L=0.15 W=0.42 nf=1 ad=0.1218 as=0.1218 pd=1.42 ps=1.42 nrd=0.69047619047619  nrs=0.69047619047619 sa=0 sb=0 sd=0 mult=1 m=1
XMRD_c1_r100_0800_0_2 rbl_c1_r100_0800_0 sn_c1_r100_0800_0_2 rwl_des 0 sky130_fd_pr__nfet_01v8 L=0.15 W=0.42 nf=1 ad=0.1218 as=0.1218 pd=1.42 ps=1.42 nrd=0.69047619047619  nrs=0.69047619047619 sa=0 sb=0 sd=0 mult=1 m=1
csn_c1_r100_0800_0_2 sn_c1_r100_0800_0_2 0 {C_SN}
XMWR_c1_r100_0800_0_3 sn_c1_r100_0800_0_3 0 0 0 sky130_fd_pr__nfet_01v8 L=0.15 W=0.42 nf=1 ad=0.1218 as=0.1218 pd=1.42 ps=1.42 nrd=0.69047619047619  nrs=0.69047619047619 sa=0 sb=0 sd=0 mult=1 m=1
XMRD_c1_r100_0800_0_3 rbl_c1_r100_0800_0 sn_c1_r100_0800_0_3 rwl_des 0 sky130_fd_pr__nfet_01v8 L=0.15 W=0.42 nf=1 ad=0.1218 as=0.1218 pd=1.42 ps=1.42 nrd=0.69047619047619  nrs=0.69047619047619 sa=0 sb=0 sd=0 mult=1 m=1
csn_c1_r100_0800_0_3 sn_c1_r100_0800_0_3 0 {C_SN}
crbl_c1_r100_0800_0 rbl_c1_r100_0800_0 0 {C_RBL}
spr_c1_r100_0800_0 pref_100 ref_c1_r100_0800_0 ctl 0 swpre
cref_c1_r100_0800_0 ref_c1_r100_0800_0 0 {C_RBL}   $ ASSUMPTION: ideal matched dummy load
XMN1_c1_r100_0800_0 rbl_c1_r100_0800_0 ref_c1_r100_0800_0 vn_c1_r100_0800_0 0 sky130_fd_pr__nfet_01v8 L=0.15 W=1 nf=1 ad=0.29 as=0.29 pd=2.58 ps=2.58 nrd=0.29 nrs=0.29 sa=0 sb=0 sd=0 mult=1 m=1
XMN2_c1_r100_0800_0 ref_c1_r100_0800_0 rbl_c1_r100_0800_0 vn_c1_r100_0800_0 0 sky130_fd_pr__nfet_01v8 L=0.15 W=1 nf=1 ad=0.29 as=0.29 pd=2.58 ps=2.58 nrd=0.29 nrs=0.29 sa=0 sb=0 sd=0 mult=1 m=1
XMP1_c1_r100_0800_0 rbl_c1_r100_0800_0 ref_c1_r100_0800_0 vp_c1_r100_0800_0 vdd sky130_fd_pr__pfet_01v8 L=0.15 W=2 nf=1 ad=0.58 as=0.58 pd=4.58 ps=4.58 nrd=0.145 nrs=0.145 sa=0 sb=0 sd=0 mult=1 m=1
XMP2_c1_r100_0800_0 ref_c1_r100_0800_0 rbl_c1_r100_0800_0 vp_c1_r100_0800_0 vdd sky130_fd_pr__pfet_01v8 L=0.15 W=2 nf=1 ad=0.58 as=0.58 pd=4.58 ps=4.58 nrd=0.145 nrs=0.145 sa=0 sb=0 sd=0 mult=1 m=1
XMNF_c1_r100_0800_0 vn_c1_r100_0800_0 en 0 0 sky130_fd_pr__nfet_01v8 L=0.15 W=2 nf=1 ad=0.58 as=0.58 pd=4.58 ps=4.58 nrd=0.145 nrs=0.145 sa=0 sb=0 sd=0 mult=1 m=1
XMPH_c1_r100_0800_0 vp_c1_r100_0800_0 enb vdd vdd sky130_fd_pr__pfet_01v8 L=0.15 W=4 nf=1 ad=1.16 as=1.16 pd=8.58 ps=8.58 nrd=0.0725 nrs=0.0725 sa=0 sb=0 sd=0 mult=1 m=1
bd_c1_r100_0800_0 d_c1_r100_0800_0 0 v=v(rbl_c1_r100_0800_0)-v(ref_c1_r100_0800_0)
bdabs_c1_r100_0800_0 dabs_c1_r100_0800_0 0 v=abs(v(rbl_c1_r100_0800_0)-v(ref_c1_r100_0800_0))

* ---- c1_r100_0800_1: cell1 SN = 0.8 V, ref offset 0.1 V, replica 1 ----
spa_c1_r100_0800_1 prea rbl_c1_r100_0800_1 ctl 0 swpre
XMWR_c1_r100_0800_1_0 sn_c1_r100_0800_1_0 0 0 0 sky130_fd_pr__nfet_01v8 L=0.15 W=0.42 nf=1 ad=0.1218 as=0.1218 pd=1.42 ps=1.42 nrd=0.69047619047619  nrs=0.69047619047619 sa=0 sb=0 sd=0 mult=1 m=1
XMRD_c1_r100_0800_1_0 rbl_c1_r100_0800_1 sn_c1_r100_0800_1_0 rwl_sel 0 sky130_fd_pr__nfet_01v8 L=0.15 W=0.42 nf=1 ad=0.1218 as=0.1218 pd=1.42 ps=1.42 nrd=0.69047619047619  nrs=0.69047619047619 sa=0 sb=0 sd=0 mult=1 m=1
csn_c1_r100_0800_1_0 sn_c1_r100_0800_1_0 0 {C_SN}
XMWR_c1_r100_0800_1_1 sn_c1_r100_0800_1_1 0 0 0 sky130_fd_pr__nfet_01v8 L=0.15 W=0.42 nf=1 ad=0.1218 as=0.1218 pd=1.42 ps=1.42 nrd=0.69047619047619  nrs=0.69047619047619 sa=0 sb=0 sd=0 mult=1 m=1
XMRD_c1_r100_0800_1_1 rbl_c1_r100_0800_1 sn_c1_r100_0800_1_1 rwl_des 0 sky130_fd_pr__nfet_01v8 L=0.15 W=0.42 nf=1 ad=0.1218 as=0.1218 pd=1.42 ps=1.42 nrd=0.69047619047619  nrs=0.69047619047619 sa=0 sb=0 sd=0 mult=1 m=1
csn_c1_r100_0800_1_1 sn_c1_r100_0800_1_1 0 {C_SN}
XMWR_c1_r100_0800_1_2 sn_c1_r100_0800_1_2 0 0 0 sky130_fd_pr__nfet_01v8 L=0.15 W=0.42 nf=1 ad=0.1218 as=0.1218 pd=1.42 ps=1.42 nrd=0.69047619047619  nrs=0.69047619047619 sa=0 sb=0 sd=0 mult=1 m=1
XMRD_c1_r100_0800_1_2 rbl_c1_r100_0800_1 sn_c1_r100_0800_1_2 rwl_des 0 sky130_fd_pr__nfet_01v8 L=0.15 W=0.42 nf=1 ad=0.1218 as=0.1218 pd=1.42 ps=1.42 nrd=0.69047619047619  nrs=0.69047619047619 sa=0 sb=0 sd=0 mult=1 m=1
csn_c1_r100_0800_1_2 sn_c1_r100_0800_1_2 0 {C_SN}
XMWR_c1_r100_0800_1_3 sn_c1_r100_0800_1_3 0 0 0 sky130_fd_pr__nfet_01v8 L=0.15 W=0.42 nf=1 ad=0.1218 as=0.1218 pd=1.42 ps=1.42 nrd=0.69047619047619  nrs=0.69047619047619 sa=0 sb=0 sd=0 mult=1 m=1
XMRD_c1_r100_0800_1_3 rbl_c1_r100_0800_1 sn_c1_r100_0800_1_3 rwl_des 0 sky130_fd_pr__nfet_01v8 L=0.15 W=0.42 nf=1 ad=0.1218 as=0.1218 pd=1.42 ps=1.42 nrd=0.69047619047619  nrs=0.69047619047619 sa=0 sb=0 sd=0 mult=1 m=1
csn_c1_r100_0800_1_3 sn_c1_r100_0800_1_3 0 {C_SN}
crbl_c1_r100_0800_1 rbl_c1_r100_0800_1 0 {C_RBL}
spr_c1_r100_0800_1 pref_100 ref_c1_r100_0800_1 ctl 0 swpre
cref_c1_r100_0800_1 ref_c1_r100_0800_1 0 {C_RBL}   $ ASSUMPTION: ideal matched dummy load
XMN1_c1_r100_0800_1 rbl_c1_r100_0800_1 ref_c1_r100_0800_1 vn_c1_r100_0800_1 0 sky130_fd_pr__nfet_01v8 L=0.15 W=1 nf=1 ad=0.29 as=0.29 pd=2.58 ps=2.58 nrd=0.29 nrs=0.29 sa=0 sb=0 sd=0 mult=1 m=1
XMN2_c1_r100_0800_1 ref_c1_r100_0800_1 rbl_c1_r100_0800_1 vn_c1_r100_0800_1 0 sky130_fd_pr__nfet_01v8 L=0.15 W=1 nf=1 ad=0.29 as=0.29 pd=2.58 ps=2.58 nrd=0.29 nrs=0.29 sa=0 sb=0 sd=0 mult=1 m=1
XMP1_c1_r100_0800_1 rbl_c1_r100_0800_1 ref_c1_r100_0800_1 vp_c1_r100_0800_1 vdd sky130_fd_pr__pfet_01v8 L=0.15 W=2 nf=1 ad=0.58 as=0.58 pd=4.58 ps=4.58 nrd=0.145 nrs=0.145 sa=0 sb=0 sd=0 mult=1 m=1
XMP2_c1_r100_0800_1 ref_c1_r100_0800_1 rbl_c1_r100_0800_1 vp_c1_r100_0800_1 vdd sky130_fd_pr__pfet_01v8 L=0.15 W=2 nf=1 ad=0.58 as=0.58 pd=4.58 ps=4.58 nrd=0.145 nrs=0.145 sa=0 sb=0 sd=0 mult=1 m=1
XMNF_c1_r100_0800_1 vn_c1_r100_0800_1 en 0 0 sky130_fd_pr__nfet_01v8 L=0.15 W=2 nf=1 ad=0.58 as=0.58 pd=4.58 ps=4.58 nrd=0.145 nrs=0.145 sa=0 sb=0 sd=0 mult=1 m=1
XMPH_c1_r100_0800_1 vp_c1_r100_0800_1 enb vdd vdd sky130_fd_pr__pfet_01v8 L=0.15 W=4 nf=1 ad=1.16 as=1.16 pd=8.58 ps=8.58 nrd=0.0725 nrs=0.0725 sa=0 sb=0 sd=0 mult=1 m=1
bd_c1_r100_0800_1 d_c1_r100_0800_1 0 v=v(rbl_c1_r100_0800_1)-v(ref_c1_r100_0800_1)
bdabs_c1_r100_0800_1 dabs_c1_r100_0800_1 0 v=abs(v(rbl_c1_r100_0800_1)-v(ref_c1_r100_0800_1))

* ---- c1_r100_0800_2: cell1 SN = 0.8 V, ref offset 0.1 V, replica 2 ----
spa_c1_r100_0800_2 prea rbl_c1_r100_0800_2 ctl 0 swpre
XMWR_c1_r100_0800_2_0 sn_c1_r100_0800_2_0 0 0 0 sky130_fd_pr__nfet_01v8 L=0.15 W=0.42 nf=1 ad=0.1218 as=0.1218 pd=1.42 ps=1.42 nrd=0.69047619047619  nrs=0.69047619047619 sa=0 sb=0 sd=0 mult=1 m=1
XMRD_c1_r100_0800_2_0 rbl_c1_r100_0800_2 sn_c1_r100_0800_2_0 rwl_sel 0 sky130_fd_pr__nfet_01v8 L=0.15 W=0.42 nf=1 ad=0.1218 as=0.1218 pd=1.42 ps=1.42 nrd=0.69047619047619  nrs=0.69047619047619 sa=0 sb=0 sd=0 mult=1 m=1
csn_c1_r100_0800_2_0 sn_c1_r100_0800_2_0 0 {C_SN}
XMWR_c1_r100_0800_2_1 sn_c1_r100_0800_2_1 0 0 0 sky130_fd_pr__nfet_01v8 L=0.15 W=0.42 nf=1 ad=0.1218 as=0.1218 pd=1.42 ps=1.42 nrd=0.69047619047619  nrs=0.69047619047619 sa=0 sb=0 sd=0 mult=1 m=1
XMRD_c1_r100_0800_2_1 rbl_c1_r100_0800_2 sn_c1_r100_0800_2_1 rwl_des 0 sky130_fd_pr__nfet_01v8 L=0.15 W=0.42 nf=1 ad=0.1218 as=0.1218 pd=1.42 ps=1.42 nrd=0.69047619047619  nrs=0.69047619047619 sa=0 sb=0 sd=0 mult=1 m=1
csn_c1_r100_0800_2_1 sn_c1_r100_0800_2_1 0 {C_SN}
XMWR_c1_r100_0800_2_2 sn_c1_r100_0800_2_2 0 0 0 sky130_fd_pr__nfet_01v8 L=0.15 W=0.42 nf=1 ad=0.1218 as=0.1218 pd=1.42 ps=1.42 nrd=0.69047619047619  nrs=0.69047619047619 sa=0 sb=0 sd=0 mult=1 m=1
XMRD_c1_r100_0800_2_2 rbl_c1_r100_0800_2 sn_c1_r100_0800_2_2 rwl_des 0 sky130_fd_pr__nfet_01v8 L=0.15 W=0.42 nf=1 ad=0.1218 as=0.1218 pd=1.42 ps=1.42 nrd=0.69047619047619  nrs=0.69047619047619 sa=0 sb=0 sd=0 mult=1 m=1
csn_c1_r100_0800_2_2 sn_c1_r100_0800_2_2 0 {C_SN}
XMWR_c1_r100_0800_2_3 sn_c1_r100_0800_2_3 0 0 0 sky130_fd_pr__nfet_01v8 L=0.15 W=0.42 nf=1 ad=0.1218 as=0.1218 pd=1.42 ps=1.42 nrd=0.69047619047619  nrs=0.69047619047619 sa=0 sb=0 sd=0 mult=1 m=1
XMRD_c1_r100_0800_2_3 rbl_c1_r100_0800_2 sn_c1_r100_0800_2_3 rwl_des 0 sky130_fd_pr__nfet_01v8 L=0.15 W=0.42 nf=1 ad=0.1218 as=0.1218 pd=1.42 ps=1.42 nrd=0.69047619047619  nrs=0.69047619047619 sa=0 sb=0 sd=0 mult=1 m=1
csn_c1_r100_0800_2_3 sn_c1_r100_0800_2_3 0 {C_SN}
crbl_c1_r100_0800_2 rbl_c1_r100_0800_2 0 {C_RBL}
spr_c1_r100_0800_2 pref_100 ref_c1_r100_0800_2 ctl 0 swpre
cref_c1_r100_0800_2 ref_c1_r100_0800_2 0 {C_RBL}   $ ASSUMPTION: ideal matched dummy load
XMN1_c1_r100_0800_2 rbl_c1_r100_0800_2 ref_c1_r100_0800_2 vn_c1_r100_0800_2 0 sky130_fd_pr__nfet_01v8 L=0.15 W=1 nf=1 ad=0.29 as=0.29 pd=2.58 ps=2.58 nrd=0.29 nrs=0.29 sa=0 sb=0 sd=0 mult=1 m=1
XMN2_c1_r100_0800_2 ref_c1_r100_0800_2 rbl_c1_r100_0800_2 vn_c1_r100_0800_2 0 sky130_fd_pr__nfet_01v8 L=0.15 W=1 nf=1 ad=0.29 as=0.29 pd=2.58 ps=2.58 nrd=0.29 nrs=0.29 sa=0 sb=0 sd=0 mult=1 m=1
XMP1_c1_r100_0800_2 rbl_c1_r100_0800_2 ref_c1_r100_0800_2 vp_c1_r100_0800_2 vdd sky130_fd_pr__pfet_01v8 L=0.15 W=2 nf=1 ad=0.58 as=0.58 pd=4.58 ps=4.58 nrd=0.145 nrs=0.145 sa=0 sb=0 sd=0 mult=1 m=1
XMP2_c1_r100_0800_2 ref_c1_r100_0800_2 rbl_c1_r100_0800_2 vp_c1_r100_0800_2 vdd sky130_fd_pr__pfet_01v8 L=0.15 W=2 nf=1 ad=0.58 as=0.58 pd=4.58 ps=4.58 nrd=0.145 nrs=0.145 sa=0 sb=0 sd=0 mult=1 m=1
XMNF_c1_r100_0800_2 vn_c1_r100_0800_2 en 0 0 sky130_fd_pr__nfet_01v8 L=0.15 W=2 nf=1 ad=0.58 as=0.58 pd=4.58 ps=4.58 nrd=0.145 nrs=0.145 sa=0 sb=0 sd=0 mult=1 m=1
XMPH_c1_r100_0800_2 vp_c1_r100_0800_2 enb vdd vdd sky130_fd_pr__pfet_01v8 L=0.15 W=4 nf=1 ad=1.16 as=1.16 pd=8.58 ps=8.58 nrd=0.0725 nrs=0.0725 sa=0 sb=0 sd=0 mult=1 m=1
bd_c1_r100_0800_2 d_c1_r100_0800_2 0 v=v(rbl_c1_r100_0800_2)-v(ref_c1_r100_0800_2)
bdabs_c1_r100_0800_2 dabs_c1_r100_0800_2 0 v=abs(v(rbl_c1_r100_0800_2)-v(ref_c1_r100_0800_2))

* ---- c1_r100_0800_3: cell1 SN = 0.8 V, ref offset 0.1 V, replica 3 ----
spa_c1_r100_0800_3 prea rbl_c1_r100_0800_3 ctl 0 swpre
XMWR_c1_r100_0800_3_0 sn_c1_r100_0800_3_0 0 0 0 sky130_fd_pr__nfet_01v8 L=0.15 W=0.42 nf=1 ad=0.1218 as=0.1218 pd=1.42 ps=1.42 nrd=0.69047619047619  nrs=0.69047619047619 sa=0 sb=0 sd=0 mult=1 m=1
XMRD_c1_r100_0800_3_0 rbl_c1_r100_0800_3 sn_c1_r100_0800_3_0 rwl_sel 0 sky130_fd_pr__nfet_01v8 L=0.15 W=0.42 nf=1 ad=0.1218 as=0.1218 pd=1.42 ps=1.42 nrd=0.69047619047619  nrs=0.69047619047619 sa=0 sb=0 sd=0 mult=1 m=1
csn_c1_r100_0800_3_0 sn_c1_r100_0800_3_0 0 {C_SN}
XMWR_c1_r100_0800_3_1 sn_c1_r100_0800_3_1 0 0 0 sky130_fd_pr__nfet_01v8 L=0.15 W=0.42 nf=1 ad=0.1218 as=0.1218 pd=1.42 ps=1.42 nrd=0.69047619047619  nrs=0.69047619047619 sa=0 sb=0 sd=0 mult=1 m=1
XMRD_c1_r100_0800_3_1 rbl_c1_r100_0800_3 sn_c1_r100_0800_3_1 rwl_des 0 sky130_fd_pr__nfet_01v8 L=0.15 W=0.42 nf=1 ad=0.1218 as=0.1218 pd=1.42 ps=1.42 nrd=0.69047619047619  nrs=0.69047619047619 sa=0 sb=0 sd=0 mult=1 m=1
csn_c1_r100_0800_3_1 sn_c1_r100_0800_3_1 0 {C_SN}
XMWR_c1_r100_0800_3_2 sn_c1_r100_0800_3_2 0 0 0 sky130_fd_pr__nfet_01v8 L=0.15 W=0.42 nf=1 ad=0.1218 as=0.1218 pd=1.42 ps=1.42 nrd=0.69047619047619  nrs=0.69047619047619 sa=0 sb=0 sd=0 mult=1 m=1
XMRD_c1_r100_0800_3_2 rbl_c1_r100_0800_3 sn_c1_r100_0800_3_2 rwl_des 0 sky130_fd_pr__nfet_01v8 L=0.15 W=0.42 nf=1 ad=0.1218 as=0.1218 pd=1.42 ps=1.42 nrd=0.69047619047619  nrs=0.69047619047619 sa=0 sb=0 sd=0 mult=1 m=1
csn_c1_r100_0800_3_2 sn_c1_r100_0800_3_2 0 {C_SN}
XMWR_c1_r100_0800_3_3 sn_c1_r100_0800_3_3 0 0 0 sky130_fd_pr__nfet_01v8 L=0.15 W=0.42 nf=1 ad=0.1218 as=0.1218 pd=1.42 ps=1.42 nrd=0.69047619047619  nrs=0.69047619047619 sa=0 sb=0 sd=0 mult=1 m=1
XMRD_c1_r100_0800_3_3 rbl_c1_r100_0800_3 sn_c1_r100_0800_3_3 rwl_des 0 sky130_fd_pr__nfet_01v8 L=0.15 W=0.42 nf=1 ad=0.1218 as=0.1218 pd=1.42 ps=1.42 nrd=0.69047619047619  nrs=0.69047619047619 sa=0 sb=0 sd=0 mult=1 m=1
csn_c1_r100_0800_3_3 sn_c1_r100_0800_3_3 0 {C_SN}
crbl_c1_r100_0800_3 rbl_c1_r100_0800_3 0 {C_RBL}
spr_c1_r100_0800_3 pref_100 ref_c1_r100_0800_3 ctl 0 swpre
cref_c1_r100_0800_3 ref_c1_r100_0800_3 0 {C_RBL}   $ ASSUMPTION: ideal matched dummy load
XMN1_c1_r100_0800_3 rbl_c1_r100_0800_3 ref_c1_r100_0800_3 vn_c1_r100_0800_3 0 sky130_fd_pr__nfet_01v8 L=0.15 W=1 nf=1 ad=0.29 as=0.29 pd=2.58 ps=2.58 nrd=0.29 nrs=0.29 sa=0 sb=0 sd=0 mult=1 m=1
XMN2_c1_r100_0800_3 ref_c1_r100_0800_3 rbl_c1_r100_0800_3 vn_c1_r100_0800_3 0 sky130_fd_pr__nfet_01v8 L=0.15 W=1 nf=1 ad=0.29 as=0.29 pd=2.58 ps=2.58 nrd=0.29 nrs=0.29 sa=0 sb=0 sd=0 mult=1 m=1
XMP1_c1_r100_0800_3 rbl_c1_r100_0800_3 ref_c1_r100_0800_3 vp_c1_r100_0800_3 vdd sky130_fd_pr__pfet_01v8 L=0.15 W=2 nf=1 ad=0.58 as=0.58 pd=4.58 ps=4.58 nrd=0.145 nrs=0.145 sa=0 sb=0 sd=0 mult=1 m=1
XMP2_c1_r100_0800_3 ref_c1_r100_0800_3 rbl_c1_r100_0800_3 vp_c1_r100_0800_3 vdd sky130_fd_pr__pfet_01v8 L=0.15 W=2 nf=1 ad=0.58 as=0.58 pd=4.58 ps=4.58 nrd=0.145 nrs=0.145 sa=0 sb=0 sd=0 mult=1 m=1
XMNF_c1_r100_0800_3 vn_c1_r100_0800_3 en 0 0 sky130_fd_pr__nfet_01v8 L=0.15 W=2 nf=1 ad=0.58 as=0.58 pd=4.58 ps=4.58 nrd=0.145 nrs=0.145 sa=0 sb=0 sd=0 mult=1 m=1
XMPH_c1_r100_0800_3 vp_c1_r100_0800_3 enb vdd vdd sky130_fd_pr__pfet_01v8 L=0.15 W=4 nf=1 ad=1.16 as=1.16 pd=8.58 ps=8.58 nrd=0.0725 nrs=0.0725 sa=0 sb=0 sd=0 mult=1 m=1
bd_c1_r100_0800_3 d_c1_r100_0800_3 0 v=v(rbl_c1_r100_0800_3)-v(ref_c1_r100_0800_3)
bdabs_c1_r100_0800_3 dabs_c1_r100_0800_3 0 v=abs(v(rbl_c1_r100_0800_3)-v(ref_c1_r100_0800_3))

* ---- c1_r100_0850_0: cell1 SN = 0.85 V, ref offset 0.1 V, replica 0 ----
spa_c1_r100_0850_0 prea rbl_c1_r100_0850_0 ctl 0 swpre
XMWR_c1_r100_0850_0_0 sn_c1_r100_0850_0_0 0 0 0 sky130_fd_pr__nfet_01v8 L=0.15 W=0.42 nf=1 ad=0.1218 as=0.1218 pd=1.42 ps=1.42 nrd=0.69047619047619  nrs=0.69047619047619 sa=0 sb=0 sd=0 mult=1 m=1
XMRD_c1_r100_0850_0_0 rbl_c1_r100_0850_0 sn_c1_r100_0850_0_0 rwl_sel 0 sky130_fd_pr__nfet_01v8 L=0.15 W=0.42 nf=1 ad=0.1218 as=0.1218 pd=1.42 ps=1.42 nrd=0.69047619047619  nrs=0.69047619047619 sa=0 sb=0 sd=0 mult=1 m=1
csn_c1_r100_0850_0_0 sn_c1_r100_0850_0_0 0 {C_SN}
XMWR_c1_r100_0850_0_1 sn_c1_r100_0850_0_1 0 0 0 sky130_fd_pr__nfet_01v8 L=0.15 W=0.42 nf=1 ad=0.1218 as=0.1218 pd=1.42 ps=1.42 nrd=0.69047619047619  nrs=0.69047619047619 sa=0 sb=0 sd=0 mult=1 m=1
XMRD_c1_r100_0850_0_1 rbl_c1_r100_0850_0 sn_c1_r100_0850_0_1 rwl_des 0 sky130_fd_pr__nfet_01v8 L=0.15 W=0.42 nf=1 ad=0.1218 as=0.1218 pd=1.42 ps=1.42 nrd=0.69047619047619  nrs=0.69047619047619 sa=0 sb=0 sd=0 mult=1 m=1
csn_c1_r100_0850_0_1 sn_c1_r100_0850_0_1 0 {C_SN}
XMWR_c1_r100_0850_0_2 sn_c1_r100_0850_0_2 0 0 0 sky130_fd_pr__nfet_01v8 L=0.15 W=0.42 nf=1 ad=0.1218 as=0.1218 pd=1.42 ps=1.42 nrd=0.69047619047619  nrs=0.69047619047619 sa=0 sb=0 sd=0 mult=1 m=1
XMRD_c1_r100_0850_0_2 rbl_c1_r100_0850_0 sn_c1_r100_0850_0_2 rwl_des 0 sky130_fd_pr__nfet_01v8 L=0.15 W=0.42 nf=1 ad=0.1218 as=0.1218 pd=1.42 ps=1.42 nrd=0.69047619047619  nrs=0.69047619047619 sa=0 sb=0 sd=0 mult=1 m=1
csn_c1_r100_0850_0_2 sn_c1_r100_0850_0_2 0 {C_SN}
XMWR_c1_r100_0850_0_3 sn_c1_r100_0850_0_3 0 0 0 sky130_fd_pr__nfet_01v8 L=0.15 W=0.42 nf=1 ad=0.1218 as=0.1218 pd=1.42 ps=1.42 nrd=0.69047619047619  nrs=0.69047619047619 sa=0 sb=0 sd=0 mult=1 m=1
XMRD_c1_r100_0850_0_3 rbl_c1_r100_0850_0 sn_c1_r100_0850_0_3 rwl_des 0 sky130_fd_pr__nfet_01v8 L=0.15 W=0.42 nf=1 ad=0.1218 as=0.1218 pd=1.42 ps=1.42 nrd=0.69047619047619  nrs=0.69047619047619 sa=0 sb=0 sd=0 mult=1 m=1
csn_c1_r100_0850_0_3 sn_c1_r100_0850_0_3 0 {C_SN}
crbl_c1_r100_0850_0 rbl_c1_r100_0850_0 0 {C_RBL}
spr_c1_r100_0850_0 pref_100 ref_c1_r100_0850_0 ctl 0 swpre
cref_c1_r100_0850_0 ref_c1_r100_0850_0 0 {C_RBL}   $ ASSUMPTION: ideal matched dummy load
XMN1_c1_r100_0850_0 rbl_c1_r100_0850_0 ref_c1_r100_0850_0 vn_c1_r100_0850_0 0 sky130_fd_pr__nfet_01v8 L=0.15 W=1 nf=1 ad=0.29 as=0.29 pd=2.58 ps=2.58 nrd=0.29 nrs=0.29 sa=0 sb=0 sd=0 mult=1 m=1
XMN2_c1_r100_0850_0 ref_c1_r100_0850_0 rbl_c1_r100_0850_0 vn_c1_r100_0850_0 0 sky130_fd_pr__nfet_01v8 L=0.15 W=1 nf=1 ad=0.29 as=0.29 pd=2.58 ps=2.58 nrd=0.29 nrs=0.29 sa=0 sb=0 sd=0 mult=1 m=1
XMP1_c1_r100_0850_0 rbl_c1_r100_0850_0 ref_c1_r100_0850_0 vp_c1_r100_0850_0 vdd sky130_fd_pr__pfet_01v8 L=0.15 W=2 nf=1 ad=0.58 as=0.58 pd=4.58 ps=4.58 nrd=0.145 nrs=0.145 sa=0 sb=0 sd=0 mult=1 m=1
XMP2_c1_r100_0850_0 ref_c1_r100_0850_0 rbl_c1_r100_0850_0 vp_c1_r100_0850_0 vdd sky130_fd_pr__pfet_01v8 L=0.15 W=2 nf=1 ad=0.58 as=0.58 pd=4.58 ps=4.58 nrd=0.145 nrs=0.145 sa=0 sb=0 sd=0 mult=1 m=1
XMNF_c1_r100_0850_0 vn_c1_r100_0850_0 en 0 0 sky130_fd_pr__nfet_01v8 L=0.15 W=2 nf=1 ad=0.58 as=0.58 pd=4.58 ps=4.58 nrd=0.145 nrs=0.145 sa=0 sb=0 sd=0 mult=1 m=1
XMPH_c1_r100_0850_0 vp_c1_r100_0850_0 enb vdd vdd sky130_fd_pr__pfet_01v8 L=0.15 W=4 nf=1 ad=1.16 as=1.16 pd=8.58 ps=8.58 nrd=0.0725 nrs=0.0725 sa=0 sb=0 sd=0 mult=1 m=1
bd_c1_r100_0850_0 d_c1_r100_0850_0 0 v=v(rbl_c1_r100_0850_0)-v(ref_c1_r100_0850_0)
bdabs_c1_r100_0850_0 dabs_c1_r100_0850_0 0 v=abs(v(rbl_c1_r100_0850_0)-v(ref_c1_r100_0850_0))

* ---- c1_r100_0850_1: cell1 SN = 0.85 V, ref offset 0.1 V, replica 1 ----
spa_c1_r100_0850_1 prea rbl_c1_r100_0850_1 ctl 0 swpre
XMWR_c1_r100_0850_1_0 sn_c1_r100_0850_1_0 0 0 0 sky130_fd_pr__nfet_01v8 L=0.15 W=0.42 nf=1 ad=0.1218 as=0.1218 pd=1.42 ps=1.42 nrd=0.69047619047619  nrs=0.69047619047619 sa=0 sb=0 sd=0 mult=1 m=1
XMRD_c1_r100_0850_1_0 rbl_c1_r100_0850_1 sn_c1_r100_0850_1_0 rwl_sel 0 sky130_fd_pr__nfet_01v8 L=0.15 W=0.42 nf=1 ad=0.1218 as=0.1218 pd=1.42 ps=1.42 nrd=0.69047619047619  nrs=0.69047619047619 sa=0 sb=0 sd=0 mult=1 m=1
csn_c1_r100_0850_1_0 sn_c1_r100_0850_1_0 0 {C_SN}
XMWR_c1_r100_0850_1_1 sn_c1_r100_0850_1_1 0 0 0 sky130_fd_pr__nfet_01v8 L=0.15 W=0.42 nf=1 ad=0.1218 as=0.1218 pd=1.42 ps=1.42 nrd=0.69047619047619  nrs=0.69047619047619 sa=0 sb=0 sd=0 mult=1 m=1
XMRD_c1_r100_0850_1_1 rbl_c1_r100_0850_1 sn_c1_r100_0850_1_1 rwl_des 0 sky130_fd_pr__nfet_01v8 L=0.15 W=0.42 nf=1 ad=0.1218 as=0.1218 pd=1.42 ps=1.42 nrd=0.69047619047619  nrs=0.69047619047619 sa=0 sb=0 sd=0 mult=1 m=1
csn_c1_r100_0850_1_1 sn_c1_r100_0850_1_1 0 {C_SN}
XMWR_c1_r100_0850_1_2 sn_c1_r100_0850_1_2 0 0 0 sky130_fd_pr__nfet_01v8 L=0.15 W=0.42 nf=1 ad=0.1218 as=0.1218 pd=1.42 ps=1.42 nrd=0.69047619047619  nrs=0.69047619047619 sa=0 sb=0 sd=0 mult=1 m=1
XMRD_c1_r100_0850_1_2 rbl_c1_r100_0850_1 sn_c1_r100_0850_1_2 rwl_des 0 sky130_fd_pr__nfet_01v8 L=0.15 W=0.42 nf=1 ad=0.1218 as=0.1218 pd=1.42 ps=1.42 nrd=0.69047619047619  nrs=0.69047619047619 sa=0 sb=0 sd=0 mult=1 m=1
csn_c1_r100_0850_1_2 sn_c1_r100_0850_1_2 0 {C_SN}
XMWR_c1_r100_0850_1_3 sn_c1_r100_0850_1_3 0 0 0 sky130_fd_pr__nfet_01v8 L=0.15 W=0.42 nf=1 ad=0.1218 as=0.1218 pd=1.42 ps=1.42 nrd=0.69047619047619  nrs=0.69047619047619 sa=0 sb=0 sd=0 mult=1 m=1
XMRD_c1_r100_0850_1_3 rbl_c1_r100_0850_1 sn_c1_r100_0850_1_3 rwl_des 0 sky130_fd_pr__nfet_01v8 L=0.15 W=0.42 nf=1 ad=0.1218 as=0.1218 pd=1.42 ps=1.42 nrd=0.69047619047619  nrs=0.69047619047619 sa=0 sb=0 sd=0 mult=1 m=1
csn_c1_r100_0850_1_3 sn_c1_r100_0850_1_3 0 {C_SN}
crbl_c1_r100_0850_1 rbl_c1_r100_0850_1 0 {C_RBL}
spr_c1_r100_0850_1 pref_100 ref_c1_r100_0850_1 ctl 0 swpre
cref_c1_r100_0850_1 ref_c1_r100_0850_1 0 {C_RBL}   $ ASSUMPTION: ideal matched dummy load
XMN1_c1_r100_0850_1 rbl_c1_r100_0850_1 ref_c1_r100_0850_1 vn_c1_r100_0850_1 0 sky130_fd_pr__nfet_01v8 L=0.15 W=1 nf=1 ad=0.29 as=0.29 pd=2.58 ps=2.58 nrd=0.29 nrs=0.29 sa=0 sb=0 sd=0 mult=1 m=1
XMN2_c1_r100_0850_1 ref_c1_r100_0850_1 rbl_c1_r100_0850_1 vn_c1_r100_0850_1 0 sky130_fd_pr__nfet_01v8 L=0.15 W=1 nf=1 ad=0.29 as=0.29 pd=2.58 ps=2.58 nrd=0.29 nrs=0.29 sa=0 sb=0 sd=0 mult=1 m=1
XMP1_c1_r100_0850_1 rbl_c1_r100_0850_1 ref_c1_r100_0850_1 vp_c1_r100_0850_1 vdd sky130_fd_pr__pfet_01v8 L=0.15 W=2 nf=1 ad=0.58 as=0.58 pd=4.58 ps=4.58 nrd=0.145 nrs=0.145 sa=0 sb=0 sd=0 mult=1 m=1
XMP2_c1_r100_0850_1 ref_c1_r100_0850_1 rbl_c1_r100_0850_1 vp_c1_r100_0850_1 vdd sky130_fd_pr__pfet_01v8 L=0.15 W=2 nf=1 ad=0.58 as=0.58 pd=4.58 ps=4.58 nrd=0.145 nrs=0.145 sa=0 sb=0 sd=0 mult=1 m=1
XMNF_c1_r100_0850_1 vn_c1_r100_0850_1 en 0 0 sky130_fd_pr__nfet_01v8 L=0.15 W=2 nf=1 ad=0.58 as=0.58 pd=4.58 ps=4.58 nrd=0.145 nrs=0.145 sa=0 sb=0 sd=0 mult=1 m=1
XMPH_c1_r100_0850_1 vp_c1_r100_0850_1 enb vdd vdd sky130_fd_pr__pfet_01v8 L=0.15 W=4 nf=1 ad=1.16 as=1.16 pd=8.58 ps=8.58 nrd=0.0725 nrs=0.0725 sa=0 sb=0 sd=0 mult=1 m=1
bd_c1_r100_0850_1 d_c1_r100_0850_1 0 v=v(rbl_c1_r100_0850_1)-v(ref_c1_r100_0850_1)
bdabs_c1_r100_0850_1 dabs_c1_r100_0850_1 0 v=abs(v(rbl_c1_r100_0850_1)-v(ref_c1_r100_0850_1))

* ---- c1_r100_0850_2: cell1 SN = 0.85 V, ref offset 0.1 V, replica 2 ----
spa_c1_r100_0850_2 prea rbl_c1_r100_0850_2 ctl 0 swpre
XMWR_c1_r100_0850_2_0 sn_c1_r100_0850_2_0 0 0 0 sky130_fd_pr__nfet_01v8 L=0.15 W=0.42 nf=1 ad=0.1218 as=0.1218 pd=1.42 ps=1.42 nrd=0.69047619047619  nrs=0.69047619047619 sa=0 sb=0 sd=0 mult=1 m=1
XMRD_c1_r100_0850_2_0 rbl_c1_r100_0850_2 sn_c1_r100_0850_2_0 rwl_sel 0 sky130_fd_pr__nfet_01v8 L=0.15 W=0.42 nf=1 ad=0.1218 as=0.1218 pd=1.42 ps=1.42 nrd=0.69047619047619  nrs=0.69047619047619 sa=0 sb=0 sd=0 mult=1 m=1
csn_c1_r100_0850_2_0 sn_c1_r100_0850_2_0 0 {C_SN}
XMWR_c1_r100_0850_2_1 sn_c1_r100_0850_2_1 0 0 0 sky130_fd_pr__nfet_01v8 L=0.15 W=0.42 nf=1 ad=0.1218 as=0.1218 pd=1.42 ps=1.42 nrd=0.69047619047619  nrs=0.69047619047619 sa=0 sb=0 sd=0 mult=1 m=1
XMRD_c1_r100_0850_2_1 rbl_c1_r100_0850_2 sn_c1_r100_0850_2_1 rwl_des 0 sky130_fd_pr__nfet_01v8 L=0.15 W=0.42 nf=1 ad=0.1218 as=0.1218 pd=1.42 ps=1.42 nrd=0.69047619047619  nrs=0.69047619047619 sa=0 sb=0 sd=0 mult=1 m=1
csn_c1_r100_0850_2_1 sn_c1_r100_0850_2_1 0 {C_SN}
XMWR_c1_r100_0850_2_2 sn_c1_r100_0850_2_2 0 0 0 sky130_fd_pr__nfet_01v8 L=0.15 W=0.42 nf=1 ad=0.1218 as=0.1218 pd=1.42 ps=1.42 nrd=0.69047619047619  nrs=0.69047619047619 sa=0 sb=0 sd=0 mult=1 m=1
XMRD_c1_r100_0850_2_2 rbl_c1_r100_0850_2 sn_c1_r100_0850_2_2 rwl_des 0 sky130_fd_pr__nfet_01v8 L=0.15 W=0.42 nf=1 ad=0.1218 as=0.1218 pd=1.42 ps=1.42 nrd=0.69047619047619  nrs=0.69047619047619 sa=0 sb=0 sd=0 mult=1 m=1
csn_c1_r100_0850_2_2 sn_c1_r100_0850_2_2 0 {C_SN}
XMWR_c1_r100_0850_2_3 sn_c1_r100_0850_2_3 0 0 0 sky130_fd_pr__nfet_01v8 L=0.15 W=0.42 nf=1 ad=0.1218 as=0.1218 pd=1.42 ps=1.42 nrd=0.69047619047619  nrs=0.69047619047619 sa=0 sb=0 sd=0 mult=1 m=1
XMRD_c1_r100_0850_2_3 rbl_c1_r100_0850_2 sn_c1_r100_0850_2_3 rwl_des 0 sky130_fd_pr__nfet_01v8 L=0.15 W=0.42 nf=1 ad=0.1218 as=0.1218 pd=1.42 ps=1.42 nrd=0.69047619047619  nrs=0.69047619047619 sa=0 sb=0 sd=0 mult=1 m=1
csn_c1_r100_0850_2_3 sn_c1_r100_0850_2_3 0 {C_SN}
crbl_c1_r100_0850_2 rbl_c1_r100_0850_2 0 {C_RBL}
spr_c1_r100_0850_2 pref_100 ref_c1_r100_0850_2 ctl 0 swpre
cref_c1_r100_0850_2 ref_c1_r100_0850_2 0 {C_RBL}   $ ASSUMPTION: ideal matched dummy load
XMN1_c1_r100_0850_2 rbl_c1_r100_0850_2 ref_c1_r100_0850_2 vn_c1_r100_0850_2 0 sky130_fd_pr__nfet_01v8 L=0.15 W=1 nf=1 ad=0.29 as=0.29 pd=2.58 ps=2.58 nrd=0.29 nrs=0.29 sa=0 sb=0 sd=0 mult=1 m=1
XMN2_c1_r100_0850_2 ref_c1_r100_0850_2 rbl_c1_r100_0850_2 vn_c1_r100_0850_2 0 sky130_fd_pr__nfet_01v8 L=0.15 W=1 nf=1 ad=0.29 as=0.29 pd=2.58 ps=2.58 nrd=0.29 nrs=0.29 sa=0 sb=0 sd=0 mult=1 m=1
XMP1_c1_r100_0850_2 rbl_c1_r100_0850_2 ref_c1_r100_0850_2 vp_c1_r100_0850_2 vdd sky130_fd_pr__pfet_01v8 L=0.15 W=2 nf=1 ad=0.58 as=0.58 pd=4.58 ps=4.58 nrd=0.145 nrs=0.145 sa=0 sb=0 sd=0 mult=1 m=1
XMP2_c1_r100_0850_2 ref_c1_r100_0850_2 rbl_c1_r100_0850_2 vp_c1_r100_0850_2 vdd sky130_fd_pr__pfet_01v8 L=0.15 W=2 nf=1 ad=0.58 as=0.58 pd=4.58 ps=4.58 nrd=0.145 nrs=0.145 sa=0 sb=0 sd=0 mult=1 m=1
XMNF_c1_r100_0850_2 vn_c1_r100_0850_2 en 0 0 sky130_fd_pr__nfet_01v8 L=0.15 W=2 nf=1 ad=0.58 as=0.58 pd=4.58 ps=4.58 nrd=0.145 nrs=0.145 sa=0 sb=0 sd=0 mult=1 m=1
XMPH_c1_r100_0850_2 vp_c1_r100_0850_2 enb vdd vdd sky130_fd_pr__pfet_01v8 L=0.15 W=4 nf=1 ad=1.16 as=1.16 pd=8.58 ps=8.58 nrd=0.0725 nrs=0.0725 sa=0 sb=0 sd=0 mult=1 m=1
bd_c1_r100_0850_2 d_c1_r100_0850_2 0 v=v(rbl_c1_r100_0850_2)-v(ref_c1_r100_0850_2)
bdabs_c1_r100_0850_2 dabs_c1_r100_0850_2 0 v=abs(v(rbl_c1_r100_0850_2)-v(ref_c1_r100_0850_2))

* ---- c1_r100_0850_3: cell1 SN = 0.85 V, ref offset 0.1 V, replica 3 ----
spa_c1_r100_0850_3 prea rbl_c1_r100_0850_3 ctl 0 swpre
XMWR_c1_r100_0850_3_0 sn_c1_r100_0850_3_0 0 0 0 sky130_fd_pr__nfet_01v8 L=0.15 W=0.42 nf=1 ad=0.1218 as=0.1218 pd=1.42 ps=1.42 nrd=0.69047619047619  nrs=0.69047619047619 sa=0 sb=0 sd=0 mult=1 m=1
XMRD_c1_r100_0850_3_0 rbl_c1_r100_0850_3 sn_c1_r100_0850_3_0 rwl_sel 0 sky130_fd_pr__nfet_01v8 L=0.15 W=0.42 nf=1 ad=0.1218 as=0.1218 pd=1.42 ps=1.42 nrd=0.69047619047619  nrs=0.69047619047619 sa=0 sb=0 sd=0 mult=1 m=1
csn_c1_r100_0850_3_0 sn_c1_r100_0850_3_0 0 {C_SN}
XMWR_c1_r100_0850_3_1 sn_c1_r100_0850_3_1 0 0 0 sky130_fd_pr__nfet_01v8 L=0.15 W=0.42 nf=1 ad=0.1218 as=0.1218 pd=1.42 ps=1.42 nrd=0.69047619047619  nrs=0.69047619047619 sa=0 sb=0 sd=0 mult=1 m=1
XMRD_c1_r100_0850_3_1 rbl_c1_r100_0850_3 sn_c1_r100_0850_3_1 rwl_des 0 sky130_fd_pr__nfet_01v8 L=0.15 W=0.42 nf=1 ad=0.1218 as=0.1218 pd=1.42 ps=1.42 nrd=0.69047619047619  nrs=0.69047619047619 sa=0 sb=0 sd=0 mult=1 m=1
csn_c1_r100_0850_3_1 sn_c1_r100_0850_3_1 0 {C_SN}
XMWR_c1_r100_0850_3_2 sn_c1_r100_0850_3_2 0 0 0 sky130_fd_pr__nfet_01v8 L=0.15 W=0.42 nf=1 ad=0.1218 as=0.1218 pd=1.42 ps=1.42 nrd=0.69047619047619  nrs=0.69047619047619 sa=0 sb=0 sd=0 mult=1 m=1
XMRD_c1_r100_0850_3_2 rbl_c1_r100_0850_3 sn_c1_r100_0850_3_2 rwl_des 0 sky130_fd_pr__nfet_01v8 L=0.15 W=0.42 nf=1 ad=0.1218 as=0.1218 pd=1.42 ps=1.42 nrd=0.69047619047619  nrs=0.69047619047619 sa=0 sb=0 sd=0 mult=1 m=1
csn_c1_r100_0850_3_2 sn_c1_r100_0850_3_2 0 {C_SN}
XMWR_c1_r100_0850_3_3 sn_c1_r100_0850_3_3 0 0 0 sky130_fd_pr__nfet_01v8 L=0.15 W=0.42 nf=1 ad=0.1218 as=0.1218 pd=1.42 ps=1.42 nrd=0.69047619047619  nrs=0.69047619047619 sa=0 sb=0 sd=0 mult=1 m=1
XMRD_c1_r100_0850_3_3 rbl_c1_r100_0850_3 sn_c1_r100_0850_3_3 rwl_des 0 sky130_fd_pr__nfet_01v8 L=0.15 W=0.42 nf=1 ad=0.1218 as=0.1218 pd=1.42 ps=1.42 nrd=0.69047619047619  nrs=0.69047619047619 sa=0 sb=0 sd=0 mult=1 m=1
csn_c1_r100_0850_3_3 sn_c1_r100_0850_3_3 0 {C_SN}
crbl_c1_r100_0850_3 rbl_c1_r100_0850_3 0 {C_RBL}
spr_c1_r100_0850_3 pref_100 ref_c1_r100_0850_3 ctl 0 swpre
cref_c1_r100_0850_3 ref_c1_r100_0850_3 0 {C_RBL}   $ ASSUMPTION: ideal matched dummy load
XMN1_c1_r100_0850_3 rbl_c1_r100_0850_3 ref_c1_r100_0850_3 vn_c1_r100_0850_3 0 sky130_fd_pr__nfet_01v8 L=0.15 W=1 nf=1 ad=0.29 as=0.29 pd=2.58 ps=2.58 nrd=0.29 nrs=0.29 sa=0 sb=0 sd=0 mult=1 m=1
XMN2_c1_r100_0850_3 ref_c1_r100_0850_3 rbl_c1_r100_0850_3 vn_c1_r100_0850_3 0 sky130_fd_pr__nfet_01v8 L=0.15 W=1 nf=1 ad=0.29 as=0.29 pd=2.58 ps=2.58 nrd=0.29 nrs=0.29 sa=0 sb=0 sd=0 mult=1 m=1
XMP1_c1_r100_0850_3 rbl_c1_r100_0850_3 ref_c1_r100_0850_3 vp_c1_r100_0850_3 vdd sky130_fd_pr__pfet_01v8 L=0.15 W=2 nf=1 ad=0.58 as=0.58 pd=4.58 ps=4.58 nrd=0.145 nrs=0.145 sa=0 sb=0 sd=0 mult=1 m=1
XMP2_c1_r100_0850_3 ref_c1_r100_0850_3 rbl_c1_r100_0850_3 vp_c1_r100_0850_3 vdd sky130_fd_pr__pfet_01v8 L=0.15 W=2 nf=1 ad=0.58 as=0.58 pd=4.58 ps=4.58 nrd=0.145 nrs=0.145 sa=0 sb=0 sd=0 mult=1 m=1
XMNF_c1_r100_0850_3 vn_c1_r100_0850_3 en 0 0 sky130_fd_pr__nfet_01v8 L=0.15 W=2 nf=1 ad=0.58 as=0.58 pd=4.58 ps=4.58 nrd=0.145 nrs=0.145 sa=0 sb=0 sd=0 mult=1 m=1
XMPH_c1_r100_0850_3 vp_c1_r100_0850_3 enb vdd vdd sky130_fd_pr__pfet_01v8 L=0.15 W=4 nf=1 ad=1.16 as=1.16 pd=8.58 ps=8.58 nrd=0.0725 nrs=0.0725 sa=0 sb=0 sd=0 mult=1 m=1
bd_c1_r100_0850_3 d_c1_r100_0850_3 0 v=v(rbl_c1_r100_0850_3)-v(ref_c1_r100_0850_3)
bdabs_c1_r100_0850_3 dabs_c1_r100_0850_3 0 v=abs(v(rbl_c1_r100_0850_3)-v(ref_c1_r100_0850_3))

* ---- c1_r100_0900_0: cell1 SN = 0.9 V, ref offset 0.1 V, replica 0 ----
spa_c1_r100_0900_0 prea rbl_c1_r100_0900_0 ctl 0 swpre
XMWR_c1_r100_0900_0_0 sn_c1_r100_0900_0_0 0 0 0 sky130_fd_pr__nfet_01v8 L=0.15 W=0.42 nf=1 ad=0.1218 as=0.1218 pd=1.42 ps=1.42 nrd=0.69047619047619  nrs=0.69047619047619 sa=0 sb=0 sd=0 mult=1 m=1
XMRD_c1_r100_0900_0_0 rbl_c1_r100_0900_0 sn_c1_r100_0900_0_0 rwl_sel 0 sky130_fd_pr__nfet_01v8 L=0.15 W=0.42 nf=1 ad=0.1218 as=0.1218 pd=1.42 ps=1.42 nrd=0.69047619047619  nrs=0.69047619047619 sa=0 sb=0 sd=0 mult=1 m=1
csn_c1_r100_0900_0_0 sn_c1_r100_0900_0_0 0 {C_SN}
XMWR_c1_r100_0900_0_1 sn_c1_r100_0900_0_1 0 0 0 sky130_fd_pr__nfet_01v8 L=0.15 W=0.42 nf=1 ad=0.1218 as=0.1218 pd=1.42 ps=1.42 nrd=0.69047619047619  nrs=0.69047619047619 sa=0 sb=0 sd=0 mult=1 m=1
XMRD_c1_r100_0900_0_1 rbl_c1_r100_0900_0 sn_c1_r100_0900_0_1 rwl_des 0 sky130_fd_pr__nfet_01v8 L=0.15 W=0.42 nf=1 ad=0.1218 as=0.1218 pd=1.42 ps=1.42 nrd=0.69047619047619  nrs=0.69047619047619 sa=0 sb=0 sd=0 mult=1 m=1
csn_c1_r100_0900_0_1 sn_c1_r100_0900_0_1 0 {C_SN}
XMWR_c1_r100_0900_0_2 sn_c1_r100_0900_0_2 0 0 0 sky130_fd_pr__nfet_01v8 L=0.15 W=0.42 nf=1 ad=0.1218 as=0.1218 pd=1.42 ps=1.42 nrd=0.69047619047619  nrs=0.69047619047619 sa=0 sb=0 sd=0 mult=1 m=1
XMRD_c1_r100_0900_0_2 rbl_c1_r100_0900_0 sn_c1_r100_0900_0_2 rwl_des 0 sky130_fd_pr__nfet_01v8 L=0.15 W=0.42 nf=1 ad=0.1218 as=0.1218 pd=1.42 ps=1.42 nrd=0.69047619047619  nrs=0.69047619047619 sa=0 sb=0 sd=0 mult=1 m=1
csn_c1_r100_0900_0_2 sn_c1_r100_0900_0_2 0 {C_SN}
XMWR_c1_r100_0900_0_3 sn_c1_r100_0900_0_3 0 0 0 sky130_fd_pr__nfet_01v8 L=0.15 W=0.42 nf=1 ad=0.1218 as=0.1218 pd=1.42 ps=1.42 nrd=0.69047619047619  nrs=0.69047619047619 sa=0 sb=0 sd=0 mult=1 m=1
XMRD_c1_r100_0900_0_3 rbl_c1_r100_0900_0 sn_c1_r100_0900_0_3 rwl_des 0 sky130_fd_pr__nfet_01v8 L=0.15 W=0.42 nf=1 ad=0.1218 as=0.1218 pd=1.42 ps=1.42 nrd=0.69047619047619  nrs=0.69047619047619 sa=0 sb=0 sd=0 mult=1 m=1
csn_c1_r100_0900_0_3 sn_c1_r100_0900_0_3 0 {C_SN}
crbl_c1_r100_0900_0 rbl_c1_r100_0900_0 0 {C_RBL}
spr_c1_r100_0900_0 pref_100 ref_c1_r100_0900_0 ctl 0 swpre
cref_c1_r100_0900_0 ref_c1_r100_0900_0 0 {C_RBL}   $ ASSUMPTION: ideal matched dummy load
XMN1_c1_r100_0900_0 rbl_c1_r100_0900_0 ref_c1_r100_0900_0 vn_c1_r100_0900_0 0 sky130_fd_pr__nfet_01v8 L=0.15 W=1 nf=1 ad=0.29 as=0.29 pd=2.58 ps=2.58 nrd=0.29 nrs=0.29 sa=0 sb=0 sd=0 mult=1 m=1
XMN2_c1_r100_0900_0 ref_c1_r100_0900_0 rbl_c1_r100_0900_0 vn_c1_r100_0900_0 0 sky130_fd_pr__nfet_01v8 L=0.15 W=1 nf=1 ad=0.29 as=0.29 pd=2.58 ps=2.58 nrd=0.29 nrs=0.29 sa=0 sb=0 sd=0 mult=1 m=1
XMP1_c1_r100_0900_0 rbl_c1_r100_0900_0 ref_c1_r100_0900_0 vp_c1_r100_0900_0 vdd sky130_fd_pr__pfet_01v8 L=0.15 W=2 nf=1 ad=0.58 as=0.58 pd=4.58 ps=4.58 nrd=0.145 nrs=0.145 sa=0 sb=0 sd=0 mult=1 m=1
XMP2_c1_r100_0900_0 ref_c1_r100_0900_0 rbl_c1_r100_0900_0 vp_c1_r100_0900_0 vdd sky130_fd_pr__pfet_01v8 L=0.15 W=2 nf=1 ad=0.58 as=0.58 pd=4.58 ps=4.58 nrd=0.145 nrs=0.145 sa=0 sb=0 sd=0 mult=1 m=1
XMNF_c1_r100_0900_0 vn_c1_r100_0900_0 en 0 0 sky130_fd_pr__nfet_01v8 L=0.15 W=2 nf=1 ad=0.58 as=0.58 pd=4.58 ps=4.58 nrd=0.145 nrs=0.145 sa=0 sb=0 sd=0 mult=1 m=1
XMPH_c1_r100_0900_0 vp_c1_r100_0900_0 enb vdd vdd sky130_fd_pr__pfet_01v8 L=0.15 W=4 nf=1 ad=1.16 as=1.16 pd=8.58 ps=8.58 nrd=0.0725 nrs=0.0725 sa=0 sb=0 sd=0 mult=1 m=1
bd_c1_r100_0900_0 d_c1_r100_0900_0 0 v=v(rbl_c1_r100_0900_0)-v(ref_c1_r100_0900_0)
bdabs_c1_r100_0900_0 dabs_c1_r100_0900_0 0 v=abs(v(rbl_c1_r100_0900_0)-v(ref_c1_r100_0900_0))

* ---- c1_r100_0900_1: cell1 SN = 0.9 V, ref offset 0.1 V, replica 1 ----
spa_c1_r100_0900_1 prea rbl_c1_r100_0900_1 ctl 0 swpre
XMWR_c1_r100_0900_1_0 sn_c1_r100_0900_1_0 0 0 0 sky130_fd_pr__nfet_01v8 L=0.15 W=0.42 nf=1 ad=0.1218 as=0.1218 pd=1.42 ps=1.42 nrd=0.69047619047619  nrs=0.69047619047619 sa=0 sb=0 sd=0 mult=1 m=1
XMRD_c1_r100_0900_1_0 rbl_c1_r100_0900_1 sn_c1_r100_0900_1_0 rwl_sel 0 sky130_fd_pr__nfet_01v8 L=0.15 W=0.42 nf=1 ad=0.1218 as=0.1218 pd=1.42 ps=1.42 nrd=0.69047619047619  nrs=0.69047619047619 sa=0 sb=0 sd=0 mult=1 m=1
csn_c1_r100_0900_1_0 sn_c1_r100_0900_1_0 0 {C_SN}
XMWR_c1_r100_0900_1_1 sn_c1_r100_0900_1_1 0 0 0 sky130_fd_pr__nfet_01v8 L=0.15 W=0.42 nf=1 ad=0.1218 as=0.1218 pd=1.42 ps=1.42 nrd=0.69047619047619  nrs=0.69047619047619 sa=0 sb=0 sd=0 mult=1 m=1
XMRD_c1_r100_0900_1_1 rbl_c1_r100_0900_1 sn_c1_r100_0900_1_1 rwl_des 0 sky130_fd_pr__nfet_01v8 L=0.15 W=0.42 nf=1 ad=0.1218 as=0.1218 pd=1.42 ps=1.42 nrd=0.69047619047619  nrs=0.69047619047619 sa=0 sb=0 sd=0 mult=1 m=1
csn_c1_r100_0900_1_1 sn_c1_r100_0900_1_1 0 {C_SN}
XMWR_c1_r100_0900_1_2 sn_c1_r100_0900_1_2 0 0 0 sky130_fd_pr__nfet_01v8 L=0.15 W=0.42 nf=1 ad=0.1218 as=0.1218 pd=1.42 ps=1.42 nrd=0.69047619047619  nrs=0.69047619047619 sa=0 sb=0 sd=0 mult=1 m=1
XMRD_c1_r100_0900_1_2 rbl_c1_r100_0900_1 sn_c1_r100_0900_1_2 rwl_des 0 sky130_fd_pr__nfet_01v8 L=0.15 W=0.42 nf=1 ad=0.1218 as=0.1218 pd=1.42 ps=1.42 nrd=0.69047619047619  nrs=0.69047619047619 sa=0 sb=0 sd=0 mult=1 m=1
csn_c1_r100_0900_1_2 sn_c1_r100_0900_1_2 0 {C_SN}
XMWR_c1_r100_0900_1_3 sn_c1_r100_0900_1_3 0 0 0 sky130_fd_pr__nfet_01v8 L=0.15 W=0.42 nf=1 ad=0.1218 as=0.1218 pd=1.42 ps=1.42 nrd=0.69047619047619  nrs=0.69047619047619 sa=0 sb=0 sd=0 mult=1 m=1
XMRD_c1_r100_0900_1_3 rbl_c1_r100_0900_1 sn_c1_r100_0900_1_3 rwl_des 0 sky130_fd_pr__nfet_01v8 L=0.15 W=0.42 nf=1 ad=0.1218 as=0.1218 pd=1.42 ps=1.42 nrd=0.69047619047619  nrs=0.69047619047619 sa=0 sb=0 sd=0 mult=1 m=1
csn_c1_r100_0900_1_3 sn_c1_r100_0900_1_3 0 {C_SN}
crbl_c1_r100_0900_1 rbl_c1_r100_0900_1 0 {C_RBL}
spr_c1_r100_0900_1 pref_100 ref_c1_r100_0900_1 ctl 0 swpre
cref_c1_r100_0900_1 ref_c1_r100_0900_1 0 {C_RBL}   $ ASSUMPTION: ideal matched dummy load
XMN1_c1_r100_0900_1 rbl_c1_r100_0900_1 ref_c1_r100_0900_1 vn_c1_r100_0900_1 0 sky130_fd_pr__nfet_01v8 L=0.15 W=1 nf=1 ad=0.29 as=0.29 pd=2.58 ps=2.58 nrd=0.29 nrs=0.29 sa=0 sb=0 sd=0 mult=1 m=1
XMN2_c1_r100_0900_1 ref_c1_r100_0900_1 rbl_c1_r100_0900_1 vn_c1_r100_0900_1 0 sky130_fd_pr__nfet_01v8 L=0.15 W=1 nf=1 ad=0.29 as=0.29 pd=2.58 ps=2.58 nrd=0.29 nrs=0.29 sa=0 sb=0 sd=0 mult=1 m=1
XMP1_c1_r100_0900_1 rbl_c1_r100_0900_1 ref_c1_r100_0900_1 vp_c1_r100_0900_1 vdd sky130_fd_pr__pfet_01v8 L=0.15 W=2 nf=1 ad=0.58 as=0.58 pd=4.58 ps=4.58 nrd=0.145 nrs=0.145 sa=0 sb=0 sd=0 mult=1 m=1
XMP2_c1_r100_0900_1 ref_c1_r100_0900_1 rbl_c1_r100_0900_1 vp_c1_r100_0900_1 vdd sky130_fd_pr__pfet_01v8 L=0.15 W=2 nf=1 ad=0.58 as=0.58 pd=4.58 ps=4.58 nrd=0.145 nrs=0.145 sa=0 sb=0 sd=0 mult=1 m=1
XMNF_c1_r100_0900_1 vn_c1_r100_0900_1 en 0 0 sky130_fd_pr__nfet_01v8 L=0.15 W=2 nf=1 ad=0.58 as=0.58 pd=4.58 ps=4.58 nrd=0.145 nrs=0.145 sa=0 sb=0 sd=0 mult=1 m=1
XMPH_c1_r100_0900_1 vp_c1_r100_0900_1 enb vdd vdd sky130_fd_pr__pfet_01v8 L=0.15 W=4 nf=1 ad=1.16 as=1.16 pd=8.58 ps=8.58 nrd=0.0725 nrs=0.0725 sa=0 sb=0 sd=0 mult=1 m=1
bd_c1_r100_0900_1 d_c1_r100_0900_1 0 v=v(rbl_c1_r100_0900_1)-v(ref_c1_r100_0900_1)
bdabs_c1_r100_0900_1 dabs_c1_r100_0900_1 0 v=abs(v(rbl_c1_r100_0900_1)-v(ref_c1_r100_0900_1))

* ---- c1_r100_0900_2: cell1 SN = 0.9 V, ref offset 0.1 V, replica 2 ----
spa_c1_r100_0900_2 prea rbl_c1_r100_0900_2 ctl 0 swpre
XMWR_c1_r100_0900_2_0 sn_c1_r100_0900_2_0 0 0 0 sky130_fd_pr__nfet_01v8 L=0.15 W=0.42 nf=1 ad=0.1218 as=0.1218 pd=1.42 ps=1.42 nrd=0.69047619047619  nrs=0.69047619047619 sa=0 sb=0 sd=0 mult=1 m=1
XMRD_c1_r100_0900_2_0 rbl_c1_r100_0900_2 sn_c1_r100_0900_2_0 rwl_sel 0 sky130_fd_pr__nfet_01v8 L=0.15 W=0.42 nf=1 ad=0.1218 as=0.1218 pd=1.42 ps=1.42 nrd=0.69047619047619  nrs=0.69047619047619 sa=0 sb=0 sd=0 mult=1 m=1
csn_c1_r100_0900_2_0 sn_c1_r100_0900_2_0 0 {C_SN}
XMWR_c1_r100_0900_2_1 sn_c1_r100_0900_2_1 0 0 0 sky130_fd_pr__nfet_01v8 L=0.15 W=0.42 nf=1 ad=0.1218 as=0.1218 pd=1.42 ps=1.42 nrd=0.69047619047619  nrs=0.69047619047619 sa=0 sb=0 sd=0 mult=1 m=1
XMRD_c1_r100_0900_2_1 rbl_c1_r100_0900_2 sn_c1_r100_0900_2_1 rwl_des 0 sky130_fd_pr__nfet_01v8 L=0.15 W=0.42 nf=1 ad=0.1218 as=0.1218 pd=1.42 ps=1.42 nrd=0.69047619047619  nrs=0.69047619047619 sa=0 sb=0 sd=0 mult=1 m=1
csn_c1_r100_0900_2_1 sn_c1_r100_0900_2_1 0 {C_SN}
XMWR_c1_r100_0900_2_2 sn_c1_r100_0900_2_2 0 0 0 sky130_fd_pr__nfet_01v8 L=0.15 W=0.42 nf=1 ad=0.1218 as=0.1218 pd=1.42 ps=1.42 nrd=0.69047619047619  nrs=0.69047619047619 sa=0 sb=0 sd=0 mult=1 m=1
XMRD_c1_r100_0900_2_2 rbl_c1_r100_0900_2 sn_c1_r100_0900_2_2 rwl_des 0 sky130_fd_pr__nfet_01v8 L=0.15 W=0.42 nf=1 ad=0.1218 as=0.1218 pd=1.42 ps=1.42 nrd=0.69047619047619  nrs=0.69047619047619 sa=0 sb=0 sd=0 mult=1 m=1
csn_c1_r100_0900_2_2 sn_c1_r100_0900_2_2 0 {C_SN}
XMWR_c1_r100_0900_2_3 sn_c1_r100_0900_2_3 0 0 0 sky130_fd_pr__nfet_01v8 L=0.15 W=0.42 nf=1 ad=0.1218 as=0.1218 pd=1.42 ps=1.42 nrd=0.69047619047619  nrs=0.69047619047619 sa=0 sb=0 sd=0 mult=1 m=1
XMRD_c1_r100_0900_2_3 rbl_c1_r100_0900_2 sn_c1_r100_0900_2_3 rwl_des 0 sky130_fd_pr__nfet_01v8 L=0.15 W=0.42 nf=1 ad=0.1218 as=0.1218 pd=1.42 ps=1.42 nrd=0.69047619047619  nrs=0.69047619047619 sa=0 sb=0 sd=0 mult=1 m=1
csn_c1_r100_0900_2_3 sn_c1_r100_0900_2_3 0 {C_SN}
crbl_c1_r100_0900_2 rbl_c1_r100_0900_2 0 {C_RBL}
spr_c1_r100_0900_2 pref_100 ref_c1_r100_0900_2 ctl 0 swpre
cref_c1_r100_0900_2 ref_c1_r100_0900_2 0 {C_RBL}   $ ASSUMPTION: ideal matched dummy load
XMN1_c1_r100_0900_2 rbl_c1_r100_0900_2 ref_c1_r100_0900_2 vn_c1_r100_0900_2 0 sky130_fd_pr__nfet_01v8 L=0.15 W=1 nf=1 ad=0.29 as=0.29 pd=2.58 ps=2.58 nrd=0.29 nrs=0.29 sa=0 sb=0 sd=0 mult=1 m=1
XMN2_c1_r100_0900_2 ref_c1_r100_0900_2 rbl_c1_r100_0900_2 vn_c1_r100_0900_2 0 sky130_fd_pr__nfet_01v8 L=0.15 W=1 nf=1 ad=0.29 as=0.29 pd=2.58 ps=2.58 nrd=0.29 nrs=0.29 sa=0 sb=0 sd=0 mult=1 m=1
XMP1_c1_r100_0900_2 rbl_c1_r100_0900_2 ref_c1_r100_0900_2 vp_c1_r100_0900_2 vdd sky130_fd_pr__pfet_01v8 L=0.15 W=2 nf=1 ad=0.58 as=0.58 pd=4.58 ps=4.58 nrd=0.145 nrs=0.145 sa=0 sb=0 sd=0 mult=1 m=1
XMP2_c1_r100_0900_2 ref_c1_r100_0900_2 rbl_c1_r100_0900_2 vp_c1_r100_0900_2 vdd sky130_fd_pr__pfet_01v8 L=0.15 W=2 nf=1 ad=0.58 as=0.58 pd=4.58 ps=4.58 nrd=0.145 nrs=0.145 sa=0 sb=0 sd=0 mult=1 m=1
XMNF_c1_r100_0900_2 vn_c1_r100_0900_2 en 0 0 sky130_fd_pr__nfet_01v8 L=0.15 W=2 nf=1 ad=0.58 as=0.58 pd=4.58 ps=4.58 nrd=0.145 nrs=0.145 sa=0 sb=0 sd=0 mult=1 m=1
XMPH_c1_r100_0900_2 vp_c1_r100_0900_2 enb vdd vdd sky130_fd_pr__pfet_01v8 L=0.15 W=4 nf=1 ad=1.16 as=1.16 pd=8.58 ps=8.58 nrd=0.0725 nrs=0.0725 sa=0 sb=0 sd=0 mult=1 m=1
bd_c1_r100_0900_2 d_c1_r100_0900_2 0 v=v(rbl_c1_r100_0900_2)-v(ref_c1_r100_0900_2)
bdabs_c1_r100_0900_2 dabs_c1_r100_0900_2 0 v=abs(v(rbl_c1_r100_0900_2)-v(ref_c1_r100_0900_2))

* ---- c1_r100_0900_3: cell1 SN = 0.9 V, ref offset 0.1 V, replica 3 ----
spa_c1_r100_0900_3 prea rbl_c1_r100_0900_3 ctl 0 swpre
XMWR_c1_r100_0900_3_0 sn_c1_r100_0900_3_0 0 0 0 sky130_fd_pr__nfet_01v8 L=0.15 W=0.42 nf=1 ad=0.1218 as=0.1218 pd=1.42 ps=1.42 nrd=0.69047619047619  nrs=0.69047619047619 sa=0 sb=0 sd=0 mult=1 m=1
XMRD_c1_r100_0900_3_0 rbl_c1_r100_0900_3 sn_c1_r100_0900_3_0 rwl_sel 0 sky130_fd_pr__nfet_01v8 L=0.15 W=0.42 nf=1 ad=0.1218 as=0.1218 pd=1.42 ps=1.42 nrd=0.69047619047619  nrs=0.69047619047619 sa=0 sb=0 sd=0 mult=1 m=1
csn_c1_r100_0900_3_0 sn_c1_r100_0900_3_0 0 {C_SN}
XMWR_c1_r100_0900_3_1 sn_c1_r100_0900_3_1 0 0 0 sky130_fd_pr__nfet_01v8 L=0.15 W=0.42 nf=1 ad=0.1218 as=0.1218 pd=1.42 ps=1.42 nrd=0.69047619047619  nrs=0.69047619047619 sa=0 sb=0 sd=0 mult=1 m=1
XMRD_c1_r100_0900_3_1 rbl_c1_r100_0900_3 sn_c1_r100_0900_3_1 rwl_des 0 sky130_fd_pr__nfet_01v8 L=0.15 W=0.42 nf=1 ad=0.1218 as=0.1218 pd=1.42 ps=1.42 nrd=0.69047619047619  nrs=0.69047619047619 sa=0 sb=0 sd=0 mult=1 m=1
csn_c1_r100_0900_3_1 sn_c1_r100_0900_3_1 0 {C_SN}
XMWR_c1_r100_0900_3_2 sn_c1_r100_0900_3_2 0 0 0 sky130_fd_pr__nfet_01v8 L=0.15 W=0.42 nf=1 ad=0.1218 as=0.1218 pd=1.42 ps=1.42 nrd=0.69047619047619  nrs=0.69047619047619 sa=0 sb=0 sd=0 mult=1 m=1
XMRD_c1_r100_0900_3_2 rbl_c1_r100_0900_3 sn_c1_r100_0900_3_2 rwl_des 0 sky130_fd_pr__nfet_01v8 L=0.15 W=0.42 nf=1 ad=0.1218 as=0.1218 pd=1.42 ps=1.42 nrd=0.69047619047619  nrs=0.69047619047619 sa=0 sb=0 sd=0 mult=1 m=1
csn_c1_r100_0900_3_2 sn_c1_r100_0900_3_2 0 {C_SN}
XMWR_c1_r100_0900_3_3 sn_c1_r100_0900_3_3 0 0 0 sky130_fd_pr__nfet_01v8 L=0.15 W=0.42 nf=1 ad=0.1218 as=0.1218 pd=1.42 ps=1.42 nrd=0.69047619047619  nrs=0.69047619047619 sa=0 sb=0 sd=0 mult=1 m=1
XMRD_c1_r100_0900_3_3 rbl_c1_r100_0900_3 sn_c1_r100_0900_3_3 rwl_des 0 sky130_fd_pr__nfet_01v8 L=0.15 W=0.42 nf=1 ad=0.1218 as=0.1218 pd=1.42 ps=1.42 nrd=0.69047619047619  nrs=0.69047619047619 sa=0 sb=0 sd=0 mult=1 m=1
csn_c1_r100_0900_3_3 sn_c1_r100_0900_3_3 0 {C_SN}
crbl_c1_r100_0900_3 rbl_c1_r100_0900_3 0 {C_RBL}
spr_c1_r100_0900_3 pref_100 ref_c1_r100_0900_3 ctl 0 swpre
cref_c1_r100_0900_3 ref_c1_r100_0900_3 0 {C_RBL}   $ ASSUMPTION: ideal matched dummy load
XMN1_c1_r100_0900_3 rbl_c1_r100_0900_3 ref_c1_r100_0900_3 vn_c1_r100_0900_3 0 sky130_fd_pr__nfet_01v8 L=0.15 W=1 nf=1 ad=0.29 as=0.29 pd=2.58 ps=2.58 nrd=0.29 nrs=0.29 sa=0 sb=0 sd=0 mult=1 m=1
XMN2_c1_r100_0900_3 ref_c1_r100_0900_3 rbl_c1_r100_0900_3 vn_c1_r100_0900_3 0 sky130_fd_pr__nfet_01v8 L=0.15 W=1 nf=1 ad=0.29 as=0.29 pd=2.58 ps=2.58 nrd=0.29 nrs=0.29 sa=0 sb=0 sd=0 mult=1 m=1
XMP1_c1_r100_0900_3 rbl_c1_r100_0900_3 ref_c1_r100_0900_3 vp_c1_r100_0900_3 vdd sky130_fd_pr__pfet_01v8 L=0.15 W=2 nf=1 ad=0.58 as=0.58 pd=4.58 ps=4.58 nrd=0.145 nrs=0.145 sa=0 sb=0 sd=0 mult=1 m=1
XMP2_c1_r100_0900_3 ref_c1_r100_0900_3 rbl_c1_r100_0900_3 vp_c1_r100_0900_3 vdd sky130_fd_pr__pfet_01v8 L=0.15 W=2 nf=1 ad=0.58 as=0.58 pd=4.58 ps=4.58 nrd=0.145 nrs=0.145 sa=0 sb=0 sd=0 mult=1 m=1
XMNF_c1_r100_0900_3 vn_c1_r100_0900_3 en 0 0 sky130_fd_pr__nfet_01v8 L=0.15 W=2 nf=1 ad=0.58 as=0.58 pd=4.58 ps=4.58 nrd=0.145 nrs=0.145 sa=0 sb=0 sd=0 mult=1 m=1
XMPH_c1_r100_0900_3 vp_c1_r100_0900_3 enb vdd vdd sky130_fd_pr__pfet_01v8 L=0.15 W=4 nf=1 ad=1.16 as=1.16 pd=8.58 ps=8.58 nrd=0.0725 nrs=0.0725 sa=0 sb=0 sd=0 mult=1 m=1
bd_c1_r100_0900_3 d_c1_r100_0900_3 0 v=v(rbl_c1_r100_0900_3)-v(ref_c1_r100_0900_3)
bdabs_c1_r100_0900_3 dabs_c1_r100_0900_3 0 v=abs(v(rbl_c1_r100_0900_3)-v(ref_c1_r100_0900_3))

* ---- c1_r100_0950_0: cell1 SN = 0.95 V, ref offset 0.1 V, replica 0 ----
spa_c1_r100_0950_0 prea rbl_c1_r100_0950_0 ctl 0 swpre
XMWR_c1_r100_0950_0_0 sn_c1_r100_0950_0_0 0 0 0 sky130_fd_pr__nfet_01v8 L=0.15 W=0.42 nf=1 ad=0.1218 as=0.1218 pd=1.42 ps=1.42 nrd=0.69047619047619  nrs=0.69047619047619 sa=0 sb=0 sd=0 mult=1 m=1
XMRD_c1_r100_0950_0_0 rbl_c1_r100_0950_0 sn_c1_r100_0950_0_0 rwl_sel 0 sky130_fd_pr__nfet_01v8 L=0.15 W=0.42 nf=1 ad=0.1218 as=0.1218 pd=1.42 ps=1.42 nrd=0.69047619047619  nrs=0.69047619047619 sa=0 sb=0 sd=0 mult=1 m=1
csn_c1_r100_0950_0_0 sn_c1_r100_0950_0_0 0 {C_SN}
XMWR_c1_r100_0950_0_1 sn_c1_r100_0950_0_1 0 0 0 sky130_fd_pr__nfet_01v8 L=0.15 W=0.42 nf=1 ad=0.1218 as=0.1218 pd=1.42 ps=1.42 nrd=0.69047619047619  nrs=0.69047619047619 sa=0 sb=0 sd=0 mult=1 m=1
XMRD_c1_r100_0950_0_1 rbl_c1_r100_0950_0 sn_c1_r100_0950_0_1 rwl_des 0 sky130_fd_pr__nfet_01v8 L=0.15 W=0.42 nf=1 ad=0.1218 as=0.1218 pd=1.42 ps=1.42 nrd=0.69047619047619  nrs=0.69047619047619 sa=0 sb=0 sd=0 mult=1 m=1
csn_c1_r100_0950_0_1 sn_c1_r100_0950_0_1 0 {C_SN}
XMWR_c1_r100_0950_0_2 sn_c1_r100_0950_0_2 0 0 0 sky130_fd_pr__nfet_01v8 L=0.15 W=0.42 nf=1 ad=0.1218 as=0.1218 pd=1.42 ps=1.42 nrd=0.69047619047619  nrs=0.69047619047619 sa=0 sb=0 sd=0 mult=1 m=1
XMRD_c1_r100_0950_0_2 rbl_c1_r100_0950_0 sn_c1_r100_0950_0_2 rwl_des 0 sky130_fd_pr__nfet_01v8 L=0.15 W=0.42 nf=1 ad=0.1218 as=0.1218 pd=1.42 ps=1.42 nrd=0.69047619047619  nrs=0.69047619047619 sa=0 sb=0 sd=0 mult=1 m=1
csn_c1_r100_0950_0_2 sn_c1_r100_0950_0_2 0 {C_SN}
XMWR_c1_r100_0950_0_3 sn_c1_r100_0950_0_3 0 0 0 sky130_fd_pr__nfet_01v8 L=0.15 W=0.42 nf=1 ad=0.1218 as=0.1218 pd=1.42 ps=1.42 nrd=0.69047619047619  nrs=0.69047619047619 sa=0 sb=0 sd=0 mult=1 m=1
XMRD_c1_r100_0950_0_3 rbl_c1_r100_0950_0 sn_c1_r100_0950_0_3 rwl_des 0 sky130_fd_pr__nfet_01v8 L=0.15 W=0.42 nf=1 ad=0.1218 as=0.1218 pd=1.42 ps=1.42 nrd=0.69047619047619  nrs=0.69047619047619 sa=0 sb=0 sd=0 mult=1 m=1
csn_c1_r100_0950_0_3 sn_c1_r100_0950_0_3 0 {C_SN}
crbl_c1_r100_0950_0 rbl_c1_r100_0950_0 0 {C_RBL}
spr_c1_r100_0950_0 pref_100 ref_c1_r100_0950_0 ctl 0 swpre
cref_c1_r100_0950_0 ref_c1_r100_0950_0 0 {C_RBL}   $ ASSUMPTION: ideal matched dummy load
XMN1_c1_r100_0950_0 rbl_c1_r100_0950_0 ref_c1_r100_0950_0 vn_c1_r100_0950_0 0 sky130_fd_pr__nfet_01v8 L=0.15 W=1 nf=1 ad=0.29 as=0.29 pd=2.58 ps=2.58 nrd=0.29 nrs=0.29 sa=0 sb=0 sd=0 mult=1 m=1
XMN2_c1_r100_0950_0 ref_c1_r100_0950_0 rbl_c1_r100_0950_0 vn_c1_r100_0950_0 0 sky130_fd_pr__nfet_01v8 L=0.15 W=1 nf=1 ad=0.29 as=0.29 pd=2.58 ps=2.58 nrd=0.29 nrs=0.29 sa=0 sb=0 sd=0 mult=1 m=1
XMP1_c1_r100_0950_0 rbl_c1_r100_0950_0 ref_c1_r100_0950_0 vp_c1_r100_0950_0 vdd sky130_fd_pr__pfet_01v8 L=0.15 W=2 nf=1 ad=0.58 as=0.58 pd=4.58 ps=4.58 nrd=0.145 nrs=0.145 sa=0 sb=0 sd=0 mult=1 m=1
XMP2_c1_r100_0950_0 ref_c1_r100_0950_0 rbl_c1_r100_0950_0 vp_c1_r100_0950_0 vdd sky130_fd_pr__pfet_01v8 L=0.15 W=2 nf=1 ad=0.58 as=0.58 pd=4.58 ps=4.58 nrd=0.145 nrs=0.145 sa=0 sb=0 sd=0 mult=1 m=1
XMNF_c1_r100_0950_0 vn_c1_r100_0950_0 en 0 0 sky130_fd_pr__nfet_01v8 L=0.15 W=2 nf=1 ad=0.58 as=0.58 pd=4.58 ps=4.58 nrd=0.145 nrs=0.145 sa=0 sb=0 sd=0 mult=1 m=1
XMPH_c1_r100_0950_0 vp_c1_r100_0950_0 enb vdd vdd sky130_fd_pr__pfet_01v8 L=0.15 W=4 nf=1 ad=1.16 as=1.16 pd=8.58 ps=8.58 nrd=0.0725 nrs=0.0725 sa=0 sb=0 sd=0 mult=1 m=1
bd_c1_r100_0950_0 d_c1_r100_0950_0 0 v=v(rbl_c1_r100_0950_0)-v(ref_c1_r100_0950_0)
bdabs_c1_r100_0950_0 dabs_c1_r100_0950_0 0 v=abs(v(rbl_c1_r100_0950_0)-v(ref_c1_r100_0950_0))

* ---- c1_r100_0950_1: cell1 SN = 0.95 V, ref offset 0.1 V, replica 1 ----
spa_c1_r100_0950_1 prea rbl_c1_r100_0950_1 ctl 0 swpre
XMWR_c1_r100_0950_1_0 sn_c1_r100_0950_1_0 0 0 0 sky130_fd_pr__nfet_01v8 L=0.15 W=0.42 nf=1 ad=0.1218 as=0.1218 pd=1.42 ps=1.42 nrd=0.69047619047619  nrs=0.69047619047619 sa=0 sb=0 sd=0 mult=1 m=1
XMRD_c1_r100_0950_1_0 rbl_c1_r100_0950_1 sn_c1_r100_0950_1_0 rwl_sel 0 sky130_fd_pr__nfet_01v8 L=0.15 W=0.42 nf=1 ad=0.1218 as=0.1218 pd=1.42 ps=1.42 nrd=0.69047619047619  nrs=0.69047619047619 sa=0 sb=0 sd=0 mult=1 m=1
csn_c1_r100_0950_1_0 sn_c1_r100_0950_1_0 0 {C_SN}
XMWR_c1_r100_0950_1_1 sn_c1_r100_0950_1_1 0 0 0 sky130_fd_pr__nfet_01v8 L=0.15 W=0.42 nf=1 ad=0.1218 as=0.1218 pd=1.42 ps=1.42 nrd=0.69047619047619  nrs=0.69047619047619 sa=0 sb=0 sd=0 mult=1 m=1
XMRD_c1_r100_0950_1_1 rbl_c1_r100_0950_1 sn_c1_r100_0950_1_1 rwl_des 0 sky130_fd_pr__nfet_01v8 L=0.15 W=0.42 nf=1 ad=0.1218 as=0.1218 pd=1.42 ps=1.42 nrd=0.69047619047619  nrs=0.69047619047619 sa=0 sb=0 sd=0 mult=1 m=1
csn_c1_r100_0950_1_1 sn_c1_r100_0950_1_1 0 {C_SN}
XMWR_c1_r100_0950_1_2 sn_c1_r100_0950_1_2 0 0 0 sky130_fd_pr__nfet_01v8 L=0.15 W=0.42 nf=1 ad=0.1218 as=0.1218 pd=1.42 ps=1.42 nrd=0.69047619047619  nrs=0.69047619047619 sa=0 sb=0 sd=0 mult=1 m=1
XMRD_c1_r100_0950_1_2 rbl_c1_r100_0950_1 sn_c1_r100_0950_1_2 rwl_des 0 sky130_fd_pr__nfet_01v8 L=0.15 W=0.42 nf=1 ad=0.1218 as=0.1218 pd=1.42 ps=1.42 nrd=0.69047619047619  nrs=0.69047619047619 sa=0 sb=0 sd=0 mult=1 m=1
csn_c1_r100_0950_1_2 sn_c1_r100_0950_1_2 0 {C_SN}
XMWR_c1_r100_0950_1_3 sn_c1_r100_0950_1_3 0 0 0 sky130_fd_pr__nfet_01v8 L=0.15 W=0.42 nf=1 ad=0.1218 as=0.1218 pd=1.42 ps=1.42 nrd=0.69047619047619  nrs=0.69047619047619 sa=0 sb=0 sd=0 mult=1 m=1
XMRD_c1_r100_0950_1_3 rbl_c1_r100_0950_1 sn_c1_r100_0950_1_3 rwl_des 0 sky130_fd_pr__nfet_01v8 L=0.15 W=0.42 nf=1 ad=0.1218 as=0.1218 pd=1.42 ps=1.42 nrd=0.69047619047619  nrs=0.69047619047619 sa=0 sb=0 sd=0 mult=1 m=1
csn_c1_r100_0950_1_3 sn_c1_r100_0950_1_3 0 {C_SN}
crbl_c1_r100_0950_1 rbl_c1_r100_0950_1 0 {C_RBL}
spr_c1_r100_0950_1 pref_100 ref_c1_r100_0950_1 ctl 0 swpre
cref_c1_r100_0950_1 ref_c1_r100_0950_1 0 {C_RBL}   $ ASSUMPTION: ideal matched dummy load
XMN1_c1_r100_0950_1 rbl_c1_r100_0950_1 ref_c1_r100_0950_1 vn_c1_r100_0950_1 0 sky130_fd_pr__nfet_01v8 L=0.15 W=1 nf=1 ad=0.29 as=0.29 pd=2.58 ps=2.58 nrd=0.29 nrs=0.29 sa=0 sb=0 sd=0 mult=1 m=1
XMN2_c1_r100_0950_1 ref_c1_r100_0950_1 rbl_c1_r100_0950_1 vn_c1_r100_0950_1 0 sky130_fd_pr__nfet_01v8 L=0.15 W=1 nf=1 ad=0.29 as=0.29 pd=2.58 ps=2.58 nrd=0.29 nrs=0.29 sa=0 sb=0 sd=0 mult=1 m=1
XMP1_c1_r100_0950_1 rbl_c1_r100_0950_1 ref_c1_r100_0950_1 vp_c1_r100_0950_1 vdd sky130_fd_pr__pfet_01v8 L=0.15 W=2 nf=1 ad=0.58 as=0.58 pd=4.58 ps=4.58 nrd=0.145 nrs=0.145 sa=0 sb=0 sd=0 mult=1 m=1
XMP2_c1_r100_0950_1 ref_c1_r100_0950_1 rbl_c1_r100_0950_1 vp_c1_r100_0950_1 vdd sky130_fd_pr__pfet_01v8 L=0.15 W=2 nf=1 ad=0.58 as=0.58 pd=4.58 ps=4.58 nrd=0.145 nrs=0.145 sa=0 sb=0 sd=0 mult=1 m=1
XMNF_c1_r100_0950_1 vn_c1_r100_0950_1 en 0 0 sky130_fd_pr__nfet_01v8 L=0.15 W=2 nf=1 ad=0.58 as=0.58 pd=4.58 ps=4.58 nrd=0.145 nrs=0.145 sa=0 sb=0 sd=0 mult=1 m=1
XMPH_c1_r100_0950_1 vp_c1_r100_0950_1 enb vdd vdd sky130_fd_pr__pfet_01v8 L=0.15 W=4 nf=1 ad=1.16 as=1.16 pd=8.58 ps=8.58 nrd=0.0725 nrs=0.0725 sa=0 sb=0 sd=0 mult=1 m=1
bd_c1_r100_0950_1 d_c1_r100_0950_1 0 v=v(rbl_c1_r100_0950_1)-v(ref_c1_r100_0950_1)
bdabs_c1_r100_0950_1 dabs_c1_r100_0950_1 0 v=abs(v(rbl_c1_r100_0950_1)-v(ref_c1_r100_0950_1))

* ---- c1_r100_0950_2: cell1 SN = 0.95 V, ref offset 0.1 V, replica 2 ----
spa_c1_r100_0950_2 prea rbl_c1_r100_0950_2 ctl 0 swpre
XMWR_c1_r100_0950_2_0 sn_c1_r100_0950_2_0 0 0 0 sky130_fd_pr__nfet_01v8 L=0.15 W=0.42 nf=1 ad=0.1218 as=0.1218 pd=1.42 ps=1.42 nrd=0.69047619047619  nrs=0.69047619047619 sa=0 sb=0 sd=0 mult=1 m=1
XMRD_c1_r100_0950_2_0 rbl_c1_r100_0950_2 sn_c1_r100_0950_2_0 rwl_sel 0 sky130_fd_pr__nfet_01v8 L=0.15 W=0.42 nf=1 ad=0.1218 as=0.1218 pd=1.42 ps=1.42 nrd=0.69047619047619  nrs=0.69047619047619 sa=0 sb=0 sd=0 mult=1 m=1
csn_c1_r100_0950_2_0 sn_c1_r100_0950_2_0 0 {C_SN}
XMWR_c1_r100_0950_2_1 sn_c1_r100_0950_2_1 0 0 0 sky130_fd_pr__nfet_01v8 L=0.15 W=0.42 nf=1 ad=0.1218 as=0.1218 pd=1.42 ps=1.42 nrd=0.69047619047619  nrs=0.69047619047619 sa=0 sb=0 sd=0 mult=1 m=1
XMRD_c1_r100_0950_2_1 rbl_c1_r100_0950_2 sn_c1_r100_0950_2_1 rwl_des 0 sky130_fd_pr__nfet_01v8 L=0.15 W=0.42 nf=1 ad=0.1218 as=0.1218 pd=1.42 ps=1.42 nrd=0.69047619047619  nrs=0.69047619047619 sa=0 sb=0 sd=0 mult=1 m=1
csn_c1_r100_0950_2_1 sn_c1_r100_0950_2_1 0 {C_SN}
XMWR_c1_r100_0950_2_2 sn_c1_r100_0950_2_2 0 0 0 sky130_fd_pr__nfet_01v8 L=0.15 W=0.42 nf=1 ad=0.1218 as=0.1218 pd=1.42 ps=1.42 nrd=0.69047619047619  nrs=0.69047619047619 sa=0 sb=0 sd=0 mult=1 m=1
XMRD_c1_r100_0950_2_2 rbl_c1_r100_0950_2 sn_c1_r100_0950_2_2 rwl_des 0 sky130_fd_pr__nfet_01v8 L=0.15 W=0.42 nf=1 ad=0.1218 as=0.1218 pd=1.42 ps=1.42 nrd=0.69047619047619  nrs=0.69047619047619 sa=0 sb=0 sd=0 mult=1 m=1
csn_c1_r100_0950_2_2 sn_c1_r100_0950_2_2 0 {C_SN}
XMWR_c1_r100_0950_2_3 sn_c1_r100_0950_2_3 0 0 0 sky130_fd_pr__nfet_01v8 L=0.15 W=0.42 nf=1 ad=0.1218 as=0.1218 pd=1.42 ps=1.42 nrd=0.69047619047619  nrs=0.69047619047619 sa=0 sb=0 sd=0 mult=1 m=1
XMRD_c1_r100_0950_2_3 rbl_c1_r100_0950_2 sn_c1_r100_0950_2_3 rwl_des 0 sky130_fd_pr__nfet_01v8 L=0.15 W=0.42 nf=1 ad=0.1218 as=0.1218 pd=1.42 ps=1.42 nrd=0.69047619047619  nrs=0.69047619047619 sa=0 sb=0 sd=0 mult=1 m=1
csn_c1_r100_0950_2_3 sn_c1_r100_0950_2_3 0 {C_SN}
crbl_c1_r100_0950_2 rbl_c1_r100_0950_2 0 {C_RBL}
spr_c1_r100_0950_2 pref_100 ref_c1_r100_0950_2 ctl 0 swpre
cref_c1_r100_0950_2 ref_c1_r100_0950_2 0 {C_RBL}   $ ASSUMPTION: ideal matched dummy load
XMN1_c1_r100_0950_2 rbl_c1_r100_0950_2 ref_c1_r100_0950_2 vn_c1_r100_0950_2 0 sky130_fd_pr__nfet_01v8 L=0.15 W=1 nf=1 ad=0.29 as=0.29 pd=2.58 ps=2.58 nrd=0.29 nrs=0.29 sa=0 sb=0 sd=0 mult=1 m=1
XMN2_c1_r100_0950_2 ref_c1_r100_0950_2 rbl_c1_r100_0950_2 vn_c1_r100_0950_2 0 sky130_fd_pr__nfet_01v8 L=0.15 W=1 nf=1 ad=0.29 as=0.29 pd=2.58 ps=2.58 nrd=0.29 nrs=0.29 sa=0 sb=0 sd=0 mult=1 m=1
XMP1_c1_r100_0950_2 rbl_c1_r100_0950_2 ref_c1_r100_0950_2 vp_c1_r100_0950_2 vdd sky130_fd_pr__pfet_01v8 L=0.15 W=2 nf=1 ad=0.58 as=0.58 pd=4.58 ps=4.58 nrd=0.145 nrs=0.145 sa=0 sb=0 sd=0 mult=1 m=1
XMP2_c1_r100_0950_2 ref_c1_r100_0950_2 rbl_c1_r100_0950_2 vp_c1_r100_0950_2 vdd sky130_fd_pr__pfet_01v8 L=0.15 W=2 nf=1 ad=0.58 as=0.58 pd=4.58 ps=4.58 nrd=0.145 nrs=0.145 sa=0 sb=0 sd=0 mult=1 m=1
XMNF_c1_r100_0950_2 vn_c1_r100_0950_2 en 0 0 sky130_fd_pr__nfet_01v8 L=0.15 W=2 nf=1 ad=0.58 as=0.58 pd=4.58 ps=4.58 nrd=0.145 nrs=0.145 sa=0 sb=0 sd=0 mult=1 m=1
XMPH_c1_r100_0950_2 vp_c1_r100_0950_2 enb vdd vdd sky130_fd_pr__pfet_01v8 L=0.15 W=4 nf=1 ad=1.16 as=1.16 pd=8.58 ps=8.58 nrd=0.0725 nrs=0.0725 sa=0 sb=0 sd=0 mult=1 m=1
bd_c1_r100_0950_2 d_c1_r100_0950_2 0 v=v(rbl_c1_r100_0950_2)-v(ref_c1_r100_0950_2)
bdabs_c1_r100_0950_2 dabs_c1_r100_0950_2 0 v=abs(v(rbl_c1_r100_0950_2)-v(ref_c1_r100_0950_2))

* ---- c1_r100_0950_3: cell1 SN = 0.95 V, ref offset 0.1 V, replica 3 ----
spa_c1_r100_0950_3 prea rbl_c1_r100_0950_3 ctl 0 swpre
XMWR_c1_r100_0950_3_0 sn_c1_r100_0950_3_0 0 0 0 sky130_fd_pr__nfet_01v8 L=0.15 W=0.42 nf=1 ad=0.1218 as=0.1218 pd=1.42 ps=1.42 nrd=0.69047619047619  nrs=0.69047619047619 sa=0 sb=0 sd=0 mult=1 m=1
XMRD_c1_r100_0950_3_0 rbl_c1_r100_0950_3 sn_c1_r100_0950_3_0 rwl_sel 0 sky130_fd_pr__nfet_01v8 L=0.15 W=0.42 nf=1 ad=0.1218 as=0.1218 pd=1.42 ps=1.42 nrd=0.69047619047619  nrs=0.69047619047619 sa=0 sb=0 sd=0 mult=1 m=1
csn_c1_r100_0950_3_0 sn_c1_r100_0950_3_0 0 {C_SN}
XMWR_c1_r100_0950_3_1 sn_c1_r100_0950_3_1 0 0 0 sky130_fd_pr__nfet_01v8 L=0.15 W=0.42 nf=1 ad=0.1218 as=0.1218 pd=1.42 ps=1.42 nrd=0.69047619047619  nrs=0.69047619047619 sa=0 sb=0 sd=0 mult=1 m=1
XMRD_c1_r100_0950_3_1 rbl_c1_r100_0950_3 sn_c1_r100_0950_3_1 rwl_des 0 sky130_fd_pr__nfet_01v8 L=0.15 W=0.42 nf=1 ad=0.1218 as=0.1218 pd=1.42 ps=1.42 nrd=0.69047619047619  nrs=0.69047619047619 sa=0 sb=0 sd=0 mult=1 m=1
csn_c1_r100_0950_3_1 sn_c1_r100_0950_3_1 0 {C_SN}
XMWR_c1_r100_0950_3_2 sn_c1_r100_0950_3_2 0 0 0 sky130_fd_pr__nfet_01v8 L=0.15 W=0.42 nf=1 ad=0.1218 as=0.1218 pd=1.42 ps=1.42 nrd=0.69047619047619  nrs=0.69047619047619 sa=0 sb=0 sd=0 mult=1 m=1
XMRD_c1_r100_0950_3_2 rbl_c1_r100_0950_3 sn_c1_r100_0950_3_2 rwl_des 0 sky130_fd_pr__nfet_01v8 L=0.15 W=0.42 nf=1 ad=0.1218 as=0.1218 pd=1.42 ps=1.42 nrd=0.69047619047619  nrs=0.69047619047619 sa=0 sb=0 sd=0 mult=1 m=1
csn_c1_r100_0950_3_2 sn_c1_r100_0950_3_2 0 {C_SN}
XMWR_c1_r100_0950_3_3 sn_c1_r100_0950_3_3 0 0 0 sky130_fd_pr__nfet_01v8 L=0.15 W=0.42 nf=1 ad=0.1218 as=0.1218 pd=1.42 ps=1.42 nrd=0.69047619047619  nrs=0.69047619047619 sa=0 sb=0 sd=0 mult=1 m=1
XMRD_c1_r100_0950_3_3 rbl_c1_r100_0950_3 sn_c1_r100_0950_3_3 rwl_des 0 sky130_fd_pr__nfet_01v8 L=0.15 W=0.42 nf=1 ad=0.1218 as=0.1218 pd=1.42 ps=1.42 nrd=0.69047619047619  nrs=0.69047619047619 sa=0 sb=0 sd=0 mult=1 m=1
csn_c1_r100_0950_3_3 sn_c1_r100_0950_3_3 0 {C_SN}
crbl_c1_r100_0950_3 rbl_c1_r100_0950_3 0 {C_RBL}
spr_c1_r100_0950_3 pref_100 ref_c1_r100_0950_3 ctl 0 swpre
cref_c1_r100_0950_3 ref_c1_r100_0950_3 0 {C_RBL}   $ ASSUMPTION: ideal matched dummy load
XMN1_c1_r100_0950_3 rbl_c1_r100_0950_3 ref_c1_r100_0950_3 vn_c1_r100_0950_3 0 sky130_fd_pr__nfet_01v8 L=0.15 W=1 nf=1 ad=0.29 as=0.29 pd=2.58 ps=2.58 nrd=0.29 nrs=0.29 sa=0 sb=0 sd=0 mult=1 m=1
XMN2_c1_r100_0950_3 ref_c1_r100_0950_3 rbl_c1_r100_0950_3 vn_c1_r100_0950_3 0 sky130_fd_pr__nfet_01v8 L=0.15 W=1 nf=1 ad=0.29 as=0.29 pd=2.58 ps=2.58 nrd=0.29 nrs=0.29 sa=0 sb=0 sd=0 mult=1 m=1
XMP1_c1_r100_0950_3 rbl_c1_r100_0950_3 ref_c1_r100_0950_3 vp_c1_r100_0950_3 vdd sky130_fd_pr__pfet_01v8 L=0.15 W=2 nf=1 ad=0.58 as=0.58 pd=4.58 ps=4.58 nrd=0.145 nrs=0.145 sa=0 sb=0 sd=0 mult=1 m=1
XMP2_c1_r100_0950_3 ref_c1_r100_0950_3 rbl_c1_r100_0950_3 vp_c1_r100_0950_3 vdd sky130_fd_pr__pfet_01v8 L=0.15 W=2 nf=1 ad=0.58 as=0.58 pd=4.58 ps=4.58 nrd=0.145 nrs=0.145 sa=0 sb=0 sd=0 mult=1 m=1
XMNF_c1_r100_0950_3 vn_c1_r100_0950_3 en 0 0 sky130_fd_pr__nfet_01v8 L=0.15 W=2 nf=1 ad=0.58 as=0.58 pd=4.58 ps=4.58 nrd=0.145 nrs=0.145 sa=0 sb=0 sd=0 mult=1 m=1
XMPH_c1_r100_0950_3 vp_c1_r100_0950_3 enb vdd vdd sky130_fd_pr__pfet_01v8 L=0.15 W=4 nf=1 ad=1.16 as=1.16 pd=8.58 ps=8.58 nrd=0.0725 nrs=0.0725 sa=0 sb=0 sd=0 mult=1 m=1
bd_c1_r100_0950_3 d_c1_r100_0950_3 0 v=v(rbl_c1_r100_0950_3)-v(ref_c1_r100_0950_3)
bdabs_c1_r100_0950_3 dabs_c1_r100_0950_3 0 v=abs(v(rbl_c1_r100_0950_3)-v(ref_c1_r100_0950_3))

* ---- c1_r100_1000_0: cell1 SN = 1.0 V, ref offset 0.1 V, replica 0 ----
spa_c1_r100_1000_0 prea rbl_c1_r100_1000_0 ctl 0 swpre
XMWR_c1_r100_1000_0_0 sn_c1_r100_1000_0_0 0 0 0 sky130_fd_pr__nfet_01v8 L=0.15 W=0.42 nf=1 ad=0.1218 as=0.1218 pd=1.42 ps=1.42 nrd=0.69047619047619  nrs=0.69047619047619 sa=0 sb=0 sd=0 mult=1 m=1
XMRD_c1_r100_1000_0_0 rbl_c1_r100_1000_0 sn_c1_r100_1000_0_0 rwl_sel 0 sky130_fd_pr__nfet_01v8 L=0.15 W=0.42 nf=1 ad=0.1218 as=0.1218 pd=1.42 ps=1.42 nrd=0.69047619047619  nrs=0.69047619047619 sa=0 sb=0 sd=0 mult=1 m=1
csn_c1_r100_1000_0_0 sn_c1_r100_1000_0_0 0 {C_SN}
XMWR_c1_r100_1000_0_1 sn_c1_r100_1000_0_1 0 0 0 sky130_fd_pr__nfet_01v8 L=0.15 W=0.42 nf=1 ad=0.1218 as=0.1218 pd=1.42 ps=1.42 nrd=0.69047619047619  nrs=0.69047619047619 sa=0 sb=0 sd=0 mult=1 m=1
XMRD_c1_r100_1000_0_1 rbl_c1_r100_1000_0 sn_c1_r100_1000_0_1 rwl_des 0 sky130_fd_pr__nfet_01v8 L=0.15 W=0.42 nf=1 ad=0.1218 as=0.1218 pd=1.42 ps=1.42 nrd=0.69047619047619  nrs=0.69047619047619 sa=0 sb=0 sd=0 mult=1 m=1
csn_c1_r100_1000_0_1 sn_c1_r100_1000_0_1 0 {C_SN}
XMWR_c1_r100_1000_0_2 sn_c1_r100_1000_0_2 0 0 0 sky130_fd_pr__nfet_01v8 L=0.15 W=0.42 nf=1 ad=0.1218 as=0.1218 pd=1.42 ps=1.42 nrd=0.69047619047619  nrs=0.69047619047619 sa=0 sb=0 sd=0 mult=1 m=1
XMRD_c1_r100_1000_0_2 rbl_c1_r100_1000_0 sn_c1_r100_1000_0_2 rwl_des 0 sky130_fd_pr__nfet_01v8 L=0.15 W=0.42 nf=1 ad=0.1218 as=0.1218 pd=1.42 ps=1.42 nrd=0.69047619047619  nrs=0.69047619047619 sa=0 sb=0 sd=0 mult=1 m=1
csn_c1_r100_1000_0_2 sn_c1_r100_1000_0_2 0 {C_SN}
XMWR_c1_r100_1000_0_3 sn_c1_r100_1000_0_3 0 0 0 sky130_fd_pr__nfet_01v8 L=0.15 W=0.42 nf=1 ad=0.1218 as=0.1218 pd=1.42 ps=1.42 nrd=0.69047619047619  nrs=0.69047619047619 sa=0 sb=0 sd=0 mult=1 m=1
XMRD_c1_r100_1000_0_3 rbl_c1_r100_1000_0 sn_c1_r100_1000_0_3 rwl_des 0 sky130_fd_pr__nfet_01v8 L=0.15 W=0.42 nf=1 ad=0.1218 as=0.1218 pd=1.42 ps=1.42 nrd=0.69047619047619  nrs=0.69047619047619 sa=0 sb=0 sd=0 mult=1 m=1
csn_c1_r100_1000_0_3 sn_c1_r100_1000_0_3 0 {C_SN}
crbl_c1_r100_1000_0 rbl_c1_r100_1000_0 0 {C_RBL}
spr_c1_r100_1000_0 pref_100 ref_c1_r100_1000_0 ctl 0 swpre
cref_c1_r100_1000_0 ref_c1_r100_1000_0 0 {C_RBL}   $ ASSUMPTION: ideal matched dummy load
XMN1_c1_r100_1000_0 rbl_c1_r100_1000_0 ref_c1_r100_1000_0 vn_c1_r100_1000_0 0 sky130_fd_pr__nfet_01v8 L=0.15 W=1 nf=1 ad=0.29 as=0.29 pd=2.58 ps=2.58 nrd=0.29 nrs=0.29 sa=0 sb=0 sd=0 mult=1 m=1
XMN2_c1_r100_1000_0 ref_c1_r100_1000_0 rbl_c1_r100_1000_0 vn_c1_r100_1000_0 0 sky130_fd_pr__nfet_01v8 L=0.15 W=1 nf=1 ad=0.29 as=0.29 pd=2.58 ps=2.58 nrd=0.29 nrs=0.29 sa=0 sb=0 sd=0 mult=1 m=1
XMP1_c1_r100_1000_0 rbl_c1_r100_1000_0 ref_c1_r100_1000_0 vp_c1_r100_1000_0 vdd sky130_fd_pr__pfet_01v8 L=0.15 W=2 nf=1 ad=0.58 as=0.58 pd=4.58 ps=4.58 nrd=0.145 nrs=0.145 sa=0 sb=0 sd=0 mult=1 m=1
XMP2_c1_r100_1000_0 ref_c1_r100_1000_0 rbl_c1_r100_1000_0 vp_c1_r100_1000_0 vdd sky130_fd_pr__pfet_01v8 L=0.15 W=2 nf=1 ad=0.58 as=0.58 pd=4.58 ps=4.58 nrd=0.145 nrs=0.145 sa=0 sb=0 sd=0 mult=1 m=1
XMNF_c1_r100_1000_0 vn_c1_r100_1000_0 en 0 0 sky130_fd_pr__nfet_01v8 L=0.15 W=2 nf=1 ad=0.58 as=0.58 pd=4.58 ps=4.58 nrd=0.145 nrs=0.145 sa=0 sb=0 sd=0 mult=1 m=1
XMPH_c1_r100_1000_0 vp_c1_r100_1000_0 enb vdd vdd sky130_fd_pr__pfet_01v8 L=0.15 W=4 nf=1 ad=1.16 as=1.16 pd=8.58 ps=8.58 nrd=0.0725 nrs=0.0725 sa=0 sb=0 sd=0 mult=1 m=1
bd_c1_r100_1000_0 d_c1_r100_1000_0 0 v=v(rbl_c1_r100_1000_0)-v(ref_c1_r100_1000_0)
bdabs_c1_r100_1000_0 dabs_c1_r100_1000_0 0 v=abs(v(rbl_c1_r100_1000_0)-v(ref_c1_r100_1000_0))

* ---- c1_r100_1000_1: cell1 SN = 1.0 V, ref offset 0.1 V, replica 1 ----
spa_c1_r100_1000_1 prea rbl_c1_r100_1000_1 ctl 0 swpre
XMWR_c1_r100_1000_1_0 sn_c1_r100_1000_1_0 0 0 0 sky130_fd_pr__nfet_01v8 L=0.15 W=0.42 nf=1 ad=0.1218 as=0.1218 pd=1.42 ps=1.42 nrd=0.69047619047619  nrs=0.69047619047619 sa=0 sb=0 sd=0 mult=1 m=1
XMRD_c1_r100_1000_1_0 rbl_c1_r100_1000_1 sn_c1_r100_1000_1_0 rwl_sel 0 sky130_fd_pr__nfet_01v8 L=0.15 W=0.42 nf=1 ad=0.1218 as=0.1218 pd=1.42 ps=1.42 nrd=0.69047619047619  nrs=0.69047619047619 sa=0 sb=0 sd=0 mult=1 m=1
csn_c1_r100_1000_1_0 sn_c1_r100_1000_1_0 0 {C_SN}
XMWR_c1_r100_1000_1_1 sn_c1_r100_1000_1_1 0 0 0 sky130_fd_pr__nfet_01v8 L=0.15 W=0.42 nf=1 ad=0.1218 as=0.1218 pd=1.42 ps=1.42 nrd=0.69047619047619  nrs=0.69047619047619 sa=0 sb=0 sd=0 mult=1 m=1
XMRD_c1_r100_1000_1_1 rbl_c1_r100_1000_1 sn_c1_r100_1000_1_1 rwl_des 0 sky130_fd_pr__nfet_01v8 L=0.15 W=0.42 nf=1 ad=0.1218 as=0.1218 pd=1.42 ps=1.42 nrd=0.69047619047619  nrs=0.69047619047619 sa=0 sb=0 sd=0 mult=1 m=1
csn_c1_r100_1000_1_1 sn_c1_r100_1000_1_1 0 {C_SN}
XMWR_c1_r100_1000_1_2 sn_c1_r100_1000_1_2 0 0 0 sky130_fd_pr__nfet_01v8 L=0.15 W=0.42 nf=1 ad=0.1218 as=0.1218 pd=1.42 ps=1.42 nrd=0.69047619047619  nrs=0.69047619047619 sa=0 sb=0 sd=0 mult=1 m=1
XMRD_c1_r100_1000_1_2 rbl_c1_r100_1000_1 sn_c1_r100_1000_1_2 rwl_des 0 sky130_fd_pr__nfet_01v8 L=0.15 W=0.42 nf=1 ad=0.1218 as=0.1218 pd=1.42 ps=1.42 nrd=0.69047619047619  nrs=0.69047619047619 sa=0 sb=0 sd=0 mult=1 m=1
csn_c1_r100_1000_1_2 sn_c1_r100_1000_1_2 0 {C_SN}
XMWR_c1_r100_1000_1_3 sn_c1_r100_1000_1_3 0 0 0 sky130_fd_pr__nfet_01v8 L=0.15 W=0.42 nf=1 ad=0.1218 as=0.1218 pd=1.42 ps=1.42 nrd=0.69047619047619  nrs=0.69047619047619 sa=0 sb=0 sd=0 mult=1 m=1
XMRD_c1_r100_1000_1_3 rbl_c1_r100_1000_1 sn_c1_r100_1000_1_3 rwl_des 0 sky130_fd_pr__nfet_01v8 L=0.15 W=0.42 nf=1 ad=0.1218 as=0.1218 pd=1.42 ps=1.42 nrd=0.69047619047619  nrs=0.69047619047619 sa=0 sb=0 sd=0 mult=1 m=1
csn_c1_r100_1000_1_3 sn_c1_r100_1000_1_3 0 {C_SN}
crbl_c1_r100_1000_1 rbl_c1_r100_1000_1 0 {C_RBL}
spr_c1_r100_1000_1 pref_100 ref_c1_r100_1000_1 ctl 0 swpre
cref_c1_r100_1000_1 ref_c1_r100_1000_1 0 {C_RBL}   $ ASSUMPTION: ideal matched dummy load
XMN1_c1_r100_1000_1 rbl_c1_r100_1000_1 ref_c1_r100_1000_1 vn_c1_r100_1000_1 0 sky130_fd_pr__nfet_01v8 L=0.15 W=1 nf=1 ad=0.29 as=0.29 pd=2.58 ps=2.58 nrd=0.29 nrs=0.29 sa=0 sb=0 sd=0 mult=1 m=1
XMN2_c1_r100_1000_1 ref_c1_r100_1000_1 rbl_c1_r100_1000_1 vn_c1_r100_1000_1 0 sky130_fd_pr__nfet_01v8 L=0.15 W=1 nf=1 ad=0.29 as=0.29 pd=2.58 ps=2.58 nrd=0.29 nrs=0.29 sa=0 sb=0 sd=0 mult=1 m=1
XMP1_c1_r100_1000_1 rbl_c1_r100_1000_1 ref_c1_r100_1000_1 vp_c1_r100_1000_1 vdd sky130_fd_pr__pfet_01v8 L=0.15 W=2 nf=1 ad=0.58 as=0.58 pd=4.58 ps=4.58 nrd=0.145 nrs=0.145 sa=0 sb=0 sd=0 mult=1 m=1
XMP2_c1_r100_1000_1 ref_c1_r100_1000_1 rbl_c1_r100_1000_1 vp_c1_r100_1000_1 vdd sky130_fd_pr__pfet_01v8 L=0.15 W=2 nf=1 ad=0.58 as=0.58 pd=4.58 ps=4.58 nrd=0.145 nrs=0.145 sa=0 sb=0 sd=0 mult=1 m=1
XMNF_c1_r100_1000_1 vn_c1_r100_1000_1 en 0 0 sky130_fd_pr__nfet_01v8 L=0.15 W=2 nf=1 ad=0.58 as=0.58 pd=4.58 ps=4.58 nrd=0.145 nrs=0.145 sa=0 sb=0 sd=0 mult=1 m=1
XMPH_c1_r100_1000_1 vp_c1_r100_1000_1 enb vdd vdd sky130_fd_pr__pfet_01v8 L=0.15 W=4 nf=1 ad=1.16 as=1.16 pd=8.58 ps=8.58 nrd=0.0725 nrs=0.0725 sa=0 sb=0 sd=0 mult=1 m=1
bd_c1_r100_1000_1 d_c1_r100_1000_1 0 v=v(rbl_c1_r100_1000_1)-v(ref_c1_r100_1000_1)
bdabs_c1_r100_1000_1 dabs_c1_r100_1000_1 0 v=abs(v(rbl_c1_r100_1000_1)-v(ref_c1_r100_1000_1))

* ---- c1_r100_1000_2: cell1 SN = 1.0 V, ref offset 0.1 V, replica 2 ----
spa_c1_r100_1000_2 prea rbl_c1_r100_1000_2 ctl 0 swpre
XMWR_c1_r100_1000_2_0 sn_c1_r100_1000_2_0 0 0 0 sky130_fd_pr__nfet_01v8 L=0.15 W=0.42 nf=1 ad=0.1218 as=0.1218 pd=1.42 ps=1.42 nrd=0.69047619047619  nrs=0.69047619047619 sa=0 sb=0 sd=0 mult=1 m=1
XMRD_c1_r100_1000_2_0 rbl_c1_r100_1000_2 sn_c1_r100_1000_2_0 rwl_sel 0 sky130_fd_pr__nfet_01v8 L=0.15 W=0.42 nf=1 ad=0.1218 as=0.1218 pd=1.42 ps=1.42 nrd=0.69047619047619  nrs=0.69047619047619 sa=0 sb=0 sd=0 mult=1 m=1
csn_c1_r100_1000_2_0 sn_c1_r100_1000_2_0 0 {C_SN}
XMWR_c1_r100_1000_2_1 sn_c1_r100_1000_2_1 0 0 0 sky130_fd_pr__nfet_01v8 L=0.15 W=0.42 nf=1 ad=0.1218 as=0.1218 pd=1.42 ps=1.42 nrd=0.69047619047619  nrs=0.69047619047619 sa=0 sb=0 sd=0 mult=1 m=1
XMRD_c1_r100_1000_2_1 rbl_c1_r100_1000_2 sn_c1_r100_1000_2_1 rwl_des 0 sky130_fd_pr__nfet_01v8 L=0.15 W=0.42 nf=1 ad=0.1218 as=0.1218 pd=1.42 ps=1.42 nrd=0.69047619047619  nrs=0.69047619047619 sa=0 sb=0 sd=0 mult=1 m=1
csn_c1_r100_1000_2_1 sn_c1_r100_1000_2_1 0 {C_SN}
XMWR_c1_r100_1000_2_2 sn_c1_r100_1000_2_2 0 0 0 sky130_fd_pr__nfet_01v8 L=0.15 W=0.42 nf=1 ad=0.1218 as=0.1218 pd=1.42 ps=1.42 nrd=0.69047619047619  nrs=0.69047619047619 sa=0 sb=0 sd=0 mult=1 m=1
XMRD_c1_r100_1000_2_2 rbl_c1_r100_1000_2 sn_c1_r100_1000_2_2 rwl_des 0 sky130_fd_pr__nfet_01v8 L=0.15 W=0.42 nf=1 ad=0.1218 as=0.1218 pd=1.42 ps=1.42 nrd=0.69047619047619  nrs=0.69047619047619 sa=0 sb=0 sd=0 mult=1 m=1
csn_c1_r100_1000_2_2 sn_c1_r100_1000_2_2 0 {C_SN}
XMWR_c1_r100_1000_2_3 sn_c1_r100_1000_2_3 0 0 0 sky130_fd_pr__nfet_01v8 L=0.15 W=0.42 nf=1 ad=0.1218 as=0.1218 pd=1.42 ps=1.42 nrd=0.69047619047619  nrs=0.69047619047619 sa=0 sb=0 sd=0 mult=1 m=1
XMRD_c1_r100_1000_2_3 rbl_c1_r100_1000_2 sn_c1_r100_1000_2_3 rwl_des 0 sky130_fd_pr__nfet_01v8 L=0.15 W=0.42 nf=1 ad=0.1218 as=0.1218 pd=1.42 ps=1.42 nrd=0.69047619047619  nrs=0.69047619047619 sa=0 sb=0 sd=0 mult=1 m=1
csn_c1_r100_1000_2_3 sn_c1_r100_1000_2_3 0 {C_SN}
crbl_c1_r100_1000_2 rbl_c1_r100_1000_2 0 {C_RBL}
spr_c1_r100_1000_2 pref_100 ref_c1_r100_1000_2 ctl 0 swpre
cref_c1_r100_1000_2 ref_c1_r100_1000_2 0 {C_RBL}   $ ASSUMPTION: ideal matched dummy load
XMN1_c1_r100_1000_2 rbl_c1_r100_1000_2 ref_c1_r100_1000_2 vn_c1_r100_1000_2 0 sky130_fd_pr__nfet_01v8 L=0.15 W=1 nf=1 ad=0.29 as=0.29 pd=2.58 ps=2.58 nrd=0.29 nrs=0.29 sa=0 sb=0 sd=0 mult=1 m=1
XMN2_c1_r100_1000_2 ref_c1_r100_1000_2 rbl_c1_r100_1000_2 vn_c1_r100_1000_2 0 sky130_fd_pr__nfet_01v8 L=0.15 W=1 nf=1 ad=0.29 as=0.29 pd=2.58 ps=2.58 nrd=0.29 nrs=0.29 sa=0 sb=0 sd=0 mult=1 m=1
XMP1_c1_r100_1000_2 rbl_c1_r100_1000_2 ref_c1_r100_1000_2 vp_c1_r100_1000_2 vdd sky130_fd_pr__pfet_01v8 L=0.15 W=2 nf=1 ad=0.58 as=0.58 pd=4.58 ps=4.58 nrd=0.145 nrs=0.145 sa=0 sb=0 sd=0 mult=1 m=1
XMP2_c1_r100_1000_2 ref_c1_r100_1000_2 rbl_c1_r100_1000_2 vp_c1_r100_1000_2 vdd sky130_fd_pr__pfet_01v8 L=0.15 W=2 nf=1 ad=0.58 as=0.58 pd=4.58 ps=4.58 nrd=0.145 nrs=0.145 sa=0 sb=0 sd=0 mult=1 m=1
XMNF_c1_r100_1000_2 vn_c1_r100_1000_2 en 0 0 sky130_fd_pr__nfet_01v8 L=0.15 W=2 nf=1 ad=0.58 as=0.58 pd=4.58 ps=4.58 nrd=0.145 nrs=0.145 sa=0 sb=0 sd=0 mult=1 m=1
XMPH_c1_r100_1000_2 vp_c1_r100_1000_2 enb vdd vdd sky130_fd_pr__pfet_01v8 L=0.15 W=4 nf=1 ad=1.16 as=1.16 pd=8.58 ps=8.58 nrd=0.0725 nrs=0.0725 sa=0 sb=0 sd=0 mult=1 m=1
bd_c1_r100_1000_2 d_c1_r100_1000_2 0 v=v(rbl_c1_r100_1000_2)-v(ref_c1_r100_1000_2)
bdabs_c1_r100_1000_2 dabs_c1_r100_1000_2 0 v=abs(v(rbl_c1_r100_1000_2)-v(ref_c1_r100_1000_2))

* ---- c1_r100_1000_3: cell1 SN = 1.0 V, ref offset 0.1 V, replica 3 ----
spa_c1_r100_1000_3 prea rbl_c1_r100_1000_3 ctl 0 swpre
XMWR_c1_r100_1000_3_0 sn_c1_r100_1000_3_0 0 0 0 sky130_fd_pr__nfet_01v8 L=0.15 W=0.42 nf=1 ad=0.1218 as=0.1218 pd=1.42 ps=1.42 nrd=0.69047619047619  nrs=0.69047619047619 sa=0 sb=0 sd=0 mult=1 m=1
XMRD_c1_r100_1000_3_0 rbl_c1_r100_1000_3 sn_c1_r100_1000_3_0 rwl_sel 0 sky130_fd_pr__nfet_01v8 L=0.15 W=0.42 nf=1 ad=0.1218 as=0.1218 pd=1.42 ps=1.42 nrd=0.69047619047619  nrs=0.69047619047619 sa=0 sb=0 sd=0 mult=1 m=1
csn_c1_r100_1000_3_0 sn_c1_r100_1000_3_0 0 {C_SN}
XMWR_c1_r100_1000_3_1 sn_c1_r100_1000_3_1 0 0 0 sky130_fd_pr__nfet_01v8 L=0.15 W=0.42 nf=1 ad=0.1218 as=0.1218 pd=1.42 ps=1.42 nrd=0.69047619047619  nrs=0.69047619047619 sa=0 sb=0 sd=0 mult=1 m=1
XMRD_c1_r100_1000_3_1 rbl_c1_r100_1000_3 sn_c1_r100_1000_3_1 rwl_des 0 sky130_fd_pr__nfet_01v8 L=0.15 W=0.42 nf=1 ad=0.1218 as=0.1218 pd=1.42 ps=1.42 nrd=0.69047619047619  nrs=0.69047619047619 sa=0 sb=0 sd=0 mult=1 m=1
csn_c1_r100_1000_3_1 sn_c1_r100_1000_3_1 0 {C_SN}
XMWR_c1_r100_1000_3_2 sn_c1_r100_1000_3_2 0 0 0 sky130_fd_pr__nfet_01v8 L=0.15 W=0.42 nf=1 ad=0.1218 as=0.1218 pd=1.42 ps=1.42 nrd=0.69047619047619  nrs=0.69047619047619 sa=0 sb=0 sd=0 mult=1 m=1
XMRD_c1_r100_1000_3_2 rbl_c1_r100_1000_3 sn_c1_r100_1000_3_2 rwl_des 0 sky130_fd_pr__nfet_01v8 L=0.15 W=0.42 nf=1 ad=0.1218 as=0.1218 pd=1.42 ps=1.42 nrd=0.69047619047619  nrs=0.69047619047619 sa=0 sb=0 sd=0 mult=1 m=1
csn_c1_r100_1000_3_2 sn_c1_r100_1000_3_2 0 {C_SN}
XMWR_c1_r100_1000_3_3 sn_c1_r100_1000_3_3 0 0 0 sky130_fd_pr__nfet_01v8 L=0.15 W=0.42 nf=1 ad=0.1218 as=0.1218 pd=1.42 ps=1.42 nrd=0.69047619047619  nrs=0.69047619047619 sa=0 sb=0 sd=0 mult=1 m=1
XMRD_c1_r100_1000_3_3 rbl_c1_r100_1000_3 sn_c1_r100_1000_3_3 rwl_des 0 sky130_fd_pr__nfet_01v8 L=0.15 W=0.42 nf=1 ad=0.1218 as=0.1218 pd=1.42 ps=1.42 nrd=0.69047619047619  nrs=0.69047619047619 sa=0 sb=0 sd=0 mult=1 m=1
csn_c1_r100_1000_3_3 sn_c1_r100_1000_3_3 0 {C_SN}
crbl_c1_r100_1000_3 rbl_c1_r100_1000_3 0 {C_RBL}
spr_c1_r100_1000_3 pref_100 ref_c1_r100_1000_3 ctl 0 swpre
cref_c1_r100_1000_3 ref_c1_r100_1000_3 0 {C_RBL}   $ ASSUMPTION: ideal matched dummy load
XMN1_c1_r100_1000_3 rbl_c1_r100_1000_3 ref_c1_r100_1000_3 vn_c1_r100_1000_3 0 sky130_fd_pr__nfet_01v8 L=0.15 W=1 nf=1 ad=0.29 as=0.29 pd=2.58 ps=2.58 nrd=0.29 nrs=0.29 sa=0 sb=0 sd=0 mult=1 m=1
XMN2_c1_r100_1000_3 ref_c1_r100_1000_3 rbl_c1_r100_1000_3 vn_c1_r100_1000_3 0 sky130_fd_pr__nfet_01v8 L=0.15 W=1 nf=1 ad=0.29 as=0.29 pd=2.58 ps=2.58 nrd=0.29 nrs=0.29 sa=0 sb=0 sd=0 mult=1 m=1
XMP1_c1_r100_1000_3 rbl_c1_r100_1000_3 ref_c1_r100_1000_3 vp_c1_r100_1000_3 vdd sky130_fd_pr__pfet_01v8 L=0.15 W=2 nf=1 ad=0.58 as=0.58 pd=4.58 ps=4.58 nrd=0.145 nrs=0.145 sa=0 sb=0 sd=0 mult=1 m=1
XMP2_c1_r100_1000_3 ref_c1_r100_1000_3 rbl_c1_r100_1000_3 vp_c1_r100_1000_3 vdd sky130_fd_pr__pfet_01v8 L=0.15 W=2 nf=1 ad=0.58 as=0.58 pd=4.58 ps=4.58 nrd=0.145 nrs=0.145 sa=0 sb=0 sd=0 mult=1 m=1
XMNF_c1_r100_1000_3 vn_c1_r100_1000_3 en 0 0 sky130_fd_pr__nfet_01v8 L=0.15 W=2 nf=1 ad=0.58 as=0.58 pd=4.58 ps=4.58 nrd=0.145 nrs=0.145 sa=0 sb=0 sd=0 mult=1 m=1
XMPH_c1_r100_1000_3 vp_c1_r100_1000_3 enb vdd vdd sky130_fd_pr__pfet_01v8 L=0.15 W=4 nf=1 ad=1.16 as=1.16 pd=8.58 ps=8.58 nrd=0.0725 nrs=0.0725 sa=0 sb=0 sd=0 mult=1 m=1
bd_c1_r100_1000_3 d_c1_r100_1000_3 0 v=v(rbl_c1_r100_1000_3)-v(ref_c1_r100_1000_3)
bdabs_c1_r100_1000_3 dabs_c1_r100_1000_3 0 v=abs(v(rbl_c1_r100_1000_3)-v(ref_c1_r100_1000_3))

* initial conditions (tran uic): precharged rails, stored levels, tail nodes
.ic v(rbl_c0_r050_0000_0)=0.9 v(sn_c0_r050_0000_0_0)=0 v(sn_c0_r050_0000_0_1)=0 v(sn_c0_r050_0000_0_2)=0 v(sn_c0_r050_0000_0_3)=0 v(ref_c0_r050_0000_0)=0.850000
.ic v(vn_c0_r050_0000_0)=0.45 v(vp_c0_r050_0000_0)=1.35 v(rbl_c0_r050_0000_1)=0.9 v(sn_c0_r050_0000_1_0)=0 v(sn_c0_r050_0000_1_1)=0 v(sn_c0_r050_0000_1_2)=0
.ic v(sn_c0_r050_0000_1_3)=0 v(ref_c0_r050_0000_1)=0.850000 v(vn_c0_r050_0000_1)=0.45 v(vp_c0_r050_0000_1)=1.35 v(rbl_c0_r050_0000_2)=0.9 v(sn_c0_r050_0000_2_0)=0
.ic v(sn_c0_r050_0000_2_1)=0 v(sn_c0_r050_0000_2_2)=0 v(sn_c0_r050_0000_2_3)=0 v(ref_c0_r050_0000_2)=0.850000 v(vn_c0_r050_0000_2)=0.45 v(vp_c0_r050_0000_2)=1.35
.ic v(rbl_c0_r050_0000_3)=0.9 v(sn_c0_r050_0000_3_0)=0 v(sn_c0_r050_0000_3_1)=0 v(sn_c0_r050_0000_3_2)=0 v(sn_c0_r050_0000_3_3)=0 v(ref_c0_r050_0000_3)=0.850000
.ic v(vn_c0_r050_0000_3)=0.45 v(vp_c0_r050_0000_3)=1.35 v(rbl_c1_r050_0600_0)=0.9 v(sn_c1_r050_0600_0_0)=0.6 v(sn_c1_r050_0600_0_1)=0.6 v(sn_c1_r050_0600_0_2)=0.6
.ic v(sn_c1_r050_0600_0_3)=0.6 v(ref_c1_r050_0600_0)=0.850000 v(vn_c1_r050_0600_0)=0.45 v(vp_c1_r050_0600_0)=1.35 v(rbl_c1_r050_0600_1)=0.9 v(sn_c1_r050_0600_1_0)=0.6
.ic v(sn_c1_r050_0600_1_1)=0.6 v(sn_c1_r050_0600_1_2)=0.6 v(sn_c1_r050_0600_1_3)=0.6 v(ref_c1_r050_0600_1)=0.850000 v(vn_c1_r050_0600_1)=0.45 v(vp_c1_r050_0600_1)=1.35
.ic v(rbl_c1_r050_0600_2)=0.9 v(sn_c1_r050_0600_2_0)=0.6 v(sn_c1_r050_0600_2_1)=0.6 v(sn_c1_r050_0600_2_2)=0.6 v(sn_c1_r050_0600_2_3)=0.6 v(ref_c1_r050_0600_2)=0.850000
.ic v(vn_c1_r050_0600_2)=0.45 v(vp_c1_r050_0600_2)=1.35 v(rbl_c1_r050_0600_3)=0.9 v(sn_c1_r050_0600_3_0)=0.6 v(sn_c1_r050_0600_3_1)=0.6 v(sn_c1_r050_0600_3_2)=0.6
.ic v(sn_c1_r050_0600_3_3)=0.6 v(ref_c1_r050_0600_3)=0.850000 v(vn_c1_r050_0600_3)=0.45 v(vp_c1_r050_0600_3)=1.35 v(rbl_c1_r050_0650_0)=0.9 v(sn_c1_r050_0650_0_0)=0.65
.ic v(sn_c1_r050_0650_0_1)=0.65 v(sn_c1_r050_0650_0_2)=0.65 v(sn_c1_r050_0650_0_3)=0.65 v(ref_c1_r050_0650_0)=0.850000 v(vn_c1_r050_0650_0)=0.45 v(vp_c1_r050_0650_0)=1.35
.ic v(rbl_c1_r050_0650_1)=0.9 v(sn_c1_r050_0650_1_0)=0.65 v(sn_c1_r050_0650_1_1)=0.65 v(sn_c1_r050_0650_1_2)=0.65 v(sn_c1_r050_0650_1_3)=0.65 v(ref_c1_r050_0650_1)=0.850000
.ic v(vn_c1_r050_0650_1)=0.45 v(vp_c1_r050_0650_1)=1.35 v(rbl_c1_r050_0650_2)=0.9 v(sn_c1_r050_0650_2_0)=0.65 v(sn_c1_r050_0650_2_1)=0.65 v(sn_c1_r050_0650_2_2)=0.65
.ic v(sn_c1_r050_0650_2_3)=0.65 v(ref_c1_r050_0650_2)=0.850000 v(vn_c1_r050_0650_2)=0.45 v(vp_c1_r050_0650_2)=1.35 v(rbl_c1_r050_0650_3)=0.9 v(sn_c1_r050_0650_3_0)=0.65
.ic v(sn_c1_r050_0650_3_1)=0.65 v(sn_c1_r050_0650_3_2)=0.65 v(sn_c1_r050_0650_3_3)=0.65 v(ref_c1_r050_0650_3)=0.850000 v(vn_c1_r050_0650_3)=0.45 v(vp_c1_r050_0650_3)=1.35
.ic v(rbl_c1_r050_0700_0)=0.9 v(sn_c1_r050_0700_0_0)=0.7 v(sn_c1_r050_0700_0_1)=0.7 v(sn_c1_r050_0700_0_2)=0.7 v(sn_c1_r050_0700_0_3)=0.7 v(ref_c1_r050_0700_0)=0.850000
.ic v(vn_c1_r050_0700_0)=0.45 v(vp_c1_r050_0700_0)=1.35 v(rbl_c1_r050_0700_1)=0.9 v(sn_c1_r050_0700_1_0)=0.7 v(sn_c1_r050_0700_1_1)=0.7 v(sn_c1_r050_0700_1_2)=0.7
.ic v(sn_c1_r050_0700_1_3)=0.7 v(ref_c1_r050_0700_1)=0.850000 v(vn_c1_r050_0700_1)=0.45 v(vp_c1_r050_0700_1)=1.35 v(rbl_c1_r050_0700_2)=0.9 v(sn_c1_r050_0700_2_0)=0.7
.ic v(sn_c1_r050_0700_2_1)=0.7 v(sn_c1_r050_0700_2_2)=0.7 v(sn_c1_r050_0700_2_3)=0.7 v(ref_c1_r050_0700_2)=0.850000 v(vn_c1_r050_0700_2)=0.45 v(vp_c1_r050_0700_2)=1.35
.ic v(rbl_c1_r050_0700_3)=0.9 v(sn_c1_r050_0700_3_0)=0.7 v(sn_c1_r050_0700_3_1)=0.7 v(sn_c1_r050_0700_3_2)=0.7 v(sn_c1_r050_0700_3_3)=0.7 v(ref_c1_r050_0700_3)=0.850000
.ic v(vn_c1_r050_0700_3)=0.45 v(vp_c1_r050_0700_3)=1.35 v(rbl_c1_r050_0750_0)=0.9 v(sn_c1_r050_0750_0_0)=0.75 v(sn_c1_r050_0750_0_1)=0.75 v(sn_c1_r050_0750_0_2)=0.75
.ic v(sn_c1_r050_0750_0_3)=0.75 v(ref_c1_r050_0750_0)=0.850000 v(vn_c1_r050_0750_0)=0.45 v(vp_c1_r050_0750_0)=1.35 v(rbl_c1_r050_0750_1)=0.9 v(sn_c1_r050_0750_1_0)=0.75
.ic v(sn_c1_r050_0750_1_1)=0.75 v(sn_c1_r050_0750_1_2)=0.75 v(sn_c1_r050_0750_1_3)=0.75 v(ref_c1_r050_0750_1)=0.850000 v(vn_c1_r050_0750_1)=0.45 v(vp_c1_r050_0750_1)=1.35
.ic v(rbl_c1_r050_0750_2)=0.9 v(sn_c1_r050_0750_2_0)=0.75 v(sn_c1_r050_0750_2_1)=0.75 v(sn_c1_r050_0750_2_2)=0.75 v(sn_c1_r050_0750_2_3)=0.75 v(ref_c1_r050_0750_2)=0.850000
.ic v(vn_c1_r050_0750_2)=0.45 v(vp_c1_r050_0750_2)=1.35 v(rbl_c1_r050_0750_3)=0.9 v(sn_c1_r050_0750_3_0)=0.75 v(sn_c1_r050_0750_3_1)=0.75 v(sn_c1_r050_0750_3_2)=0.75
.ic v(sn_c1_r050_0750_3_3)=0.75 v(ref_c1_r050_0750_3)=0.850000 v(vn_c1_r050_0750_3)=0.45 v(vp_c1_r050_0750_3)=1.35 v(rbl_c1_r050_0800_0)=0.9 v(sn_c1_r050_0800_0_0)=0.8
.ic v(sn_c1_r050_0800_0_1)=0.8 v(sn_c1_r050_0800_0_2)=0.8 v(sn_c1_r050_0800_0_3)=0.8 v(ref_c1_r050_0800_0)=0.850000 v(vn_c1_r050_0800_0)=0.45 v(vp_c1_r050_0800_0)=1.35
.ic v(rbl_c1_r050_0800_1)=0.9 v(sn_c1_r050_0800_1_0)=0.8 v(sn_c1_r050_0800_1_1)=0.8 v(sn_c1_r050_0800_1_2)=0.8 v(sn_c1_r050_0800_1_3)=0.8 v(ref_c1_r050_0800_1)=0.850000
.ic v(vn_c1_r050_0800_1)=0.45 v(vp_c1_r050_0800_1)=1.35 v(rbl_c1_r050_0800_2)=0.9 v(sn_c1_r050_0800_2_0)=0.8 v(sn_c1_r050_0800_2_1)=0.8 v(sn_c1_r050_0800_2_2)=0.8
.ic v(sn_c1_r050_0800_2_3)=0.8 v(ref_c1_r050_0800_2)=0.850000 v(vn_c1_r050_0800_2)=0.45 v(vp_c1_r050_0800_2)=1.35 v(rbl_c1_r050_0800_3)=0.9 v(sn_c1_r050_0800_3_0)=0.8
.ic v(sn_c1_r050_0800_3_1)=0.8 v(sn_c1_r050_0800_3_2)=0.8 v(sn_c1_r050_0800_3_3)=0.8 v(ref_c1_r050_0800_3)=0.850000 v(vn_c1_r050_0800_3)=0.45 v(vp_c1_r050_0800_3)=1.35
.ic v(rbl_c1_r050_0850_0)=0.9 v(sn_c1_r050_0850_0_0)=0.85 v(sn_c1_r050_0850_0_1)=0.85 v(sn_c1_r050_0850_0_2)=0.85 v(sn_c1_r050_0850_0_3)=0.85 v(ref_c1_r050_0850_0)=0.850000
.ic v(vn_c1_r050_0850_0)=0.45 v(vp_c1_r050_0850_0)=1.35 v(rbl_c1_r050_0850_1)=0.9 v(sn_c1_r050_0850_1_0)=0.85 v(sn_c1_r050_0850_1_1)=0.85 v(sn_c1_r050_0850_1_2)=0.85
.ic v(sn_c1_r050_0850_1_3)=0.85 v(ref_c1_r050_0850_1)=0.850000 v(vn_c1_r050_0850_1)=0.45 v(vp_c1_r050_0850_1)=1.35 v(rbl_c1_r050_0850_2)=0.9 v(sn_c1_r050_0850_2_0)=0.85
.ic v(sn_c1_r050_0850_2_1)=0.85 v(sn_c1_r050_0850_2_2)=0.85 v(sn_c1_r050_0850_2_3)=0.85 v(ref_c1_r050_0850_2)=0.850000 v(vn_c1_r050_0850_2)=0.45 v(vp_c1_r050_0850_2)=1.35
.ic v(rbl_c1_r050_0850_3)=0.9 v(sn_c1_r050_0850_3_0)=0.85 v(sn_c1_r050_0850_3_1)=0.85 v(sn_c1_r050_0850_3_2)=0.85 v(sn_c1_r050_0850_3_3)=0.85 v(ref_c1_r050_0850_3)=0.850000
.ic v(vn_c1_r050_0850_3)=0.45 v(vp_c1_r050_0850_3)=1.35 v(rbl_c1_r050_0900_0)=0.9 v(sn_c1_r050_0900_0_0)=0.9 v(sn_c1_r050_0900_0_1)=0.9 v(sn_c1_r050_0900_0_2)=0.9
.ic v(sn_c1_r050_0900_0_3)=0.9 v(ref_c1_r050_0900_0)=0.850000 v(vn_c1_r050_0900_0)=0.45 v(vp_c1_r050_0900_0)=1.35 v(rbl_c1_r050_0900_1)=0.9 v(sn_c1_r050_0900_1_0)=0.9
.ic v(sn_c1_r050_0900_1_1)=0.9 v(sn_c1_r050_0900_1_2)=0.9 v(sn_c1_r050_0900_1_3)=0.9 v(ref_c1_r050_0900_1)=0.850000 v(vn_c1_r050_0900_1)=0.45 v(vp_c1_r050_0900_1)=1.35
.ic v(rbl_c1_r050_0900_2)=0.9 v(sn_c1_r050_0900_2_0)=0.9 v(sn_c1_r050_0900_2_1)=0.9 v(sn_c1_r050_0900_2_2)=0.9 v(sn_c1_r050_0900_2_3)=0.9 v(ref_c1_r050_0900_2)=0.850000
.ic v(vn_c1_r050_0900_2)=0.45 v(vp_c1_r050_0900_2)=1.35 v(rbl_c1_r050_0900_3)=0.9 v(sn_c1_r050_0900_3_0)=0.9 v(sn_c1_r050_0900_3_1)=0.9 v(sn_c1_r050_0900_3_2)=0.9
.ic v(sn_c1_r050_0900_3_3)=0.9 v(ref_c1_r050_0900_3)=0.850000 v(vn_c1_r050_0900_3)=0.45 v(vp_c1_r050_0900_3)=1.35 v(rbl_c1_r050_0950_0)=0.9 v(sn_c1_r050_0950_0_0)=0.95
.ic v(sn_c1_r050_0950_0_1)=0.95 v(sn_c1_r050_0950_0_2)=0.95 v(sn_c1_r050_0950_0_3)=0.95 v(ref_c1_r050_0950_0)=0.850000 v(vn_c1_r050_0950_0)=0.45 v(vp_c1_r050_0950_0)=1.35
.ic v(rbl_c1_r050_0950_1)=0.9 v(sn_c1_r050_0950_1_0)=0.95 v(sn_c1_r050_0950_1_1)=0.95 v(sn_c1_r050_0950_1_2)=0.95 v(sn_c1_r050_0950_1_3)=0.95 v(ref_c1_r050_0950_1)=0.850000
.ic v(vn_c1_r050_0950_1)=0.45 v(vp_c1_r050_0950_1)=1.35 v(rbl_c1_r050_0950_2)=0.9 v(sn_c1_r050_0950_2_0)=0.95 v(sn_c1_r050_0950_2_1)=0.95 v(sn_c1_r050_0950_2_2)=0.95
.ic v(sn_c1_r050_0950_2_3)=0.95 v(ref_c1_r050_0950_2)=0.850000 v(vn_c1_r050_0950_2)=0.45 v(vp_c1_r050_0950_2)=1.35 v(rbl_c1_r050_0950_3)=0.9 v(sn_c1_r050_0950_3_0)=0.95
.ic v(sn_c1_r050_0950_3_1)=0.95 v(sn_c1_r050_0950_3_2)=0.95 v(sn_c1_r050_0950_3_3)=0.95 v(ref_c1_r050_0950_3)=0.850000 v(vn_c1_r050_0950_3)=0.45 v(vp_c1_r050_0950_3)=1.35
.ic v(rbl_c1_r050_1000_0)=0.9 v(sn_c1_r050_1000_0_0)=1 v(sn_c1_r050_1000_0_1)=1 v(sn_c1_r050_1000_0_2)=1 v(sn_c1_r050_1000_0_3)=1 v(ref_c1_r050_1000_0)=0.850000
.ic v(vn_c1_r050_1000_0)=0.45 v(vp_c1_r050_1000_0)=1.35 v(rbl_c1_r050_1000_1)=0.9 v(sn_c1_r050_1000_1_0)=1 v(sn_c1_r050_1000_1_1)=1 v(sn_c1_r050_1000_1_2)=1
.ic v(sn_c1_r050_1000_1_3)=1 v(ref_c1_r050_1000_1)=0.850000 v(vn_c1_r050_1000_1)=0.45 v(vp_c1_r050_1000_1)=1.35 v(rbl_c1_r050_1000_2)=0.9 v(sn_c1_r050_1000_2_0)=1
.ic v(sn_c1_r050_1000_2_1)=1 v(sn_c1_r050_1000_2_2)=1 v(sn_c1_r050_1000_2_3)=1 v(ref_c1_r050_1000_2)=0.850000 v(vn_c1_r050_1000_2)=0.45 v(vp_c1_r050_1000_2)=1.35
.ic v(rbl_c1_r050_1000_3)=0.9 v(sn_c1_r050_1000_3_0)=1 v(sn_c1_r050_1000_3_1)=1 v(sn_c1_r050_1000_3_2)=1 v(sn_c1_r050_1000_3_3)=1 v(ref_c1_r050_1000_3)=0.850000
.ic v(vn_c1_r050_1000_3)=0.45 v(vp_c1_r050_1000_3)=1.35 v(rbl_c0_r100_0000_0)=0.9 v(sn_c0_r100_0000_0_0)=0 v(sn_c0_r100_0000_0_1)=0 v(sn_c0_r100_0000_0_2)=0
.ic v(sn_c0_r100_0000_0_3)=0 v(ref_c0_r100_0000_0)=0.800000 v(vn_c0_r100_0000_0)=0.45 v(vp_c0_r100_0000_0)=1.35 v(rbl_c0_r100_0000_1)=0.9 v(sn_c0_r100_0000_1_0)=0
.ic v(sn_c0_r100_0000_1_1)=0 v(sn_c0_r100_0000_1_2)=0 v(sn_c0_r100_0000_1_3)=0 v(ref_c0_r100_0000_1)=0.800000 v(vn_c0_r100_0000_1)=0.45 v(vp_c0_r100_0000_1)=1.35
.ic v(rbl_c0_r100_0000_2)=0.9 v(sn_c0_r100_0000_2_0)=0 v(sn_c0_r100_0000_2_1)=0 v(sn_c0_r100_0000_2_2)=0 v(sn_c0_r100_0000_2_3)=0 v(ref_c0_r100_0000_2)=0.800000
.ic v(vn_c0_r100_0000_2)=0.45 v(vp_c0_r100_0000_2)=1.35 v(rbl_c0_r100_0000_3)=0.9 v(sn_c0_r100_0000_3_0)=0 v(sn_c0_r100_0000_3_1)=0 v(sn_c0_r100_0000_3_2)=0
.ic v(sn_c0_r100_0000_3_3)=0 v(ref_c0_r100_0000_3)=0.800000 v(vn_c0_r100_0000_3)=0.45 v(vp_c0_r100_0000_3)=1.35 v(rbl_c1_r100_0600_0)=0.9 v(sn_c1_r100_0600_0_0)=0.6
.ic v(sn_c1_r100_0600_0_1)=0.6 v(sn_c1_r100_0600_0_2)=0.6 v(sn_c1_r100_0600_0_3)=0.6 v(ref_c1_r100_0600_0)=0.800000 v(vn_c1_r100_0600_0)=0.45 v(vp_c1_r100_0600_0)=1.35
.ic v(rbl_c1_r100_0600_1)=0.9 v(sn_c1_r100_0600_1_0)=0.6 v(sn_c1_r100_0600_1_1)=0.6 v(sn_c1_r100_0600_1_2)=0.6 v(sn_c1_r100_0600_1_3)=0.6 v(ref_c1_r100_0600_1)=0.800000
.ic v(vn_c1_r100_0600_1)=0.45 v(vp_c1_r100_0600_1)=1.35 v(rbl_c1_r100_0600_2)=0.9 v(sn_c1_r100_0600_2_0)=0.6 v(sn_c1_r100_0600_2_1)=0.6 v(sn_c1_r100_0600_2_2)=0.6
.ic v(sn_c1_r100_0600_2_3)=0.6 v(ref_c1_r100_0600_2)=0.800000 v(vn_c1_r100_0600_2)=0.45 v(vp_c1_r100_0600_2)=1.35 v(rbl_c1_r100_0600_3)=0.9 v(sn_c1_r100_0600_3_0)=0.6
.ic v(sn_c1_r100_0600_3_1)=0.6 v(sn_c1_r100_0600_3_2)=0.6 v(sn_c1_r100_0600_3_3)=0.6 v(ref_c1_r100_0600_3)=0.800000 v(vn_c1_r100_0600_3)=0.45 v(vp_c1_r100_0600_3)=1.35
.ic v(rbl_c1_r100_0650_0)=0.9 v(sn_c1_r100_0650_0_0)=0.65 v(sn_c1_r100_0650_0_1)=0.65 v(sn_c1_r100_0650_0_2)=0.65 v(sn_c1_r100_0650_0_3)=0.65 v(ref_c1_r100_0650_0)=0.800000
.ic v(vn_c1_r100_0650_0)=0.45 v(vp_c1_r100_0650_0)=1.35 v(rbl_c1_r100_0650_1)=0.9 v(sn_c1_r100_0650_1_0)=0.65 v(sn_c1_r100_0650_1_1)=0.65 v(sn_c1_r100_0650_1_2)=0.65
.ic v(sn_c1_r100_0650_1_3)=0.65 v(ref_c1_r100_0650_1)=0.800000 v(vn_c1_r100_0650_1)=0.45 v(vp_c1_r100_0650_1)=1.35 v(rbl_c1_r100_0650_2)=0.9 v(sn_c1_r100_0650_2_0)=0.65
.ic v(sn_c1_r100_0650_2_1)=0.65 v(sn_c1_r100_0650_2_2)=0.65 v(sn_c1_r100_0650_2_3)=0.65 v(ref_c1_r100_0650_2)=0.800000 v(vn_c1_r100_0650_2)=0.45 v(vp_c1_r100_0650_2)=1.35
.ic v(rbl_c1_r100_0650_3)=0.9 v(sn_c1_r100_0650_3_0)=0.65 v(sn_c1_r100_0650_3_1)=0.65 v(sn_c1_r100_0650_3_2)=0.65 v(sn_c1_r100_0650_3_3)=0.65 v(ref_c1_r100_0650_3)=0.800000
.ic v(vn_c1_r100_0650_3)=0.45 v(vp_c1_r100_0650_3)=1.35 v(rbl_c1_r100_0700_0)=0.9 v(sn_c1_r100_0700_0_0)=0.7 v(sn_c1_r100_0700_0_1)=0.7 v(sn_c1_r100_0700_0_2)=0.7
.ic v(sn_c1_r100_0700_0_3)=0.7 v(ref_c1_r100_0700_0)=0.800000 v(vn_c1_r100_0700_0)=0.45 v(vp_c1_r100_0700_0)=1.35 v(rbl_c1_r100_0700_1)=0.9 v(sn_c1_r100_0700_1_0)=0.7
.ic v(sn_c1_r100_0700_1_1)=0.7 v(sn_c1_r100_0700_1_2)=0.7 v(sn_c1_r100_0700_1_3)=0.7 v(ref_c1_r100_0700_1)=0.800000 v(vn_c1_r100_0700_1)=0.45 v(vp_c1_r100_0700_1)=1.35
.ic v(rbl_c1_r100_0700_2)=0.9 v(sn_c1_r100_0700_2_0)=0.7 v(sn_c1_r100_0700_2_1)=0.7 v(sn_c1_r100_0700_2_2)=0.7 v(sn_c1_r100_0700_2_3)=0.7 v(ref_c1_r100_0700_2)=0.800000
.ic v(vn_c1_r100_0700_2)=0.45 v(vp_c1_r100_0700_2)=1.35 v(rbl_c1_r100_0700_3)=0.9 v(sn_c1_r100_0700_3_0)=0.7 v(sn_c1_r100_0700_3_1)=0.7 v(sn_c1_r100_0700_3_2)=0.7
.ic v(sn_c1_r100_0700_3_3)=0.7 v(ref_c1_r100_0700_3)=0.800000 v(vn_c1_r100_0700_3)=0.45 v(vp_c1_r100_0700_3)=1.35 v(rbl_c1_r100_0750_0)=0.9 v(sn_c1_r100_0750_0_0)=0.75
.ic v(sn_c1_r100_0750_0_1)=0.75 v(sn_c1_r100_0750_0_2)=0.75 v(sn_c1_r100_0750_0_3)=0.75 v(ref_c1_r100_0750_0)=0.800000 v(vn_c1_r100_0750_0)=0.45 v(vp_c1_r100_0750_0)=1.35
.ic v(rbl_c1_r100_0750_1)=0.9 v(sn_c1_r100_0750_1_0)=0.75 v(sn_c1_r100_0750_1_1)=0.75 v(sn_c1_r100_0750_1_2)=0.75 v(sn_c1_r100_0750_1_3)=0.75 v(ref_c1_r100_0750_1)=0.800000
.ic v(vn_c1_r100_0750_1)=0.45 v(vp_c1_r100_0750_1)=1.35 v(rbl_c1_r100_0750_2)=0.9 v(sn_c1_r100_0750_2_0)=0.75 v(sn_c1_r100_0750_2_1)=0.75 v(sn_c1_r100_0750_2_2)=0.75
.ic v(sn_c1_r100_0750_2_3)=0.75 v(ref_c1_r100_0750_2)=0.800000 v(vn_c1_r100_0750_2)=0.45 v(vp_c1_r100_0750_2)=1.35 v(rbl_c1_r100_0750_3)=0.9 v(sn_c1_r100_0750_3_0)=0.75
.ic v(sn_c1_r100_0750_3_1)=0.75 v(sn_c1_r100_0750_3_2)=0.75 v(sn_c1_r100_0750_3_3)=0.75 v(ref_c1_r100_0750_3)=0.800000 v(vn_c1_r100_0750_3)=0.45 v(vp_c1_r100_0750_3)=1.35
.ic v(rbl_c1_r100_0800_0)=0.9 v(sn_c1_r100_0800_0_0)=0.8 v(sn_c1_r100_0800_0_1)=0.8 v(sn_c1_r100_0800_0_2)=0.8 v(sn_c1_r100_0800_0_3)=0.8 v(ref_c1_r100_0800_0)=0.800000
.ic v(vn_c1_r100_0800_0)=0.45 v(vp_c1_r100_0800_0)=1.35 v(rbl_c1_r100_0800_1)=0.9 v(sn_c1_r100_0800_1_0)=0.8 v(sn_c1_r100_0800_1_1)=0.8 v(sn_c1_r100_0800_1_2)=0.8
.ic v(sn_c1_r100_0800_1_3)=0.8 v(ref_c1_r100_0800_1)=0.800000 v(vn_c1_r100_0800_1)=0.45 v(vp_c1_r100_0800_1)=1.35 v(rbl_c1_r100_0800_2)=0.9 v(sn_c1_r100_0800_2_0)=0.8
.ic v(sn_c1_r100_0800_2_1)=0.8 v(sn_c1_r100_0800_2_2)=0.8 v(sn_c1_r100_0800_2_3)=0.8 v(ref_c1_r100_0800_2)=0.800000 v(vn_c1_r100_0800_2)=0.45 v(vp_c1_r100_0800_2)=1.35
.ic v(rbl_c1_r100_0800_3)=0.9 v(sn_c1_r100_0800_3_0)=0.8 v(sn_c1_r100_0800_3_1)=0.8 v(sn_c1_r100_0800_3_2)=0.8 v(sn_c1_r100_0800_3_3)=0.8 v(ref_c1_r100_0800_3)=0.800000
.ic v(vn_c1_r100_0800_3)=0.45 v(vp_c1_r100_0800_3)=1.35 v(rbl_c1_r100_0850_0)=0.9 v(sn_c1_r100_0850_0_0)=0.85 v(sn_c1_r100_0850_0_1)=0.85 v(sn_c1_r100_0850_0_2)=0.85
.ic v(sn_c1_r100_0850_0_3)=0.85 v(ref_c1_r100_0850_0)=0.800000 v(vn_c1_r100_0850_0)=0.45 v(vp_c1_r100_0850_0)=1.35 v(rbl_c1_r100_0850_1)=0.9 v(sn_c1_r100_0850_1_0)=0.85
.ic v(sn_c1_r100_0850_1_1)=0.85 v(sn_c1_r100_0850_1_2)=0.85 v(sn_c1_r100_0850_1_3)=0.85 v(ref_c1_r100_0850_1)=0.800000 v(vn_c1_r100_0850_1)=0.45 v(vp_c1_r100_0850_1)=1.35
.ic v(rbl_c1_r100_0850_2)=0.9 v(sn_c1_r100_0850_2_0)=0.85 v(sn_c1_r100_0850_2_1)=0.85 v(sn_c1_r100_0850_2_2)=0.85 v(sn_c1_r100_0850_2_3)=0.85 v(ref_c1_r100_0850_2)=0.800000
.ic v(vn_c1_r100_0850_2)=0.45 v(vp_c1_r100_0850_2)=1.35 v(rbl_c1_r100_0850_3)=0.9 v(sn_c1_r100_0850_3_0)=0.85 v(sn_c1_r100_0850_3_1)=0.85 v(sn_c1_r100_0850_3_2)=0.85
.ic v(sn_c1_r100_0850_3_3)=0.85 v(ref_c1_r100_0850_3)=0.800000 v(vn_c1_r100_0850_3)=0.45 v(vp_c1_r100_0850_3)=1.35 v(rbl_c1_r100_0900_0)=0.9 v(sn_c1_r100_0900_0_0)=0.9
.ic v(sn_c1_r100_0900_0_1)=0.9 v(sn_c1_r100_0900_0_2)=0.9 v(sn_c1_r100_0900_0_3)=0.9 v(ref_c1_r100_0900_0)=0.800000 v(vn_c1_r100_0900_0)=0.45 v(vp_c1_r100_0900_0)=1.35
.ic v(rbl_c1_r100_0900_1)=0.9 v(sn_c1_r100_0900_1_0)=0.9 v(sn_c1_r100_0900_1_1)=0.9 v(sn_c1_r100_0900_1_2)=0.9 v(sn_c1_r100_0900_1_3)=0.9 v(ref_c1_r100_0900_1)=0.800000
.ic v(vn_c1_r100_0900_1)=0.45 v(vp_c1_r100_0900_1)=1.35 v(rbl_c1_r100_0900_2)=0.9 v(sn_c1_r100_0900_2_0)=0.9 v(sn_c1_r100_0900_2_1)=0.9 v(sn_c1_r100_0900_2_2)=0.9
.ic v(sn_c1_r100_0900_2_3)=0.9 v(ref_c1_r100_0900_2)=0.800000 v(vn_c1_r100_0900_2)=0.45 v(vp_c1_r100_0900_2)=1.35 v(rbl_c1_r100_0900_3)=0.9 v(sn_c1_r100_0900_3_0)=0.9
.ic v(sn_c1_r100_0900_3_1)=0.9 v(sn_c1_r100_0900_3_2)=0.9 v(sn_c1_r100_0900_3_3)=0.9 v(ref_c1_r100_0900_3)=0.800000 v(vn_c1_r100_0900_3)=0.45 v(vp_c1_r100_0900_3)=1.35
.ic v(rbl_c1_r100_0950_0)=0.9 v(sn_c1_r100_0950_0_0)=0.95 v(sn_c1_r100_0950_0_1)=0.95 v(sn_c1_r100_0950_0_2)=0.95 v(sn_c1_r100_0950_0_3)=0.95 v(ref_c1_r100_0950_0)=0.800000
.ic v(vn_c1_r100_0950_0)=0.45 v(vp_c1_r100_0950_0)=1.35 v(rbl_c1_r100_0950_1)=0.9 v(sn_c1_r100_0950_1_0)=0.95 v(sn_c1_r100_0950_1_1)=0.95 v(sn_c1_r100_0950_1_2)=0.95
.ic v(sn_c1_r100_0950_1_3)=0.95 v(ref_c1_r100_0950_1)=0.800000 v(vn_c1_r100_0950_1)=0.45 v(vp_c1_r100_0950_1)=1.35 v(rbl_c1_r100_0950_2)=0.9 v(sn_c1_r100_0950_2_0)=0.95
.ic v(sn_c1_r100_0950_2_1)=0.95 v(sn_c1_r100_0950_2_2)=0.95 v(sn_c1_r100_0950_2_3)=0.95 v(ref_c1_r100_0950_2)=0.800000 v(vn_c1_r100_0950_2)=0.45 v(vp_c1_r100_0950_2)=1.35
.ic v(rbl_c1_r100_0950_3)=0.9 v(sn_c1_r100_0950_3_0)=0.95 v(sn_c1_r100_0950_3_1)=0.95 v(sn_c1_r100_0950_3_2)=0.95 v(sn_c1_r100_0950_3_3)=0.95 v(ref_c1_r100_0950_3)=0.800000
.ic v(vn_c1_r100_0950_3)=0.45 v(vp_c1_r100_0950_3)=1.35 v(rbl_c1_r100_1000_0)=0.9 v(sn_c1_r100_1000_0_0)=1 v(sn_c1_r100_1000_0_1)=1 v(sn_c1_r100_1000_0_2)=1
.ic v(sn_c1_r100_1000_0_3)=1 v(ref_c1_r100_1000_0)=0.800000 v(vn_c1_r100_1000_0)=0.45 v(vp_c1_r100_1000_0)=1.35 v(rbl_c1_r100_1000_1)=0.9 v(sn_c1_r100_1000_1_0)=1
.ic v(sn_c1_r100_1000_1_1)=1 v(sn_c1_r100_1000_1_2)=1 v(sn_c1_r100_1000_1_3)=1 v(ref_c1_r100_1000_1)=0.800000 v(vn_c1_r100_1000_1)=0.45 v(vp_c1_r100_1000_1)=1.35
.ic v(rbl_c1_r100_1000_2)=0.9 v(sn_c1_r100_1000_2_0)=1 v(sn_c1_r100_1000_2_1)=1 v(sn_c1_r100_1000_2_2)=1 v(sn_c1_r100_1000_2_3)=1 v(ref_c1_r100_1000_2)=0.800000
.ic v(vn_c1_r100_1000_2)=0.45 v(vp_c1_r100_1000_2)=1.35 v(rbl_c1_r100_1000_3)=0.9 v(sn_c1_r100_1000_3_0)=1 v(sn_c1_r100_1000_3_1)=1 v(sn_c1_r100_1000_3_2)=1
.ic v(sn_c1_r100_1000_3_3)=1 v(ref_c1_r100_1000_3)=0.800000 v(vn_c1_r100_1000_3)=0.45 v(vp_c1_r100_1000_3)=1.35
