* write_disturb.spice -- write disturb of unselected / half-selected cells in the extracted 4x4
* 2T gain-cell array (issue #98, Epic #24 item 6). GENERATED by gen_write_disturb.py; do not edit.
*
* PROPOSED/UNRATIFIED SCOPE: corners/temperatures come from
* spec/operating-range-decision-PROPOSED.md (27 C and 125 C only).
* CIRCUIT BODY for `klt sim`: no .control/.end; the PDK .lib/.temp cards are appended per corner
* by klt. Flat and self-contained (batch fleet gets only this file + request.json).
*
* Each instance below is the committed extracted array
* layout/gain_cell_2t_array.extract.parasitics.spice (as-is; array C_SN not yet reconciled, #89),
* node-for-node with the instance name appended to every net, generic `nfet` -> sky130_fd_pr__nfet_01v8,
* GND and vsubs tied to ideal ground (ASSUMPTION). Drawn diffusion AD/AS/PD/PS are the extracted ones.
* ASSUMPTIONS (all labelled; none is a spec value): ideal rail-to-rail bitline / wordline drivers, ideal
* read bitline source (0.9 V) and read wordline (VDD, read device off), no mismatch, global corners only,
* stored levels and 34 ns write cadence as in the generator constants, no sense / read activity.

.options gmin=1e-15 abstol=1e-15 chgtol=1e-18
.param VDD = 1.8
vdd  vdd  0 dc {VDD}
vrbl vrbl 0 dc 0.9
vg_wl_train g_wl_train 0 pwl(0 0 1.2e-08 0 1.21e-08 1.8 3.2e-08 1.8 3.21e-08 0 4.6e-08 0
+ 4.61e-08 1.8 6.6e-08 1.8 6.61e-08 0 8e-08 0 8.01e-08 1.8 1e-07 1.8
+ 1.001e-07 0 1.14e-07 0 1.141e-07 1.8 1.34e-07 1.8 1.341e-07 0 1.48e-07 0
+ 1.481e-07 1.8 1.68e-07 1.8 1.681e-07 0 1.82e-07 0 1.821e-07 1.8 2.02e-07 1.8
+ 2.021e-07 0 2.16e-07 0 2.161e-07 1.8 2.36e-07 1.8 2.361e-07 0 2.5e-07 0
+ 2.501e-07 1.8 2.7e-07 1.8 2.701e-07 0 2.84e-07 0 2.841e-07 1.8 3.04e-07 1.8
+ 3.041e-07 0 3.18e-07 0 3.181e-07 1.8 3.38e-07 1.8 3.381e-07 0 3.52e-07 0
+ 3.521e-07 1.8 3.72e-07 1.8 3.721e-07 0 3.86e-07 0 3.861e-07 1.8 4.06e-07 1.8
+ 4.061e-07 0 4.2e-07 0 4.201e-07 1.8 4.4e-07 1.8 4.401e-07 0 4.54e-07 0
+ 4.541e-07 1.8 4.74e-07 1.8 4.741e-07 0 4.88e-07 0 4.881e-07 1.8 5.08e-07 1.8
+ 5.081e-07 0 5.22e-07 0 5.221e-07 1.8 5.42e-07 1.8 5.421e-07 0 5.56e-07 0
+ 5.561e-07 1.8 5.76e-07 1.8 5.761e-07 0 5.9e-07 0 5.901e-07 1.8 6.1e-07 1.8
+ 6.101e-07 0 6.24e-07 0 6.241e-07 1.8 6.44e-07 1.8 6.441e-07 0 6.58e-07 0
+ 6.581e-07 1.8 6.78e-07 1.8 6.781e-07 0 6.92e-07 0 6.921e-07 1.8 7.12e-07 1.8
+ 7.121e-07 0 7.26e-07 0 7.261e-07 1.8 7.46e-07 1.8 7.461e-07 0 7.6e-07 0
+ 7.601e-07 1.8 7.8e-07 1.8 7.801e-07 0 7.94e-07 0 7.941e-07 1.8 8.14e-07 1.8
+ 8.141e-07 0 8.28e-07 0 8.281e-07 1.8 8.48e-07 1.8 8.481e-07 0 8.62e-07 0
+ 8.621e-07 1.8 8.82e-07 1.8 8.821e-07 0 8.96e-07 0 8.961e-07 1.8 9.16e-07 1.8
+ 9.161e-07 0 9.3e-07 0 9.301e-07 1.8 9.5e-07 1.8 9.501e-07 0 9.64e-07 0
+ 9.641e-07 1.8 9.84e-07 1.8 9.841e-07 0 9.98e-07 0 9.981e-07 1.8 1.018e-06 1.8
+ 1.0181e-06 0 1.032e-06 0 1.0321e-06 1.8 1.052e-06 1.8 1.0521e-06 0 1.066e-06 0
+ 1.0661e-06 1.8 1.086e-06 1.8 1.0861e-06 0 1.1e-06 0 1.1001e-06 1.8 1.12e-06 1.8
+ 1.1201e-06 0 1.134e-06 0 1.1341e-06 1.8 1.154e-06 1.8 1.1541e-06 0 1.168e-06 0
+ 1.1681e-06 1.8 1.188e-06 1.8 1.1881e-06 0 1.202e-06 0 1.2021e-06 1.8 1.222e-06 1.8
+ 1.2221e-06 0 1.236e-06 0 1.2361e-06 1.8 1.256e-06 1.8 1.2561e-06 0 1.27e-06 0
+ 1.2701e-06 1.8 1.29e-06 1.8 1.2901e-06 0 1.304e-06 0 1.3041e-06 1.8 1.324e-06 1.8
+ 1.3241e-06 0 1.338e-06 0 1.3381e-06 1.8 1.358e-06 1.8 1.3581e-06 0 1.372e-06 0
+ 1.3721e-06 1.8 1.392e-06 1.8 1.3921e-06 0 1.406e-06 0 1.4061e-06 1.8 1.426e-06 1.8
+ 1.4261e-06 0 1.44e-06 0 1.4401e-06 1.8 1.46e-06 1.8 1.4601e-06 0 1.474e-06 0
+ 1.4741e-06 1.8 1.494e-06 1.8 1.4941e-06 0 1.508e-06 0 1.5081e-06 1.8 1.528e-06 1.8
+ 1.5281e-06 0 1.542e-06 0 1.5421e-06 1.8 1.562e-06 1.8 1.5621e-06 0 1.576e-06 0
+ 1.5761e-06 1.8 1.596e-06 1.8 1.5961e-06 0 1.61e-06 0 1.6101e-06 1.8 1.63e-06 1.8
+ 1.6301e-06 0 1.644e-06 0 1.6441e-06 1.8 1.664e-06 1.8 1.6641e-06 0 1.678e-06 0
+ 1.6781e-06 1.8 1.698e-06 1.8 1.6981e-06 0 1.712e-06 0 1.7121e-06 1.8 1.732e-06 1.8
+ 1.7321e-06 0 1.746e-06 0 1.7461e-06 1.8 1.766e-06 1.8 1.7661e-06 0 1.78e-06 0
+ 1.7801e-06 1.8 1.8e-06 1.8 1.8001e-06 0 1.814e-06 0 1.8141e-06 1.8 1.834e-06 1.8
+ 1.8341e-06 0 1.848e-06 0 1.8481e-06 1.8 1.868e-06 1.8 1.8681e-06 0 1.882e-06 0
+ 1.8821e-06 1.8 1.902e-06 1.8 1.9021e-06 0 1.916e-06 0 1.9161e-06 1.8 1.936e-06 1.8
+ 1.9361e-06 0 1.95e-06 0 1.9501e-06 1.8 1.97e-06 1.8 1.9701e-06 0 1.984e-06 0
+ 1.9841e-06 1.8 2.004e-06 1.8 2.0041e-06 0 2.018e-06 0 2.0181e-06 1.8 2.038e-06 1.8
+ 2.0381e-06 0 2.052e-06 0 2.0521e-06 1.8 2.072e-06 1.8 2.0721e-06 0 2.086e-06 0
+ 2.0861e-06 1.8 2.106e-06 1.8 2.1061e-06 0 2.12e-06 0 2.1201e-06 1.8 2.14e-06 1.8
+ 2.1401e-06 0 2.154e-06 0 2.1541e-06 1.8 2.174e-06 1.8 2.1741e-06 0 2.188e-06 0
+ 2.1881e-06 1.8 2.208e-06 1.8 2.2081e-06 0 2.222e-06 0 2.2221e-06 1.8 2.242e-06 1.8
+ 2.2421e-06 0 2.256e-06 0 2.2561e-06 1.8 2.276e-06 1.8 2.2761e-06 0 2.29e-06 0
+ 2.2901e-06 1.8 2.31e-06 1.8 2.3101e-06 0 2.324e-06 0 2.3241e-06 1.8 2.344e-06 1.8
+ 2.3441e-06 0 2.358e-06 0 2.3581e-06 1.8 2.378e-06 1.8 2.3781e-06 0 2.392e-06 0
+ 2.3921e-06 1.8 2.412e-06 1.8 2.4121e-06 0 2.426e-06 0 2.4261e-06 1.8 2.446e-06 1.8
+ 2.4461e-06 0 2.46e-06 0 2.4601e-06 1.8 2.48e-06 1.8 2.4801e-06 0 2.494e-06 0
+ 2.4941e-06 1.8 2.514e-06 1.8 2.5141e-06 0 2.528e-06 0 2.5281e-06 1.8 2.548e-06 1.8
+ 2.5481e-06 0 2.562e-06 0 2.5621e-06 1.8 2.582e-06 1.8 2.5821e-06 0 2.596e-06 0
+ 2.5961e-06 1.8 2.616e-06 1.8 2.6161e-06 0 2.63e-06 0 2.6301e-06 1.8 2.65e-06 1.8
+ 2.6501e-06 0 2.664e-06 0 2.6641e-06 1.8 2.684e-06 1.8 2.6841e-06 0 2.698e-06 0
+ 2.6981e-06 1.8 2.718e-06 1.8 2.7181e-06 0 2.732e-06 0 2.7321e-06 1.8 2.752e-06 1.8
+ 2.7521e-06 0 2.766e-06 0 2.7661e-06 1.8 2.786e-06 1.8 2.7861e-06 0 2.8e-06 0
+ 2.8001e-06 1.8 2.82e-06 1.8 2.8201e-06 0 2.834e-06 0 2.8341e-06 1.8 2.854e-06 1.8
+ 2.8541e-06 0 2.868e-06 0 2.8681e-06 1.8 2.888e-06 1.8 2.8881e-06 0 2.902e-06 0
+ 2.9021e-06 1.8 2.922e-06 1.8 2.9221e-06 0 2.936e-06 0 2.9361e-06 1.8 2.956e-06 1.8
+ 2.9561e-06 0 2.97e-06 0 2.9701e-06 1.8 2.99e-06 1.8 2.9901e-06 0 3.004e-06 0
+ 3.0041e-06 1.8 3.024e-06 1.8 3.0241e-06 0 3.038e-06 0 3.0381e-06 1.8 3.058e-06 1.8
+ 3.0581e-06 0 3.072e-06 0 3.0721e-06 1.8 3.092e-06 1.8 3.0921e-06 0 3.106e-06 0
+ 3.1061e-06 1.8 3.126e-06 1.8 3.1261e-06 0 3.14e-06 0 3.1401e-06 1.8 3.16e-06 1.8
+ 3.1601e-06 0 3.174e-06 0 3.1741e-06 1.8 3.194e-06 1.8 3.1941e-06 0 3.208e-06 0
+ 3.2081e-06 1.8 3.228e-06 1.8 3.2281e-06 0 3.242e-06 0 3.2421e-06 1.8 3.262e-06 1.8
+ 3.2621e-06 0 3.276e-06 0 3.2761e-06 1.8 3.296e-06 1.8 3.2961e-06 0 3.31e-06 0
+ 3.3101e-06 1.8 3.33e-06 1.8 3.3301e-06 0 3.344e-06 0 3.3441e-06 1.8 3.364e-06 1.8
+ 3.3641e-06 0 3.378e-06 0 3.3781e-06 1.8 3.398e-06 1.8 3.3981e-06 0 3.412e-06 0
+ 3.4121e-06 1.8 3.432e-06 1.8 3.4321e-06 0 3.446e-06 0 3.4461e-06 1.8 3.466e-06 1.8
+ 3.4661e-06 0 3.48e-06 0 3.4801e-06 1.8 3.5e-06 1.8 3.5001e-06 0 3.514e-06 0
+ 3.5141e-06 1.8 3.534e-06 1.8 3.5341e-06 0 3.548e-06 0 3.5481e-06 1.8 3.568e-06 1.8
+ 3.5681e-06 0 3.582e-06 0 3.5821e-06 1.8 3.602e-06 1.8 3.6021e-06 0 3.616e-06 0
+ 3.6161e-06 1.8 3.636e-06 1.8 3.6361e-06 0 3.65e-06 0 3.6501e-06 1.8 3.67e-06 1.8
+ 3.6701e-06 0 3.684e-06 0 3.6841e-06 1.8 3.704e-06 1.8 3.7041e-06 0 3.718e-06 0
+ 3.7181e-06 1.8 3.738e-06 1.8 3.7381e-06 0 3.752e-06 0 3.7521e-06 1.8 3.772e-06 1.8
+ 3.7721e-06 0 3.786e-06 0 3.7861e-06 1.8 3.806e-06 1.8 3.8061e-06 0 3.82e-06 0
+ 3.8201e-06 1.8 3.84e-06 1.8 3.8401e-06 0 3.854e-06 0 3.8541e-06 1.8 3.874e-06 1.8
+ 3.8741e-06 0 3.888e-06 0 3.8881e-06 1.8 3.908e-06 1.8 3.9081e-06 0 3.922e-06 0
+ 3.9221e-06 1.8 3.942e-06 1.8 3.9421e-06 0 3.956e-06 0 3.9561e-06 1.8 3.976e-06 1.8
+ 3.9761e-06 0 3.99e-06 0 3.9901e-06 1.8 4.01e-06 1.8 4.0101e-06 0 4.024e-06 0
+ 4.0241e-06 1.8 4.044e-06 1.8 4.0441e-06 0 4.058e-06 0 4.0581e-06 1.8 4.078e-06 1.8
+ 4.0781e-06 0 4.092e-06 0 4.0921e-06 1.8 4.112e-06 1.8 4.1121e-06 0 4.126e-06 0
+ 4.1261e-06 1.8 4.146e-06 1.8 4.1461e-06 0 4.16e-06 0 4.1601e-06 1.8 4.18e-06 1.8
+ 4.1801e-06 0 4.194e-06 0 4.1941e-06 1.8 4.214e-06 1.8 4.2141e-06 0 4.228e-06 0
+ 4.2281e-06 1.8 4.248e-06 1.8 4.2481e-06 0 4.262e-06 0 4.2621e-06 1.8 4.282e-06 1.8
+ 4.2821e-06 0 4.296e-06 0 4.2961e-06 1.8 4.316e-06 1.8 4.3161e-06 0 4.33e-06 0
+ 4.3301e-06 1.8 4.35e-06 1.8 4.3501e-06 0 4.364e-06 0 4.3641e-06 1.8 4.384e-06 1.8
+ 4.3841e-06 0 4.398e-06 0 4.3981e-06 1.8 4.418e-06 1.8 4.4181e-06 0 4.432e-06 0
+ 4.4321e-06 1.8 4.452e-06 1.8 4.4521e-06 0 4.466e-06 0 4.4661e-06 1.8 4.486e-06 1.8
+ 4.4861e-06 0 4.5e-06 0 4.5001e-06 1.8 4.52e-06 1.8 4.5201e-06 0 4.534e-06 0
+ 4.5341e-06 1.8 4.554e-06 1.8 4.5541e-06 0 4.568e-06 0 4.5681e-06 1.8 4.588e-06 1.8
+ 4.5881e-06 0 4.602e-06 0 4.6021e-06 1.8 4.622e-06 1.8 4.6221e-06 0 4.636e-06 0
+ 4.6361e-06 1.8 4.656e-06 1.8 4.6561e-06 0 4.67e-06 0 4.6701e-06 1.8 4.69e-06 1.8
+ 4.6901e-06 0 4.704e-06 0 4.7041e-06 1.8 4.724e-06 1.8 4.7241e-06 0 4.738e-06 0
+ 4.7381e-06 1.8 4.758e-06 1.8 4.7581e-06 0 4.772e-06 0 4.7721e-06 1.8 4.792e-06 1.8
+ 4.7921e-06 0 4.806e-06 0 4.8061e-06 1.8 4.826e-06 1.8 4.8261e-06 0 4.84e-06 0
+ 4.8401e-06 1.8 4.86e-06 1.8 4.8601e-06 0 4.874e-06 0 4.8741e-06 1.8 4.894e-06 1.8
+ 4.8941e-06 0 4.908e-06 0 4.9081e-06 1.8 4.928e-06 1.8 4.9281e-06 0 4.942e-06 0
+ 4.9421e-06 1.8 4.962e-06 1.8 4.9621e-06 0 4.976e-06 0 4.9761e-06 1.8 4.996e-06 1.8
+ 4.9961e-06 0)
vg_wl_one g_wl_one 0 pwl(0 0 1.2e-08 0 1.21e-08 1.8 3.2e-08 1.8 3.21e-08 0)
vg_hi_train g_hi_train 0 pwl(0 0 1e-08 0 1.01e-08 1.8 3.4e-08 1.8 3.41e-08 0 4.4e-08 0
+ 4.41e-08 1.8 6.8e-08 1.8 6.81e-08 0 7.8e-08 0 7.81e-08 1.8 1.02e-07 1.8
+ 1.021e-07 0 1.12e-07 0 1.121e-07 1.8 1.36e-07 1.8 1.361e-07 0 1.46e-07 0
+ 1.461e-07 1.8 1.7e-07 1.8 1.701e-07 0 1.8e-07 0 1.801e-07 1.8 2.04e-07 1.8
+ 2.041e-07 0 2.14e-07 0 2.141e-07 1.8 2.38e-07 1.8 2.381e-07 0 2.48e-07 0
+ 2.481e-07 1.8 2.72e-07 1.8 2.721e-07 0 2.82e-07 0 2.821e-07 1.8 3.06e-07 1.8
+ 3.061e-07 0 3.16e-07 0 3.161e-07 1.8 3.4e-07 1.8 3.401e-07 0 3.5e-07 0
+ 3.501e-07 1.8 3.74e-07 1.8 3.741e-07 0 3.84e-07 0 3.841e-07 1.8 4.08e-07 1.8
+ 4.081e-07 0 4.18e-07 0 4.181e-07 1.8 4.42e-07 1.8 4.421e-07 0 4.52e-07 0
+ 4.521e-07 1.8 4.76e-07 1.8 4.761e-07 0 4.86e-07 0 4.861e-07 1.8 5.1e-07 1.8
+ 5.101e-07 0 5.2e-07 0 5.201e-07 1.8 5.44e-07 1.8 5.441e-07 0 5.54e-07 0
+ 5.541e-07 1.8 5.78e-07 1.8 5.781e-07 0 5.88e-07 0 5.881e-07 1.8 6.12e-07 1.8
+ 6.121e-07 0 6.22e-07 0 6.221e-07 1.8 6.46e-07 1.8 6.461e-07 0 6.56e-07 0
+ 6.561e-07 1.8 6.8e-07 1.8 6.801e-07 0 6.9e-07 0 6.901e-07 1.8 7.14e-07 1.8
+ 7.141e-07 0 7.24e-07 0 7.241e-07 1.8 7.48e-07 1.8 7.481e-07 0 7.58e-07 0
+ 7.581e-07 1.8 7.82e-07 1.8 7.821e-07 0 7.92e-07 0 7.921e-07 1.8 8.16e-07 1.8
+ 8.161e-07 0 8.26e-07 0 8.261e-07 1.8 8.5e-07 1.8 8.501e-07 0 8.6e-07 0
+ 8.601e-07 1.8 8.84e-07 1.8 8.841e-07 0 8.94e-07 0 8.941e-07 1.8 9.18e-07 1.8
+ 9.181e-07 0 9.28e-07 0 9.281e-07 1.8 9.52e-07 1.8 9.521e-07 0 9.62e-07 0
+ 9.621e-07 1.8 9.86e-07 1.8 9.861e-07 0 9.96e-07 0 9.961e-07 1.8 1.02e-06 1.8
+ 1.0201e-06 0 1.03e-06 0 1.0301e-06 1.8 1.054e-06 1.8 1.0541e-06 0 1.064e-06 0
+ 1.0641e-06 1.8 1.088e-06 1.8 1.0881e-06 0 1.098e-06 0 1.0981e-06 1.8 1.122e-06 1.8
+ 1.1221e-06 0 1.132e-06 0 1.1321e-06 1.8 1.156e-06 1.8 1.1561e-06 0 1.166e-06 0
+ 1.1661e-06 1.8 1.19e-06 1.8 1.1901e-06 0 1.2e-06 0 1.2001e-06 1.8 1.224e-06 1.8
+ 1.2241e-06 0 1.234e-06 0 1.2341e-06 1.8 1.258e-06 1.8 1.2581e-06 0 1.268e-06 0
+ 1.2681e-06 1.8 1.292e-06 1.8 1.2921e-06 0 1.302e-06 0 1.3021e-06 1.8 1.326e-06 1.8
+ 1.3261e-06 0 1.336e-06 0 1.3361e-06 1.8 1.36e-06 1.8 1.3601e-06 0 1.37e-06 0
+ 1.3701e-06 1.8 1.394e-06 1.8 1.3941e-06 0 1.404e-06 0 1.4041e-06 1.8 1.428e-06 1.8
+ 1.4281e-06 0 1.438e-06 0 1.4381e-06 1.8 1.462e-06 1.8 1.4621e-06 0 1.472e-06 0
+ 1.4721e-06 1.8 1.496e-06 1.8 1.4961e-06 0 1.506e-06 0 1.5061e-06 1.8 1.53e-06 1.8
+ 1.5301e-06 0 1.54e-06 0 1.5401e-06 1.8 1.564e-06 1.8 1.5641e-06 0 1.574e-06 0
+ 1.5741e-06 1.8 1.598e-06 1.8 1.5981e-06 0 1.608e-06 0 1.6081e-06 1.8 1.632e-06 1.8
+ 1.6321e-06 0 1.642e-06 0 1.6421e-06 1.8 1.666e-06 1.8 1.6661e-06 0 1.676e-06 0
+ 1.6761e-06 1.8 1.7e-06 1.8 1.7001e-06 0 1.71e-06 0 1.7101e-06 1.8 1.734e-06 1.8
+ 1.7341e-06 0 1.744e-06 0 1.7441e-06 1.8 1.768e-06 1.8 1.7681e-06 0 1.778e-06 0
+ 1.7781e-06 1.8 1.802e-06 1.8 1.8021e-06 0 1.812e-06 0 1.8121e-06 1.8 1.836e-06 1.8
+ 1.8361e-06 0 1.846e-06 0 1.8461e-06 1.8 1.87e-06 1.8 1.8701e-06 0 1.88e-06 0
+ 1.8801e-06 1.8 1.904e-06 1.8 1.9041e-06 0 1.914e-06 0 1.9141e-06 1.8 1.938e-06 1.8
+ 1.9381e-06 0 1.948e-06 0 1.9481e-06 1.8 1.972e-06 1.8 1.9721e-06 0 1.982e-06 0
+ 1.9821e-06 1.8 2.006e-06 1.8 2.0061e-06 0 2.016e-06 0 2.0161e-06 1.8 2.04e-06 1.8
+ 2.0401e-06 0 2.05e-06 0 2.0501e-06 1.8 2.074e-06 1.8 2.0741e-06 0 2.084e-06 0
+ 2.0841e-06 1.8 2.108e-06 1.8 2.1081e-06 0 2.118e-06 0 2.1181e-06 1.8 2.142e-06 1.8
+ 2.1421e-06 0 2.152e-06 0 2.1521e-06 1.8 2.176e-06 1.8 2.1761e-06 0 2.186e-06 0
+ 2.1861e-06 1.8 2.21e-06 1.8 2.2101e-06 0 2.22e-06 0 2.2201e-06 1.8 2.244e-06 1.8
+ 2.2441e-06 0 2.254e-06 0 2.2541e-06 1.8 2.278e-06 1.8 2.2781e-06 0 2.288e-06 0
+ 2.2881e-06 1.8 2.312e-06 1.8 2.3121e-06 0 2.322e-06 0 2.3221e-06 1.8 2.346e-06 1.8
+ 2.3461e-06 0 2.356e-06 0 2.3561e-06 1.8 2.38e-06 1.8 2.3801e-06 0 2.39e-06 0
+ 2.3901e-06 1.8 2.414e-06 1.8 2.4141e-06 0 2.424e-06 0 2.4241e-06 1.8 2.448e-06 1.8
+ 2.4481e-06 0 2.458e-06 0 2.4581e-06 1.8 2.482e-06 1.8 2.4821e-06 0 2.492e-06 0
+ 2.4921e-06 1.8 2.516e-06 1.8 2.5161e-06 0 2.526e-06 0 2.5261e-06 1.8 2.55e-06 1.8
+ 2.5501e-06 0 2.56e-06 0 2.5601e-06 1.8 2.584e-06 1.8 2.5841e-06 0 2.594e-06 0
+ 2.5941e-06 1.8 2.618e-06 1.8 2.6181e-06 0 2.628e-06 0 2.6281e-06 1.8 2.652e-06 1.8
+ 2.6521e-06 0 2.662e-06 0 2.6621e-06 1.8 2.686e-06 1.8 2.6861e-06 0 2.696e-06 0
+ 2.6961e-06 1.8 2.72e-06 1.8 2.7201e-06 0 2.73e-06 0 2.7301e-06 1.8 2.754e-06 1.8
+ 2.7541e-06 0 2.764e-06 0 2.7641e-06 1.8 2.788e-06 1.8 2.7881e-06 0 2.798e-06 0
+ 2.7981e-06 1.8 2.822e-06 1.8 2.8221e-06 0 2.832e-06 0 2.8321e-06 1.8 2.856e-06 1.8
+ 2.8561e-06 0 2.866e-06 0 2.8661e-06 1.8 2.89e-06 1.8 2.8901e-06 0 2.9e-06 0
+ 2.9001e-06 1.8 2.924e-06 1.8 2.9241e-06 0 2.934e-06 0 2.9341e-06 1.8 2.958e-06 1.8
+ 2.9581e-06 0 2.968e-06 0 2.9681e-06 1.8 2.992e-06 1.8 2.9921e-06 0 3.002e-06 0
+ 3.0021e-06 1.8 3.026e-06 1.8 3.0261e-06 0 3.036e-06 0 3.0361e-06 1.8 3.06e-06 1.8
+ 3.0601e-06 0 3.07e-06 0 3.0701e-06 1.8 3.094e-06 1.8 3.0941e-06 0 3.104e-06 0
+ 3.1041e-06 1.8 3.128e-06 1.8 3.1281e-06 0 3.138e-06 0 3.1381e-06 1.8 3.162e-06 1.8
+ 3.1621e-06 0 3.172e-06 0 3.1721e-06 1.8 3.196e-06 1.8 3.1961e-06 0 3.206e-06 0
+ 3.2061e-06 1.8 3.23e-06 1.8 3.2301e-06 0 3.24e-06 0 3.2401e-06 1.8 3.264e-06 1.8
+ 3.2641e-06 0 3.274e-06 0 3.2741e-06 1.8 3.298e-06 1.8 3.2981e-06 0 3.308e-06 0
+ 3.3081e-06 1.8 3.332e-06 1.8 3.3321e-06 0 3.342e-06 0 3.3421e-06 1.8 3.366e-06 1.8
+ 3.3661e-06 0 3.376e-06 0 3.3761e-06 1.8 3.4e-06 1.8 3.4001e-06 0 3.41e-06 0
+ 3.4101e-06 1.8 3.434e-06 1.8 3.4341e-06 0 3.444e-06 0 3.4441e-06 1.8 3.468e-06 1.8
+ 3.4681e-06 0 3.478e-06 0 3.4781e-06 1.8 3.502e-06 1.8 3.5021e-06 0 3.512e-06 0
+ 3.5121e-06 1.8 3.536e-06 1.8 3.5361e-06 0 3.546e-06 0 3.5461e-06 1.8 3.57e-06 1.8
+ 3.5701e-06 0 3.58e-06 0 3.5801e-06 1.8 3.604e-06 1.8 3.6041e-06 0 3.614e-06 0
+ 3.6141e-06 1.8 3.638e-06 1.8 3.6381e-06 0 3.648e-06 0 3.6481e-06 1.8 3.672e-06 1.8
+ 3.6721e-06 0 3.682e-06 0 3.6821e-06 1.8 3.706e-06 1.8 3.7061e-06 0 3.716e-06 0
+ 3.7161e-06 1.8 3.74e-06 1.8 3.7401e-06 0 3.75e-06 0 3.7501e-06 1.8 3.774e-06 1.8
+ 3.7741e-06 0 3.784e-06 0 3.7841e-06 1.8 3.808e-06 1.8 3.8081e-06 0 3.818e-06 0
+ 3.8181e-06 1.8 3.842e-06 1.8 3.8421e-06 0 3.852e-06 0 3.8521e-06 1.8 3.876e-06 1.8
+ 3.8761e-06 0 3.886e-06 0 3.8861e-06 1.8 3.91e-06 1.8 3.9101e-06 0 3.92e-06 0
+ 3.9201e-06 1.8 3.944e-06 1.8 3.9441e-06 0 3.954e-06 0 3.9541e-06 1.8 3.978e-06 1.8
+ 3.9781e-06 0 3.988e-06 0 3.9881e-06 1.8 4.012e-06 1.8 4.0121e-06 0 4.022e-06 0
+ 4.0221e-06 1.8 4.046e-06 1.8 4.0461e-06 0 4.056e-06 0 4.0561e-06 1.8 4.08e-06 1.8
+ 4.0801e-06 0 4.09e-06 0 4.0901e-06 1.8 4.114e-06 1.8 4.1141e-06 0 4.124e-06 0
+ 4.1241e-06 1.8 4.148e-06 1.8 4.1481e-06 0 4.158e-06 0 4.1581e-06 1.8 4.182e-06 1.8
+ 4.1821e-06 0 4.192e-06 0 4.1921e-06 1.8 4.216e-06 1.8 4.2161e-06 0 4.226e-06 0
+ 4.2261e-06 1.8 4.25e-06 1.8 4.2501e-06 0 4.26e-06 0 4.2601e-06 1.8 4.284e-06 1.8
+ 4.2841e-06 0 4.294e-06 0 4.2941e-06 1.8 4.318e-06 1.8 4.3181e-06 0 4.328e-06 0
+ 4.3281e-06 1.8 4.352e-06 1.8 4.3521e-06 0 4.362e-06 0 4.3621e-06 1.8 4.386e-06 1.8
+ 4.3861e-06 0 4.396e-06 0 4.3961e-06 1.8 4.42e-06 1.8 4.4201e-06 0 4.43e-06 0
+ 4.4301e-06 1.8 4.454e-06 1.8 4.4541e-06 0 4.464e-06 0 4.4641e-06 1.8 4.488e-06 1.8
+ 4.4881e-06 0 4.498e-06 0 4.4981e-06 1.8 4.522e-06 1.8 4.5221e-06 0 4.532e-06 0
+ 4.5321e-06 1.8 4.556e-06 1.8 4.5561e-06 0 4.566e-06 0 4.5661e-06 1.8 4.59e-06 1.8
+ 4.5901e-06 0 4.6e-06 0 4.6001e-06 1.8 4.624e-06 1.8 4.6241e-06 0 4.634e-06 0
+ 4.6341e-06 1.8 4.658e-06 1.8 4.6581e-06 0 4.668e-06 0 4.6681e-06 1.8 4.692e-06 1.8
+ 4.6921e-06 0 4.702e-06 0 4.7021e-06 1.8 4.726e-06 1.8 4.7261e-06 0 4.736e-06 0
+ 4.7361e-06 1.8 4.76e-06 1.8 4.7601e-06 0 4.77e-06 0 4.7701e-06 1.8 4.794e-06 1.8
+ 4.7941e-06 0 4.804e-06 0 4.8041e-06 1.8 4.828e-06 1.8 4.8281e-06 0 4.838e-06 0
+ 4.8381e-06 1.8 4.862e-06 1.8 4.8621e-06 0 4.872e-06 0 4.8721e-06 1.8 4.896e-06 1.8
+ 4.8961e-06 0 4.906e-06 0 4.9061e-06 1.8 4.93e-06 1.8 4.9301e-06 0 4.94e-06 0
+ 4.9401e-06 1.8 4.964e-06 1.8 4.9641e-06 0 4.974e-06 0 4.9741e-06 1.8 4.998e-06 1.8
+ 4.9981e-06 0)
vg_hi_one g_hi_one 0 pwl(0 0 1e-08 0 1.01e-08 1.8 3.4e-08 1.8 3.41e-08 0)
vg_lo_train g_lo_train 0 pwl(0 1.8 1e-08 1.8 1.01e-08 0 3.4e-08 0 3.41e-08 1.8 4.4e-08 1.8
+ 4.41e-08 0 6.8e-08 0 6.81e-08 1.8 7.8e-08 1.8 7.81e-08 0 1.02e-07 0
+ 1.021e-07 1.8 1.12e-07 1.8 1.121e-07 0 1.36e-07 0 1.361e-07 1.8 1.46e-07 1.8
+ 1.461e-07 0 1.7e-07 0 1.701e-07 1.8 1.8e-07 1.8 1.801e-07 0 2.04e-07 0
+ 2.041e-07 1.8 2.14e-07 1.8 2.141e-07 0 2.38e-07 0 2.381e-07 1.8 2.48e-07 1.8
+ 2.481e-07 0 2.72e-07 0 2.721e-07 1.8 2.82e-07 1.8 2.821e-07 0 3.06e-07 0
+ 3.061e-07 1.8 3.16e-07 1.8 3.161e-07 0 3.4e-07 0 3.401e-07 1.8 3.5e-07 1.8
+ 3.501e-07 0 3.74e-07 0 3.741e-07 1.8 3.84e-07 1.8 3.841e-07 0 4.08e-07 0
+ 4.081e-07 1.8 4.18e-07 1.8 4.181e-07 0 4.42e-07 0 4.421e-07 1.8 4.52e-07 1.8
+ 4.521e-07 0 4.76e-07 0 4.761e-07 1.8 4.86e-07 1.8 4.861e-07 0 5.1e-07 0
+ 5.101e-07 1.8 5.2e-07 1.8 5.201e-07 0 5.44e-07 0 5.441e-07 1.8 5.54e-07 1.8
+ 5.541e-07 0 5.78e-07 0 5.781e-07 1.8 5.88e-07 1.8 5.881e-07 0 6.12e-07 0
+ 6.121e-07 1.8 6.22e-07 1.8 6.221e-07 0 6.46e-07 0 6.461e-07 1.8 6.56e-07 1.8
+ 6.561e-07 0 6.8e-07 0 6.801e-07 1.8 6.9e-07 1.8 6.901e-07 0 7.14e-07 0
+ 7.141e-07 1.8 7.24e-07 1.8 7.241e-07 0 7.48e-07 0 7.481e-07 1.8 7.58e-07 1.8
+ 7.581e-07 0 7.82e-07 0 7.821e-07 1.8 7.92e-07 1.8 7.921e-07 0 8.16e-07 0
+ 8.161e-07 1.8 8.26e-07 1.8 8.261e-07 0 8.5e-07 0 8.501e-07 1.8 8.6e-07 1.8
+ 8.601e-07 0 8.84e-07 0 8.841e-07 1.8 8.94e-07 1.8 8.941e-07 0 9.18e-07 0
+ 9.181e-07 1.8 9.28e-07 1.8 9.281e-07 0 9.52e-07 0 9.521e-07 1.8 9.62e-07 1.8
+ 9.621e-07 0 9.86e-07 0 9.861e-07 1.8 9.96e-07 1.8 9.961e-07 0 1.02e-06 0
+ 1.0201e-06 1.8 1.03e-06 1.8 1.0301e-06 0 1.054e-06 0 1.0541e-06 1.8 1.064e-06 1.8
+ 1.0641e-06 0 1.088e-06 0 1.0881e-06 1.8 1.098e-06 1.8 1.0981e-06 0 1.122e-06 0
+ 1.1221e-06 1.8 1.132e-06 1.8 1.1321e-06 0 1.156e-06 0 1.1561e-06 1.8 1.166e-06 1.8
+ 1.1661e-06 0 1.19e-06 0 1.1901e-06 1.8 1.2e-06 1.8 1.2001e-06 0 1.224e-06 0
+ 1.2241e-06 1.8 1.234e-06 1.8 1.2341e-06 0 1.258e-06 0 1.2581e-06 1.8 1.268e-06 1.8
+ 1.2681e-06 0 1.292e-06 0 1.2921e-06 1.8 1.302e-06 1.8 1.3021e-06 0 1.326e-06 0
+ 1.3261e-06 1.8 1.336e-06 1.8 1.3361e-06 0 1.36e-06 0 1.3601e-06 1.8 1.37e-06 1.8
+ 1.3701e-06 0 1.394e-06 0 1.3941e-06 1.8 1.404e-06 1.8 1.4041e-06 0 1.428e-06 0
+ 1.4281e-06 1.8 1.438e-06 1.8 1.4381e-06 0 1.462e-06 0 1.4621e-06 1.8 1.472e-06 1.8
+ 1.4721e-06 0 1.496e-06 0 1.4961e-06 1.8 1.506e-06 1.8 1.5061e-06 0 1.53e-06 0
+ 1.5301e-06 1.8 1.54e-06 1.8 1.5401e-06 0 1.564e-06 0 1.5641e-06 1.8 1.574e-06 1.8
+ 1.5741e-06 0 1.598e-06 0 1.5981e-06 1.8 1.608e-06 1.8 1.6081e-06 0 1.632e-06 0
+ 1.6321e-06 1.8 1.642e-06 1.8 1.6421e-06 0 1.666e-06 0 1.6661e-06 1.8 1.676e-06 1.8
+ 1.6761e-06 0 1.7e-06 0 1.7001e-06 1.8 1.71e-06 1.8 1.7101e-06 0 1.734e-06 0
+ 1.7341e-06 1.8 1.744e-06 1.8 1.7441e-06 0 1.768e-06 0 1.7681e-06 1.8 1.778e-06 1.8
+ 1.7781e-06 0 1.802e-06 0 1.8021e-06 1.8 1.812e-06 1.8 1.8121e-06 0 1.836e-06 0
+ 1.8361e-06 1.8 1.846e-06 1.8 1.8461e-06 0 1.87e-06 0 1.8701e-06 1.8 1.88e-06 1.8
+ 1.8801e-06 0 1.904e-06 0 1.9041e-06 1.8 1.914e-06 1.8 1.9141e-06 0 1.938e-06 0
+ 1.9381e-06 1.8 1.948e-06 1.8 1.9481e-06 0 1.972e-06 0 1.9721e-06 1.8 1.982e-06 1.8
+ 1.9821e-06 0 2.006e-06 0 2.0061e-06 1.8 2.016e-06 1.8 2.0161e-06 0 2.04e-06 0
+ 2.0401e-06 1.8 2.05e-06 1.8 2.0501e-06 0 2.074e-06 0 2.0741e-06 1.8 2.084e-06 1.8
+ 2.0841e-06 0 2.108e-06 0 2.1081e-06 1.8 2.118e-06 1.8 2.1181e-06 0 2.142e-06 0
+ 2.1421e-06 1.8 2.152e-06 1.8 2.1521e-06 0 2.176e-06 0 2.1761e-06 1.8 2.186e-06 1.8
+ 2.1861e-06 0 2.21e-06 0 2.2101e-06 1.8 2.22e-06 1.8 2.2201e-06 0 2.244e-06 0
+ 2.2441e-06 1.8 2.254e-06 1.8 2.2541e-06 0 2.278e-06 0 2.2781e-06 1.8 2.288e-06 1.8
+ 2.2881e-06 0 2.312e-06 0 2.3121e-06 1.8 2.322e-06 1.8 2.3221e-06 0 2.346e-06 0
+ 2.3461e-06 1.8 2.356e-06 1.8 2.3561e-06 0 2.38e-06 0 2.3801e-06 1.8 2.39e-06 1.8
+ 2.3901e-06 0 2.414e-06 0 2.4141e-06 1.8 2.424e-06 1.8 2.4241e-06 0 2.448e-06 0
+ 2.4481e-06 1.8 2.458e-06 1.8 2.4581e-06 0 2.482e-06 0 2.4821e-06 1.8 2.492e-06 1.8
+ 2.4921e-06 0 2.516e-06 0 2.5161e-06 1.8 2.526e-06 1.8 2.5261e-06 0 2.55e-06 0
+ 2.5501e-06 1.8 2.56e-06 1.8 2.5601e-06 0 2.584e-06 0 2.5841e-06 1.8 2.594e-06 1.8
+ 2.5941e-06 0 2.618e-06 0 2.6181e-06 1.8 2.628e-06 1.8 2.6281e-06 0 2.652e-06 0
+ 2.6521e-06 1.8 2.662e-06 1.8 2.6621e-06 0 2.686e-06 0 2.6861e-06 1.8 2.696e-06 1.8
+ 2.6961e-06 0 2.72e-06 0 2.7201e-06 1.8 2.73e-06 1.8 2.7301e-06 0 2.754e-06 0
+ 2.7541e-06 1.8 2.764e-06 1.8 2.7641e-06 0 2.788e-06 0 2.7881e-06 1.8 2.798e-06 1.8
+ 2.7981e-06 0 2.822e-06 0 2.8221e-06 1.8 2.832e-06 1.8 2.8321e-06 0 2.856e-06 0
+ 2.8561e-06 1.8 2.866e-06 1.8 2.8661e-06 0 2.89e-06 0 2.8901e-06 1.8 2.9e-06 1.8
+ 2.9001e-06 0 2.924e-06 0 2.9241e-06 1.8 2.934e-06 1.8 2.9341e-06 0 2.958e-06 0
+ 2.9581e-06 1.8 2.968e-06 1.8 2.9681e-06 0 2.992e-06 0 2.9921e-06 1.8 3.002e-06 1.8
+ 3.0021e-06 0 3.026e-06 0 3.0261e-06 1.8 3.036e-06 1.8 3.0361e-06 0 3.06e-06 0
+ 3.0601e-06 1.8 3.07e-06 1.8 3.0701e-06 0 3.094e-06 0 3.0941e-06 1.8 3.104e-06 1.8
+ 3.1041e-06 0 3.128e-06 0 3.1281e-06 1.8 3.138e-06 1.8 3.1381e-06 0 3.162e-06 0
+ 3.1621e-06 1.8 3.172e-06 1.8 3.1721e-06 0 3.196e-06 0 3.1961e-06 1.8 3.206e-06 1.8
+ 3.2061e-06 0 3.23e-06 0 3.2301e-06 1.8 3.24e-06 1.8 3.2401e-06 0 3.264e-06 0
+ 3.2641e-06 1.8 3.274e-06 1.8 3.2741e-06 0 3.298e-06 0 3.2981e-06 1.8 3.308e-06 1.8
+ 3.3081e-06 0 3.332e-06 0 3.3321e-06 1.8 3.342e-06 1.8 3.3421e-06 0 3.366e-06 0
+ 3.3661e-06 1.8 3.376e-06 1.8 3.3761e-06 0 3.4e-06 0 3.4001e-06 1.8 3.41e-06 1.8
+ 3.4101e-06 0 3.434e-06 0 3.4341e-06 1.8 3.444e-06 1.8 3.4441e-06 0 3.468e-06 0
+ 3.4681e-06 1.8 3.478e-06 1.8 3.4781e-06 0 3.502e-06 0 3.5021e-06 1.8 3.512e-06 1.8
+ 3.5121e-06 0 3.536e-06 0 3.5361e-06 1.8 3.546e-06 1.8 3.5461e-06 0 3.57e-06 0
+ 3.5701e-06 1.8 3.58e-06 1.8 3.5801e-06 0 3.604e-06 0 3.6041e-06 1.8 3.614e-06 1.8
+ 3.6141e-06 0 3.638e-06 0 3.6381e-06 1.8 3.648e-06 1.8 3.6481e-06 0 3.672e-06 0
+ 3.6721e-06 1.8 3.682e-06 1.8 3.6821e-06 0 3.706e-06 0 3.7061e-06 1.8 3.716e-06 1.8
+ 3.7161e-06 0 3.74e-06 0 3.7401e-06 1.8 3.75e-06 1.8 3.7501e-06 0 3.774e-06 0
+ 3.7741e-06 1.8 3.784e-06 1.8 3.7841e-06 0 3.808e-06 0 3.8081e-06 1.8 3.818e-06 1.8
+ 3.8181e-06 0 3.842e-06 0 3.8421e-06 1.8 3.852e-06 1.8 3.8521e-06 0 3.876e-06 0
+ 3.8761e-06 1.8 3.886e-06 1.8 3.8861e-06 0 3.91e-06 0 3.9101e-06 1.8 3.92e-06 1.8
+ 3.9201e-06 0 3.944e-06 0 3.9441e-06 1.8 3.954e-06 1.8 3.9541e-06 0 3.978e-06 0
+ 3.9781e-06 1.8 3.988e-06 1.8 3.9881e-06 0 4.012e-06 0 4.0121e-06 1.8 4.022e-06 1.8
+ 4.0221e-06 0 4.046e-06 0 4.0461e-06 1.8 4.056e-06 1.8 4.0561e-06 0 4.08e-06 0
+ 4.0801e-06 1.8 4.09e-06 1.8 4.0901e-06 0 4.114e-06 0 4.1141e-06 1.8 4.124e-06 1.8
+ 4.1241e-06 0 4.148e-06 0 4.1481e-06 1.8 4.158e-06 1.8 4.1581e-06 0 4.182e-06 0
+ 4.1821e-06 1.8 4.192e-06 1.8 4.1921e-06 0 4.216e-06 0 4.2161e-06 1.8 4.226e-06 1.8
+ 4.2261e-06 0 4.25e-06 0 4.2501e-06 1.8 4.26e-06 1.8 4.2601e-06 0 4.284e-06 0
+ 4.2841e-06 1.8 4.294e-06 1.8 4.2941e-06 0 4.318e-06 0 4.3181e-06 1.8 4.328e-06 1.8
+ 4.3281e-06 0 4.352e-06 0 4.3521e-06 1.8 4.362e-06 1.8 4.3621e-06 0 4.386e-06 0
+ 4.3861e-06 1.8 4.396e-06 1.8 4.3961e-06 0 4.42e-06 0 4.4201e-06 1.8 4.43e-06 1.8
+ 4.4301e-06 0 4.454e-06 0 4.4541e-06 1.8 4.464e-06 1.8 4.4641e-06 0 4.488e-06 0
+ 4.4881e-06 1.8 4.498e-06 1.8 4.4981e-06 0 4.522e-06 0 4.5221e-06 1.8 4.532e-06 1.8
+ 4.5321e-06 0 4.556e-06 0 4.5561e-06 1.8 4.566e-06 1.8 4.5661e-06 0 4.59e-06 0
+ 4.5901e-06 1.8 4.6e-06 1.8 4.6001e-06 0 4.624e-06 0 4.6241e-06 1.8 4.634e-06 1.8
+ 4.6341e-06 0 4.658e-06 0 4.6581e-06 1.8 4.668e-06 1.8 4.6681e-06 0 4.692e-06 0
+ 4.6921e-06 1.8 4.702e-06 1.8 4.7021e-06 0 4.726e-06 0 4.7261e-06 1.8 4.736e-06 1.8
+ 4.7361e-06 0 4.76e-06 0 4.7601e-06 1.8 4.77e-06 1.8 4.7701e-06 0 4.794e-06 0
+ 4.7941e-06 1.8 4.804e-06 1.8 4.8041e-06 0 4.828e-06 0 4.8281e-06 1.8 4.838e-06 1.8
+ 4.8381e-06 0 4.862e-06 0 4.8621e-06 1.8 4.872e-06 1.8 4.8721e-06 0 4.896e-06 0
+ 4.8961e-06 1.8 4.906e-06 1.8 4.9061e-06 0 4.93e-06 0 4.9301e-06 1.8 4.94e-06 1.8
+ 4.9401e-06 0 4.964e-06 0 4.9641e-06 1.8 4.974e-06 1.8 4.9741e-06 0 4.998e-06 0
+ 4.9981e-06 1.8)
vg_lo_one g_lo_one 0 pwl(0 1.8 1e-08 1.8 1.01e-08 0 3.4e-08 0 3.41e-08 1.8)

* ---- instance ctl0: family ctl0 ----
xm1_ctl0 sn_0_0__t0_ctl0 wl_0__t3_ctl0 bl_0__t0_ctl0 gnd__t0_ctl0 sky130_fd_pr__nfet_01v8 L=0.15 W=0.42 nf=1 ad=0.1974 as=0.1974 pd=1.78 ps=1.78 mult=1 m=1
xm2_ctl0 rbl_0__t0_ctl0 sn_0_0__t1_ctl0 rwl_0__t0_ctl0 gnd__t1_ctl0 sky130_fd_pr__nfet_01v8 L=0.15 W=0.42 nf=1 ad=0.1974 as=0.1974 pd=1.78 ps=1.78 mult=1 m=1
xm3_ctl0 sn_0_1__t1_ctl0 wl_0__t0_ctl0 bl_1__t0_ctl0 gnd__t2_ctl0 sky130_fd_pr__nfet_01v8 L=0.15 W=0.42 nf=1 ad=0.1974 as=0.1974 pd=1.78 ps=1.78 mult=1 m=1
xm4_ctl0 rbl_1__t0_ctl0 sn_0_1__t0_ctl0 rwl_0__t1_ctl0 gnd__t3_ctl0 sky130_fd_pr__nfet_01v8 L=0.15 W=0.42 nf=1 ad=0.1974 as=0.1974 pd=1.78 ps=1.78 mult=1 m=1
xm5_ctl0 sn_0_2__t1_ctl0 wl_0__t1_ctl0 bl_2__t0_ctl0 gnd__t4_ctl0 sky130_fd_pr__nfet_01v8 L=0.15 W=0.42 nf=1 ad=0.1974 as=0.1974 pd=1.78 ps=1.78 mult=1 m=1
xm6_ctl0 rbl_2__t0_ctl0 sn_0_2__t0_ctl0 rwl_0__t2_ctl0 gnd__t5_ctl0 sky130_fd_pr__nfet_01v8 L=0.15 W=0.42 nf=1 ad=0.1974 as=0.1974 pd=1.78 ps=1.78 mult=1 m=1
xm7_ctl0 sn_0_3__t1_ctl0 wl_0__t2_ctl0 bl_3__t0_ctl0 gnd__t6_ctl0 sky130_fd_pr__nfet_01v8 L=0.15 W=0.42 nf=1 ad=0.1974 as=0.1974 pd=1.78 ps=1.78 mult=1 m=1
xm8_ctl0 rbl_3__t0_ctl0 sn_0_3__t0_ctl0 rwl_0__t3_ctl0 gnd__t7_ctl0 sky130_fd_pr__nfet_01v8 L=0.15 W=0.42 nf=1 ad=0.1974 as=0.1974 pd=1.78 ps=1.78 mult=1 m=1
xm9_ctl0 sn_1_0__t1_ctl0 wl_1__t0_ctl0 bl_0__t1_ctl0 gnd__t8_ctl0 sky130_fd_pr__nfet_01v8 L=0.15 W=0.42 nf=1 ad=0.1974 as=0.1974 pd=1.78 ps=1.78 mult=1 m=1
xm10_ctl0 rbl_0__t1_ctl0 sn_1_0__t0_ctl0 rwl_1__t0_ctl0 gnd__t9_ctl0 sky130_fd_pr__nfet_01v8 L=0.15 W=0.42 nf=1 ad=0.1974 as=0.1974 pd=1.78 ps=1.78 mult=1 m=1
xm11_ctl0 sn_1_1__t1_ctl0 wl_1__t1_ctl0 bl_1__t1_ctl0 gnd__t10_ctl0 sky130_fd_pr__nfet_01v8 L=0.15 W=0.42 nf=1 ad=0.1974 as=0.1974 pd=1.78 ps=1.78 mult=1 m=1
xm12_ctl0 rbl_1__t1_ctl0 sn_1_1__t0_ctl0 rwl_1__t1_ctl0 gnd__t11_ctl0 sky130_fd_pr__nfet_01v8 L=0.15 W=0.42 nf=1 ad=0.1974 as=0.1974 pd=1.78 ps=1.78 mult=1 m=1
xm13_ctl0 sn_1_2__t1_ctl0 wl_1__t2_ctl0 bl_2__t1_ctl0 gnd__t12_ctl0 sky130_fd_pr__nfet_01v8 L=0.15 W=0.42 nf=1 ad=0.1974 as=0.1974 pd=1.78 ps=1.78 mult=1 m=1
xm14_ctl0 rbl_2__t1_ctl0 sn_1_2__t0_ctl0 rwl_1__t2_ctl0 gnd__t13_ctl0 sky130_fd_pr__nfet_01v8 L=0.15 W=0.42 nf=1 ad=0.1974 as=0.1974 pd=1.78 ps=1.78 mult=1 m=1
xm15_ctl0 sn_1_3__t1_ctl0 wl_1__t3_ctl0 bl_3__t1_ctl0 gnd__t14_ctl0 sky130_fd_pr__nfet_01v8 L=0.15 W=0.42 nf=1 ad=0.1974 as=0.1974 pd=1.78 ps=1.78 mult=1 m=1
xm16_ctl0 rbl_3__t1_ctl0 sn_1_3__t0_ctl0 rwl_1__t3_ctl0 gnd__t15_ctl0 sky130_fd_pr__nfet_01v8 L=0.15 W=0.42 nf=1 ad=0.1974 as=0.1974 pd=1.78 ps=1.78 mult=1 m=1
xm17_ctl0 sn_2_0__t1_ctl0 wl_2__t3_ctl0 bl_0__t3_ctl0 gnd__t16_ctl0 sky130_fd_pr__nfet_01v8 L=0.15 W=0.42 nf=1 ad=0.1974 as=0.1974 pd=1.78 ps=1.78 mult=1 m=1
xm18_ctl0 rbl_0__t2_ctl0 sn_2_0__t0_ctl0 rwl_2__t0_ctl0 gnd__t17_ctl0 sky130_fd_pr__nfet_01v8 L=0.15 W=0.42 nf=1 ad=0.1974 as=0.1974 pd=1.78 ps=1.78 mult=1 m=1
xm19_ctl0 sn_2_1__t1_ctl0 wl_2__t0_ctl0 bl_1__t2_ctl0 gnd__t18_ctl0 sky130_fd_pr__nfet_01v8 L=0.15 W=0.42 nf=1 ad=0.1974 as=0.1974 pd=1.78 ps=1.78 mult=1 m=1
xm20_ctl0 rbl_1__t2_ctl0 sn_2_1__t0_ctl0 rwl_2__t1_ctl0 gnd__t19_ctl0 sky130_fd_pr__nfet_01v8 L=0.15 W=0.42 nf=1 ad=0.1974 as=0.1974 pd=1.78 ps=1.78 mult=1 m=1
xm21_ctl0 sn_2_2__t1_ctl0 wl_2__t1_ctl0 bl_2__t2_ctl0 gnd__t20_ctl0 sky130_fd_pr__nfet_01v8 L=0.15 W=0.42 nf=1 ad=0.1974 as=0.1974 pd=1.78 ps=1.78 mult=1 m=1
xm22_ctl0 rbl_2__t2_ctl0 sn_2_2__t0_ctl0 rwl_2__t2_ctl0 gnd__t21_ctl0 sky130_fd_pr__nfet_01v8 L=0.15 W=0.42 nf=1 ad=0.1974 as=0.1974 pd=1.78 ps=1.78 mult=1 m=1
xm23_ctl0 sn_2_3__t1_ctl0 wl_2__t2_ctl0 bl_3__t2_ctl0 gnd__t22_ctl0 sky130_fd_pr__nfet_01v8 L=0.15 W=0.42 nf=1 ad=0.1974 as=0.1974 pd=1.78 ps=1.78 mult=1 m=1
xm24_ctl0 rbl_3__t2_ctl0 sn_2_3__t0_ctl0 rwl_2__t3_ctl0 gnd__t23_ctl0 sky130_fd_pr__nfet_01v8 L=0.15 W=0.42 nf=1 ad=0.1974 as=0.1974 pd=1.78 ps=1.78 mult=1 m=1
xm25_ctl0 sn_3_0__t1_ctl0 wl_3__t0_ctl0 bl_0__t2_ctl0 gnd__t24_ctl0 sky130_fd_pr__nfet_01v8 L=0.15 W=0.42 nf=1 ad=0.1974 as=0.1974 pd=1.78 ps=1.78 mult=1 m=1
xm26_ctl0 rbl_0__t3_ctl0 sn_3_0__t0_ctl0 rwl_3__t0_ctl0 gnd__t25_ctl0 sky130_fd_pr__nfet_01v8 L=0.15 W=0.42 nf=1 ad=0.1974 as=0.1974 pd=1.78 ps=1.78 mult=1 m=1
xm27_ctl0 sn_3_1__t1_ctl0 wl_3__t1_ctl0 bl_1__t3_ctl0 gnd__t26_ctl0 sky130_fd_pr__nfet_01v8 L=0.15 W=0.42 nf=1 ad=0.1974 as=0.1974 pd=1.78 ps=1.78 mult=1 m=1
xm28_ctl0 rbl_1__t3_ctl0 sn_3_1__t0_ctl0 rwl_3__t1_ctl0 gnd__t27_ctl0 sky130_fd_pr__nfet_01v8 L=0.15 W=0.42 nf=1 ad=0.1974 as=0.1974 pd=1.78 ps=1.78 mult=1 m=1
xm29_ctl0 sn_3_2__t1_ctl0 wl_3__t2_ctl0 bl_2__t3_ctl0 gnd__t28_ctl0 sky130_fd_pr__nfet_01v8 L=0.15 W=0.42 nf=1 ad=0.1974 as=0.1974 pd=1.78 ps=1.78 mult=1 m=1
xm30_ctl0 rbl_2__t3_ctl0 sn_3_2__t0_ctl0 rwl_3__t2_ctl0 gnd__t29_ctl0 sky130_fd_pr__nfet_01v8 L=0.15 W=0.42 nf=1 ad=0.1974 as=0.1974 pd=1.78 ps=1.78 mult=1 m=1
xm31_ctl0 sn_3_3__t1_ctl0 wl_3__t3_ctl0 bl_3__t3_ctl0 gnd__t30_ctl0 sky130_fd_pr__nfet_01v8 L=0.15 W=0.42 nf=1 ad=0.1974 as=0.1974 pd=1.78 ps=1.78 mult=1 m=1
xm32_ctl0 rbl_3__t3_ctl0 sn_3_3__t0_ctl0 rwl_3__t3_ctl0 gnd__t31_ctl0 sky130_fd_pr__nfet_01v8 L=0.15 W=0.42 nf=1 ad=0.1974 as=0.1974 pd=1.78 ps=1.78 mult=1 m=1
rgnd_t0_ctl0 gnd__t0_ctl0 0 63.3529
rgnd_t1_ctl0 gnd__t1_ctl0 0 49.0465
rgnd_t2_ctl0 gnd__t2_ctl0 0 36.5177
rgnd_t3_ctl0 gnd__t3_ctl0 0 28.2406
rgnd_t4_ctl0 gnd__t4_ctl0 0 28.2406
rgnd_t5_ctl0 gnd__t5_ctl0 0 36.5177
rgnd_t6_ctl0 gnd__t6_ctl0 0 49.0465
rgnd_t7_ctl0 gnd__t7_ctl0 0 63.3529
rgnd_t8_ctl0 gnd__t8_ctl0 0 58.0019
rgnd_t9_ctl0 gnd__t9_ctl0 0 41.907
rgnd_t10_ctl0 gnd__t10_ctl0 0 26.1568
rgnd_t11_ctl0 gnd__t11_ctl0 0 12.1726
rgnd_t12_ctl0 gnd__t12_ctl0 0 12.1726
rgnd_t13_ctl0 gnd__t13_ctl0 0 26.1568
rgnd_t14_ctl0 gnd__t14_ctl0 0 41.907
rgnd_t15_ctl0 gnd__t15_ctl0 0 58.0019
rgnd_t16_ctl0 gnd__t16_ctl0 0 58.0019
rgnd_t17_ctl0 gnd__t17_ctl0 0 41.907
rgnd_t18_ctl0 gnd__t18_ctl0 0 26.1568
rgnd_t19_ctl0 gnd__t19_ctl0 0 12.1726
rgnd_t20_ctl0 gnd__t20_ctl0 0 12.1726
rgnd_t21_ctl0 gnd__t21_ctl0 0 26.1568
rgnd_t22_ctl0 gnd__t22_ctl0 0 41.907
rgnd_t23_ctl0 gnd__t23_ctl0 0 58.0019
rgnd_t24_ctl0 gnd__t24_ctl0 0 63.3529
rgnd_t25_ctl0 gnd__t25_ctl0 0 49.0465
rgnd_t26_ctl0 gnd__t26_ctl0 0 36.5177
rgnd_t27_ctl0 gnd__t27_ctl0 0 28.2406
rgnd_t28_ctl0 gnd__t28_ctl0 0 28.2406
rgnd_t29_ctl0 gnd__t29_ctl0 0 36.5177
rgnd_t30_ctl0 gnd__t30_ctl0 0 49.0465
rgnd_t31_ctl0 gnd__t31_ctl0 0 63.3529
rbl_0_t0_ctl0 bl_0__t0_ctl0 bl_0_ctl0 144.555
rbl_0_t1_ctl0 bl_0__t1_ctl0 bl_0_ctl0 48.1851
rbl_0_t2_ctl0 bl_0__t2_ctl0 bl_0_ctl0 144.555
rbl_0_t3_ctl0 bl_0__t3_ctl0 bl_0_ctl0 48.1851
rbl_1_t0_ctl0 bl_1__t0_ctl0 bl_1_ctl0 144.555
rbl_1_t1_ctl0 bl_1__t1_ctl0 bl_1_ctl0 48.1851
rbl_1_t2_ctl0 bl_1__t2_ctl0 bl_1_ctl0 48.1851
rbl_1_t3_ctl0 bl_1__t3_ctl0 bl_1_ctl0 144.555
rbl_2_t0_ctl0 bl_2__t0_ctl0 bl_2_ctl0 144.555
rbl_2_t1_ctl0 bl_2__t1_ctl0 bl_2_ctl0 48.1851
rbl_2_t2_ctl0 bl_2__t2_ctl0 bl_2_ctl0 48.1851
rbl_2_t3_ctl0 bl_2__t3_ctl0 bl_2_ctl0 144.555
rbl_3_t0_ctl0 bl_3__t0_ctl0 bl_3_ctl0 144.555
rbl_3_t1_ctl0 bl_3__t1_ctl0 bl_3_ctl0 48.1851
rbl_3_t2_ctl0 bl_3__t2_ctl0 bl_3_ctl0 48.1851
rbl_3_t3_ctl0 bl_3__t3_ctl0 bl_3_ctl0 144.555
rrbl_0_t0_ctl0 rbl_0__t0_ctl0 rbl_0_ctl0 144.555
rrbl_0_t1_ctl0 rbl_0__t1_ctl0 rbl_0_ctl0 48.1851
rrbl_0_t2_ctl0 rbl_0__t2_ctl0 rbl_0_ctl0 48.1851
rrbl_0_t3_ctl0 rbl_0__t3_ctl0 rbl_0_ctl0 144.555
rrbl_1_t0_ctl0 rbl_1__t0_ctl0 rbl_1_ctl0 144.555
rrbl_1_t1_ctl0 rbl_1__t1_ctl0 rbl_1_ctl0 48.1851
rrbl_1_t2_ctl0 rbl_1__t2_ctl0 rbl_1_ctl0 48.1851
rrbl_1_t3_ctl0 rbl_1__t3_ctl0 rbl_1_ctl0 144.555
rrbl_2_t0_ctl0 rbl_2__t0_ctl0 rbl_2_ctl0 144.555
rrbl_2_t1_ctl0 rbl_2__t1_ctl0 rbl_2_ctl0 48.1851
rrbl_2_t2_ctl0 rbl_2__t2_ctl0 rbl_2_ctl0 48.1851
rrbl_2_t3_ctl0 rbl_2__t3_ctl0 rbl_2_ctl0 144.555
rrbl_3_t0_ctl0 rbl_3__t0_ctl0 rbl_3_ctl0 144.555
rrbl_3_t1_ctl0 rbl_3__t1_ctl0 rbl_3_ctl0 48.1851
rrbl_3_t2_ctl0 rbl_3__t2_ctl0 rbl_3_ctl0 48.1851
rrbl_3_t3_ctl0 rbl_3__t3_ctl0 rbl_3_ctl0 144.555
rrwl_0_t0_ctl0 rwl_0__t0_ctl0 rwl_0_ctl0 21.6897
rrwl_0_t1_ctl0 rwl_0__t1_ctl0 rwl_0_ctl0 7.22989
rrwl_0_t2_ctl0 rwl_0__t2_ctl0 rwl_0_ctl0 7.22989
rrwl_0_t3_ctl0 rwl_0__t3_ctl0 rwl_0_ctl0 21.6897
rrwl_1_t0_ctl0 rwl_1__t0_ctl0 rwl_1_ctl0 21.6897
rrwl_1_t1_ctl0 rwl_1__t1_ctl0 rwl_1_ctl0 7.22989
rrwl_1_t2_ctl0 rwl_1__t2_ctl0 rwl_1_ctl0 7.22989
rrwl_1_t3_ctl0 rwl_1__t3_ctl0 rwl_1_ctl0 21.6897
rrwl_2_t0_ctl0 rwl_2__t0_ctl0 rwl_2_ctl0 21.6897
rrwl_2_t1_ctl0 rwl_2__t1_ctl0 rwl_2_ctl0 7.22989
rrwl_2_t2_ctl0 rwl_2__t2_ctl0 rwl_2_ctl0 7.22989
rrwl_2_t3_ctl0 rwl_2__t3_ctl0 rwl_2_ctl0 21.6897
rrwl_3_t0_ctl0 rwl_3__t0_ctl0 rwl_3_ctl0 21.6897
rrwl_3_t1_ctl0 rwl_3__t1_ctl0 rwl_3_ctl0 7.22989
rrwl_3_t2_ctl0 rwl_3__t2_ctl0 rwl_3_ctl0 7.22989
rrwl_3_t3_ctl0 rwl_3__t3_ctl0 rwl_3_ctl0 21.6897
rsn_0_0_t0_ctl0 sn_0_0__t0_ctl0 sn_0_0_ctl0 125.123
rsn_0_0_t1_ctl0 sn_0_0__t1_ctl0 sn_0_0_ctl0 125.123
rsn_0_1_t0_ctl0 sn_0_1__t0_ctl0 sn_0_1_ctl0 125.123
rsn_0_1_t1_ctl0 sn_0_1__t1_ctl0 sn_0_1_ctl0 125.123
rsn_0_2_t0_ctl0 sn_0_2__t0_ctl0 sn_0_2_ctl0 125.123
rsn_0_2_t1_ctl0 sn_0_2__t1_ctl0 sn_0_2_ctl0 125.123
rsn_0_3_t0_ctl0 sn_0_3__t0_ctl0 sn_0_3_ctl0 125.123
rsn_0_3_t1_ctl0 sn_0_3__t1_ctl0 sn_0_3_ctl0 125.123
rsn_1_0_t0_ctl0 sn_1_0__t0_ctl0 sn_1_0_ctl0 125.123
rsn_1_0_t1_ctl0 sn_1_0__t1_ctl0 sn_1_0_ctl0 125.123
rsn_1_1_t0_ctl0 sn_1_1__t0_ctl0 sn_1_1_ctl0 125.123
rsn_1_1_t1_ctl0 sn_1_1__t1_ctl0 sn_1_1_ctl0 125.123
rsn_1_2_t0_ctl0 sn_1_2__t0_ctl0 sn_1_2_ctl0 125.123
rsn_1_2_t1_ctl0 sn_1_2__t1_ctl0 sn_1_2_ctl0 125.123
rsn_1_3_t0_ctl0 sn_1_3__t0_ctl0 sn_1_3_ctl0 125.123
rsn_1_3_t1_ctl0 sn_1_3__t1_ctl0 sn_1_3_ctl0 125.123
rsn_2_0_t0_ctl0 sn_2_0__t0_ctl0 sn_2_0_ctl0 125.123
rsn_2_0_t1_ctl0 sn_2_0__t1_ctl0 sn_2_0_ctl0 125.123
rsn_2_1_t0_ctl0 sn_2_1__t0_ctl0 sn_2_1_ctl0 125.123
rsn_2_1_t1_ctl0 sn_2_1__t1_ctl0 sn_2_1_ctl0 125.123
rsn_2_2_t0_ctl0 sn_2_2__t0_ctl0 sn_2_2_ctl0 125.123
rsn_2_2_t1_ctl0 sn_2_2__t1_ctl0 sn_2_2_ctl0 125.123
rsn_2_3_t0_ctl0 sn_2_3__t0_ctl0 sn_2_3_ctl0 125.123
rsn_2_3_t1_ctl0 sn_2_3__t1_ctl0 sn_2_3_ctl0 125.123
rsn_3_0_t0_ctl0 sn_3_0__t0_ctl0 sn_3_0_ctl0 125.123
rsn_3_0_t1_ctl0 sn_3_0__t1_ctl0 sn_3_0_ctl0 125.123
rsn_3_1_t0_ctl0 sn_3_1__t0_ctl0 sn_3_1_ctl0 125.123
rsn_3_1_t1_ctl0 sn_3_1__t1_ctl0 sn_3_1_ctl0 125.123
rsn_3_2_t0_ctl0 sn_3_2__t0_ctl0 sn_3_2_ctl0 125.123
rsn_3_2_t1_ctl0 sn_3_2__t1_ctl0 sn_3_2_ctl0 125.123
rsn_3_3_t0_ctl0 sn_3_3__t0_ctl0 sn_3_3_ctl0 125.123
rsn_3_3_t1_ctl0 sn_3_3__t1_ctl0 sn_3_3_ctl0 125.123
rwl_0_t0_ctl0 wl_0__t0_ctl0 wl_0_ctl0 54.2844
rwl_0_t1_ctl0 wl_0__t1_ctl0 wl_0_ctl0 54.2844
rwl_0_t2_ctl0 wl_0__t2_ctl0 wl_0_ctl0 162.853
rwl_0_t3_ctl0 wl_0__t3_ctl0 wl_0_ctl0 162.853
rwl_1_t0_ctl0 wl_1__t0_ctl0 wl_1_ctl0 162.853
rwl_1_t1_ctl0 wl_1__t1_ctl0 wl_1_ctl0 54.2844
rwl_1_t2_ctl0 wl_1__t2_ctl0 wl_1_ctl0 54.2844
rwl_1_t3_ctl0 wl_1__t3_ctl0 wl_1_ctl0 162.853
rwl_2_t0_ctl0 wl_2__t0_ctl0 wl_2_ctl0 54.2844
rwl_2_t1_ctl0 wl_2__t1_ctl0 wl_2_ctl0 54.2844
rwl_2_t2_ctl0 wl_2__t2_ctl0 wl_2_ctl0 162.853
rwl_2_t3_ctl0 wl_2__t3_ctl0 wl_2_ctl0 162.853
rwl_3_t0_ctl0 wl_3__t0_ctl0 wl_3_ctl0 162.853
rwl_3_t1_ctl0 wl_3__t1_ctl0 wl_3_ctl0 54.2844
rwl_3_t2_ctl0 wl_3__t2_ctl0 wl_3_ctl0 54.2844
rwl_3_t3_ctl0 wl_3__t3_ctl0 wl_3_ctl0 162.853
cgnd_ctl0 0 0 4.09475e-15
cbl_0_ctl0 bl_0_ctl0 0 5.96076e-16
cbl_1_ctl0 bl_1_ctl0 0 5.81168e-16
cbl_2_ctl0 bl_2_ctl0 0 5.81168e-16
cbl_3_ctl0 bl_3_ctl0 0 5.81168e-16
crbl_0_ctl0 rbl_0_ctl0 0 5.81168e-16
crbl_1_ctl0 rbl_1_ctl0 0 5.81168e-16
crbl_2_ctl0 rbl_2_ctl0 0 5.81168e-16
crbl_3_ctl0 rbl_3_ctl0 0 5.96076e-16
crwl_0_ctl0 rwl_0_ctl0 0 1.18713e-15
crwl_1_ctl0 rwl_1_ctl0 0 1.18713e-15
crwl_2_ctl0 rwl_2_ctl0 0 1.18713e-15
crwl_3_ctl0 rwl_3_ctl0 0 1.18713e-15
csn_0_0_ctl0 sn_0_0_ctl0 0 4.33689e-16
csn_0_1_ctl0 sn_0_1_ctl0 0 4.30576e-16
csn_0_2_ctl0 sn_0_2_ctl0 0 4.30576e-16
csn_0_3_ctl0 sn_0_3_ctl0 0 4.32518e-16
csn_1_0_ctl0 sn_1_0_ctl0 0 4.33689e-16
csn_1_1_ctl0 sn_1_1_ctl0 0 4.30576e-16
csn_1_2_ctl0 sn_1_2_ctl0 0 4.30576e-16
csn_1_3_ctl0 sn_1_3_ctl0 0 4.32518e-16
csn_2_0_ctl0 sn_2_0_ctl0 0 4.33689e-16
csn_2_1_ctl0 sn_2_1_ctl0 0 4.30576e-16
csn_2_2_ctl0 sn_2_2_ctl0 0 4.30576e-16
csn_2_3_ctl0 sn_2_3_ctl0 0 4.32518e-16
csn_3_0_ctl0 sn_3_0_ctl0 0 4.33689e-16
csn_3_1_ctl0 sn_3_1_ctl0 0 4.30576e-16
csn_3_2_ctl0 sn_3_2_ctl0 0 4.30576e-16
csn_3_3_ctl0 sn_3_3_ctl0 0 4.32518e-16
cwl_0_ctl0 wl_0_ctl0 0 1.90928e-15
cwl_1_ctl0 wl_1_ctl0 0 1.90928e-15
cwl_2_ctl0 wl_2_ctl0 0 1.90928e-15
cwl_3_ctl0 wl_3_ctl0 0 1.91375e-15
ccc_bl_0_sn_0_0_ctl0 bl_0_ctl0 sn_0_0_ctl0 1.071e-17
ccc_bl_0_sn_1_0_ctl0 bl_0_ctl0 sn_1_0_ctl0 1.071e-17
ccc_bl_0_sn_2_0_ctl0 bl_0_ctl0 sn_2_0_ctl0 1.071e-17
ccc_bl_0_sn_3_0_ctl0 bl_0_ctl0 sn_3_0_ctl0 1.071e-17
ccc_bl_0_wl_0_ctl0 bl_0_ctl0 wl_0_ctl0 2.4327e-17
ccc_bl_0_wl_1_ctl0 bl_0_ctl0 wl_1_ctl0 2.4327e-17
ccc_bl_0_wl_2_ctl0 bl_0_ctl0 wl_2_ctl0 2.4327e-17
ccc_bl_1_rbl_0_ctl0 bl_1_ctl0 rbl_0_ctl0 1.29795e-16
ccc_bl_1_rwl_0_ctl0 bl_1_ctl0 rwl_0_ctl0 9.028e-18
ccc_bl_1_rwl_1_ctl0 bl_1_ctl0 rwl_1_ctl0 9.028e-18
ccc_bl_1_rwl_2_ctl0 bl_1_ctl0 rwl_2_ctl0 9.028e-18
ccc_bl_1_rwl_3_ctl0 bl_1_ctl0 rwl_3_ctl0 9.028e-18
ccc_bl_1_sn_0_1_ctl0 bl_1_ctl0 sn_0_1_ctl0 1.071e-17
ccc_bl_1_sn_1_1_ctl0 bl_1_ctl0 sn_1_1_ctl0 1.071e-17
ccc_bl_1_sn_2_1_ctl0 bl_1_ctl0 sn_2_1_ctl0 1.071e-17
ccc_bl_1_sn_3_1_ctl0 bl_1_ctl0 sn_3_1_ctl0 1.071e-17
ccc_bl_1_wl_0_ctl0 bl_1_ctl0 wl_0_ctl0 2.7627e-17
ccc_bl_1_wl_1_ctl0 bl_1_ctl0 wl_1_ctl0 2.7627e-17
ccc_bl_1_wl_2_ctl0 bl_1_ctl0 wl_2_ctl0 2.7627e-17
ccc_bl_2_rbl_1_ctl0 bl_2_ctl0 rbl_1_ctl0 1.29795e-16
ccc_bl_2_rwl_0_ctl0 bl_2_ctl0 rwl_0_ctl0 9.028e-18
ccc_bl_2_rwl_1_ctl0 bl_2_ctl0 rwl_1_ctl0 9.028e-18
ccc_bl_2_rwl_2_ctl0 bl_2_ctl0 rwl_2_ctl0 9.028e-18
ccc_bl_2_rwl_3_ctl0 bl_2_ctl0 rwl_3_ctl0 9.028e-18
ccc_bl_2_sn_0_2_ctl0 bl_2_ctl0 sn_0_2_ctl0 1.071e-17
ccc_bl_2_sn_1_2_ctl0 bl_2_ctl0 sn_1_2_ctl0 1.071e-17
ccc_bl_2_sn_2_2_ctl0 bl_2_ctl0 sn_2_2_ctl0 1.071e-17
ccc_bl_2_sn_3_2_ctl0 bl_2_ctl0 sn_3_2_ctl0 1.071e-17
ccc_bl_2_wl_0_ctl0 bl_2_ctl0 wl_0_ctl0 2.7627e-17
ccc_bl_2_wl_1_ctl0 bl_2_ctl0 wl_1_ctl0 2.7627e-17
ccc_bl_2_wl_2_ctl0 bl_2_ctl0 wl_2_ctl0 2.7627e-17
ccc_bl_3_rbl_2_ctl0 bl_3_ctl0 rbl_2_ctl0 1.29795e-16
ccc_bl_3_rwl_0_ctl0 bl_3_ctl0 rwl_0_ctl0 9.028e-18
ccc_bl_3_rwl_1_ctl0 bl_3_ctl0 rwl_1_ctl0 9.028e-18
ccc_bl_3_rwl_2_ctl0 bl_3_ctl0 rwl_2_ctl0 9.028e-18
ccc_bl_3_rwl_3_ctl0 bl_3_ctl0 rwl_3_ctl0 9.028e-18
ccc_bl_3_sn_0_3_ctl0 bl_3_ctl0 sn_0_3_ctl0 1.071e-17
ccc_bl_3_sn_1_3_ctl0 bl_3_ctl0 sn_1_3_ctl0 1.071e-17
ccc_bl_3_sn_2_3_ctl0 bl_3_ctl0 sn_2_3_ctl0 1.071e-17
ccc_bl_3_sn_3_3_ctl0 bl_3_ctl0 sn_3_3_ctl0 1.071e-17
ccc_bl_3_wl_0_ctl0 bl_3_ctl0 wl_0_ctl0 2.7627e-17
ccc_bl_3_wl_1_ctl0 bl_3_ctl0 wl_1_ctl0 2.7627e-17
ccc_bl_3_wl_2_ctl0 bl_3_ctl0 wl_2_ctl0 2.7627e-17
ccc_rbl_0_rwl_0_ctl0 rbl_0_ctl0 rwl_0_ctl0 1.9738e-17
ccc_rbl_0_rwl_1_ctl0 rbl_0_ctl0 rwl_1_ctl0 1.9738e-17
ccc_rbl_0_rwl_2_ctl0 rbl_0_ctl0 rwl_2_ctl0 1.9738e-17
ccc_rbl_0_rwl_3_ctl0 rbl_0_ctl0 rwl_3_ctl0 1.9738e-17
ccc_rbl_0_sn_0_0_ctl0 rbl_0_ctl0 sn_0_0_ctl0 1.071e-17
ccc_rbl_0_sn_1_0_ctl0 rbl_0_ctl0 sn_1_0_ctl0 2.4327e-17
ccc_rbl_0_sn_2_0_ctl0 rbl_0_ctl0 sn_2_0_ctl0 2.4327e-17
ccc_rbl_0_wl_0_ctl0 rbl_0_ctl0 wl_0_ctl0 3.3e-18
ccc_rbl_0_wl_1_ctl0 rbl_0_ctl0 wl_1_ctl0 3.3e-18
ccc_rbl_0_wl_2_ctl0 rbl_0_ctl0 wl_2_ctl0 3.3e-18
ccc_rbl_1_rwl_0_ctl0 rbl_1_ctl0 rwl_0_ctl0 1.9738e-17
ccc_rbl_1_rwl_1_ctl0 rbl_1_ctl0 rwl_1_ctl0 1.9738e-17
ccc_rbl_1_rwl_2_ctl0 rbl_1_ctl0 rwl_2_ctl0 1.9738e-17
ccc_rbl_1_rwl_3_ctl0 rbl_1_ctl0 rwl_3_ctl0 1.9738e-17
ccc_rbl_1_sn_0_1_ctl0 rbl_1_ctl0 sn_0_1_ctl0 1.071e-17
ccc_rbl_1_sn_1_1_ctl0 rbl_1_ctl0 sn_1_1_ctl0 2.4327e-17
ccc_rbl_1_sn_2_1_ctl0 rbl_1_ctl0 sn_2_1_ctl0 2.4327e-17
ccc_rbl_1_wl_0_ctl0 rbl_1_ctl0 wl_0_ctl0 3.3e-18
ccc_rbl_1_wl_1_ctl0 rbl_1_ctl0 wl_1_ctl0 3.3e-18
ccc_rbl_1_wl_2_ctl0 rbl_1_ctl0 wl_2_ctl0 3.3e-18
ccc_rbl_2_rwl_0_ctl0 rbl_2_ctl0 rwl_0_ctl0 1.9738e-17
ccc_rbl_2_rwl_1_ctl0 rbl_2_ctl0 rwl_1_ctl0 1.9738e-17
ccc_rbl_2_rwl_2_ctl0 rbl_2_ctl0 rwl_2_ctl0 1.9738e-17
ccc_rbl_2_rwl_3_ctl0 rbl_2_ctl0 rwl_3_ctl0 1.9738e-17
ccc_rbl_2_sn_0_2_ctl0 rbl_2_ctl0 sn_0_2_ctl0 1.071e-17
ccc_rbl_2_sn_1_2_ctl0 rbl_2_ctl0 sn_1_2_ctl0 2.4327e-17
ccc_rbl_2_sn_2_2_ctl0 rbl_2_ctl0 sn_2_2_ctl0 2.4327e-17
ccc_rbl_2_wl_0_ctl0 rbl_2_ctl0 wl_0_ctl0 3.3e-18
ccc_rbl_2_wl_1_ctl0 rbl_2_ctl0 wl_1_ctl0 3.3e-18
ccc_rbl_2_wl_2_ctl0 rbl_2_ctl0 wl_2_ctl0 3.3e-18
ccc_rbl_3_rwl_0_ctl0 rbl_3_ctl0 rwl_0_ctl0 1.071e-17
ccc_rbl_3_rwl_1_ctl0 rbl_3_ctl0 rwl_1_ctl0 1.071e-17
ccc_rbl_3_rwl_2_ctl0 rbl_3_ctl0 rwl_2_ctl0 1.071e-17
ccc_rbl_3_rwl_3_ctl0 rbl_3_ctl0 rwl_3_ctl0 1.071e-17
ccc_rbl_3_sn_0_3_ctl0 rbl_3_ctl0 sn_0_3_ctl0 1.071e-17
ccc_rbl_3_sn_1_3_ctl0 rbl_3_ctl0 sn_1_3_ctl0 2.4327e-17
ccc_rbl_3_sn_2_3_ctl0 rbl_3_ctl0 sn_2_3_ctl0 2.4327e-17
ccc_rwl_0_sn_0_0_ctl0 rwl_0_ctl0 sn_0_0_ctl0 1.0072e-17
ccc_rwl_0_sn_0_1_ctl0 rwl_0_ctl0 sn_0_1_ctl0 1.9682e-17
ccc_rwl_0_sn_0_2_ctl0 rwl_0_ctl0 sn_0_2_ctl0 1.9682e-17
ccc_rwl_0_sn_0_3_ctl0 rwl_0_ctl0 sn_0_3_ctl0 1.9682e-17
ccc_rwl_1_sn_1_0_ctl0 rwl_1_ctl0 sn_1_0_ctl0 1.0072e-17
ccc_rwl_1_sn_1_1_ctl0 rwl_1_ctl0 sn_1_1_ctl0 1.9682e-17
ccc_rwl_1_sn_1_2_ctl0 rwl_1_ctl0 sn_1_2_ctl0 1.9682e-17
ccc_rwl_1_sn_1_3_ctl0 rwl_1_ctl0 sn_1_3_ctl0 1.9682e-17
ccc_rwl_2_sn_2_0_ctl0 rwl_2_ctl0 sn_2_0_ctl0 1.0072e-17
ccc_rwl_2_sn_2_1_ctl0 rwl_2_ctl0 sn_2_1_ctl0 1.9682e-17
ccc_rwl_2_sn_2_2_ctl0 rwl_2_ctl0 sn_2_2_ctl0 1.9682e-17
ccc_rwl_2_sn_2_3_ctl0 rwl_2_ctl0 sn_2_3_ctl0 1.9682e-17
ccc_rwl_3_sn_3_0_ctl0 rwl_3_ctl0 sn_3_0_ctl0 1.0072e-17
ccc_rwl_3_sn_3_1_ctl0 rwl_3_ctl0 sn_3_1_ctl0 1.9682e-17
ccc_rwl_3_sn_3_2_ctl0 rwl_3_ctl0 sn_3_2_ctl0 1.9682e-17
ccc_rwl_3_sn_3_3_ctl0 rwl_3_ctl0 sn_3_3_ctl0 1.9682e-17
ccc_sn_0_0_wl_0_ctl0 sn_0_0_ctl0 wl_0_ctl0 1.9664e-17
ccc_sn_0_1_wl_0_ctl0 sn_0_1_ctl0 wl_0_ctl0 1.9664e-17
ccc_sn_0_2_wl_0_ctl0 sn_0_2_ctl0 wl_0_ctl0 1.9664e-17
ccc_sn_0_3_wl_0_ctl0 sn_0_3_ctl0 wl_0_ctl0 1.3668e-17
ccc_sn_1_0_wl_1_ctl0 sn_1_0_ctl0 wl_1_ctl0 1.9664e-17
ccc_sn_1_1_wl_1_ctl0 sn_1_1_ctl0 wl_1_ctl0 1.6705e-17
ccc_sn_1_2_wl_1_ctl0 sn_1_2_ctl0 wl_1_ctl0 1.6705e-17
ccc_sn_1_3_wl_1_ctl0 sn_1_3_ctl0 wl_1_ctl0 1.071e-17
ccc_sn_2_0_wl_2_ctl0 sn_2_0_ctl0 wl_2_ctl0 1.9664e-17
ccc_sn_2_1_wl_2_ctl0 sn_2_1_ctl0 wl_2_ctl0 1.6705e-17
ccc_sn_2_2_wl_2_ctl0 sn_2_2_ctl0 wl_2_ctl0 1.6705e-17
ccc_sn_2_3_wl_2_ctl0 sn_2_3_ctl0 wl_2_ctl0 1.071e-17
ccc_sn_3_0_wl_3_ctl0 sn_3_0_ctl0 wl_3_ctl0 1.9664e-17
ccc_sn_3_1_wl_3_ctl0 sn_3_1_ctl0 wl_3_ctl0 1.6705e-17
ccc_sn_3_2_wl_3_ctl0 sn_3_2_ctl0 wl_3_ctl0 1.6705e-17
ccc_sn_3_3_wl_3_ctl0 sn_3_3_ctl0 wl_3_ctl0 1.071e-17
vdw_ctl0_0 wl_0_ctl0 0 dc 0
vdr_ctl0_0 rwl_0_ctl0 vdd dc 0
vdw_ctl0_1 wl_1_ctl0 0 dc 0
vdr_ctl0_1 rwl_1_ctl0 vdd dc 0
vdw_ctl0_2 wl_2_ctl0 0 dc 0
vdr_ctl0_2 rwl_2_ctl0 vdd dc 0
vdw_ctl0_3 wl_3_ctl0 0 dc 0
vdr_ctl0_3 rwl_3_ctl0 vdd dc 0
vdb_ctl0_0 bl_0_ctl0 0 dc 0
vdp_ctl0_0 rbl_0_ctl0 vrbl dc 0
vdb_ctl0_1 bl_1_ctl0 0 dc 0
vdp_ctl0_1 rbl_1_ctl0 vrbl dc 0
vdb_ctl0_2 bl_2_ctl0 0 dc 0
vdp_ctl0_2 rbl_2_ctl0 vrbl dc 0
vdb_ctl0_3 bl_3_ctl0 0 dc 0
vdp_ctl0_3 rbl_3_ctl0 vrbl dc 0

* ---- instance ctl1: family ctl1 ----
xm1_ctl1 sn_0_0__t0_ctl1 wl_0__t3_ctl1 bl_0__t0_ctl1 gnd__t0_ctl1 sky130_fd_pr__nfet_01v8 L=0.15 W=0.42 nf=1 ad=0.1974 as=0.1974 pd=1.78 ps=1.78 mult=1 m=1
xm2_ctl1 rbl_0__t0_ctl1 sn_0_0__t1_ctl1 rwl_0__t0_ctl1 gnd__t1_ctl1 sky130_fd_pr__nfet_01v8 L=0.15 W=0.42 nf=1 ad=0.1974 as=0.1974 pd=1.78 ps=1.78 mult=1 m=1
xm3_ctl1 sn_0_1__t1_ctl1 wl_0__t0_ctl1 bl_1__t0_ctl1 gnd__t2_ctl1 sky130_fd_pr__nfet_01v8 L=0.15 W=0.42 nf=1 ad=0.1974 as=0.1974 pd=1.78 ps=1.78 mult=1 m=1
xm4_ctl1 rbl_1__t0_ctl1 sn_0_1__t0_ctl1 rwl_0__t1_ctl1 gnd__t3_ctl1 sky130_fd_pr__nfet_01v8 L=0.15 W=0.42 nf=1 ad=0.1974 as=0.1974 pd=1.78 ps=1.78 mult=1 m=1
xm5_ctl1 sn_0_2__t1_ctl1 wl_0__t1_ctl1 bl_2__t0_ctl1 gnd__t4_ctl1 sky130_fd_pr__nfet_01v8 L=0.15 W=0.42 nf=1 ad=0.1974 as=0.1974 pd=1.78 ps=1.78 mult=1 m=1
xm6_ctl1 rbl_2__t0_ctl1 sn_0_2__t0_ctl1 rwl_0__t2_ctl1 gnd__t5_ctl1 sky130_fd_pr__nfet_01v8 L=0.15 W=0.42 nf=1 ad=0.1974 as=0.1974 pd=1.78 ps=1.78 mult=1 m=1
xm7_ctl1 sn_0_3__t1_ctl1 wl_0__t2_ctl1 bl_3__t0_ctl1 gnd__t6_ctl1 sky130_fd_pr__nfet_01v8 L=0.15 W=0.42 nf=1 ad=0.1974 as=0.1974 pd=1.78 ps=1.78 mult=1 m=1
xm8_ctl1 rbl_3__t0_ctl1 sn_0_3__t0_ctl1 rwl_0__t3_ctl1 gnd__t7_ctl1 sky130_fd_pr__nfet_01v8 L=0.15 W=0.42 nf=1 ad=0.1974 as=0.1974 pd=1.78 ps=1.78 mult=1 m=1
xm9_ctl1 sn_1_0__t1_ctl1 wl_1__t0_ctl1 bl_0__t1_ctl1 gnd__t8_ctl1 sky130_fd_pr__nfet_01v8 L=0.15 W=0.42 nf=1 ad=0.1974 as=0.1974 pd=1.78 ps=1.78 mult=1 m=1
xm10_ctl1 rbl_0__t1_ctl1 sn_1_0__t0_ctl1 rwl_1__t0_ctl1 gnd__t9_ctl1 sky130_fd_pr__nfet_01v8 L=0.15 W=0.42 nf=1 ad=0.1974 as=0.1974 pd=1.78 ps=1.78 mult=1 m=1
xm11_ctl1 sn_1_1__t1_ctl1 wl_1__t1_ctl1 bl_1__t1_ctl1 gnd__t10_ctl1 sky130_fd_pr__nfet_01v8 L=0.15 W=0.42 nf=1 ad=0.1974 as=0.1974 pd=1.78 ps=1.78 mult=1 m=1
xm12_ctl1 rbl_1__t1_ctl1 sn_1_1__t0_ctl1 rwl_1__t1_ctl1 gnd__t11_ctl1 sky130_fd_pr__nfet_01v8 L=0.15 W=0.42 nf=1 ad=0.1974 as=0.1974 pd=1.78 ps=1.78 mult=1 m=1
xm13_ctl1 sn_1_2__t1_ctl1 wl_1__t2_ctl1 bl_2__t1_ctl1 gnd__t12_ctl1 sky130_fd_pr__nfet_01v8 L=0.15 W=0.42 nf=1 ad=0.1974 as=0.1974 pd=1.78 ps=1.78 mult=1 m=1
xm14_ctl1 rbl_2__t1_ctl1 sn_1_2__t0_ctl1 rwl_1__t2_ctl1 gnd__t13_ctl1 sky130_fd_pr__nfet_01v8 L=0.15 W=0.42 nf=1 ad=0.1974 as=0.1974 pd=1.78 ps=1.78 mult=1 m=1
xm15_ctl1 sn_1_3__t1_ctl1 wl_1__t3_ctl1 bl_3__t1_ctl1 gnd__t14_ctl1 sky130_fd_pr__nfet_01v8 L=0.15 W=0.42 nf=1 ad=0.1974 as=0.1974 pd=1.78 ps=1.78 mult=1 m=1
xm16_ctl1 rbl_3__t1_ctl1 sn_1_3__t0_ctl1 rwl_1__t3_ctl1 gnd__t15_ctl1 sky130_fd_pr__nfet_01v8 L=0.15 W=0.42 nf=1 ad=0.1974 as=0.1974 pd=1.78 ps=1.78 mult=1 m=1
xm17_ctl1 sn_2_0__t1_ctl1 wl_2__t3_ctl1 bl_0__t3_ctl1 gnd__t16_ctl1 sky130_fd_pr__nfet_01v8 L=0.15 W=0.42 nf=1 ad=0.1974 as=0.1974 pd=1.78 ps=1.78 mult=1 m=1
xm18_ctl1 rbl_0__t2_ctl1 sn_2_0__t0_ctl1 rwl_2__t0_ctl1 gnd__t17_ctl1 sky130_fd_pr__nfet_01v8 L=0.15 W=0.42 nf=1 ad=0.1974 as=0.1974 pd=1.78 ps=1.78 mult=1 m=1
xm19_ctl1 sn_2_1__t1_ctl1 wl_2__t0_ctl1 bl_1__t2_ctl1 gnd__t18_ctl1 sky130_fd_pr__nfet_01v8 L=0.15 W=0.42 nf=1 ad=0.1974 as=0.1974 pd=1.78 ps=1.78 mult=1 m=1
xm20_ctl1 rbl_1__t2_ctl1 sn_2_1__t0_ctl1 rwl_2__t1_ctl1 gnd__t19_ctl1 sky130_fd_pr__nfet_01v8 L=0.15 W=0.42 nf=1 ad=0.1974 as=0.1974 pd=1.78 ps=1.78 mult=1 m=1
xm21_ctl1 sn_2_2__t1_ctl1 wl_2__t1_ctl1 bl_2__t2_ctl1 gnd__t20_ctl1 sky130_fd_pr__nfet_01v8 L=0.15 W=0.42 nf=1 ad=0.1974 as=0.1974 pd=1.78 ps=1.78 mult=1 m=1
xm22_ctl1 rbl_2__t2_ctl1 sn_2_2__t0_ctl1 rwl_2__t2_ctl1 gnd__t21_ctl1 sky130_fd_pr__nfet_01v8 L=0.15 W=0.42 nf=1 ad=0.1974 as=0.1974 pd=1.78 ps=1.78 mult=1 m=1
xm23_ctl1 sn_2_3__t1_ctl1 wl_2__t2_ctl1 bl_3__t2_ctl1 gnd__t22_ctl1 sky130_fd_pr__nfet_01v8 L=0.15 W=0.42 nf=1 ad=0.1974 as=0.1974 pd=1.78 ps=1.78 mult=1 m=1
xm24_ctl1 rbl_3__t2_ctl1 sn_2_3__t0_ctl1 rwl_2__t3_ctl1 gnd__t23_ctl1 sky130_fd_pr__nfet_01v8 L=0.15 W=0.42 nf=1 ad=0.1974 as=0.1974 pd=1.78 ps=1.78 mult=1 m=1
xm25_ctl1 sn_3_0__t1_ctl1 wl_3__t0_ctl1 bl_0__t2_ctl1 gnd__t24_ctl1 sky130_fd_pr__nfet_01v8 L=0.15 W=0.42 nf=1 ad=0.1974 as=0.1974 pd=1.78 ps=1.78 mult=1 m=1
xm26_ctl1 rbl_0__t3_ctl1 sn_3_0__t0_ctl1 rwl_3__t0_ctl1 gnd__t25_ctl1 sky130_fd_pr__nfet_01v8 L=0.15 W=0.42 nf=1 ad=0.1974 as=0.1974 pd=1.78 ps=1.78 mult=1 m=1
xm27_ctl1 sn_3_1__t1_ctl1 wl_3__t1_ctl1 bl_1__t3_ctl1 gnd__t26_ctl1 sky130_fd_pr__nfet_01v8 L=0.15 W=0.42 nf=1 ad=0.1974 as=0.1974 pd=1.78 ps=1.78 mult=1 m=1
xm28_ctl1 rbl_1__t3_ctl1 sn_3_1__t0_ctl1 rwl_3__t1_ctl1 gnd__t27_ctl1 sky130_fd_pr__nfet_01v8 L=0.15 W=0.42 nf=1 ad=0.1974 as=0.1974 pd=1.78 ps=1.78 mult=1 m=1
xm29_ctl1 sn_3_2__t1_ctl1 wl_3__t2_ctl1 bl_2__t3_ctl1 gnd__t28_ctl1 sky130_fd_pr__nfet_01v8 L=0.15 W=0.42 nf=1 ad=0.1974 as=0.1974 pd=1.78 ps=1.78 mult=1 m=1
xm30_ctl1 rbl_2__t3_ctl1 sn_3_2__t0_ctl1 rwl_3__t2_ctl1 gnd__t29_ctl1 sky130_fd_pr__nfet_01v8 L=0.15 W=0.42 nf=1 ad=0.1974 as=0.1974 pd=1.78 ps=1.78 mult=1 m=1
xm31_ctl1 sn_3_3__t1_ctl1 wl_3__t3_ctl1 bl_3__t3_ctl1 gnd__t30_ctl1 sky130_fd_pr__nfet_01v8 L=0.15 W=0.42 nf=1 ad=0.1974 as=0.1974 pd=1.78 ps=1.78 mult=1 m=1
xm32_ctl1 rbl_3__t3_ctl1 sn_3_3__t0_ctl1 rwl_3__t3_ctl1 gnd__t31_ctl1 sky130_fd_pr__nfet_01v8 L=0.15 W=0.42 nf=1 ad=0.1974 as=0.1974 pd=1.78 ps=1.78 mult=1 m=1
rgnd_t0_ctl1 gnd__t0_ctl1 0 63.3529
rgnd_t1_ctl1 gnd__t1_ctl1 0 49.0465
rgnd_t2_ctl1 gnd__t2_ctl1 0 36.5177
rgnd_t3_ctl1 gnd__t3_ctl1 0 28.2406
rgnd_t4_ctl1 gnd__t4_ctl1 0 28.2406
rgnd_t5_ctl1 gnd__t5_ctl1 0 36.5177
rgnd_t6_ctl1 gnd__t6_ctl1 0 49.0465
rgnd_t7_ctl1 gnd__t7_ctl1 0 63.3529
rgnd_t8_ctl1 gnd__t8_ctl1 0 58.0019
rgnd_t9_ctl1 gnd__t9_ctl1 0 41.907
rgnd_t10_ctl1 gnd__t10_ctl1 0 26.1568
rgnd_t11_ctl1 gnd__t11_ctl1 0 12.1726
rgnd_t12_ctl1 gnd__t12_ctl1 0 12.1726
rgnd_t13_ctl1 gnd__t13_ctl1 0 26.1568
rgnd_t14_ctl1 gnd__t14_ctl1 0 41.907
rgnd_t15_ctl1 gnd__t15_ctl1 0 58.0019
rgnd_t16_ctl1 gnd__t16_ctl1 0 58.0019
rgnd_t17_ctl1 gnd__t17_ctl1 0 41.907
rgnd_t18_ctl1 gnd__t18_ctl1 0 26.1568
rgnd_t19_ctl1 gnd__t19_ctl1 0 12.1726
rgnd_t20_ctl1 gnd__t20_ctl1 0 12.1726
rgnd_t21_ctl1 gnd__t21_ctl1 0 26.1568
rgnd_t22_ctl1 gnd__t22_ctl1 0 41.907
rgnd_t23_ctl1 gnd__t23_ctl1 0 58.0019
rgnd_t24_ctl1 gnd__t24_ctl1 0 63.3529
rgnd_t25_ctl1 gnd__t25_ctl1 0 49.0465
rgnd_t26_ctl1 gnd__t26_ctl1 0 36.5177
rgnd_t27_ctl1 gnd__t27_ctl1 0 28.2406
rgnd_t28_ctl1 gnd__t28_ctl1 0 28.2406
rgnd_t29_ctl1 gnd__t29_ctl1 0 36.5177
rgnd_t30_ctl1 gnd__t30_ctl1 0 49.0465
rgnd_t31_ctl1 gnd__t31_ctl1 0 63.3529
rbl_0_t0_ctl1 bl_0__t0_ctl1 bl_0_ctl1 144.555
rbl_0_t1_ctl1 bl_0__t1_ctl1 bl_0_ctl1 48.1851
rbl_0_t2_ctl1 bl_0__t2_ctl1 bl_0_ctl1 144.555
rbl_0_t3_ctl1 bl_0__t3_ctl1 bl_0_ctl1 48.1851
rbl_1_t0_ctl1 bl_1__t0_ctl1 bl_1_ctl1 144.555
rbl_1_t1_ctl1 bl_1__t1_ctl1 bl_1_ctl1 48.1851
rbl_1_t2_ctl1 bl_1__t2_ctl1 bl_1_ctl1 48.1851
rbl_1_t3_ctl1 bl_1__t3_ctl1 bl_1_ctl1 144.555
rbl_2_t0_ctl1 bl_2__t0_ctl1 bl_2_ctl1 144.555
rbl_2_t1_ctl1 bl_2__t1_ctl1 bl_2_ctl1 48.1851
rbl_2_t2_ctl1 bl_2__t2_ctl1 bl_2_ctl1 48.1851
rbl_2_t3_ctl1 bl_2__t3_ctl1 bl_2_ctl1 144.555
rbl_3_t0_ctl1 bl_3__t0_ctl1 bl_3_ctl1 144.555
rbl_3_t1_ctl1 bl_3__t1_ctl1 bl_3_ctl1 48.1851
rbl_3_t2_ctl1 bl_3__t2_ctl1 bl_3_ctl1 48.1851
rbl_3_t3_ctl1 bl_3__t3_ctl1 bl_3_ctl1 144.555
rrbl_0_t0_ctl1 rbl_0__t0_ctl1 rbl_0_ctl1 144.555
rrbl_0_t1_ctl1 rbl_0__t1_ctl1 rbl_0_ctl1 48.1851
rrbl_0_t2_ctl1 rbl_0__t2_ctl1 rbl_0_ctl1 48.1851
rrbl_0_t3_ctl1 rbl_0__t3_ctl1 rbl_0_ctl1 144.555
rrbl_1_t0_ctl1 rbl_1__t0_ctl1 rbl_1_ctl1 144.555
rrbl_1_t1_ctl1 rbl_1__t1_ctl1 rbl_1_ctl1 48.1851
rrbl_1_t2_ctl1 rbl_1__t2_ctl1 rbl_1_ctl1 48.1851
rrbl_1_t3_ctl1 rbl_1__t3_ctl1 rbl_1_ctl1 144.555
rrbl_2_t0_ctl1 rbl_2__t0_ctl1 rbl_2_ctl1 144.555
rrbl_2_t1_ctl1 rbl_2__t1_ctl1 rbl_2_ctl1 48.1851
rrbl_2_t2_ctl1 rbl_2__t2_ctl1 rbl_2_ctl1 48.1851
rrbl_2_t3_ctl1 rbl_2__t3_ctl1 rbl_2_ctl1 144.555
rrbl_3_t0_ctl1 rbl_3__t0_ctl1 rbl_3_ctl1 144.555
rrbl_3_t1_ctl1 rbl_3__t1_ctl1 rbl_3_ctl1 48.1851
rrbl_3_t2_ctl1 rbl_3__t2_ctl1 rbl_3_ctl1 48.1851
rrbl_3_t3_ctl1 rbl_3__t3_ctl1 rbl_3_ctl1 144.555
rrwl_0_t0_ctl1 rwl_0__t0_ctl1 rwl_0_ctl1 21.6897
rrwl_0_t1_ctl1 rwl_0__t1_ctl1 rwl_0_ctl1 7.22989
rrwl_0_t2_ctl1 rwl_0__t2_ctl1 rwl_0_ctl1 7.22989
rrwl_0_t3_ctl1 rwl_0__t3_ctl1 rwl_0_ctl1 21.6897
rrwl_1_t0_ctl1 rwl_1__t0_ctl1 rwl_1_ctl1 21.6897
rrwl_1_t1_ctl1 rwl_1__t1_ctl1 rwl_1_ctl1 7.22989
rrwl_1_t2_ctl1 rwl_1__t2_ctl1 rwl_1_ctl1 7.22989
rrwl_1_t3_ctl1 rwl_1__t3_ctl1 rwl_1_ctl1 21.6897
rrwl_2_t0_ctl1 rwl_2__t0_ctl1 rwl_2_ctl1 21.6897
rrwl_2_t1_ctl1 rwl_2__t1_ctl1 rwl_2_ctl1 7.22989
rrwl_2_t2_ctl1 rwl_2__t2_ctl1 rwl_2_ctl1 7.22989
rrwl_2_t3_ctl1 rwl_2__t3_ctl1 rwl_2_ctl1 21.6897
rrwl_3_t0_ctl1 rwl_3__t0_ctl1 rwl_3_ctl1 21.6897
rrwl_3_t1_ctl1 rwl_3__t1_ctl1 rwl_3_ctl1 7.22989
rrwl_3_t2_ctl1 rwl_3__t2_ctl1 rwl_3_ctl1 7.22989
rrwl_3_t3_ctl1 rwl_3__t3_ctl1 rwl_3_ctl1 21.6897
rsn_0_0_t0_ctl1 sn_0_0__t0_ctl1 sn_0_0_ctl1 125.123
rsn_0_0_t1_ctl1 sn_0_0__t1_ctl1 sn_0_0_ctl1 125.123
rsn_0_1_t0_ctl1 sn_0_1__t0_ctl1 sn_0_1_ctl1 125.123
rsn_0_1_t1_ctl1 sn_0_1__t1_ctl1 sn_0_1_ctl1 125.123
rsn_0_2_t0_ctl1 sn_0_2__t0_ctl1 sn_0_2_ctl1 125.123
rsn_0_2_t1_ctl1 sn_0_2__t1_ctl1 sn_0_2_ctl1 125.123
rsn_0_3_t0_ctl1 sn_0_3__t0_ctl1 sn_0_3_ctl1 125.123
rsn_0_3_t1_ctl1 sn_0_3__t1_ctl1 sn_0_3_ctl1 125.123
rsn_1_0_t0_ctl1 sn_1_0__t0_ctl1 sn_1_0_ctl1 125.123
rsn_1_0_t1_ctl1 sn_1_0__t1_ctl1 sn_1_0_ctl1 125.123
rsn_1_1_t0_ctl1 sn_1_1__t0_ctl1 sn_1_1_ctl1 125.123
rsn_1_1_t1_ctl1 sn_1_1__t1_ctl1 sn_1_1_ctl1 125.123
rsn_1_2_t0_ctl1 sn_1_2__t0_ctl1 sn_1_2_ctl1 125.123
rsn_1_2_t1_ctl1 sn_1_2__t1_ctl1 sn_1_2_ctl1 125.123
rsn_1_3_t0_ctl1 sn_1_3__t0_ctl1 sn_1_3_ctl1 125.123
rsn_1_3_t1_ctl1 sn_1_3__t1_ctl1 sn_1_3_ctl1 125.123
rsn_2_0_t0_ctl1 sn_2_0__t0_ctl1 sn_2_0_ctl1 125.123
rsn_2_0_t1_ctl1 sn_2_0__t1_ctl1 sn_2_0_ctl1 125.123
rsn_2_1_t0_ctl1 sn_2_1__t0_ctl1 sn_2_1_ctl1 125.123
rsn_2_1_t1_ctl1 sn_2_1__t1_ctl1 sn_2_1_ctl1 125.123
rsn_2_2_t0_ctl1 sn_2_2__t0_ctl1 sn_2_2_ctl1 125.123
rsn_2_2_t1_ctl1 sn_2_2__t1_ctl1 sn_2_2_ctl1 125.123
rsn_2_3_t0_ctl1 sn_2_3__t0_ctl1 sn_2_3_ctl1 125.123
rsn_2_3_t1_ctl1 sn_2_3__t1_ctl1 sn_2_3_ctl1 125.123
rsn_3_0_t0_ctl1 sn_3_0__t0_ctl1 sn_3_0_ctl1 125.123
rsn_3_0_t1_ctl1 sn_3_0__t1_ctl1 sn_3_0_ctl1 125.123
rsn_3_1_t0_ctl1 sn_3_1__t0_ctl1 sn_3_1_ctl1 125.123
rsn_3_1_t1_ctl1 sn_3_1__t1_ctl1 sn_3_1_ctl1 125.123
rsn_3_2_t0_ctl1 sn_3_2__t0_ctl1 sn_3_2_ctl1 125.123
rsn_3_2_t1_ctl1 sn_3_2__t1_ctl1 sn_3_2_ctl1 125.123
rsn_3_3_t0_ctl1 sn_3_3__t0_ctl1 sn_3_3_ctl1 125.123
rsn_3_3_t1_ctl1 sn_3_3__t1_ctl1 sn_3_3_ctl1 125.123
rwl_0_t0_ctl1 wl_0__t0_ctl1 wl_0_ctl1 54.2844
rwl_0_t1_ctl1 wl_0__t1_ctl1 wl_0_ctl1 54.2844
rwl_0_t2_ctl1 wl_0__t2_ctl1 wl_0_ctl1 162.853
rwl_0_t3_ctl1 wl_0__t3_ctl1 wl_0_ctl1 162.853
rwl_1_t0_ctl1 wl_1__t0_ctl1 wl_1_ctl1 162.853
rwl_1_t1_ctl1 wl_1__t1_ctl1 wl_1_ctl1 54.2844
rwl_1_t2_ctl1 wl_1__t2_ctl1 wl_1_ctl1 54.2844
rwl_1_t3_ctl1 wl_1__t3_ctl1 wl_1_ctl1 162.853
rwl_2_t0_ctl1 wl_2__t0_ctl1 wl_2_ctl1 54.2844
rwl_2_t1_ctl1 wl_2__t1_ctl1 wl_2_ctl1 54.2844
rwl_2_t2_ctl1 wl_2__t2_ctl1 wl_2_ctl1 162.853
rwl_2_t3_ctl1 wl_2__t3_ctl1 wl_2_ctl1 162.853
rwl_3_t0_ctl1 wl_3__t0_ctl1 wl_3_ctl1 162.853
rwl_3_t1_ctl1 wl_3__t1_ctl1 wl_3_ctl1 54.2844
rwl_3_t2_ctl1 wl_3__t2_ctl1 wl_3_ctl1 54.2844
rwl_3_t3_ctl1 wl_3__t3_ctl1 wl_3_ctl1 162.853
cgnd_ctl1 0 0 4.09475e-15
cbl_0_ctl1 bl_0_ctl1 0 5.96076e-16
cbl_1_ctl1 bl_1_ctl1 0 5.81168e-16
cbl_2_ctl1 bl_2_ctl1 0 5.81168e-16
cbl_3_ctl1 bl_3_ctl1 0 5.81168e-16
crbl_0_ctl1 rbl_0_ctl1 0 5.81168e-16
crbl_1_ctl1 rbl_1_ctl1 0 5.81168e-16
crbl_2_ctl1 rbl_2_ctl1 0 5.81168e-16
crbl_3_ctl1 rbl_3_ctl1 0 5.96076e-16
crwl_0_ctl1 rwl_0_ctl1 0 1.18713e-15
crwl_1_ctl1 rwl_1_ctl1 0 1.18713e-15
crwl_2_ctl1 rwl_2_ctl1 0 1.18713e-15
crwl_3_ctl1 rwl_3_ctl1 0 1.18713e-15
csn_0_0_ctl1 sn_0_0_ctl1 0 4.33689e-16
csn_0_1_ctl1 sn_0_1_ctl1 0 4.30576e-16
csn_0_2_ctl1 sn_0_2_ctl1 0 4.30576e-16
csn_0_3_ctl1 sn_0_3_ctl1 0 4.32518e-16
csn_1_0_ctl1 sn_1_0_ctl1 0 4.33689e-16
csn_1_1_ctl1 sn_1_1_ctl1 0 4.30576e-16
csn_1_2_ctl1 sn_1_2_ctl1 0 4.30576e-16
csn_1_3_ctl1 sn_1_3_ctl1 0 4.32518e-16
csn_2_0_ctl1 sn_2_0_ctl1 0 4.33689e-16
csn_2_1_ctl1 sn_2_1_ctl1 0 4.30576e-16
csn_2_2_ctl1 sn_2_2_ctl1 0 4.30576e-16
csn_2_3_ctl1 sn_2_3_ctl1 0 4.32518e-16
csn_3_0_ctl1 sn_3_0_ctl1 0 4.33689e-16
csn_3_1_ctl1 sn_3_1_ctl1 0 4.30576e-16
csn_3_2_ctl1 sn_3_2_ctl1 0 4.30576e-16
csn_3_3_ctl1 sn_3_3_ctl1 0 4.32518e-16
cwl_0_ctl1 wl_0_ctl1 0 1.90928e-15
cwl_1_ctl1 wl_1_ctl1 0 1.90928e-15
cwl_2_ctl1 wl_2_ctl1 0 1.90928e-15
cwl_3_ctl1 wl_3_ctl1 0 1.91375e-15
ccc_bl_0_sn_0_0_ctl1 bl_0_ctl1 sn_0_0_ctl1 1.071e-17
ccc_bl_0_sn_1_0_ctl1 bl_0_ctl1 sn_1_0_ctl1 1.071e-17
ccc_bl_0_sn_2_0_ctl1 bl_0_ctl1 sn_2_0_ctl1 1.071e-17
ccc_bl_0_sn_3_0_ctl1 bl_0_ctl1 sn_3_0_ctl1 1.071e-17
ccc_bl_0_wl_0_ctl1 bl_0_ctl1 wl_0_ctl1 2.4327e-17
ccc_bl_0_wl_1_ctl1 bl_0_ctl1 wl_1_ctl1 2.4327e-17
ccc_bl_0_wl_2_ctl1 bl_0_ctl1 wl_2_ctl1 2.4327e-17
ccc_bl_1_rbl_0_ctl1 bl_1_ctl1 rbl_0_ctl1 1.29795e-16
ccc_bl_1_rwl_0_ctl1 bl_1_ctl1 rwl_0_ctl1 9.028e-18
ccc_bl_1_rwl_1_ctl1 bl_1_ctl1 rwl_1_ctl1 9.028e-18
ccc_bl_1_rwl_2_ctl1 bl_1_ctl1 rwl_2_ctl1 9.028e-18
ccc_bl_1_rwl_3_ctl1 bl_1_ctl1 rwl_3_ctl1 9.028e-18
ccc_bl_1_sn_0_1_ctl1 bl_1_ctl1 sn_0_1_ctl1 1.071e-17
ccc_bl_1_sn_1_1_ctl1 bl_1_ctl1 sn_1_1_ctl1 1.071e-17
ccc_bl_1_sn_2_1_ctl1 bl_1_ctl1 sn_2_1_ctl1 1.071e-17
ccc_bl_1_sn_3_1_ctl1 bl_1_ctl1 sn_3_1_ctl1 1.071e-17
ccc_bl_1_wl_0_ctl1 bl_1_ctl1 wl_0_ctl1 2.7627e-17
ccc_bl_1_wl_1_ctl1 bl_1_ctl1 wl_1_ctl1 2.7627e-17
ccc_bl_1_wl_2_ctl1 bl_1_ctl1 wl_2_ctl1 2.7627e-17
ccc_bl_2_rbl_1_ctl1 bl_2_ctl1 rbl_1_ctl1 1.29795e-16
ccc_bl_2_rwl_0_ctl1 bl_2_ctl1 rwl_0_ctl1 9.028e-18
ccc_bl_2_rwl_1_ctl1 bl_2_ctl1 rwl_1_ctl1 9.028e-18
ccc_bl_2_rwl_2_ctl1 bl_2_ctl1 rwl_2_ctl1 9.028e-18
ccc_bl_2_rwl_3_ctl1 bl_2_ctl1 rwl_3_ctl1 9.028e-18
ccc_bl_2_sn_0_2_ctl1 bl_2_ctl1 sn_0_2_ctl1 1.071e-17
ccc_bl_2_sn_1_2_ctl1 bl_2_ctl1 sn_1_2_ctl1 1.071e-17
ccc_bl_2_sn_2_2_ctl1 bl_2_ctl1 sn_2_2_ctl1 1.071e-17
ccc_bl_2_sn_3_2_ctl1 bl_2_ctl1 sn_3_2_ctl1 1.071e-17
ccc_bl_2_wl_0_ctl1 bl_2_ctl1 wl_0_ctl1 2.7627e-17
ccc_bl_2_wl_1_ctl1 bl_2_ctl1 wl_1_ctl1 2.7627e-17
ccc_bl_2_wl_2_ctl1 bl_2_ctl1 wl_2_ctl1 2.7627e-17
ccc_bl_3_rbl_2_ctl1 bl_3_ctl1 rbl_2_ctl1 1.29795e-16
ccc_bl_3_rwl_0_ctl1 bl_3_ctl1 rwl_0_ctl1 9.028e-18
ccc_bl_3_rwl_1_ctl1 bl_3_ctl1 rwl_1_ctl1 9.028e-18
ccc_bl_3_rwl_2_ctl1 bl_3_ctl1 rwl_2_ctl1 9.028e-18
ccc_bl_3_rwl_3_ctl1 bl_3_ctl1 rwl_3_ctl1 9.028e-18
ccc_bl_3_sn_0_3_ctl1 bl_3_ctl1 sn_0_3_ctl1 1.071e-17
ccc_bl_3_sn_1_3_ctl1 bl_3_ctl1 sn_1_3_ctl1 1.071e-17
ccc_bl_3_sn_2_3_ctl1 bl_3_ctl1 sn_2_3_ctl1 1.071e-17
ccc_bl_3_sn_3_3_ctl1 bl_3_ctl1 sn_3_3_ctl1 1.071e-17
ccc_bl_3_wl_0_ctl1 bl_3_ctl1 wl_0_ctl1 2.7627e-17
ccc_bl_3_wl_1_ctl1 bl_3_ctl1 wl_1_ctl1 2.7627e-17
ccc_bl_3_wl_2_ctl1 bl_3_ctl1 wl_2_ctl1 2.7627e-17
ccc_rbl_0_rwl_0_ctl1 rbl_0_ctl1 rwl_0_ctl1 1.9738e-17
ccc_rbl_0_rwl_1_ctl1 rbl_0_ctl1 rwl_1_ctl1 1.9738e-17
ccc_rbl_0_rwl_2_ctl1 rbl_0_ctl1 rwl_2_ctl1 1.9738e-17
ccc_rbl_0_rwl_3_ctl1 rbl_0_ctl1 rwl_3_ctl1 1.9738e-17
ccc_rbl_0_sn_0_0_ctl1 rbl_0_ctl1 sn_0_0_ctl1 1.071e-17
ccc_rbl_0_sn_1_0_ctl1 rbl_0_ctl1 sn_1_0_ctl1 2.4327e-17
ccc_rbl_0_sn_2_0_ctl1 rbl_0_ctl1 sn_2_0_ctl1 2.4327e-17
ccc_rbl_0_wl_0_ctl1 rbl_0_ctl1 wl_0_ctl1 3.3e-18
ccc_rbl_0_wl_1_ctl1 rbl_0_ctl1 wl_1_ctl1 3.3e-18
ccc_rbl_0_wl_2_ctl1 rbl_0_ctl1 wl_2_ctl1 3.3e-18
ccc_rbl_1_rwl_0_ctl1 rbl_1_ctl1 rwl_0_ctl1 1.9738e-17
ccc_rbl_1_rwl_1_ctl1 rbl_1_ctl1 rwl_1_ctl1 1.9738e-17
ccc_rbl_1_rwl_2_ctl1 rbl_1_ctl1 rwl_2_ctl1 1.9738e-17
ccc_rbl_1_rwl_3_ctl1 rbl_1_ctl1 rwl_3_ctl1 1.9738e-17
ccc_rbl_1_sn_0_1_ctl1 rbl_1_ctl1 sn_0_1_ctl1 1.071e-17
ccc_rbl_1_sn_1_1_ctl1 rbl_1_ctl1 sn_1_1_ctl1 2.4327e-17
ccc_rbl_1_sn_2_1_ctl1 rbl_1_ctl1 sn_2_1_ctl1 2.4327e-17
ccc_rbl_1_wl_0_ctl1 rbl_1_ctl1 wl_0_ctl1 3.3e-18
ccc_rbl_1_wl_1_ctl1 rbl_1_ctl1 wl_1_ctl1 3.3e-18
ccc_rbl_1_wl_2_ctl1 rbl_1_ctl1 wl_2_ctl1 3.3e-18
ccc_rbl_2_rwl_0_ctl1 rbl_2_ctl1 rwl_0_ctl1 1.9738e-17
ccc_rbl_2_rwl_1_ctl1 rbl_2_ctl1 rwl_1_ctl1 1.9738e-17
ccc_rbl_2_rwl_2_ctl1 rbl_2_ctl1 rwl_2_ctl1 1.9738e-17
ccc_rbl_2_rwl_3_ctl1 rbl_2_ctl1 rwl_3_ctl1 1.9738e-17
ccc_rbl_2_sn_0_2_ctl1 rbl_2_ctl1 sn_0_2_ctl1 1.071e-17
ccc_rbl_2_sn_1_2_ctl1 rbl_2_ctl1 sn_1_2_ctl1 2.4327e-17
ccc_rbl_2_sn_2_2_ctl1 rbl_2_ctl1 sn_2_2_ctl1 2.4327e-17
ccc_rbl_2_wl_0_ctl1 rbl_2_ctl1 wl_0_ctl1 3.3e-18
ccc_rbl_2_wl_1_ctl1 rbl_2_ctl1 wl_1_ctl1 3.3e-18
ccc_rbl_2_wl_2_ctl1 rbl_2_ctl1 wl_2_ctl1 3.3e-18
ccc_rbl_3_rwl_0_ctl1 rbl_3_ctl1 rwl_0_ctl1 1.071e-17
ccc_rbl_3_rwl_1_ctl1 rbl_3_ctl1 rwl_1_ctl1 1.071e-17
ccc_rbl_3_rwl_2_ctl1 rbl_3_ctl1 rwl_2_ctl1 1.071e-17
ccc_rbl_3_rwl_3_ctl1 rbl_3_ctl1 rwl_3_ctl1 1.071e-17
ccc_rbl_3_sn_0_3_ctl1 rbl_3_ctl1 sn_0_3_ctl1 1.071e-17
ccc_rbl_3_sn_1_3_ctl1 rbl_3_ctl1 sn_1_3_ctl1 2.4327e-17
ccc_rbl_3_sn_2_3_ctl1 rbl_3_ctl1 sn_2_3_ctl1 2.4327e-17
ccc_rwl_0_sn_0_0_ctl1 rwl_0_ctl1 sn_0_0_ctl1 1.0072e-17
ccc_rwl_0_sn_0_1_ctl1 rwl_0_ctl1 sn_0_1_ctl1 1.9682e-17
ccc_rwl_0_sn_0_2_ctl1 rwl_0_ctl1 sn_0_2_ctl1 1.9682e-17
ccc_rwl_0_sn_0_3_ctl1 rwl_0_ctl1 sn_0_3_ctl1 1.9682e-17
ccc_rwl_1_sn_1_0_ctl1 rwl_1_ctl1 sn_1_0_ctl1 1.0072e-17
ccc_rwl_1_sn_1_1_ctl1 rwl_1_ctl1 sn_1_1_ctl1 1.9682e-17
ccc_rwl_1_sn_1_2_ctl1 rwl_1_ctl1 sn_1_2_ctl1 1.9682e-17
ccc_rwl_1_sn_1_3_ctl1 rwl_1_ctl1 sn_1_3_ctl1 1.9682e-17
ccc_rwl_2_sn_2_0_ctl1 rwl_2_ctl1 sn_2_0_ctl1 1.0072e-17
ccc_rwl_2_sn_2_1_ctl1 rwl_2_ctl1 sn_2_1_ctl1 1.9682e-17
ccc_rwl_2_sn_2_2_ctl1 rwl_2_ctl1 sn_2_2_ctl1 1.9682e-17
ccc_rwl_2_sn_2_3_ctl1 rwl_2_ctl1 sn_2_3_ctl1 1.9682e-17
ccc_rwl_3_sn_3_0_ctl1 rwl_3_ctl1 sn_3_0_ctl1 1.0072e-17
ccc_rwl_3_sn_3_1_ctl1 rwl_3_ctl1 sn_3_1_ctl1 1.9682e-17
ccc_rwl_3_sn_3_2_ctl1 rwl_3_ctl1 sn_3_2_ctl1 1.9682e-17
ccc_rwl_3_sn_3_3_ctl1 rwl_3_ctl1 sn_3_3_ctl1 1.9682e-17
ccc_sn_0_0_wl_0_ctl1 sn_0_0_ctl1 wl_0_ctl1 1.9664e-17
ccc_sn_0_1_wl_0_ctl1 sn_0_1_ctl1 wl_0_ctl1 1.9664e-17
ccc_sn_0_2_wl_0_ctl1 sn_0_2_ctl1 wl_0_ctl1 1.9664e-17
ccc_sn_0_3_wl_0_ctl1 sn_0_3_ctl1 wl_0_ctl1 1.3668e-17
ccc_sn_1_0_wl_1_ctl1 sn_1_0_ctl1 wl_1_ctl1 1.9664e-17
ccc_sn_1_1_wl_1_ctl1 sn_1_1_ctl1 wl_1_ctl1 1.6705e-17
ccc_sn_1_2_wl_1_ctl1 sn_1_2_ctl1 wl_1_ctl1 1.6705e-17
ccc_sn_1_3_wl_1_ctl1 sn_1_3_ctl1 wl_1_ctl1 1.071e-17
ccc_sn_2_0_wl_2_ctl1 sn_2_0_ctl1 wl_2_ctl1 1.9664e-17
ccc_sn_2_1_wl_2_ctl1 sn_2_1_ctl1 wl_2_ctl1 1.6705e-17
ccc_sn_2_2_wl_2_ctl1 sn_2_2_ctl1 wl_2_ctl1 1.6705e-17
ccc_sn_2_3_wl_2_ctl1 sn_2_3_ctl1 wl_2_ctl1 1.071e-17
ccc_sn_3_0_wl_3_ctl1 sn_3_0_ctl1 wl_3_ctl1 1.9664e-17
ccc_sn_3_1_wl_3_ctl1 sn_3_1_ctl1 wl_3_ctl1 1.6705e-17
ccc_sn_3_2_wl_3_ctl1 sn_3_2_ctl1 wl_3_ctl1 1.6705e-17
ccc_sn_3_3_wl_3_ctl1 sn_3_3_ctl1 wl_3_ctl1 1.071e-17
vdw_ctl1_0 wl_0_ctl1 0 dc 0
vdr_ctl1_0 rwl_0_ctl1 vdd dc 0
vdw_ctl1_1 wl_1_ctl1 0 dc 0
vdr_ctl1_1 rwl_1_ctl1 vdd dc 0
vdw_ctl1_2 wl_2_ctl1 0 dc 0
vdr_ctl1_2 rwl_2_ctl1 vdd dc 0
vdw_ctl1_3 wl_3_ctl1 0 dc 0
vdr_ctl1_3 rwl_3_ctl1 vdd dc 0
vdb_ctl1_0 bl_0_ctl1 vdd dc 0
vdp_ctl1_0 rbl_0_ctl1 vrbl dc 0
vdb_ctl1_1 bl_1_ctl1 vdd dc 0
vdp_ctl1_1 rbl_1_ctl1 vrbl dc 0
vdb_ctl1_2 bl_2_ctl1 vdd dc 0
vdp_ctl1_2 rbl_2_ctl1 vrbl dc 0
vdb_ctl1_3 bl_3_ctl1 vdd dc 0
vdp_ctl1_3 rbl_3_ctl1 vrbl dc 0

* ---- instance rep1: family rep1 ----
xm1_rep1 sn_0_0__t0_rep1 wl_0__t3_rep1 bl_0__t0_rep1 gnd__t0_rep1 sky130_fd_pr__nfet_01v8 L=0.15 W=0.42 nf=1 ad=0.1974 as=0.1974 pd=1.78 ps=1.78 mult=1 m=1
xm2_rep1 rbl_0__t0_rep1 sn_0_0__t1_rep1 rwl_0__t0_rep1 gnd__t1_rep1 sky130_fd_pr__nfet_01v8 L=0.15 W=0.42 nf=1 ad=0.1974 as=0.1974 pd=1.78 ps=1.78 mult=1 m=1
xm3_rep1 sn_0_1__t1_rep1 wl_0__t0_rep1 bl_1__t0_rep1 gnd__t2_rep1 sky130_fd_pr__nfet_01v8 L=0.15 W=0.42 nf=1 ad=0.1974 as=0.1974 pd=1.78 ps=1.78 mult=1 m=1
xm4_rep1 rbl_1__t0_rep1 sn_0_1__t0_rep1 rwl_0__t1_rep1 gnd__t3_rep1 sky130_fd_pr__nfet_01v8 L=0.15 W=0.42 nf=1 ad=0.1974 as=0.1974 pd=1.78 ps=1.78 mult=1 m=1
xm5_rep1 sn_0_2__t1_rep1 wl_0__t1_rep1 bl_2__t0_rep1 gnd__t4_rep1 sky130_fd_pr__nfet_01v8 L=0.15 W=0.42 nf=1 ad=0.1974 as=0.1974 pd=1.78 ps=1.78 mult=1 m=1
xm6_rep1 rbl_2__t0_rep1 sn_0_2__t0_rep1 rwl_0__t2_rep1 gnd__t5_rep1 sky130_fd_pr__nfet_01v8 L=0.15 W=0.42 nf=1 ad=0.1974 as=0.1974 pd=1.78 ps=1.78 mult=1 m=1
xm7_rep1 sn_0_3__t1_rep1 wl_0__t2_rep1 bl_3__t0_rep1 gnd__t6_rep1 sky130_fd_pr__nfet_01v8 L=0.15 W=0.42 nf=1 ad=0.1974 as=0.1974 pd=1.78 ps=1.78 mult=1 m=1
xm8_rep1 rbl_3__t0_rep1 sn_0_3__t0_rep1 rwl_0__t3_rep1 gnd__t7_rep1 sky130_fd_pr__nfet_01v8 L=0.15 W=0.42 nf=1 ad=0.1974 as=0.1974 pd=1.78 ps=1.78 mult=1 m=1
xm9_rep1 sn_1_0__t1_rep1 wl_1__t0_rep1 bl_0__t1_rep1 gnd__t8_rep1 sky130_fd_pr__nfet_01v8 L=0.15 W=0.42 nf=1 ad=0.1974 as=0.1974 pd=1.78 ps=1.78 mult=1 m=1
xm10_rep1 rbl_0__t1_rep1 sn_1_0__t0_rep1 rwl_1__t0_rep1 gnd__t9_rep1 sky130_fd_pr__nfet_01v8 L=0.15 W=0.42 nf=1 ad=0.1974 as=0.1974 pd=1.78 ps=1.78 mult=1 m=1
xm11_rep1 sn_1_1__t1_rep1 wl_1__t1_rep1 bl_1__t1_rep1 gnd__t10_rep1 sky130_fd_pr__nfet_01v8 L=0.15 W=0.42 nf=1 ad=0.1974 as=0.1974 pd=1.78 ps=1.78 mult=1 m=1
xm12_rep1 rbl_1__t1_rep1 sn_1_1__t0_rep1 rwl_1__t1_rep1 gnd__t11_rep1 sky130_fd_pr__nfet_01v8 L=0.15 W=0.42 nf=1 ad=0.1974 as=0.1974 pd=1.78 ps=1.78 mult=1 m=1
xm13_rep1 sn_1_2__t1_rep1 wl_1__t2_rep1 bl_2__t1_rep1 gnd__t12_rep1 sky130_fd_pr__nfet_01v8 L=0.15 W=0.42 nf=1 ad=0.1974 as=0.1974 pd=1.78 ps=1.78 mult=1 m=1
xm14_rep1 rbl_2__t1_rep1 sn_1_2__t0_rep1 rwl_1__t2_rep1 gnd__t13_rep1 sky130_fd_pr__nfet_01v8 L=0.15 W=0.42 nf=1 ad=0.1974 as=0.1974 pd=1.78 ps=1.78 mult=1 m=1
xm15_rep1 sn_1_3__t1_rep1 wl_1__t3_rep1 bl_3__t1_rep1 gnd__t14_rep1 sky130_fd_pr__nfet_01v8 L=0.15 W=0.42 nf=1 ad=0.1974 as=0.1974 pd=1.78 ps=1.78 mult=1 m=1
xm16_rep1 rbl_3__t1_rep1 sn_1_3__t0_rep1 rwl_1__t3_rep1 gnd__t15_rep1 sky130_fd_pr__nfet_01v8 L=0.15 W=0.42 nf=1 ad=0.1974 as=0.1974 pd=1.78 ps=1.78 mult=1 m=1
xm17_rep1 sn_2_0__t1_rep1 wl_2__t3_rep1 bl_0__t3_rep1 gnd__t16_rep1 sky130_fd_pr__nfet_01v8 L=0.15 W=0.42 nf=1 ad=0.1974 as=0.1974 pd=1.78 ps=1.78 mult=1 m=1
xm18_rep1 rbl_0__t2_rep1 sn_2_0__t0_rep1 rwl_2__t0_rep1 gnd__t17_rep1 sky130_fd_pr__nfet_01v8 L=0.15 W=0.42 nf=1 ad=0.1974 as=0.1974 pd=1.78 ps=1.78 mult=1 m=1
xm19_rep1 sn_2_1__t1_rep1 wl_2__t0_rep1 bl_1__t2_rep1 gnd__t18_rep1 sky130_fd_pr__nfet_01v8 L=0.15 W=0.42 nf=1 ad=0.1974 as=0.1974 pd=1.78 ps=1.78 mult=1 m=1
xm20_rep1 rbl_1__t2_rep1 sn_2_1__t0_rep1 rwl_2__t1_rep1 gnd__t19_rep1 sky130_fd_pr__nfet_01v8 L=0.15 W=0.42 nf=1 ad=0.1974 as=0.1974 pd=1.78 ps=1.78 mult=1 m=1
xm21_rep1 sn_2_2__t1_rep1 wl_2__t1_rep1 bl_2__t2_rep1 gnd__t20_rep1 sky130_fd_pr__nfet_01v8 L=0.15 W=0.42 nf=1 ad=0.1974 as=0.1974 pd=1.78 ps=1.78 mult=1 m=1
xm22_rep1 rbl_2__t2_rep1 sn_2_2__t0_rep1 rwl_2__t2_rep1 gnd__t21_rep1 sky130_fd_pr__nfet_01v8 L=0.15 W=0.42 nf=1 ad=0.1974 as=0.1974 pd=1.78 ps=1.78 mult=1 m=1
xm23_rep1 sn_2_3__t1_rep1 wl_2__t2_rep1 bl_3__t2_rep1 gnd__t22_rep1 sky130_fd_pr__nfet_01v8 L=0.15 W=0.42 nf=1 ad=0.1974 as=0.1974 pd=1.78 ps=1.78 mult=1 m=1
xm24_rep1 rbl_3__t2_rep1 sn_2_3__t0_rep1 rwl_2__t3_rep1 gnd__t23_rep1 sky130_fd_pr__nfet_01v8 L=0.15 W=0.42 nf=1 ad=0.1974 as=0.1974 pd=1.78 ps=1.78 mult=1 m=1
xm25_rep1 sn_3_0__t1_rep1 wl_3__t0_rep1 bl_0__t2_rep1 gnd__t24_rep1 sky130_fd_pr__nfet_01v8 L=0.15 W=0.42 nf=1 ad=0.1974 as=0.1974 pd=1.78 ps=1.78 mult=1 m=1
xm26_rep1 rbl_0__t3_rep1 sn_3_0__t0_rep1 rwl_3__t0_rep1 gnd__t25_rep1 sky130_fd_pr__nfet_01v8 L=0.15 W=0.42 nf=1 ad=0.1974 as=0.1974 pd=1.78 ps=1.78 mult=1 m=1
xm27_rep1 sn_3_1__t1_rep1 wl_3__t1_rep1 bl_1__t3_rep1 gnd__t26_rep1 sky130_fd_pr__nfet_01v8 L=0.15 W=0.42 nf=1 ad=0.1974 as=0.1974 pd=1.78 ps=1.78 mult=1 m=1
xm28_rep1 rbl_1__t3_rep1 sn_3_1__t0_rep1 rwl_3__t1_rep1 gnd__t27_rep1 sky130_fd_pr__nfet_01v8 L=0.15 W=0.42 nf=1 ad=0.1974 as=0.1974 pd=1.78 ps=1.78 mult=1 m=1
xm29_rep1 sn_3_2__t1_rep1 wl_3__t2_rep1 bl_2__t3_rep1 gnd__t28_rep1 sky130_fd_pr__nfet_01v8 L=0.15 W=0.42 nf=1 ad=0.1974 as=0.1974 pd=1.78 ps=1.78 mult=1 m=1
xm30_rep1 rbl_2__t3_rep1 sn_3_2__t0_rep1 rwl_3__t2_rep1 gnd__t29_rep1 sky130_fd_pr__nfet_01v8 L=0.15 W=0.42 nf=1 ad=0.1974 as=0.1974 pd=1.78 ps=1.78 mult=1 m=1
xm31_rep1 sn_3_3__t1_rep1 wl_3__t3_rep1 bl_3__t3_rep1 gnd__t30_rep1 sky130_fd_pr__nfet_01v8 L=0.15 W=0.42 nf=1 ad=0.1974 as=0.1974 pd=1.78 ps=1.78 mult=1 m=1
xm32_rep1 rbl_3__t3_rep1 sn_3_3__t0_rep1 rwl_3__t3_rep1 gnd__t31_rep1 sky130_fd_pr__nfet_01v8 L=0.15 W=0.42 nf=1 ad=0.1974 as=0.1974 pd=1.78 ps=1.78 mult=1 m=1
rgnd_t0_rep1 gnd__t0_rep1 0 63.3529
rgnd_t1_rep1 gnd__t1_rep1 0 49.0465
rgnd_t2_rep1 gnd__t2_rep1 0 36.5177
rgnd_t3_rep1 gnd__t3_rep1 0 28.2406
rgnd_t4_rep1 gnd__t4_rep1 0 28.2406
rgnd_t5_rep1 gnd__t5_rep1 0 36.5177
rgnd_t6_rep1 gnd__t6_rep1 0 49.0465
rgnd_t7_rep1 gnd__t7_rep1 0 63.3529
rgnd_t8_rep1 gnd__t8_rep1 0 58.0019
rgnd_t9_rep1 gnd__t9_rep1 0 41.907
rgnd_t10_rep1 gnd__t10_rep1 0 26.1568
rgnd_t11_rep1 gnd__t11_rep1 0 12.1726
rgnd_t12_rep1 gnd__t12_rep1 0 12.1726
rgnd_t13_rep1 gnd__t13_rep1 0 26.1568
rgnd_t14_rep1 gnd__t14_rep1 0 41.907
rgnd_t15_rep1 gnd__t15_rep1 0 58.0019
rgnd_t16_rep1 gnd__t16_rep1 0 58.0019
rgnd_t17_rep1 gnd__t17_rep1 0 41.907
rgnd_t18_rep1 gnd__t18_rep1 0 26.1568
rgnd_t19_rep1 gnd__t19_rep1 0 12.1726
rgnd_t20_rep1 gnd__t20_rep1 0 12.1726
rgnd_t21_rep1 gnd__t21_rep1 0 26.1568
rgnd_t22_rep1 gnd__t22_rep1 0 41.907
rgnd_t23_rep1 gnd__t23_rep1 0 58.0019
rgnd_t24_rep1 gnd__t24_rep1 0 63.3529
rgnd_t25_rep1 gnd__t25_rep1 0 49.0465
rgnd_t26_rep1 gnd__t26_rep1 0 36.5177
rgnd_t27_rep1 gnd__t27_rep1 0 28.2406
rgnd_t28_rep1 gnd__t28_rep1 0 28.2406
rgnd_t29_rep1 gnd__t29_rep1 0 36.5177
rgnd_t30_rep1 gnd__t30_rep1 0 49.0465
rgnd_t31_rep1 gnd__t31_rep1 0 63.3529
rbl_0_t0_rep1 bl_0__t0_rep1 bl_0_rep1 144.555
rbl_0_t1_rep1 bl_0__t1_rep1 bl_0_rep1 48.1851
rbl_0_t2_rep1 bl_0__t2_rep1 bl_0_rep1 144.555
rbl_0_t3_rep1 bl_0__t3_rep1 bl_0_rep1 48.1851
rbl_1_t0_rep1 bl_1__t0_rep1 bl_1_rep1 144.555
rbl_1_t1_rep1 bl_1__t1_rep1 bl_1_rep1 48.1851
rbl_1_t2_rep1 bl_1__t2_rep1 bl_1_rep1 48.1851
rbl_1_t3_rep1 bl_1__t3_rep1 bl_1_rep1 144.555
rbl_2_t0_rep1 bl_2__t0_rep1 bl_2_rep1 144.555
rbl_2_t1_rep1 bl_2__t1_rep1 bl_2_rep1 48.1851
rbl_2_t2_rep1 bl_2__t2_rep1 bl_2_rep1 48.1851
rbl_2_t3_rep1 bl_2__t3_rep1 bl_2_rep1 144.555
rbl_3_t0_rep1 bl_3__t0_rep1 bl_3_rep1 144.555
rbl_3_t1_rep1 bl_3__t1_rep1 bl_3_rep1 48.1851
rbl_3_t2_rep1 bl_3__t2_rep1 bl_3_rep1 48.1851
rbl_3_t3_rep1 bl_3__t3_rep1 bl_3_rep1 144.555
rrbl_0_t0_rep1 rbl_0__t0_rep1 rbl_0_rep1 144.555
rrbl_0_t1_rep1 rbl_0__t1_rep1 rbl_0_rep1 48.1851
rrbl_0_t2_rep1 rbl_0__t2_rep1 rbl_0_rep1 48.1851
rrbl_0_t3_rep1 rbl_0__t3_rep1 rbl_0_rep1 144.555
rrbl_1_t0_rep1 rbl_1__t0_rep1 rbl_1_rep1 144.555
rrbl_1_t1_rep1 rbl_1__t1_rep1 rbl_1_rep1 48.1851
rrbl_1_t2_rep1 rbl_1__t2_rep1 rbl_1_rep1 48.1851
rrbl_1_t3_rep1 rbl_1__t3_rep1 rbl_1_rep1 144.555
rrbl_2_t0_rep1 rbl_2__t0_rep1 rbl_2_rep1 144.555
rrbl_2_t1_rep1 rbl_2__t1_rep1 rbl_2_rep1 48.1851
rrbl_2_t2_rep1 rbl_2__t2_rep1 rbl_2_rep1 48.1851
rrbl_2_t3_rep1 rbl_2__t3_rep1 rbl_2_rep1 144.555
rrbl_3_t0_rep1 rbl_3__t0_rep1 rbl_3_rep1 144.555
rrbl_3_t1_rep1 rbl_3__t1_rep1 rbl_3_rep1 48.1851
rrbl_3_t2_rep1 rbl_3__t2_rep1 rbl_3_rep1 48.1851
rrbl_3_t3_rep1 rbl_3__t3_rep1 rbl_3_rep1 144.555
rrwl_0_t0_rep1 rwl_0__t0_rep1 rwl_0_rep1 21.6897
rrwl_0_t1_rep1 rwl_0__t1_rep1 rwl_0_rep1 7.22989
rrwl_0_t2_rep1 rwl_0__t2_rep1 rwl_0_rep1 7.22989
rrwl_0_t3_rep1 rwl_0__t3_rep1 rwl_0_rep1 21.6897
rrwl_1_t0_rep1 rwl_1__t0_rep1 rwl_1_rep1 21.6897
rrwl_1_t1_rep1 rwl_1__t1_rep1 rwl_1_rep1 7.22989
rrwl_1_t2_rep1 rwl_1__t2_rep1 rwl_1_rep1 7.22989
rrwl_1_t3_rep1 rwl_1__t3_rep1 rwl_1_rep1 21.6897
rrwl_2_t0_rep1 rwl_2__t0_rep1 rwl_2_rep1 21.6897
rrwl_2_t1_rep1 rwl_2__t1_rep1 rwl_2_rep1 7.22989
rrwl_2_t2_rep1 rwl_2__t2_rep1 rwl_2_rep1 7.22989
rrwl_2_t3_rep1 rwl_2__t3_rep1 rwl_2_rep1 21.6897
rrwl_3_t0_rep1 rwl_3__t0_rep1 rwl_3_rep1 21.6897
rrwl_3_t1_rep1 rwl_3__t1_rep1 rwl_3_rep1 7.22989
rrwl_3_t2_rep1 rwl_3__t2_rep1 rwl_3_rep1 7.22989
rrwl_3_t3_rep1 rwl_3__t3_rep1 rwl_3_rep1 21.6897
rsn_0_0_t0_rep1 sn_0_0__t0_rep1 sn_0_0_rep1 125.123
rsn_0_0_t1_rep1 sn_0_0__t1_rep1 sn_0_0_rep1 125.123
rsn_0_1_t0_rep1 sn_0_1__t0_rep1 sn_0_1_rep1 125.123
rsn_0_1_t1_rep1 sn_0_1__t1_rep1 sn_0_1_rep1 125.123
rsn_0_2_t0_rep1 sn_0_2__t0_rep1 sn_0_2_rep1 125.123
rsn_0_2_t1_rep1 sn_0_2__t1_rep1 sn_0_2_rep1 125.123
rsn_0_3_t0_rep1 sn_0_3__t0_rep1 sn_0_3_rep1 125.123
rsn_0_3_t1_rep1 sn_0_3__t1_rep1 sn_0_3_rep1 125.123
rsn_1_0_t0_rep1 sn_1_0__t0_rep1 sn_1_0_rep1 125.123
rsn_1_0_t1_rep1 sn_1_0__t1_rep1 sn_1_0_rep1 125.123
rsn_1_1_t0_rep1 sn_1_1__t0_rep1 sn_1_1_rep1 125.123
rsn_1_1_t1_rep1 sn_1_1__t1_rep1 sn_1_1_rep1 125.123
rsn_1_2_t0_rep1 sn_1_2__t0_rep1 sn_1_2_rep1 125.123
rsn_1_2_t1_rep1 sn_1_2__t1_rep1 sn_1_2_rep1 125.123
rsn_1_3_t0_rep1 sn_1_3__t0_rep1 sn_1_3_rep1 125.123
rsn_1_3_t1_rep1 sn_1_3__t1_rep1 sn_1_3_rep1 125.123
rsn_2_0_t0_rep1 sn_2_0__t0_rep1 sn_2_0_rep1 125.123
rsn_2_0_t1_rep1 sn_2_0__t1_rep1 sn_2_0_rep1 125.123
rsn_2_1_t0_rep1 sn_2_1__t0_rep1 sn_2_1_rep1 125.123
rsn_2_1_t1_rep1 sn_2_1__t1_rep1 sn_2_1_rep1 125.123
rsn_2_2_t0_rep1 sn_2_2__t0_rep1 sn_2_2_rep1 125.123
rsn_2_2_t1_rep1 sn_2_2__t1_rep1 sn_2_2_rep1 125.123
rsn_2_3_t0_rep1 sn_2_3__t0_rep1 sn_2_3_rep1 125.123
rsn_2_3_t1_rep1 sn_2_3__t1_rep1 sn_2_3_rep1 125.123
rsn_3_0_t0_rep1 sn_3_0__t0_rep1 sn_3_0_rep1 125.123
rsn_3_0_t1_rep1 sn_3_0__t1_rep1 sn_3_0_rep1 125.123
rsn_3_1_t0_rep1 sn_3_1__t0_rep1 sn_3_1_rep1 125.123
rsn_3_1_t1_rep1 sn_3_1__t1_rep1 sn_3_1_rep1 125.123
rsn_3_2_t0_rep1 sn_3_2__t0_rep1 sn_3_2_rep1 125.123
rsn_3_2_t1_rep1 sn_3_2__t1_rep1 sn_3_2_rep1 125.123
rsn_3_3_t0_rep1 sn_3_3__t0_rep1 sn_3_3_rep1 125.123
rsn_3_3_t1_rep1 sn_3_3__t1_rep1 sn_3_3_rep1 125.123
rwl_0_t0_rep1 wl_0__t0_rep1 wl_0_rep1 54.2844
rwl_0_t1_rep1 wl_0__t1_rep1 wl_0_rep1 54.2844
rwl_0_t2_rep1 wl_0__t2_rep1 wl_0_rep1 162.853
rwl_0_t3_rep1 wl_0__t3_rep1 wl_0_rep1 162.853
rwl_1_t0_rep1 wl_1__t0_rep1 wl_1_rep1 162.853
rwl_1_t1_rep1 wl_1__t1_rep1 wl_1_rep1 54.2844
rwl_1_t2_rep1 wl_1__t2_rep1 wl_1_rep1 54.2844
rwl_1_t3_rep1 wl_1__t3_rep1 wl_1_rep1 162.853
rwl_2_t0_rep1 wl_2__t0_rep1 wl_2_rep1 54.2844
rwl_2_t1_rep1 wl_2__t1_rep1 wl_2_rep1 54.2844
rwl_2_t2_rep1 wl_2__t2_rep1 wl_2_rep1 162.853
rwl_2_t3_rep1 wl_2__t3_rep1 wl_2_rep1 162.853
rwl_3_t0_rep1 wl_3__t0_rep1 wl_3_rep1 162.853
rwl_3_t1_rep1 wl_3__t1_rep1 wl_3_rep1 54.2844
rwl_3_t2_rep1 wl_3__t2_rep1 wl_3_rep1 54.2844
rwl_3_t3_rep1 wl_3__t3_rep1 wl_3_rep1 162.853
cgnd_rep1 0 0 4.09475e-15
cbl_0_rep1 bl_0_rep1 0 5.96076e-16
cbl_1_rep1 bl_1_rep1 0 5.81168e-16
cbl_2_rep1 bl_2_rep1 0 5.81168e-16
cbl_3_rep1 bl_3_rep1 0 5.81168e-16
crbl_0_rep1 rbl_0_rep1 0 5.81168e-16
crbl_1_rep1 rbl_1_rep1 0 5.81168e-16
crbl_2_rep1 rbl_2_rep1 0 5.81168e-16
crbl_3_rep1 rbl_3_rep1 0 5.96076e-16
crwl_0_rep1 rwl_0_rep1 0 1.18713e-15
crwl_1_rep1 rwl_1_rep1 0 1.18713e-15
crwl_2_rep1 rwl_2_rep1 0 1.18713e-15
crwl_3_rep1 rwl_3_rep1 0 1.18713e-15
csn_0_0_rep1 sn_0_0_rep1 0 4.33689e-16
csn_0_1_rep1 sn_0_1_rep1 0 4.30576e-16
csn_0_2_rep1 sn_0_2_rep1 0 4.30576e-16
csn_0_3_rep1 sn_0_3_rep1 0 4.32518e-16
csn_1_0_rep1 sn_1_0_rep1 0 4.33689e-16
csn_1_1_rep1 sn_1_1_rep1 0 4.30576e-16
csn_1_2_rep1 sn_1_2_rep1 0 4.30576e-16
csn_1_3_rep1 sn_1_3_rep1 0 4.32518e-16
csn_2_0_rep1 sn_2_0_rep1 0 4.33689e-16
csn_2_1_rep1 sn_2_1_rep1 0 4.30576e-16
csn_2_2_rep1 sn_2_2_rep1 0 4.30576e-16
csn_2_3_rep1 sn_2_3_rep1 0 4.32518e-16
csn_3_0_rep1 sn_3_0_rep1 0 4.33689e-16
csn_3_1_rep1 sn_3_1_rep1 0 4.30576e-16
csn_3_2_rep1 sn_3_2_rep1 0 4.30576e-16
csn_3_3_rep1 sn_3_3_rep1 0 4.32518e-16
cwl_0_rep1 wl_0_rep1 0 1.90928e-15
cwl_1_rep1 wl_1_rep1 0 1.90928e-15
cwl_2_rep1 wl_2_rep1 0 1.90928e-15
cwl_3_rep1 wl_3_rep1 0 1.91375e-15
ccc_bl_0_sn_0_0_rep1 bl_0_rep1 sn_0_0_rep1 1.071e-17
ccc_bl_0_sn_1_0_rep1 bl_0_rep1 sn_1_0_rep1 1.071e-17
ccc_bl_0_sn_2_0_rep1 bl_0_rep1 sn_2_0_rep1 1.071e-17
ccc_bl_0_sn_3_0_rep1 bl_0_rep1 sn_3_0_rep1 1.071e-17
ccc_bl_0_wl_0_rep1 bl_0_rep1 wl_0_rep1 2.4327e-17
ccc_bl_0_wl_1_rep1 bl_0_rep1 wl_1_rep1 2.4327e-17
ccc_bl_0_wl_2_rep1 bl_0_rep1 wl_2_rep1 2.4327e-17
ccc_bl_1_rbl_0_rep1 bl_1_rep1 rbl_0_rep1 1.29795e-16
ccc_bl_1_rwl_0_rep1 bl_1_rep1 rwl_0_rep1 9.028e-18
ccc_bl_1_rwl_1_rep1 bl_1_rep1 rwl_1_rep1 9.028e-18
ccc_bl_1_rwl_2_rep1 bl_1_rep1 rwl_2_rep1 9.028e-18
ccc_bl_1_rwl_3_rep1 bl_1_rep1 rwl_3_rep1 9.028e-18
ccc_bl_1_sn_0_1_rep1 bl_1_rep1 sn_0_1_rep1 1.071e-17
ccc_bl_1_sn_1_1_rep1 bl_1_rep1 sn_1_1_rep1 1.071e-17
ccc_bl_1_sn_2_1_rep1 bl_1_rep1 sn_2_1_rep1 1.071e-17
ccc_bl_1_sn_3_1_rep1 bl_1_rep1 sn_3_1_rep1 1.071e-17
ccc_bl_1_wl_0_rep1 bl_1_rep1 wl_0_rep1 2.7627e-17
ccc_bl_1_wl_1_rep1 bl_1_rep1 wl_1_rep1 2.7627e-17
ccc_bl_1_wl_2_rep1 bl_1_rep1 wl_2_rep1 2.7627e-17
ccc_bl_2_rbl_1_rep1 bl_2_rep1 rbl_1_rep1 1.29795e-16
ccc_bl_2_rwl_0_rep1 bl_2_rep1 rwl_0_rep1 9.028e-18
ccc_bl_2_rwl_1_rep1 bl_2_rep1 rwl_1_rep1 9.028e-18
ccc_bl_2_rwl_2_rep1 bl_2_rep1 rwl_2_rep1 9.028e-18
ccc_bl_2_rwl_3_rep1 bl_2_rep1 rwl_3_rep1 9.028e-18
ccc_bl_2_sn_0_2_rep1 bl_2_rep1 sn_0_2_rep1 1.071e-17
ccc_bl_2_sn_1_2_rep1 bl_2_rep1 sn_1_2_rep1 1.071e-17
ccc_bl_2_sn_2_2_rep1 bl_2_rep1 sn_2_2_rep1 1.071e-17
ccc_bl_2_sn_3_2_rep1 bl_2_rep1 sn_3_2_rep1 1.071e-17
ccc_bl_2_wl_0_rep1 bl_2_rep1 wl_0_rep1 2.7627e-17
ccc_bl_2_wl_1_rep1 bl_2_rep1 wl_1_rep1 2.7627e-17
ccc_bl_2_wl_2_rep1 bl_2_rep1 wl_2_rep1 2.7627e-17
ccc_bl_3_rbl_2_rep1 bl_3_rep1 rbl_2_rep1 1.29795e-16
ccc_bl_3_rwl_0_rep1 bl_3_rep1 rwl_0_rep1 9.028e-18
ccc_bl_3_rwl_1_rep1 bl_3_rep1 rwl_1_rep1 9.028e-18
ccc_bl_3_rwl_2_rep1 bl_3_rep1 rwl_2_rep1 9.028e-18
ccc_bl_3_rwl_3_rep1 bl_3_rep1 rwl_3_rep1 9.028e-18
ccc_bl_3_sn_0_3_rep1 bl_3_rep1 sn_0_3_rep1 1.071e-17
ccc_bl_3_sn_1_3_rep1 bl_3_rep1 sn_1_3_rep1 1.071e-17
ccc_bl_3_sn_2_3_rep1 bl_3_rep1 sn_2_3_rep1 1.071e-17
ccc_bl_3_sn_3_3_rep1 bl_3_rep1 sn_3_3_rep1 1.071e-17
ccc_bl_3_wl_0_rep1 bl_3_rep1 wl_0_rep1 2.7627e-17
ccc_bl_3_wl_1_rep1 bl_3_rep1 wl_1_rep1 2.7627e-17
ccc_bl_3_wl_2_rep1 bl_3_rep1 wl_2_rep1 2.7627e-17
ccc_rbl_0_rwl_0_rep1 rbl_0_rep1 rwl_0_rep1 1.9738e-17
ccc_rbl_0_rwl_1_rep1 rbl_0_rep1 rwl_1_rep1 1.9738e-17
ccc_rbl_0_rwl_2_rep1 rbl_0_rep1 rwl_2_rep1 1.9738e-17
ccc_rbl_0_rwl_3_rep1 rbl_0_rep1 rwl_3_rep1 1.9738e-17
ccc_rbl_0_sn_0_0_rep1 rbl_0_rep1 sn_0_0_rep1 1.071e-17
ccc_rbl_0_sn_1_0_rep1 rbl_0_rep1 sn_1_0_rep1 2.4327e-17
ccc_rbl_0_sn_2_0_rep1 rbl_0_rep1 sn_2_0_rep1 2.4327e-17
ccc_rbl_0_wl_0_rep1 rbl_0_rep1 wl_0_rep1 3.3e-18
ccc_rbl_0_wl_1_rep1 rbl_0_rep1 wl_1_rep1 3.3e-18
ccc_rbl_0_wl_2_rep1 rbl_0_rep1 wl_2_rep1 3.3e-18
ccc_rbl_1_rwl_0_rep1 rbl_1_rep1 rwl_0_rep1 1.9738e-17
ccc_rbl_1_rwl_1_rep1 rbl_1_rep1 rwl_1_rep1 1.9738e-17
ccc_rbl_1_rwl_2_rep1 rbl_1_rep1 rwl_2_rep1 1.9738e-17
ccc_rbl_1_rwl_3_rep1 rbl_1_rep1 rwl_3_rep1 1.9738e-17
ccc_rbl_1_sn_0_1_rep1 rbl_1_rep1 sn_0_1_rep1 1.071e-17
ccc_rbl_1_sn_1_1_rep1 rbl_1_rep1 sn_1_1_rep1 2.4327e-17
ccc_rbl_1_sn_2_1_rep1 rbl_1_rep1 sn_2_1_rep1 2.4327e-17
ccc_rbl_1_wl_0_rep1 rbl_1_rep1 wl_0_rep1 3.3e-18
ccc_rbl_1_wl_1_rep1 rbl_1_rep1 wl_1_rep1 3.3e-18
ccc_rbl_1_wl_2_rep1 rbl_1_rep1 wl_2_rep1 3.3e-18
ccc_rbl_2_rwl_0_rep1 rbl_2_rep1 rwl_0_rep1 1.9738e-17
ccc_rbl_2_rwl_1_rep1 rbl_2_rep1 rwl_1_rep1 1.9738e-17
ccc_rbl_2_rwl_2_rep1 rbl_2_rep1 rwl_2_rep1 1.9738e-17
ccc_rbl_2_rwl_3_rep1 rbl_2_rep1 rwl_3_rep1 1.9738e-17
ccc_rbl_2_sn_0_2_rep1 rbl_2_rep1 sn_0_2_rep1 1.071e-17
ccc_rbl_2_sn_1_2_rep1 rbl_2_rep1 sn_1_2_rep1 2.4327e-17
ccc_rbl_2_sn_2_2_rep1 rbl_2_rep1 sn_2_2_rep1 2.4327e-17
ccc_rbl_2_wl_0_rep1 rbl_2_rep1 wl_0_rep1 3.3e-18
ccc_rbl_2_wl_1_rep1 rbl_2_rep1 wl_1_rep1 3.3e-18
ccc_rbl_2_wl_2_rep1 rbl_2_rep1 wl_2_rep1 3.3e-18
ccc_rbl_3_rwl_0_rep1 rbl_3_rep1 rwl_0_rep1 1.071e-17
ccc_rbl_3_rwl_1_rep1 rbl_3_rep1 rwl_1_rep1 1.071e-17
ccc_rbl_3_rwl_2_rep1 rbl_3_rep1 rwl_2_rep1 1.071e-17
ccc_rbl_3_rwl_3_rep1 rbl_3_rep1 rwl_3_rep1 1.071e-17
ccc_rbl_3_sn_0_3_rep1 rbl_3_rep1 sn_0_3_rep1 1.071e-17
ccc_rbl_3_sn_1_3_rep1 rbl_3_rep1 sn_1_3_rep1 2.4327e-17
ccc_rbl_3_sn_2_3_rep1 rbl_3_rep1 sn_2_3_rep1 2.4327e-17
ccc_rwl_0_sn_0_0_rep1 rwl_0_rep1 sn_0_0_rep1 1.0072e-17
ccc_rwl_0_sn_0_1_rep1 rwl_0_rep1 sn_0_1_rep1 1.9682e-17
ccc_rwl_0_sn_0_2_rep1 rwl_0_rep1 sn_0_2_rep1 1.9682e-17
ccc_rwl_0_sn_0_3_rep1 rwl_0_rep1 sn_0_3_rep1 1.9682e-17
ccc_rwl_1_sn_1_0_rep1 rwl_1_rep1 sn_1_0_rep1 1.0072e-17
ccc_rwl_1_sn_1_1_rep1 rwl_1_rep1 sn_1_1_rep1 1.9682e-17
ccc_rwl_1_sn_1_2_rep1 rwl_1_rep1 sn_1_2_rep1 1.9682e-17
ccc_rwl_1_sn_1_3_rep1 rwl_1_rep1 sn_1_3_rep1 1.9682e-17
ccc_rwl_2_sn_2_0_rep1 rwl_2_rep1 sn_2_0_rep1 1.0072e-17
ccc_rwl_2_sn_2_1_rep1 rwl_2_rep1 sn_2_1_rep1 1.9682e-17
ccc_rwl_2_sn_2_2_rep1 rwl_2_rep1 sn_2_2_rep1 1.9682e-17
ccc_rwl_2_sn_2_3_rep1 rwl_2_rep1 sn_2_3_rep1 1.9682e-17
ccc_rwl_3_sn_3_0_rep1 rwl_3_rep1 sn_3_0_rep1 1.0072e-17
ccc_rwl_3_sn_3_1_rep1 rwl_3_rep1 sn_3_1_rep1 1.9682e-17
ccc_rwl_3_sn_3_2_rep1 rwl_3_rep1 sn_3_2_rep1 1.9682e-17
ccc_rwl_3_sn_3_3_rep1 rwl_3_rep1 sn_3_3_rep1 1.9682e-17
ccc_sn_0_0_wl_0_rep1 sn_0_0_rep1 wl_0_rep1 1.9664e-17
ccc_sn_0_1_wl_0_rep1 sn_0_1_rep1 wl_0_rep1 1.9664e-17
ccc_sn_0_2_wl_0_rep1 sn_0_2_rep1 wl_0_rep1 1.9664e-17
ccc_sn_0_3_wl_0_rep1 sn_0_3_rep1 wl_0_rep1 1.3668e-17
ccc_sn_1_0_wl_1_rep1 sn_1_0_rep1 wl_1_rep1 1.9664e-17
ccc_sn_1_1_wl_1_rep1 sn_1_1_rep1 wl_1_rep1 1.6705e-17
ccc_sn_1_2_wl_1_rep1 sn_1_2_rep1 wl_1_rep1 1.6705e-17
ccc_sn_1_3_wl_1_rep1 sn_1_3_rep1 wl_1_rep1 1.071e-17
ccc_sn_2_0_wl_2_rep1 sn_2_0_rep1 wl_2_rep1 1.9664e-17
ccc_sn_2_1_wl_2_rep1 sn_2_1_rep1 wl_2_rep1 1.6705e-17
ccc_sn_2_2_wl_2_rep1 sn_2_2_rep1 wl_2_rep1 1.6705e-17
ccc_sn_2_3_wl_2_rep1 sn_2_3_rep1 wl_2_rep1 1.071e-17
ccc_sn_3_0_wl_3_rep1 sn_3_0_rep1 wl_3_rep1 1.9664e-17
ccc_sn_3_1_wl_3_rep1 sn_3_1_rep1 wl_3_rep1 1.6705e-17
ccc_sn_3_2_wl_3_rep1 sn_3_2_rep1 wl_3_rep1 1.6705e-17
ccc_sn_3_3_wl_3_rep1 sn_3_3_rep1 wl_3_rep1 1.071e-17
vdw_rep1_0 wl_0_rep1 g_wl_train dc 0
vdr_rep1_0 rwl_0_rep1 vdd dc 0
vdw_rep1_1 wl_1_rep1 0 dc 0
vdr_rep1_1 rwl_1_rep1 vdd dc 0
vdw_rep1_2 wl_2_rep1 0 dc 0
vdr_rep1_2 rwl_2_rep1 vdd dc 0
vdw_rep1_3 wl_3_rep1 0 dc 0
vdr_rep1_3 rwl_3_rep1 vdd dc 0
vdb_rep1_0 bl_0_rep1 0 dc 0
vdp_rep1_0 rbl_0_rep1 vrbl dc 0
vdb_rep1_1 bl_1_rep1 g_hi_train dc 0
vdp_rep1_1 rbl_1_rep1 vrbl dc 0
vdb_rep1_2 bl_2_rep1 0 dc 0
vdp_rep1_2 rbl_2_rep1 vrbl dc 0
vdb_rep1_3 bl_3_rep1 0 dc 0
vdp_rep1_3 rbl_3_rep1 vrbl dc 0

* ---- instance rep0: family rep0 ----
xm1_rep0 sn_0_0__t0_rep0 wl_0__t3_rep0 bl_0__t0_rep0 gnd__t0_rep0 sky130_fd_pr__nfet_01v8 L=0.15 W=0.42 nf=1 ad=0.1974 as=0.1974 pd=1.78 ps=1.78 mult=1 m=1
xm2_rep0 rbl_0__t0_rep0 sn_0_0__t1_rep0 rwl_0__t0_rep0 gnd__t1_rep0 sky130_fd_pr__nfet_01v8 L=0.15 W=0.42 nf=1 ad=0.1974 as=0.1974 pd=1.78 ps=1.78 mult=1 m=1
xm3_rep0 sn_0_1__t1_rep0 wl_0__t0_rep0 bl_1__t0_rep0 gnd__t2_rep0 sky130_fd_pr__nfet_01v8 L=0.15 W=0.42 nf=1 ad=0.1974 as=0.1974 pd=1.78 ps=1.78 mult=1 m=1
xm4_rep0 rbl_1__t0_rep0 sn_0_1__t0_rep0 rwl_0__t1_rep0 gnd__t3_rep0 sky130_fd_pr__nfet_01v8 L=0.15 W=0.42 nf=1 ad=0.1974 as=0.1974 pd=1.78 ps=1.78 mult=1 m=1
xm5_rep0 sn_0_2__t1_rep0 wl_0__t1_rep0 bl_2__t0_rep0 gnd__t4_rep0 sky130_fd_pr__nfet_01v8 L=0.15 W=0.42 nf=1 ad=0.1974 as=0.1974 pd=1.78 ps=1.78 mult=1 m=1
xm6_rep0 rbl_2__t0_rep0 sn_0_2__t0_rep0 rwl_0__t2_rep0 gnd__t5_rep0 sky130_fd_pr__nfet_01v8 L=0.15 W=0.42 nf=1 ad=0.1974 as=0.1974 pd=1.78 ps=1.78 mult=1 m=1
xm7_rep0 sn_0_3__t1_rep0 wl_0__t2_rep0 bl_3__t0_rep0 gnd__t6_rep0 sky130_fd_pr__nfet_01v8 L=0.15 W=0.42 nf=1 ad=0.1974 as=0.1974 pd=1.78 ps=1.78 mult=1 m=1
xm8_rep0 rbl_3__t0_rep0 sn_0_3__t0_rep0 rwl_0__t3_rep0 gnd__t7_rep0 sky130_fd_pr__nfet_01v8 L=0.15 W=0.42 nf=1 ad=0.1974 as=0.1974 pd=1.78 ps=1.78 mult=1 m=1
xm9_rep0 sn_1_0__t1_rep0 wl_1__t0_rep0 bl_0__t1_rep0 gnd__t8_rep0 sky130_fd_pr__nfet_01v8 L=0.15 W=0.42 nf=1 ad=0.1974 as=0.1974 pd=1.78 ps=1.78 mult=1 m=1
xm10_rep0 rbl_0__t1_rep0 sn_1_0__t0_rep0 rwl_1__t0_rep0 gnd__t9_rep0 sky130_fd_pr__nfet_01v8 L=0.15 W=0.42 nf=1 ad=0.1974 as=0.1974 pd=1.78 ps=1.78 mult=1 m=1
xm11_rep0 sn_1_1__t1_rep0 wl_1__t1_rep0 bl_1__t1_rep0 gnd__t10_rep0 sky130_fd_pr__nfet_01v8 L=0.15 W=0.42 nf=1 ad=0.1974 as=0.1974 pd=1.78 ps=1.78 mult=1 m=1
xm12_rep0 rbl_1__t1_rep0 sn_1_1__t0_rep0 rwl_1__t1_rep0 gnd__t11_rep0 sky130_fd_pr__nfet_01v8 L=0.15 W=0.42 nf=1 ad=0.1974 as=0.1974 pd=1.78 ps=1.78 mult=1 m=1
xm13_rep0 sn_1_2__t1_rep0 wl_1__t2_rep0 bl_2__t1_rep0 gnd__t12_rep0 sky130_fd_pr__nfet_01v8 L=0.15 W=0.42 nf=1 ad=0.1974 as=0.1974 pd=1.78 ps=1.78 mult=1 m=1
xm14_rep0 rbl_2__t1_rep0 sn_1_2__t0_rep0 rwl_1__t2_rep0 gnd__t13_rep0 sky130_fd_pr__nfet_01v8 L=0.15 W=0.42 nf=1 ad=0.1974 as=0.1974 pd=1.78 ps=1.78 mult=1 m=1
xm15_rep0 sn_1_3__t1_rep0 wl_1__t3_rep0 bl_3__t1_rep0 gnd__t14_rep0 sky130_fd_pr__nfet_01v8 L=0.15 W=0.42 nf=1 ad=0.1974 as=0.1974 pd=1.78 ps=1.78 mult=1 m=1
xm16_rep0 rbl_3__t1_rep0 sn_1_3__t0_rep0 rwl_1__t3_rep0 gnd__t15_rep0 sky130_fd_pr__nfet_01v8 L=0.15 W=0.42 nf=1 ad=0.1974 as=0.1974 pd=1.78 ps=1.78 mult=1 m=1
xm17_rep0 sn_2_0__t1_rep0 wl_2__t3_rep0 bl_0__t3_rep0 gnd__t16_rep0 sky130_fd_pr__nfet_01v8 L=0.15 W=0.42 nf=1 ad=0.1974 as=0.1974 pd=1.78 ps=1.78 mult=1 m=1
xm18_rep0 rbl_0__t2_rep0 sn_2_0__t0_rep0 rwl_2__t0_rep0 gnd__t17_rep0 sky130_fd_pr__nfet_01v8 L=0.15 W=0.42 nf=1 ad=0.1974 as=0.1974 pd=1.78 ps=1.78 mult=1 m=1
xm19_rep0 sn_2_1__t1_rep0 wl_2__t0_rep0 bl_1__t2_rep0 gnd__t18_rep0 sky130_fd_pr__nfet_01v8 L=0.15 W=0.42 nf=1 ad=0.1974 as=0.1974 pd=1.78 ps=1.78 mult=1 m=1
xm20_rep0 rbl_1__t2_rep0 sn_2_1__t0_rep0 rwl_2__t1_rep0 gnd__t19_rep0 sky130_fd_pr__nfet_01v8 L=0.15 W=0.42 nf=1 ad=0.1974 as=0.1974 pd=1.78 ps=1.78 mult=1 m=1
xm21_rep0 sn_2_2__t1_rep0 wl_2__t1_rep0 bl_2__t2_rep0 gnd__t20_rep0 sky130_fd_pr__nfet_01v8 L=0.15 W=0.42 nf=1 ad=0.1974 as=0.1974 pd=1.78 ps=1.78 mult=1 m=1
xm22_rep0 rbl_2__t2_rep0 sn_2_2__t0_rep0 rwl_2__t2_rep0 gnd__t21_rep0 sky130_fd_pr__nfet_01v8 L=0.15 W=0.42 nf=1 ad=0.1974 as=0.1974 pd=1.78 ps=1.78 mult=1 m=1
xm23_rep0 sn_2_3__t1_rep0 wl_2__t2_rep0 bl_3__t2_rep0 gnd__t22_rep0 sky130_fd_pr__nfet_01v8 L=0.15 W=0.42 nf=1 ad=0.1974 as=0.1974 pd=1.78 ps=1.78 mult=1 m=1
xm24_rep0 rbl_3__t2_rep0 sn_2_3__t0_rep0 rwl_2__t3_rep0 gnd__t23_rep0 sky130_fd_pr__nfet_01v8 L=0.15 W=0.42 nf=1 ad=0.1974 as=0.1974 pd=1.78 ps=1.78 mult=1 m=1
xm25_rep0 sn_3_0__t1_rep0 wl_3__t0_rep0 bl_0__t2_rep0 gnd__t24_rep0 sky130_fd_pr__nfet_01v8 L=0.15 W=0.42 nf=1 ad=0.1974 as=0.1974 pd=1.78 ps=1.78 mult=1 m=1
xm26_rep0 rbl_0__t3_rep0 sn_3_0__t0_rep0 rwl_3__t0_rep0 gnd__t25_rep0 sky130_fd_pr__nfet_01v8 L=0.15 W=0.42 nf=1 ad=0.1974 as=0.1974 pd=1.78 ps=1.78 mult=1 m=1
xm27_rep0 sn_3_1__t1_rep0 wl_3__t1_rep0 bl_1__t3_rep0 gnd__t26_rep0 sky130_fd_pr__nfet_01v8 L=0.15 W=0.42 nf=1 ad=0.1974 as=0.1974 pd=1.78 ps=1.78 mult=1 m=1
xm28_rep0 rbl_1__t3_rep0 sn_3_1__t0_rep0 rwl_3__t1_rep0 gnd__t27_rep0 sky130_fd_pr__nfet_01v8 L=0.15 W=0.42 nf=1 ad=0.1974 as=0.1974 pd=1.78 ps=1.78 mult=1 m=1
xm29_rep0 sn_3_2__t1_rep0 wl_3__t2_rep0 bl_2__t3_rep0 gnd__t28_rep0 sky130_fd_pr__nfet_01v8 L=0.15 W=0.42 nf=1 ad=0.1974 as=0.1974 pd=1.78 ps=1.78 mult=1 m=1
xm30_rep0 rbl_2__t3_rep0 sn_3_2__t0_rep0 rwl_3__t2_rep0 gnd__t29_rep0 sky130_fd_pr__nfet_01v8 L=0.15 W=0.42 nf=1 ad=0.1974 as=0.1974 pd=1.78 ps=1.78 mult=1 m=1
xm31_rep0 sn_3_3__t1_rep0 wl_3__t3_rep0 bl_3__t3_rep0 gnd__t30_rep0 sky130_fd_pr__nfet_01v8 L=0.15 W=0.42 nf=1 ad=0.1974 as=0.1974 pd=1.78 ps=1.78 mult=1 m=1
xm32_rep0 rbl_3__t3_rep0 sn_3_3__t0_rep0 rwl_3__t3_rep0 gnd__t31_rep0 sky130_fd_pr__nfet_01v8 L=0.15 W=0.42 nf=1 ad=0.1974 as=0.1974 pd=1.78 ps=1.78 mult=1 m=1
rgnd_t0_rep0 gnd__t0_rep0 0 63.3529
rgnd_t1_rep0 gnd__t1_rep0 0 49.0465
rgnd_t2_rep0 gnd__t2_rep0 0 36.5177
rgnd_t3_rep0 gnd__t3_rep0 0 28.2406
rgnd_t4_rep0 gnd__t4_rep0 0 28.2406
rgnd_t5_rep0 gnd__t5_rep0 0 36.5177
rgnd_t6_rep0 gnd__t6_rep0 0 49.0465
rgnd_t7_rep0 gnd__t7_rep0 0 63.3529
rgnd_t8_rep0 gnd__t8_rep0 0 58.0019
rgnd_t9_rep0 gnd__t9_rep0 0 41.907
rgnd_t10_rep0 gnd__t10_rep0 0 26.1568
rgnd_t11_rep0 gnd__t11_rep0 0 12.1726
rgnd_t12_rep0 gnd__t12_rep0 0 12.1726
rgnd_t13_rep0 gnd__t13_rep0 0 26.1568
rgnd_t14_rep0 gnd__t14_rep0 0 41.907
rgnd_t15_rep0 gnd__t15_rep0 0 58.0019
rgnd_t16_rep0 gnd__t16_rep0 0 58.0019
rgnd_t17_rep0 gnd__t17_rep0 0 41.907
rgnd_t18_rep0 gnd__t18_rep0 0 26.1568
rgnd_t19_rep0 gnd__t19_rep0 0 12.1726
rgnd_t20_rep0 gnd__t20_rep0 0 12.1726
rgnd_t21_rep0 gnd__t21_rep0 0 26.1568
rgnd_t22_rep0 gnd__t22_rep0 0 41.907
rgnd_t23_rep0 gnd__t23_rep0 0 58.0019
rgnd_t24_rep0 gnd__t24_rep0 0 63.3529
rgnd_t25_rep0 gnd__t25_rep0 0 49.0465
rgnd_t26_rep0 gnd__t26_rep0 0 36.5177
rgnd_t27_rep0 gnd__t27_rep0 0 28.2406
rgnd_t28_rep0 gnd__t28_rep0 0 28.2406
rgnd_t29_rep0 gnd__t29_rep0 0 36.5177
rgnd_t30_rep0 gnd__t30_rep0 0 49.0465
rgnd_t31_rep0 gnd__t31_rep0 0 63.3529
rbl_0_t0_rep0 bl_0__t0_rep0 bl_0_rep0 144.555
rbl_0_t1_rep0 bl_0__t1_rep0 bl_0_rep0 48.1851
rbl_0_t2_rep0 bl_0__t2_rep0 bl_0_rep0 144.555
rbl_0_t3_rep0 bl_0__t3_rep0 bl_0_rep0 48.1851
rbl_1_t0_rep0 bl_1__t0_rep0 bl_1_rep0 144.555
rbl_1_t1_rep0 bl_1__t1_rep0 bl_1_rep0 48.1851
rbl_1_t2_rep0 bl_1__t2_rep0 bl_1_rep0 48.1851
rbl_1_t3_rep0 bl_1__t3_rep0 bl_1_rep0 144.555
rbl_2_t0_rep0 bl_2__t0_rep0 bl_2_rep0 144.555
rbl_2_t1_rep0 bl_2__t1_rep0 bl_2_rep0 48.1851
rbl_2_t2_rep0 bl_2__t2_rep0 bl_2_rep0 48.1851
rbl_2_t3_rep0 bl_2__t3_rep0 bl_2_rep0 144.555
rbl_3_t0_rep0 bl_3__t0_rep0 bl_3_rep0 144.555
rbl_3_t1_rep0 bl_3__t1_rep0 bl_3_rep0 48.1851
rbl_3_t2_rep0 bl_3__t2_rep0 bl_3_rep0 48.1851
rbl_3_t3_rep0 bl_3__t3_rep0 bl_3_rep0 144.555
rrbl_0_t0_rep0 rbl_0__t0_rep0 rbl_0_rep0 144.555
rrbl_0_t1_rep0 rbl_0__t1_rep0 rbl_0_rep0 48.1851
rrbl_0_t2_rep0 rbl_0__t2_rep0 rbl_0_rep0 48.1851
rrbl_0_t3_rep0 rbl_0__t3_rep0 rbl_0_rep0 144.555
rrbl_1_t0_rep0 rbl_1__t0_rep0 rbl_1_rep0 144.555
rrbl_1_t1_rep0 rbl_1__t1_rep0 rbl_1_rep0 48.1851
rrbl_1_t2_rep0 rbl_1__t2_rep0 rbl_1_rep0 48.1851
rrbl_1_t3_rep0 rbl_1__t3_rep0 rbl_1_rep0 144.555
rrbl_2_t0_rep0 rbl_2__t0_rep0 rbl_2_rep0 144.555
rrbl_2_t1_rep0 rbl_2__t1_rep0 rbl_2_rep0 48.1851
rrbl_2_t2_rep0 rbl_2__t2_rep0 rbl_2_rep0 48.1851
rrbl_2_t3_rep0 rbl_2__t3_rep0 rbl_2_rep0 144.555
rrbl_3_t0_rep0 rbl_3__t0_rep0 rbl_3_rep0 144.555
rrbl_3_t1_rep0 rbl_3__t1_rep0 rbl_3_rep0 48.1851
rrbl_3_t2_rep0 rbl_3__t2_rep0 rbl_3_rep0 48.1851
rrbl_3_t3_rep0 rbl_3__t3_rep0 rbl_3_rep0 144.555
rrwl_0_t0_rep0 rwl_0__t0_rep0 rwl_0_rep0 21.6897
rrwl_0_t1_rep0 rwl_0__t1_rep0 rwl_0_rep0 7.22989
rrwl_0_t2_rep0 rwl_0__t2_rep0 rwl_0_rep0 7.22989
rrwl_0_t3_rep0 rwl_0__t3_rep0 rwl_0_rep0 21.6897
rrwl_1_t0_rep0 rwl_1__t0_rep0 rwl_1_rep0 21.6897
rrwl_1_t1_rep0 rwl_1__t1_rep0 rwl_1_rep0 7.22989
rrwl_1_t2_rep0 rwl_1__t2_rep0 rwl_1_rep0 7.22989
rrwl_1_t3_rep0 rwl_1__t3_rep0 rwl_1_rep0 21.6897
rrwl_2_t0_rep0 rwl_2__t0_rep0 rwl_2_rep0 21.6897
rrwl_2_t1_rep0 rwl_2__t1_rep0 rwl_2_rep0 7.22989
rrwl_2_t2_rep0 rwl_2__t2_rep0 rwl_2_rep0 7.22989
rrwl_2_t3_rep0 rwl_2__t3_rep0 rwl_2_rep0 21.6897
rrwl_3_t0_rep0 rwl_3__t0_rep0 rwl_3_rep0 21.6897
rrwl_3_t1_rep0 rwl_3__t1_rep0 rwl_3_rep0 7.22989
rrwl_3_t2_rep0 rwl_3__t2_rep0 rwl_3_rep0 7.22989
rrwl_3_t3_rep0 rwl_3__t3_rep0 rwl_3_rep0 21.6897
rsn_0_0_t0_rep0 sn_0_0__t0_rep0 sn_0_0_rep0 125.123
rsn_0_0_t1_rep0 sn_0_0__t1_rep0 sn_0_0_rep0 125.123
rsn_0_1_t0_rep0 sn_0_1__t0_rep0 sn_0_1_rep0 125.123
rsn_0_1_t1_rep0 sn_0_1__t1_rep0 sn_0_1_rep0 125.123
rsn_0_2_t0_rep0 sn_0_2__t0_rep0 sn_0_2_rep0 125.123
rsn_0_2_t1_rep0 sn_0_2__t1_rep0 sn_0_2_rep0 125.123
rsn_0_3_t0_rep0 sn_0_3__t0_rep0 sn_0_3_rep0 125.123
rsn_0_3_t1_rep0 sn_0_3__t1_rep0 sn_0_3_rep0 125.123
rsn_1_0_t0_rep0 sn_1_0__t0_rep0 sn_1_0_rep0 125.123
rsn_1_0_t1_rep0 sn_1_0__t1_rep0 sn_1_0_rep0 125.123
rsn_1_1_t0_rep0 sn_1_1__t0_rep0 sn_1_1_rep0 125.123
rsn_1_1_t1_rep0 sn_1_1__t1_rep0 sn_1_1_rep0 125.123
rsn_1_2_t0_rep0 sn_1_2__t0_rep0 sn_1_2_rep0 125.123
rsn_1_2_t1_rep0 sn_1_2__t1_rep0 sn_1_2_rep0 125.123
rsn_1_3_t0_rep0 sn_1_3__t0_rep0 sn_1_3_rep0 125.123
rsn_1_3_t1_rep0 sn_1_3__t1_rep0 sn_1_3_rep0 125.123
rsn_2_0_t0_rep0 sn_2_0__t0_rep0 sn_2_0_rep0 125.123
rsn_2_0_t1_rep0 sn_2_0__t1_rep0 sn_2_0_rep0 125.123
rsn_2_1_t0_rep0 sn_2_1__t0_rep0 sn_2_1_rep0 125.123
rsn_2_1_t1_rep0 sn_2_1__t1_rep0 sn_2_1_rep0 125.123
rsn_2_2_t0_rep0 sn_2_2__t0_rep0 sn_2_2_rep0 125.123
rsn_2_2_t1_rep0 sn_2_2__t1_rep0 sn_2_2_rep0 125.123
rsn_2_3_t0_rep0 sn_2_3__t0_rep0 sn_2_3_rep0 125.123
rsn_2_3_t1_rep0 sn_2_3__t1_rep0 sn_2_3_rep0 125.123
rsn_3_0_t0_rep0 sn_3_0__t0_rep0 sn_3_0_rep0 125.123
rsn_3_0_t1_rep0 sn_3_0__t1_rep0 sn_3_0_rep0 125.123
rsn_3_1_t0_rep0 sn_3_1__t0_rep0 sn_3_1_rep0 125.123
rsn_3_1_t1_rep0 sn_3_1__t1_rep0 sn_3_1_rep0 125.123
rsn_3_2_t0_rep0 sn_3_2__t0_rep0 sn_3_2_rep0 125.123
rsn_3_2_t1_rep0 sn_3_2__t1_rep0 sn_3_2_rep0 125.123
rsn_3_3_t0_rep0 sn_3_3__t0_rep0 sn_3_3_rep0 125.123
rsn_3_3_t1_rep0 sn_3_3__t1_rep0 sn_3_3_rep0 125.123
rwl_0_t0_rep0 wl_0__t0_rep0 wl_0_rep0 54.2844
rwl_0_t1_rep0 wl_0__t1_rep0 wl_0_rep0 54.2844
rwl_0_t2_rep0 wl_0__t2_rep0 wl_0_rep0 162.853
rwl_0_t3_rep0 wl_0__t3_rep0 wl_0_rep0 162.853
rwl_1_t0_rep0 wl_1__t0_rep0 wl_1_rep0 162.853
rwl_1_t1_rep0 wl_1__t1_rep0 wl_1_rep0 54.2844
rwl_1_t2_rep0 wl_1__t2_rep0 wl_1_rep0 54.2844
rwl_1_t3_rep0 wl_1__t3_rep0 wl_1_rep0 162.853
rwl_2_t0_rep0 wl_2__t0_rep0 wl_2_rep0 54.2844
rwl_2_t1_rep0 wl_2__t1_rep0 wl_2_rep0 54.2844
rwl_2_t2_rep0 wl_2__t2_rep0 wl_2_rep0 162.853
rwl_2_t3_rep0 wl_2__t3_rep0 wl_2_rep0 162.853
rwl_3_t0_rep0 wl_3__t0_rep0 wl_3_rep0 162.853
rwl_3_t1_rep0 wl_3__t1_rep0 wl_3_rep0 54.2844
rwl_3_t2_rep0 wl_3__t2_rep0 wl_3_rep0 54.2844
rwl_3_t3_rep0 wl_3__t3_rep0 wl_3_rep0 162.853
cgnd_rep0 0 0 4.09475e-15
cbl_0_rep0 bl_0_rep0 0 5.96076e-16
cbl_1_rep0 bl_1_rep0 0 5.81168e-16
cbl_2_rep0 bl_2_rep0 0 5.81168e-16
cbl_3_rep0 bl_3_rep0 0 5.81168e-16
crbl_0_rep0 rbl_0_rep0 0 5.81168e-16
crbl_1_rep0 rbl_1_rep0 0 5.81168e-16
crbl_2_rep0 rbl_2_rep0 0 5.81168e-16
crbl_3_rep0 rbl_3_rep0 0 5.96076e-16
crwl_0_rep0 rwl_0_rep0 0 1.18713e-15
crwl_1_rep0 rwl_1_rep0 0 1.18713e-15
crwl_2_rep0 rwl_2_rep0 0 1.18713e-15
crwl_3_rep0 rwl_3_rep0 0 1.18713e-15
csn_0_0_rep0 sn_0_0_rep0 0 4.33689e-16
csn_0_1_rep0 sn_0_1_rep0 0 4.30576e-16
csn_0_2_rep0 sn_0_2_rep0 0 4.30576e-16
csn_0_3_rep0 sn_0_3_rep0 0 4.32518e-16
csn_1_0_rep0 sn_1_0_rep0 0 4.33689e-16
csn_1_1_rep0 sn_1_1_rep0 0 4.30576e-16
csn_1_2_rep0 sn_1_2_rep0 0 4.30576e-16
csn_1_3_rep0 sn_1_3_rep0 0 4.32518e-16
csn_2_0_rep0 sn_2_0_rep0 0 4.33689e-16
csn_2_1_rep0 sn_2_1_rep0 0 4.30576e-16
csn_2_2_rep0 sn_2_2_rep0 0 4.30576e-16
csn_2_3_rep0 sn_2_3_rep0 0 4.32518e-16
csn_3_0_rep0 sn_3_0_rep0 0 4.33689e-16
csn_3_1_rep0 sn_3_1_rep0 0 4.30576e-16
csn_3_2_rep0 sn_3_2_rep0 0 4.30576e-16
csn_3_3_rep0 sn_3_3_rep0 0 4.32518e-16
cwl_0_rep0 wl_0_rep0 0 1.90928e-15
cwl_1_rep0 wl_1_rep0 0 1.90928e-15
cwl_2_rep0 wl_2_rep0 0 1.90928e-15
cwl_3_rep0 wl_3_rep0 0 1.91375e-15
ccc_bl_0_sn_0_0_rep0 bl_0_rep0 sn_0_0_rep0 1.071e-17
ccc_bl_0_sn_1_0_rep0 bl_0_rep0 sn_1_0_rep0 1.071e-17
ccc_bl_0_sn_2_0_rep0 bl_0_rep0 sn_2_0_rep0 1.071e-17
ccc_bl_0_sn_3_0_rep0 bl_0_rep0 sn_3_0_rep0 1.071e-17
ccc_bl_0_wl_0_rep0 bl_0_rep0 wl_0_rep0 2.4327e-17
ccc_bl_0_wl_1_rep0 bl_0_rep0 wl_1_rep0 2.4327e-17
ccc_bl_0_wl_2_rep0 bl_0_rep0 wl_2_rep0 2.4327e-17
ccc_bl_1_rbl_0_rep0 bl_1_rep0 rbl_0_rep0 1.29795e-16
ccc_bl_1_rwl_0_rep0 bl_1_rep0 rwl_0_rep0 9.028e-18
ccc_bl_1_rwl_1_rep0 bl_1_rep0 rwl_1_rep0 9.028e-18
ccc_bl_1_rwl_2_rep0 bl_1_rep0 rwl_2_rep0 9.028e-18
ccc_bl_1_rwl_3_rep0 bl_1_rep0 rwl_3_rep0 9.028e-18
ccc_bl_1_sn_0_1_rep0 bl_1_rep0 sn_0_1_rep0 1.071e-17
ccc_bl_1_sn_1_1_rep0 bl_1_rep0 sn_1_1_rep0 1.071e-17
ccc_bl_1_sn_2_1_rep0 bl_1_rep0 sn_2_1_rep0 1.071e-17
ccc_bl_1_sn_3_1_rep0 bl_1_rep0 sn_3_1_rep0 1.071e-17
ccc_bl_1_wl_0_rep0 bl_1_rep0 wl_0_rep0 2.7627e-17
ccc_bl_1_wl_1_rep0 bl_1_rep0 wl_1_rep0 2.7627e-17
ccc_bl_1_wl_2_rep0 bl_1_rep0 wl_2_rep0 2.7627e-17
ccc_bl_2_rbl_1_rep0 bl_2_rep0 rbl_1_rep0 1.29795e-16
ccc_bl_2_rwl_0_rep0 bl_2_rep0 rwl_0_rep0 9.028e-18
ccc_bl_2_rwl_1_rep0 bl_2_rep0 rwl_1_rep0 9.028e-18
ccc_bl_2_rwl_2_rep0 bl_2_rep0 rwl_2_rep0 9.028e-18
ccc_bl_2_rwl_3_rep0 bl_2_rep0 rwl_3_rep0 9.028e-18
ccc_bl_2_sn_0_2_rep0 bl_2_rep0 sn_0_2_rep0 1.071e-17
ccc_bl_2_sn_1_2_rep0 bl_2_rep0 sn_1_2_rep0 1.071e-17
ccc_bl_2_sn_2_2_rep0 bl_2_rep0 sn_2_2_rep0 1.071e-17
ccc_bl_2_sn_3_2_rep0 bl_2_rep0 sn_3_2_rep0 1.071e-17
ccc_bl_2_wl_0_rep0 bl_2_rep0 wl_0_rep0 2.7627e-17
ccc_bl_2_wl_1_rep0 bl_2_rep0 wl_1_rep0 2.7627e-17
ccc_bl_2_wl_2_rep0 bl_2_rep0 wl_2_rep0 2.7627e-17
ccc_bl_3_rbl_2_rep0 bl_3_rep0 rbl_2_rep0 1.29795e-16
ccc_bl_3_rwl_0_rep0 bl_3_rep0 rwl_0_rep0 9.028e-18
ccc_bl_3_rwl_1_rep0 bl_3_rep0 rwl_1_rep0 9.028e-18
ccc_bl_3_rwl_2_rep0 bl_3_rep0 rwl_2_rep0 9.028e-18
ccc_bl_3_rwl_3_rep0 bl_3_rep0 rwl_3_rep0 9.028e-18
ccc_bl_3_sn_0_3_rep0 bl_3_rep0 sn_0_3_rep0 1.071e-17
ccc_bl_3_sn_1_3_rep0 bl_3_rep0 sn_1_3_rep0 1.071e-17
ccc_bl_3_sn_2_3_rep0 bl_3_rep0 sn_2_3_rep0 1.071e-17
ccc_bl_3_sn_3_3_rep0 bl_3_rep0 sn_3_3_rep0 1.071e-17
ccc_bl_3_wl_0_rep0 bl_3_rep0 wl_0_rep0 2.7627e-17
ccc_bl_3_wl_1_rep0 bl_3_rep0 wl_1_rep0 2.7627e-17
ccc_bl_3_wl_2_rep0 bl_3_rep0 wl_2_rep0 2.7627e-17
ccc_rbl_0_rwl_0_rep0 rbl_0_rep0 rwl_0_rep0 1.9738e-17
ccc_rbl_0_rwl_1_rep0 rbl_0_rep0 rwl_1_rep0 1.9738e-17
ccc_rbl_0_rwl_2_rep0 rbl_0_rep0 rwl_2_rep0 1.9738e-17
ccc_rbl_0_rwl_3_rep0 rbl_0_rep0 rwl_3_rep0 1.9738e-17
ccc_rbl_0_sn_0_0_rep0 rbl_0_rep0 sn_0_0_rep0 1.071e-17
ccc_rbl_0_sn_1_0_rep0 rbl_0_rep0 sn_1_0_rep0 2.4327e-17
ccc_rbl_0_sn_2_0_rep0 rbl_0_rep0 sn_2_0_rep0 2.4327e-17
ccc_rbl_0_wl_0_rep0 rbl_0_rep0 wl_0_rep0 3.3e-18
ccc_rbl_0_wl_1_rep0 rbl_0_rep0 wl_1_rep0 3.3e-18
ccc_rbl_0_wl_2_rep0 rbl_0_rep0 wl_2_rep0 3.3e-18
ccc_rbl_1_rwl_0_rep0 rbl_1_rep0 rwl_0_rep0 1.9738e-17
ccc_rbl_1_rwl_1_rep0 rbl_1_rep0 rwl_1_rep0 1.9738e-17
ccc_rbl_1_rwl_2_rep0 rbl_1_rep0 rwl_2_rep0 1.9738e-17
ccc_rbl_1_rwl_3_rep0 rbl_1_rep0 rwl_3_rep0 1.9738e-17
ccc_rbl_1_sn_0_1_rep0 rbl_1_rep0 sn_0_1_rep0 1.071e-17
ccc_rbl_1_sn_1_1_rep0 rbl_1_rep0 sn_1_1_rep0 2.4327e-17
ccc_rbl_1_sn_2_1_rep0 rbl_1_rep0 sn_2_1_rep0 2.4327e-17
ccc_rbl_1_wl_0_rep0 rbl_1_rep0 wl_0_rep0 3.3e-18
ccc_rbl_1_wl_1_rep0 rbl_1_rep0 wl_1_rep0 3.3e-18
ccc_rbl_1_wl_2_rep0 rbl_1_rep0 wl_2_rep0 3.3e-18
ccc_rbl_2_rwl_0_rep0 rbl_2_rep0 rwl_0_rep0 1.9738e-17
ccc_rbl_2_rwl_1_rep0 rbl_2_rep0 rwl_1_rep0 1.9738e-17
ccc_rbl_2_rwl_2_rep0 rbl_2_rep0 rwl_2_rep0 1.9738e-17
ccc_rbl_2_rwl_3_rep0 rbl_2_rep0 rwl_3_rep0 1.9738e-17
ccc_rbl_2_sn_0_2_rep0 rbl_2_rep0 sn_0_2_rep0 1.071e-17
ccc_rbl_2_sn_1_2_rep0 rbl_2_rep0 sn_1_2_rep0 2.4327e-17
ccc_rbl_2_sn_2_2_rep0 rbl_2_rep0 sn_2_2_rep0 2.4327e-17
ccc_rbl_2_wl_0_rep0 rbl_2_rep0 wl_0_rep0 3.3e-18
ccc_rbl_2_wl_1_rep0 rbl_2_rep0 wl_1_rep0 3.3e-18
ccc_rbl_2_wl_2_rep0 rbl_2_rep0 wl_2_rep0 3.3e-18
ccc_rbl_3_rwl_0_rep0 rbl_3_rep0 rwl_0_rep0 1.071e-17
ccc_rbl_3_rwl_1_rep0 rbl_3_rep0 rwl_1_rep0 1.071e-17
ccc_rbl_3_rwl_2_rep0 rbl_3_rep0 rwl_2_rep0 1.071e-17
ccc_rbl_3_rwl_3_rep0 rbl_3_rep0 rwl_3_rep0 1.071e-17
ccc_rbl_3_sn_0_3_rep0 rbl_3_rep0 sn_0_3_rep0 1.071e-17
ccc_rbl_3_sn_1_3_rep0 rbl_3_rep0 sn_1_3_rep0 2.4327e-17
ccc_rbl_3_sn_2_3_rep0 rbl_3_rep0 sn_2_3_rep0 2.4327e-17
ccc_rwl_0_sn_0_0_rep0 rwl_0_rep0 sn_0_0_rep0 1.0072e-17
ccc_rwl_0_sn_0_1_rep0 rwl_0_rep0 sn_0_1_rep0 1.9682e-17
ccc_rwl_0_sn_0_2_rep0 rwl_0_rep0 sn_0_2_rep0 1.9682e-17
ccc_rwl_0_sn_0_3_rep0 rwl_0_rep0 sn_0_3_rep0 1.9682e-17
ccc_rwl_1_sn_1_0_rep0 rwl_1_rep0 sn_1_0_rep0 1.0072e-17
ccc_rwl_1_sn_1_1_rep0 rwl_1_rep0 sn_1_1_rep0 1.9682e-17
ccc_rwl_1_sn_1_2_rep0 rwl_1_rep0 sn_1_2_rep0 1.9682e-17
ccc_rwl_1_sn_1_3_rep0 rwl_1_rep0 sn_1_3_rep0 1.9682e-17
ccc_rwl_2_sn_2_0_rep0 rwl_2_rep0 sn_2_0_rep0 1.0072e-17
ccc_rwl_2_sn_2_1_rep0 rwl_2_rep0 sn_2_1_rep0 1.9682e-17
ccc_rwl_2_sn_2_2_rep0 rwl_2_rep0 sn_2_2_rep0 1.9682e-17
ccc_rwl_2_sn_2_3_rep0 rwl_2_rep0 sn_2_3_rep0 1.9682e-17
ccc_rwl_3_sn_3_0_rep0 rwl_3_rep0 sn_3_0_rep0 1.0072e-17
ccc_rwl_3_sn_3_1_rep0 rwl_3_rep0 sn_3_1_rep0 1.9682e-17
ccc_rwl_3_sn_3_2_rep0 rwl_3_rep0 sn_3_2_rep0 1.9682e-17
ccc_rwl_3_sn_3_3_rep0 rwl_3_rep0 sn_3_3_rep0 1.9682e-17
ccc_sn_0_0_wl_0_rep0 sn_0_0_rep0 wl_0_rep0 1.9664e-17
ccc_sn_0_1_wl_0_rep0 sn_0_1_rep0 wl_0_rep0 1.9664e-17
ccc_sn_0_2_wl_0_rep0 sn_0_2_rep0 wl_0_rep0 1.9664e-17
ccc_sn_0_3_wl_0_rep0 sn_0_3_rep0 wl_0_rep0 1.3668e-17
ccc_sn_1_0_wl_1_rep0 sn_1_0_rep0 wl_1_rep0 1.9664e-17
ccc_sn_1_1_wl_1_rep0 sn_1_1_rep0 wl_1_rep0 1.6705e-17
ccc_sn_1_2_wl_1_rep0 sn_1_2_rep0 wl_1_rep0 1.6705e-17
ccc_sn_1_3_wl_1_rep0 sn_1_3_rep0 wl_1_rep0 1.071e-17
ccc_sn_2_0_wl_2_rep0 sn_2_0_rep0 wl_2_rep0 1.9664e-17
ccc_sn_2_1_wl_2_rep0 sn_2_1_rep0 wl_2_rep0 1.6705e-17
ccc_sn_2_2_wl_2_rep0 sn_2_2_rep0 wl_2_rep0 1.6705e-17
ccc_sn_2_3_wl_2_rep0 sn_2_3_rep0 wl_2_rep0 1.071e-17
ccc_sn_3_0_wl_3_rep0 sn_3_0_rep0 wl_3_rep0 1.9664e-17
ccc_sn_3_1_wl_3_rep0 sn_3_1_rep0 wl_3_rep0 1.6705e-17
ccc_sn_3_2_wl_3_rep0 sn_3_2_rep0 wl_3_rep0 1.6705e-17
ccc_sn_3_3_wl_3_rep0 sn_3_3_rep0 wl_3_rep0 1.071e-17
vdw_rep0_0 wl_0_rep0 g_wl_train dc 0
vdr_rep0_0 rwl_0_rep0 vdd dc 0
vdw_rep0_1 wl_1_rep0 0 dc 0
vdr_rep0_1 rwl_1_rep0 vdd dc 0
vdw_rep0_2 wl_2_rep0 0 dc 0
vdr_rep0_2 rwl_2_rep0 vdd dc 0
vdw_rep0_3 wl_3_rep0 0 dc 0
vdr_rep0_3 rwl_3_rep0 vdd dc 0
vdb_rep0_0 bl_0_rep0 vdd dc 0
vdp_rep0_0 rbl_0_rep0 vrbl dc 0
vdb_rep0_1 bl_1_rep0 g_lo_train dc 0
vdp_rep0_1 rbl_1_rep0 vrbl dc 0
vdb_rep0_2 bl_2_rep0 vdd dc 0
vdp_rep0_2 rbl_2_rep0 vrbl dc 0
vdb_rep0_3 bl_3_rep0 vdd dc 0
vdp_rep0_3 rbl_3_rep0 vrbl dc 0

* ---- instance hs_p1: family hs_p1 ----
xm1_hs_p1 sn_0_0__t0_hs_p1 wl_0__t3_hs_p1 bl_0__t0_hs_p1 gnd__t0_hs_p1 sky130_fd_pr__nfet_01v8 L=0.15 W=0.42 nf=1 ad=0.1974 as=0.1974 pd=1.78 ps=1.78 mult=1 m=1
xm2_hs_p1 rbl_0__t0_hs_p1 sn_0_0__t1_hs_p1 rwl_0__t0_hs_p1 gnd__t1_hs_p1 sky130_fd_pr__nfet_01v8 L=0.15 W=0.42 nf=1 ad=0.1974 as=0.1974 pd=1.78 ps=1.78 mult=1 m=1
xm3_hs_p1 sn_0_1__t1_hs_p1 wl_0__t0_hs_p1 bl_1__t0_hs_p1 gnd__t2_hs_p1 sky130_fd_pr__nfet_01v8 L=0.15 W=0.42 nf=1 ad=0.1974 as=0.1974 pd=1.78 ps=1.78 mult=1 m=1
xm4_hs_p1 rbl_1__t0_hs_p1 sn_0_1__t0_hs_p1 rwl_0__t1_hs_p1 gnd__t3_hs_p1 sky130_fd_pr__nfet_01v8 L=0.15 W=0.42 nf=1 ad=0.1974 as=0.1974 pd=1.78 ps=1.78 mult=1 m=1
xm5_hs_p1 sn_0_2__t1_hs_p1 wl_0__t1_hs_p1 bl_2__t0_hs_p1 gnd__t4_hs_p1 sky130_fd_pr__nfet_01v8 L=0.15 W=0.42 nf=1 ad=0.1974 as=0.1974 pd=1.78 ps=1.78 mult=1 m=1
xm6_hs_p1 rbl_2__t0_hs_p1 sn_0_2__t0_hs_p1 rwl_0__t2_hs_p1 gnd__t5_hs_p1 sky130_fd_pr__nfet_01v8 L=0.15 W=0.42 nf=1 ad=0.1974 as=0.1974 pd=1.78 ps=1.78 mult=1 m=1
xm7_hs_p1 sn_0_3__t1_hs_p1 wl_0__t2_hs_p1 bl_3__t0_hs_p1 gnd__t6_hs_p1 sky130_fd_pr__nfet_01v8 L=0.15 W=0.42 nf=1 ad=0.1974 as=0.1974 pd=1.78 ps=1.78 mult=1 m=1
xm8_hs_p1 rbl_3__t0_hs_p1 sn_0_3__t0_hs_p1 rwl_0__t3_hs_p1 gnd__t7_hs_p1 sky130_fd_pr__nfet_01v8 L=0.15 W=0.42 nf=1 ad=0.1974 as=0.1974 pd=1.78 ps=1.78 mult=1 m=1
xm9_hs_p1 sn_1_0__t1_hs_p1 wl_1__t0_hs_p1 bl_0__t1_hs_p1 gnd__t8_hs_p1 sky130_fd_pr__nfet_01v8 L=0.15 W=0.42 nf=1 ad=0.1974 as=0.1974 pd=1.78 ps=1.78 mult=1 m=1
xm10_hs_p1 rbl_0__t1_hs_p1 sn_1_0__t0_hs_p1 rwl_1__t0_hs_p1 gnd__t9_hs_p1 sky130_fd_pr__nfet_01v8 L=0.15 W=0.42 nf=1 ad=0.1974 as=0.1974 pd=1.78 ps=1.78 mult=1 m=1
xm11_hs_p1 sn_1_1__t1_hs_p1 wl_1__t1_hs_p1 bl_1__t1_hs_p1 gnd__t10_hs_p1 sky130_fd_pr__nfet_01v8 L=0.15 W=0.42 nf=1 ad=0.1974 as=0.1974 pd=1.78 ps=1.78 mult=1 m=1
xm12_hs_p1 rbl_1__t1_hs_p1 sn_1_1__t0_hs_p1 rwl_1__t1_hs_p1 gnd__t11_hs_p1 sky130_fd_pr__nfet_01v8 L=0.15 W=0.42 nf=1 ad=0.1974 as=0.1974 pd=1.78 ps=1.78 mult=1 m=1
xm13_hs_p1 sn_1_2__t1_hs_p1 wl_1__t2_hs_p1 bl_2__t1_hs_p1 gnd__t12_hs_p1 sky130_fd_pr__nfet_01v8 L=0.15 W=0.42 nf=1 ad=0.1974 as=0.1974 pd=1.78 ps=1.78 mult=1 m=1
xm14_hs_p1 rbl_2__t1_hs_p1 sn_1_2__t0_hs_p1 rwl_1__t2_hs_p1 gnd__t13_hs_p1 sky130_fd_pr__nfet_01v8 L=0.15 W=0.42 nf=1 ad=0.1974 as=0.1974 pd=1.78 ps=1.78 mult=1 m=1
xm15_hs_p1 sn_1_3__t1_hs_p1 wl_1__t3_hs_p1 bl_3__t1_hs_p1 gnd__t14_hs_p1 sky130_fd_pr__nfet_01v8 L=0.15 W=0.42 nf=1 ad=0.1974 as=0.1974 pd=1.78 ps=1.78 mult=1 m=1
xm16_hs_p1 rbl_3__t1_hs_p1 sn_1_3__t0_hs_p1 rwl_1__t3_hs_p1 gnd__t15_hs_p1 sky130_fd_pr__nfet_01v8 L=0.15 W=0.42 nf=1 ad=0.1974 as=0.1974 pd=1.78 ps=1.78 mult=1 m=1
xm17_hs_p1 sn_2_0__t1_hs_p1 wl_2__t3_hs_p1 bl_0__t3_hs_p1 gnd__t16_hs_p1 sky130_fd_pr__nfet_01v8 L=0.15 W=0.42 nf=1 ad=0.1974 as=0.1974 pd=1.78 ps=1.78 mult=1 m=1
xm18_hs_p1 rbl_0__t2_hs_p1 sn_2_0__t0_hs_p1 rwl_2__t0_hs_p1 gnd__t17_hs_p1 sky130_fd_pr__nfet_01v8 L=0.15 W=0.42 nf=1 ad=0.1974 as=0.1974 pd=1.78 ps=1.78 mult=1 m=1
xm19_hs_p1 sn_2_1__t1_hs_p1 wl_2__t0_hs_p1 bl_1__t2_hs_p1 gnd__t18_hs_p1 sky130_fd_pr__nfet_01v8 L=0.15 W=0.42 nf=1 ad=0.1974 as=0.1974 pd=1.78 ps=1.78 mult=1 m=1
xm20_hs_p1 rbl_1__t2_hs_p1 sn_2_1__t0_hs_p1 rwl_2__t1_hs_p1 gnd__t19_hs_p1 sky130_fd_pr__nfet_01v8 L=0.15 W=0.42 nf=1 ad=0.1974 as=0.1974 pd=1.78 ps=1.78 mult=1 m=1
xm21_hs_p1 sn_2_2__t1_hs_p1 wl_2__t1_hs_p1 bl_2__t2_hs_p1 gnd__t20_hs_p1 sky130_fd_pr__nfet_01v8 L=0.15 W=0.42 nf=1 ad=0.1974 as=0.1974 pd=1.78 ps=1.78 mult=1 m=1
xm22_hs_p1 rbl_2__t2_hs_p1 sn_2_2__t0_hs_p1 rwl_2__t2_hs_p1 gnd__t21_hs_p1 sky130_fd_pr__nfet_01v8 L=0.15 W=0.42 nf=1 ad=0.1974 as=0.1974 pd=1.78 ps=1.78 mult=1 m=1
xm23_hs_p1 sn_2_3__t1_hs_p1 wl_2__t2_hs_p1 bl_3__t2_hs_p1 gnd__t22_hs_p1 sky130_fd_pr__nfet_01v8 L=0.15 W=0.42 nf=1 ad=0.1974 as=0.1974 pd=1.78 ps=1.78 mult=1 m=1
xm24_hs_p1 rbl_3__t2_hs_p1 sn_2_3__t0_hs_p1 rwl_2__t3_hs_p1 gnd__t23_hs_p1 sky130_fd_pr__nfet_01v8 L=0.15 W=0.42 nf=1 ad=0.1974 as=0.1974 pd=1.78 ps=1.78 mult=1 m=1
xm25_hs_p1 sn_3_0__t1_hs_p1 wl_3__t0_hs_p1 bl_0__t2_hs_p1 gnd__t24_hs_p1 sky130_fd_pr__nfet_01v8 L=0.15 W=0.42 nf=1 ad=0.1974 as=0.1974 pd=1.78 ps=1.78 mult=1 m=1
xm26_hs_p1 rbl_0__t3_hs_p1 sn_3_0__t0_hs_p1 rwl_3__t0_hs_p1 gnd__t25_hs_p1 sky130_fd_pr__nfet_01v8 L=0.15 W=0.42 nf=1 ad=0.1974 as=0.1974 pd=1.78 ps=1.78 mult=1 m=1
xm27_hs_p1 sn_3_1__t1_hs_p1 wl_3__t1_hs_p1 bl_1__t3_hs_p1 gnd__t26_hs_p1 sky130_fd_pr__nfet_01v8 L=0.15 W=0.42 nf=1 ad=0.1974 as=0.1974 pd=1.78 ps=1.78 mult=1 m=1
xm28_hs_p1 rbl_1__t3_hs_p1 sn_3_1__t0_hs_p1 rwl_3__t1_hs_p1 gnd__t27_hs_p1 sky130_fd_pr__nfet_01v8 L=0.15 W=0.42 nf=1 ad=0.1974 as=0.1974 pd=1.78 ps=1.78 mult=1 m=1
xm29_hs_p1 sn_3_2__t1_hs_p1 wl_3__t2_hs_p1 bl_2__t3_hs_p1 gnd__t28_hs_p1 sky130_fd_pr__nfet_01v8 L=0.15 W=0.42 nf=1 ad=0.1974 as=0.1974 pd=1.78 ps=1.78 mult=1 m=1
xm30_hs_p1 rbl_2__t3_hs_p1 sn_3_2__t0_hs_p1 rwl_3__t2_hs_p1 gnd__t29_hs_p1 sky130_fd_pr__nfet_01v8 L=0.15 W=0.42 nf=1 ad=0.1974 as=0.1974 pd=1.78 ps=1.78 mult=1 m=1
xm31_hs_p1 sn_3_3__t1_hs_p1 wl_3__t3_hs_p1 bl_3__t3_hs_p1 gnd__t30_hs_p1 sky130_fd_pr__nfet_01v8 L=0.15 W=0.42 nf=1 ad=0.1974 as=0.1974 pd=1.78 ps=1.78 mult=1 m=1
xm32_hs_p1 rbl_3__t3_hs_p1 sn_3_3__t0_hs_p1 rwl_3__t3_hs_p1 gnd__t31_hs_p1 sky130_fd_pr__nfet_01v8 L=0.15 W=0.42 nf=1 ad=0.1974 as=0.1974 pd=1.78 ps=1.78 mult=1 m=1
rgnd_t0_hs_p1 gnd__t0_hs_p1 0 63.3529
rgnd_t1_hs_p1 gnd__t1_hs_p1 0 49.0465
rgnd_t2_hs_p1 gnd__t2_hs_p1 0 36.5177
rgnd_t3_hs_p1 gnd__t3_hs_p1 0 28.2406
rgnd_t4_hs_p1 gnd__t4_hs_p1 0 28.2406
rgnd_t5_hs_p1 gnd__t5_hs_p1 0 36.5177
rgnd_t6_hs_p1 gnd__t6_hs_p1 0 49.0465
rgnd_t7_hs_p1 gnd__t7_hs_p1 0 63.3529
rgnd_t8_hs_p1 gnd__t8_hs_p1 0 58.0019
rgnd_t9_hs_p1 gnd__t9_hs_p1 0 41.907
rgnd_t10_hs_p1 gnd__t10_hs_p1 0 26.1568
rgnd_t11_hs_p1 gnd__t11_hs_p1 0 12.1726
rgnd_t12_hs_p1 gnd__t12_hs_p1 0 12.1726
rgnd_t13_hs_p1 gnd__t13_hs_p1 0 26.1568
rgnd_t14_hs_p1 gnd__t14_hs_p1 0 41.907
rgnd_t15_hs_p1 gnd__t15_hs_p1 0 58.0019
rgnd_t16_hs_p1 gnd__t16_hs_p1 0 58.0019
rgnd_t17_hs_p1 gnd__t17_hs_p1 0 41.907
rgnd_t18_hs_p1 gnd__t18_hs_p1 0 26.1568
rgnd_t19_hs_p1 gnd__t19_hs_p1 0 12.1726
rgnd_t20_hs_p1 gnd__t20_hs_p1 0 12.1726
rgnd_t21_hs_p1 gnd__t21_hs_p1 0 26.1568
rgnd_t22_hs_p1 gnd__t22_hs_p1 0 41.907
rgnd_t23_hs_p1 gnd__t23_hs_p1 0 58.0019
rgnd_t24_hs_p1 gnd__t24_hs_p1 0 63.3529
rgnd_t25_hs_p1 gnd__t25_hs_p1 0 49.0465
rgnd_t26_hs_p1 gnd__t26_hs_p1 0 36.5177
rgnd_t27_hs_p1 gnd__t27_hs_p1 0 28.2406
rgnd_t28_hs_p1 gnd__t28_hs_p1 0 28.2406
rgnd_t29_hs_p1 gnd__t29_hs_p1 0 36.5177
rgnd_t30_hs_p1 gnd__t30_hs_p1 0 49.0465
rgnd_t31_hs_p1 gnd__t31_hs_p1 0 63.3529
rbl_0_t0_hs_p1 bl_0__t0_hs_p1 bl_0_hs_p1 144.555
rbl_0_t1_hs_p1 bl_0__t1_hs_p1 bl_0_hs_p1 48.1851
rbl_0_t2_hs_p1 bl_0__t2_hs_p1 bl_0_hs_p1 144.555
rbl_0_t3_hs_p1 bl_0__t3_hs_p1 bl_0_hs_p1 48.1851
rbl_1_t0_hs_p1 bl_1__t0_hs_p1 bl_1_hs_p1 144.555
rbl_1_t1_hs_p1 bl_1__t1_hs_p1 bl_1_hs_p1 48.1851
rbl_1_t2_hs_p1 bl_1__t2_hs_p1 bl_1_hs_p1 48.1851
rbl_1_t3_hs_p1 bl_1__t3_hs_p1 bl_1_hs_p1 144.555
rbl_2_t0_hs_p1 bl_2__t0_hs_p1 bl_2_hs_p1 144.555
rbl_2_t1_hs_p1 bl_2__t1_hs_p1 bl_2_hs_p1 48.1851
rbl_2_t2_hs_p1 bl_2__t2_hs_p1 bl_2_hs_p1 48.1851
rbl_2_t3_hs_p1 bl_2__t3_hs_p1 bl_2_hs_p1 144.555
rbl_3_t0_hs_p1 bl_3__t0_hs_p1 bl_3_hs_p1 144.555
rbl_3_t1_hs_p1 bl_3__t1_hs_p1 bl_3_hs_p1 48.1851
rbl_3_t2_hs_p1 bl_3__t2_hs_p1 bl_3_hs_p1 48.1851
rbl_3_t3_hs_p1 bl_3__t3_hs_p1 bl_3_hs_p1 144.555
rrbl_0_t0_hs_p1 rbl_0__t0_hs_p1 rbl_0_hs_p1 144.555
rrbl_0_t1_hs_p1 rbl_0__t1_hs_p1 rbl_0_hs_p1 48.1851
rrbl_0_t2_hs_p1 rbl_0__t2_hs_p1 rbl_0_hs_p1 48.1851
rrbl_0_t3_hs_p1 rbl_0__t3_hs_p1 rbl_0_hs_p1 144.555
rrbl_1_t0_hs_p1 rbl_1__t0_hs_p1 rbl_1_hs_p1 144.555
rrbl_1_t1_hs_p1 rbl_1__t1_hs_p1 rbl_1_hs_p1 48.1851
rrbl_1_t2_hs_p1 rbl_1__t2_hs_p1 rbl_1_hs_p1 48.1851
rrbl_1_t3_hs_p1 rbl_1__t3_hs_p1 rbl_1_hs_p1 144.555
rrbl_2_t0_hs_p1 rbl_2__t0_hs_p1 rbl_2_hs_p1 144.555
rrbl_2_t1_hs_p1 rbl_2__t1_hs_p1 rbl_2_hs_p1 48.1851
rrbl_2_t2_hs_p1 rbl_2__t2_hs_p1 rbl_2_hs_p1 48.1851
rrbl_2_t3_hs_p1 rbl_2__t3_hs_p1 rbl_2_hs_p1 144.555
rrbl_3_t0_hs_p1 rbl_3__t0_hs_p1 rbl_3_hs_p1 144.555
rrbl_3_t1_hs_p1 rbl_3__t1_hs_p1 rbl_3_hs_p1 48.1851
rrbl_3_t2_hs_p1 rbl_3__t2_hs_p1 rbl_3_hs_p1 48.1851
rrbl_3_t3_hs_p1 rbl_3__t3_hs_p1 rbl_3_hs_p1 144.555
rrwl_0_t0_hs_p1 rwl_0__t0_hs_p1 rwl_0_hs_p1 21.6897
rrwl_0_t1_hs_p1 rwl_0__t1_hs_p1 rwl_0_hs_p1 7.22989
rrwl_0_t2_hs_p1 rwl_0__t2_hs_p1 rwl_0_hs_p1 7.22989
rrwl_0_t3_hs_p1 rwl_0__t3_hs_p1 rwl_0_hs_p1 21.6897
rrwl_1_t0_hs_p1 rwl_1__t0_hs_p1 rwl_1_hs_p1 21.6897
rrwl_1_t1_hs_p1 rwl_1__t1_hs_p1 rwl_1_hs_p1 7.22989
rrwl_1_t2_hs_p1 rwl_1__t2_hs_p1 rwl_1_hs_p1 7.22989
rrwl_1_t3_hs_p1 rwl_1__t3_hs_p1 rwl_1_hs_p1 21.6897
rrwl_2_t0_hs_p1 rwl_2__t0_hs_p1 rwl_2_hs_p1 21.6897
rrwl_2_t1_hs_p1 rwl_2__t1_hs_p1 rwl_2_hs_p1 7.22989
rrwl_2_t2_hs_p1 rwl_2__t2_hs_p1 rwl_2_hs_p1 7.22989
rrwl_2_t3_hs_p1 rwl_2__t3_hs_p1 rwl_2_hs_p1 21.6897
rrwl_3_t0_hs_p1 rwl_3__t0_hs_p1 rwl_3_hs_p1 21.6897
rrwl_3_t1_hs_p1 rwl_3__t1_hs_p1 rwl_3_hs_p1 7.22989
rrwl_3_t2_hs_p1 rwl_3__t2_hs_p1 rwl_3_hs_p1 7.22989
rrwl_3_t3_hs_p1 rwl_3__t3_hs_p1 rwl_3_hs_p1 21.6897
rsn_0_0_t0_hs_p1 sn_0_0__t0_hs_p1 sn_0_0_hs_p1 125.123
rsn_0_0_t1_hs_p1 sn_0_0__t1_hs_p1 sn_0_0_hs_p1 125.123
rsn_0_1_t0_hs_p1 sn_0_1__t0_hs_p1 sn_0_1_hs_p1 125.123
rsn_0_1_t1_hs_p1 sn_0_1__t1_hs_p1 sn_0_1_hs_p1 125.123
rsn_0_2_t0_hs_p1 sn_0_2__t0_hs_p1 sn_0_2_hs_p1 125.123
rsn_0_2_t1_hs_p1 sn_0_2__t1_hs_p1 sn_0_2_hs_p1 125.123
rsn_0_3_t0_hs_p1 sn_0_3__t0_hs_p1 sn_0_3_hs_p1 125.123
rsn_0_3_t1_hs_p1 sn_0_3__t1_hs_p1 sn_0_3_hs_p1 125.123
rsn_1_0_t0_hs_p1 sn_1_0__t0_hs_p1 sn_1_0_hs_p1 125.123
rsn_1_0_t1_hs_p1 sn_1_0__t1_hs_p1 sn_1_0_hs_p1 125.123
rsn_1_1_t0_hs_p1 sn_1_1__t0_hs_p1 sn_1_1_hs_p1 125.123
rsn_1_1_t1_hs_p1 sn_1_1__t1_hs_p1 sn_1_1_hs_p1 125.123
rsn_1_2_t0_hs_p1 sn_1_2__t0_hs_p1 sn_1_2_hs_p1 125.123
rsn_1_2_t1_hs_p1 sn_1_2__t1_hs_p1 sn_1_2_hs_p1 125.123
rsn_1_3_t0_hs_p1 sn_1_3__t0_hs_p1 sn_1_3_hs_p1 125.123
rsn_1_3_t1_hs_p1 sn_1_3__t1_hs_p1 sn_1_3_hs_p1 125.123
rsn_2_0_t0_hs_p1 sn_2_0__t0_hs_p1 sn_2_0_hs_p1 125.123
rsn_2_0_t1_hs_p1 sn_2_0__t1_hs_p1 sn_2_0_hs_p1 125.123
rsn_2_1_t0_hs_p1 sn_2_1__t0_hs_p1 sn_2_1_hs_p1 125.123
rsn_2_1_t1_hs_p1 sn_2_1__t1_hs_p1 sn_2_1_hs_p1 125.123
rsn_2_2_t0_hs_p1 sn_2_2__t0_hs_p1 sn_2_2_hs_p1 125.123
rsn_2_2_t1_hs_p1 sn_2_2__t1_hs_p1 sn_2_2_hs_p1 125.123
rsn_2_3_t0_hs_p1 sn_2_3__t0_hs_p1 sn_2_3_hs_p1 125.123
rsn_2_3_t1_hs_p1 sn_2_3__t1_hs_p1 sn_2_3_hs_p1 125.123
rsn_3_0_t0_hs_p1 sn_3_0__t0_hs_p1 sn_3_0_hs_p1 125.123
rsn_3_0_t1_hs_p1 sn_3_0__t1_hs_p1 sn_3_0_hs_p1 125.123
rsn_3_1_t0_hs_p1 sn_3_1__t0_hs_p1 sn_3_1_hs_p1 125.123
rsn_3_1_t1_hs_p1 sn_3_1__t1_hs_p1 sn_3_1_hs_p1 125.123
rsn_3_2_t0_hs_p1 sn_3_2__t0_hs_p1 sn_3_2_hs_p1 125.123
rsn_3_2_t1_hs_p1 sn_3_2__t1_hs_p1 sn_3_2_hs_p1 125.123
rsn_3_3_t0_hs_p1 sn_3_3__t0_hs_p1 sn_3_3_hs_p1 125.123
rsn_3_3_t1_hs_p1 sn_3_3__t1_hs_p1 sn_3_3_hs_p1 125.123
rwl_0_t0_hs_p1 wl_0__t0_hs_p1 wl_0_hs_p1 54.2844
rwl_0_t1_hs_p1 wl_0__t1_hs_p1 wl_0_hs_p1 54.2844
rwl_0_t2_hs_p1 wl_0__t2_hs_p1 wl_0_hs_p1 162.853
rwl_0_t3_hs_p1 wl_0__t3_hs_p1 wl_0_hs_p1 162.853
rwl_1_t0_hs_p1 wl_1__t0_hs_p1 wl_1_hs_p1 162.853
rwl_1_t1_hs_p1 wl_1__t1_hs_p1 wl_1_hs_p1 54.2844
rwl_1_t2_hs_p1 wl_1__t2_hs_p1 wl_1_hs_p1 54.2844
rwl_1_t3_hs_p1 wl_1__t3_hs_p1 wl_1_hs_p1 162.853
rwl_2_t0_hs_p1 wl_2__t0_hs_p1 wl_2_hs_p1 54.2844
rwl_2_t1_hs_p1 wl_2__t1_hs_p1 wl_2_hs_p1 54.2844
rwl_2_t2_hs_p1 wl_2__t2_hs_p1 wl_2_hs_p1 162.853
rwl_2_t3_hs_p1 wl_2__t3_hs_p1 wl_2_hs_p1 162.853
rwl_3_t0_hs_p1 wl_3__t0_hs_p1 wl_3_hs_p1 162.853
rwl_3_t1_hs_p1 wl_3__t1_hs_p1 wl_3_hs_p1 54.2844
rwl_3_t2_hs_p1 wl_3__t2_hs_p1 wl_3_hs_p1 54.2844
rwl_3_t3_hs_p1 wl_3__t3_hs_p1 wl_3_hs_p1 162.853
cgnd_hs_p1 0 0 4.09475e-15
cbl_0_hs_p1 bl_0_hs_p1 0 5.96076e-16
cbl_1_hs_p1 bl_1_hs_p1 0 5.81168e-16
cbl_2_hs_p1 bl_2_hs_p1 0 5.81168e-16
cbl_3_hs_p1 bl_3_hs_p1 0 5.81168e-16
crbl_0_hs_p1 rbl_0_hs_p1 0 5.81168e-16
crbl_1_hs_p1 rbl_1_hs_p1 0 5.81168e-16
crbl_2_hs_p1 rbl_2_hs_p1 0 5.81168e-16
crbl_3_hs_p1 rbl_3_hs_p1 0 5.96076e-16
crwl_0_hs_p1 rwl_0_hs_p1 0 1.18713e-15
crwl_1_hs_p1 rwl_1_hs_p1 0 1.18713e-15
crwl_2_hs_p1 rwl_2_hs_p1 0 1.18713e-15
crwl_3_hs_p1 rwl_3_hs_p1 0 1.18713e-15
csn_0_0_hs_p1 sn_0_0_hs_p1 0 4.33689e-16
csn_0_1_hs_p1 sn_0_1_hs_p1 0 4.30576e-16
csn_0_2_hs_p1 sn_0_2_hs_p1 0 4.30576e-16
csn_0_3_hs_p1 sn_0_3_hs_p1 0 4.32518e-16
csn_1_0_hs_p1 sn_1_0_hs_p1 0 4.33689e-16
csn_1_1_hs_p1 sn_1_1_hs_p1 0 4.30576e-16
csn_1_2_hs_p1 sn_1_2_hs_p1 0 4.30576e-16
csn_1_3_hs_p1 sn_1_3_hs_p1 0 4.32518e-16
csn_2_0_hs_p1 sn_2_0_hs_p1 0 4.33689e-16
csn_2_1_hs_p1 sn_2_1_hs_p1 0 4.30576e-16
csn_2_2_hs_p1 sn_2_2_hs_p1 0 4.30576e-16
csn_2_3_hs_p1 sn_2_3_hs_p1 0 4.32518e-16
csn_3_0_hs_p1 sn_3_0_hs_p1 0 4.33689e-16
csn_3_1_hs_p1 sn_3_1_hs_p1 0 4.30576e-16
csn_3_2_hs_p1 sn_3_2_hs_p1 0 4.30576e-16
csn_3_3_hs_p1 sn_3_3_hs_p1 0 4.32518e-16
cwl_0_hs_p1 wl_0_hs_p1 0 1.90928e-15
cwl_1_hs_p1 wl_1_hs_p1 0 1.90928e-15
cwl_2_hs_p1 wl_2_hs_p1 0 1.90928e-15
cwl_3_hs_p1 wl_3_hs_p1 0 1.91375e-15
ccc_bl_0_sn_0_0_hs_p1 bl_0_hs_p1 sn_0_0_hs_p1 1.071e-17
ccc_bl_0_sn_1_0_hs_p1 bl_0_hs_p1 sn_1_0_hs_p1 1.071e-17
ccc_bl_0_sn_2_0_hs_p1 bl_0_hs_p1 sn_2_0_hs_p1 1.071e-17
ccc_bl_0_sn_3_0_hs_p1 bl_0_hs_p1 sn_3_0_hs_p1 1.071e-17
ccc_bl_0_wl_0_hs_p1 bl_0_hs_p1 wl_0_hs_p1 2.4327e-17
ccc_bl_0_wl_1_hs_p1 bl_0_hs_p1 wl_1_hs_p1 2.4327e-17
ccc_bl_0_wl_2_hs_p1 bl_0_hs_p1 wl_2_hs_p1 2.4327e-17
ccc_bl_1_rbl_0_hs_p1 bl_1_hs_p1 rbl_0_hs_p1 1.29795e-16
ccc_bl_1_rwl_0_hs_p1 bl_1_hs_p1 rwl_0_hs_p1 9.028e-18
ccc_bl_1_rwl_1_hs_p1 bl_1_hs_p1 rwl_1_hs_p1 9.028e-18
ccc_bl_1_rwl_2_hs_p1 bl_1_hs_p1 rwl_2_hs_p1 9.028e-18
ccc_bl_1_rwl_3_hs_p1 bl_1_hs_p1 rwl_3_hs_p1 9.028e-18
ccc_bl_1_sn_0_1_hs_p1 bl_1_hs_p1 sn_0_1_hs_p1 1.071e-17
ccc_bl_1_sn_1_1_hs_p1 bl_1_hs_p1 sn_1_1_hs_p1 1.071e-17
ccc_bl_1_sn_2_1_hs_p1 bl_1_hs_p1 sn_2_1_hs_p1 1.071e-17
ccc_bl_1_sn_3_1_hs_p1 bl_1_hs_p1 sn_3_1_hs_p1 1.071e-17
ccc_bl_1_wl_0_hs_p1 bl_1_hs_p1 wl_0_hs_p1 2.7627e-17
ccc_bl_1_wl_1_hs_p1 bl_1_hs_p1 wl_1_hs_p1 2.7627e-17
ccc_bl_1_wl_2_hs_p1 bl_1_hs_p1 wl_2_hs_p1 2.7627e-17
ccc_bl_2_rbl_1_hs_p1 bl_2_hs_p1 rbl_1_hs_p1 1.29795e-16
ccc_bl_2_rwl_0_hs_p1 bl_2_hs_p1 rwl_0_hs_p1 9.028e-18
ccc_bl_2_rwl_1_hs_p1 bl_2_hs_p1 rwl_1_hs_p1 9.028e-18
ccc_bl_2_rwl_2_hs_p1 bl_2_hs_p1 rwl_2_hs_p1 9.028e-18
ccc_bl_2_rwl_3_hs_p1 bl_2_hs_p1 rwl_3_hs_p1 9.028e-18
ccc_bl_2_sn_0_2_hs_p1 bl_2_hs_p1 sn_0_2_hs_p1 1.071e-17
ccc_bl_2_sn_1_2_hs_p1 bl_2_hs_p1 sn_1_2_hs_p1 1.071e-17
ccc_bl_2_sn_2_2_hs_p1 bl_2_hs_p1 sn_2_2_hs_p1 1.071e-17
ccc_bl_2_sn_3_2_hs_p1 bl_2_hs_p1 sn_3_2_hs_p1 1.071e-17
ccc_bl_2_wl_0_hs_p1 bl_2_hs_p1 wl_0_hs_p1 2.7627e-17
ccc_bl_2_wl_1_hs_p1 bl_2_hs_p1 wl_1_hs_p1 2.7627e-17
ccc_bl_2_wl_2_hs_p1 bl_2_hs_p1 wl_2_hs_p1 2.7627e-17
ccc_bl_3_rbl_2_hs_p1 bl_3_hs_p1 rbl_2_hs_p1 1.29795e-16
ccc_bl_3_rwl_0_hs_p1 bl_3_hs_p1 rwl_0_hs_p1 9.028e-18
ccc_bl_3_rwl_1_hs_p1 bl_3_hs_p1 rwl_1_hs_p1 9.028e-18
ccc_bl_3_rwl_2_hs_p1 bl_3_hs_p1 rwl_2_hs_p1 9.028e-18
ccc_bl_3_rwl_3_hs_p1 bl_3_hs_p1 rwl_3_hs_p1 9.028e-18
ccc_bl_3_sn_0_3_hs_p1 bl_3_hs_p1 sn_0_3_hs_p1 1.071e-17
ccc_bl_3_sn_1_3_hs_p1 bl_3_hs_p1 sn_1_3_hs_p1 1.071e-17
ccc_bl_3_sn_2_3_hs_p1 bl_3_hs_p1 sn_2_3_hs_p1 1.071e-17
ccc_bl_3_sn_3_3_hs_p1 bl_3_hs_p1 sn_3_3_hs_p1 1.071e-17
ccc_bl_3_wl_0_hs_p1 bl_3_hs_p1 wl_0_hs_p1 2.7627e-17
ccc_bl_3_wl_1_hs_p1 bl_3_hs_p1 wl_1_hs_p1 2.7627e-17
ccc_bl_3_wl_2_hs_p1 bl_3_hs_p1 wl_2_hs_p1 2.7627e-17
ccc_rbl_0_rwl_0_hs_p1 rbl_0_hs_p1 rwl_0_hs_p1 1.9738e-17
ccc_rbl_0_rwl_1_hs_p1 rbl_0_hs_p1 rwl_1_hs_p1 1.9738e-17
ccc_rbl_0_rwl_2_hs_p1 rbl_0_hs_p1 rwl_2_hs_p1 1.9738e-17
ccc_rbl_0_rwl_3_hs_p1 rbl_0_hs_p1 rwl_3_hs_p1 1.9738e-17
ccc_rbl_0_sn_0_0_hs_p1 rbl_0_hs_p1 sn_0_0_hs_p1 1.071e-17
ccc_rbl_0_sn_1_0_hs_p1 rbl_0_hs_p1 sn_1_0_hs_p1 2.4327e-17
ccc_rbl_0_sn_2_0_hs_p1 rbl_0_hs_p1 sn_2_0_hs_p1 2.4327e-17
ccc_rbl_0_wl_0_hs_p1 rbl_0_hs_p1 wl_0_hs_p1 3.3e-18
ccc_rbl_0_wl_1_hs_p1 rbl_0_hs_p1 wl_1_hs_p1 3.3e-18
ccc_rbl_0_wl_2_hs_p1 rbl_0_hs_p1 wl_2_hs_p1 3.3e-18
ccc_rbl_1_rwl_0_hs_p1 rbl_1_hs_p1 rwl_0_hs_p1 1.9738e-17
ccc_rbl_1_rwl_1_hs_p1 rbl_1_hs_p1 rwl_1_hs_p1 1.9738e-17
ccc_rbl_1_rwl_2_hs_p1 rbl_1_hs_p1 rwl_2_hs_p1 1.9738e-17
ccc_rbl_1_rwl_3_hs_p1 rbl_1_hs_p1 rwl_3_hs_p1 1.9738e-17
ccc_rbl_1_sn_0_1_hs_p1 rbl_1_hs_p1 sn_0_1_hs_p1 1.071e-17
ccc_rbl_1_sn_1_1_hs_p1 rbl_1_hs_p1 sn_1_1_hs_p1 2.4327e-17
ccc_rbl_1_sn_2_1_hs_p1 rbl_1_hs_p1 sn_2_1_hs_p1 2.4327e-17
ccc_rbl_1_wl_0_hs_p1 rbl_1_hs_p1 wl_0_hs_p1 3.3e-18
ccc_rbl_1_wl_1_hs_p1 rbl_1_hs_p1 wl_1_hs_p1 3.3e-18
ccc_rbl_1_wl_2_hs_p1 rbl_1_hs_p1 wl_2_hs_p1 3.3e-18
ccc_rbl_2_rwl_0_hs_p1 rbl_2_hs_p1 rwl_0_hs_p1 1.9738e-17
ccc_rbl_2_rwl_1_hs_p1 rbl_2_hs_p1 rwl_1_hs_p1 1.9738e-17
ccc_rbl_2_rwl_2_hs_p1 rbl_2_hs_p1 rwl_2_hs_p1 1.9738e-17
ccc_rbl_2_rwl_3_hs_p1 rbl_2_hs_p1 rwl_3_hs_p1 1.9738e-17
ccc_rbl_2_sn_0_2_hs_p1 rbl_2_hs_p1 sn_0_2_hs_p1 1.071e-17
ccc_rbl_2_sn_1_2_hs_p1 rbl_2_hs_p1 sn_1_2_hs_p1 2.4327e-17
ccc_rbl_2_sn_2_2_hs_p1 rbl_2_hs_p1 sn_2_2_hs_p1 2.4327e-17
ccc_rbl_2_wl_0_hs_p1 rbl_2_hs_p1 wl_0_hs_p1 3.3e-18
ccc_rbl_2_wl_1_hs_p1 rbl_2_hs_p1 wl_1_hs_p1 3.3e-18
ccc_rbl_2_wl_2_hs_p1 rbl_2_hs_p1 wl_2_hs_p1 3.3e-18
ccc_rbl_3_rwl_0_hs_p1 rbl_3_hs_p1 rwl_0_hs_p1 1.071e-17
ccc_rbl_3_rwl_1_hs_p1 rbl_3_hs_p1 rwl_1_hs_p1 1.071e-17
ccc_rbl_3_rwl_2_hs_p1 rbl_3_hs_p1 rwl_2_hs_p1 1.071e-17
ccc_rbl_3_rwl_3_hs_p1 rbl_3_hs_p1 rwl_3_hs_p1 1.071e-17
ccc_rbl_3_sn_0_3_hs_p1 rbl_3_hs_p1 sn_0_3_hs_p1 1.071e-17
ccc_rbl_3_sn_1_3_hs_p1 rbl_3_hs_p1 sn_1_3_hs_p1 2.4327e-17
ccc_rbl_3_sn_2_3_hs_p1 rbl_3_hs_p1 sn_2_3_hs_p1 2.4327e-17
ccc_rwl_0_sn_0_0_hs_p1 rwl_0_hs_p1 sn_0_0_hs_p1 1.0072e-17
ccc_rwl_0_sn_0_1_hs_p1 rwl_0_hs_p1 sn_0_1_hs_p1 1.9682e-17
ccc_rwl_0_sn_0_2_hs_p1 rwl_0_hs_p1 sn_0_2_hs_p1 1.9682e-17
ccc_rwl_0_sn_0_3_hs_p1 rwl_0_hs_p1 sn_0_3_hs_p1 1.9682e-17
ccc_rwl_1_sn_1_0_hs_p1 rwl_1_hs_p1 sn_1_0_hs_p1 1.0072e-17
ccc_rwl_1_sn_1_1_hs_p1 rwl_1_hs_p1 sn_1_1_hs_p1 1.9682e-17
ccc_rwl_1_sn_1_2_hs_p1 rwl_1_hs_p1 sn_1_2_hs_p1 1.9682e-17
ccc_rwl_1_sn_1_3_hs_p1 rwl_1_hs_p1 sn_1_3_hs_p1 1.9682e-17
ccc_rwl_2_sn_2_0_hs_p1 rwl_2_hs_p1 sn_2_0_hs_p1 1.0072e-17
ccc_rwl_2_sn_2_1_hs_p1 rwl_2_hs_p1 sn_2_1_hs_p1 1.9682e-17
ccc_rwl_2_sn_2_2_hs_p1 rwl_2_hs_p1 sn_2_2_hs_p1 1.9682e-17
ccc_rwl_2_sn_2_3_hs_p1 rwl_2_hs_p1 sn_2_3_hs_p1 1.9682e-17
ccc_rwl_3_sn_3_0_hs_p1 rwl_3_hs_p1 sn_3_0_hs_p1 1.0072e-17
ccc_rwl_3_sn_3_1_hs_p1 rwl_3_hs_p1 sn_3_1_hs_p1 1.9682e-17
ccc_rwl_3_sn_3_2_hs_p1 rwl_3_hs_p1 sn_3_2_hs_p1 1.9682e-17
ccc_rwl_3_sn_3_3_hs_p1 rwl_3_hs_p1 sn_3_3_hs_p1 1.9682e-17
ccc_sn_0_0_wl_0_hs_p1 sn_0_0_hs_p1 wl_0_hs_p1 1.9664e-17
ccc_sn_0_1_wl_0_hs_p1 sn_0_1_hs_p1 wl_0_hs_p1 1.9664e-17
ccc_sn_0_2_wl_0_hs_p1 sn_0_2_hs_p1 wl_0_hs_p1 1.9664e-17
ccc_sn_0_3_wl_0_hs_p1 sn_0_3_hs_p1 wl_0_hs_p1 1.3668e-17
ccc_sn_1_0_wl_1_hs_p1 sn_1_0_hs_p1 wl_1_hs_p1 1.9664e-17
ccc_sn_1_1_wl_1_hs_p1 sn_1_1_hs_p1 wl_1_hs_p1 1.6705e-17
ccc_sn_1_2_wl_1_hs_p1 sn_1_2_hs_p1 wl_1_hs_p1 1.6705e-17
ccc_sn_1_3_wl_1_hs_p1 sn_1_3_hs_p1 wl_1_hs_p1 1.071e-17
ccc_sn_2_0_wl_2_hs_p1 sn_2_0_hs_p1 wl_2_hs_p1 1.9664e-17
ccc_sn_2_1_wl_2_hs_p1 sn_2_1_hs_p1 wl_2_hs_p1 1.6705e-17
ccc_sn_2_2_wl_2_hs_p1 sn_2_2_hs_p1 wl_2_hs_p1 1.6705e-17
ccc_sn_2_3_wl_2_hs_p1 sn_2_3_hs_p1 wl_2_hs_p1 1.071e-17
ccc_sn_3_0_wl_3_hs_p1 sn_3_0_hs_p1 wl_3_hs_p1 1.9664e-17
ccc_sn_3_1_wl_3_hs_p1 sn_3_1_hs_p1 wl_3_hs_p1 1.6705e-17
ccc_sn_3_2_wl_3_hs_p1 sn_3_2_hs_p1 wl_3_hs_p1 1.6705e-17
ccc_sn_3_3_wl_3_hs_p1 sn_3_3_hs_p1 wl_3_hs_p1 1.071e-17
vdw_hs_p1_0 wl_0_hs_p1 g_wl_one dc 0
vdr_hs_p1_0 rwl_0_hs_p1 vdd dc 0
vdw_hs_p1_1 wl_1_hs_p1 0 dc 0
vdr_hs_p1_1 rwl_1_hs_p1 vdd dc 0
vdw_hs_p1_2 wl_2_hs_p1 0 dc 0
vdr_hs_p1_2 rwl_2_hs_p1 vdd dc 0
vdw_hs_p1_3 wl_3_hs_p1 0 dc 0
vdr_hs_p1_3 rwl_3_hs_p1 vdd dc 0
vdb_hs_p1_0 bl_0_hs_p1 0 dc 0
vdp_hs_p1_0 rbl_0_hs_p1 vrbl dc 0
vdb_hs_p1_1 bl_1_hs_p1 g_hi_one dc 0
vdp_hs_p1_1 rbl_1_hs_p1 vrbl dc 0
vdb_hs_p1_2 bl_2_hs_p1 vdd dc 0
vdp_hs_p1_2 rbl_2_hs_p1 vrbl dc 0
vdb_hs_p1_3 bl_3_hs_p1 0 dc 0
vdp_hs_p1_3 rbl_3_hs_p1 vrbl dc 0

* ---- instance hs_p0: family hs_p0 ----
xm1_hs_p0 sn_0_0__t0_hs_p0 wl_0__t3_hs_p0 bl_0__t0_hs_p0 gnd__t0_hs_p0 sky130_fd_pr__nfet_01v8 L=0.15 W=0.42 nf=1 ad=0.1974 as=0.1974 pd=1.78 ps=1.78 mult=1 m=1
xm2_hs_p0 rbl_0__t0_hs_p0 sn_0_0__t1_hs_p0 rwl_0__t0_hs_p0 gnd__t1_hs_p0 sky130_fd_pr__nfet_01v8 L=0.15 W=0.42 nf=1 ad=0.1974 as=0.1974 pd=1.78 ps=1.78 mult=1 m=1
xm3_hs_p0 sn_0_1__t1_hs_p0 wl_0__t0_hs_p0 bl_1__t0_hs_p0 gnd__t2_hs_p0 sky130_fd_pr__nfet_01v8 L=0.15 W=0.42 nf=1 ad=0.1974 as=0.1974 pd=1.78 ps=1.78 mult=1 m=1
xm4_hs_p0 rbl_1__t0_hs_p0 sn_0_1__t0_hs_p0 rwl_0__t1_hs_p0 gnd__t3_hs_p0 sky130_fd_pr__nfet_01v8 L=0.15 W=0.42 nf=1 ad=0.1974 as=0.1974 pd=1.78 ps=1.78 mult=1 m=1
xm5_hs_p0 sn_0_2__t1_hs_p0 wl_0__t1_hs_p0 bl_2__t0_hs_p0 gnd__t4_hs_p0 sky130_fd_pr__nfet_01v8 L=0.15 W=0.42 nf=1 ad=0.1974 as=0.1974 pd=1.78 ps=1.78 mult=1 m=1
xm6_hs_p0 rbl_2__t0_hs_p0 sn_0_2__t0_hs_p0 rwl_0__t2_hs_p0 gnd__t5_hs_p0 sky130_fd_pr__nfet_01v8 L=0.15 W=0.42 nf=1 ad=0.1974 as=0.1974 pd=1.78 ps=1.78 mult=1 m=1
xm7_hs_p0 sn_0_3__t1_hs_p0 wl_0__t2_hs_p0 bl_3__t0_hs_p0 gnd__t6_hs_p0 sky130_fd_pr__nfet_01v8 L=0.15 W=0.42 nf=1 ad=0.1974 as=0.1974 pd=1.78 ps=1.78 mult=1 m=1
xm8_hs_p0 rbl_3__t0_hs_p0 sn_0_3__t0_hs_p0 rwl_0__t3_hs_p0 gnd__t7_hs_p0 sky130_fd_pr__nfet_01v8 L=0.15 W=0.42 nf=1 ad=0.1974 as=0.1974 pd=1.78 ps=1.78 mult=1 m=1
xm9_hs_p0 sn_1_0__t1_hs_p0 wl_1__t0_hs_p0 bl_0__t1_hs_p0 gnd__t8_hs_p0 sky130_fd_pr__nfet_01v8 L=0.15 W=0.42 nf=1 ad=0.1974 as=0.1974 pd=1.78 ps=1.78 mult=1 m=1
xm10_hs_p0 rbl_0__t1_hs_p0 sn_1_0__t0_hs_p0 rwl_1__t0_hs_p0 gnd__t9_hs_p0 sky130_fd_pr__nfet_01v8 L=0.15 W=0.42 nf=1 ad=0.1974 as=0.1974 pd=1.78 ps=1.78 mult=1 m=1
xm11_hs_p0 sn_1_1__t1_hs_p0 wl_1__t1_hs_p0 bl_1__t1_hs_p0 gnd__t10_hs_p0 sky130_fd_pr__nfet_01v8 L=0.15 W=0.42 nf=1 ad=0.1974 as=0.1974 pd=1.78 ps=1.78 mult=1 m=1
xm12_hs_p0 rbl_1__t1_hs_p0 sn_1_1__t0_hs_p0 rwl_1__t1_hs_p0 gnd__t11_hs_p0 sky130_fd_pr__nfet_01v8 L=0.15 W=0.42 nf=1 ad=0.1974 as=0.1974 pd=1.78 ps=1.78 mult=1 m=1
xm13_hs_p0 sn_1_2__t1_hs_p0 wl_1__t2_hs_p0 bl_2__t1_hs_p0 gnd__t12_hs_p0 sky130_fd_pr__nfet_01v8 L=0.15 W=0.42 nf=1 ad=0.1974 as=0.1974 pd=1.78 ps=1.78 mult=1 m=1
xm14_hs_p0 rbl_2__t1_hs_p0 sn_1_2__t0_hs_p0 rwl_1__t2_hs_p0 gnd__t13_hs_p0 sky130_fd_pr__nfet_01v8 L=0.15 W=0.42 nf=1 ad=0.1974 as=0.1974 pd=1.78 ps=1.78 mult=1 m=1
xm15_hs_p0 sn_1_3__t1_hs_p0 wl_1__t3_hs_p0 bl_3__t1_hs_p0 gnd__t14_hs_p0 sky130_fd_pr__nfet_01v8 L=0.15 W=0.42 nf=1 ad=0.1974 as=0.1974 pd=1.78 ps=1.78 mult=1 m=1
xm16_hs_p0 rbl_3__t1_hs_p0 sn_1_3__t0_hs_p0 rwl_1__t3_hs_p0 gnd__t15_hs_p0 sky130_fd_pr__nfet_01v8 L=0.15 W=0.42 nf=1 ad=0.1974 as=0.1974 pd=1.78 ps=1.78 mult=1 m=1
xm17_hs_p0 sn_2_0__t1_hs_p0 wl_2__t3_hs_p0 bl_0__t3_hs_p0 gnd__t16_hs_p0 sky130_fd_pr__nfet_01v8 L=0.15 W=0.42 nf=1 ad=0.1974 as=0.1974 pd=1.78 ps=1.78 mult=1 m=1
xm18_hs_p0 rbl_0__t2_hs_p0 sn_2_0__t0_hs_p0 rwl_2__t0_hs_p0 gnd__t17_hs_p0 sky130_fd_pr__nfet_01v8 L=0.15 W=0.42 nf=1 ad=0.1974 as=0.1974 pd=1.78 ps=1.78 mult=1 m=1
xm19_hs_p0 sn_2_1__t1_hs_p0 wl_2__t0_hs_p0 bl_1__t2_hs_p0 gnd__t18_hs_p0 sky130_fd_pr__nfet_01v8 L=0.15 W=0.42 nf=1 ad=0.1974 as=0.1974 pd=1.78 ps=1.78 mult=1 m=1
xm20_hs_p0 rbl_1__t2_hs_p0 sn_2_1__t0_hs_p0 rwl_2__t1_hs_p0 gnd__t19_hs_p0 sky130_fd_pr__nfet_01v8 L=0.15 W=0.42 nf=1 ad=0.1974 as=0.1974 pd=1.78 ps=1.78 mult=1 m=1
xm21_hs_p0 sn_2_2__t1_hs_p0 wl_2__t1_hs_p0 bl_2__t2_hs_p0 gnd__t20_hs_p0 sky130_fd_pr__nfet_01v8 L=0.15 W=0.42 nf=1 ad=0.1974 as=0.1974 pd=1.78 ps=1.78 mult=1 m=1
xm22_hs_p0 rbl_2__t2_hs_p0 sn_2_2__t0_hs_p0 rwl_2__t2_hs_p0 gnd__t21_hs_p0 sky130_fd_pr__nfet_01v8 L=0.15 W=0.42 nf=1 ad=0.1974 as=0.1974 pd=1.78 ps=1.78 mult=1 m=1
xm23_hs_p0 sn_2_3__t1_hs_p0 wl_2__t2_hs_p0 bl_3__t2_hs_p0 gnd__t22_hs_p0 sky130_fd_pr__nfet_01v8 L=0.15 W=0.42 nf=1 ad=0.1974 as=0.1974 pd=1.78 ps=1.78 mult=1 m=1
xm24_hs_p0 rbl_3__t2_hs_p0 sn_2_3__t0_hs_p0 rwl_2__t3_hs_p0 gnd__t23_hs_p0 sky130_fd_pr__nfet_01v8 L=0.15 W=0.42 nf=1 ad=0.1974 as=0.1974 pd=1.78 ps=1.78 mult=1 m=1
xm25_hs_p0 sn_3_0__t1_hs_p0 wl_3__t0_hs_p0 bl_0__t2_hs_p0 gnd__t24_hs_p0 sky130_fd_pr__nfet_01v8 L=0.15 W=0.42 nf=1 ad=0.1974 as=0.1974 pd=1.78 ps=1.78 mult=1 m=1
xm26_hs_p0 rbl_0__t3_hs_p0 sn_3_0__t0_hs_p0 rwl_3__t0_hs_p0 gnd__t25_hs_p0 sky130_fd_pr__nfet_01v8 L=0.15 W=0.42 nf=1 ad=0.1974 as=0.1974 pd=1.78 ps=1.78 mult=1 m=1
xm27_hs_p0 sn_3_1__t1_hs_p0 wl_3__t1_hs_p0 bl_1__t3_hs_p0 gnd__t26_hs_p0 sky130_fd_pr__nfet_01v8 L=0.15 W=0.42 nf=1 ad=0.1974 as=0.1974 pd=1.78 ps=1.78 mult=1 m=1
xm28_hs_p0 rbl_1__t3_hs_p0 sn_3_1__t0_hs_p0 rwl_3__t1_hs_p0 gnd__t27_hs_p0 sky130_fd_pr__nfet_01v8 L=0.15 W=0.42 nf=1 ad=0.1974 as=0.1974 pd=1.78 ps=1.78 mult=1 m=1
xm29_hs_p0 sn_3_2__t1_hs_p0 wl_3__t2_hs_p0 bl_2__t3_hs_p0 gnd__t28_hs_p0 sky130_fd_pr__nfet_01v8 L=0.15 W=0.42 nf=1 ad=0.1974 as=0.1974 pd=1.78 ps=1.78 mult=1 m=1
xm30_hs_p0 rbl_2__t3_hs_p0 sn_3_2__t0_hs_p0 rwl_3__t2_hs_p0 gnd__t29_hs_p0 sky130_fd_pr__nfet_01v8 L=0.15 W=0.42 nf=1 ad=0.1974 as=0.1974 pd=1.78 ps=1.78 mult=1 m=1
xm31_hs_p0 sn_3_3__t1_hs_p0 wl_3__t3_hs_p0 bl_3__t3_hs_p0 gnd__t30_hs_p0 sky130_fd_pr__nfet_01v8 L=0.15 W=0.42 nf=1 ad=0.1974 as=0.1974 pd=1.78 ps=1.78 mult=1 m=1
xm32_hs_p0 rbl_3__t3_hs_p0 sn_3_3__t0_hs_p0 rwl_3__t3_hs_p0 gnd__t31_hs_p0 sky130_fd_pr__nfet_01v8 L=0.15 W=0.42 nf=1 ad=0.1974 as=0.1974 pd=1.78 ps=1.78 mult=1 m=1
rgnd_t0_hs_p0 gnd__t0_hs_p0 0 63.3529
rgnd_t1_hs_p0 gnd__t1_hs_p0 0 49.0465
rgnd_t2_hs_p0 gnd__t2_hs_p0 0 36.5177
rgnd_t3_hs_p0 gnd__t3_hs_p0 0 28.2406
rgnd_t4_hs_p0 gnd__t4_hs_p0 0 28.2406
rgnd_t5_hs_p0 gnd__t5_hs_p0 0 36.5177
rgnd_t6_hs_p0 gnd__t6_hs_p0 0 49.0465
rgnd_t7_hs_p0 gnd__t7_hs_p0 0 63.3529
rgnd_t8_hs_p0 gnd__t8_hs_p0 0 58.0019
rgnd_t9_hs_p0 gnd__t9_hs_p0 0 41.907
rgnd_t10_hs_p0 gnd__t10_hs_p0 0 26.1568
rgnd_t11_hs_p0 gnd__t11_hs_p0 0 12.1726
rgnd_t12_hs_p0 gnd__t12_hs_p0 0 12.1726
rgnd_t13_hs_p0 gnd__t13_hs_p0 0 26.1568
rgnd_t14_hs_p0 gnd__t14_hs_p0 0 41.907
rgnd_t15_hs_p0 gnd__t15_hs_p0 0 58.0019
rgnd_t16_hs_p0 gnd__t16_hs_p0 0 58.0019
rgnd_t17_hs_p0 gnd__t17_hs_p0 0 41.907
rgnd_t18_hs_p0 gnd__t18_hs_p0 0 26.1568
rgnd_t19_hs_p0 gnd__t19_hs_p0 0 12.1726
rgnd_t20_hs_p0 gnd__t20_hs_p0 0 12.1726
rgnd_t21_hs_p0 gnd__t21_hs_p0 0 26.1568
rgnd_t22_hs_p0 gnd__t22_hs_p0 0 41.907
rgnd_t23_hs_p0 gnd__t23_hs_p0 0 58.0019
rgnd_t24_hs_p0 gnd__t24_hs_p0 0 63.3529
rgnd_t25_hs_p0 gnd__t25_hs_p0 0 49.0465
rgnd_t26_hs_p0 gnd__t26_hs_p0 0 36.5177
rgnd_t27_hs_p0 gnd__t27_hs_p0 0 28.2406
rgnd_t28_hs_p0 gnd__t28_hs_p0 0 28.2406
rgnd_t29_hs_p0 gnd__t29_hs_p0 0 36.5177
rgnd_t30_hs_p0 gnd__t30_hs_p0 0 49.0465
rgnd_t31_hs_p0 gnd__t31_hs_p0 0 63.3529
rbl_0_t0_hs_p0 bl_0__t0_hs_p0 bl_0_hs_p0 144.555
rbl_0_t1_hs_p0 bl_0__t1_hs_p0 bl_0_hs_p0 48.1851
rbl_0_t2_hs_p0 bl_0__t2_hs_p0 bl_0_hs_p0 144.555
rbl_0_t3_hs_p0 bl_0__t3_hs_p0 bl_0_hs_p0 48.1851
rbl_1_t0_hs_p0 bl_1__t0_hs_p0 bl_1_hs_p0 144.555
rbl_1_t1_hs_p0 bl_1__t1_hs_p0 bl_1_hs_p0 48.1851
rbl_1_t2_hs_p0 bl_1__t2_hs_p0 bl_1_hs_p0 48.1851
rbl_1_t3_hs_p0 bl_1__t3_hs_p0 bl_1_hs_p0 144.555
rbl_2_t0_hs_p0 bl_2__t0_hs_p0 bl_2_hs_p0 144.555
rbl_2_t1_hs_p0 bl_2__t1_hs_p0 bl_2_hs_p0 48.1851
rbl_2_t2_hs_p0 bl_2__t2_hs_p0 bl_2_hs_p0 48.1851
rbl_2_t3_hs_p0 bl_2__t3_hs_p0 bl_2_hs_p0 144.555
rbl_3_t0_hs_p0 bl_3__t0_hs_p0 bl_3_hs_p0 144.555
rbl_3_t1_hs_p0 bl_3__t1_hs_p0 bl_3_hs_p0 48.1851
rbl_3_t2_hs_p0 bl_3__t2_hs_p0 bl_3_hs_p0 48.1851
rbl_3_t3_hs_p0 bl_3__t3_hs_p0 bl_3_hs_p0 144.555
rrbl_0_t0_hs_p0 rbl_0__t0_hs_p0 rbl_0_hs_p0 144.555
rrbl_0_t1_hs_p0 rbl_0__t1_hs_p0 rbl_0_hs_p0 48.1851
rrbl_0_t2_hs_p0 rbl_0__t2_hs_p0 rbl_0_hs_p0 48.1851
rrbl_0_t3_hs_p0 rbl_0__t3_hs_p0 rbl_0_hs_p0 144.555
rrbl_1_t0_hs_p0 rbl_1__t0_hs_p0 rbl_1_hs_p0 144.555
rrbl_1_t1_hs_p0 rbl_1__t1_hs_p0 rbl_1_hs_p0 48.1851
rrbl_1_t2_hs_p0 rbl_1__t2_hs_p0 rbl_1_hs_p0 48.1851
rrbl_1_t3_hs_p0 rbl_1__t3_hs_p0 rbl_1_hs_p0 144.555
rrbl_2_t0_hs_p0 rbl_2__t0_hs_p0 rbl_2_hs_p0 144.555
rrbl_2_t1_hs_p0 rbl_2__t1_hs_p0 rbl_2_hs_p0 48.1851
rrbl_2_t2_hs_p0 rbl_2__t2_hs_p0 rbl_2_hs_p0 48.1851
rrbl_2_t3_hs_p0 rbl_2__t3_hs_p0 rbl_2_hs_p0 144.555
rrbl_3_t0_hs_p0 rbl_3__t0_hs_p0 rbl_3_hs_p0 144.555
rrbl_3_t1_hs_p0 rbl_3__t1_hs_p0 rbl_3_hs_p0 48.1851
rrbl_3_t2_hs_p0 rbl_3__t2_hs_p0 rbl_3_hs_p0 48.1851
rrbl_3_t3_hs_p0 rbl_3__t3_hs_p0 rbl_3_hs_p0 144.555
rrwl_0_t0_hs_p0 rwl_0__t0_hs_p0 rwl_0_hs_p0 21.6897
rrwl_0_t1_hs_p0 rwl_0__t1_hs_p0 rwl_0_hs_p0 7.22989
rrwl_0_t2_hs_p0 rwl_0__t2_hs_p0 rwl_0_hs_p0 7.22989
rrwl_0_t3_hs_p0 rwl_0__t3_hs_p0 rwl_0_hs_p0 21.6897
rrwl_1_t0_hs_p0 rwl_1__t0_hs_p0 rwl_1_hs_p0 21.6897
rrwl_1_t1_hs_p0 rwl_1__t1_hs_p0 rwl_1_hs_p0 7.22989
rrwl_1_t2_hs_p0 rwl_1__t2_hs_p0 rwl_1_hs_p0 7.22989
rrwl_1_t3_hs_p0 rwl_1__t3_hs_p0 rwl_1_hs_p0 21.6897
rrwl_2_t0_hs_p0 rwl_2__t0_hs_p0 rwl_2_hs_p0 21.6897
rrwl_2_t1_hs_p0 rwl_2__t1_hs_p0 rwl_2_hs_p0 7.22989
rrwl_2_t2_hs_p0 rwl_2__t2_hs_p0 rwl_2_hs_p0 7.22989
rrwl_2_t3_hs_p0 rwl_2__t3_hs_p0 rwl_2_hs_p0 21.6897
rrwl_3_t0_hs_p0 rwl_3__t0_hs_p0 rwl_3_hs_p0 21.6897
rrwl_3_t1_hs_p0 rwl_3__t1_hs_p0 rwl_3_hs_p0 7.22989
rrwl_3_t2_hs_p0 rwl_3__t2_hs_p0 rwl_3_hs_p0 7.22989
rrwl_3_t3_hs_p0 rwl_3__t3_hs_p0 rwl_3_hs_p0 21.6897
rsn_0_0_t0_hs_p0 sn_0_0__t0_hs_p0 sn_0_0_hs_p0 125.123
rsn_0_0_t1_hs_p0 sn_0_0__t1_hs_p0 sn_0_0_hs_p0 125.123
rsn_0_1_t0_hs_p0 sn_0_1__t0_hs_p0 sn_0_1_hs_p0 125.123
rsn_0_1_t1_hs_p0 sn_0_1__t1_hs_p0 sn_0_1_hs_p0 125.123
rsn_0_2_t0_hs_p0 sn_0_2__t0_hs_p0 sn_0_2_hs_p0 125.123
rsn_0_2_t1_hs_p0 sn_0_2__t1_hs_p0 sn_0_2_hs_p0 125.123
rsn_0_3_t0_hs_p0 sn_0_3__t0_hs_p0 sn_0_3_hs_p0 125.123
rsn_0_3_t1_hs_p0 sn_0_3__t1_hs_p0 sn_0_3_hs_p0 125.123
rsn_1_0_t0_hs_p0 sn_1_0__t0_hs_p0 sn_1_0_hs_p0 125.123
rsn_1_0_t1_hs_p0 sn_1_0__t1_hs_p0 sn_1_0_hs_p0 125.123
rsn_1_1_t0_hs_p0 sn_1_1__t0_hs_p0 sn_1_1_hs_p0 125.123
rsn_1_1_t1_hs_p0 sn_1_1__t1_hs_p0 sn_1_1_hs_p0 125.123
rsn_1_2_t0_hs_p0 sn_1_2__t0_hs_p0 sn_1_2_hs_p0 125.123
rsn_1_2_t1_hs_p0 sn_1_2__t1_hs_p0 sn_1_2_hs_p0 125.123
rsn_1_3_t0_hs_p0 sn_1_3__t0_hs_p0 sn_1_3_hs_p0 125.123
rsn_1_3_t1_hs_p0 sn_1_3__t1_hs_p0 sn_1_3_hs_p0 125.123
rsn_2_0_t0_hs_p0 sn_2_0__t0_hs_p0 sn_2_0_hs_p0 125.123
rsn_2_0_t1_hs_p0 sn_2_0__t1_hs_p0 sn_2_0_hs_p0 125.123
rsn_2_1_t0_hs_p0 sn_2_1__t0_hs_p0 sn_2_1_hs_p0 125.123
rsn_2_1_t1_hs_p0 sn_2_1__t1_hs_p0 sn_2_1_hs_p0 125.123
rsn_2_2_t0_hs_p0 sn_2_2__t0_hs_p0 sn_2_2_hs_p0 125.123
rsn_2_2_t1_hs_p0 sn_2_2__t1_hs_p0 sn_2_2_hs_p0 125.123
rsn_2_3_t0_hs_p0 sn_2_3__t0_hs_p0 sn_2_3_hs_p0 125.123
rsn_2_3_t1_hs_p0 sn_2_3__t1_hs_p0 sn_2_3_hs_p0 125.123
rsn_3_0_t0_hs_p0 sn_3_0__t0_hs_p0 sn_3_0_hs_p0 125.123
rsn_3_0_t1_hs_p0 sn_3_0__t1_hs_p0 sn_3_0_hs_p0 125.123
rsn_3_1_t0_hs_p0 sn_3_1__t0_hs_p0 sn_3_1_hs_p0 125.123
rsn_3_1_t1_hs_p0 sn_3_1__t1_hs_p0 sn_3_1_hs_p0 125.123
rsn_3_2_t0_hs_p0 sn_3_2__t0_hs_p0 sn_3_2_hs_p0 125.123
rsn_3_2_t1_hs_p0 sn_3_2__t1_hs_p0 sn_3_2_hs_p0 125.123
rsn_3_3_t0_hs_p0 sn_3_3__t0_hs_p0 sn_3_3_hs_p0 125.123
rsn_3_3_t1_hs_p0 sn_3_3__t1_hs_p0 sn_3_3_hs_p0 125.123
rwl_0_t0_hs_p0 wl_0__t0_hs_p0 wl_0_hs_p0 54.2844
rwl_0_t1_hs_p0 wl_0__t1_hs_p0 wl_0_hs_p0 54.2844
rwl_0_t2_hs_p0 wl_0__t2_hs_p0 wl_0_hs_p0 162.853
rwl_0_t3_hs_p0 wl_0__t3_hs_p0 wl_0_hs_p0 162.853
rwl_1_t0_hs_p0 wl_1__t0_hs_p0 wl_1_hs_p0 162.853
rwl_1_t1_hs_p0 wl_1__t1_hs_p0 wl_1_hs_p0 54.2844
rwl_1_t2_hs_p0 wl_1__t2_hs_p0 wl_1_hs_p0 54.2844
rwl_1_t3_hs_p0 wl_1__t3_hs_p0 wl_1_hs_p0 162.853
rwl_2_t0_hs_p0 wl_2__t0_hs_p0 wl_2_hs_p0 54.2844
rwl_2_t1_hs_p0 wl_2__t1_hs_p0 wl_2_hs_p0 54.2844
rwl_2_t2_hs_p0 wl_2__t2_hs_p0 wl_2_hs_p0 162.853
rwl_2_t3_hs_p0 wl_2__t3_hs_p0 wl_2_hs_p0 162.853
rwl_3_t0_hs_p0 wl_3__t0_hs_p0 wl_3_hs_p0 162.853
rwl_3_t1_hs_p0 wl_3__t1_hs_p0 wl_3_hs_p0 54.2844
rwl_3_t2_hs_p0 wl_3__t2_hs_p0 wl_3_hs_p0 54.2844
rwl_3_t3_hs_p0 wl_3__t3_hs_p0 wl_3_hs_p0 162.853
cgnd_hs_p0 0 0 4.09475e-15
cbl_0_hs_p0 bl_0_hs_p0 0 5.96076e-16
cbl_1_hs_p0 bl_1_hs_p0 0 5.81168e-16
cbl_2_hs_p0 bl_2_hs_p0 0 5.81168e-16
cbl_3_hs_p0 bl_3_hs_p0 0 5.81168e-16
crbl_0_hs_p0 rbl_0_hs_p0 0 5.81168e-16
crbl_1_hs_p0 rbl_1_hs_p0 0 5.81168e-16
crbl_2_hs_p0 rbl_2_hs_p0 0 5.81168e-16
crbl_3_hs_p0 rbl_3_hs_p0 0 5.96076e-16
crwl_0_hs_p0 rwl_0_hs_p0 0 1.18713e-15
crwl_1_hs_p0 rwl_1_hs_p0 0 1.18713e-15
crwl_2_hs_p0 rwl_2_hs_p0 0 1.18713e-15
crwl_3_hs_p0 rwl_3_hs_p0 0 1.18713e-15
csn_0_0_hs_p0 sn_0_0_hs_p0 0 4.33689e-16
csn_0_1_hs_p0 sn_0_1_hs_p0 0 4.30576e-16
csn_0_2_hs_p0 sn_0_2_hs_p0 0 4.30576e-16
csn_0_3_hs_p0 sn_0_3_hs_p0 0 4.32518e-16
csn_1_0_hs_p0 sn_1_0_hs_p0 0 4.33689e-16
csn_1_1_hs_p0 sn_1_1_hs_p0 0 4.30576e-16
csn_1_2_hs_p0 sn_1_2_hs_p0 0 4.30576e-16
csn_1_3_hs_p0 sn_1_3_hs_p0 0 4.32518e-16
csn_2_0_hs_p0 sn_2_0_hs_p0 0 4.33689e-16
csn_2_1_hs_p0 sn_2_1_hs_p0 0 4.30576e-16
csn_2_2_hs_p0 sn_2_2_hs_p0 0 4.30576e-16
csn_2_3_hs_p0 sn_2_3_hs_p0 0 4.32518e-16
csn_3_0_hs_p0 sn_3_0_hs_p0 0 4.33689e-16
csn_3_1_hs_p0 sn_3_1_hs_p0 0 4.30576e-16
csn_3_2_hs_p0 sn_3_2_hs_p0 0 4.30576e-16
csn_3_3_hs_p0 sn_3_3_hs_p0 0 4.32518e-16
cwl_0_hs_p0 wl_0_hs_p0 0 1.90928e-15
cwl_1_hs_p0 wl_1_hs_p0 0 1.90928e-15
cwl_2_hs_p0 wl_2_hs_p0 0 1.90928e-15
cwl_3_hs_p0 wl_3_hs_p0 0 1.91375e-15
ccc_bl_0_sn_0_0_hs_p0 bl_0_hs_p0 sn_0_0_hs_p0 1.071e-17
ccc_bl_0_sn_1_0_hs_p0 bl_0_hs_p0 sn_1_0_hs_p0 1.071e-17
ccc_bl_0_sn_2_0_hs_p0 bl_0_hs_p0 sn_2_0_hs_p0 1.071e-17
ccc_bl_0_sn_3_0_hs_p0 bl_0_hs_p0 sn_3_0_hs_p0 1.071e-17
ccc_bl_0_wl_0_hs_p0 bl_0_hs_p0 wl_0_hs_p0 2.4327e-17
ccc_bl_0_wl_1_hs_p0 bl_0_hs_p0 wl_1_hs_p0 2.4327e-17
ccc_bl_0_wl_2_hs_p0 bl_0_hs_p0 wl_2_hs_p0 2.4327e-17
ccc_bl_1_rbl_0_hs_p0 bl_1_hs_p0 rbl_0_hs_p0 1.29795e-16
ccc_bl_1_rwl_0_hs_p0 bl_1_hs_p0 rwl_0_hs_p0 9.028e-18
ccc_bl_1_rwl_1_hs_p0 bl_1_hs_p0 rwl_1_hs_p0 9.028e-18
ccc_bl_1_rwl_2_hs_p0 bl_1_hs_p0 rwl_2_hs_p0 9.028e-18
ccc_bl_1_rwl_3_hs_p0 bl_1_hs_p0 rwl_3_hs_p0 9.028e-18
ccc_bl_1_sn_0_1_hs_p0 bl_1_hs_p0 sn_0_1_hs_p0 1.071e-17
ccc_bl_1_sn_1_1_hs_p0 bl_1_hs_p0 sn_1_1_hs_p0 1.071e-17
ccc_bl_1_sn_2_1_hs_p0 bl_1_hs_p0 sn_2_1_hs_p0 1.071e-17
ccc_bl_1_sn_3_1_hs_p0 bl_1_hs_p0 sn_3_1_hs_p0 1.071e-17
ccc_bl_1_wl_0_hs_p0 bl_1_hs_p0 wl_0_hs_p0 2.7627e-17
ccc_bl_1_wl_1_hs_p0 bl_1_hs_p0 wl_1_hs_p0 2.7627e-17
ccc_bl_1_wl_2_hs_p0 bl_1_hs_p0 wl_2_hs_p0 2.7627e-17
ccc_bl_2_rbl_1_hs_p0 bl_2_hs_p0 rbl_1_hs_p0 1.29795e-16
ccc_bl_2_rwl_0_hs_p0 bl_2_hs_p0 rwl_0_hs_p0 9.028e-18
ccc_bl_2_rwl_1_hs_p0 bl_2_hs_p0 rwl_1_hs_p0 9.028e-18
ccc_bl_2_rwl_2_hs_p0 bl_2_hs_p0 rwl_2_hs_p0 9.028e-18
ccc_bl_2_rwl_3_hs_p0 bl_2_hs_p0 rwl_3_hs_p0 9.028e-18
ccc_bl_2_sn_0_2_hs_p0 bl_2_hs_p0 sn_0_2_hs_p0 1.071e-17
ccc_bl_2_sn_1_2_hs_p0 bl_2_hs_p0 sn_1_2_hs_p0 1.071e-17
ccc_bl_2_sn_2_2_hs_p0 bl_2_hs_p0 sn_2_2_hs_p0 1.071e-17
ccc_bl_2_sn_3_2_hs_p0 bl_2_hs_p0 sn_3_2_hs_p0 1.071e-17
ccc_bl_2_wl_0_hs_p0 bl_2_hs_p0 wl_0_hs_p0 2.7627e-17
ccc_bl_2_wl_1_hs_p0 bl_2_hs_p0 wl_1_hs_p0 2.7627e-17
ccc_bl_2_wl_2_hs_p0 bl_2_hs_p0 wl_2_hs_p0 2.7627e-17
ccc_bl_3_rbl_2_hs_p0 bl_3_hs_p0 rbl_2_hs_p0 1.29795e-16
ccc_bl_3_rwl_0_hs_p0 bl_3_hs_p0 rwl_0_hs_p0 9.028e-18
ccc_bl_3_rwl_1_hs_p0 bl_3_hs_p0 rwl_1_hs_p0 9.028e-18
ccc_bl_3_rwl_2_hs_p0 bl_3_hs_p0 rwl_2_hs_p0 9.028e-18
ccc_bl_3_rwl_3_hs_p0 bl_3_hs_p0 rwl_3_hs_p0 9.028e-18
ccc_bl_3_sn_0_3_hs_p0 bl_3_hs_p0 sn_0_3_hs_p0 1.071e-17
ccc_bl_3_sn_1_3_hs_p0 bl_3_hs_p0 sn_1_3_hs_p0 1.071e-17
ccc_bl_3_sn_2_3_hs_p0 bl_3_hs_p0 sn_2_3_hs_p0 1.071e-17
ccc_bl_3_sn_3_3_hs_p0 bl_3_hs_p0 sn_3_3_hs_p0 1.071e-17
ccc_bl_3_wl_0_hs_p0 bl_3_hs_p0 wl_0_hs_p0 2.7627e-17
ccc_bl_3_wl_1_hs_p0 bl_3_hs_p0 wl_1_hs_p0 2.7627e-17
ccc_bl_3_wl_2_hs_p0 bl_3_hs_p0 wl_2_hs_p0 2.7627e-17
ccc_rbl_0_rwl_0_hs_p0 rbl_0_hs_p0 rwl_0_hs_p0 1.9738e-17
ccc_rbl_0_rwl_1_hs_p0 rbl_0_hs_p0 rwl_1_hs_p0 1.9738e-17
ccc_rbl_0_rwl_2_hs_p0 rbl_0_hs_p0 rwl_2_hs_p0 1.9738e-17
ccc_rbl_0_rwl_3_hs_p0 rbl_0_hs_p0 rwl_3_hs_p0 1.9738e-17
ccc_rbl_0_sn_0_0_hs_p0 rbl_0_hs_p0 sn_0_0_hs_p0 1.071e-17
ccc_rbl_0_sn_1_0_hs_p0 rbl_0_hs_p0 sn_1_0_hs_p0 2.4327e-17
ccc_rbl_0_sn_2_0_hs_p0 rbl_0_hs_p0 sn_2_0_hs_p0 2.4327e-17
ccc_rbl_0_wl_0_hs_p0 rbl_0_hs_p0 wl_0_hs_p0 3.3e-18
ccc_rbl_0_wl_1_hs_p0 rbl_0_hs_p0 wl_1_hs_p0 3.3e-18
ccc_rbl_0_wl_2_hs_p0 rbl_0_hs_p0 wl_2_hs_p0 3.3e-18
ccc_rbl_1_rwl_0_hs_p0 rbl_1_hs_p0 rwl_0_hs_p0 1.9738e-17
ccc_rbl_1_rwl_1_hs_p0 rbl_1_hs_p0 rwl_1_hs_p0 1.9738e-17
ccc_rbl_1_rwl_2_hs_p0 rbl_1_hs_p0 rwl_2_hs_p0 1.9738e-17
ccc_rbl_1_rwl_3_hs_p0 rbl_1_hs_p0 rwl_3_hs_p0 1.9738e-17
ccc_rbl_1_sn_0_1_hs_p0 rbl_1_hs_p0 sn_0_1_hs_p0 1.071e-17
ccc_rbl_1_sn_1_1_hs_p0 rbl_1_hs_p0 sn_1_1_hs_p0 2.4327e-17
ccc_rbl_1_sn_2_1_hs_p0 rbl_1_hs_p0 sn_2_1_hs_p0 2.4327e-17
ccc_rbl_1_wl_0_hs_p0 rbl_1_hs_p0 wl_0_hs_p0 3.3e-18
ccc_rbl_1_wl_1_hs_p0 rbl_1_hs_p0 wl_1_hs_p0 3.3e-18
ccc_rbl_1_wl_2_hs_p0 rbl_1_hs_p0 wl_2_hs_p0 3.3e-18
ccc_rbl_2_rwl_0_hs_p0 rbl_2_hs_p0 rwl_0_hs_p0 1.9738e-17
ccc_rbl_2_rwl_1_hs_p0 rbl_2_hs_p0 rwl_1_hs_p0 1.9738e-17
ccc_rbl_2_rwl_2_hs_p0 rbl_2_hs_p0 rwl_2_hs_p0 1.9738e-17
ccc_rbl_2_rwl_3_hs_p0 rbl_2_hs_p0 rwl_3_hs_p0 1.9738e-17
ccc_rbl_2_sn_0_2_hs_p0 rbl_2_hs_p0 sn_0_2_hs_p0 1.071e-17
ccc_rbl_2_sn_1_2_hs_p0 rbl_2_hs_p0 sn_1_2_hs_p0 2.4327e-17
ccc_rbl_2_sn_2_2_hs_p0 rbl_2_hs_p0 sn_2_2_hs_p0 2.4327e-17
ccc_rbl_2_wl_0_hs_p0 rbl_2_hs_p0 wl_0_hs_p0 3.3e-18
ccc_rbl_2_wl_1_hs_p0 rbl_2_hs_p0 wl_1_hs_p0 3.3e-18
ccc_rbl_2_wl_2_hs_p0 rbl_2_hs_p0 wl_2_hs_p0 3.3e-18
ccc_rbl_3_rwl_0_hs_p0 rbl_3_hs_p0 rwl_0_hs_p0 1.071e-17
ccc_rbl_3_rwl_1_hs_p0 rbl_3_hs_p0 rwl_1_hs_p0 1.071e-17
ccc_rbl_3_rwl_2_hs_p0 rbl_3_hs_p0 rwl_2_hs_p0 1.071e-17
ccc_rbl_3_rwl_3_hs_p0 rbl_3_hs_p0 rwl_3_hs_p0 1.071e-17
ccc_rbl_3_sn_0_3_hs_p0 rbl_3_hs_p0 sn_0_3_hs_p0 1.071e-17
ccc_rbl_3_sn_1_3_hs_p0 rbl_3_hs_p0 sn_1_3_hs_p0 2.4327e-17
ccc_rbl_3_sn_2_3_hs_p0 rbl_3_hs_p0 sn_2_3_hs_p0 2.4327e-17
ccc_rwl_0_sn_0_0_hs_p0 rwl_0_hs_p0 sn_0_0_hs_p0 1.0072e-17
ccc_rwl_0_sn_0_1_hs_p0 rwl_0_hs_p0 sn_0_1_hs_p0 1.9682e-17
ccc_rwl_0_sn_0_2_hs_p0 rwl_0_hs_p0 sn_0_2_hs_p0 1.9682e-17
ccc_rwl_0_sn_0_3_hs_p0 rwl_0_hs_p0 sn_0_3_hs_p0 1.9682e-17
ccc_rwl_1_sn_1_0_hs_p0 rwl_1_hs_p0 sn_1_0_hs_p0 1.0072e-17
ccc_rwl_1_sn_1_1_hs_p0 rwl_1_hs_p0 sn_1_1_hs_p0 1.9682e-17
ccc_rwl_1_sn_1_2_hs_p0 rwl_1_hs_p0 sn_1_2_hs_p0 1.9682e-17
ccc_rwl_1_sn_1_3_hs_p0 rwl_1_hs_p0 sn_1_3_hs_p0 1.9682e-17
ccc_rwl_2_sn_2_0_hs_p0 rwl_2_hs_p0 sn_2_0_hs_p0 1.0072e-17
ccc_rwl_2_sn_2_1_hs_p0 rwl_2_hs_p0 sn_2_1_hs_p0 1.9682e-17
ccc_rwl_2_sn_2_2_hs_p0 rwl_2_hs_p0 sn_2_2_hs_p0 1.9682e-17
ccc_rwl_2_sn_2_3_hs_p0 rwl_2_hs_p0 sn_2_3_hs_p0 1.9682e-17
ccc_rwl_3_sn_3_0_hs_p0 rwl_3_hs_p0 sn_3_0_hs_p0 1.0072e-17
ccc_rwl_3_sn_3_1_hs_p0 rwl_3_hs_p0 sn_3_1_hs_p0 1.9682e-17
ccc_rwl_3_sn_3_2_hs_p0 rwl_3_hs_p0 sn_3_2_hs_p0 1.9682e-17
ccc_rwl_3_sn_3_3_hs_p0 rwl_3_hs_p0 sn_3_3_hs_p0 1.9682e-17
ccc_sn_0_0_wl_0_hs_p0 sn_0_0_hs_p0 wl_0_hs_p0 1.9664e-17
ccc_sn_0_1_wl_0_hs_p0 sn_0_1_hs_p0 wl_0_hs_p0 1.9664e-17
ccc_sn_0_2_wl_0_hs_p0 sn_0_2_hs_p0 wl_0_hs_p0 1.9664e-17
ccc_sn_0_3_wl_0_hs_p0 sn_0_3_hs_p0 wl_0_hs_p0 1.3668e-17
ccc_sn_1_0_wl_1_hs_p0 sn_1_0_hs_p0 wl_1_hs_p0 1.9664e-17
ccc_sn_1_1_wl_1_hs_p0 sn_1_1_hs_p0 wl_1_hs_p0 1.6705e-17
ccc_sn_1_2_wl_1_hs_p0 sn_1_2_hs_p0 wl_1_hs_p0 1.6705e-17
ccc_sn_1_3_wl_1_hs_p0 sn_1_3_hs_p0 wl_1_hs_p0 1.071e-17
ccc_sn_2_0_wl_2_hs_p0 sn_2_0_hs_p0 wl_2_hs_p0 1.9664e-17
ccc_sn_2_1_wl_2_hs_p0 sn_2_1_hs_p0 wl_2_hs_p0 1.6705e-17
ccc_sn_2_2_wl_2_hs_p0 sn_2_2_hs_p0 wl_2_hs_p0 1.6705e-17
ccc_sn_2_3_wl_2_hs_p0 sn_2_3_hs_p0 wl_2_hs_p0 1.071e-17
ccc_sn_3_0_wl_3_hs_p0 sn_3_0_hs_p0 wl_3_hs_p0 1.9664e-17
ccc_sn_3_1_wl_3_hs_p0 sn_3_1_hs_p0 wl_3_hs_p0 1.6705e-17
ccc_sn_3_2_wl_3_hs_p0 sn_3_2_hs_p0 wl_3_hs_p0 1.6705e-17
ccc_sn_3_3_wl_3_hs_p0 sn_3_3_hs_p0 wl_3_hs_p0 1.071e-17
vdw_hs_p0_0 wl_0_hs_p0 g_wl_one dc 0
vdr_hs_p0_0 rwl_0_hs_p0 vdd dc 0
vdw_hs_p0_1 wl_1_hs_p0 0 dc 0
vdr_hs_p0_1 rwl_1_hs_p0 vdd dc 0
vdw_hs_p0_2 wl_2_hs_p0 0 dc 0
vdr_hs_p0_2 rwl_2_hs_p0 vdd dc 0
vdw_hs_p0_3 wl_3_hs_p0 0 dc 0
vdr_hs_p0_3 rwl_3_hs_p0 vdd dc 0
vdb_hs_p0_0 bl_0_hs_p0 vdd dc 0
vdp_hs_p0_0 rbl_0_hs_p0 vrbl dc 0
vdb_hs_p0_1 bl_1_hs_p0 g_lo_one dc 0
vdp_hs_p0_1 rbl_1_hs_p0 vrbl dc 0
vdb_hs_p0_2 bl_2_hs_p0 0 dc 0
vdp_hs_p0_2 rbl_2_hs_p0 vrbl dc 0
vdb_hs_p0_3 bl_3_hs_p0 vdd dc 0
vdp_hs_p0_3 rbl_3_hs_p0 vrbl dc 0

* ---- instance neg_ctl0: family ctl0 (LEAKY write devices x10) ----
xm1_neg_ctl0 sn_0_0__t0_neg_ctl0 wl_0__t3_neg_ctl0 bl_0__t0_neg_ctl0 gnd__t0_neg_ctl0 sky130_fd_pr__nfet_01v8 L=0.15 W=4.2 nf=1 ad=1.974 as=1.974 pd=9.34 ps=9.34 mult=1 m=1
xm2_neg_ctl0 rbl_0__t0_neg_ctl0 sn_0_0__t1_neg_ctl0 rwl_0__t0_neg_ctl0 gnd__t1_neg_ctl0 sky130_fd_pr__nfet_01v8 L=0.15 W=0.42 nf=1 ad=0.1974 as=0.1974 pd=1.78 ps=1.78 mult=1 m=1
xm3_neg_ctl0 sn_0_1__t1_neg_ctl0 wl_0__t0_neg_ctl0 bl_1__t0_neg_ctl0 gnd__t2_neg_ctl0 sky130_fd_pr__nfet_01v8 L=0.15 W=4.2 nf=1 ad=1.974 as=1.974 pd=9.34 ps=9.34 mult=1 m=1
xm4_neg_ctl0 rbl_1__t0_neg_ctl0 sn_0_1__t0_neg_ctl0 rwl_0__t1_neg_ctl0 gnd__t3_neg_ctl0 sky130_fd_pr__nfet_01v8 L=0.15 W=0.42 nf=1 ad=0.1974 as=0.1974 pd=1.78 ps=1.78 mult=1 m=1
xm5_neg_ctl0 sn_0_2__t1_neg_ctl0 wl_0__t1_neg_ctl0 bl_2__t0_neg_ctl0 gnd__t4_neg_ctl0 sky130_fd_pr__nfet_01v8 L=0.15 W=4.2 nf=1 ad=1.974 as=1.974 pd=9.34 ps=9.34 mult=1 m=1
xm6_neg_ctl0 rbl_2__t0_neg_ctl0 sn_0_2__t0_neg_ctl0 rwl_0__t2_neg_ctl0 gnd__t5_neg_ctl0 sky130_fd_pr__nfet_01v8 L=0.15 W=0.42 nf=1 ad=0.1974 as=0.1974 pd=1.78 ps=1.78 mult=1 m=1
xm7_neg_ctl0 sn_0_3__t1_neg_ctl0 wl_0__t2_neg_ctl0 bl_3__t0_neg_ctl0 gnd__t6_neg_ctl0 sky130_fd_pr__nfet_01v8 L=0.15 W=4.2 nf=1 ad=1.974 as=1.974 pd=9.34 ps=9.34 mult=1 m=1
xm8_neg_ctl0 rbl_3__t0_neg_ctl0 sn_0_3__t0_neg_ctl0 rwl_0__t3_neg_ctl0 gnd__t7_neg_ctl0 sky130_fd_pr__nfet_01v8 L=0.15 W=0.42 nf=1 ad=0.1974 as=0.1974 pd=1.78 ps=1.78 mult=1 m=1
xm9_neg_ctl0 sn_1_0__t1_neg_ctl0 wl_1__t0_neg_ctl0 bl_0__t1_neg_ctl0 gnd__t8_neg_ctl0 sky130_fd_pr__nfet_01v8 L=0.15 W=4.2 nf=1 ad=1.974 as=1.974 pd=9.34 ps=9.34 mult=1 m=1
xm10_neg_ctl0 rbl_0__t1_neg_ctl0 sn_1_0__t0_neg_ctl0 rwl_1__t0_neg_ctl0 gnd__t9_neg_ctl0 sky130_fd_pr__nfet_01v8 L=0.15 W=0.42 nf=1 ad=0.1974 as=0.1974 pd=1.78 ps=1.78 mult=1 m=1
xm11_neg_ctl0 sn_1_1__t1_neg_ctl0 wl_1__t1_neg_ctl0 bl_1__t1_neg_ctl0 gnd__t10_neg_ctl0 sky130_fd_pr__nfet_01v8 L=0.15 W=4.2 nf=1 ad=1.974 as=1.974 pd=9.34 ps=9.34 mult=1 m=1
xm12_neg_ctl0 rbl_1__t1_neg_ctl0 sn_1_1__t0_neg_ctl0 rwl_1__t1_neg_ctl0 gnd__t11_neg_ctl0 sky130_fd_pr__nfet_01v8 L=0.15 W=0.42 nf=1 ad=0.1974 as=0.1974 pd=1.78 ps=1.78 mult=1 m=1
xm13_neg_ctl0 sn_1_2__t1_neg_ctl0 wl_1__t2_neg_ctl0 bl_2__t1_neg_ctl0 gnd__t12_neg_ctl0 sky130_fd_pr__nfet_01v8 L=0.15 W=4.2 nf=1 ad=1.974 as=1.974 pd=9.34 ps=9.34 mult=1 m=1
xm14_neg_ctl0 rbl_2__t1_neg_ctl0 sn_1_2__t0_neg_ctl0 rwl_1__t2_neg_ctl0 gnd__t13_neg_ctl0 sky130_fd_pr__nfet_01v8 L=0.15 W=0.42 nf=1 ad=0.1974 as=0.1974 pd=1.78 ps=1.78 mult=1 m=1
xm15_neg_ctl0 sn_1_3__t1_neg_ctl0 wl_1__t3_neg_ctl0 bl_3__t1_neg_ctl0 gnd__t14_neg_ctl0 sky130_fd_pr__nfet_01v8 L=0.15 W=4.2 nf=1 ad=1.974 as=1.974 pd=9.34 ps=9.34 mult=1 m=1
xm16_neg_ctl0 rbl_3__t1_neg_ctl0 sn_1_3__t0_neg_ctl0 rwl_1__t3_neg_ctl0 gnd__t15_neg_ctl0 sky130_fd_pr__nfet_01v8 L=0.15 W=0.42 nf=1 ad=0.1974 as=0.1974 pd=1.78 ps=1.78 mult=1 m=1
xm17_neg_ctl0 sn_2_0__t1_neg_ctl0 wl_2__t3_neg_ctl0 bl_0__t3_neg_ctl0 gnd__t16_neg_ctl0 sky130_fd_pr__nfet_01v8 L=0.15 W=4.2 nf=1 ad=1.974 as=1.974 pd=9.34 ps=9.34 mult=1 m=1
xm18_neg_ctl0 rbl_0__t2_neg_ctl0 sn_2_0__t0_neg_ctl0 rwl_2__t0_neg_ctl0 gnd__t17_neg_ctl0 sky130_fd_pr__nfet_01v8 L=0.15 W=0.42 nf=1 ad=0.1974 as=0.1974 pd=1.78 ps=1.78 mult=1 m=1
xm19_neg_ctl0 sn_2_1__t1_neg_ctl0 wl_2__t0_neg_ctl0 bl_1__t2_neg_ctl0 gnd__t18_neg_ctl0 sky130_fd_pr__nfet_01v8 L=0.15 W=4.2 nf=1 ad=1.974 as=1.974 pd=9.34 ps=9.34 mult=1 m=1
xm20_neg_ctl0 rbl_1__t2_neg_ctl0 sn_2_1__t0_neg_ctl0 rwl_2__t1_neg_ctl0 gnd__t19_neg_ctl0 sky130_fd_pr__nfet_01v8 L=0.15 W=0.42 nf=1 ad=0.1974 as=0.1974 pd=1.78 ps=1.78 mult=1 m=1
xm21_neg_ctl0 sn_2_2__t1_neg_ctl0 wl_2__t1_neg_ctl0 bl_2__t2_neg_ctl0 gnd__t20_neg_ctl0 sky130_fd_pr__nfet_01v8 L=0.15 W=4.2 nf=1 ad=1.974 as=1.974 pd=9.34 ps=9.34 mult=1 m=1
xm22_neg_ctl0 rbl_2__t2_neg_ctl0 sn_2_2__t0_neg_ctl0 rwl_2__t2_neg_ctl0 gnd__t21_neg_ctl0 sky130_fd_pr__nfet_01v8 L=0.15 W=0.42 nf=1 ad=0.1974 as=0.1974 pd=1.78 ps=1.78 mult=1 m=1
xm23_neg_ctl0 sn_2_3__t1_neg_ctl0 wl_2__t2_neg_ctl0 bl_3__t2_neg_ctl0 gnd__t22_neg_ctl0 sky130_fd_pr__nfet_01v8 L=0.15 W=4.2 nf=1 ad=1.974 as=1.974 pd=9.34 ps=9.34 mult=1 m=1
xm24_neg_ctl0 rbl_3__t2_neg_ctl0 sn_2_3__t0_neg_ctl0 rwl_2__t3_neg_ctl0 gnd__t23_neg_ctl0 sky130_fd_pr__nfet_01v8 L=0.15 W=0.42 nf=1 ad=0.1974 as=0.1974 pd=1.78 ps=1.78 mult=1 m=1
xm25_neg_ctl0 sn_3_0__t1_neg_ctl0 wl_3__t0_neg_ctl0 bl_0__t2_neg_ctl0 gnd__t24_neg_ctl0 sky130_fd_pr__nfet_01v8 L=0.15 W=4.2 nf=1 ad=1.974 as=1.974 pd=9.34 ps=9.34 mult=1 m=1
xm26_neg_ctl0 rbl_0__t3_neg_ctl0 sn_3_0__t0_neg_ctl0 rwl_3__t0_neg_ctl0 gnd__t25_neg_ctl0 sky130_fd_pr__nfet_01v8 L=0.15 W=0.42 nf=1 ad=0.1974 as=0.1974 pd=1.78 ps=1.78 mult=1 m=1
xm27_neg_ctl0 sn_3_1__t1_neg_ctl0 wl_3__t1_neg_ctl0 bl_1__t3_neg_ctl0 gnd__t26_neg_ctl0 sky130_fd_pr__nfet_01v8 L=0.15 W=4.2 nf=1 ad=1.974 as=1.974 pd=9.34 ps=9.34 mult=1 m=1
xm28_neg_ctl0 rbl_1__t3_neg_ctl0 sn_3_1__t0_neg_ctl0 rwl_3__t1_neg_ctl0 gnd__t27_neg_ctl0 sky130_fd_pr__nfet_01v8 L=0.15 W=0.42 nf=1 ad=0.1974 as=0.1974 pd=1.78 ps=1.78 mult=1 m=1
xm29_neg_ctl0 sn_3_2__t1_neg_ctl0 wl_3__t2_neg_ctl0 bl_2__t3_neg_ctl0 gnd__t28_neg_ctl0 sky130_fd_pr__nfet_01v8 L=0.15 W=4.2 nf=1 ad=1.974 as=1.974 pd=9.34 ps=9.34 mult=1 m=1
xm30_neg_ctl0 rbl_2__t3_neg_ctl0 sn_3_2__t0_neg_ctl0 rwl_3__t2_neg_ctl0 gnd__t29_neg_ctl0 sky130_fd_pr__nfet_01v8 L=0.15 W=0.42 nf=1 ad=0.1974 as=0.1974 pd=1.78 ps=1.78 mult=1 m=1
xm31_neg_ctl0 sn_3_3__t1_neg_ctl0 wl_3__t3_neg_ctl0 bl_3__t3_neg_ctl0 gnd__t30_neg_ctl0 sky130_fd_pr__nfet_01v8 L=0.15 W=4.2 nf=1 ad=1.974 as=1.974 pd=9.34 ps=9.34 mult=1 m=1
xm32_neg_ctl0 rbl_3__t3_neg_ctl0 sn_3_3__t0_neg_ctl0 rwl_3__t3_neg_ctl0 gnd__t31_neg_ctl0 sky130_fd_pr__nfet_01v8 L=0.15 W=0.42 nf=1 ad=0.1974 as=0.1974 pd=1.78 ps=1.78 mult=1 m=1
rgnd_t0_neg_ctl0 gnd__t0_neg_ctl0 0 63.3529
rgnd_t1_neg_ctl0 gnd__t1_neg_ctl0 0 49.0465
rgnd_t2_neg_ctl0 gnd__t2_neg_ctl0 0 36.5177
rgnd_t3_neg_ctl0 gnd__t3_neg_ctl0 0 28.2406
rgnd_t4_neg_ctl0 gnd__t4_neg_ctl0 0 28.2406
rgnd_t5_neg_ctl0 gnd__t5_neg_ctl0 0 36.5177
rgnd_t6_neg_ctl0 gnd__t6_neg_ctl0 0 49.0465
rgnd_t7_neg_ctl0 gnd__t7_neg_ctl0 0 63.3529
rgnd_t8_neg_ctl0 gnd__t8_neg_ctl0 0 58.0019
rgnd_t9_neg_ctl0 gnd__t9_neg_ctl0 0 41.907
rgnd_t10_neg_ctl0 gnd__t10_neg_ctl0 0 26.1568
rgnd_t11_neg_ctl0 gnd__t11_neg_ctl0 0 12.1726
rgnd_t12_neg_ctl0 gnd__t12_neg_ctl0 0 12.1726
rgnd_t13_neg_ctl0 gnd__t13_neg_ctl0 0 26.1568
rgnd_t14_neg_ctl0 gnd__t14_neg_ctl0 0 41.907
rgnd_t15_neg_ctl0 gnd__t15_neg_ctl0 0 58.0019
rgnd_t16_neg_ctl0 gnd__t16_neg_ctl0 0 58.0019
rgnd_t17_neg_ctl0 gnd__t17_neg_ctl0 0 41.907
rgnd_t18_neg_ctl0 gnd__t18_neg_ctl0 0 26.1568
rgnd_t19_neg_ctl0 gnd__t19_neg_ctl0 0 12.1726
rgnd_t20_neg_ctl0 gnd__t20_neg_ctl0 0 12.1726
rgnd_t21_neg_ctl0 gnd__t21_neg_ctl0 0 26.1568
rgnd_t22_neg_ctl0 gnd__t22_neg_ctl0 0 41.907
rgnd_t23_neg_ctl0 gnd__t23_neg_ctl0 0 58.0019
rgnd_t24_neg_ctl0 gnd__t24_neg_ctl0 0 63.3529
rgnd_t25_neg_ctl0 gnd__t25_neg_ctl0 0 49.0465
rgnd_t26_neg_ctl0 gnd__t26_neg_ctl0 0 36.5177
rgnd_t27_neg_ctl0 gnd__t27_neg_ctl0 0 28.2406
rgnd_t28_neg_ctl0 gnd__t28_neg_ctl0 0 28.2406
rgnd_t29_neg_ctl0 gnd__t29_neg_ctl0 0 36.5177
rgnd_t30_neg_ctl0 gnd__t30_neg_ctl0 0 49.0465
rgnd_t31_neg_ctl0 gnd__t31_neg_ctl0 0 63.3529
rbl_0_t0_neg_ctl0 bl_0__t0_neg_ctl0 bl_0_neg_ctl0 144.555
rbl_0_t1_neg_ctl0 bl_0__t1_neg_ctl0 bl_0_neg_ctl0 48.1851
rbl_0_t2_neg_ctl0 bl_0__t2_neg_ctl0 bl_0_neg_ctl0 144.555
rbl_0_t3_neg_ctl0 bl_0__t3_neg_ctl0 bl_0_neg_ctl0 48.1851
rbl_1_t0_neg_ctl0 bl_1__t0_neg_ctl0 bl_1_neg_ctl0 144.555
rbl_1_t1_neg_ctl0 bl_1__t1_neg_ctl0 bl_1_neg_ctl0 48.1851
rbl_1_t2_neg_ctl0 bl_1__t2_neg_ctl0 bl_1_neg_ctl0 48.1851
rbl_1_t3_neg_ctl0 bl_1__t3_neg_ctl0 bl_1_neg_ctl0 144.555
rbl_2_t0_neg_ctl0 bl_2__t0_neg_ctl0 bl_2_neg_ctl0 144.555
rbl_2_t1_neg_ctl0 bl_2__t1_neg_ctl0 bl_2_neg_ctl0 48.1851
rbl_2_t2_neg_ctl0 bl_2__t2_neg_ctl0 bl_2_neg_ctl0 48.1851
rbl_2_t3_neg_ctl0 bl_2__t3_neg_ctl0 bl_2_neg_ctl0 144.555
rbl_3_t0_neg_ctl0 bl_3__t0_neg_ctl0 bl_3_neg_ctl0 144.555
rbl_3_t1_neg_ctl0 bl_3__t1_neg_ctl0 bl_3_neg_ctl0 48.1851
rbl_3_t2_neg_ctl0 bl_3__t2_neg_ctl0 bl_3_neg_ctl0 48.1851
rbl_3_t3_neg_ctl0 bl_3__t3_neg_ctl0 bl_3_neg_ctl0 144.555
rrbl_0_t0_neg_ctl0 rbl_0__t0_neg_ctl0 rbl_0_neg_ctl0 144.555
rrbl_0_t1_neg_ctl0 rbl_0__t1_neg_ctl0 rbl_0_neg_ctl0 48.1851
rrbl_0_t2_neg_ctl0 rbl_0__t2_neg_ctl0 rbl_0_neg_ctl0 48.1851
rrbl_0_t3_neg_ctl0 rbl_0__t3_neg_ctl0 rbl_0_neg_ctl0 144.555
rrbl_1_t0_neg_ctl0 rbl_1__t0_neg_ctl0 rbl_1_neg_ctl0 144.555
rrbl_1_t1_neg_ctl0 rbl_1__t1_neg_ctl0 rbl_1_neg_ctl0 48.1851
rrbl_1_t2_neg_ctl0 rbl_1__t2_neg_ctl0 rbl_1_neg_ctl0 48.1851
rrbl_1_t3_neg_ctl0 rbl_1__t3_neg_ctl0 rbl_1_neg_ctl0 144.555
rrbl_2_t0_neg_ctl0 rbl_2__t0_neg_ctl0 rbl_2_neg_ctl0 144.555
rrbl_2_t1_neg_ctl0 rbl_2__t1_neg_ctl0 rbl_2_neg_ctl0 48.1851
rrbl_2_t2_neg_ctl0 rbl_2__t2_neg_ctl0 rbl_2_neg_ctl0 48.1851
rrbl_2_t3_neg_ctl0 rbl_2__t3_neg_ctl0 rbl_2_neg_ctl0 144.555
rrbl_3_t0_neg_ctl0 rbl_3__t0_neg_ctl0 rbl_3_neg_ctl0 144.555
rrbl_3_t1_neg_ctl0 rbl_3__t1_neg_ctl0 rbl_3_neg_ctl0 48.1851
rrbl_3_t2_neg_ctl0 rbl_3__t2_neg_ctl0 rbl_3_neg_ctl0 48.1851
rrbl_3_t3_neg_ctl0 rbl_3__t3_neg_ctl0 rbl_3_neg_ctl0 144.555
rrwl_0_t0_neg_ctl0 rwl_0__t0_neg_ctl0 rwl_0_neg_ctl0 21.6897
rrwl_0_t1_neg_ctl0 rwl_0__t1_neg_ctl0 rwl_0_neg_ctl0 7.22989
rrwl_0_t2_neg_ctl0 rwl_0__t2_neg_ctl0 rwl_0_neg_ctl0 7.22989
rrwl_0_t3_neg_ctl0 rwl_0__t3_neg_ctl0 rwl_0_neg_ctl0 21.6897
rrwl_1_t0_neg_ctl0 rwl_1__t0_neg_ctl0 rwl_1_neg_ctl0 21.6897
rrwl_1_t1_neg_ctl0 rwl_1__t1_neg_ctl0 rwl_1_neg_ctl0 7.22989
rrwl_1_t2_neg_ctl0 rwl_1__t2_neg_ctl0 rwl_1_neg_ctl0 7.22989
rrwl_1_t3_neg_ctl0 rwl_1__t3_neg_ctl0 rwl_1_neg_ctl0 21.6897
rrwl_2_t0_neg_ctl0 rwl_2__t0_neg_ctl0 rwl_2_neg_ctl0 21.6897
rrwl_2_t1_neg_ctl0 rwl_2__t1_neg_ctl0 rwl_2_neg_ctl0 7.22989
rrwl_2_t2_neg_ctl0 rwl_2__t2_neg_ctl0 rwl_2_neg_ctl0 7.22989
rrwl_2_t3_neg_ctl0 rwl_2__t3_neg_ctl0 rwl_2_neg_ctl0 21.6897
rrwl_3_t0_neg_ctl0 rwl_3__t0_neg_ctl0 rwl_3_neg_ctl0 21.6897
rrwl_3_t1_neg_ctl0 rwl_3__t1_neg_ctl0 rwl_3_neg_ctl0 7.22989
rrwl_3_t2_neg_ctl0 rwl_3__t2_neg_ctl0 rwl_3_neg_ctl0 7.22989
rrwl_3_t3_neg_ctl0 rwl_3__t3_neg_ctl0 rwl_3_neg_ctl0 21.6897
rsn_0_0_t0_neg_ctl0 sn_0_0__t0_neg_ctl0 sn_0_0_neg_ctl0 125.123
rsn_0_0_t1_neg_ctl0 sn_0_0__t1_neg_ctl0 sn_0_0_neg_ctl0 125.123
rsn_0_1_t0_neg_ctl0 sn_0_1__t0_neg_ctl0 sn_0_1_neg_ctl0 125.123
rsn_0_1_t1_neg_ctl0 sn_0_1__t1_neg_ctl0 sn_0_1_neg_ctl0 125.123
rsn_0_2_t0_neg_ctl0 sn_0_2__t0_neg_ctl0 sn_0_2_neg_ctl0 125.123
rsn_0_2_t1_neg_ctl0 sn_0_2__t1_neg_ctl0 sn_0_2_neg_ctl0 125.123
rsn_0_3_t0_neg_ctl0 sn_0_3__t0_neg_ctl0 sn_0_3_neg_ctl0 125.123
rsn_0_3_t1_neg_ctl0 sn_0_3__t1_neg_ctl0 sn_0_3_neg_ctl0 125.123
rsn_1_0_t0_neg_ctl0 sn_1_0__t0_neg_ctl0 sn_1_0_neg_ctl0 125.123
rsn_1_0_t1_neg_ctl0 sn_1_0__t1_neg_ctl0 sn_1_0_neg_ctl0 125.123
rsn_1_1_t0_neg_ctl0 sn_1_1__t0_neg_ctl0 sn_1_1_neg_ctl0 125.123
rsn_1_1_t1_neg_ctl0 sn_1_1__t1_neg_ctl0 sn_1_1_neg_ctl0 125.123
rsn_1_2_t0_neg_ctl0 sn_1_2__t0_neg_ctl0 sn_1_2_neg_ctl0 125.123
rsn_1_2_t1_neg_ctl0 sn_1_2__t1_neg_ctl0 sn_1_2_neg_ctl0 125.123
rsn_1_3_t0_neg_ctl0 sn_1_3__t0_neg_ctl0 sn_1_3_neg_ctl0 125.123
rsn_1_3_t1_neg_ctl0 sn_1_3__t1_neg_ctl0 sn_1_3_neg_ctl0 125.123
rsn_2_0_t0_neg_ctl0 sn_2_0__t0_neg_ctl0 sn_2_0_neg_ctl0 125.123
rsn_2_0_t1_neg_ctl0 sn_2_0__t1_neg_ctl0 sn_2_0_neg_ctl0 125.123
rsn_2_1_t0_neg_ctl0 sn_2_1__t0_neg_ctl0 sn_2_1_neg_ctl0 125.123
rsn_2_1_t1_neg_ctl0 sn_2_1__t1_neg_ctl0 sn_2_1_neg_ctl0 125.123
rsn_2_2_t0_neg_ctl0 sn_2_2__t0_neg_ctl0 sn_2_2_neg_ctl0 125.123
rsn_2_2_t1_neg_ctl0 sn_2_2__t1_neg_ctl0 sn_2_2_neg_ctl0 125.123
rsn_2_3_t0_neg_ctl0 sn_2_3__t0_neg_ctl0 sn_2_3_neg_ctl0 125.123
rsn_2_3_t1_neg_ctl0 sn_2_3__t1_neg_ctl0 sn_2_3_neg_ctl0 125.123
rsn_3_0_t0_neg_ctl0 sn_3_0__t0_neg_ctl0 sn_3_0_neg_ctl0 125.123
rsn_3_0_t1_neg_ctl0 sn_3_0__t1_neg_ctl0 sn_3_0_neg_ctl0 125.123
rsn_3_1_t0_neg_ctl0 sn_3_1__t0_neg_ctl0 sn_3_1_neg_ctl0 125.123
rsn_3_1_t1_neg_ctl0 sn_3_1__t1_neg_ctl0 sn_3_1_neg_ctl0 125.123
rsn_3_2_t0_neg_ctl0 sn_3_2__t0_neg_ctl0 sn_3_2_neg_ctl0 125.123
rsn_3_2_t1_neg_ctl0 sn_3_2__t1_neg_ctl0 sn_3_2_neg_ctl0 125.123
rsn_3_3_t0_neg_ctl0 sn_3_3__t0_neg_ctl0 sn_3_3_neg_ctl0 125.123
rsn_3_3_t1_neg_ctl0 sn_3_3__t1_neg_ctl0 sn_3_3_neg_ctl0 125.123
rwl_0_t0_neg_ctl0 wl_0__t0_neg_ctl0 wl_0_neg_ctl0 54.2844
rwl_0_t1_neg_ctl0 wl_0__t1_neg_ctl0 wl_0_neg_ctl0 54.2844
rwl_0_t2_neg_ctl0 wl_0__t2_neg_ctl0 wl_0_neg_ctl0 162.853
rwl_0_t3_neg_ctl0 wl_0__t3_neg_ctl0 wl_0_neg_ctl0 162.853
rwl_1_t0_neg_ctl0 wl_1__t0_neg_ctl0 wl_1_neg_ctl0 162.853
rwl_1_t1_neg_ctl0 wl_1__t1_neg_ctl0 wl_1_neg_ctl0 54.2844
rwl_1_t2_neg_ctl0 wl_1__t2_neg_ctl0 wl_1_neg_ctl0 54.2844
rwl_1_t3_neg_ctl0 wl_1__t3_neg_ctl0 wl_1_neg_ctl0 162.853
rwl_2_t0_neg_ctl0 wl_2__t0_neg_ctl0 wl_2_neg_ctl0 54.2844
rwl_2_t1_neg_ctl0 wl_2__t1_neg_ctl0 wl_2_neg_ctl0 54.2844
rwl_2_t2_neg_ctl0 wl_2__t2_neg_ctl0 wl_2_neg_ctl0 162.853
rwl_2_t3_neg_ctl0 wl_2__t3_neg_ctl0 wl_2_neg_ctl0 162.853
rwl_3_t0_neg_ctl0 wl_3__t0_neg_ctl0 wl_3_neg_ctl0 162.853
rwl_3_t1_neg_ctl0 wl_3__t1_neg_ctl0 wl_3_neg_ctl0 54.2844
rwl_3_t2_neg_ctl0 wl_3__t2_neg_ctl0 wl_3_neg_ctl0 54.2844
rwl_3_t3_neg_ctl0 wl_3__t3_neg_ctl0 wl_3_neg_ctl0 162.853
cgnd_neg_ctl0 0 0 4.09475e-15
cbl_0_neg_ctl0 bl_0_neg_ctl0 0 5.96076e-16
cbl_1_neg_ctl0 bl_1_neg_ctl0 0 5.81168e-16
cbl_2_neg_ctl0 bl_2_neg_ctl0 0 5.81168e-16
cbl_3_neg_ctl0 bl_3_neg_ctl0 0 5.81168e-16
crbl_0_neg_ctl0 rbl_0_neg_ctl0 0 5.81168e-16
crbl_1_neg_ctl0 rbl_1_neg_ctl0 0 5.81168e-16
crbl_2_neg_ctl0 rbl_2_neg_ctl0 0 5.81168e-16
crbl_3_neg_ctl0 rbl_3_neg_ctl0 0 5.96076e-16
crwl_0_neg_ctl0 rwl_0_neg_ctl0 0 1.18713e-15
crwl_1_neg_ctl0 rwl_1_neg_ctl0 0 1.18713e-15
crwl_2_neg_ctl0 rwl_2_neg_ctl0 0 1.18713e-15
crwl_3_neg_ctl0 rwl_3_neg_ctl0 0 1.18713e-15
csn_0_0_neg_ctl0 sn_0_0_neg_ctl0 0 4.33689e-16
csn_0_1_neg_ctl0 sn_0_1_neg_ctl0 0 4.30576e-16
csn_0_2_neg_ctl0 sn_0_2_neg_ctl0 0 4.30576e-16
csn_0_3_neg_ctl0 sn_0_3_neg_ctl0 0 4.32518e-16
csn_1_0_neg_ctl0 sn_1_0_neg_ctl0 0 4.33689e-16
csn_1_1_neg_ctl0 sn_1_1_neg_ctl0 0 4.30576e-16
csn_1_2_neg_ctl0 sn_1_2_neg_ctl0 0 4.30576e-16
csn_1_3_neg_ctl0 sn_1_3_neg_ctl0 0 4.32518e-16
csn_2_0_neg_ctl0 sn_2_0_neg_ctl0 0 4.33689e-16
csn_2_1_neg_ctl0 sn_2_1_neg_ctl0 0 4.30576e-16
csn_2_2_neg_ctl0 sn_2_2_neg_ctl0 0 4.30576e-16
csn_2_3_neg_ctl0 sn_2_3_neg_ctl0 0 4.32518e-16
csn_3_0_neg_ctl0 sn_3_0_neg_ctl0 0 4.33689e-16
csn_3_1_neg_ctl0 sn_3_1_neg_ctl0 0 4.30576e-16
csn_3_2_neg_ctl0 sn_3_2_neg_ctl0 0 4.30576e-16
csn_3_3_neg_ctl0 sn_3_3_neg_ctl0 0 4.32518e-16
cwl_0_neg_ctl0 wl_0_neg_ctl0 0 1.90928e-15
cwl_1_neg_ctl0 wl_1_neg_ctl0 0 1.90928e-15
cwl_2_neg_ctl0 wl_2_neg_ctl0 0 1.90928e-15
cwl_3_neg_ctl0 wl_3_neg_ctl0 0 1.91375e-15
ccc_bl_0_sn_0_0_neg_ctl0 bl_0_neg_ctl0 sn_0_0_neg_ctl0 1.071e-17
ccc_bl_0_sn_1_0_neg_ctl0 bl_0_neg_ctl0 sn_1_0_neg_ctl0 1.071e-17
ccc_bl_0_sn_2_0_neg_ctl0 bl_0_neg_ctl0 sn_2_0_neg_ctl0 1.071e-17
ccc_bl_0_sn_3_0_neg_ctl0 bl_0_neg_ctl0 sn_3_0_neg_ctl0 1.071e-17
ccc_bl_0_wl_0_neg_ctl0 bl_0_neg_ctl0 wl_0_neg_ctl0 2.4327e-17
ccc_bl_0_wl_1_neg_ctl0 bl_0_neg_ctl0 wl_1_neg_ctl0 2.4327e-17
ccc_bl_0_wl_2_neg_ctl0 bl_0_neg_ctl0 wl_2_neg_ctl0 2.4327e-17
ccc_bl_1_rbl_0_neg_ctl0 bl_1_neg_ctl0 rbl_0_neg_ctl0 1.29795e-16
ccc_bl_1_rwl_0_neg_ctl0 bl_1_neg_ctl0 rwl_0_neg_ctl0 9.028e-18
ccc_bl_1_rwl_1_neg_ctl0 bl_1_neg_ctl0 rwl_1_neg_ctl0 9.028e-18
ccc_bl_1_rwl_2_neg_ctl0 bl_1_neg_ctl0 rwl_2_neg_ctl0 9.028e-18
ccc_bl_1_rwl_3_neg_ctl0 bl_1_neg_ctl0 rwl_3_neg_ctl0 9.028e-18
ccc_bl_1_sn_0_1_neg_ctl0 bl_1_neg_ctl0 sn_0_1_neg_ctl0 1.071e-17
ccc_bl_1_sn_1_1_neg_ctl0 bl_1_neg_ctl0 sn_1_1_neg_ctl0 1.071e-17
ccc_bl_1_sn_2_1_neg_ctl0 bl_1_neg_ctl0 sn_2_1_neg_ctl0 1.071e-17
ccc_bl_1_sn_3_1_neg_ctl0 bl_1_neg_ctl0 sn_3_1_neg_ctl0 1.071e-17
ccc_bl_1_wl_0_neg_ctl0 bl_1_neg_ctl0 wl_0_neg_ctl0 2.7627e-17
ccc_bl_1_wl_1_neg_ctl0 bl_1_neg_ctl0 wl_1_neg_ctl0 2.7627e-17
ccc_bl_1_wl_2_neg_ctl0 bl_1_neg_ctl0 wl_2_neg_ctl0 2.7627e-17
ccc_bl_2_rbl_1_neg_ctl0 bl_2_neg_ctl0 rbl_1_neg_ctl0 1.29795e-16
ccc_bl_2_rwl_0_neg_ctl0 bl_2_neg_ctl0 rwl_0_neg_ctl0 9.028e-18
ccc_bl_2_rwl_1_neg_ctl0 bl_2_neg_ctl0 rwl_1_neg_ctl0 9.028e-18
ccc_bl_2_rwl_2_neg_ctl0 bl_2_neg_ctl0 rwl_2_neg_ctl0 9.028e-18
ccc_bl_2_rwl_3_neg_ctl0 bl_2_neg_ctl0 rwl_3_neg_ctl0 9.028e-18
ccc_bl_2_sn_0_2_neg_ctl0 bl_2_neg_ctl0 sn_0_2_neg_ctl0 1.071e-17
ccc_bl_2_sn_1_2_neg_ctl0 bl_2_neg_ctl0 sn_1_2_neg_ctl0 1.071e-17
ccc_bl_2_sn_2_2_neg_ctl0 bl_2_neg_ctl0 sn_2_2_neg_ctl0 1.071e-17
ccc_bl_2_sn_3_2_neg_ctl0 bl_2_neg_ctl0 sn_3_2_neg_ctl0 1.071e-17
ccc_bl_2_wl_0_neg_ctl0 bl_2_neg_ctl0 wl_0_neg_ctl0 2.7627e-17
ccc_bl_2_wl_1_neg_ctl0 bl_2_neg_ctl0 wl_1_neg_ctl0 2.7627e-17
ccc_bl_2_wl_2_neg_ctl0 bl_2_neg_ctl0 wl_2_neg_ctl0 2.7627e-17
ccc_bl_3_rbl_2_neg_ctl0 bl_3_neg_ctl0 rbl_2_neg_ctl0 1.29795e-16
ccc_bl_3_rwl_0_neg_ctl0 bl_3_neg_ctl0 rwl_0_neg_ctl0 9.028e-18
ccc_bl_3_rwl_1_neg_ctl0 bl_3_neg_ctl0 rwl_1_neg_ctl0 9.028e-18
ccc_bl_3_rwl_2_neg_ctl0 bl_3_neg_ctl0 rwl_2_neg_ctl0 9.028e-18
ccc_bl_3_rwl_3_neg_ctl0 bl_3_neg_ctl0 rwl_3_neg_ctl0 9.028e-18
ccc_bl_3_sn_0_3_neg_ctl0 bl_3_neg_ctl0 sn_0_3_neg_ctl0 1.071e-17
ccc_bl_3_sn_1_3_neg_ctl0 bl_3_neg_ctl0 sn_1_3_neg_ctl0 1.071e-17
ccc_bl_3_sn_2_3_neg_ctl0 bl_3_neg_ctl0 sn_2_3_neg_ctl0 1.071e-17
ccc_bl_3_sn_3_3_neg_ctl0 bl_3_neg_ctl0 sn_3_3_neg_ctl0 1.071e-17
ccc_bl_3_wl_0_neg_ctl0 bl_3_neg_ctl0 wl_0_neg_ctl0 2.7627e-17
ccc_bl_3_wl_1_neg_ctl0 bl_3_neg_ctl0 wl_1_neg_ctl0 2.7627e-17
ccc_bl_3_wl_2_neg_ctl0 bl_3_neg_ctl0 wl_2_neg_ctl0 2.7627e-17
ccc_rbl_0_rwl_0_neg_ctl0 rbl_0_neg_ctl0 rwl_0_neg_ctl0 1.9738e-17
ccc_rbl_0_rwl_1_neg_ctl0 rbl_0_neg_ctl0 rwl_1_neg_ctl0 1.9738e-17
ccc_rbl_0_rwl_2_neg_ctl0 rbl_0_neg_ctl0 rwl_2_neg_ctl0 1.9738e-17
ccc_rbl_0_rwl_3_neg_ctl0 rbl_0_neg_ctl0 rwl_3_neg_ctl0 1.9738e-17
ccc_rbl_0_sn_0_0_neg_ctl0 rbl_0_neg_ctl0 sn_0_0_neg_ctl0 1.071e-17
ccc_rbl_0_sn_1_0_neg_ctl0 rbl_0_neg_ctl0 sn_1_0_neg_ctl0 2.4327e-17
ccc_rbl_0_sn_2_0_neg_ctl0 rbl_0_neg_ctl0 sn_2_0_neg_ctl0 2.4327e-17
ccc_rbl_0_wl_0_neg_ctl0 rbl_0_neg_ctl0 wl_0_neg_ctl0 3.3e-18
ccc_rbl_0_wl_1_neg_ctl0 rbl_0_neg_ctl0 wl_1_neg_ctl0 3.3e-18
ccc_rbl_0_wl_2_neg_ctl0 rbl_0_neg_ctl0 wl_2_neg_ctl0 3.3e-18
ccc_rbl_1_rwl_0_neg_ctl0 rbl_1_neg_ctl0 rwl_0_neg_ctl0 1.9738e-17
ccc_rbl_1_rwl_1_neg_ctl0 rbl_1_neg_ctl0 rwl_1_neg_ctl0 1.9738e-17
ccc_rbl_1_rwl_2_neg_ctl0 rbl_1_neg_ctl0 rwl_2_neg_ctl0 1.9738e-17
ccc_rbl_1_rwl_3_neg_ctl0 rbl_1_neg_ctl0 rwl_3_neg_ctl0 1.9738e-17
ccc_rbl_1_sn_0_1_neg_ctl0 rbl_1_neg_ctl0 sn_0_1_neg_ctl0 1.071e-17
ccc_rbl_1_sn_1_1_neg_ctl0 rbl_1_neg_ctl0 sn_1_1_neg_ctl0 2.4327e-17
ccc_rbl_1_sn_2_1_neg_ctl0 rbl_1_neg_ctl0 sn_2_1_neg_ctl0 2.4327e-17
ccc_rbl_1_wl_0_neg_ctl0 rbl_1_neg_ctl0 wl_0_neg_ctl0 3.3e-18
ccc_rbl_1_wl_1_neg_ctl0 rbl_1_neg_ctl0 wl_1_neg_ctl0 3.3e-18
ccc_rbl_1_wl_2_neg_ctl0 rbl_1_neg_ctl0 wl_2_neg_ctl0 3.3e-18
ccc_rbl_2_rwl_0_neg_ctl0 rbl_2_neg_ctl0 rwl_0_neg_ctl0 1.9738e-17
ccc_rbl_2_rwl_1_neg_ctl0 rbl_2_neg_ctl0 rwl_1_neg_ctl0 1.9738e-17
ccc_rbl_2_rwl_2_neg_ctl0 rbl_2_neg_ctl0 rwl_2_neg_ctl0 1.9738e-17
ccc_rbl_2_rwl_3_neg_ctl0 rbl_2_neg_ctl0 rwl_3_neg_ctl0 1.9738e-17
ccc_rbl_2_sn_0_2_neg_ctl0 rbl_2_neg_ctl0 sn_0_2_neg_ctl0 1.071e-17
ccc_rbl_2_sn_1_2_neg_ctl0 rbl_2_neg_ctl0 sn_1_2_neg_ctl0 2.4327e-17
ccc_rbl_2_sn_2_2_neg_ctl0 rbl_2_neg_ctl0 sn_2_2_neg_ctl0 2.4327e-17
ccc_rbl_2_wl_0_neg_ctl0 rbl_2_neg_ctl0 wl_0_neg_ctl0 3.3e-18
ccc_rbl_2_wl_1_neg_ctl0 rbl_2_neg_ctl0 wl_1_neg_ctl0 3.3e-18
ccc_rbl_2_wl_2_neg_ctl0 rbl_2_neg_ctl0 wl_2_neg_ctl0 3.3e-18
ccc_rbl_3_rwl_0_neg_ctl0 rbl_3_neg_ctl0 rwl_0_neg_ctl0 1.071e-17
ccc_rbl_3_rwl_1_neg_ctl0 rbl_3_neg_ctl0 rwl_1_neg_ctl0 1.071e-17
ccc_rbl_3_rwl_2_neg_ctl0 rbl_3_neg_ctl0 rwl_2_neg_ctl0 1.071e-17
ccc_rbl_3_rwl_3_neg_ctl0 rbl_3_neg_ctl0 rwl_3_neg_ctl0 1.071e-17
ccc_rbl_3_sn_0_3_neg_ctl0 rbl_3_neg_ctl0 sn_0_3_neg_ctl0 1.071e-17
ccc_rbl_3_sn_1_3_neg_ctl0 rbl_3_neg_ctl0 sn_1_3_neg_ctl0 2.4327e-17
ccc_rbl_3_sn_2_3_neg_ctl0 rbl_3_neg_ctl0 sn_2_3_neg_ctl0 2.4327e-17
ccc_rwl_0_sn_0_0_neg_ctl0 rwl_0_neg_ctl0 sn_0_0_neg_ctl0 1.0072e-17
ccc_rwl_0_sn_0_1_neg_ctl0 rwl_0_neg_ctl0 sn_0_1_neg_ctl0 1.9682e-17
ccc_rwl_0_sn_0_2_neg_ctl0 rwl_0_neg_ctl0 sn_0_2_neg_ctl0 1.9682e-17
ccc_rwl_0_sn_0_3_neg_ctl0 rwl_0_neg_ctl0 sn_0_3_neg_ctl0 1.9682e-17
ccc_rwl_1_sn_1_0_neg_ctl0 rwl_1_neg_ctl0 sn_1_0_neg_ctl0 1.0072e-17
ccc_rwl_1_sn_1_1_neg_ctl0 rwl_1_neg_ctl0 sn_1_1_neg_ctl0 1.9682e-17
ccc_rwl_1_sn_1_2_neg_ctl0 rwl_1_neg_ctl0 sn_1_2_neg_ctl0 1.9682e-17
ccc_rwl_1_sn_1_3_neg_ctl0 rwl_1_neg_ctl0 sn_1_3_neg_ctl0 1.9682e-17
ccc_rwl_2_sn_2_0_neg_ctl0 rwl_2_neg_ctl0 sn_2_0_neg_ctl0 1.0072e-17
ccc_rwl_2_sn_2_1_neg_ctl0 rwl_2_neg_ctl0 sn_2_1_neg_ctl0 1.9682e-17
ccc_rwl_2_sn_2_2_neg_ctl0 rwl_2_neg_ctl0 sn_2_2_neg_ctl0 1.9682e-17
ccc_rwl_2_sn_2_3_neg_ctl0 rwl_2_neg_ctl0 sn_2_3_neg_ctl0 1.9682e-17
ccc_rwl_3_sn_3_0_neg_ctl0 rwl_3_neg_ctl0 sn_3_0_neg_ctl0 1.0072e-17
ccc_rwl_3_sn_3_1_neg_ctl0 rwl_3_neg_ctl0 sn_3_1_neg_ctl0 1.9682e-17
ccc_rwl_3_sn_3_2_neg_ctl0 rwl_3_neg_ctl0 sn_3_2_neg_ctl0 1.9682e-17
ccc_rwl_3_sn_3_3_neg_ctl0 rwl_3_neg_ctl0 sn_3_3_neg_ctl0 1.9682e-17
ccc_sn_0_0_wl_0_neg_ctl0 sn_0_0_neg_ctl0 wl_0_neg_ctl0 1.9664e-17
ccc_sn_0_1_wl_0_neg_ctl0 sn_0_1_neg_ctl0 wl_0_neg_ctl0 1.9664e-17
ccc_sn_0_2_wl_0_neg_ctl0 sn_0_2_neg_ctl0 wl_0_neg_ctl0 1.9664e-17
ccc_sn_0_3_wl_0_neg_ctl0 sn_0_3_neg_ctl0 wl_0_neg_ctl0 1.3668e-17
ccc_sn_1_0_wl_1_neg_ctl0 sn_1_0_neg_ctl0 wl_1_neg_ctl0 1.9664e-17
ccc_sn_1_1_wl_1_neg_ctl0 sn_1_1_neg_ctl0 wl_1_neg_ctl0 1.6705e-17
ccc_sn_1_2_wl_1_neg_ctl0 sn_1_2_neg_ctl0 wl_1_neg_ctl0 1.6705e-17
ccc_sn_1_3_wl_1_neg_ctl0 sn_1_3_neg_ctl0 wl_1_neg_ctl0 1.071e-17
ccc_sn_2_0_wl_2_neg_ctl0 sn_2_0_neg_ctl0 wl_2_neg_ctl0 1.9664e-17
ccc_sn_2_1_wl_2_neg_ctl0 sn_2_1_neg_ctl0 wl_2_neg_ctl0 1.6705e-17
ccc_sn_2_2_wl_2_neg_ctl0 sn_2_2_neg_ctl0 wl_2_neg_ctl0 1.6705e-17
ccc_sn_2_3_wl_2_neg_ctl0 sn_2_3_neg_ctl0 wl_2_neg_ctl0 1.071e-17
ccc_sn_3_0_wl_3_neg_ctl0 sn_3_0_neg_ctl0 wl_3_neg_ctl0 1.9664e-17
ccc_sn_3_1_wl_3_neg_ctl0 sn_3_1_neg_ctl0 wl_3_neg_ctl0 1.6705e-17
ccc_sn_3_2_wl_3_neg_ctl0 sn_3_2_neg_ctl0 wl_3_neg_ctl0 1.6705e-17
ccc_sn_3_3_wl_3_neg_ctl0 sn_3_3_neg_ctl0 wl_3_neg_ctl0 1.071e-17
vdw_neg_ctl0_0 wl_0_neg_ctl0 0 dc 0
vdr_neg_ctl0_0 rwl_0_neg_ctl0 vdd dc 0
vdw_neg_ctl0_1 wl_1_neg_ctl0 0 dc 0
vdr_neg_ctl0_1 rwl_1_neg_ctl0 vdd dc 0
vdw_neg_ctl0_2 wl_2_neg_ctl0 0 dc 0
vdr_neg_ctl0_2 rwl_2_neg_ctl0 vdd dc 0
vdw_neg_ctl0_3 wl_3_neg_ctl0 0 dc 0
vdr_neg_ctl0_3 rwl_3_neg_ctl0 vdd dc 0
vdb_neg_ctl0_0 bl_0_neg_ctl0 0 dc 0
vdp_neg_ctl0_0 rbl_0_neg_ctl0 vrbl dc 0
vdb_neg_ctl0_1 bl_1_neg_ctl0 0 dc 0
vdp_neg_ctl0_1 rbl_1_neg_ctl0 vrbl dc 0
vdb_neg_ctl0_2 bl_2_neg_ctl0 0 dc 0
vdp_neg_ctl0_2 rbl_2_neg_ctl0 vrbl dc 0
vdb_neg_ctl0_3 bl_3_neg_ctl0 0 dc 0
vdp_neg_ctl0_3 rbl_3_neg_ctl0 vrbl dc 0

* ---- instance neg_ctl1: family ctl1 (LEAKY write devices x10) ----
xm1_neg_ctl1 sn_0_0__t0_neg_ctl1 wl_0__t3_neg_ctl1 bl_0__t0_neg_ctl1 gnd__t0_neg_ctl1 sky130_fd_pr__nfet_01v8 L=0.15 W=4.2 nf=1 ad=1.974 as=1.974 pd=9.34 ps=9.34 mult=1 m=1
xm2_neg_ctl1 rbl_0__t0_neg_ctl1 sn_0_0__t1_neg_ctl1 rwl_0__t0_neg_ctl1 gnd__t1_neg_ctl1 sky130_fd_pr__nfet_01v8 L=0.15 W=0.42 nf=1 ad=0.1974 as=0.1974 pd=1.78 ps=1.78 mult=1 m=1
xm3_neg_ctl1 sn_0_1__t1_neg_ctl1 wl_0__t0_neg_ctl1 bl_1__t0_neg_ctl1 gnd__t2_neg_ctl1 sky130_fd_pr__nfet_01v8 L=0.15 W=4.2 nf=1 ad=1.974 as=1.974 pd=9.34 ps=9.34 mult=1 m=1
xm4_neg_ctl1 rbl_1__t0_neg_ctl1 sn_0_1__t0_neg_ctl1 rwl_0__t1_neg_ctl1 gnd__t3_neg_ctl1 sky130_fd_pr__nfet_01v8 L=0.15 W=0.42 nf=1 ad=0.1974 as=0.1974 pd=1.78 ps=1.78 mult=1 m=1
xm5_neg_ctl1 sn_0_2__t1_neg_ctl1 wl_0__t1_neg_ctl1 bl_2__t0_neg_ctl1 gnd__t4_neg_ctl1 sky130_fd_pr__nfet_01v8 L=0.15 W=4.2 nf=1 ad=1.974 as=1.974 pd=9.34 ps=9.34 mult=1 m=1
xm6_neg_ctl1 rbl_2__t0_neg_ctl1 sn_0_2__t0_neg_ctl1 rwl_0__t2_neg_ctl1 gnd__t5_neg_ctl1 sky130_fd_pr__nfet_01v8 L=0.15 W=0.42 nf=1 ad=0.1974 as=0.1974 pd=1.78 ps=1.78 mult=1 m=1
xm7_neg_ctl1 sn_0_3__t1_neg_ctl1 wl_0__t2_neg_ctl1 bl_3__t0_neg_ctl1 gnd__t6_neg_ctl1 sky130_fd_pr__nfet_01v8 L=0.15 W=4.2 nf=1 ad=1.974 as=1.974 pd=9.34 ps=9.34 mult=1 m=1
xm8_neg_ctl1 rbl_3__t0_neg_ctl1 sn_0_3__t0_neg_ctl1 rwl_0__t3_neg_ctl1 gnd__t7_neg_ctl1 sky130_fd_pr__nfet_01v8 L=0.15 W=0.42 nf=1 ad=0.1974 as=0.1974 pd=1.78 ps=1.78 mult=1 m=1
xm9_neg_ctl1 sn_1_0__t1_neg_ctl1 wl_1__t0_neg_ctl1 bl_0__t1_neg_ctl1 gnd__t8_neg_ctl1 sky130_fd_pr__nfet_01v8 L=0.15 W=4.2 nf=1 ad=1.974 as=1.974 pd=9.34 ps=9.34 mult=1 m=1
xm10_neg_ctl1 rbl_0__t1_neg_ctl1 sn_1_0__t0_neg_ctl1 rwl_1__t0_neg_ctl1 gnd__t9_neg_ctl1 sky130_fd_pr__nfet_01v8 L=0.15 W=0.42 nf=1 ad=0.1974 as=0.1974 pd=1.78 ps=1.78 mult=1 m=1
xm11_neg_ctl1 sn_1_1__t1_neg_ctl1 wl_1__t1_neg_ctl1 bl_1__t1_neg_ctl1 gnd__t10_neg_ctl1 sky130_fd_pr__nfet_01v8 L=0.15 W=4.2 nf=1 ad=1.974 as=1.974 pd=9.34 ps=9.34 mult=1 m=1
xm12_neg_ctl1 rbl_1__t1_neg_ctl1 sn_1_1__t0_neg_ctl1 rwl_1__t1_neg_ctl1 gnd__t11_neg_ctl1 sky130_fd_pr__nfet_01v8 L=0.15 W=0.42 nf=1 ad=0.1974 as=0.1974 pd=1.78 ps=1.78 mult=1 m=1
xm13_neg_ctl1 sn_1_2__t1_neg_ctl1 wl_1__t2_neg_ctl1 bl_2__t1_neg_ctl1 gnd__t12_neg_ctl1 sky130_fd_pr__nfet_01v8 L=0.15 W=4.2 nf=1 ad=1.974 as=1.974 pd=9.34 ps=9.34 mult=1 m=1
xm14_neg_ctl1 rbl_2__t1_neg_ctl1 sn_1_2__t0_neg_ctl1 rwl_1__t2_neg_ctl1 gnd__t13_neg_ctl1 sky130_fd_pr__nfet_01v8 L=0.15 W=0.42 nf=1 ad=0.1974 as=0.1974 pd=1.78 ps=1.78 mult=1 m=1
xm15_neg_ctl1 sn_1_3__t1_neg_ctl1 wl_1__t3_neg_ctl1 bl_3__t1_neg_ctl1 gnd__t14_neg_ctl1 sky130_fd_pr__nfet_01v8 L=0.15 W=4.2 nf=1 ad=1.974 as=1.974 pd=9.34 ps=9.34 mult=1 m=1
xm16_neg_ctl1 rbl_3__t1_neg_ctl1 sn_1_3__t0_neg_ctl1 rwl_1__t3_neg_ctl1 gnd__t15_neg_ctl1 sky130_fd_pr__nfet_01v8 L=0.15 W=0.42 nf=1 ad=0.1974 as=0.1974 pd=1.78 ps=1.78 mult=1 m=1
xm17_neg_ctl1 sn_2_0__t1_neg_ctl1 wl_2__t3_neg_ctl1 bl_0__t3_neg_ctl1 gnd__t16_neg_ctl1 sky130_fd_pr__nfet_01v8 L=0.15 W=4.2 nf=1 ad=1.974 as=1.974 pd=9.34 ps=9.34 mult=1 m=1
xm18_neg_ctl1 rbl_0__t2_neg_ctl1 sn_2_0__t0_neg_ctl1 rwl_2__t0_neg_ctl1 gnd__t17_neg_ctl1 sky130_fd_pr__nfet_01v8 L=0.15 W=0.42 nf=1 ad=0.1974 as=0.1974 pd=1.78 ps=1.78 mult=1 m=1
xm19_neg_ctl1 sn_2_1__t1_neg_ctl1 wl_2__t0_neg_ctl1 bl_1__t2_neg_ctl1 gnd__t18_neg_ctl1 sky130_fd_pr__nfet_01v8 L=0.15 W=4.2 nf=1 ad=1.974 as=1.974 pd=9.34 ps=9.34 mult=1 m=1
xm20_neg_ctl1 rbl_1__t2_neg_ctl1 sn_2_1__t0_neg_ctl1 rwl_2__t1_neg_ctl1 gnd__t19_neg_ctl1 sky130_fd_pr__nfet_01v8 L=0.15 W=0.42 nf=1 ad=0.1974 as=0.1974 pd=1.78 ps=1.78 mult=1 m=1
xm21_neg_ctl1 sn_2_2__t1_neg_ctl1 wl_2__t1_neg_ctl1 bl_2__t2_neg_ctl1 gnd__t20_neg_ctl1 sky130_fd_pr__nfet_01v8 L=0.15 W=4.2 nf=1 ad=1.974 as=1.974 pd=9.34 ps=9.34 mult=1 m=1
xm22_neg_ctl1 rbl_2__t2_neg_ctl1 sn_2_2__t0_neg_ctl1 rwl_2__t2_neg_ctl1 gnd__t21_neg_ctl1 sky130_fd_pr__nfet_01v8 L=0.15 W=0.42 nf=1 ad=0.1974 as=0.1974 pd=1.78 ps=1.78 mult=1 m=1
xm23_neg_ctl1 sn_2_3__t1_neg_ctl1 wl_2__t2_neg_ctl1 bl_3__t2_neg_ctl1 gnd__t22_neg_ctl1 sky130_fd_pr__nfet_01v8 L=0.15 W=4.2 nf=1 ad=1.974 as=1.974 pd=9.34 ps=9.34 mult=1 m=1
xm24_neg_ctl1 rbl_3__t2_neg_ctl1 sn_2_3__t0_neg_ctl1 rwl_2__t3_neg_ctl1 gnd__t23_neg_ctl1 sky130_fd_pr__nfet_01v8 L=0.15 W=0.42 nf=1 ad=0.1974 as=0.1974 pd=1.78 ps=1.78 mult=1 m=1
xm25_neg_ctl1 sn_3_0__t1_neg_ctl1 wl_3__t0_neg_ctl1 bl_0__t2_neg_ctl1 gnd__t24_neg_ctl1 sky130_fd_pr__nfet_01v8 L=0.15 W=4.2 nf=1 ad=1.974 as=1.974 pd=9.34 ps=9.34 mult=1 m=1
xm26_neg_ctl1 rbl_0__t3_neg_ctl1 sn_3_0__t0_neg_ctl1 rwl_3__t0_neg_ctl1 gnd__t25_neg_ctl1 sky130_fd_pr__nfet_01v8 L=0.15 W=0.42 nf=1 ad=0.1974 as=0.1974 pd=1.78 ps=1.78 mult=1 m=1
xm27_neg_ctl1 sn_3_1__t1_neg_ctl1 wl_3__t1_neg_ctl1 bl_1__t3_neg_ctl1 gnd__t26_neg_ctl1 sky130_fd_pr__nfet_01v8 L=0.15 W=4.2 nf=1 ad=1.974 as=1.974 pd=9.34 ps=9.34 mult=1 m=1
xm28_neg_ctl1 rbl_1__t3_neg_ctl1 sn_3_1__t0_neg_ctl1 rwl_3__t1_neg_ctl1 gnd__t27_neg_ctl1 sky130_fd_pr__nfet_01v8 L=0.15 W=0.42 nf=1 ad=0.1974 as=0.1974 pd=1.78 ps=1.78 mult=1 m=1
xm29_neg_ctl1 sn_3_2__t1_neg_ctl1 wl_3__t2_neg_ctl1 bl_2__t3_neg_ctl1 gnd__t28_neg_ctl1 sky130_fd_pr__nfet_01v8 L=0.15 W=4.2 nf=1 ad=1.974 as=1.974 pd=9.34 ps=9.34 mult=1 m=1
xm30_neg_ctl1 rbl_2__t3_neg_ctl1 sn_3_2__t0_neg_ctl1 rwl_3__t2_neg_ctl1 gnd__t29_neg_ctl1 sky130_fd_pr__nfet_01v8 L=0.15 W=0.42 nf=1 ad=0.1974 as=0.1974 pd=1.78 ps=1.78 mult=1 m=1
xm31_neg_ctl1 sn_3_3__t1_neg_ctl1 wl_3__t3_neg_ctl1 bl_3__t3_neg_ctl1 gnd__t30_neg_ctl1 sky130_fd_pr__nfet_01v8 L=0.15 W=4.2 nf=1 ad=1.974 as=1.974 pd=9.34 ps=9.34 mult=1 m=1
xm32_neg_ctl1 rbl_3__t3_neg_ctl1 sn_3_3__t0_neg_ctl1 rwl_3__t3_neg_ctl1 gnd__t31_neg_ctl1 sky130_fd_pr__nfet_01v8 L=0.15 W=0.42 nf=1 ad=0.1974 as=0.1974 pd=1.78 ps=1.78 mult=1 m=1
rgnd_t0_neg_ctl1 gnd__t0_neg_ctl1 0 63.3529
rgnd_t1_neg_ctl1 gnd__t1_neg_ctl1 0 49.0465
rgnd_t2_neg_ctl1 gnd__t2_neg_ctl1 0 36.5177
rgnd_t3_neg_ctl1 gnd__t3_neg_ctl1 0 28.2406
rgnd_t4_neg_ctl1 gnd__t4_neg_ctl1 0 28.2406
rgnd_t5_neg_ctl1 gnd__t5_neg_ctl1 0 36.5177
rgnd_t6_neg_ctl1 gnd__t6_neg_ctl1 0 49.0465
rgnd_t7_neg_ctl1 gnd__t7_neg_ctl1 0 63.3529
rgnd_t8_neg_ctl1 gnd__t8_neg_ctl1 0 58.0019
rgnd_t9_neg_ctl1 gnd__t9_neg_ctl1 0 41.907
rgnd_t10_neg_ctl1 gnd__t10_neg_ctl1 0 26.1568
rgnd_t11_neg_ctl1 gnd__t11_neg_ctl1 0 12.1726
rgnd_t12_neg_ctl1 gnd__t12_neg_ctl1 0 12.1726
rgnd_t13_neg_ctl1 gnd__t13_neg_ctl1 0 26.1568
rgnd_t14_neg_ctl1 gnd__t14_neg_ctl1 0 41.907
rgnd_t15_neg_ctl1 gnd__t15_neg_ctl1 0 58.0019
rgnd_t16_neg_ctl1 gnd__t16_neg_ctl1 0 58.0019
rgnd_t17_neg_ctl1 gnd__t17_neg_ctl1 0 41.907
rgnd_t18_neg_ctl1 gnd__t18_neg_ctl1 0 26.1568
rgnd_t19_neg_ctl1 gnd__t19_neg_ctl1 0 12.1726
rgnd_t20_neg_ctl1 gnd__t20_neg_ctl1 0 12.1726
rgnd_t21_neg_ctl1 gnd__t21_neg_ctl1 0 26.1568
rgnd_t22_neg_ctl1 gnd__t22_neg_ctl1 0 41.907
rgnd_t23_neg_ctl1 gnd__t23_neg_ctl1 0 58.0019
rgnd_t24_neg_ctl1 gnd__t24_neg_ctl1 0 63.3529
rgnd_t25_neg_ctl1 gnd__t25_neg_ctl1 0 49.0465
rgnd_t26_neg_ctl1 gnd__t26_neg_ctl1 0 36.5177
rgnd_t27_neg_ctl1 gnd__t27_neg_ctl1 0 28.2406
rgnd_t28_neg_ctl1 gnd__t28_neg_ctl1 0 28.2406
rgnd_t29_neg_ctl1 gnd__t29_neg_ctl1 0 36.5177
rgnd_t30_neg_ctl1 gnd__t30_neg_ctl1 0 49.0465
rgnd_t31_neg_ctl1 gnd__t31_neg_ctl1 0 63.3529
rbl_0_t0_neg_ctl1 bl_0__t0_neg_ctl1 bl_0_neg_ctl1 144.555
rbl_0_t1_neg_ctl1 bl_0__t1_neg_ctl1 bl_0_neg_ctl1 48.1851
rbl_0_t2_neg_ctl1 bl_0__t2_neg_ctl1 bl_0_neg_ctl1 144.555
rbl_0_t3_neg_ctl1 bl_0__t3_neg_ctl1 bl_0_neg_ctl1 48.1851
rbl_1_t0_neg_ctl1 bl_1__t0_neg_ctl1 bl_1_neg_ctl1 144.555
rbl_1_t1_neg_ctl1 bl_1__t1_neg_ctl1 bl_1_neg_ctl1 48.1851
rbl_1_t2_neg_ctl1 bl_1__t2_neg_ctl1 bl_1_neg_ctl1 48.1851
rbl_1_t3_neg_ctl1 bl_1__t3_neg_ctl1 bl_1_neg_ctl1 144.555
rbl_2_t0_neg_ctl1 bl_2__t0_neg_ctl1 bl_2_neg_ctl1 144.555
rbl_2_t1_neg_ctl1 bl_2__t1_neg_ctl1 bl_2_neg_ctl1 48.1851
rbl_2_t2_neg_ctl1 bl_2__t2_neg_ctl1 bl_2_neg_ctl1 48.1851
rbl_2_t3_neg_ctl1 bl_2__t3_neg_ctl1 bl_2_neg_ctl1 144.555
rbl_3_t0_neg_ctl1 bl_3__t0_neg_ctl1 bl_3_neg_ctl1 144.555
rbl_3_t1_neg_ctl1 bl_3__t1_neg_ctl1 bl_3_neg_ctl1 48.1851
rbl_3_t2_neg_ctl1 bl_3__t2_neg_ctl1 bl_3_neg_ctl1 48.1851
rbl_3_t3_neg_ctl1 bl_3__t3_neg_ctl1 bl_3_neg_ctl1 144.555
rrbl_0_t0_neg_ctl1 rbl_0__t0_neg_ctl1 rbl_0_neg_ctl1 144.555
rrbl_0_t1_neg_ctl1 rbl_0__t1_neg_ctl1 rbl_0_neg_ctl1 48.1851
rrbl_0_t2_neg_ctl1 rbl_0__t2_neg_ctl1 rbl_0_neg_ctl1 48.1851
rrbl_0_t3_neg_ctl1 rbl_0__t3_neg_ctl1 rbl_0_neg_ctl1 144.555
rrbl_1_t0_neg_ctl1 rbl_1__t0_neg_ctl1 rbl_1_neg_ctl1 144.555
rrbl_1_t1_neg_ctl1 rbl_1__t1_neg_ctl1 rbl_1_neg_ctl1 48.1851
rrbl_1_t2_neg_ctl1 rbl_1__t2_neg_ctl1 rbl_1_neg_ctl1 48.1851
rrbl_1_t3_neg_ctl1 rbl_1__t3_neg_ctl1 rbl_1_neg_ctl1 144.555
rrbl_2_t0_neg_ctl1 rbl_2__t0_neg_ctl1 rbl_2_neg_ctl1 144.555
rrbl_2_t1_neg_ctl1 rbl_2__t1_neg_ctl1 rbl_2_neg_ctl1 48.1851
rrbl_2_t2_neg_ctl1 rbl_2__t2_neg_ctl1 rbl_2_neg_ctl1 48.1851
rrbl_2_t3_neg_ctl1 rbl_2__t3_neg_ctl1 rbl_2_neg_ctl1 144.555
rrbl_3_t0_neg_ctl1 rbl_3__t0_neg_ctl1 rbl_3_neg_ctl1 144.555
rrbl_3_t1_neg_ctl1 rbl_3__t1_neg_ctl1 rbl_3_neg_ctl1 48.1851
rrbl_3_t2_neg_ctl1 rbl_3__t2_neg_ctl1 rbl_3_neg_ctl1 48.1851
rrbl_3_t3_neg_ctl1 rbl_3__t3_neg_ctl1 rbl_3_neg_ctl1 144.555
rrwl_0_t0_neg_ctl1 rwl_0__t0_neg_ctl1 rwl_0_neg_ctl1 21.6897
rrwl_0_t1_neg_ctl1 rwl_0__t1_neg_ctl1 rwl_0_neg_ctl1 7.22989
rrwl_0_t2_neg_ctl1 rwl_0__t2_neg_ctl1 rwl_0_neg_ctl1 7.22989
rrwl_0_t3_neg_ctl1 rwl_0__t3_neg_ctl1 rwl_0_neg_ctl1 21.6897
rrwl_1_t0_neg_ctl1 rwl_1__t0_neg_ctl1 rwl_1_neg_ctl1 21.6897
rrwl_1_t1_neg_ctl1 rwl_1__t1_neg_ctl1 rwl_1_neg_ctl1 7.22989
rrwl_1_t2_neg_ctl1 rwl_1__t2_neg_ctl1 rwl_1_neg_ctl1 7.22989
rrwl_1_t3_neg_ctl1 rwl_1__t3_neg_ctl1 rwl_1_neg_ctl1 21.6897
rrwl_2_t0_neg_ctl1 rwl_2__t0_neg_ctl1 rwl_2_neg_ctl1 21.6897
rrwl_2_t1_neg_ctl1 rwl_2__t1_neg_ctl1 rwl_2_neg_ctl1 7.22989
rrwl_2_t2_neg_ctl1 rwl_2__t2_neg_ctl1 rwl_2_neg_ctl1 7.22989
rrwl_2_t3_neg_ctl1 rwl_2__t3_neg_ctl1 rwl_2_neg_ctl1 21.6897
rrwl_3_t0_neg_ctl1 rwl_3__t0_neg_ctl1 rwl_3_neg_ctl1 21.6897
rrwl_3_t1_neg_ctl1 rwl_3__t1_neg_ctl1 rwl_3_neg_ctl1 7.22989
rrwl_3_t2_neg_ctl1 rwl_3__t2_neg_ctl1 rwl_3_neg_ctl1 7.22989
rrwl_3_t3_neg_ctl1 rwl_3__t3_neg_ctl1 rwl_3_neg_ctl1 21.6897
rsn_0_0_t0_neg_ctl1 sn_0_0__t0_neg_ctl1 sn_0_0_neg_ctl1 125.123
rsn_0_0_t1_neg_ctl1 sn_0_0__t1_neg_ctl1 sn_0_0_neg_ctl1 125.123
rsn_0_1_t0_neg_ctl1 sn_0_1__t0_neg_ctl1 sn_0_1_neg_ctl1 125.123
rsn_0_1_t1_neg_ctl1 sn_0_1__t1_neg_ctl1 sn_0_1_neg_ctl1 125.123
rsn_0_2_t0_neg_ctl1 sn_0_2__t0_neg_ctl1 sn_0_2_neg_ctl1 125.123
rsn_0_2_t1_neg_ctl1 sn_0_2__t1_neg_ctl1 sn_0_2_neg_ctl1 125.123
rsn_0_3_t0_neg_ctl1 sn_0_3__t0_neg_ctl1 sn_0_3_neg_ctl1 125.123
rsn_0_3_t1_neg_ctl1 sn_0_3__t1_neg_ctl1 sn_0_3_neg_ctl1 125.123
rsn_1_0_t0_neg_ctl1 sn_1_0__t0_neg_ctl1 sn_1_0_neg_ctl1 125.123
rsn_1_0_t1_neg_ctl1 sn_1_0__t1_neg_ctl1 sn_1_0_neg_ctl1 125.123
rsn_1_1_t0_neg_ctl1 sn_1_1__t0_neg_ctl1 sn_1_1_neg_ctl1 125.123
rsn_1_1_t1_neg_ctl1 sn_1_1__t1_neg_ctl1 sn_1_1_neg_ctl1 125.123
rsn_1_2_t0_neg_ctl1 sn_1_2__t0_neg_ctl1 sn_1_2_neg_ctl1 125.123
rsn_1_2_t1_neg_ctl1 sn_1_2__t1_neg_ctl1 sn_1_2_neg_ctl1 125.123
rsn_1_3_t0_neg_ctl1 sn_1_3__t0_neg_ctl1 sn_1_3_neg_ctl1 125.123
rsn_1_3_t1_neg_ctl1 sn_1_3__t1_neg_ctl1 sn_1_3_neg_ctl1 125.123
rsn_2_0_t0_neg_ctl1 sn_2_0__t0_neg_ctl1 sn_2_0_neg_ctl1 125.123
rsn_2_0_t1_neg_ctl1 sn_2_0__t1_neg_ctl1 sn_2_0_neg_ctl1 125.123
rsn_2_1_t0_neg_ctl1 sn_2_1__t0_neg_ctl1 sn_2_1_neg_ctl1 125.123
rsn_2_1_t1_neg_ctl1 sn_2_1__t1_neg_ctl1 sn_2_1_neg_ctl1 125.123
rsn_2_2_t0_neg_ctl1 sn_2_2__t0_neg_ctl1 sn_2_2_neg_ctl1 125.123
rsn_2_2_t1_neg_ctl1 sn_2_2__t1_neg_ctl1 sn_2_2_neg_ctl1 125.123
rsn_2_3_t0_neg_ctl1 sn_2_3__t0_neg_ctl1 sn_2_3_neg_ctl1 125.123
rsn_2_3_t1_neg_ctl1 sn_2_3__t1_neg_ctl1 sn_2_3_neg_ctl1 125.123
rsn_3_0_t0_neg_ctl1 sn_3_0__t0_neg_ctl1 sn_3_0_neg_ctl1 125.123
rsn_3_0_t1_neg_ctl1 sn_3_0__t1_neg_ctl1 sn_3_0_neg_ctl1 125.123
rsn_3_1_t0_neg_ctl1 sn_3_1__t0_neg_ctl1 sn_3_1_neg_ctl1 125.123
rsn_3_1_t1_neg_ctl1 sn_3_1__t1_neg_ctl1 sn_3_1_neg_ctl1 125.123
rsn_3_2_t0_neg_ctl1 sn_3_2__t0_neg_ctl1 sn_3_2_neg_ctl1 125.123
rsn_3_2_t1_neg_ctl1 sn_3_2__t1_neg_ctl1 sn_3_2_neg_ctl1 125.123
rsn_3_3_t0_neg_ctl1 sn_3_3__t0_neg_ctl1 sn_3_3_neg_ctl1 125.123
rsn_3_3_t1_neg_ctl1 sn_3_3__t1_neg_ctl1 sn_3_3_neg_ctl1 125.123
rwl_0_t0_neg_ctl1 wl_0__t0_neg_ctl1 wl_0_neg_ctl1 54.2844
rwl_0_t1_neg_ctl1 wl_0__t1_neg_ctl1 wl_0_neg_ctl1 54.2844
rwl_0_t2_neg_ctl1 wl_0__t2_neg_ctl1 wl_0_neg_ctl1 162.853
rwl_0_t3_neg_ctl1 wl_0__t3_neg_ctl1 wl_0_neg_ctl1 162.853
rwl_1_t0_neg_ctl1 wl_1__t0_neg_ctl1 wl_1_neg_ctl1 162.853
rwl_1_t1_neg_ctl1 wl_1__t1_neg_ctl1 wl_1_neg_ctl1 54.2844
rwl_1_t2_neg_ctl1 wl_1__t2_neg_ctl1 wl_1_neg_ctl1 54.2844
rwl_1_t3_neg_ctl1 wl_1__t3_neg_ctl1 wl_1_neg_ctl1 162.853
rwl_2_t0_neg_ctl1 wl_2__t0_neg_ctl1 wl_2_neg_ctl1 54.2844
rwl_2_t1_neg_ctl1 wl_2__t1_neg_ctl1 wl_2_neg_ctl1 54.2844
rwl_2_t2_neg_ctl1 wl_2__t2_neg_ctl1 wl_2_neg_ctl1 162.853
rwl_2_t3_neg_ctl1 wl_2__t3_neg_ctl1 wl_2_neg_ctl1 162.853
rwl_3_t0_neg_ctl1 wl_3__t0_neg_ctl1 wl_3_neg_ctl1 162.853
rwl_3_t1_neg_ctl1 wl_3__t1_neg_ctl1 wl_3_neg_ctl1 54.2844
rwl_3_t2_neg_ctl1 wl_3__t2_neg_ctl1 wl_3_neg_ctl1 54.2844
rwl_3_t3_neg_ctl1 wl_3__t3_neg_ctl1 wl_3_neg_ctl1 162.853
cgnd_neg_ctl1 0 0 4.09475e-15
cbl_0_neg_ctl1 bl_0_neg_ctl1 0 5.96076e-16
cbl_1_neg_ctl1 bl_1_neg_ctl1 0 5.81168e-16
cbl_2_neg_ctl1 bl_2_neg_ctl1 0 5.81168e-16
cbl_3_neg_ctl1 bl_3_neg_ctl1 0 5.81168e-16
crbl_0_neg_ctl1 rbl_0_neg_ctl1 0 5.81168e-16
crbl_1_neg_ctl1 rbl_1_neg_ctl1 0 5.81168e-16
crbl_2_neg_ctl1 rbl_2_neg_ctl1 0 5.81168e-16
crbl_3_neg_ctl1 rbl_3_neg_ctl1 0 5.96076e-16
crwl_0_neg_ctl1 rwl_0_neg_ctl1 0 1.18713e-15
crwl_1_neg_ctl1 rwl_1_neg_ctl1 0 1.18713e-15
crwl_2_neg_ctl1 rwl_2_neg_ctl1 0 1.18713e-15
crwl_3_neg_ctl1 rwl_3_neg_ctl1 0 1.18713e-15
csn_0_0_neg_ctl1 sn_0_0_neg_ctl1 0 4.33689e-16
csn_0_1_neg_ctl1 sn_0_1_neg_ctl1 0 4.30576e-16
csn_0_2_neg_ctl1 sn_0_2_neg_ctl1 0 4.30576e-16
csn_0_3_neg_ctl1 sn_0_3_neg_ctl1 0 4.32518e-16
csn_1_0_neg_ctl1 sn_1_0_neg_ctl1 0 4.33689e-16
csn_1_1_neg_ctl1 sn_1_1_neg_ctl1 0 4.30576e-16
csn_1_2_neg_ctl1 sn_1_2_neg_ctl1 0 4.30576e-16
csn_1_3_neg_ctl1 sn_1_3_neg_ctl1 0 4.32518e-16
csn_2_0_neg_ctl1 sn_2_0_neg_ctl1 0 4.33689e-16
csn_2_1_neg_ctl1 sn_2_1_neg_ctl1 0 4.30576e-16
csn_2_2_neg_ctl1 sn_2_2_neg_ctl1 0 4.30576e-16
csn_2_3_neg_ctl1 sn_2_3_neg_ctl1 0 4.32518e-16
csn_3_0_neg_ctl1 sn_3_0_neg_ctl1 0 4.33689e-16
csn_3_1_neg_ctl1 sn_3_1_neg_ctl1 0 4.30576e-16
csn_3_2_neg_ctl1 sn_3_2_neg_ctl1 0 4.30576e-16
csn_3_3_neg_ctl1 sn_3_3_neg_ctl1 0 4.32518e-16
cwl_0_neg_ctl1 wl_0_neg_ctl1 0 1.90928e-15
cwl_1_neg_ctl1 wl_1_neg_ctl1 0 1.90928e-15
cwl_2_neg_ctl1 wl_2_neg_ctl1 0 1.90928e-15
cwl_3_neg_ctl1 wl_3_neg_ctl1 0 1.91375e-15
ccc_bl_0_sn_0_0_neg_ctl1 bl_0_neg_ctl1 sn_0_0_neg_ctl1 1.071e-17
ccc_bl_0_sn_1_0_neg_ctl1 bl_0_neg_ctl1 sn_1_0_neg_ctl1 1.071e-17
ccc_bl_0_sn_2_0_neg_ctl1 bl_0_neg_ctl1 sn_2_0_neg_ctl1 1.071e-17
ccc_bl_0_sn_3_0_neg_ctl1 bl_0_neg_ctl1 sn_3_0_neg_ctl1 1.071e-17
ccc_bl_0_wl_0_neg_ctl1 bl_0_neg_ctl1 wl_0_neg_ctl1 2.4327e-17
ccc_bl_0_wl_1_neg_ctl1 bl_0_neg_ctl1 wl_1_neg_ctl1 2.4327e-17
ccc_bl_0_wl_2_neg_ctl1 bl_0_neg_ctl1 wl_2_neg_ctl1 2.4327e-17
ccc_bl_1_rbl_0_neg_ctl1 bl_1_neg_ctl1 rbl_0_neg_ctl1 1.29795e-16
ccc_bl_1_rwl_0_neg_ctl1 bl_1_neg_ctl1 rwl_0_neg_ctl1 9.028e-18
ccc_bl_1_rwl_1_neg_ctl1 bl_1_neg_ctl1 rwl_1_neg_ctl1 9.028e-18
ccc_bl_1_rwl_2_neg_ctl1 bl_1_neg_ctl1 rwl_2_neg_ctl1 9.028e-18
ccc_bl_1_rwl_3_neg_ctl1 bl_1_neg_ctl1 rwl_3_neg_ctl1 9.028e-18
ccc_bl_1_sn_0_1_neg_ctl1 bl_1_neg_ctl1 sn_0_1_neg_ctl1 1.071e-17
ccc_bl_1_sn_1_1_neg_ctl1 bl_1_neg_ctl1 sn_1_1_neg_ctl1 1.071e-17
ccc_bl_1_sn_2_1_neg_ctl1 bl_1_neg_ctl1 sn_2_1_neg_ctl1 1.071e-17
ccc_bl_1_sn_3_1_neg_ctl1 bl_1_neg_ctl1 sn_3_1_neg_ctl1 1.071e-17
ccc_bl_1_wl_0_neg_ctl1 bl_1_neg_ctl1 wl_0_neg_ctl1 2.7627e-17
ccc_bl_1_wl_1_neg_ctl1 bl_1_neg_ctl1 wl_1_neg_ctl1 2.7627e-17
ccc_bl_1_wl_2_neg_ctl1 bl_1_neg_ctl1 wl_2_neg_ctl1 2.7627e-17
ccc_bl_2_rbl_1_neg_ctl1 bl_2_neg_ctl1 rbl_1_neg_ctl1 1.29795e-16
ccc_bl_2_rwl_0_neg_ctl1 bl_2_neg_ctl1 rwl_0_neg_ctl1 9.028e-18
ccc_bl_2_rwl_1_neg_ctl1 bl_2_neg_ctl1 rwl_1_neg_ctl1 9.028e-18
ccc_bl_2_rwl_2_neg_ctl1 bl_2_neg_ctl1 rwl_2_neg_ctl1 9.028e-18
ccc_bl_2_rwl_3_neg_ctl1 bl_2_neg_ctl1 rwl_3_neg_ctl1 9.028e-18
ccc_bl_2_sn_0_2_neg_ctl1 bl_2_neg_ctl1 sn_0_2_neg_ctl1 1.071e-17
ccc_bl_2_sn_1_2_neg_ctl1 bl_2_neg_ctl1 sn_1_2_neg_ctl1 1.071e-17
ccc_bl_2_sn_2_2_neg_ctl1 bl_2_neg_ctl1 sn_2_2_neg_ctl1 1.071e-17
ccc_bl_2_sn_3_2_neg_ctl1 bl_2_neg_ctl1 sn_3_2_neg_ctl1 1.071e-17
ccc_bl_2_wl_0_neg_ctl1 bl_2_neg_ctl1 wl_0_neg_ctl1 2.7627e-17
ccc_bl_2_wl_1_neg_ctl1 bl_2_neg_ctl1 wl_1_neg_ctl1 2.7627e-17
ccc_bl_2_wl_2_neg_ctl1 bl_2_neg_ctl1 wl_2_neg_ctl1 2.7627e-17
ccc_bl_3_rbl_2_neg_ctl1 bl_3_neg_ctl1 rbl_2_neg_ctl1 1.29795e-16
ccc_bl_3_rwl_0_neg_ctl1 bl_3_neg_ctl1 rwl_0_neg_ctl1 9.028e-18
ccc_bl_3_rwl_1_neg_ctl1 bl_3_neg_ctl1 rwl_1_neg_ctl1 9.028e-18
ccc_bl_3_rwl_2_neg_ctl1 bl_3_neg_ctl1 rwl_2_neg_ctl1 9.028e-18
ccc_bl_3_rwl_3_neg_ctl1 bl_3_neg_ctl1 rwl_3_neg_ctl1 9.028e-18
ccc_bl_3_sn_0_3_neg_ctl1 bl_3_neg_ctl1 sn_0_3_neg_ctl1 1.071e-17
ccc_bl_3_sn_1_3_neg_ctl1 bl_3_neg_ctl1 sn_1_3_neg_ctl1 1.071e-17
ccc_bl_3_sn_2_3_neg_ctl1 bl_3_neg_ctl1 sn_2_3_neg_ctl1 1.071e-17
ccc_bl_3_sn_3_3_neg_ctl1 bl_3_neg_ctl1 sn_3_3_neg_ctl1 1.071e-17
ccc_bl_3_wl_0_neg_ctl1 bl_3_neg_ctl1 wl_0_neg_ctl1 2.7627e-17
ccc_bl_3_wl_1_neg_ctl1 bl_3_neg_ctl1 wl_1_neg_ctl1 2.7627e-17
ccc_bl_3_wl_2_neg_ctl1 bl_3_neg_ctl1 wl_2_neg_ctl1 2.7627e-17
ccc_rbl_0_rwl_0_neg_ctl1 rbl_0_neg_ctl1 rwl_0_neg_ctl1 1.9738e-17
ccc_rbl_0_rwl_1_neg_ctl1 rbl_0_neg_ctl1 rwl_1_neg_ctl1 1.9738e-17
ccc_rbl_0_rwl_2_neg_ctl1 rbl_0_neg_ctl1 rwl_2_neg_ctl1 1.9738e-17
ccc_rbl_0_rwl_3_neg_ctl1 rbl_0_neg_ctl1 rwl_3_neg_ctl1 1.9738e-17
ccc_rbl_0_sn_0_0_neg_ctl1 rbl_0_neg_ctl1 sn_0_0_neg_ctl1 1.071e-17
ccc_rbl_0_sn_1_0_neg_ctl1 rbl_0_neg_ctl1 sn_1_0_neg_ctl1 2.4327e-17
ccc_rbl_0_sn_2_0_neg_ctl1 rbl_0_neg_ctl1 sn_2_0_neg_ctl1 2.4327e-17
ccc_rbl_0_wl_0_neg_ctl1 rbl_0_neg_ctl1 wl_0_neg_ctl1 3.3e-18
ccc_rbl_0_wl_1_neg_ctl1 rbl_0_neg_ctl1 wl_1_neg_ctl1 3.3e-18
ccc_rbl_0_wl_2_neg_ctl1 rbl_0_neg_ctl1 wl_2_neg_ctl1 3.3e-18
ccc_rbl_1_rwl_0_neg_ctl1 rbl_1_neg_ctl1 rwl_0_neg_ctl1 1.9738e-17
ccc_rbl_1_rwl_1_neg_ctl1 rbl_1_neg_ctl1 rwl_1_neg_ctl1 1.9738e-17
ccc_rbl_1_rwl_2_neg_ctl1 rbl_1_neg_ctl1 rwl_2_neg_ctl1 1.9738e-17
ccc_rbl_1_rwl_3_neg_ctl1 rbl_1_neg_ctl1 rwl_3_neg_ctl1 1.9738e-17
ccc_rbl_1_sn_0_1_neg_ctl1 rbl_1_neg_ctl1 sn_0_1_neg_ctl1 1.071e-17
ccc_rbl_1_sn_1_1_neg_ctl1 rbl_1_neg_ctl1 sn_1_1_neg_ctl1 2.4327e-17
ccc_rbl_1_sn_2_1_neg_ctl1 rbl_1_neg_ctl1 sn_2_1_neg_ctl1 2.4327e-17
ccc_rbl_1_wl_0_neg_ctl1 rbl_1_neg_ctl1 wl_0_neg_ctl1 3.3e-18
ccc_rbl_1_wl_1_neg_ctl1 rbl_1_neg_ctl1 wl_1_neg_ctl1 3.3e-18
ccc_rbl_1_wl_2_neg_ctl1 rbl_1_neg_ctl1 wl_2_neg_ctl1 3.3e-18
ccc_rbl_2_rwl_0_neg_ctl1 rbl_2_neg_ctl1 rwl_0_neg_ctl1 1.9738e-17
ccc_rbl_2_rwl_1_neg_ctl1 rbl_2_neg_ctl1 rwl_1_neg_ctl1 1.9738e-17
ccc_rbl_2_rwl_2_neg_ctl1 rbl_2_neg_ctl1 rwl_2_neg_ctl1 1.9738e-17
ccc_rbl_2_rwl_3_neg_ctl1 rbl_2_neg_ctl1 rwl_3_neg_ctl1 1.9738e-17
ccc_rbl_2_sn_0_2_neg_ctl1 rbl_2_neg_ctl1 sn_0_2_neg_ctl1 1.071e-17
ccc_rbl_2_sn_1_2_neg_ctl1 rbl_2_neg_ctl1 sn_1_2_neg_ctl1 2.4327e-17
ccc_rbl_2_sn_2_2_neg_ctl1 rbl_2_neg_ctl1 sn_2_2_neg_ctl1 2.4327e-17
ccc_rbl_2_wl_0_neg_ctl1 rbl_2_neg_ctl1 wl_0_neg_ctl1 3.3e-18
ccc_rbl_2_wl_1_neg_ctl1 rbl_2_neg_ctl1 wl_1_neg_ctl1 3.3e-18
ccc_rbl_2_wl_2_neg_ctl1 rbl_2_neg_ctl1 wl_2_neg_ctl1 3.3e-18
ccc_rbl_3_rwl_0_neg_ctl1 rbl_3_neg_ctl1 rwl_0_neg_ctl1 1.071e-17
ccc_rbl_3_rwl_1_neg_ctl1 rbl_3_neg_ctl1 rwl_1_neg_ctl1 1.071e-17
ccc_rbl_3_rwl_2_neg_ctl1 rbl_3_neg_ctl1 rwl_2_neg_ctl1 1.071e-17
ccc_rbl_3_rwl_3_neg_ctl1 rbl_3_neg_ctl1 rwl_3_neg_ctl1 1.071e-17
ccc_rbl_3_sn_0_3_neg_ctl1 rbl_3_neg_ctl1 sn_0_3_neg_ctl1 1.071e-17
ccc_rbl_3_sn_1_3_neg_ctl1 rbl_3_neg_ctl1 sn_1_3_neg_ctl1 2.4327e-17
ccc_rbl_3_sn_2_3_neg_ctl1 rbl_3_neg_ctl1 sn_2_3_neg_ctl1 2.4327e-17
ccc_rwl_0_sn_0_0_neg_ctl1 rwl_0_neg_ctl1 sn_0_0_neg_ctl1 1.0072e-17
ccc_rwl_0_sn_0_1_neg_ctl1 rwl_0_neg_ctl1 sn_0_1_neg_ctl1 1.9682e-17
ccc_rwl_0_sn_0_2_neg_ctl1 rwl_0_neg_ctl1 sn_0_2_neg_ctl1 1.9682e-17
ccc_rwl_0_sn_0_3_neg_ctl1 rwl_0_neg_ctl1 sn_0_3_neg_ctl1 1.9682e-17
ccc_rwl_1_sn_1_0_neg_ctl1 rwl_1_neg_ctl1 sn_1_0_neg_ctl1 1.0072e-17
ccc_rwl_1_sn_1_1_neg_ctl1 rwl_1_neg_ctl1 sn_1_1_neg_ctl1 1.9682e-17
ccc_rwl_1_sn_1_2_neg_ctl1 rwl_1_neg_ctl1 sn_1_2_neg_ctl1 1.9682e-17
ccc_rwl_1_sn_1_3_neg_ctl1 rwl_1_neg_ctl1 sn_1_3_neg_ctl1 1.9682e-17
ccc_rwl_2_sn_2_0_neg_ctl1 rwl_2_neg_ctl1 sn_2_0_neg_ctl1 1.0072e-17
ccc_rwl_2_sn_2_1_neg_ctl1 rwl_2_neg_ctl1 sn_2_1_neg_ctl1 1.9682e-17
ccc_rwl_2_sn_2_2_neg_ctl1 rwl_2_neg_ctl1 sn_2_2_neg_ctl1 1.9682e-17
ccc_rwl_2_sn_2_3_neg_ctl1 rwl_2_neg_ctl1 sn_2_3_neg_ctl1 1.9682e-17
ccc_rwl_3_sn_3_0_neg_ctl1 rwl_3_neg_ctl1 sn_3_0_neg_ctl1 1.0072e-17
ccc_rwl_3_sn_3_1_neg_ctl1 rwl_3_neg_ctl1 sn_3_1_neg_ctl1 1.9682e-17
ccc_rwl_3_sn_3_2_neg_ctl1 rwl_3_neg_ctl1 sn_3_2_neg_ctl1 1.9682e-17
ccc_rwl_3_sn_3_3_neg_ctl1 rwl_3_neg_ctl1 sn_3_3_neg_ctl1 1.9682e-17
ccc_sn_0_0_wl_0_neg_ctl1 sn_0_0_neg_ctl1 wl_0_neg_ctl1 1.9664e-17
ccc_sn_0_1_wl_0_neg_ctl1 sn_0_1_neg_ctl1 wl_0_neg_ctl1 1.9664e-17
ccc_sn_0_2_wl_0_neg_ctl1 sn_0_2_neg_ctl1 wl_0_neg_ctl1 1.9664e-17
ccc_sn_0_3_wl_0_neg_ctl1 sn_0_3_neg_ctl1 wl_0_neg_ctl1 1.3668e-17
ccc_sn_1_0_wl_1_neg_ctl1 sn_1_0_neg_ctl1 wl_1_neg_ctl1 1.9664e-17
ccc_sn_1_1_wl_1_neg_ctl1 sn_1_1_neg_ctl1 wl_1_neg_ctl1 1.6705e-17
ccc_sn_1_2_wl_1_neg_ctl1 sn_1_2_neg_ctl1 wl_1_neg_ctl1 1.6705e-17
ccc_sn_1_3_wl_1_neg_ctl1 sn_1_3_neg_ctl1 wl_1_neg_ctl1 1.071e-17
ccc_sn_2_0_wl_2_neg_ctl1 sn_2_0_neg_ctl1 wl_2_neg_ctl1 1.9664e-17
ccc_sn_2_1_wl_2_neg_ctl1 sn_2_1_neg_ctl1 wl_2_neg_ctl1 1.6705e-17
ccc_sn_2_2_wl_2_neg_ctl1 sn_2_2_neg_ctl1 wl_2_neg_ctl1 1.6705e-17
ccc_sn_2_3_wl_2_neg_ctl1 sn_2_3_neg_ctl1 wl_2_neg_ctl1 1.071e-17
ccc_sn_3_0_wl_3_neg_ctl1 sn_3_0_neg_ctl1 wl_3_neg_ctl1 1.9664e-17
ccc_sn_3_1_wl_3_neg_ctl1 sn_3_1_neg_ctl1 wl_3_neg_ctl1 1.6705e-17
ccc_sn_3_2_wl_3_neg_ctl1 sn_3_2_neg_ctl1 wl_3_neg_ctl1 1.6705e-17
ccc_sn_3_3_wl_3_neg_ctl1 sn_3_3_neg_ctl1 wl_3_neg_ctl1 1.071e-17
vdw_neg_ctl1_0 wl_0_neg_ctl1 0 dc 0
vdr_neg_ctl1_0 rwl_0_neg_ctl1 vdd dc 0
vdw_neg_ctl1_1 wl_1_neg_ctl1 0 dc 0
vdr_neg_ctl1_1 rwl_1_neg_ctl1 vdd dc 0
vdw_neg_ctl1_2 wl_2_neg_ctl1 0 dc 0
vdr_neg_ctl1_2 rwl_2_neg_ctl1 vdd dc 0
vdw_neg_ctl1_3 wl_3_neg_ctl1 0 dc 0
vdr_neg_ctl1_3 rwl_3_neg_ctl1 vdd dc 0
vdb_neg_ctl1_0 bl_0_neg_ctl1 vdd dc 0
vdp_neg_ctl1_0 rbl_0_neg_ctl1 vrbl dc 0
vdb_neg_ctl1_1 bl_1_neg_ctl1 vdd dc 0
vdp_neg_ctl1_1 rbl_1_neg_ctl1 vrbl dc 0
vdb_neg_ctl1_2 bl_2_neg_ctl1 vdd dc 0
vdp_neg_ctl1_2 rbl_2_neg_ctl1 vrbl dc 0
vdb_neg_ctl1_3 bl_3_neg_ctl1 vdd dc 0
vdp_neg_ctl1_3 rbl_3_neg_ctl1 vrbl dc 0

* ---- instance neg_rep1: family rep1 (LEAKY write devices x10) ----
xm1_neg_rep1 sn_0_0__t0_neg_rep1 wl_0__t3_neg_rep1 bl_0__t0_neg_rep1 gnd__t0_neg_rep1 sky130_fd_pr__nfet_01v8 L=0.15 W=4.2 nf=1 ad=1.974 as=1.974 pd=9.34 ps=9.34 mult=1 m=1
xm2_neg_rep1 rbl_0__t0_neg_rep1 sn_0_0__t1_neg_rep1 rwl_0__t0_neg_rep1 gnd__t1_neg_rep1 sky130_fd_pr__nfet_01v8 L=0.15 W=0.42 nf=1 ad=0.1974 as=0.1974 pd=1.78 ps=1.78 mult=1 m=1
xm3_neg_rep1 sn_0_1__t1_neg_rep1 wl_0__t0_neg_rep1 bl_1__t0_neg_rep1 gnd__t2_neg_rep1 sky130_fd_pr__nfet_01v8 L=0.15 W=4.2 nf=1 ad=1.974 as=1.974 pd=9.34 ps=9.34 mult=1 m=1
xm4_neg_rep1 rbl_1__t0_neg_rep1 sn_0_1__t0_neg_rep1 rwl_0__t1_neg_rep1 gnd__t3_neg_rep1 sky130_fd_pr__nfet_01v8 L=0.15 W=0.42 nf=1 ad=0.1974 as=0.1974 pd=1.78 ps=1.78 mult=1 m=1
xm5_neg_rep1 sn_0_2__t1_neg_rep1 wl_0__t1_neg_rep1 bl_2__t0_neg_rep1 gnd__t4_neg_rep1 sky130_fd_pr__nfet_01v8 L=0.15 W=4.2 nf=1 ad=1.974 as=1.974 pd=9.34 ps=9.34 mult=1 m=1
xm6_neg_rep1 rbl_2__t0_neg_rep1 sn_0_2__t0_neg_rep1 rwl_0__t2_neg_rep1 gnd__t5_neg_rep1 sky130_fd_pr__nfet_01v8 L=0.15 W=0.42 nf=1 ad=0.1974 as=0.1974 pd=1.78 ps=1.78 mult=1 m=1
xm7_neg_rep1 sn_0_3__t1_neg_rep1 wl_0__t2_neg_rep1 bl_3__t0_neg_rep1 gnd__t6_neg_rep1 sky130_fd_pr__nfet_01v8 L=0.15 W=4.2 nf=1 ad=1.974 as=1.974 pd=9.34 ps=9.34 mult=1 m=1
xm8_neg_rep1 rbl_3__t0_neg_rep1 sn_0_3__t0_neg_rep1 rwl_0__t3_neg_rep1 gnd__t7_neg_rep1 sky130_fd_pr__nfet_01v8 L=0.15 W=0.42 nf=1 ad=0.1974 as=0.1974 pd=1.78 ps=1.78 mult=1 m=1
xm9_neg_rep1 sn_1_0__t1_neg_rep1 wl_1__t0_neg_rep1 bl_0__t1_neg_rep1 gnd__t8_neg_rep1 sky130_fd_pr__nfet_01v8 L=0.15 W=4.2 nf=1 ad=1.974 as=1.974 pd=9.34 ps=9.34 mult=1 m=1
xm10_neg_rep1 rbl_0__t1_neg_rep1 sn_1_0__t0_neg_rep1 rwl_1__t0_neg_rep1 gnd__t9_neg_rep1 sky130_fd_pr__nfet_01v8 L=0.15 W=0.42 nf=1 ad=0.1974 as=0.1974 pd=1.78 ps=1.78 mult=1 m=1
xm11_neg_rep1 sn_1_1__t1_neg_rep1 wl_1__t1_neg_rep1 bl_1__t1_neg_rep1 gnd__t10_neg_rep1 sky130_fd_pr__nfet_01v8 L=0.15 W=4.2 nf=1 ad=1.974 as=1.974 pd=9.34 ps=9.34 mult=1 m=1
xm12_neg_rep1 rbl_1__t1_neg_rep1 sn_1_1__t0_neg_rep1 rwl_1__t1_neg_rep1 gnd__t11_neg_rep1 sky130_fd_pr__nfet_01v8 L=0.15 W=0.42 nf=1 ad=0.1974 as=0.1974 pd=1.78 ps=1.78 mult=1 m=1
xm13_neg_rep1 sn_1_2__t1_neg_rep1 wl_1__t2_neg_rep1 bl_2__t1_neg_rep1 gnd__t12_neg_rep1 sky130_fd_pr__nfet_01v8 L=0.15 W=4.2 nf=1 ad=1.974 as=1.974 pd=9.34 ps=9.34 mult=1 m=1
xm14_neg_rep1 rbl_2__t1_neg_rep1 sn_1_2__t0_neg_rep1 rwl_1__t2_neg_rep1 gnd__t13_neg_rep1 sky130_fd_pr__nfet_01v8 L=0.15 W=0.42 nf=1 ad=0.1974 as=0.1974 pd=1.78 ps=1.78 mult=1 m=1
xm15_neg_rep1 sn_1_3__t1_neg_rep1 wl_1__t3_neg_rep1 bl_3__t1_neg_rep1 gnd__t14_neg_rep1 sky130_fd_pr__nfet_01v8 L=0.15 W=4.2 nf=1 ad=1.974 as=1.974 pd=9.34 ps=9.34 mult=1 m=1
xm16_neg_rep1 rbl_3__t1_neg_rep1 sn_1_3__t0_neg_rep1 rwl_1__t3_neg_rep1 gnd__t15_neg_rep1 sky130_fd_pr__nfet_01v8 L=0.15 W=0.42 nf=1 ad=0.1974 as=0.1974 pd=1.78 ps=1.78 mult=1 m=1
xm17_neg_rep1 sn_2_0__t1_neg_rep1 wl_2__t3_neg_rep1 bl_0__t3_neg_rep1 gnd__t16_neg_rep1 sky130_fd_pr__nfet_01v8 L=0.15 W=4.2 nf=1 ad=1.974 as=1.974 pd=9.34 ps=9.34 mult=1 m=1
xm18_neg_rep1 rbl_0__t2_neg_rep1 sn_2_0__t0_neg_rep1 rwl_2__t0_neg_rep1 gnd__t17_neg_rep1 sky130_fd_pr__nfet_01v8 L=0.15 W=0.42 nf=1 ad=0.1974 as=0.1974 pd=1.78 ps=1.78 mult=1 m=1
xm19_neg_rep1 sn_2_1__t1_neg_rep1 wl_2__t0_neg_rep1 bl_1__t2_neg_rep1 gnd__t18_neg_rep1 sky130_fd_pr__nfet_01v8 L=0.15 W=4.2 nf=1 ad=1.974 as=1.974 pd=9.34 ps=9.34 mult=1 m=1
xm20_neg_rep1 rbl_1__t2_neg_rep1 sn_2_1__t0_neg_rep1 rwl_2__t1_neg_rep1 gnd__t19_neg_rep1 sky130_fd_pr__nfet_01v8 L=0.15 W=0.42 nf=1 ad=0.1974 as=0.1974 pd=1.78 ps=1.78 mult=1 m=1
xm21_neg_rep1 sn_2_2__t1_neg_rep1 wl_2__t1_neg_rep1 bl_2__t2_neg_rep1 gnd__t20_neg_rep1 sky130_fd_pr__nfet_01v8 L=0.15 W=4.2 nf=1 ad=1.974 as=1.974 pd=9.34 ps=9.34 mult=1 m=1
xm22_neg_rep1 rbl_2__t2_neg_rep1 sn_2_2__t0_neg_rep1 rwl_2__t2_neg_rep1 gnd__t21_neg_rep1 sky130_fd_pr__nfet_01v8 L=0.15 W=0.42 nf=1 ad=0.1974 as=0.1974 pd=1.78 ps=1.78 mult=1 m=1
xm23_neg_rep1 sn_2_3__t1_neg_rep1 wl_2__t2_neg_rep1 bl_3__t2_neg_rep1 gnd__t22_neg_rep1 sky130_fd_pr__nfet_01v8 L=0.15 W=4.2 nf=1 ad=1.974 as=1.974 pd=9.34 ps=9.34 mult=1 m=1
xm24_neg_rep1 rbl_3__t2_neg_rep1 sn_2_3__t0_neg_rep1 rwl_2__t3_neg_rep1 gnd__t23_neg_rep1 sky130_fd_pr__nfet_01v8 L=0.15 W=0.42 nf=1 ad=0.1974 as=0.1974 pd=1.78 ps=1.78 mult=1 m=1
xm25_neg_rep1 sn_3_0__t1_neg_rep1 wl_3__t0_neg_rep1 bl_0__t2_neg_rep1 gnd__t24_neg_rep1 sky130_fd_pr__nfet_01v8 L=0.15 W=4.2 nf=1 ad=1.974 as=1.974 pd=9.34 ps=9.34 mult=1 m=1
xm26_neg_rep1 rbl_0__t3_neg_rep1 sn_3_0__t0_neg_rep1 rwl_3__t0_neg_rep1 gnd__t25_neg_rep1 sky130_fd_pr__nfet_01v8 L=0.15 W=0.42 nf=1 ad=0.1974 as=0.1974 pd=1.78 ps=1.78 mult=1 m=1
xm27_neg_rep1 sn_3_1__t1_neg_rep1 wl_3__t1_neg_rep1 bl_1__t3_neg_rep1 gnd__t26_neg_rep1 sky130_fd_pr__nfet_01v8 L=0.15 W=4.2 nf=1 ad=1.974 as=1.974 pd=9.34 ps=9.34 mult=1 m=1
xm28_neg_rep1 rbl_1__t3_neg_rep1 sn_3_1__t0_neg_rep1 rwl_3__t1_neg_rep1 gnd__t27_neg_rep1 sky130_fd_pr__nfet_01v8 L=0.15 W=0.42 nf=1 ad=0.1974 as=0.1974 pd=1.78 ps=1.78 mult=1 m=1
xm29_neg_rep1 sn_3_2__t1_neg_rep1 wl_3__t2_neg_rep1 bl_2__t3_neg_rep1 gnd__t28_neg_rep1 sky130_fd_pr__nfet_01v8 L=0.15 W=4.2 nf=1 ad=1.974 as=1.974 pd=9.34 ps=9.34 mult=1 m=1
xm30_neg_rep1 rbl_2__t3_neg_rep1 sn_3_2__t0_neg_rep1 rwl_3__t2_neg_rep1 gnd__t29_neg_rep1 sky130_fd_pr__nfet_01v8 L=0.15 W=0.42 nf=1 ad=0.1974 as=0.1974 pd=1.78 ps=1.78 mult=1 m=1
xm31_neg_rep1 sn_3_3__t1_neg_rep1 wl_3__t3_neg_rep1 bl_3__t3_neg_rep1 gnd__t30_neg_rep1 sky130_fd_pr__nfet_01v8 L=0.15 W=4.2 nf=1 ad=1.974 as=1.974 pd=9.34 ps=9.34 mult=1 m=1
xm32_neg_rep1 rbl_3__t3_neg_rep1 sn_3_3__t0_neg_rep1 rwl_3__t3_neg_rep1 gnd__t31_neg_rep1 sky130_fd_pr__nfet_01v8 L=0.15 W=0.42 nf=1 ad=0.1974 as=0.1974 pd=1.78 ps=1.78 mult=1 m=1
rgnd_t0_neg_rep1 gnd__t0_neg_rep1 0 63.3529
rgnd_t1_neg_rep1 gnd__t1_neg_rep1 0 49.0465
rgnd_t2_neg_rep1 gnd__t2_neg_rep1 0 36.5177
rgnd_t3_neg_rep1 gnd__t3_neg_rep1 0 28.2406
rgnd_t4_neg_rep1 gnd__t4_neg_rep1 0 28.2406
rgnd_t5_neg_rep1 gnd__t5_neg_rep1 0 36.5177
rgnd_t6_neg_rep1 gnd__t6_neg_rep1 0 49.0465
rgnd_t7_neg_rep1 gnd__t7_neg_rep1 0 63.3529
rgnd_t8_neg_rep1 gnd__t8_neg_rep1 0 58.0019
rgnd_t9_neg_rep1 gnd__t9_neg_rep1 0 41.907
rgnd_t10_neg_rep1 gnd__t10_neg_rep1 0 26.1568
rgnd_t11_neg_rep1 gnd__t11_neg_rep1 0 12.1726
rgnd_t12_neg_rep1 gnd__t12_neg_rep1 0 12.1726
rgnd_t13_neg_rep1 gnd__t13_neg_rep1 0 26.1568
rgnd_t14_neg_rep1 gnd__t14_neg_rep1 0 41.907
rgnd_t15_neg_rep1 gnd__t15_neg_rep1 0 58.0019
rgnd_t16_neg_rep1 gnd__t16_neg_rep1 0 58.0019
rgnd_t17_neg_rep1 gnd__t17_neg_rep1 0 41.907
rgnd_t18_neg_rep1 gnd__t18_neg_rep1 0 26.1568
rgnd_t19_neg_rep1 gnd__t19_neg_rep1 0 12.1726
rgnd_t20_neg_rep1 gnd__t20_neg_rep1 0 12.1726
rgnd_t21_neg_rep1 gnd__t21_neg_rep1 0 26.1568
rgnd_t22_neg_rep1 gnd__t22_neg_rep1 0 41.907
rgnd_t23_neg_rep1 gnd__t23_neg_rep1 0 58.0019
rgnd_t24_neg_rep1 gnd__t24_neg_rep1 0 63.3529
rgnd_t25_neg_rep1 gnd__t25_neg_rep1 0 49.0465
rgnd_t26_neg_rep1 gnd__t26_neg_rep1 0 36.5177
rgnd_t27_neg_rep1 gnd__t27_neg_rep1 0 28.2406
rgnd_t28_neg_rep1 gnd__t28_neg_rep1 0 28.2406
rgnd_t29_neg_rep1 gnd__t29_neg_rep1 0 36.5177
rgnd_t30_neg_rep1 gnd__t30_neg_rep1 0 49.0465
rgnd_t31_neg_rep1 gnd__t31_neg_rep1 0 63.3529
rbl_0_t0_neg_rep1 bl_0__t0_neg_rep1 bl_0_neg_rep1 144.555
rbl_0_t1_neg_rep1 bl_0__t1_neg_rep1 bl_0_neg_rep1 48.1851
rbl_0_t2_neg_rep1 bl_0__t2_neg_rep1 bl_0_neg_rep1 144.555
rbl_0_t3_neg_rep1 bl_0__t3_neg_rep1 bl_0_neg_rep1 48.1851
rbl_1_t0_neg_rep1 bl_1__t0_neg_rep1 bl_1_neg_rep1 144.555
rbl_1_t1_neg_rep1 bl_1__t1_neg_rep1 bl_1_neg_rep1 48.1851
rbl_1_t2_neg_rep1 bl_1__t2_neg_rep1 bl_1_neg_rep1 48.1851
rbl_1_t3_neg_rep1 bl_1__t3_neg_rep1 bl_1_neg_rep1 144.555
rbl_2_t0_neg_rep1 bl_2__t0_neg_rep1 bl_2_neg_rep1 144.555
rbl_2_t1_neg_rep1 bl_2__t1_neg_rep1 bl_2_neg_rep1 48.1851
rbl_2_t2_neg_rep1 bl_2__t2_neg_rep1 bl_2_neg_rep1 48.1851
rbl_2_t3_neg_rep1 bl_2__t3_neg_rep1 bl_2_neg_rep1 144.555
rbl_3_t0_neg_rep1 bl_3__t0_neg_rep1 bl_3_neg_rep1 144.555
rbl_3_t1_neg_rep1 bl_3__t1_neg_rep1 bl_3_neg_rep1 48.1851
rbl_3_t2_neg_rep1 bl_3__t2_neg_rep1 bl_3_neg_rep1 48.1851
rbl_3_t3_neg_rep1 bl_3__t3_neg_rep1 bl_3_neg_rep1 144.555
rrbl_0_t0_neg_rep1 rbl_0__t0_neg_rep1 rbl_0_neg_rep1 144.555
rrbl_0_t1_neg_rep1 rbl_0__t1_neg_rep1 rbl_0_neg_rep1 48.1851
rrbl_0_t2_neg_rep1 rbl_0__t2_neg_rep1 rbl_0_neg_rep1 48.1851
rrbl_0_t3_neg_rep1 rbl_0__t3_neg_rep1 rbl_0_neg_rep1 144.555
rrbl_1_t0_neg_rep1 rbl_1__t0_neg_rep1 rbl_1_neg_rep1 144.555
rrbl_1_t1_neg_rep1 rbl_1__t1_neg_rep1 rbl_1_neg_rep1 48.1851
rrbl_1_t2_neg_rep1 rbl_1__t2_neg_rep1 rbl_1_neg_rep1 48.1851
rrbl_1_t3_neg_rep1 rbl_1__t3_neg_rep1 rbl_1_neg_rep1 144.555
rrbl_2_t0_neg_rep1 rbl_2__t0_neg_rep1 rbl_2_neg_rep1 144.555
rrbl_2_t1_neg_rep1 rbl_2__t1_neg_rep1 rbl_2_neg_rep1 48.1851
rrbl_2_t2_neg_rep1 rbl_2__t2_neg_rep1 rbl_2_neg_rep1 48.1851
rrbl_2_t3_neg_rep1 rbl_2__t3_neg_rep1 rbl_2_neg_rep1 144.555
rrbl_3_t0_neg_rep1 rbl_3__t0_neg_rep1 rbl_3_neg_rep1 144.555
rrbl_3_t1_neg_rep1 rbl_3__t1_neg_rep1 rbl_3_neg_rep1 48.1851
rrbl_3_t2_neg_rep1 rbl_3__t2_neg_rep1 rbl_3_neg_rep1 48.1851
rrbl_3_t3_neg_rep1 rbl_3__t3_neg_rep1 rbl_3_neg_rep1 144.555
rrwl_0_t0_neg_rep1 rwl_0__t0_neg_rep1 rwl_0_neg_rep1 21.6897
rrwl_0_t1_neg_rep1 rwl_0__t1_neg_rep1 rwl_0_neg_rep1 7.22989
rrwl_0_t2_neg_rep1 rwl_0__t2_neg_rep1 rwl_0_neg_rep1 7.22989
rrwl_0_t3_neg_rep1 rwl_0__t3_neg_rep1 rwl_0_neg_rep1 21.6897
rrwl_1_t0_neg_rep1 rwl_1__t0_neg_rep1 rwl_1_neg_rep1 21.6897
rrwl_1_t1_neg_rep1 rwl_1__t1_neg_rep1 rwl_1_neg_rep1 7.22989
rrwl_1_t2_neg_rep1 rwl_1__t2_neg_rep1 rwl_1_neg_rep1 7.22989
rrwl_1_t3_neg_rep1 rwl_1__t3_neg_rep1 rwl_1_neg_rep1 21.6897
rrwl_2_t0_neg_rep1 rwl_2__t0_neg_rep1 rwl_2_neg_rep1 21.6897
rrwl_2_t1_neg_rep1 rwl_2__t1_neg_rep1 rwl_2_neg_rep1 7.22989
rrwl_2_t2_neg_rep1 rwl_2__t2_neg_rep1 rwl_2_neg_rep1 7.22989
rrwl_2_t3_neg_rep1 rwl_2__t3_neg_rep1 rwl_2_neg_rep1 21.6897
rrwl_3_t0_neg_rep1 rwl_3__t0_neg_rep1 rwl_3_neg_rep1 21.6897
rrwl_3_t1_neg_rep1 rwl_3__t1_neg_rep1 rwl_3_neg_rep1 7.22989
rrwl_3_t2_neg_rep1 rwl_3__t2_neg_rep1 rwl_3_neg_rep1 7.22989
rrwl_3_t3_neg_rep1 rwl_3__t3_neg_rep1 rwl_3_neg_rep1 21.6897
rsn_0_0_t0_neg_rep1 sn_0_0__t0_neg_rep1 sn_0_0_neg_rep1 125.123
rsn_0_0_t1_neg_rep1 sn_0_0__t1_neg_rep1 sn_0_0_neg_rep1 125.123
rsn_0_1_t0_neg_rep1 sn_0_1__t0_neg_rep1 sn_0_1_neg_rep1 125.123
rsn_0_1_t1_neg_rep1 sn_0_1__t1_neg_rep1 sn_0_1_neg_rep1 125.123
rsn_0_2_t0_neg_rep1 sn_0_2__t0_neg_rep1 sn_0_2_neg_rep1 125.123
rsn_0_2_t1_neg_rep1 sn_0_2__t1_neg_rep1 sn_0_2_neg_rep1 125.123
rsn_0_3_t0_neg_rep1 sn_0_3__t0_neg_rep1 sn_0_3_neg_rep1 125.123
rsn_0_3_t1_neg_rep1 sn_0_3__t1_neg_rep1 sn_0_3_neg_rep1 125.123
rsn_1_0_t0_neg_rep1 sn_1_0__t0_neg_rep1 sn_1_0_neg_rep1 125.123
rsn_1_0_t1_neg_rep1 sn_1_0__t1_neg_rep1 sn_1_0_neg_rep1 125.123
rsn_1_1_t0_neg_rep1 sn_1_1__t0_neg_rep1 sn_1_1_neg_rep1 125.123
rsn_1_1_t1_neg_rep1 sn_1_1__t1_neg_rep1 sn_1_1_neg_rep1 125.123
rsn_1_2_t0_neg_rep1 sn_1_2__t0_neg_rep1 sn_1_2_neg_rep1 125.123
rsn_1_2_t1_neg_rep1 sn_1_2__t1_neg_rep1 sn_1_2_neg_rep1 125.123
rsn_1_3_t0_neg_rep1 sn_1_3__t0_neg_rep1 sn_1_3_neg_rep1 125.123
rsn_1_3_t1_neg_rep1 sn_1_3__t1_neg_rep1 sn_1_3_neg_rep1 125.123
rsn_2_0_t0_neg_rep1 sn_2_0__t0_neg_rep1 sn_2_0_neg_rep1 125.123
rsn_2_0_t1_neg_rep1 sn_2_0__t1_neg_rep1 sn_2_0_neg_rep1 125.123
rsn_2_1_t0_neg_rep1 sn_2_1__t0_neg_rep1 sn_2_1_neg_rep1 125.123
rsn_2_1_t1_neg_rep1 sn_2_1__t1_neg_rep1 sn_2_1_neg_rep1 125.123
rsn_2_2_t0_neg_rep1 sn_2_2__t0_neg_rep1 sn_2_2_neg_rep1 125.123
rsn_2_2_t1_neg_rep1 sn_2_2__t1_neg_rep1 sn_2_2_neg_rep1 125.123
rsn_2_3_t0_neg_rep1 sn_2_3__t0_neg_rep1 sn_2_3_neg_rep1 125.123
rsn_2_3_t1_neg_rep1 sn_2_3__t1_neg_rep1 sn_2_3_neg_rep1 125.123
rsn_3_0_t0_neg_rep1 sn_3_0__t0_neg_rep1 sn_3_0_neg_rep1 125.123
rsn_3_0_t1_neg_rep1 sn_3_0__t1_neg_rep1 sn_3_0_neg_rep1 125.123
rsn_3_1_t0_neg_rep1 sn_3_1__t0_neg_rep1 sn_3_1_neg_rep1 125.123
rsn_3_1_t1_neg_rep1 sn_3_1__t1_neg_rep1 sn_3_1_neg_rep1 125.123
rsn_3_2_t0_neg_rep1 sn_3_2__t0_neg_rep1 sn_3_2_neg_rep1 125.123
rsn_3_2_t1_neg_rep1 sn_3_2__t1_neg_rep1 sn_3_2_neg_rep1 125.123
rsn_3_3_t0_neg_rep1 sn_3_3__t0_neg_rep1 sn_3_3_neg_rep1 125.123
rsn_3_3_t1_neg_rep1 sn_3_3__t1_neg_rep1 sn_3_3_neg_rep1 125.123
rwl_0_t0_neg_rep1 wl_0__t0_neg_rep1 wl_0_neg_rep1 54.2844
rwl_0_t1_neg_rep1 wl_0__t1_neg_rep1 wl_0_neg_rep1 54.2844
rwl_0_t2_neg_rep1 wl_0__t2_neg_rep1 wl_0_neg_rep1 162.853
rwl_0_t3_neg_rep1 wl_0__t3_neg_rep1 wl_0_neg_rep1 162.853
rwl_1_t0_neg_rep1 wl_1__t0_neg_rep1 wl_1_neg_rep1 162.853
rwl_1_t1_neg_rep1 wl_1__t1_neg_rep1 wl_1_neg_rep1 54.2844
rwl_1_t2_neg_rep1 wl_1__t2_neg_rep1 wl_1_neg_rep1 54.2844
rwl_1_t3_neg_rep1 wl_1__t3_neg_rep1 wl_1_neg_rep1 162.853
rwl_2_t0_neg_rep1 wl_2__t0_neg_rep1 wl_2_neg_rep1 54.2844
rwl_2_t1_neg_rep1 wl_2__t1_neg_rep1 wl_2_neg_rep1 54.2844
rwl_2_t2_neg_rep1 wl_2__t2_neg_rep1 wl_2_neg_rep1 162.853
rwl_2_t3_neg_rep1 wl_2__t3_neg_rep1 wl_2_neg_rep1 162.853
rwl_3_t0_neg_rep1 wl_3__t0_neg_rep1 wl_3_neg_rep1 162.853
rwl_3_t1_neg_rep1 wl_3__t1_neg_rep1 wl_3_neg_rep1 54.2844
rwl_3_t2_neg_rep1 wl_3__t2_neg_rep1 wl_3_neg_rep1 54.2844
rwl_3_t3_neg_rep1 wl_3__t3_neg_rep1 wl_3_neg_rep1 162.853
cgnd_neg_rep1 0 0 4.09475e-15
cbl_0_neg_rep1 bl_0_neg_rep1 0 5.96076e-16
cbl_1_neg_rep1 bl_1_neg_rep1 0 5.81168e-16
cbl_2_neg_rep1 bl_2_neg_rep1 0 5.81168e-16
cbl_3_neg_rep1 bl_3_neg_rep1 0 5.81168e-16
crbl_0_neg_rep1 rbl_0_neg_rep1 0 5.81168e-16
crbl_1_neg_rep1 rbl_1_neg_rep1 0 5.81168e-16
crbl_2_neg_rep1 rbl_2_neg_rep1 0 5.81168e-16
crbl_3_neg_rep1 rbl_3_neg_rep1 0 5.96076e-16
crwl_0_neg_rep1 rwl_0_neg_rep1 0 1.18713e-15
crwl_1_neg_rep1 rwl_1_neg_rep1 0 1.18713e-15
crwl_2_neg_rep1 rwl_2_neg_rep1 0 1.18713e-15
crwl_3_neg_rep1 rwl_3_neg_rep1 0 1.18713e-15
csn_0_0_neg_rep1 sn_0_0_neg_rep1 0 4.33689e-16
csn_0_1_neg_rep1 sn_0_1_neg_rep1 0 4.30576e-16
csn_0_2_neg_rep1 sn_0_2_neg_rep1 0 4.30576e-16
csn_0_3_neg_rep1 sn_0_3_neg_rep1 0 4.32518e-16
csn_1_0_neg_rep1 sn_1_0_neg_rep1 0 4.33689e-16
csn_1_1_neg_rep1 sn_1_1_neg_rep1 0 4.30576e-16
csn_1_2_neg_rep1 sn_1_2_neg_rep1 0 4.30576e-16
csn_1_3_neg_rep1 sn_1_3_neg_rep1 0 4.32518e-16
csn_2_0_neg_rep1 sn_2_0_neg_rep1 0 4.33689e-16
csn_2_1_neg_rep1 sn_2_1_neg_rep1 0 4.30576e-16
csn_2_2_neg_rep1 sn_2_2_neg_rep1 0 4.30576e-16
csn_2_3_neg_rep1 sn_2_3_neg_rep1 0 4.32518e-16
csn_3_0_neg_rep1 sn_3_0_neg_rep1 0 4.33689e-16
csn_3_1_neg_rep1 sn_3_1_neg_rep1 0 4.30576e-16
csn_3_2_neg_rep1 sn_3_2_neg_rep1 0 4.30576e-16
csn_3_3_neg_rep1 sn_3_3_neg_rep1 0 4.32518e-16
cwl_0_neg_rep1 wl_0_neg_rep1 0 1.90928e-15
cwl_1_neg_rep1 wl_1_neg_rep1 0 1.90928e-15
cwl_2_neg_rep1 wl_2_neg_rep1 0 1.90928e-15
cwl_3_neg_rep1 wl_3_neg_rep1 0 1.91375e-15
ccc_bl_0_sn_0_0_neg_rep1 bl_0_neg_rep1 sn_0_0_neg_rep1 1.071e-17
ccc_bl_0_sn_1_0_neg_rep1 bl_0_neg_rep1 sn_1_0_neg_rep1 1.071e-17
ccc_bl_0_sn_2_0_neg_rep1 bl_0_neg_rep1 sn_2_0_neg_rep1 1.071e-17
ccc_bl_0_sn_3_0_neg_rep1 bl_0_neg_rep1 sn_3_0_neg_rep1 1.071e-17
ccc_bl_0_wl_0_neg_rep1 bl_0_neg_rep1 wl_0_neg_rep1 2.4327e-17
ccc_bl_0_wl_1_neg_rep1 bl_0_neg_rep1 wl_1_neg_rep1 2.4327e-17
ccc_bl_0_wl_2_neg_rep1 bl_0_neg_rep1 wl_2_neg_rep1 2.4327e-17
ccc_bl_1_rbl_0_neg_rep1 bl_1_neg_rep1 rbl_0_neg_rep1 1.29795e-16
ccc_bl_1_rwl_0_neg_rep1 bl_1_neg_rep1 rwl_0_neg_rep1 9.028e-18
ccc_bl_1_rwl_1_neg_rep1 bl_1_neg_rep1 rwl_1_neg_rep1 9.028e-18
ccc_bl_1_rwl_2_neg_rep1 bl_1_neg_rep1 rwl_2_neg_rep1 9.028e-18
ccc_bl_1_rwl_3_neg_rep1 bl_1_neg_rep1 rwl_3_neg_rep1 9.028e-18
ccc_bl_1_sn_0_1_neg_rep1 bl_1_neg_rep1 sn_0_1_neg_rep1 1.071e-17
ccc_bl_1_sn_1_1_neg_rep1 bl_1_neg_rep1 sn_1_1_neg_rep1 1.071e-17
ccc_bl_1_sn_2_1_neg_rep1 bl_1_neg_rep1 sn_2_1_neg_rep1 1.071e-17
ccc_bl_1_sn_3_1_neg_rep1 bl_1_neg_rep1 sn_3_1_neg_rep1 1.071e-17
ccc_bl_1_wl_0_neg_rep1 bl_1_neg_rep1 wl_0_neg_rep1 2.7627e-17
ccc_bl_1_wl_1_neg_rep1 bl_1_neg_rep1 wl_1_neg_rep1 2.7627e-17
ccc_bl_1_wl_2_neg_rep1 bl_1_neg_rep1 wl_2_neg_rep1 2.7627e-17
ccc_bl_2_rbl_1_neg_rep1 bl_2_neg_rep1 rbl_1_neg_rep1 1.29795e-16
ccc_bl_2_rwl_0_neg_rep1 bl_2_neg_rep1 rwl_0_neg_rep1 9.028e-18
ccc_bl_2_rwl_1_neg_rep1 bl_2_neg_rep1 rwl_1_neg_rep1 9.028e-18
ccc_bl_2_rwl_2_neg_rep1 bl_2_neg_rep1 rwl_2_neg_rep1 9.028e-18
ccc_bl_2_rwl_3_neg_rep1 bl_2_neg_rep1 rwl_3_neg_rep1 9.028e-18
ccc_bl_2_sn_0_2_neg_rep1 bl_2_neg_rep1 sn_0_2_neg_rep1 1.071e-17
ccc_bl_2_sn_1_2_neg_rep1 bl_2_neg_rep1 sn_1_2_neg_rep1 1.071e-17
ccc_bl_2_sn_2_2_neg_rep1 bl_2_neg_rep1 sn_2_2_neg_rep1 1.071e-17
ccc_bl_2_sn_3_2_neg_rep1 bl_2_neg_rep1 sn_3_2_neg_rep1 1.071e-17
ccc_bl_2_wl_0_neg_rep1 bl_2_neg_rep1 wl_0_neg_rep1 2.7627e-17
ccc_bl_2_wl_1_neg_rep1 bl_2_neg_rep1 wl_1_neg_rep1 2.7627e-17
ccc_bl_2_wl_2_neg_rep1 bl_2_neg_rep1 wl_2_neg_rep1 2.7627e-17
ccc_bl_3_rbl_2_neg_rep1 bl_3_neg_rep1 rbl_2_neg_rep1 1.29795e-16
ccc_bl_3_rwl_0_neg_rep1 bl_3_neg_rep1 rwl_0_neg_rep1 9.028e-18
ccc_bl_3_rwl_1_neg_rep1 bl_3_neg_rep1 rwl_1_neg_rep1 9.028e-18
ccc_bl_3_rwl_2_neg_rep1 bl_3_neg_rep1 rwl_2_neg_rep1 9.028e-18
ccc_bl_3_rwl_3_neg_rep1 bl_3_neg_rep1 rwl_3_neg_rep1 9.028e-18
ccc_bl_3_sn_0_3_neg_rep1 bl_3_neg_rep1 sn_0_3_neg_rep1 1.071e-17
ccc_bl_3_sn_1_3_neg_rep1 bl_3_neg_rep1 sn_1_3_neg_rep1 1.071e-17
ccc_bl_3_sn_2_3_neg_rep1 bl_3_neg_rep1 sn_2_3_neg_rep1 1.071e-17
ccc_bl_3_sn_3_3_neg_rep1 bl_3_neg_rep1 sn_3_3_neg_rep1 1.071e-17
ccc_bl_3_wl_0_neg_rep1 bl_3_neg_rep1 wl_0_neg_rep1 2.7627e-17
ccc_bl_3_wl_1_neg_rep1 bl_3_neg_rep1 wl_1_neg_rep1 2.7627e-17
ccc_bl_3_wl_2_neg_rep1 bl_3_neg_rep1 wl_2_neg_rep1 2.7627e-17
ccc_rbl_0_rwl_0_neg_rep1 rbl_0_neg_rep1 rwl_0_neg_rep1 1.9738e-17
ccc_rbl_0_rwl_1_neg_rep1 rbl_0_neg_rep1 rwl_1_neg_rep1 1.9738e-17
ccc_rbl_0_rwl_2_neg_rep1 rbl_0_neg_rep1 rwl_2_neg_rep1 1.9738e-17
ccc_rbl_0_rwl_3_neg_rep1 rbl_0_neg_rep1 rwl_3_neg_rep1 1.9738e-17
ccc_rbl_0_sn_0_0_neg_rep1 rbl_0_neg_rep1 sn_0_0_neg_rep1 1.071e-17
ccc_rbl_0_sn_1_0_neg_rep1 rbl_0_neg_rep1 sn_1_0_neg_rep1 2.4327e-17
ccc_rbl_0_sn_2_0_neg_rep1 rbl_0_neg_rep1 sn_2_0_neg_rep1 2.4327e-17
ccc_rbl_0_wl_0_neg_rep1 rbl_0_neg_rep1 wl_0_neg_rep1 3.3e-18
ccc_rbl_0_wl_1_neg_rep1 rbl_0_neg_rep1 wl_1_neg_rep1 3.3e-18
ccc_rbl_0_wl_2_neg_rep1 rbl_0_neg_rep1 wl_2_neg_rep1 3.3e-18
ccc_rbl_1_rwl_0_neg_rep1 rbl_1_neg_rep1 rwl_0_neg_rep1 1.9738e-17
ccc_rbl_1_rwl_1_neg_rep1 rbl_1_neg_rep1 rwl_1_neg_rep1 1.9738e-17
ccc_rbl_1_rwl_2_neg_rep1 rbl_1_neg_rep1 rwl_2_neg_rep1 1.9738e-17
ccc_rbl_1_rwl_3_neg_rep1 rbl_1_neg_rep1 rwl_3_neg_rep1 1.9738e-17
ccc_rbl_1_sn_0_1_neg_rep1 rbl_1_neg_rep1 sn_0_1_neg_rep1 1.071e-17
ccc_rbl_1_sn_1_1_neg_rep1 rbl_1_neg_rep1 sn_1_1_neg_rep1 2.4327e-17
ccc_rbl_1_sn_2_1_neg_rep1 rbl_1_neg_rep1 sn_2_1_neg_rep1 2.4327e-17
ccc_rbl_1_wl_0_neg_rep1 rbl_1_neg_rep1 wl_0_neg_rep1 3.3e-18
ccc_rbl_1_wl_1_neg_rep1 rbl_1_neg_rep1 wl_1_neg_rep1 3.3e-18
ccc_rbl_1_wl_2_neg_rep1 rbl_1_neg_rep1 wl_2_neg_rep1 3.3e-18
ccc_rbl_2_rwl_0_neg_rep1 rbl_2_neg_rep1 rwl_0_neg_rep1 1.9738e-17
ccc_rbl_2_rwl_1_neg_rep1 rbl_2_neg_rep1 rwl_1_neg_rep1 1.9738e-17
ccc_rbl_2_rwl_2_neg_rep1 rbl_2_neg_rep1 rwl_2_neg_rep1 1.9738e-17
ccc_rbl_2_rwl_3_neg_rep1 rbl_2_neg_rep1 rwl_3_neg_rep1 1.9738e-17
ccc_rbl_2_sn_0_2_neg_rep1 rbl_2_neg_rep1 sn_0_2_neg_rep1 1.071e-17
ccc_rbl_2_sn_1_2_neg_rep1 rbl_2_neg_rep1 sn_1_2_neg_rep1 2.4327e-17
ccc_rbl_2_sn_2_2_neg_rep1 rbl_2_neg_rep1 sn_2_2_neg_rep1 2.4327e-17
ccc_rbl_2_wl_0_neg_rep1 rbl_2_neg_rep1 wl_0_neg_rep1 3.3e-18
ccc_rbl_2_wl_1_neg_rep1 rbl_2_neg_rep1 wl_1_neg_rep1 3.3e-18
ccc_rbl_2_wl_2_neg_rep1 rbl_2_neg_rep1 wl_2_neg_rep1 3.3e-18
ccc_rbl_3_rwl_0_neg_rep1 rbl_3_neg_rep1 rwl_0_neg_rep1 1.071e-17
ccc_rbl_3_rwl_1_neg_rep1 rbl_3_neg_rep1 rwl_1_neg_rep1 1.071e-17
ccc_rbl_3_rwl_2_neg_rep1 rbl_3_neg_rep1 rwl_2_neg_rep1 1.071e-17
ccc_rbl_3_rwl_3_neg_rep1 rbl_3_neg_rep1 rwl_3_neg_rep1 1.071e-17
ccc_rbl_3_sn_0_3_neg_rep1 rbl_3_neg_rep1 sn_0_3_neg_rep1 1.071e-17
ccc_rbl_3_sn_1_3_neg_rep1 rbl_3_neg_rep1 sn_1_3_neg_rep1 2.4327e-17
ccc_rbl_3_sn_2_3_neg_rep1 rbl_3_neg_rep1 sn_2_3_neg_rep1 2.4327e-17
ccc_rwl_0_sn_0_0_neg_rep1 rwl_0_neg_rep1 sn_0_0_neg_rep1 1.0072e-17
ccc_rwl_0_sn_0_1_neg_rep1 rwl_0_neg_rep1 sn_0_1_neg_rep1 1.9682e-17
ccc_rwl_0_sn_0_2_neg_rep1 rwl_0_neg_rep1 sn_0_2_neg_rep1 1.9682e-17
ccc_rwl_0_sn_0_3_neg_rep1 rwl_0_neg_rep1 sn_0_3_neg_rep1 1.9682e-17
ccc_rwl_1_sn_1_0_neg_rep1 rwl_1_neg_rep1 sn_1_0_neg_rep1 1.0072e-17
ccc_rwl_1_sn_1_1_neg_rep1 rwl_1_neg_rep1 sn_1_1_neg_rep1 1.9682e-17
ccc_rwl_1_sn_1_2_neg_rep1 rwl_1_neg_rep1 sn_1_2_neg_rep1 1.9682e-17
ccc_rwl_1_sn_1_3_neg_rep1 rwl_1_neg_rep1 sn_1_3_neg_rep1 1.9682e-17
ccc_rwl_2_sn_2_0_neg_rep1 rwl_2_neg_rep1 sn_2_0_neg_rep1 1.0072e-17
ccc_rwl_2_sn_2_1_neg_rep1 rwl_2_neg_rep1 sn_2_1_neg_rep1 1.9682e-17
ccc_rwl_2_sn_2_2_neg_rep1 rwl_2_neg_rep1 sn_2_2_neg_rep1 1.9682e-17
ccc_rwl_2_sn_2_3_neg_rep1 rwl_2_neg_rep1 sn_2_3_neg_rep1 1.9682e-17
ccc_rwl_3_sn_3_0_neg_rep1 rwl_3_neg_rep1 sn_3_0_neg_rep1 1.0072e-17
ccc_rwl_3_sn_3_1_neg_rep1 rwl_3_neg_rep1 sn_3_1_neg_rep1 1.9682e-17
ccc_rwl_3_sn_3_2_neg_rep1 rwl_3_neg_rep1 sn_3_2_neg_rep1 1.9682e-17
ccc_rwl_3_sn_3_3_neg_rep1 rwl_3_neg_rep1 sn_3_3_neg_rep1 1.9682e-17
ccc_sn_0_0_wl_0_neg_rep1 sn_0_0_neg_rep1 wl_0_neg_rep1 1.9664e-17
ccc_sn_0_1_wl_0_neg_rep1 sn_0_1_neg_rep1 wl_0_neg_rep1 1.9664e-17
ccc_sn_0_2_wl_0_neg_rep1 sn_0_2_neg_rep1 wl_0_neg_rep1 1.9664e-17
ccc_sn_0_3_wl_0_neg_rep1 sn_0_3_neg_rep1 wl_0_neg_rep1 1.3668e-17
ccc_sn_1_0_wl_1_neg_rep1 sn_1_0_neg_rep1 wl_1_neg_rep1 1.9664e-17
ccc_sn_1_1_wl_1_neg_rep1 sn_1_1_neg_rep1 wl_1_neg_rep1 1.6705e-17
ccc_sn_1_2_wl_1_neg_rep1 sn_1_2_neg_rep1 wl_1_neg_rep1 1.6705e-17
ccc_sn_1_3_wl_1_neg_rep1 sn_1_3_neg_rep1 wl_1_neg_rep1 1.071e-17
ccc_sn_2_0_wl_2_neg_rep1 sn_2_0_neg_rep1 wl_2_neg_rep1 1.9664e-17
ccc_sn_2_1_wl_2_neg_rep1 sn_2_1_neg_rep1 wl_2_neg_rep1 1.6705e-17
ccc_sn_2_2_wl_2_neg_rep1 sn_2_2_neg_rep1 wl_2_neg_rep1 1.6705e-17
ccc_sn_2_3_wl_2_neg_rep1 sn_2_3_neg_rep1 wl_2_neg_rep1 1.071e-17
ccc_sn_3_0_wl_3_neg_rep1 sn_3_0_neg_rep1 wl_3_neg_rep1 1.9664e-17
ccc_sn_3_1_wl_3_neg_rep1 sn_3_1_neg_rep1 wl_3_neg_rep1 1.6705e-17
ccc_sn_3_2_wl_3_neg_rep1 sn_3_2_neg_rep1 wl_3_neg_rep1 1.6705e-17
ccc_sn_3_3_wl_3_neg_rep1 sn_3_3_neg_rep1 wl_3_neg_rep1 1.071e-17
vdw_neg_rep1_0 wl_0_neg_rep1 g_wl_train dc 0
vdr_neg_rep1_0 rwl_0_neg_rep1 vdd dc 0
vdw_neg_rep1_1 wl_1_neg_rep1 0 dc 0
vdr_neg_rep1_1 rwl_1_neg_rep1 vdd dc 0
vdw_neg_rep1_2 wl_2_neg_rep1 0 dc 0
vdr_neg_rep1_2 rwl_2_neg_rep1 vdd dc 0
vdw_neg_rep1_3 wl_3_neg_rep1 0 dc 0
vdr_neg_rep1_3 rwl_3_neg_rep1 vdd dc 0
vdb_neg_rep1_0 bl_0_neg_rep1 0 dc 0
vdp_neg_rep1_0 rbl_0_neg_rep1 vrbl dc 0
vdb_neg_rep1_1 bl_1_neg_rep1 g_hi_train dc 0
vdp_neg_rep1_1 rbl_1_neg_rep1 vrbl dc 0
vdb_neg_rep1_2 bl_2_neg_rep1 0 dc 0
vdp_neg_rep1_2 rbl_2_neg_rep1 vrbl dc 0
vdb_neg_rep1_3 bl_3_neg_rep1 0 dc 0
vdp_neg_rep1_3 rbl_3_neg_rep1 vrbl dc 0

* ---- instance neg_rep0: family rep0 (LEAKY write devices x10) ----
xm1_neg_rep0 sn_0_0__t0_neg_rep0 wl_0__t3_neg_rep0 bl_0__t0_neg_rep0 gnd__t0_neg_rep0 sky130_fd_pr__nfet_01v8 L=0.15 W=4.2 nf=1 ad=1.974 as=1.974 pd=9.34 ps=9.34 mult=1 m=1
xm2_neg_rep0 rbl_0__t0_neg_rep0 sn_0_0__t1_neg_rep0 rwl_0__t0_neg_rep0 gnd__t1_neg_rep0 sky130_fd_pr__nfet_01v8 L=0.15 W=0.42 nf=1 ad=0.1974 as=0.1974 pd=1.78 ps=1.78 mult=1 m=1
xm3_neg_rep0 sn_0_1__t1_neg_rep0 wl_0__t0_neg_rep0 bl_1__t0_neg_rep0 gnd__t2_neg_rep0 sky130_fd_pr__nfet_01v8 L=0.15 W=4.2 nf=1 ad=1.974 as=1.974 pd=9.34 ps=9.34 mult=1 m=1
xm4_neg_rep0 rbl_1__t0_neg_rep0 sn_0_1__t0_neg_rep0 rwl_0__t1_neg_rep0 gnd__t3_neg_rep0 sky130_fd_pr__nfet_01v8 L=0.15 W=0.42 nf=1 ad=0.1974 as=0.1974 pd=1.78 ps=1.78 mult=1 m=1
xm5_neg_rep0 sn_0_2__t1_neg_rep0 wl_0__t1_neg_rep0 bl_2__t0_neg_rep0 gnd__t4_neg_rep0 sky130_fd_pr__nfet_01v8 L=0.15 W=4.2 nf=1 ad=1.974 as=1.974 pd=9.34 ps=9.34 mult=1 m=1
xm6_neg_rep0 rbl_2__t0_neg_rep0 sn_0_2__t0_neg_rep0 rwl_0__t2_neg_rep0 gnd__t5_neg_rep0 sky130_fd_pr__nfet_01v8 L=0.15 W=0.42 nf=1 ad=0.1974 as=0.1974 pd=1.78 ps=1.78 mult=1 m=1
xm7_neg_rep0 sn_0_3__t1_neg_rep0 wl_0__t2_neg_rep0 bl_3__t0_neg_rep0 gnd__t6_neg_rep0 sky130_fd_pr__nfet_01v8 L=0.15 W=4.2 nf=1 ad=1.974 as=1.974 pd=9.34 ps=9.34 mult=1 m=1
xm8_neg_rep0 rbl_3__t0_neg_rep0 sn_0_3__t0_neg_rep0 rwl_0__t3_neg_rep0 gnd__t7_neg_rep0 sky130_fd_pr__nfet_01v8 L=0.15 W=0.42 nf=1 ad=0.1974 as=0.1974 pd=1.78 ps=1.78 mult=1 m=1
xm9_neg_rep0 sn_1_0__t1_neg_rep0 wl_1__t0_neg_rep0 bl_0__t1_neg_rep0 gnd__t8_neg_rep0 sky130_fd_pr__nfet_01v8 L=0.15 W=4.2 nf=1 ad=1.974 as=1.974 pd=9.34 ps=9.34 mult=1 m=1
xm10_neg_rep0 rbl_0__t1_neg_rep0 sn_1_0__t0_neg_rep0 rwl_1__t0_neg_rep0 gnd__t9_neg_rep0 sky130_fd_pr__nfet_01v8 L=0.15 W=0.42 nf=1 ad=0.1974 as=0.1974 pd=1.78 ps=1.78 mult=1 m=1
xm11_neg_rep0 sn_1_1__t1_neg_rep0 wl_1__t1_neg_rep0 bl_1__t1_neg_rep0 gnd__t10_neg_rep0 sky130_fd_pr__nfet_01v8 L=0.15 W=4.2 nf=1 ad=1.974 as=1.974 pd=9.34 ps=9.34 mult=1 m=1
xm12_neg_rep0 rbl_1__t1_neg_rep0 sn_1_1__t0_neg_rep0 rwl_1__t1_neg_rep0 gnd__t11_neg_rep0 sky130_fd_pr__nfet_01v8 L=0.15 W=0.42 nf=1 ad=0.1974 as=0.1974 pd=1.78 ps=1.78 mult=1 m=1
xm13_neg_rep0 sn_1_2__t1_neg_rep0 wl_1__t2_neg_rep0 bl_2__t1_neg_rep0 gnd__t12_neg_rep0 sky130_fd_pr__nfet_01v8 L=0.15 W=4.2 nf=1 ad=1.974 as=1.974 pd=9.34 ps=9.34 mult=1 m=1
xm14_neg_rep0 rbl_2__t1_neg_rep0 sn_1_2__t0_neg_rep0 rwl_1__t2_neg_rep0 gnd__t13_neg_rep0 sky130_fd_pr__nfet_01v8 L=0.15 W=0.42 nf=1 ad=0.1974 as=0.1974 pd=1.78 ps=1.78 mult=1 m=1
xm15_neg_rep0 sn_1_3__t1_neg_rep0 wl_1__t3_neg_rep0 bl_3__t1_neg_rep0 gnd__t14_neg_rep0 sky130_fd_pr__nfet_01v8 L=0.15 W=4.2 nf=1 ad=1.974 as=1.974 pd=9.34 ps=9.34 mult=1 m=1
xm16_neg_rep0 rbl_3__t1_neg_rep0 sn_1_3__t0_neg_rep0 rwl_1__t3_neg_rep0 gnd__t15_neg_rep0 sky130_fd_pr__nfet_01v8 L=0.15 W=0.42 nf=1 ad=0.1974 as=0.1974 pd=1.78 ps=1.78 mult=1 m=1
xm17_neg_rep0 sn_2_0__t1_neg_rep0 wl_2__t3_neg_rep0 bl_0__t3_neg_rep0 gnd__t16_neg_rep0 sky130_fd_pr__nfet_01v8 L=0.15 W=4.2 nf=1 ad=1.974 as=1.974 pd=9.34 ps=9.34 mult=1 m=1
xm18_neg_rep0 rbl_0__t2_neg_rep0 sn_2_0__t0_neg_rep0 rwl_2__t0_neg_rep0 gnd__t17_neg_rep0 sky130_fd_pr__nfet_01v8 L=0.15 W=0.42 nf=1 ad=0.1974 as=0.1974 pd=1.78 ps=1.78 mult=1 m=1
xm19_neg_rep0 sn_2_1__t1_neg_rep0 wl_2__t0_neg_rep0 bl_1__t2_neg_rep0 gnd__t18_neg_rep0 sky130_fd_pr__nfet_01v8 L=0.15 W=4.2 nf=1 ad=1.974 as=1.974 pd=9.34 ps=9.34 mult=1 m=1
xm20_neg_rep0 rbl_1__t2_neg_rep0 sn_2_1__t0_neg_rep0 rwl_2__t1_neg_rep0 gnd__t19_neg_rep0 sky130_fd_pr__nfet_01v8 L=0.15 W=0.42 nf=1 ad=0.1974 as=0.1974 pd=1.78 ps=1.78 mult=1 m=1
xm21_neg_rep0 sn_2_2__t1_neg_rep0 wl_2__t1_neg_rep0 bl_2__t2_neg_rep0 gnd__t20_neg_rep0 sky130_fd_pr__nfet_01v8 L=0.15 W=4.2 nf=1 ad=1.974 as=1.974 pd=9.34 ps=9.34 mult=1 m=1
xm22_neg_rep0 rbl_2__t2_neg_rep0 sn_2_2__t0_neg_rep0 rwl_2__t2_neg_rep0 gnd__t21_neg_rep0 sky130_fd_pr__nfet_01v8 L=0.15 W=0.42 nf=1 ad=0.1974 as=0.1974 pd=1.78 ps=1.78 mult=1 m=1
xm23_neg_rep0 sn_2_3__t1_neg_rep0 wl_2__t2_neg_rep0 bl_3__t2_neg_rep0 gnd__t22_neg_rep0 sky130_fd_pr__nfet_01v8 L=0.15 W=4.2 nf=1 ad=1.974 as=1.974 pd=9.34 ps=9.34 mult=1 m=1
xm24_neg_rep0 rbl_3__t2_neg_rep0 sn_2_3__t0_neg_rep0 rwl_2__t3_neg_rep0 gnd__t23_neg_rep0 sky130_fd_pr__nfet_01v8 L=0.15 W=0.42 nf=1 ad=0.1974 as=0.1974 pd=1.78 ps=1.78 mult=1 m=1
xm25_neg_rep0 sn_3_0__t1_neg_rep0 wl_3__t0_neg_rep0 bl_0__t2_neg_rep0 gnd__t24_neg_rep0 sky130_fd_pr__nfet_01v8 L=0.15 W=4.2 nf=1 ad=1.974 as=1.974 pd=9.34 ps=9.34 mult=1 m=1
xm26_neg_rep0 rbl_0__t3_neg_rep0 sn_3_0__t0_neg_rep0 rwl_3__t0_neg_rep0 gnd__t25_neg_rep0 sky130_fd_pr__nfet_01v8 L=0.15 W=0.42 nf=1 ad=0.1974 as=0.1974 pd=1.78 ps=1.78 mult=1 m=1
xm27_neg_rep0 sn_3_1__t1_neg_rep0 wl_3__t1_neg_rep0 bl_1__t3_neg_rep0 gnd__t26_neg_rep0 sky130_fd_pr__nfet_01v8 L=0.15 W=4.2 nf=1 ad=1.974 as=1.974 pd=9.34 ps=9.34 mult=1 m=1
xm28_neg_rep0 rbl_1__t3_neg_rep0 sn_3_1__t0_neg_rep0 rwl_3__t1_neg_rep0 gnd__t27_neg_rep0 sky130_fd_pr__nfet_01v8 L=0.15 W=0.42 nf=1 ad=0.1974 as=0.1974 pd=1.78 ps=1.78 mult=1 m=1
xm29_neg_rep0 sn_3_2__t1_neg_rep0 wl_3__t2_neg_rep0 bl_2__t3_neg_rep0 gnd__t28_neg_rep0 sky130_fd_pr__nfet_01v8 L=0.15 W=4.2 nf=1 ad=1.974 as=1.974 pd=9.34 ps=9.34 mult=1 m=1
xm30_neg_rep0 rbl_2__t3_neg_rep0 sn_3_2__t0_neg_rep0 rwl_3__t2_neg_rep0 gnd__t29_neg_rep0 sky130_fd_pr__nfet_01v8 L=0.15 W=0.42 nf=1 ad=0.1974 as=0.1974 pd=1.78 ps=1.78 mult=1 m=1
xm31_neg_rep0 sn_3_3__t1_neg_rep0 wl_3__t3_neg_rep0 bl_3__t3_neg_rep0 gnd__t30_neg_rep0 sky130_fd_pr__nfet_01v8 L=0.15 W=4.2 nf=1 ad=1.974 as=1.974 pd=9.34 ps=9.34 mult=1 m=1
xm32_neg_rep0 rbl_3__t3_neg_rep0 sn_3_3__t0_neg_rep0 rwl_3__t3_neg_rep0 gnd__t31_neg_rep0 sky130_fd_pr__nfet_01v8 L=0.15 W=0.42 nf=1 ad=0.1974 as=0.1974 pd=1.78 ps=1.78 mult=1 m=1
rgnd_t0_neg_rep0 gnd__t0_neg_rep0 0 63.3529
rgnd_t1_neg_rep0 gnd__t1_neg_rep0 0 49.0465
rgnd_t2_neg_rep0 gnd__t2_neg_rep0 0 36.5177
rgnd_t3_neg_rep0 gnd__t3_neg_rep0 0 28.2406
rgnd_t4_neg_rep0 gnd__t4_neg_rep0 0 28.2406
rgnd_t5_neg_rep0 gnd__t5_neg_rep0 0 36.5177
rgnd_t6_neg_rep0 gnd__t6_neg_rep0 0 49.0465
rgnd_t7_neg_rep0 gnd__t7_neg_rep0 0 63.3529
rgnd_t8_neg_rep0 gnd__t8_neg_rep0 0 58.0019
rgnd_t9_neg_rep0 gnd__t9_neg_rep0 0 41.907
rgnd_t10_neg_rep0 gnd__t10_neg_rep0 0 26.1568
rgnd_t11_neg_rep0 gnd__t11_neg_rep0 0 12.1726
rgnd_t12_neg_rep0 gnd__t12_neg_rep0 0 12.1726
rgnd_t13_neg_rep0 gnd__t13_neg_rep0 0 26.1568
rgnd_t14_neg_rep0 gnd__t14_neg_rep0 0 41.907
rgnd_t15_neg_rep0 gnd__t15_neg_rep0 0 58.0019
rgnd_t16_neg_rep0 gnd__t16_neg_rep0 0 58.0019
rgnd_t17_neg_rep0 gnd__t17_neg_rep0 0 41.907
rgnd_t18_neg_rep0 gnd__t18_neg_rep0 0 26.1568
rgnd_t19_neg_rep0 gnd__t19_neg_rep0 0 12.1726
rgnd_t20_neg_rep0 gnd__t20_neg_rep0 0 12.1726
rgnd_t21_neg_rep0 gnd__t21_neg_rep0 0 26.1568
rgnd_t22_neg_rep0 gnd__t22_neg_rep0 0 41.907
rgnd_t23_neg_rep0 gnd__t23_neg_rep0 0 58.0019
rgnd_t24_neg_rep0 gnd__t24_neg_rep0 0 63.3529
rgnd_t25_neg_rep0 gnd__t25_neg_rep0 0 49.0465
rgnd_t26_neg_rep0 gnd__t26_neg_rep0 0 36.5177
rgnd_t27_neg_rep0 gnd__t27_neg_rep0 0 28.2406
rgnd_t28_neg_rep0 gnd__t28_neg_rep0 0 28.2406
rgnd_t29_neg_rep0 gnd__t29_neg_rep0 0 36.5177
rgnd_t30_neg_rep0 gnd__t30_neg_rep0 0 49.0465
rgnd_t31_neg_rep0 gnd__t31_neg_rep0 0 63.3529
rbl_0_t0_neg_rep0 bl_0__t0_neg_rep0 bl_0_neg_rep0 144.555
rbl_0_t1_neg_rep0 bl_0__t1_neg_rep0 bl_0_neg_rep0 48.1851
rbl_0_t2_neg_rep0 bl_0__t2_neg_rep0 bl_0_neg_rep0 144.555
rbl_0_t3_neg_rep0 bl_0__t3_neg_rep0 bl_0_neg_rep0 48.1851
rbl_1_t0_neg_rep0 bl_1__t0_neg_rep0 bl_1_neg_rep0 144.555
rbl_1_t1_neg_rep0 bl_1__t1_neg_rep0 bl_1_neg_rep0 48.1851
rbl_1_t2_neg_rep0 bl_1__t2_neg_rep0 bl_1_neg_rep0 48.1851
rbl_1_t3_neg_rep0 bl_1__t3_neg_rep0 bl_1_neg_rep0 144.555
rbl_2_t0_neg_rep0 bl_2__t0_neg_rep0 bl_2_neg_rep0 144.555
rbl_2_t1_neg_rep0 bl_2__t1_neg_rep0 bl_2_neg_rep0 48.1851
rbl_2_t2_neg_rep0 bl_2__t2_neg_rep0 bl_2_neg_rep0 48.1851
rbl_2_t3_neg_rep0 bl_2__t3_neg_rep0 bl_2_neg_rep0 144.555
rbl_3_t0_neg_rep0 bl_3__t0_neg_rep0 bl_3_neg_rep0 144.555
rbl_3_t1_neg_rep0 bl_3__t1_neg_rep0 bl_3_neg_rep0 48.1851
rbl_3_t2_neg_rep0 bl_3__t2_neg_rep0 bl_3_neg_rep0 48.1851
rbl_3_t3_neg_rep0 bl_3__t3_neg_rep0 bl_3_neg_rep0 144.555
rrbl_0_t0_neg_rep0 rbl_0__t0_neg_rep0 rbl_0_neg_rep0 144.555
rrbl_0_t1_neg_rep0 rbl_0__t1_neg_rep0 rbl_0_neg_rep0 48.1851
rrbl_0_t2_neg_rep0 rbl_0__t2_neg_rep0 rbl_0_neg_rep0 48.1851
rrbl_0_t3_neg_rep0 rbl_0__t3_neg_rep0 rbl_0_neg_rep0 144.555
rrbl_1_t0_neg_rep0 rbl_1__t0_neg_rep0 rbl_1_neg_rep0 144.555
rrbl_1_t1_neg_rep0 rbl_1__t1_neg_rep0 rbl_1_neg_rep0 48.1851
rrbl_1_t2_neg_rep0 rbl_1__t2_neg_rep0 rbl_1_neg_rep0 48.1851
rrbl_1_t3_neg_rep0 rbl_1__t3_neg_rep0 rbl_1_neg_rep0 144.555
rrbl_2_t0_neg_rep0 rbl_2__t0_neg_rep0 rbl_2_neg_rep0 144.555
rrbl_2_t1_neg_rep0 rbl_2__t1_neg_rep0 rbl_2_neg_rep0 48.1851
rrbl_2_t2_neg_rep0 rbl_2__t2_neg_rep0 rbl_2_neg_rep0 48.1851
rrbl_2_t3_neg_rep0 rbl_2__t3_neg_rep0 rbl_2_neg_rep0 144.555
rrbl_3_t0_neg_rep0 rbl_3__t0_neg_rep0 rbl_3_neg_rep0 144.555
rrbl_3_t1_neg_rep0 rbl_3__t1_neg_rep0 rbl_3_neg_rep0 48.1851
rrbl_3_t2_neg_rep0 rbl_3__t2_neg_rep0 rbl_3_neg_rep0 48.1851
rrbl_3_t3_neg_rep0 rbl_3__t3_neg_rep0 rbl_3_neg_rep0 144.555
rrwl_0_t0_neg_rep0 rwl_0__t0_neg_rep0 rwl_0_neg_rep0 21.6897
rrwl_0_t1_neg_rep0 rwl_0__t1_neg_rep0 rwl_0_neg_rep0 7.22989
rrwl_0_t2_neg_rep0 rwl_0__t2_neg_rep0 rwl_0_neg_rep0 7.22989
rrwl_0_t3_neg_rep0 rwl_0__t3_neg_rep0 rwl_0_neg_rep0 21.6897
rrwl_1_t0_neg_rep0 rwl_1__t0_neg_rep0 rwl_1_neg_rep0 21.6897
rrwl_1_t1_neg_rep0 rwl_1__t1_neg_rep0 rwl_1_neg_rep0 7.22989
rrwl_1_t2_neg_rep0 rwl_1__t2_neg_rep0 rwl_1_neg_rep0 7.22989
rrwl_1_t3_neg_rep0 rwl_1__t3_neg_rep0 rwl_1_neg_rep0 21.6897
rrwl_2_t0_neg_rep0 rwl_2__t0_neg_rep0 rwl_2_neg_rep0 21.6897
rrwl_2_t1_neg_rep0 rwl_2__t1_neg_rep0 rwl_2_neg_rep0 7.22989
rrwl_2_t2_neg_rep0 rwl_2__t2_neg_rep0 rwl_2_neg_rep0 7.22989
rrwl_2_t3_neg_rep0 rwl_2__t3_neg_rep0 rwl_2_neg_rep0 21.6897
rrwl_3_t0_neg_rep0 rwl_3__t0_neg_rep0 rwl_3_neg_rep0 21.6897
rrwl_3_t1_neg_rep0 rwl_3__t1_neg_rep0 rwl_3_neg_rep0 7.22989
rrwl_3_t2_neg_rep0 rwl_3__t2_neg_rep0 rwl_3_neg_rep0 7.22989
rrwl_3_t3_neg_rep0 rwl_3__t3_neg_rep0 rwl_3_neg_rep0 21.6897
rsn_0_0_t0_neg_rep0 sn_0_0__t0_neg_rep0 sn_0_0_neg_rep0 125.123
rsn_0_0_t1_neg_rep0 sn_0_0__t1_neg_rep0 sn_0_0_neg_rep0 125.123
rsn_0_1_t0_neg_rep0 sn_0_1__t0_neg_rep0 sn_0_1_neg_rep0 125.123
rsn_0_1_t1_neg_rep0 sn_0_1__t1_neg_rep0 sn_0_1_neg_rep0 125.123
rsn_0_2_t0_neg_rep0 sn_0_2__t0_neg_rep0 sn_0_2_neg_rep0 125.123
rsn_0_2_t1_neg_rep0 sn_0_2__t1_neg_rep0 sn_0_2_neg_rep0 125.123
rsn_0_3_t0_neg_rep0 sn_0_3__t0_neg_rep0 sn_0_3_neg_rep0 125.123
rsn_0_3_t1_neg_rep0 sn_0_3__t1_neg_rep0 sn_0_3_neg_rep0 125.123
rsn_1_0_t0_neg_rep0 sn_1_0__t0_neg_rep0 sn_1_0_neg_rep0 125.123
rsn_1_0_t1_neg_rep0 sn_1_0__t1_neg_rep0 sn_1_0_neg_rep0 125.123
rsn_1_1_t0_neg_rep0 sn_1_1__t0_neg_rep0 sn_1_1_neg_rep0 125.123
rsn_1_1_t1_neg_rep0 sn_1_1__t1_neg_rep0 sn_1_1_neg_rep0 125.123
rsn_1_2_t0_neg_rep0 sn_1_2__t0_neg_rep0 sn_1_2_neg_rep0 125.123
rsn_1_2_t1_neg_rep0 sn_1_2__t1_neg_rep0 sn_1_2_neg_rep0 125.123
rsn_1_3_t0_neg_rep0 sn_1_3__t0_neg_rep0 sn_1_3_neg_rep0 125.123
rsn_1_3_t1_neg_rep0 sn_1_3__t1_neg_rep0 sn_1_3_neg_rep0 125.123
rsn_2_0_t0_neg_rep0 sn_2_0__t0_neg_rep0 sn_2_0_neg_rep0 125.123
rsn_2_0_t1_neg_rep0 sn_2_0__t1_neg_rep0 sn_2_0_neg_rep0 125.123
rsn_2_1_t0_neg_rep0 sn_2_1__t0_neg_rep0 sn_2_1_neg_rep0 125.123
rsn_2_1_t1_neg_rep0 sn_2_1__t1_neg_rep0 sn_2_1_neg_rep0 125.123
rsn_2_2_t0_neg_rep0 sn_2_2__t0_neg_rep0 sn_2_2_neg_rep0 125.123
rsn_2_2_t1_neg_rep0 sn_2_2__t1_neg_rep0 sn_2_2_neg_rep0 125.123
rsn_2_3_t0_neg_rep0 sn_2_3__t0_neg_rep0 sn_2_3_neg_rep0 125.123
rsn_2_3_t1_neg_rep0 sn_2_3__t1_neg_rep0 sn_2_3_neg_rep0 125.123
rsn_3_0_t0_neg_rep0 sn_3_0__t0_neg_rep0 sn_3_0_neg_rep0 125.123
rsn_3_0_t1_neg_rep0 sn_3_0__t1_neg_rep0 sn_3_0_neg_rep0 125.123
rsn_3_1_t0_neg_rep0 sn_3_1__t0_neg_rep0 sn_3_1_neg_rep0 125.123
rsn_3_1_t1_neg_rep0 sn_3_1__t1_neg_rep0 sn_3_1_neg_rep0 125.123
rsn_3_2_t0_neg_rep0 sn_3_2__t0_neg_rep0 sn_3_2_neg_rep0 125.123
rsn_3_2_t1_neg_rep0 sn_3_2__t1_neg_rep0 sn_3_2_neg_rep0 125.123
rsn_3_3_t0_neg_rep0 sn_3_3__t0_neg_rep0 sn_3_3_neg_rep0 125.123
rsn_3_3_t1_neg_rep0 sn_3_3__t1_neg_rep0 sn_3_3_neg_rep0 125.123
rwl_0_t0_neg_rep0 wl_0__t0_neg_rep0 wl_0_neg_rep0 54.2844
rwl_0_t1_neg_rep0 wl_0__t1_neg_rep0 wl_0_neg_rep0 54.2844
rwl_0_t2_neg_rep0 wl_0__t2_neg_rep0 wl_0_neg_rep0 162.853
rwl_0_t3_neg_rep0 wl_0__t3_neg_rep0 wl_0_neg_rep0 162.853
rwl_1_t0_neg_rep0 wl_1__t0_neg_rep0 wl_1_neg_rep0 162.853
rwl_1_t1_neg_rep0 wl_1__t1_neg_rep0 wl_1_neg_rep0 54.2844
rwl_1_t2_neg_rep0 wl_1__t2_neg_rep0 wl_1_neg_rep0 54.2844
rwl_1_t3_neg_rep0 wl_1__t3_neg_rep0 wl_1_neg_rep0 162.853
rwl_2_t0_neg_rep0 wl_2__t0_neg_rep0 wl_2_neg_rep0 54.2844
rwl_2_t1_neg_rep0 wl_2__t1_neg_rep0 wl_2_neg_rep0 54.2844
rwl_2_t2_neg_rep0 wl_2__t2_neg_rep0 wl_2_neg_rep0 162.853
rwl_2_t3_neg_rep0 wl_2__t3_neg_rep0 wl_2_neg_rep0 162.853
rwl_3_t0_neg_rep0 wl_3__t0_neg_rep0 wl_3_neg_rep0 162.853
rwl_3_t1_neg_rep0 wl_3__t1_neg_rep0 wl_3_neg_rep0 54.2844
rwl_3_t2_neg_rep0 wl_3__t2_neg_rep0 wl_3_neg_rep0 54.2844
rwl_3_t3_neg_rep0 wl_3__t3_neg_rep0 wl_3_neg_rep0 162.853
cgnd_neg_rep0 0 0 4.09475e-15
cbl_0_neg_rep0 bl_0_neg_rep0 0 5.96076e-16
cbl_1_neg_rep0 bl_1_neg_rep0 0 5.81168e-16
cbl_2_neg_rep0 bl_2_neg_rep0 0 5.81168e-16
cbl_3_neg_rep0 bl_3_neg_rep0 0 5.81168e-16
crbl_0_neg_rep0 rbl_0_neg_rep0 0 5.81168e-16
crbl_1_neg_rep0 rbl_1_neg_rep0 0 5.81168e-16
crbl_2_neg_rep0 rbl_2_neg_rep0 0 5.81168e-16
crbl_3_neg_rep0 rbl_3_neg_rep0 0 5.96076e-16
crwl_0_neg_rep0 rwl_0_neg_rep0 0 1.18713e-15
crwl_1_neg_rep0 rwl_1_neg_rep0 0 1.18713e-15
crwl_2_neg_rep0 rwl_2_neg_rep0 0 1.18713e-15
crwl_3_neg_rep0 rwl_3_neg_rep0 0 1.18713e-15
csn_0_0_neg_rep0 sn_0_0_neg_rep0 0 4.33689e-16
csn_0_1_neg_rep0 sn_0_1_neg_rep0 0 4.30576e-16
csn_0_2_neg_rep0 sn_0_2_neg_rep0 0 4.30576e-16
csn_0_3_neg_rep0 sn_0_3_neg_rep0 0 4.32518e-16
csn_1_0_neg_rep0 sn_1_0_neg_rep0 0 4.33689e-16
csn_1_1_neg_rep0 sn_1_1_neg_rep0 0 4.30576e-16
csn_1_2_neg_rep0 sn_1_2_neg_rep0 0 4.30576e-16
csn_1_3_neg_rep0 sn_1_3_neg_rep0 0 4.32518e-16
csn_2_0_neg_rep0 sn_2_0_neg_rep0 0 4.33689e-16
csn_2_1_neg_rep0 sn_2_1_neg_rep0 0 4.30576e-16
csn_2_2_neg_rep0 sn_2_2_neg_rep0 0 4.30576e-16
csn_2_3_neg_rep0 sn_2_3_neg_rep0 0 4.32518e-16
csn_3_0_neg_rep0 sn_3_0_neg_rep0 0 4.33689e-16
csn_3_1_neg_rep0 sn_3_1_neg_rep0 0 4.30576e-16
csn_3_2_neg_rep0 sn_3_2_neg_rep0 0 4.30576e-16
csn_3_3_neg_rep0 sn_3_3_neg_rep0 0 4.32518e-16
cwl_0_neg_rep0 wl_0_neg_rep0 0 1.90928e-15
cwl_1_neg_rep0 wl_1_neg_rep0 0 1.90928e-15
cwl_2_neg_rep0 wl_2_neg_rep0 0 1.90928e-15
cwl_3_neg_rep0 wl_3_neg_rep0 0 1.91375e-15
ccc_bl_0_sn_0_0_neg_rep0 bl_0_neg_rep0 sn_0_0_neg_rep0 1.071e-17
ccc_bl_0_sn_1_0_neg_rep0 bl_0_neg_rep0 sn_1_0_neg_rep0 1.071e-17
ccc_bl_0_sn_2_0_neg_rep0 bl_0_neg_rep0 sn_2_0_neg_rep0 1.071e-17
ccc_bl_0_sn_3_0_neg_rep0 bl_0_neg_rep0 sn_3_0_neg_rep0 1.071e-17
ccc_bl_0_wl_0_neg_rep0 bl_0_neg_rep0 wl_0_neg_rep0 2.4327e-17
ccc_bl_0_wl_1_neg_rep0 bl_0_neg_rep0 wl_1_neg_rep0 2.4327e-17
ccc_bl_0_wl_2_neg_rep0 bl_0_neg_rep0 wl_2_neg_rep0 2.4327e-17
ccc_bl_1_rbl_0_neg_rep0 bl_1_neg_rep0 rbl_0_neg_rep0 1.29795e-16
ccc_bl_1_rwl_0_neg_rep0 bl_1_neg_rep0 rwl_0_neg_rep0 9.028e-18
ccc_bl_1_rwl_1_neg_rep0 bl_1_neg_rep0 rwl_1_neg_rep0 9.028e-18
ccc_bl_1_rwl_2_neg_rep0 bl_1_neg_rep0 rwl_2_neg_rep0 9.028e-18
ccc_bl_1_rwl_3_neg_rep0 bl_1_neg_rep0 rwl_3_neg_rep0 9.028e-18
ccc_bl_1_sn_0_1_neg_rep0 bl_1_neg_rep0 sn_0_1_neg_rep0 1.071e-17
ccc_bl_1_sn_1_1_neg_rep0 bl_1_neg_rep0 sn_1_1_neg_rep0 1.071e-17
ccc_bl_1_sn_2_1_neg_rep0 bl_1_neg_rep0 sn_2_1_neg_rep0 1.071e-17
ccc_bl_1_sn_3_1_neg_rep0 bl_1_neg_rep0 sn_3_1_neg_rep0 1.071e-17
ccc_bl_1_wl_0_neg_rep0 bl_1_neg_rep0 wl_0_neg_rep0 2.7627e-17
ccc_bl_1_wl_1_neg_rep0 bl_1_neg_rep0 wl_1_neg_rep0 2.7627e-17
ccc_bl_1_wl_2_neg_rep0 bl_1_neg_rep0 wl_2_neg_rep0 2.7627e-17
ccc_bl_2_rbl_1_neg_rep0 bl_2_neg_rep0 rbl_1_neg_rep0 1.29795e-16
ccc_bl_2_rwl_0_neg_rep0 bl_2_neg_rep0 rwl_0_neg_rep0 9.028e-18
ccc_bl_2_rwl_1_neg_rep0 bl_2_neg_rep0 rwl_1_neg_rep0 9.028e-18
ccc_bl_2_rwl_2_neg_rep0 bl_2_neg_rep0 rwl_2_neg_rep0 9.028e-18
ccc_bl_2_rwl_3_neg_rep0 bl_2_neg_rep0 rwl_3_neg_rep0 9.028e-18
ccc_bl_2_sn_0_2_neg_rep0 bl_2_neg_rep0 sn_0_2_neg_rep0 1.071e-17
ccc_bl_2_sn_1_2_neg_rep0 bl_2_neg_rep0 sn_1_2_neg_rep0 1.071e-17
ccc_bl_2_sn_2_2_neg_rep0 bl_2_neg_rep0 sn_2_2_neg_rep0 1.071e-17
ccc_bl_2_sn_3_2_neg_rep0 bl_2_neg_rep0 sn_3_2_neg_rep0 1.071e-17
ccc_bl_2_wl_0_neg_rep0 bl_2_neg_rep0 wl_0_neg_rep0 2.7627e-17
ccc_bl_2_wl_1_neg_rep0 bl_2_neg_rep0 wl_1_neg_rep0 2.7627e-17
ccc_bl_2_wl_2_neg_rep0 bl_2_neg_rep0 wl_2_neg_rep0 2.7627e-17
ccc_bl_3_rbl_2_neg_rep0 bl_3_neg_rep0 rbl_2_neg_rep0 1.29795e-16
ccc_bl_3_rwl_0_neg_rep0 bl_3_neg_rep0 rwl_0_neg_rep0 9.028e-18
ccc_bl_3_rwl_1_neg_rep0 bl_3_neg_rep0 rwl_1_neg_rep0 9.028e-18
ccc_bl_3_rwl_2_neg_rep0 bl_3_neg_rep0 rwl_2_neg_rep0 9.028e-18
ccc_bl_3_rwl_3_neg_rep0 bl_3_neg_rep0 rwl_3_neg_rep0 9.028e-18
ccc_bl_3_sn_0_3_neg_rep0 bl_3_neg_rep0 sn_0_3_neg_rep0 1.071e-17
ccc_bl_3_sn_1_3_neg_rep0 bl_3_neg_rep0 sn_1_3_neg_rep0 1.071e-17
ccc_bl_3_sn_2_3_neg_rep0 bl_3_neg_rep0 sn_2_3_neg_rep0 1.071e-17
ccc_bl_3_sn_3_3_neg_rep0 bl_3_neg_rep0 sn_3_3_neg_rep0 1.071e-17
ccc_bl_3_wl_0_neg_rep0 bl_3_neg_rep0 wl_0_neg_rep0 2.7627e-17
ccc_bl_3_wl_1_neg_rep0 bl_3_neg_rep0 wl_1_neg_rep0 2.7627e-17
ccc_bl_3_wl_2_neg_rep0 bl_3_neg_rep0 wl_2_neg_rep0 2.7627e-17
ccc_rbl_0_rwl_0_neg_rep0 rbl_0_neg_rep0 rwl_0_neg_rep0 1.9738e-17
ccc_rbl_0_rwl_1_neg_rep0 rbl_0_neg_rep0 rwl_1_neg_rep0 1.9738e-17
ccc_rbl_0_rwl_2_neg_rep0 rbl_0_neg_rep0 rwl_2_neg_rep0 1.9738e-17
ccc_rbl_0_rwl_3_neg_rep0 rbl_0_neg_rep0 rwl_3_neg_rep0 1.9738e-17
ccc_rbl_0_sn_0_0_neg_rep0 rbl_0_neg_rep0 sn_0_0_neg_rep0 1.071e-17
ccc_rbl_0_sn_1_0_neg_rep0 rbl_0_neg_rep0 sn_1_0_neg_rep0 2.4327e-17
ccc_rbl_0_sn_2_0_neg_rep0 rbl_0_neg_rep0 sn_2_0_neg_rep0 2.4327e-17
ccc_rbl_0_wl_0_neg_rep0 rbl_0_neg_rep0 wl_0_neg_rep0 3.3e-18
ccc_rbl_0_wl_1_neg_rep0 rbl_0_neg_rep0 wl_1_neg_rep0 3.3e-18
ccc_rbl_0_wl_2_neg_rep0 rbl_0_neg_rep0 wl_2_neg_rep0 3.3e-18
ccc_rbl_1_rwl_0_neg_rep0 rbl_1_neg_rep0 rwl_0_neg_rep0 1.9738e-17
ccc_rbl_1_rwl_1_neg_rep0 rbl_1_neg_rep0 rwl_1_neg_rep0 1.9738e-17
ccc_rbl_1_rwl_2_neg_rep0 rbl_1_neg_rep0 rwl_2_neg_rep0 1.9738e-17
ccc_rbl_1_rwl_3_neg_rep0 rbl_1_neg_rep0 rwl_3_neg_rep0 1.9738e-17
ccc_rbl_1_sn_0_1_neg_rep0 rbl_1_neg_rep0 sn_0_1_neg_rep0 1.071e-17
ccc_rbl_1_sn_1_1_neg_rep0 rbl_1_neg_rep0 sn_1_1_neg_rep0 2.4327e-17
ccc_rbl_1_sn_2_1_neg_rep0 rbl_1_neg_rep0 sn_2_1_neg_rep0 2.4327e-17
ccc_rbl_1_wl_0_neg_rep0 rbl_1_neg_rep0 wl_0_neg_rep0 3.3e-18
ccc_rbl_1_wl_1_neg_rep0 rbl_1_neg_rep0 wl_1_neg_rep0 3.3e-18
ccc_rbl_1_wl_2_neg_rep0 rbl_1_neg_rep0 wl_2_neg_rep0 3.3e-18
ccc_rbl_2_rwl_0_neg_rep0 rbl_2_neg_rep0 rwl_0_neg_rep0 1.9738e-17
ccc_rbl_2_rwl_1_neg_rep0 rbl_2_neg_rep0 rwl_1_neg_rep0 1.9738e-17
ccc_rbl_2_rwl_2_neg_rep0 rbl_2_neg_rep0 rwl_2_neg_rep0 1.9738e-17
ccc_rbl_2_rwl_3_neg_rep0 rbl_2_neg_rep0 rwl_3_neg_rep0 1.9738e-17
ccc_rbl_2_sn_0_2_neg_rep0 rbl_2_neg_rep0 sn_0_2_neg_rep0 1.071e-17
ccc_rbl_2_sn_1_2_neg_rep0 rbl_2_neg_rep0 sn_1_2_neg_rep0 2.4327e-17
ccc_rbl_2_sn_2_2_neg_rep0 rbl_2_neg_rep0 sn_2_2_neg_rep0 2.4327e-17
ccc_rbl_2_wl_0_neg_rep0 rbl_2_neg_rep0 wl_0_neg_rep0 3.3e-18
ccc_rbl_2_wl_1_neg_rep0 rbl_2_neg_rep0 wl_1_neg_rep0 3.3e-18
ccc_rbl_2_wl_2_neg_rep0 rbl_2_neg_rep0 wl_2_neg_rep0 3.3e-18
ccc_rbl_3_rwl_0_neg_rep0 rbl_3_neg_rep0 rwl_0_neg_rep0 1.071e-17
ccc_rbl_3_rwl_1_neg_rep0 rbl_3_neg_rep0 rwl_1_neg_rep0 1.071e-17
ccc_rbl_3_rwl_2_neg_rep0 rbl_3_neg_rep0 rwl_2_neg_rep0 1.071e-17
ccc_rbl_3_rwl_3_neg_rep0 rbl_3_neg_rep0 rwl_3_neg_rep0 1.071e-17
ccc_rbl_3_sn_0_3_neg_rep0 rbl_3_neg_rep0 sn_0_3_neg_rep0 1.071e-17
ccc_rbl_3_sn_1_3_neg_rep0 rbl_3_neg_rep0 sn_1_3_neg_rep0 2.4327e-17
ccc_rbl_3_sn_2_3_neg_rep0 rbl_3_neg_rep0 sn_2_3_neg_rep0 2.4327e-17
ccc_rwl_0_sn_0_0_neg_rep0 rwl_0_neg_rep0 sn_0_0_neg_rep0 1.0072e-17
ccc_rwl_0_sn_0_1_neg_rep0 rwl_0_neg_rep0 sn_0_1_neg_rep0 1.9682e-17
ccc_rwl_0_sn_0_2_neg_rep0 rwl_0_neg_rep0 sn_0_2_neg_rep0 1.9682e-17
ccc_rwl_0_sn_0_3_neg_rep0 rwl_0_neg_rep0 sn_0_3_neg_rep0 1.9682e-17
ccc_rwl_1_sn_1_0_neg_rep0 rwl_1_neg_rep0 sn_1_0_neg_rep0 1.0072e-17
ccc_rwl_1_sn_1_1_neg_rep0 rwl_1_neg_rep0 sn_1_1_neg_rep0 1.9682e-17
ccc_rwl_1_sn_1_2_neg_rep0 rwl_1_neg_rep0 sn_1_2_neg_rep0 1.9682e-17
ccc_rwl_1_sn_1_3_neg_rep0 rwl_1_neg_rep0 sn_1_3_neg_rep0 1.9682e-17
ccc_rwl_2_sn_2_0_neg_rep0 rwl_2_neg_rep0 sn_2_0_neg_rep0 1.0072e-17
ccc_rwl_2_sn_2_1_neg_rep0 rwl_2_neg_rep0 sn_2_1_neg_rep0 1.9682e-17
ccc_rwl_2_sn_2_2_neg_rep0 rwl_2_neg_rep0 sn_2_2_neg_rep0 1.9682e-17
ccc_rwl_2_sn_2_3_neg_rep0 rwl_2_neg_rep0 sn_2_3_neg_rep0 1.9682e-17
ccc_rwl_3_sn_3_0_neg_rep0 rwl_3_neg_rep0 sn_3_0_neg_rep0 1.0072e-17
ccc_rwl_3_sn_3_1_neg_rep0 rwl_3_neg_rep0 sn_3_1_neg_rep0 1.9682e-17
ccc_rwl_3_sn_3_2_neg_rep0 rwl_3_neg_rep0 sn_3_2_neg_rep0 1.9682e-17
ccc_rwl_3_sn_3_3_neg_rep0 rwl_3_neg_rep0 sn_3_3_neg_rep0 1.9682e-17
ccc_sn_0_0_wl_0_neg_rep0 sn_0_0_neg_rep0 wl_0_neg_rep0 1.9664e-17
ccc_sn_0_1_wl_0_neg_rep0 sn_0_1_neg_rep0 wl_0_neg_rep0 1.9664e-17
ccc_sn_0_2_wl_0_neg_rep0 sn_0_2_neg_rep0 wl_0_neg_rep0 1.9664e-17
ccc_sn_0_3_wl_0_neg_rep0 sn_0_3_neg_rep0 wl_0_neg_rep0 1.3668e-17
ccc_sn_1_0_wl_1_neg_rep0 sn_1_0_neg_rep0 wl_1_neg_rep0 1.9664e-17
ccc_sn_1_1_wl_1_neg_rep0 sn_1_1_neg_rep0 wl_1_neg_rep0 1.6705e-17
ccc_sn_1_2_wl_1_neg_rep0 sn_1_2_neg_rep0 wl_1_neg_rep0 1.6705e-17
ccc_sn_1_3_wl_1_neg_rep0 sn_1_3_neg_rep0 wl_1_neg_rep0 1.071e-17
ccc_sn_2_0_wl_2_neg_rep0 sn_2_0_neg_rep0 wl_2_neg_rep0 1.9664e-17
ccc_sn_2_1_wl_2_neg_rep0 sn_2_1_neg_rep0 wl_2_neg_rep0 1.6705e-17
ccc_sn_2_2_wl_2_neg_rep0 sn_2_2_neg_rep0 wl_2_neg_rep0 1.6705e-17
ccc_sn_2_3_wl_2_neg_rep0 sn_2_3_neg_rep0 wl_2_neg_rep0 1.071e-17
ccc_sn_3_0_wl_3_neg_rep0 sn_3_0_neg_rep0 wl_3_neg_rep0 1.9664e-17
ccc_sn_3_1_wl_3_neg_rep0 sn_3_1_neg_rep0 wl_3_neg_rep0 1.6705e-17
ccc_sn_3_2_wl_3_neg_rep0 sn_3_2_neg_rep0 wl_3_neg_rep0 1.6705e-17
ccc_sn_3_3_wl_3_neg_rep0 sn_3_3_neg_rep0 wl_3_neg_rep0 1.071e-17
vdw_neg_rep0_0 wl_0_neg_rep0 g_wl_train dc 0
vdr_neg_rep0_0 rwl_0_neg_rep0 vdd dc 0
vdw_neg_rep0_1 wl_1_neg_rep0 0 dc 0
vdr_neg_rep0_1 rwl_1_neg_rep0 vdd dc 0
vdw_neg_rep0_2 wl_2_neg_rep0 0 dc 0
vdr_neg_rep0_2 rwl_2_neg_rep0 vdd dc 0
vdw_neg_rep0_3 wl_3_neg_rep0 0 dc 0
vdr_neg_rep0_3 rwl_3_neg_rep0 vdd dc 0
vdb_neg_rep0_0 bl_0_neg_rep0 vdd dc 0
vdp_neg_rep0_0 rbl_0_neg_rep0 vrbl dc 0
vdb_neg_rep0_1 bl_1_neg_rep0 g_lo_train dc 0
vdp_neg_rep0_1 rbl_1_neg_rep0 vrbl dc 0
vdb_neg_rep0_2 bl_2_neg_rep0 vdd dc 0
vdp_neg_rep0_2 rbl_2_neg_rep0 vrbl dc 0
vdb_neg_rep0_3 bl_3_neg_rep0 vdd dc 0
vdp_neg_rep0_3 rbl_3_neg_rep0 vrbl dc 0

* initial conditions (tran uic): stored levels, driven nets at their idle level
.ic v(bl_0__t0_ctl0)=0 v(bl_0__t1_ctl0)=0 v(bl_0__t2_ctl0)=0 v(bl_0__t3_ctl0)=0
.ic v(bl_1__t0_ctl0)=0 v(bl_1__t1_ctl0)=0 v(bl_1__t2_ctl0)=0 v(bl_1__t3_ctl0)=0
.ic v(bl_2__t0_ctl0)=0 v(bl_2__t1_ctl0)=0 v(bl_2__t2_ctl0)=0 v(bl_2__t3_ctl0)=0
.ic v(bl_3__t0_ctl0)=0 v(bl_3__t1_ctl0)=0 v(bl_3__t2_ctl0)=0 v(bl_3__t3_ctl0)=0
.ic v(rbl_0__t0_ctl0)=0.9 v(rbl_0__t1_ctl0)=0.9 v(rbl_0__t2_ctl0)=0.9 v(rbl_0__t3_ctl0)=0.9
.ic v(rbl_1__t0_ctl0)=0.9 v(rbl_1__t1_ctl0)=0.9 v(rbl_1__t2_ctl0)=0.9 v(rbl_1__t3_ctl0)=0.9
.ic v(rbl_2__t0_ctl0)=0.9 v(rbl_2__t1_ctl0)=0.9 v(rbl_2__t2_ctl0)=0.9 v(rbl_2__t3_ctl0)=0.9
.ic v(rbl_3__t0_ctl0)=0.9 v(rbl_3__t1_ctl0)=0.9 v(rbl_3__t2_ctl0)=0.9 v(rbl_3__t3_ctl0)=0.9
.ic v(rwl_0__t0_ctl0)=1.8 v(rwl_0__t1_ctl0)=1.8 v(rwl_0__t2_ctl0)=1.8 v(rwl_0__t3_ctl0)=1.8
.ic v(rwl_1__t0_ctl0)=1.8 v(rwl_1__t1_ctl0)=1.8 v(rwl_1__t2_ctl0)=1.8 v(rwl_1__t3_ctl0)=1.8
.ic v(rwl_2__t0_ctl0)=1.8 v(rwl_2__t1_ctl0)=1.8 v(rwl_2__t2_ctl0)=1.8 v(rwl_2__t3_ctl0)=1.8
.ic v(rwl_3__t0_ctl0)=1.8 v(rwl_3__t1_ctl0)=1.8 v(rwl_3__t2_ctl0)=1.8 v(rwl_3__t3_ctl0)=1.8
.ic v(sn_0_0_ctl0)=0 v(sn_0_0__t0_ctl0)=0 v(sn_0_0__t1_ctl0)=0 v(sn_0_1_ctl0)=0
.ic v(sn_0_1__t0_ctl0)=0 v(sn_0_1__t1_ctl0)=0 v(sn_0_2_ctl0)=0 v(sn_0_2__t0_ctl0)=0
.ic v(sn_0_2__t1_ctl0)=0 v(sn_0_3_ctl0)=0 v(sn_0_3__t0_ctl0)=0 v(sn_0_3__t1_ctl0)=0
.ic v(sn_1_0_ctl0)=1 v(sn_1_0__t0_ctl0)=1 v(sn_1_0__t1_ctl0)=1 v(sn_1_1_ctl0)=1
.ic v(sn_1_1__t0_ctl0)=1 v(sn_1_1__t1_ctl0)=1 v(sn_1_2_ctl0)=1 v(sn_1_2__t0_ctl0)=1
.ic v(sn_1_2__t1_ctl0)=1 v(sn_1_3_ctl0)=1 v(sn_1_3__t0_ctl0)=1 v(sn_1_3__t1_ctl0)=1
.ic v(sn_2_0_ctl0)=0 v(sn_2_0__t0_ctl0)=0 v(sn_2_0__t1_ctl0)=0 v(sn_2_1_ctl0)=0
.ic v(sn_2_1__t0_ctl0)=0 v(sn_2_1__t1_ctl0)=0 v(sn_2_2_ctl0)=0 v(sn_2_2__t0_ctl0)=0
.ic v(sn_2_2__t1_ctl0)=0 v(sn_2_3_ctl0)=0 v(sn_2_3__t0_ctl0)=0 v(sn_2_3__t1_ctl0)=0
.ic v(sn_3_0_ctl0)=1 v(sn_3_0__t0_ctl0)=1 v(sn_3_0__t1_ctl0)=1 v(sn_3_1_ctl0)=1
.ic v(sn_3_1__t0_ctl0)=1 v(sn_3_1__t1_ctl0)=1 v(sn_3_2_ctl0)=1 v(sn_3_2__t0_ctl0)=1
.ic v(sn_3_2__t1_ctl0)=1 v(sn_3_3_ctl0)=1 v(sn_3_3__t0_ctl0)=1 v(sn_3_3__t1_ctl0)=1
.ic v(wl_0__t0_ctl0)=0 v(wl_0__t1_ctl0)=0 v(wl_0__t2_ctl0)=0 v(wl_0__t3_ctl0)=0
.ic v(wl_1__t0_ctl0)=0 v(wl_1__t1_ctl0)=0 v(wl_1__t2_ctl0)=0 v(wl_1__t3_ctl0)=0
.ic v(wl_2__t0_ctl0)=0 v(wl_2__t1_ctl0)=0 v(wl_2__t2_ctl0)=0 v(wl_2__t3_ctl0)=0
.ic v(wl_3__t0_ctl0)=0 v(wl_3__t1_ctl0)=0 v(wl_3__t2_ctl0)=0 v(wl_3__t3_ctl0)=0
.ic v(bl_0__t0_ctl1)=1.8 v(bl_0__t1_ctl1)=1.8 v(bl_0__t2_ctl1)=1.8 v(bl_0__t3_ctl1)=1.8
.ic v(bl_1__t0_ctl1)=1.8 v(bl_1__t1_ctl1)=1.8 v(bl_1__t2_ctl1)=1.8 v(bl_1__t3_ctl1)=1.8
.ic v(bl_2__t0_ctl1)=1.8 v(bl_2__t1_ctl1)=1.8 v(bl_2__t2_ctl1)=1.8 v(bl_2__t3_ctl1)=1.8
.ic v(bl_3__t0_ctl1)=1.8 v(bl_3__t1_ctl1)=1.8 v(bl_3__t2_ctl1)=1.8 v(bl_3__t3_ctl1)=1.8
.ic v(rbl_0__t0_ctl1)=0.9 v(rbl_0__t1_ctl1)=0.9 v(rbl_0__t2_ctl1)=0.9 v(rbl_0__t3_ctl1)=0.9
.ic v(rbl_1__t0_ctl1)=0.9 v(rbl_1__t1_ctl1)=0.9 v(rbl_1__t2_ctl1)=0.9 v(rbl_1__t3_ctl1)=0.9
.ic v(rbl_2__t0_ctl1)=0.9 v(rbl_2__t1_ctl1)=0.9 v(rbl_2__t2_ctl1)=0.9 v(rbl_2__t3_ctl1)=0.9
.ic v(rbl_3__t0_ctl1)=0.9 v(rbl_3__t1_ctl1)=0.9 v(rbl_3__t2_ctl1)=0.9 v(rbl_3__t3_ctl1)=0.9
.ic v(rwl_0__t0_ctl1)=1.8 v(rwl_0__t1_ctl1)=1.8 v(rwl_0__t2_ctl1)=1.8 v(rwl_0__t3_ctl1)=1.8
.ic v(rwl_1__t0_ctl1)=1.8 v(rwl_1__t1_ctl1)=1.8 v(rwl_1__t2_ctl1)=1.8 v(rwl_1__t3_ctl1)=1.8
.ic v(rwl_2__t0_ctl1)=1.8 v(rwl_2__t1_ctl1)=1.8 v(rwl_2__t2_ctl1)=1.8 v(rwl_2__t3_ctl1)=1.8
.ic v(rwl_3__t0_ctl1)=1.8 v(rwl_3__t1_ctl1)=1.8 v(rwl_3__t2_ctl1)=1.8 v(rwl_3__t3_ctl1)=1.8
.ic v(sn_0_0_ctl1)=1 v(sn_0_0__t0_ctl1)=1 v(sn_0_0__t1_ctl1)=1 v(sn_0_1_ctl1)=1
.ic v(sn_0_1__t0_ctl1)=1 v(sn_0_1__t1_ctl1)=1 v(sn_0_2_ctl1)=1 v(sn_0_2__t0_ctl1)=1
.ic v(sn_0_2__t1_ctl1)=1 v(sn_0_3_ctl1)=1 v(sn_0_3__t0_ctl1)=1 v(sn_0_3__t1_ctl1)=1
.ic v(sn_1_0_ctl1)=1 v(sn_1_0__t0_ctl1)=1 v(sn_1_0__t1_ctl1)=1 v(sn_1_1_ctl1)=1
.ic v(sn_1_1__t0_ctl1)=1 v(sn_1_1__t1_ctl1)=1 v(sn_1_2_ctl1)=1 v(sn_1_2__t0_ctl1)=1
.ic v(sn_1_2__t1_ctl1)=1 v(sn_1_3_ctl1)=1 v(sn_1_3__t0_ctl1)=1 v(sn_1_3__t1_ctl1)=1
.ic v(sn_2_0_ctl1)=0 v(sn_2_0__t0_ctl1)=0 v(sn_2_0__t1_ctl1)=0 v(sn_2_1_ctl1)=0
.ic v(sn_2_1__t0_ctl1)=0 v(sn_2_1__t1_ctl1)=0 v(sn_2_2_ctl1)=0 v(sn_2_2__t0_ctl1)=0
.ic v(sn_2_2__t1_ctl1)=0 v(sn_2_3_ctl1)=0 v(sn_2_3__t0_ctl1)=0 v(sn_2_3__t1_ctl1)=0
.ic v(sn_3_0_ctl1)=1 v(sn_3_0__t0_ctl1)=1 v(sn_3_0__t1_ctl1)=1 v(sn_3_1_ctl1)=1
.ic v(sn_3_1__t0_ctl1)=1 v(sn_3_1__t1_ctl1)=1 v(sn_3_2_ctl1)=1 v(sn_3_2__t0_ctl1)=1
.ic v(sn_3_2__t1_ctl1)=1 v(sn_3_3_ctl1)=1 v(sn_3_3__t0_ctl1)=1 v(sn_3_3__t1_ctl1)=1
.ic v(wl_0__t0_ctl1)=0 v(wl_0__t1_ctl1)=0 v(wl_0__t2_ctl1)=0 v(wl_0__t3_ctl1)=0
.ic v(wl_1__t0_ctl1)=0 v(wl_1__t1_ctl1)=0 v(wl_1__t2_ctl1)=0 v(wl_1__t3_ctl1)=0
.ic v(wl_2__t0_ctl1)=0 v(wl_2__t1_ctl1)=0 v(wl_2__t2_ctl1)=0 v(wl_2__t3_ctl1)=0
.ic v(wl_3__t0_ctl1)=0 v(wl_3__t1_ctl1)=0 v(wl_3__t2_ctl1)=0 v(wl_3__t3_ctl1)=0
.ic v(bl_0__t0_rep1)=0 v(bl_0__t1_rep1)=0 v(bl_0__t2_rep1)=0 v(bl_0__t3_rep1)=0
.ic v(bl_1__t0_rep1)=0 v(bl_1__t1_rep1)=0 v(bl_1__t2_rep1)=0 v(bl_1__t3_rep1)=0
.ic v(bl_2__t0_rep1)=0 v(bl_2__t1_rep1)=0 v(bl_2__t2_rep1)=0 v(bl_2__t3_rep1)=0
.ic v(bl_3__t0_rep1)=0 v(bl_3__t1_rep1)=0 v(bl_3__t2_rep1)=0 v(bl_3__t3_rep1)=0
.ic v(rbl_0__t0_rep1)=0.9 v(rbl_0__t1_rep1)=0.9 v(rbl_0__t2_rep1)=0.9 v(rbl_0__t3_rep1)=0.9
.ic v(rbl_1__t0_rep1)=0.9 v(rbl_1__t1_rep1)=0.9 v(rbl_1__t2_rep1)=0.9 v(rbl_1__t3_rep1)=0.9
.ic v(rbl_2__t0_rep1)=0.9 v(rbl_2__t1_rep1)=0.9 v(rbl_2__t2_rep1)=0.9 v(rbl_2__t3_rep1)=0.9
.ic v(rbl_3__t0_rep1)=0.9 v(rbl_3__t1_rep1)=0.9 v(rbl_3__t2_rep1)=0.9 v(rbl_3__t3_rep1)=0.9
.ic v(rwl_0__t0_rep1)=1.8 v(rwl_0__t1_rep1)=1.8 v(rwl_0__t2_rep1)=1.8 v(rwl_0__t3_rep1)=1.8
.ic v(rwl_1__t0_rep1)=1.8 v(rwl_1__t1_rep1)=1.8 v(rwl_1__t2_rep1)=1.8 v(rwl_1__t3_rep1)=1.8
.ic v(rwl_2__t0_rep1)=1.8 v(rwl_2__t1_rep1)=1.8 v(rwl_2__t2_rep1)=1.8 v(rwl_2__t3_rep1)=1.8
.ic v(rwl_3__t0_rep1)=1.8 v(rwl_3__t1_rep1)=1.8 v(rwl_3__t2_rep1)=1.8 v(rwl_3__t3_rep1)=1.8
.ic v(sn_0_0_rep1)=0 v(sn_0_0__t0_rep1)=0 v(sn_0_0__t1_rep1)=0 v(sn_0_1_rep1)=0
.ic v(sn_0_1__t0_rep1)=0 v(sn_0_1__t1_rep1)=0 v(sn_0_2_rep1)=0 v(sn_0_2__t0_rep1)=0
.ic v(sn_0_2__t1_rep1)=0 v(sn_0_3_rep1)=0 v(sn_0_3__t0_rep1)=0 v(sn_0_3__t1_rep1)=0
.ic v(sn_1_0_rep1)=1 v(sn_1_0__t0_rep1)=1 v(sn_1_0__t1_rep1)=1 v(sn_1_1_rep1)=1
.ic v(sn_1_1__t0_rep1)=1 v(sn_1_1__t1_rep1)=1 v(sn_1_2_rep1)=1 v(sn_1_2__t0_rep1)=1
.ic v(sn_1_2__t1_rep1)=1 v(sn_1_3_rep1)=1 v(sn_1_3__t0_rep1)=1 v(sn_1_3__t1_rep1)=1
.ic v(sn_2_0_rep1)=0 v(sn_2_0__t0_rep1)=0 v(sn_2_0__t1_rep1)=0 v(sn_2_1_rep1)=0
.ic v(sn_2_1__t0_rep1)=0 v(sn_2_1__t1_rep1)=0 v(sn_2_2_rep1)=0 v(sn_2_2__t0_rep1)=0
.ic v(sn_2_2__t1_rep1)=0 v(sn_2_3_rep1)=0 v(sn_2_3__t0_rep1)=0 v(sn_2_3__t1_rep1)=0
.ic v(sn_3_0_rep1)=1 v(sn_3_0__t0_rep1)=1 v(sn_3_0__t1_rep1)=1 v(sn_3_1_rep1)=1
.ic v(sn_3_1__t0_rep1)=1 v(sn_3_1__t1_rep1)=1 v(sn_3_2_rep1)=1 v(sn_3_2__t0_rep1)=1
.ic v(sn_3_2__t1_rep1)=1 v(sn_3_3_rep1)=1 v(sn_3_3__t0_rep1)=1 v(sn_3_3__t1_rep1)=1
.ic v(wl_0__t0_rep1)=0 v(wl_0__t1_rep1)=0 v(wl_0__t2_rep1)=0 v(wl_0__t3_rep1)=0
.ic v(wl_1__t0_rep1)=0 v(wl_1__t1_rep1)=0 v(wl_1__t2_rep1)=0 v(wl_1__t3_rep1)=0
.ic v(wl_2__t0_rep1)=0 v(wl_2__t1_rep1)=0 v(wl_2__t2_rep1)=0 v(wl_2__t3_rep1)=0
.ic v(wl_3__t0_rep1)=0 v(wl_3__t1_rep1)=0 v(wl_3__t2_rep1)=0 v(wl_3__t3_rep1)=0
.ic v(bl_0__t0_rep0)=1.8 v(bl_0__t1_rep0)=1.8 v(bl_0__t2_rep0)=1.8 v(bl_0__t3_rep0)=1.8
.ic v(bl_1__t0_rep0)=1.8 v(bl_1__t1_rep0)=1.8 v(bl_1__t2_rep0)=1.8 v(bl_1__t3_rep0)=1.8
.ic v(bl_2__t0_rep0)=1.8 v(bl_2__t1_rep0)=1.8 v(bl_2__t2_rep0)=1.8 v(bl_2__t3_rep0)=1.8
.ic v(bl_3__t0_rep0)=1.8 v(bl_3__t1_rep0)=1.8 v(bl_3__t2_rep0)=1.8 v(bl_3__t3_rep0)=1.8
.ic v(rbl_0__t0_rep0)=0.9 v(rbl_0__t1_rep0)=0.9 v(rbl_0__t2_rep0)=0.9 v(rbl_0__t3_rep0)=0.9
.ic v(rbl_1__t0_rep0)=0.9 v(rbl_1__t1_rep0)=0.9 v(rbl_1__t2_rep0)=0.9 v(rbl_1__t3_rep0)=0.9
.ic v(rbl_2__t0_rep0)=0.9 v(rbl_2__t1_rep0)=0.9 v(rbl_2__t2_rep0)=0.9 v(rbl_2__t3_rep0)=0.9
.ic v(rbl_3__t0_rep0)=0.9 v(rbl_3__t1_rep0)=0.9 v(rbl_3__t2_rep0)=0.9 v(rbl_3__t3_rep0)=0.9
.ic v(rwl_0__t0_rep0)=1.8 v(rwl_0__t1_rep0)=1.8 v(rwl_0__t2_rep0)=1.8 v(rwl_0__t3_rep0)=1.8
.ic v(rwl_1__t0_rep0)=1.8 v(rwl_1__t1_rep0)=1.8 v(rwl_1__t2_rep0)=1.8 v(rwl_1__t3_rep0)=1.8
.ic v(rwl_2__t0_rep0)=1.8 v(rwl_2__t1_rep0)=1.8 v(rwl_2__t2_rep0)=1.8 v(rwl_2__t3_rep0)=1.8
.ic v(rwl_3__t0_rep0)=1.8 v(rwl_3__t1_rep0)=1.8 v(rwl_3__t2_rep0)=1.8 v(rwl_3__t3_rep0)=1.8
.ic v(sn_0_0_rep0)=1 v(sn_0_0__t0_rep0)=1 v(sn_0_0__t1_rep0)=1 v(sn_0_1_rep0)=1
.ic v(sn_0_1__t0_rep0)=1 v(sn_0_1__t1_rep0)=1 v(sn_0_2_rep0)=1 v(sn_0_2__t0_rep0)=1
.ic v(sn_0_2__t1_rep0)=1 v(sn_0_3_rep0)=1 v(sn_0_3__t0_rep0)=1 v(sn_0_3__t1_rep0)=1
.ic v(sn_1_0_rep0)=1 v(sn_1_0__t0_rep0)=1 v(sn_1_0__t1_rep0)=1 v(sn_1_1_rep0)=1
.ic v(sn_1_1__t0_rep0)=1 v(sn_1_1__t1_rep0)=1 v(sn_1_2_rep0)=1 v(sn_1_2__t0_rep0)=1
.ic v(sn_1_2__t1_rep0)=1 v(sn_1_3_rep0)=1 v(sn_1_3__t0_rep0)=1 v(sn_1_3__t1_rep0)=1
.ic v(sn_2_0_rep0)=0 v(sn_2_0__t0_rep0)=0 v(sn_2_0__t1_rep0)=0 v(sn_2_1_rep0)=0
.ic v(sn_2_1__t0_rep0)=0 v(sn_2_1__t1_rep0)=0 v(sn_2_2_rep0)=0 v(sn_2_2__t0_rep0)=0
.ic v(sn_2_2__t1_rep0)=0 v(sn_2_3_rep0)=0 v(sn_2_3__t0_rep0)=0 v(sn_2_3__t1_rep0)=0
.ic v(sn_3_0_rep0)=1 v(sn_3_0__t0_rep0)=1 v(sn_3_0__t1_rep0)=1 v(sn_3_1_rep0)=1
.ic v(sn_3_1__t0_rep0)=1 v(sn_3_1__t1_rep0)=1 v(sn_3_2_rep0)=1 v(sn_3_2__t0_rep0)=1
.ic v(sn_3_2__t1_rep0)=1 v(sn_3_3_rep0)=1 v(sn_3_3__t0_rep0)=1 v(sn_3_3__t1_rep0)=1
.ic v(wl_0__t0_rep0)=0 v(wl_0__t1_rep0)=0 v(wl_0__t2_rep0)=0 v(wl_0__t3_rep0)=0
.ic v(wl_1__t0_rep0)=0 v(wl_1__t1_rep0)=0 v(wl_1__t2_rep0)=0 v(wl_1__t3_rep0)=0
.ic v(wl_2__t0_rep0)=0 v(wl_2__t1_rep0)=0 v(wl_2__t2_rep0)=0 v(wl_2__t3_rep0)=0
.ic v(wl_3__t0_rep0)=0 v(wl_3__t1_rep0)=0 v(wl_3__t2_rep0)=0 v(wl_3__t3_rep0)=0
.ic v(bl_0__t0_hs_p1)=0 v(bl_0__t1_hs_p1)=0 v(bl_0__t2_hs_p1)=0 v(bl_0__t3_hs_p1)=0
.ic v(bl_1__t0_hs_p1)=0 v(bl_1__t1_hs_p1)=0 v(bl_1__t2_hs_p1)=0 v(bl_1__t3_hs_p1)=0
.ic v(bl_2__t0_hs_p1)=1.8 v(bl_2__t1_hs_p1)=1.8 v(bl_2__t2_hs_p1)=1.8 v(bl_2__t3_hs_p1)=1.8
.ic v(bl_3__t0_hs_p1)=0 v(bl_3__t1_hs_p1)=0 v(bl_3__t2_hs_p1)=0 v(bl_3__t3_hs_p1)=0
.ic v(rbl_0__t0_hs_p1)=0.9 v(rbl_0__t1_hs_p1)=0.9 v(rbl_0__t2_hs_p1)=0.9 v(rbl_0__t3_hs_p1)=0.9
.ic v(rbl_1__t0_hs_p1)=0.9 v(rbl_1__t1_hs_p1)=0.9 v(rbl_1__t2_hs_p1)=0.9 v(rbl_1__t3_hs_p1)=0.9
.ic v(rbl_2__t0_hs_p1)=0.9 v(rbl_2__t1_hs_p1)=0.9 v(rbl_2__t2_hs_p1)=0.9 v(rbl_2__t3_hs_p1)=0.9
.ic v(rbl_3__t0_hs_p1)=0.9 v(rbl_3__t1_hs_p1)=0.9 v(rbl_3__t2_hs_p1)=0.9 v(rbl_3__t3_hs_p1)=0.9
.ic v(rwl_0__t0_hs_p1)=1.8 v(rwl_0__t1_hs_p1)=1.8 v(rwl_0__t2_hs_p1)=1.8 v(rwl_0__t3_hs_p1)=1.8
.ic v(rwl_1__t0_hs_p1)=1.8 v(rwl_1__t1_hs_p1)=1.8 v(rwl_1__t2_hs_p1)=1.8 v(rwl_1__t3_hs_p1)=1.8
.ic v(rwl_2__t0_hs_p1)=1.8 v(rwl_2__t1_hs_p1)=1.8 v(rwl_2__t2_hs_p1)=1.8 v(rwl_2__t3_hs_p1)=1.8
.ic v(rwl_3__t0_hs_p1)=1.8 v(rwl_3__t1_hs_p1)=1.8 v(rwl_3__t2_hs_p1)=1.8 v(rwl_3__t3_hs_p1)=1.8
.ic v(sn_0_0_hs_p1)=0 v(sn_0_0__t0_hs_p1)=0 v(sn_0_0__t1_hs_p1)=0 v(sn_0_1_hs_p1)=0
.ic v(sn_0_1__t0_hs_p1)=0 v(sn_0_1__t1_hs_p1)=0 v(sn_0_2_hs_p1)=1 v(sn_0_2__t0_hs_p1)=1
.ic v(sn_0_2__t1_hs_p1)=1 v(sn_0_3_hs_p1)=0 v(sn_0_3__t0_hs_p1)=0 v(sn_0_3__t1_hs_p1)=0
.ic v(sn_1_0_hs_p1)=1 v(sn_1_0__t0_hs_p1)=1 v(sn_1_0__t1_hs_p1)=1 v(sn_1_1_hs_p1)=1
.ic v(sn_1_1__t0_hs_p1)=1 v(sn_1_1__t1_hs_p1)=1 v(sn_1_2_hs_p1)=1 v(sn_1_2__t0_hs_p1)=1
.ic v(sn_1_2__t1_hs_p1)=1 v(sn_1_3_hs_p1)=1 v(sn_1_3__t0_hs_p1)=1 v(sn_1_3__t1_hs_p1)=1
.ic v(sn_2_0_hs_p1)=0 v(sn_2_0__t0_hs_p1)=0 v(sn_2_0__t1_hs_p1)=0 v(sn_2_1_hs_p1)=0
.ic v(sn_2_1__t0_hs_p1)=0 v(sn_2_1__t1_hs_p1)=0 v(sn_2_2_hs_p1)=0 v(sn_2_2__t0_hs_p1)=0
.ic v(sn_2_2__t1_hs_p1)=0 v(sn_2_3_hs_p1)=0 v(sn_2_3__t0_hs_p1)=0 v(sn_2_3__t1_hs_p1)=0
.ic v(sn_3_0_hs_p1)=1 v(sn_3_0__t0_hs_p1)=1 v(sn_3_0__t1_hs_p1)=1 v(sn_3_1_hs_p1)=1
.ic v(sn_3_1__t0_hs_p1)=1 v(sn_3_1__t1_hs_p1)=1 v(sn_3_2_hs_p1)=1 v(sn_3_2__t0_hs_p1)=1
.ic v(sn_3_2__t1_hs_p1)=1 v(sn_3_3_hs_p1)=1 v(sn_3_3__t0_hs_p1)=1 v(sn_3_3__t1_hs_p1)=1
.ic v(wl_0__t0_hs_p1)=0 v(wl_0__t1_hs_p1)=0 v(wl_0__t2_hs_p1)=0 v(wl_0__t3_hs_p1)=0
.ic v(wl_1__t0_hs_p1)=0 v(wl_1__t1_hs_p1)=0 v(wl_1__t2_hs_p1)=0 v(wl_1__t3_hs_p1)=0
.ic v(wl_2__t0_hs_p1)=0 v(wl_2__t1_hs_p1)=0 v(wl_2__t2_hs_p1)=0 v(wl_2__t3_hs_p1)=0
.ic v(wl_3__t0_hs_p1)=0 v(wl_3__t1_hs_p1)=0 v(wl_3__t2_hs_p1)=0 v(wl_3__t3_hs_p1)=0
.ic v(bl_0__t0_hs_p0)=1.8 v(bl_0__t1_hs_p0)=1.8 v(bl_0__t2_hs_p0)=1.8 v(bl_0__t3_hs_p0)=1.8
.ic v(bl_1__t0_hs_p0)=1.8 v(bl_1__t1_hs_p0)=1.8 v(bl_1__t2_hs_p0)=1.8 v(bl_1__t3_hs_p0)=1.8
.ic v(bl_2__t0_hs_p0)=0 v(bl_2__t1_hs_p0)=0 v(bl_2__t2_hs_p0)=0 v(bl_2__t3_hs_p0)=0
.ic v(bl_3__t0_hs_p0)=1.8 v(bl_3__t1_hs_p0)=1.8 v(bl_3__t2_hs_p0)=1.8 v(bl_3__t3_hs_p0)=1.8
.ic v(rbl_0__t0_hs_p0)=0.9 v(rbl_0__t1_hs_p0)=0.9 v(rbl_0__t2_hs_p0)=0.9 v(rbl_0__t3_hs_p0)=0.9
.ic v(rbl_1__t0_hs_p0)=0.9 v(rbl_1__t1_hs_p0)=0.9 v(rbl_1__t2_hs_p0)=0.9 v(rbl_1__t3_hs_p0)=0.9
.ic v(rbl_2__t0_hs_p0)=0.9 v(rbl_2__t1_hs_p0)=0.9 v(rbl_2__t2_hs_p0)=0.9 v(rbl_2__t3_hs_p0)=0.9
.ic v(rbl_3__t0_hs_p0)=0.9 v(rbl_3__t1_hs_p0)=0.9 v(rbl_3__t2_hs_p0)=0.9 v(rbl_3__t3_hs_p0)=0.9
.ic v(rwl_0__t0_hs_p0)=1.8 v(rwl_0__t1_hs_p0)=1.8 v(rwl_0__t2_hs_p0)=1.8 v(rwl_0__t3_hs_p0)=1.8
.ic v(rwl_1__t0_hs_p0)=1.8 v(rwl_1__t1_hs_p0)=1.8 v(rwl_1__t2_hs_p0)=1.8 v(rwl_1__t3_hs_p0)=1.8
.ic v(rwl_2__t0_hs_p0)=1.8 v(rwl_2__t1_hs_p0)=1.8 v(rwl_2__t2_hs_p0)=1.8 v(rwl_2__t3_hs_p0)=1.8
.ic v(rwl_3__t0_hs_p0)=1.8 v(rwl_3__t1_hs_p0)=1.8 v(rwl_3__t2_hs_p0)=1.8 v(rwl_3__t3_hs_p0)=1.8
.ic v(sn_0_0_hs_p0)=1 v(sn_0_0__t0_hs_p0)=1 v(sn_0_0__t1_hs_p0)=1 v(sn_0_1_hs_p0)=1
.ic v(sn_0_1__t0_hs_p0)=1 v(sn_0_1__t1_hs_p0)=1 v(sn_0_2_hs_p0)=0 v(sn_0_2__t0_hs_p0)=0
.ic v(sn_0_2__t1_hs_p0)=0 v(sn_0_3_hs_p0)=1 v(sn_0_3__t0_hs_p0)=1 v(sn_0_3__t1_hs_p0)=1
.ic v(sn_1_0_hs_p0)=1 v(sn_1_0__t0_hs_p0)=1 v(sn_1_0__t1_hs_p0)=1 v(sn_1_1_hs_p0)=1
.ic v(sn_1_1__t0_hs_p0)=1 v(sn_1_1__t1_hs_p0)=1 v(sn_1_2_hs_p0)=1 v(sn_1_2__t0_hs_p0)=1
.ic v(sn_1_2__t1_hs_p0)=1 v(sn_1_3_hs_p0)=1 v(sn_1_3__t0_hs_p0)=1 v(sn_1_3__t1_hs_p0)=1
.ic v(sn_2_0_hs_p0)=0 v(sn_2_0__t0_hs_p0)=0 v(sn_2_0__t1_hs_p0)=0 v(sn_2_1_hs_p0)=0
.ic v(sn_2_1__t0_hs_p0)=0 v(sn_2_1__t1_hs_p0)=0 v(sn_2_2_hs_p0)=0 v(sn_2_2__t0_hs_p0)=0
.ic v(sn_2_2__t1_hs_p0)=0 v(sn_2_3_hs_p0)=0 v(sn_2_3__t0_hs_p0)=0 v(sn_2_3__t1_hs_p0)=0
.ic v(sn_3_0_hs_p0)=1 v(sn_3_0__t0_hs_p0)=1 v(sn_3_0__t1_hs_p0)=1 v(sn_3_1_hs_p0)=1
.ic v(sn_3_1__t0_hs_p0)=1 v(sn_3_1__t1_hs_p0)=1 v(sn_3_2_hs_p0)=1 v(sn_3_2__t0_hs_p0)=1
.ic v(sn_3_2__t1_hs_p0)=1 v(sn_3_3_hs_p0)=1 v(sn_3_3__t0_hs_p0)=1 v(sn_3_3__t1_hs_p0)=1
.ic v(wl_0__t0_hs_p0)=0 v(wl_0__t1_hs_p0)=0 v(wl_0__t2_hs_p0)=0 v(wl_0__t3_hs_p0)=0
.ic v(wl_1__t0_hs_p0)=0 v(wl_1__t1_hs_p0)=0 v(wl_1__t2_hs_p0)=0 v(wl_1__t3_hs_p0)=0
.ic v(wl_2__t0_hs_p0)=0 v(wl_2__t1_hs_p0)=0 v(wl_2__t2_hs_p0)=0 v(wl_2__t3_hs_p0)=0
.ic v(wl_3__t0_hs_p0)=0 v(wl_3__t1_hs_p0)=0 v(wl_3__t2_hs_p0)=0 v(wl_3__t3_hs_p0)=0
.ic v(bl_0__t0_neg_ctl0)=0 v(bl_0__t1_neg_ctl0)=0 v(bl_0__t2_neg_ctl0)=0 v(bl_0__t3_neg_ctl0)=0
.ic v(bl_1__t0_neg_ctl0)=0 v(bl_1__t1_neg_ctl0)=0 v(bl_1__t2_neg_ctl0)=0 v(bl_1__t3_neg_ctl0)=0
.ic v(bl_2__t0_neg_ctl0)=0 v(bl_2__t1_neg_ctl0)=0 v(bl_2__t2_neg_ctl0)=0 v(bl_2__t3_neg_ctl0)=0
.ic v(bl_3__t0_neg_ctl0)=0 v(bl_3__t1_neg_ctl0)=0 v(bl_3__t2_neg_ctl0)=0 v(bl_3__t3_neg_ctl0)=0
.ic v(rbl_0__t0_neg_ctl0)=0.9 v(rbl_0__t1_neg_ctl0)=0.9 v(rbl_0__t2_neg_ctl0)=0.9 v(rbl_0__t3_neg_ctl0)=0.9
.ic v(rbl_1__t0_neg_ctl0)=0.9 v(rbl_1__t1_neg_ctl0)=0.9 v(rbl_1__t2_neg_ctl0)=0.9 v(rbl_1__t3_neg_ctl0)=0.9
.ic v(rbl_2__t0_neg_ctl0)=0.9 v(rbl_2__t1_neg_ctl0)=0.9 v(rbl_2__t2_neg_ctl0)=0.9 v(rbl_2__t3_neg_ctl0)=0.9
.ic v(rbl_3__t0_neg_ctl0)=0.9 v(rbl_3__t1_neg_ctl0)=0.9 v(rbl_3__t2_neg_ctl0)=0.9 v(rbl_3__t3_neg_ctl0)=0.9
.ic v(rwl_0__t0_neg_ctl0)=1.8 v(rwl_0__t1_neg_ctl0)=1.8 v(rwl_0__t2_neg_ctl0)=1.8 v(rwl_0__t3_neg_ctl0)=1.8
.ic v(rwl_1__t0_neg_ctl0)=1.8 v(rwl_1__t1_neg_ctl0)=1.8 v(rwl_1__t2_neg_ctl0)=1.8 v(rwl_1__t3_neg_ctl0)=1.8
.ic v(rwl_2__t0_neg_ctl0)=1.8 v(rwl_2__t1_neg_ctl0)=1.8 v(rwl_2__t2_neg_ctl0)=1.8 v(rwl_2__t3_neg_ctl0)=1.8
.ic v(rwl_3__t0_neg_ctl0)=1.8 v(rwl_3__t1_neg_ctl0)=1.8 v(rwl_3__t2_neg_ctl0)=1.8 v(rwl_3__t3_neg_ctl0)=1.8
.ic v(sn_0_0_neg_ctl0)=0 v(sn_0_0__t0_neg_ctl0)=0 v(sn_0_0__t1_neg_ctl0)=0 v(sn_0_1_neg_ctl0)=0
.ic v(sn_0_1__t0_neg_ctl0)=0 v(sn_0_1__t1_neg_ctl0)=0 v(sn_0_2_neg_ctl0)=0 v(sn_0_2__t0_neg_ctl0)=0
.ic v(sn_0_2__t1_neg_ctl0)=0 v(sn_0_3_neg_ctl0)=0 v(sn_0_3__t0_neg_ctl0)=0 v(sn_0_3__t1_neg_ctl0)=0
.ic v(sn_1_0_neg_ctl0)=1 v(sn_1_0__t0_neg_ctl0)=1 v(sn_1_0__t1_neg_ctl0)=1 v(sn_1_1_neg_ctl0)=1
.ic v(sn_1_1__t0_neg_ctl0)=1 v(sn_1_1__t1_neg_ctl0)=1 v(sn_1_2_neg_ctl0)=1 v(sn_1_2__t0_neg_ctl0)=1
.ic v(sn_1_2__t1_neg_ctl0)=1 v(sn_1_3_neg_ctl0)=1 v(sn_1_3__t0_neg_ctl0)=1 v(sn_1_3__t1_neg_ctl0)=1
.ic v(sn_2_0_neg_ctl0)=0 v(sn_2_0__t0_neg_ctl0)=0 v(sn_2_0__t1_neg_ctl0)=0 v(sn_2_1_neg_ctl0)=0
.ic v(sn_2_1__t0_neg_ctl0)=0 v(sn_2_1__t1_neg_ctl0)=0 v(sn_2_2_neg_ctl0)=0 v(sn_2_2__t0_neg_ctl0)=0
.ic v(sn_2_2__t1_neg_ctl0)=0 v(sn_2_3_neg_ctl0)=0 v(sn_2_3__t0_neg_ctl0)=0 v(sn_2_3__t1_neg_ctl0)=0
.ic v(sn_3_0_neg_ctl0)=1 v(sn_3_0__t0_neg_ctl0)=1 v(sn_3_0__t1_neg_ctl0)=1 v(sn_3_1_neg_ctl0)=1
.ic v(sn_3_1__t0_neg_ctl0)=1 v(sn_3_1__t1_neg_ctl0)=1 v(sn_3_2_neg_ctl0)=1 v(sn_3_2__t0_neg_ctl0)=1
.ic v(sn_3_2__t1_neg_ctl0)=1 v(sn_3_3_neg_ctl0)=1 v(sn_3_3__t0_neg_ctl0)=1 v(sn_3_3__t1_neg_ctl0)=1
.ic v(wl_0__t0_neg_ctl0)=0 v(wl_0__t1_neg_ctl0)=0 v(wl_0__t2_neg_ctl0)=0 v(wl_0__t3_neg_ctl0)=0
.ic v(wl_1__t0_neg_ctl0)=0 v(wl_1__t1_neg_ctl0)=0 v(wl_1__t2_neg_ctl0)=0 v(wl_1__t3_neg_ctl0)=0
.ic v(wl_2__t0_neg_ctl0)=0 v(wl_2__t1_neg_ctl0)=0 v(wl_2__t2_neg_ctl0)=0 v(wl_2__t3_neg_ctl0)=0
.ic v(wl_3__t0_neg_ctl0)=0 v(wl_3__t1_neg_ctl0)=0 v(wl_3__t2_neg_ctl0)=0 v(wl_3__t3_neg_ctl0)=0
.ic v(bl_0__t0_neg_ctl1)=1.8 v(bl_0__t1_neg_ctl1)=1.8 v(bl_0__t2_neg_ctl1)=1.8 v(bl_0__t3_neg_ctl1)=1.8
.ic v(bl_1__t0_neg_ctl1)=1.8 v(bl_1__t1_neg_ctl1)=1.8 v(bl_1__t2_neg_ctl1)=1.8 v(bl_1__t3_neg_ctl1)=1.8
.ic v(bl_2__t0_neg_ctl1)=1.8 v(bl_2__t1_neg_ctl1)=1.8 v(bl_2__t2_neg_ctl1)=1.8 v(bl_2__t3_neg_ctl1)=1.8
.ic v(bl_3__t0_neg_ctl1)=1.8 v(bl_3__t1_neg_ctl1)=1.8 v(bl_3__t2_neg_ctl1)=1.8 v(bl_3__t3_neg_ctl1)=1.8
.ic v(rbl_0__t0_neg_ctl1)=0.9 v(rbl_0__t1_neg_ctl1)=0.9 v(rbl_0__t2_neg_ctl1)=0.9 v(rbl_0__t3_neg_ctl1)=0.9
.ic v(rbl_1__t0_neg_ctl1)=0.9 v(rbl_1__t1_neg_ctl1)=0.9 v(rbl_1__t2_neg_ctl1)=0.9 v(rbl_1__t3_neg_ctl1)=0.9
.ic v(rbl_2__t0_neg_ctl1)=0.9 v(rbl_2__t1_neg_ctl1)=0.9 v(rbl_2__t2_neg_ctl1)=0.9 v(rbl_2__t3_neg_ctl1)=0.9
.ic v(rbl_3__t0_neg_ctl1)=0.9 v(rbl_3__t1_neg_ctl1)=0.9 v(rbl_3__t2_neg_ctl1)=0.9 v(rbl_3__t3_neg_ctl1)=0.9
.ic v(rwl_0__t0_neg_ctl1)=1.8 v(rwl_0__t1_neg_ctl1)=1.8 v(rwl_0__t2_neg_ctl1)=1.8 v(rwl_0__t3_neg_ctl1)=1.8
.ic v(rwl_1__t0_neg_ctl1)=1.8 v(rwl_1__t1_neg_ctl1)=1.8 v(rwl_1__t2_neg_ctl1)=1.8 v(rwl_1__t3_neg_ctl1)=1.8
.ic v(rwl_2__t0_neg_ctl1)=1.8 v(rwl_2__t1_neg_ctl1)=1.8 v(rwl_2__t2_neg_ctl1)=1.8 v(rwl_2__t3_neg_ctl1)=1.8
.ic v(rwl_3__t0_neg_ctl1)=1.8 v(rwl_3__t1_neg_ctl1)=1.8 v(rwl_3__t2_neg_ctl1)=1.8 v(rwl_3__t3_neg_ctl1)=1.8
.ic v(sn_0_0_neg_ctl1)=1 v(sn_0_0__t0_neg_ctl1)=1 v(sn_0_0__t1_neg_ctl1)=1 v(sn_0_1_neg_ctl1)=1
.ic v(sn_0_1__t0_neg_ctl1)=1 v(sn_0_1__t1_neg_ctl1)=1 v(sn_0_2_neg_ctl1)=1 v(sn_0_2__t0_neg_ctl1)=1
.ic v(sn_0_2__t1_neg_ctl1)=1 v(sn_0_3_neg_ctl1)=1 v(sn_0_3__t0_neg_ctl1)=1 v(sn_0_3__t1_neg_ctl1)=1
.ic v(sn_1_0_neg_ctl1)=1 v(sn_1_0__t0_neg_ctl1)=1 v(sn_1_0__t1_neg_ctl1)=1 v(sn_1_1_neg_ctl1)=1
.ic v(sn_1_1__t0_neg_ctl1)=1 v(sn_1_1__t1_neg_ctl1)=1 v(sn_1_2_neg_ctl1)=1 v(sn_1_2__t0_neg_ctl1)=1
.ic v(sn_1_2__t1_neg_ctl1)=1 v(sn_1_3_neg_ctl1)=1 v(sn_1_3__t0_neg_ctl1)=1 v(sn_1_3__t1_neg_ctl1)=1
.ic v(sn_2_0_neg_ctl1)=0 v(sn_2_0__t0_neg_ctl1)=0 v(sn_2_0__t1_neg_ctl1)=0 v(sn_2_1_neg_ctl1)=0
.ic v(sn_2_1__t0_neg_ctl1)=0 v(sn_2_1__t1_neg_ctl1)=0 v(sn_2_2_neg_ctl1)=0 v(sn_2_2__t0_neg_ctl1)=0
.ic v(sn_2_2__t1_neg_ctl1)=0 v(sn_2_3_neg_ctl1)=0 v(sn_2_3__t0_neg_ctl1)=0 v(sn_2_3__t1_neg_ctl1)=0
.ic v(sn_3_0_neg_ctl1)=1 v(sn_3_0__t0_neg_ctl1)=1 v(sn_3_0__t1_neg_ctl1)=1 v(sn_3_1_neg_ctl1)=1
.ic v(sn_3_1__t0_neg_ctl1)=1 v(sn_3_1__t1_neg_ctl1)=1 v(sn_3_2_neg_ctl1)=1 v(sn_3_2__t0_neg_ctl1)=1
.ic v(sn_3_2__t1_neg_ctl1)=1 v(sn_3_3_neg_ctl1)=1 v(sn_3_3__t0_neg_ctl1)=1 v(sn_3_3__t1_neg_ctl1)=1
.ic v(wl_0__t0_neg_ctl1)=0 v(wl_0__t1_neg_ctl1)=0 v(wl_0__t2_neg_ctl1)=0 v(wl_0__t3_neg_ctl1)=0
.ic v(wl_1__t0_neg_ctl1)=0 v(wl_1__t1_neg_ctl1)=0 v(wl_1__t2_neg_ctl1)=0 v(wl_1__t3_neg_ctl1)=0
.ic v(wl_2__t0_neg_ctl1)=0 v(wl_2__t1_neg_ctl1)=0 v(wl_2__t2_neg_ctl1)=0 v(wl_2__t3_neg_ctl1)=0
.ic v(wl_3__t0_neg_ctl1)=0 v(wl_3__t1_neg_ctl1)=0 v(wl_3__t2_neg_ctl1)=0 v(wl_3__t3_neg_ctl1)=0
.ic v(bl_0__t0_neg_rep1)=0 v(bl_0__t1_neg_rep1)=0 v(bl_0__t2_neg_rep1)=0 v(bl_0__t3_neg_rep1)=0
.ic v(bl_1__t0_neg_rep1)=0 v(bl_1__t1_neg_rep1)=0 v(bl_1__t2_neg_rep1)=0 v(bl_1__t3_neg_rep1)=0
.ic v(bl_2__t0_neg_rep1)=0 v(bl_2__t1_neg_rep1)=0 v(bl_2__t2_neg_rep1)=0 v(bl_2__t3_neg_rep1)=0
.ic v(bl_3__t0_neg_rep1)=0 v(bl_3__t1_neg_rep1)=0 v(bl_3__t2_neg_rep1)=0 v(bl_3__t3_neg_rep1)=0
.ic v(rbl_0__t0_neg_rep1)=0.9 v(rbl_0__t1_neg_rep1)=0.9 v(rbl_0__t2_neg_rep1)=0.9 v(rbl_0__t3_neg_rep1)=0.9
.ic v(rbl_1__t0_neg_rep1)=0.9 v(rbl_1__t1_neg_rep1)=0.9 v(rbl_1__t2_neg_rep1)=0.9 v(rbl_1__t3_neg_rep1)=0.9
.ic v(rbl_2__t0_neg_rep1)=0.9 v(rbl_2__t1_neg_rep1)=0.9 v(rbl_2__t2_neg_rep1)=0.9 v(rbl_2__t3_neg_rep1)=0.9
.ic v(rbl_3__t0_neg_rep1)=0.9 v(rbl_3__t1_neg_rep1)=0.9 v(rbl_3__t2_neg_rep1)=0.9 v(rbl_3__t3_neg_rep1)=0.9
.ic v(rwl_0__t0_neg_rep1)=1.8 v(rwl_0__t1_neg_rep1)=1.8 v(rwl_0__t2_neg_rep1)=1.8 v(rwl_0__t3_neg_rep1)=1.8
.ic v(rwl_1__t0_neg_rep1)=1.8 v(rwl_1__t1_neg_rep1)=1.8 v(rwl_1__t2_neg_rep1)=1.8 v(rwl_1__t3_neg_rep1)=1.8
.ic v(rwl_2__t0_neg_rep1)=1.8 v(rwl_2__t1_neg_rep1)=1.8 v(rwl_2__t2_neg_rep1)=1.8 v(rwl_2__t3_neg_rep1)=1.8
.ic v(rwl_3__t0_neg_rep1)=1.8 v(rwl_3__t1_neg_rep1)=1.8 v(rwl_3__t2_neg_rep1)=1.8 v(rwl_3__t3_neg_rep1)=1.8
.ic v(sn_0_0_neg_rep1)=0 v(sn_0_0__t0_neg_rep1)=0 v(sn_0_0__t1_neg_rep1)=0 v(sn_0_1_neg_rep1)=0
.ic v(sn_0_1__t0_neg_rep1)=0 v(sn_0_1__t1_neg_rep1)=0 v(sn_0_2_neg_rep1)=0 v(sn_0_2__t0_neg_rep1)=0
.ic v(sn_0_2__t1_neg_rep1)=0 v(sn_0_3_neg_rep1)=0 v(sn_0_3__t0_neg_rep1)=0 v(sn_0_3__t1_neg_rep1)=0
.ic v(sn_1_0_neg_rep1)=1 v(sn_1_0__t0_neg_rep1)=1 v(sn_1_0__t1_neg_rep1)=1 v(sn_1_1_neg_rep1)=1
.ic v(sn_1_1__t0_neg_rep1)=1 v(sn_1_1__t1_neg_rep1)=1 v(sn_1_2_neg_rep1)=1 v(sn_1_2__t0_neg_rep1)=1
.ic v(sn_1_2__t1_neg_rep1)=1 v(sn_1_3_neg_rep1)=1 v(sn_1_3__t0_neg_rep1)=1 v(sn_1_3__t1_neg_rep1)=1
.ic v(sn_2_0_neg_rep1)=0 v(sn_2_0__t0_neg_rep1)=0 v(sn_2_0__t1_neg_rep1)=0 v(sn_2_1_neg_rep1)=0
.ic v(sn_2_1__t0_neg_rep1)=0 v(sn_2_1__t1_neg_rep1)=0 v(sn_2_2_neg_rep1)=0 v(sn_2_2__t0_neg_rep1)=0
.ic v(sn_2_2__t1_neg_rep1)=0 v(sn_2_3_neg_rep1)=0 v(sn_2_3__t0_neg_rep1)=0 v(sn_2_3__t1_neg_rep1)=0
.ic v(sn_3_0_neg_rep1)=1 v(sn_3_0__t0_neg_rep1)=1 v(sn_3_0__t1_neg_rep1)=1 v(sn_3_1_neg_rep1)=1
.ic v(sn_3_1__t0_neg_rep1)=1 v(sn_3_1__t1_neg_rep1)=1 v(sn_3_2_neg_rep1)=1 v(sn_3_2__t0_neg_rep1)=1
.ic v(sn_3_2__t1_neg_rep1)=1 v(sn_3_3_neg_rep1)=1 v(sn_3_3__t0_neg_rep1)=1 v(sn_3_3__t1_neg_rep1)=1
.ic v(wl_0__t0_neg_rep1)=0 v(wl_0__t1_neg_rep1)=0 v(wl_0__t2_neg_rep1)=0 v(wl_0__t3_neg_rep1)=0
.ic v(wl_1__t0_neg_rep1)=0 v(wl_1__t1_neg_rep1)=0 v(wl_1__t2_neg_rep1)=0 v(wl_1__t3_neg_rep1)=0
.ic v(wl_2__t0_neg_rep1)=0 v(wl_2__t1_neg_rep1)=0 v(wl_2__t2_neg_rep1)=0 v(wl_2__t3_neg_rep1)=0
.ic v(wl_3__t0_neg_rep1)=0 v(wl_3__t1_neg_rep1)=0 v(wl_3__t2_neg_rep1)=0 v(wl_3__t3_neg_rep1)=0
.ic v(bl_0__t0_neg_rep0)=1.8 v(bl_0__t1_neg_rep0)=1.8 v(bl_0__t2_neg_rep0)=1.8 v(bl_0__t3_neg_rep0)=1.8
.ic v(bl_1__t0_neg_rep0)=1.8 v(bl_1__t1_neg_rep0)=1.8 v(bl_1__t2_neg_rep0)=1.8 v(bl_1__t3_neg_rep0)=1.8
.ic v(bl_2__t0_neg_rep0)=1.8 v(bl_2__t1_neg_rep0)=1.8 v(bl_2__t2_neg_rep0)=1.8 v(bl_2__t3_neg_rep0)=1.8
.ic v(bl_3__t0_neg_rep0)=1.8 v(bl_3__t1_neg_rep0)=1.8 v(bl_3__t2_neg_rep0)=1.8 v(bl_3__t3_neg_rep0)=1.8
.ic v(rbl_0__t0_neg_rep0)=0.9 v(rbl_0__t1_neg_rep0)=0.9 v(rbl_0__t2_neg_rep0)=0.9 v(rbl_0__t3_neg_rep0)=0.9
.ic v(rbl_1__t0_neg_rep0)=0.9 v(rbl_1__t1_neg_rep0)=0.9 v(rbl_1__t2_neg_rep0)=0.9 v(rbl_1__t3_neg_rep0)=0.9
.ic v(rbl_2__t0_neg_rep0)=0.9 v(rbl_2__t1_neg_rep0)=0.9 v(rbl_2__t2_neg_rep0)=0.9 v(rbl_2__t3_neg_rep0)=0.9
.ic v(rbl_3__t0_neg_rep0)=0.9 v(rbl_3__t1_neg_rep0)=0.9 v(rbl_3__t2_neg_rep0)=0.9 v(rbl_3__t3_neg_rep0)=0.9
.ic v(rwl_0__t0_neg_rep0)=1.8 v(rwl_0__t1_neg_rep0)=1.8 v(rwl_0__t2_neg_rep0)=1.8 v(rwl_0__t3_neg_rep0)=1.8
.ic v(rwl_1__t0_neg_rep0)=1.8 v(rwl_1__t1_neg_rep0)=1.8 v(rwl_1__t2_neg_rep0)=1.8 v(rwl_1__t3_neg_rep0)=1.8
.ic v(rwl_2__t0_neg_rep0)=1.8 v(rwl_2__t1_neg_rep0)=1.8 v(rwl_2__t2_neg_rep0)=1.8 v(rwl_2__t3_neg_rep0)=1.8
.ic v(rwl_3__t0_neg_rep0)=1.8 v(rwl_3__t1_neg_rep0)=1.8 v(rwl_3__t2_neg_rep0)=1.8 v(rwl_3__t3_neg_rep0)=1.8
.ic v(sn_0_0_neg_rep0)=1 v(sn_0_0__t0_neg_rep0)=1 v(sn_0_0__t1_neg_rep0)=1 v(sn_0_1_neg_rep0)=1
.ic v(sn_0_1__t0_neg_rep0)=1 v(sn_0_1__t1_neg_rep0)=1 v(sn_0_2_neg_rep0)=1 v(sn_0_2__t0_neg_rep0)=1
.ic v(sn_0_2__t1_neg_rep0)=1 v(sn_0_3_neg_rep0)=1 v(sn_0_3__t0_neg_rep0)=1 v(sn_0_3__t1_neg_rep0)=1
.ic v(sn_1_0_neg_rep0)=1 v(sn_1_0__t0_neg_rep0)=1 v(sn_1_0__t1_neg_rep0)=1 v(sn_1_1_neg_rep0)=1
.ic v(sn_1_1__t0_neg_rep0)=1 v(sn_1_1__t1_neg_rep0)=1 v(sn_1_2_neg_rep0)=1 v(sn_1_2__t0_neg_rep0)=1
.ic v(sn_1_2__t1_neg_rep0)=1 v(sn_1_3_neg_rep0)=1 v(sn_1_3__t0_neg_rep0)=1 v(sn_1_3__t1_neg_rep0)=1
.ic v(sn_2_0_neg_rep0)=0 v(sn_2_0__t0_neg_rep0)=0 v(sn_2_0__t1_neg_rep0)=0 v(sn_2_1_neg_rep0)=0
.ic v(sn_2_1__t0_neg_rep0)=0 v(sn_2_1__t1_neg_rep0)=0 v(sn_2_2_neg_rep0)=0 v(sn_2_2__t0_neg_rep0)=0
.ic v(sn_2_2__t1_neg_rep0)=0 v(sn_2_3_neg_rep0)=0 v(sn_2_3__t0_neg_rep0)=0 v(sn_2_3__t1_neg_rep0)=0
.ic v(sn_3_0_neg_rep0)=1 v(sn_3_0__t0_neg_rep0)=1 v(sn_3_0__t1_neg_rep0)=1 v(sn_3_1_neg_rep0)=1
.ic v(sn_3_1__t0_neg_rep0)=1 v(sn_3_1__t1_neg_rep0)=1 v(sn_3_2_neg_rep0)=1 v(sn_3_2__t0_neg_rep0)=1
.ic v(sn_3_2__t1_neg_rep0)=1 v(sn_3_3_neg_rep0)=1 v(sn_3_3__t0_neg_rep0)=1 v(sn_3_3__t1_neg_rep0)=1
.ic v(wl_0__t0_neg_rep0)=0 v(wl_0__t1_neg_rep0)=0 v(wl_0__t2_neg_rep0)=0 v(wl_0__t3_neg_rep0)=0
.ic v(wl_1__t0_neg_rep0)=0 v(wl_1__t1_neg_rep0)=0 v(wl_1__t2_neg_rep0)=0 v(wl_1__t3_neg_rep0)=0
.ic v(wl_2__t0_neg_rep0)=0 v(wl_2__t1_neg_rep0)=0 v(wl_2__t2_neg_rep0)=0 v(wl_2__t3_neg_rep0)=0
.ic v(wl_3__t0_neg_rep0)=0 v(wl_3__t1_neg_rep0)=0 v(wl_3__t2_neg_rep0)=0 v(wl_3__t3_neg_rep0)=0
