* refresh_replay.spice -- RTL-strobe replay of one REFRESH op in the refresh-op circuit, issue #128
* GENERATED by gen_refresh_replay.py; do not edit by hand.
*
* PROPOSED/UNRATIFIED SCOPE: 27 C and 125 C, tt/ss/ff/sf/fs global corners, 1.8 V, no mismatch.
* Circuit body identical to sim/refresh-op/refresh_op.spice (ideal drivers, 100 ohm switches,
* C_RBL = C_WBL = 10 fF assumed, 4-row column, ref = VRBL - 100 mV, same latch); ONLY the control
* PWL sources differ. Sources per instance: ctl<-pre_en, rwls<-rwl_sel (inverted), en/enb<-sense_en
* (or the latch-hold adapter waveform), wwl<-wwl_en, wbc<-bl_drive. Instance suffix = variant.

.param VDD   = 1.8
.param VRBL  = 0.9   $ ASSUMPTION (contract)
.param C_RBL = 1e-14   $ ASSUMPTION (contract; not extracted)
.param C_WBL = 1e-14   $ ASSUMPTION (not extracted)
.param C_SN  = 6.05354e-16   $ extracted-from-netlist (layout/gain_cell_2t.extract.parasitics.json)

* ---- shared static drivers (ideal) ----
vdd   vdd 0 dc {VDD}
vrwld rwl_des 0 dc {VDD}
vwwld wwl_des 0 dc 0
vpre  prea 0 dc {VRBL}
vref  pref 0 dc 0.8   $ reference = VRBL - 0.1 (ASSUMPTION)
.model swpre sw(vt=0.9 vh=0.1 ron=100 roff=1e12)
.model swwbl sw(vt=0.9 vh=0.1 ron=100 roff=1e12)

* ---- instance 0: op1_0900_baseline_analog (variant baseline_analog; probe dec 14.9 ns, release 37 ns, meas 39 ns) ----
vctl_op1_0900_baseline_analog ctl_op1_0900_baseline_analog 0 pwl(0.0000e+00 {VDD} 2.0000e-09 {VDD} 2.1000e-09 0)
vrs_op1_0900_baseline_analog rwls_op1_0900_baseline_analog 0 pwl(0.0000e+00 {VDD} 4.0000e-09 {VDD} 4.1000e-09 0 3.7000e-08 0 3.7100e-08 {VDD})
ven_op1_0900_baseline_analog en_op1_0900_baseline_analog 0 pwl(0.0000e+00 0 1.4000e-08 0 1.4100e-08 {VDD} 3.7000e-08 {VDD} 3.7100e-08 0)
venb_op1_0900_baseline_analog enb_op1_0900_baseline_analog 0 pwl(0.0000e+00 {VDD} 1.4000e-08 {VDD} 1.4100e-08 0 3.7000e-08 0 3.7100e-08 {VDD})
vww_op1_0900_baseline_analog wwl_op1_0900_baseline_analog 0 pwl(0.0000e+00 0 1.5000e-08 0 1.5100e-08 {VDD} 3.5000e-08 {VDD} 3.5100e-08 0)
vwc_op1_0900_baseline_analog wbc_op1_0900_baseline_analog 0 pwl(0.0000e+00 0 1.5000e-08 0 1.5100e-08 {VDD} 3.7000e-08 {VDD} 3.7100e-08 0)
swb_op1_0900_baseline_analog ref_op1_0900_baseline_analog wbl_op1_0900_baseline_analog wbc_op1_0900_baseline_analog 0 swwbl
cwbl_op1_0900_baseline_analog wbl_op1_0900_baseline_analog 0 {C_WBL}
spa_op1_0900_baseline_analog prea rbl_op1_0900_baseline_analog ctl_op1_0900_baseline_analog 0 swpre
spr_op1_0900_baseline_analog pref ref_op1_0900_baseline_analog ctl_op1_0900_baseline_analog 0 swpre
crbl_op1_0900_baseline_analog rbl_op1_0900_baseline_analog 0 {C_RBL}
cref_op1_0900_baseline_analog ref_op1_0900_baseline_analog 0 {C_RBL}   $ ASSUMPTION: ideal matched dummy load
XMWR_op1_0900_baseline_analog_0 sn_op1_0900_baseline_analog_0 wwl_op1_0900_baseline_analog wbl_op1_0900_baseline_analog 0 sky130_fd_pr__nfet_01v8 L=0.15 W=0.42 nf=1 ad=0.1218 as=0.1218 pd=1.42 ps=1.42 nrd=0.69047619047619  nrs=0.69047619047619 sa=0 sb=0 sd=0 mult=1 m=1
XMRD_op1_0900_baseline_analog_0 rbl_op1_0900_baseline_analog sn_op1_0900_baseline_analog_0 rwls_op1_0900_baseline_analog 0 sky130_fd_pr__nfet_01v8 L=0.15 W=0.42 nf=1 ad=0.1218 as=0.1218 pd=1.42 ps=1.42 nrd=0.69047619047619  nrs=0.69047619047619 sa=0 sb=0 sd=0 mult=1 m=1
csn_op1_0900_baseline_analog_0 sn_op1_0900_baseline_analog_0 0 {C_SN}
XMWR_op1_0900_baseline_analog_1 sn_op1_0900_baseline_analog_1 wwl_des wbl_op1_0900_baseline_analog 0 sky130_fd_pr__nfet_01v8 L=0.15 W=0.42 nf=1 ad=0.1218 as=0.1218 pd=1.42 ps=1.42 nrd=0.69047619047619  nrs=0.69047619047619 sa=0 sb=0 sd=0 mult=1 m=1
XMRD_op1_0900_baseline_analog_1 rbl_op1_0900_baseline_analog sn_op1_0900_baseline_analog_1 rwl_des 0 sky130_fd_pr__nfet_01v8 L=0.15 W=0.42 nf=1 ad=0.1218 as=0.1218 pd=1.42 ps=1.42 nrd=0.69047619047619  nrs=0.69047619047619 sa=0 sb=0 sd=0 mult=1 m=1
csn_op1_0900_baseline_analog_1 sn_op1_0900_baseline_analog_1 0 {C_SN}
XMWR_op1_0900_baseline_analog_2 sn_op1_0900_baseline_analog_2 wwl_des wbl_op1_0900_baseline_analog 0 sky130_fd_pr__nfet_01v8 L=0.15 W=0.42 nf=1 ad=0.1218 as=0.1218 pd=1.42 ps=1.42 nrd=0.69047619047619  nrs=0.69047619047619 sa=0 sb=0 sd=0 mult=1 m=1
XMRD_op1_0900_baseline_analog_2 rbl_op1_0900_baseline_analog sn_op1_0900_baseline_analog_2 rwl_des 0 sky130_fd_pr__nfet_01v8 L=0.15 W=0.42 nf=1 ad=0.1218 as=0.1218 pd=1.42 ps=1.42 nrd=0.69047619047619  nrs=0.69047619047619 sa=0 sb=0 sd=0 mult=1 m=1
csn_op1_0900_baseline_analog_2 sn_op1_0900_baseline_analog_2 0 {C_SN}
XMWR_op1_0900_baseline_analog_3 sn_op1_0900_baseline_analog_3 wwl_des wbl_op1_0900_baseline_analog 0 sky130_fd_pr__nfet_01v8 L=0.15 W=0.42 nf=1 ad=0.1218 as=0.1218 pd=1.42 ps=1.42 nrd=0.69047619047619  nrs=0.69047619047619 sa=0 sb=0 sd=0 mult=1 m=1
XMRD_op1_0900_baseline_analog_3 rbl_op1_0900_baseline_analog sn_op1_0900_baseline_analog_3 rwl_des 0 sky130_fd_pr__nfet_01v8 L=0.15 W=0.42 nf=1 ad=0.1218 as=0.1218 pd=1.42 ps=1.42 nrd=0.69047619047619  nrs=0.69047619047619 sa=0 sb=0 sd=0 mult=1 m=1
csn_op1_0900_baseline_analog_3 sn_op1_0900_baseline_analog_3 0 {C_SN}
XMN1_op1_0900_baseline_analog rbl_op1_0900_baseline_analog ref_op1_0900_baseline_analog vn_op1_0900_baseline_analog 0 sky130_fd_pr__nfet_01v8 L=0.15 W=1 nf=1 ad=0.29 as=0.29 pd=2.58 ps=2.58 mult=1 m=1
XMN2_op1_0900_baseline_analog ref_op1_0900_baseline_analog rbl_op1_0900_baseline_analog vn_op1_0900_baseline_analog 0 sky130_fd_pr__nfet_01v8 L=0.15 W=1 nf=1 ad=0.29 as=0.29 pd=2.58 ps=2.58 mult=1 m=1
XMP1_op1_0900_baseline_analog rbl_op1_0900_baseline_analog ref_op1_0900_baseline_analog vp_op1_0900_baseline_analog vdd sky130_fd_pr__pfet_01v8 L=0.15 W=2 nf=1 ad=0.58 as=0.58 pd=4.58 ps=4.58 mult=1 m=1
XMP2_op1_0900_baseline_analog ref_op1_0900_baseline_analog rbl_op1_0900_baseline_analog vp_op1_0900_baseline_analog vdd sky130_fd_pr__pfet_01v8 L=0.15 W=2 nf=1 ad=0.58 as=0.58 pd=4.58 ps=4.58 mult=1 m=1
XMNF_op1_0900_baseline_analog vn_op1_0900_baseline_analog en_op1_0900_baseline_analog 0 0 sky130_fd_pr__nfet_01v8 L=0.15 W=2 nf=1 ad=0.58 as=0.58 pd=4.58 ps=4.58 mult=1 m=1
XMPH_op1_0900_baseline_analog vp_op1_0900_baseline_analog enb_op1_0900_baseline_analog vdd vdd sky130_fd_pr__pfet_01v8 L=0.15 W=4 nf=1 ad=1.16 as=1.16 pd=8.58 ps=8.58 mult=1 m=1
bd_op1_0900_baseline_analog d_op1_0900_baseline_analog 0 v=v(rbl_op1_0900_baseline_analog)-v(ref_op1_0900_baseline_analog)

* ---- instance 1: op1_1000_baseline_analog (variant baseline_analog; probe dec 14.9 ns, release 37 ns, meas 39 ns) ----
vctl_op1_1000_baseline_analog ctl_op1_1000_baseline_analog 0 pwl(0.0000e+00 {VDD} 2.0000e-09 {VDD} 2.1000e-09 0)
vrs_op1_1000_baseline_analog rwls_op1_1000_baseline_analog 0 pwl(0.0000e+00 {VDD} 4.0000e-09 {VDD} 4.1000e-09 0 3.7000e-08 0 3.7100e-08 {VDD})
ven_op1_1000_baseline_analog en_op1_1000_baseline_analog 0 pwl(0.0000e+00 0 1.4000e-08 0 1.4100e-08 {VDD} 3.7000e-08 {VDD} 3.7100e-08 0)
venb_op1_1000_baseline_analog enb_op1_1000_baseline_analog 0 pwl(0.0000e+00 {VDD} 1.4000e-08 {VDD} 1.4100e-08 0 3.7000e-08 0 3.7100e-08 {VDD})
vww_op1_1000_baseline_analog wwl_op1_1000_baseline_analog 0 pwl(0.0000e+00 0 1.5000e-08 0 1.5100e-08 {VDD} 3.5000e-08 {VDD} 3.5100e-08 0)
vwc_op1_1000_baseline_analog wbc_op1_1000_baseline_analog 0 pwl(0.0000e+00 0 1.5000e-08 0 1.5100e-08 {VDD} 3.7000e-08 {VDD} 3.7100e-08 0)
swb_op1_1000_baseline_analog ref_op1_1000_baseline_analog wbl_op1_1000_baseline_analog wbc_op1_1000_baseline_analog 0 swwbl
cwbl_op1_1000_baseline_analog wbl_op1_1000_baseline_analog 0 {C_WBL}
spa_op1_1000_baseline_analog prea rbl_op1_1000_baseline_analog ctl_op1_1000_baseline_analog 0 swpre
spr_op1_1000_baseline_analog pref ref_op1_1000_baseline_analog ctl_op1_1000_baseline_analog 0 swpre
crbl_op1_1000_baseline_analog rbl_op1_1000_baseline_analog 0 {C_RBL}
cref_op1_1000_baseline_analog ref_op1_1000_baseline_analog 0 {C_RBL}   $ ASSUMPTION: ideal matched dummy load
XMWR_op1_1000_baseline_analog_0 sn_op1_1000_baseline_analog_0 wwl_op1_1000_baseline_analog wbl_op1_1000_baseline_analog 0 sky130_fd_pr__nfet_01v8 L=0.15 W=0.42 nf=1 ad=0.1218 as=0.1218 pd=1.42 ps=1.42 nrd=0.69047619047619  nrs=0.69047619047619 sa=0 sb=0 sd=0 mult=1 m=1
XMRD_op1_1000_baseline_analog_0 rbl_op1_1000_baseline_analog sn_op1_1000_baseline_analog_0 rwls_op1_1000_baseline_analog 0 sky130_fd_pr__nfet_01v8 L=0.15 W=0.42 nf=1 ad=0.1218 as=0.1218 pd=1.42 ps=1.42 nrd=0.69047619047619  nrs=0.69047619047619 sa=0 sb=0 sd=0 mult=1 m=1
csn_op1_1000_baseline_analog_0 sn_op1_1000_baseline_analog_0 0 {C_SN}
XMWR_op1_1000_baseline_analog_1 sn_op1_1000_baseline_analog_1 wwl_des wbl_op1_1000_baseline_analog 0 sky130_fd_pr__nfet_01v8 L=0.15 W=0.42 nf=1 ad=0.1218 as=0.1218 pd=1.42 ps=1.42 nrd=0.69047619047619  nrs=0.69047619047619 sa=0 sb=0 sd=0 mult=1 m=1
XMRD_op1_1000_baseline_analog_1 rbl_op1_1000_baseline_analog sn_op1_1000_baseline_analog_1 rwl_des 0 sky130_fd_pr__nfet_01v8 L=0.15 W=0.42 nf=1 ad=0.1218 as=0.1218 pd=1.42 ps=1.42 nrd=0.69047619047619  nrs=0.69047619047619 sa=0 sb=0 sd=0 mult=1 m=1
csn_op1_1000_baseline_analog_1 sn_op1_1000_baseline_analog_1 0 {C_SN}
XMWR_op1_1000_baseline_analog_2 sn_op1_1000_baseline_analog_2 wwl_des wbl_op1_1000_baseline_analog 0 sky130_fd_pr__nfet_01v8 L=0.15 W=0.42 nf=1 ad=0.1218 as=0.1218 pd=1.42 ps=1.42 nrd=0.69047619047619  nrs=0.69047619047619 sa=0 sb=0 sd=0 mult=1 m=1
XMRD_op1_1000_baseline_analog_2 rbl_op1_1000_baseline_analog sn_op1_1000_baseline_analog_2 rwl_des 0 sky130_fd_pr__nfet_01v8 L=0.15 W=0.42 nf=1 ad=0.1218 as=0.1218 pd=1.42 ps=1.42 nrd=0.69047619047619  nrs=0.69047619047619 sa=0 sb=0 sd=0 mult=1 m=1
csn_op1_1000_baseline_analog_2 sn_op1_1000_baseline_analog_2 0 {C_SN}
XMWR_op1_1000_baseline_analog_3 sn_op1_1000_baseline_analog_3 wwl_des wbl_op1_1000_baseline_analog 0 sky130_fd_pr__nfet_01v8 L=0.15 W=0.42 nf=1 ad=0.1218 as=0.1218 pd=1.42 ps=1.42 nrd=0.69047619047619  nrs=0.69047619047619 sa=0 sb=0 sd=0 mult=1 m=1
XMRD_op1_1000_baseline_analog_3 rbl_op1_1000_baseline_analog sn_op1_1000_baseline_analog_3 rwl_des 0 sky130_fd_pr__nfet_01v8 L=0.15 W=0.42 nf=1 ad=0.1218 as=0.1218 pd=1.42 ps=1.42 nrd=0.69047619047619  nrs=0.69047619047619 sa=0 sb=0 sd=0 mult=1 m=1
csn_op1_1000_baseline_analog_3 sn_op1_1000_baseline_analog_3 0 {C_SN}
XMN1_op1_1000_baseline_analog rbl_op1_1000_baseline_analog ref_op1_1000_baseline_analog vn_op1_1000_baseline_analog 0 sky130_fd_pr__nfet_01v8 L=0.15 W=1 nf=1 ad=0.29 as=0.29 pd=2.58 ps=2.58 mult=1 m=1
XMN2_op1_1000_baseline_analog ref_op1_1000_baseline_analog rbl_op1_1000_baseline_analog vn_op1_1000_baseline_analog 0 sky130_fd_pr__nfet_01v8 L=0.15 W=1 nf=1 ad=0.29 as=0.29 pd=2.58 ps=2.58 mult=1 m=1
XMP1_op1_1000_baseline_analog rbl_op1_1000_baseline_analog ref_op1_1000_baseline_analog vp_op1_1000_baseline_analog vdd sky130_fd_pr__pfet_01v8 L=0.15 W=2 nf=1 ad=0.58 as=0.58 pd=4.58 ps=4.58 mult=1 m=1
XMP2_op1_1000_baseline_analog ref_op1_1000_baseline_analog rbl_op1_1000_baseline_analog vp_op1_1000_baseline_analog vdd sky130_fd_pr__pfet_01v8 L=0.15 W=2 nf=1 ad=0.58 as=0.58 pd=4.58 ps=4.58 mult=1 m=1
XMNF_op1_1000_baseline_analog vn_op1_1000_baseline_analog en_op1_1000_baseline_analog 0 0 sky130_fd_pr__nfet_01v8 L=0.15 W=2 nf=1 ad=0.58 as=0.58 pd=4.58 ps=4.58 mult=1 m=1
XMPH_op1_1000_baseline_analog vp_op1_1000_baseline_analog enb_op1_1000_baseline_analog vdd vdd sky130_fd_pr__pfet_01v8 L=0.15 W=4 nf=1 ad=1.16 as=1.16 pd=8.58 ps=8.58 mult=1 m=1
bd_op1_1000_baseline_analog d_op1_1000_baseline_analog 0 v=v(rbl_op1_1000_baseline_analog)-v(ref_op1_1000_baseline_analog)

* ---- instance 2: op0_n100_baseline_analog (variant baseline_analog; probe dec 14.9 ns, release 37 ns, meas 39 ns) ----
vctl_op0_n100_baseline_analog ctl_op0_n100_baseline_analog 0 pwl(0.0000e+00 {VDD} 2.0000e-09 {VDD} 2.1000e-09 0)
vrs_op0_n100_baseline_analog rwls_op0_n100_baseline_analog 0 pwl(0.0000e+00 {VDD} 4.0000e-09 {VDD} 4.1000e-09 0 3.7000e-08 0 3.7100e-08 {VDD})
ven_op0_n100_baseline_analog en_op0_n100_baseline_analog 0 pwl(0.0000e+00 0 1.4000e-08 0 1.4100e-08 {VDD} 3.7000e-08 {VDD} 3.7100e-08 0)
venb_op0_n100_baseline_analog enb_op0_n100_baseline_analog 0 pwl(0.0000e+00 {VDD} 1.4000e-08 {VDD} 1.4100e-08 0 3.7000e-08 0 3.7100e-08 {VDD})
vww_op0_n100_baseline_analog wwl_op0_n100_baseline_analog 0 pwl(0.0000e+00 0 1.5000e-08 0 1.5100e-08 {VDD} 3.5000e-08 {VDD} 3.5100e-08 0)
vwc_op0_n100_baseline_analog wbc_op0_n100_baseline_analog 0 pwl(0.0000e+00 0 1.5000e-08 0 1.5100e-08 {VDD} 3.7000e-08 {VDD} 3.7100e-08 0)
swb_op0_n100_baseline_analog ref_op0_n100_baseline_analog wbl_op0_n100_baseline_analog wbc_op0_n100_baseline_analog 0 swwbl
cwbl_op0_n100_baseline_analog wbl_op0_n100_baseline_analog 0 {C_WBL}
spa_op0_n100_baseline_analog prea rbl_op0_n100_baseline_analog ctl_op0_n100_baseline_analog 0 swpre
spr_op0_n100_baseline_analog pref ref_op0_n100_baseline_analog ctl_op0_n100_baseline_analog 0 swpre
crbl_op0_n100_baseline_analog rbl_op0_n100_baseline_analog 0 {C_RBL}
cref_op0_n100_baseline_analog ref_op0_n100_baseline_analog 0 {C_RBL}   $ ASSUMPTION: ideal matched dummy load
XMWR_op0_n100_baseline_analog_0 sn_op0_n100_baseline_analog_0 wwl_op0_n100_baseline_analog wbl_op0_n100_baseline_analog 0 sky130_fd_pr__nfet_01v8 L=0.15 W=0.42 nf=1 ad=0.1218 as=0.1218 pd=1.42 ps=1.42 nrd=0.69047619047619  nrs=0.69047619047619 sa=0 sb=0 sd=0 mult=1 m=1
XMRD_op0_n100_baseline_analog_0 rbl_op0_n100_baseline_analog sn_op0_n100_baseline_analog_0 rwls_op0_n100_baseline_analog 0 sky130_fd_pr__nfet_01v8 L=0.15 W=0.42 nf=1 ad=0.1218 as=0.1218 pd=1.42 ps=1.42 nrd=0.69047619047619  nrs=0.69047619047619 sa=0 sb=0 sd=0 mult=1 m=1
csn_op0_n100_baseline_analog_0 sn_op0_n100_baseline_analog_0 0 {C_SN}
XMWR_op0_n100_baseline_analog_1 sn_op0_n100_baseline_analog_1 wwl_des wbl_op0_n100_baseline_analog 0 sky130_fd_pr__nfet_01v8 L=0.15 W=0.42 nf=1 ad=0.1218 as=0.1218 pd=1.42 ps=1.42 nrd=0.69047619047619  nrs=0.69047619047619 sa=0 sb=0 sd=0 mult=1 m=1
XMRD_op0_n100_baseline_analog_1 rbl_op0_n100_baseline_analog sn_op0_n100_baseline_analog_1 rwl_des 0 sky130_fd_pr__nfet_01v8 L=0.15 W=0.42 nf=1 ad=0.1218 as=0.1218 pd=1.42 ps=1.42 nrd=0.69047619047619  nrs=0.69047619047619 sa=0 sb=0 sd=0 mult=1 m=1
csn_op0_n100_baseline_analog_1 sn_op0_n100_baseline_analog_1 0 {C_SN}
XMWR_op0_n100_baseline_analog_2 sn_op0_n100_baseline_analog_2 wwl_des wbl_op0_n100_baseline_analog 0 sky130_fd_pr__nfet_01v8 L=0.15 W=0.42 nf=1 ad=0.1218 as=0.1218 pd=1.42 ps=1.42 nrd=0.69047619047619  nrs=0.69047619047619 sa=0 sb=0 sd=0 mult=1 m=1
XMRD_op0_n100_baseline_analog_2 rbl_op0_n100_baseline_analog sn_op0_n100_baseline_analog_2 rwl_des 0 sky130_fd_pr__nfet_01v8 L=0.15 W=0.42 nf=1 ad=0.1218 as=0.1218 pd=1.42 ps=1.42 nrd=0.69047619047619  nrs=0.69047619047619 sa=0 sb=0 sd=0 mult=1 m=1
csn_op0_n100_baseline_analog_2 sn_op0_n100_baseline_analog_2 0 {C_SN}
XMWR_op0_n100_baseline_analog_3 sn_op0_n100_baseline_analog_3 wwl_des wbl_op0_n100_baseline_analog 0 sky130_fd_pr__nfet_01v8 L=0.15 W=0.42 nf=1 ad=0.1218 as=0.1218 pd=1.42 ps=1.42 nrd=0.69047619047619  nrs=0.69047619047619 sa=0 sb=0 sd=0 mult=1 m=1
XMRD_op0_n100_baseline_analog_3 rbl_op0_n100_baseline_analog sn_op0_n100_baseline_analog_3 rwl_des 0 sky130_fd_pr__nfet_01v8 L=0.15 W=0.42 nf=1 ad=0.1218 as=0.1218 pd=1.42 ps=1.42 nrd=0.69047619047619  nrs=0.69047619047619 sa=0 sb=0 sd=0 mult=1 m=1
csn_op0_n100_baseline_analog_3 sn_op0_n100_baseline_analog_3 0 {C_SN}
XMN1_op0_n100_baseline_analog rbl_op0_n100_baseline_analog ref_op0_n100_baseline_analog vn_op0_n100_baseline_analog 0 sky130_fd_pr__nfet_01v8 L=0.15 W=1 nf=1 ad=0.29 as=0.29 pd=2.58 ps=2.58 mult=1 m=1
XMN2_op0_n100_baseline_analog ref_op0_n100_baseline_analog rbl_op0_n100_baseline_analog vn_op0_n100_baseline_analog 0 sky130_fd_pr__nfet_01v8 L=0.15 W=1 nf=1 ad=0.29 as=0.29 pd=2.58 ps=2.58 mult=1 m=1
XMP1_op0_n100_baseline_analog rbl_op0_n100_baseline_analog ref_op0_n100_baseline_analog vp_op0_n100_baseline_analog vdd sky130_fd_pr__pfet_01v8 L=0.15 W=2 nf=1 ad=0.58 as=0.58 pd=4.58 ps=4.58 mult=1 m=1
XMP2_op0_n100_baseline_analog ref_op0_n100_baseline_analog rbl_op0_n100_baseline_analog vp_op0_n100_baseline_analog vdd sky130_fd_pr__pfet_01v8 L=0.15 W=2 nf=1 ad=0.58 as=0.58 pd=4.58 ps=4.58 mult=1 m=1
XMNF_op0_n100_baseline_analog vn_op0_n100_baseline_analog en_op0_n100_baseline_analog 0 0 sky130_fd_pr__nfet_01v8 L=0.15 W=2 nf=1 ad=0.58 as=0.58 pd=4.58 ps=4.58 mult=1 m=1
XMPH_op0_n100_baseline_analog vp_op0_n100_baseline_analog enb_op0_n100_baseline_analog vdd vdd sky130_fd_pr__pfet_01v8 L=0.15 W=4 nf=1 ad=1.16 as=1.16 pd=8.58 ps=8.58 mult=1 m=1
bd_op0_n100_baseline_analog d_op0_n100_baseline_analog 0 v=v(rbl_op0_n100_baseline_analog)-v(ref_op0_n100_baseline_analog)

* ---- instance 3: op0_0000_baseline_analog (variant baseline_analog; probe dec 14.9 ns, release 37 ns, meas 39 ns) ----
vctl_op0_0000_baseline_analog ctl_op0_0000_baseline_analog 0 pwl(0.0000e+00 {VDD} 2.0000e-09 {VDD} 2.1000e-09 0)
vrs_op0_0000_baseline_analog rwls_op0_0000_baseline_analog 0 pwl(0.0000e+00 {VDD} 4.0000e-09 {VDD} 4.1000e-09 0 3.7000e-08 0 3.7100e-08 {VDD})
ven_op0_0000_baseline_analog en_op0_0000_baseline_analog 0 pwl(0.0000e+00 0 1.4000e-08 0 1.4100e-08 {VDD} 3.7000e-08 {VDD} 3.7100e-08 0)
venb_op0_0000_baseline_analog enb_op0_0000_baseline_analog 0 pwl(0.0000e+00 {VDD} 1.4000e-08 {VDD} 1.4100e-08 0 3.7000e-08 0 3.7100e-08 {VDD})
vww_op0_0000_baseline_analog wwl_op0_0000_baseline_analog 0 pwl(0.0000e+00 0 1.5000e-08 0 1.5100e-08 {VDD} 3.5000e-08 {VDD} 3.5100e-08 0)
vwc_op0_0000_baseline_analog wbc_op0_0000_baseline_analog 0 pwl(0.0000e+00 0 1.5000e-08 0 1.5100e-08 {VDD} 3.7000e-08 {VDD} 3.7100e-08 0)
swb_op0_0000_baseline_analog ref_op0_0000_baseline_analog wbl_op0_0000_baseline_analog wbc_op0_0000_baseline_analog 0 swwbl
cwbl_op0_0000_baseline_analog wbl_op0_0000_baseline_analog 0 {C_WBL}
spa_op0_0000_baseline_analog prea rbl_op0_0000_baseline_analog ctl_op0_0000_baseline_analog 0 swpre
spr_op0_0000_baseline_analog pref ref_op0_0000_baseline_analog ctl_op0_0000_baseline_analog 0 swpre
crbl_op0_0000_baseline_analog rbl_op0_0000_baseline_analog 0 {C_RBL}
cref_op0_0000_baseline_analog ref_op0_0000_baseline_analog 0 {C_RBL}   $ ASSUMPTION: ideal matched dummy load
XMWR_op0_0000_baseline_analog_0 sn_op0_0000_baseline_analog_0 wwl_op0_0000_baseline_analog wbl_op0_0000_baseline_analog 0 sky130_fd_pr__nfet_01v8 L=0.15 W=0.42 nf=1 ad=0.1218 as=0.1218 pd=1.42 ps=1.42 nrd=0.69047619047619  nrs=0.69047619047619 sa=0 sb=0 sd=0 mult=1 m=1
XMRD_op0_0000_baseline_analog_0 rbl_op0_0000_baseline_analog sn_op0_0000_baseline_analog_0 rwls_op0_0000_baseline_analog 0 sky130_fd_pr__nfet_01v8 L=0.15 W=0.42 nf=1 ad=0.1218 as=0.1218 pd=1.42 ps=1.42 nrd=0.69047619047619  nrs=0.69047619047619 sa=0 sb=0 sd=0 mult=1 m=1
csn_op0_0000_baseline_analog_0 sn_op0_0000_baseline_analog_0 0 {C_SN}
XMWR_op0_0000_baseline_analog_1 sn_op0_0000_baseline_analog_1 wwl_des wbl_op0_0000_baseline_analog 0 sky130_fd_pr__nfet_01v8 L=0.15 W=0.42 nf=1 ad=0.1218 as=0.1218 pd=1.42 ps=1.42 nrd=0.69047619047619  nrs=0.69047619047619 sa=0 sb=0 sd=0 mult=1 m=1
XMRD_op0_0000_baseline_analog_1 rbl_op0_0000_baseline_analog sn_op0_0000_baseline_analog_1 rwl_des 0 sky130_fd_pr__nfet_01v8 L=0.15 W=0.42 nf=1 ad=0.1218 as=0.1218 pd=1.42 ps=1.42 nrd=0.69047619047619  nrs=0.69047619047619 sa=0 sb=0 sd=0 mult=1 m=1
csn_op0_0000_baseline_analog_1 sn_op0_0000_baseline_analog_1 0 {C_SN}
XMWR_op0_0000_baseline_analog_2 sn_op0_0000_baseline_analog_2 wwl_des wbl_op0_0000_baseline_analog 0 sky130_fd_pr__nfet_01v8 L=0.15 W=0.42 nf=1 ad=0.1218 as=0.1218 pd=1.42 ps=1.42 nrd=0.69047619047619  nrs=0.69047619047619 sa=0 sb=0 sd=0 mult=1 m=1
XMRD_op0_0000_baseline_analog_2 rbl_op0_0000_baseline_analog sn_op0_0000_baseline_analog_2 rwl_des 0 sky130_fd_pr__nfet_01v8 L=0.15 W=0.42 nf=1 ad=0.1218 as=0.1218 pd=1.42 ps=1.42 nrd=0.69047619047619  nrs=0.69047619047619 sa=0 sb=0 sd=0 mult=1 m=1
csn_op0_0000_baseline_analog_2 sn_op0_0000_baseline_analog_2 0 {C_SN}
XMWR_op0_0000_baseline_analog_3 sn_op0_0000_baseline_analog_3 wwl_des wbl_op0_0000_baseline_analog 0 sky130_fd_pr__nfet_01v8 L=0.15 W=0.42 nf=1 ad=0.1218 as=0.1218 pd=1.42 ps=1.42 nrd=0.69047619047619  nrs=0.69047619047619 sa=0 sb=0 sd=0 mult=1 m=1
XMRD_op0_0000_baseline_analog_3 rbl_op0_0000_baseline_analog sn_op0_0000_baseline_analog_3 rwl_des 0 sky130_fd_pr__nfet_01v8 L=0.15 W=0.42 nf=1 ad=0.1218 as=0.1218 pd=1.42 ps=1.42 nrd=0.69047619047619  nrs=0.69047619047619 sa=0 sb=0 sd=0 mult=1 m=1
csn_op0_0000_baseline_analog_3 sn_op0_0000_baseline_analog_3 0 {C_SN}
XMN1_op0_0000_baseline_analog rbl_op0_0000_baseline_analog ref_op0_0000_baseline_analog vn_op0_0000_baseline_analog 0 sky130_fd_pr__nfet_01v8 L=0.15 W=1 nf=1 ad=0.29 as=0.29 pd=2.58 ps=2.58 mult=1 m=1
XMN2_op0_0000_baseline_analog ref_op0_0000_baseline_analog rbl_op0_0000_baseline_analog vn_op0_0000_baseline_analog 0 sky130_fd_pr__nfet_01v8 L=0.15 W=1 nf=1 ad=0.29 as=0.29 pd=2.58 ps=2.58 mult=1 m=1
XMP1_op0_0000_baseline_analog rbl_op0_0000_baseline_analog ref_op0_0000_baseline_analog vp_op0_0000_baseline_analog vdd sky130_fd_pr__pfet_01v8 L=0.15 W=2 nf=1 ad=0.58 as=0.58 pd=4.58 ps=4.58 mult=1 m=1
XMP2_op0_0000_baseline_analog ref_op0_0000_baseline_analog rbl_op0_0000_baseline_analog vp_op0_0000_baseline_analog vdd sky130_fd_pr__pfet_01v8 L=0.15 W=2 nf=1 ad=0.58 as=0.58 pd=4.58 ps=4.58 mult=1 m=1
XMNF_op0_0000_baseline_analog vn_op0_0000_baseline_analog en_op0_0000_baseline_analog 0 0 sky130_fd_pr__nfet_01v8 L=0.15 W=2 nf=1 ad=0.58 as=0.58 pd=4.58 ps=4.58 mult=1 m=1
XMPH_op0_0000_baseline_analog vp_op0_0000_baseline_analog enb_op0_0000_baseline_analog vdd vdd sky130_fd_pr__pfet_01v8 L=0.15 W=4 nf=1 ad=1.16 as=1.16 pd=8.58 ps=8.58 mult=1 m=1
bd_op0_0000_baseline_analog d_op0_0000_baseline_analog 0 v=v(rbl_op0_0000_baseline_analog)-v(ref_op0_0000_baseline_analog)

* ---- instance 4: op1_0900_rtl_raw (variant rtl_raw; probe dec 11.9 ns, release 34 ns, meas 36 ns) ----
vctl_op1_0900_rtl_raw ctl_op1_0900_rtl_raw 0 pwl(0.0000e+00 {VDD} 2.0000e-09 {VDD} 2.1000e-09 0)
vrs_op1_0900_rtl_raw rwls_op1_0900_rtl_raw 0 pwl(0.0000e+00 {VDD} 2.0000e-09 {VDD} 2.1000e-09 0 1.2000e-08 0 1.2100e-08 {VDD})
ven_op1_0900_rtl_raw en_op1_0900_rtl_raw 0 pwl(0.0000e+00 0 1.1000e-08 0 1.1100e-08 {VDD} 1.2000e-08 {VDD} 1.2100e-08 0)
venb_op1_0900_rtl_raw enb_op1_0900_rtl_raw 0 pwl(0.0000e+00 {VDD} 1.1000e-08 {VDD} 1.1100e-08 0 1.2000e-08 0 1.2100e-08 {VDD})
vww_op1_0900_rtl_raw wwl_op1_0900_rtl_raw 0 pwl(0.0000e+00 0 1.2000e-08 0 1.2100e-08 {VDD} 3.2000e-08 {VDD} 3.2100e-08 0)
vwc_op1_0900_rtl_raw wbc_op1_0900_rtl_raw 0 pwl(0.0000e+00 0 1.2000e-08 0 1.2100e-08 {VDD} 3.4000e-08 {VDD} 3.4100e-08 0)
swb_op1_0900_rtl_raw ref_op1_0900_rtl_raw wbl_op1_0900_rtl_raw wbc_op1_0900_rtl_raw 0 swwbl
cwbl_op1_0900_rtl_raw wbl_op1_0900_rtl_raw 0 {C_WBL}
spa_op1_0900_rtl_raw prea rbl_op1_0900_rtl_raw ctl_op1_0900_rtl_raw 0 swpre
spr_op1_0900_rtl_raw pref ref_op1_0900_rtl_raw ctl_op1_0900_rtl_raw 0 swpre
crbl_op1_0900_rtl_raw rbl_op1_0900_rtl_raw 0 {C_RBL}
cref_op1_0900_rtl_raw ref_op1_0900_rtl_raw 0 {C_RBL}   $ ASSUMPTION: ideal matched dummy load
XMWR_op1_0900_rtl_raw_0 sn_op1_0900_rtl_raw_0 wwl_op1_0900_rtl_raw wbl_op1_0900_rtl_raw 0 sky130_fd_pr__nfet_01v8 L=0.15 W=0.42 nf=1 ad=0.1218 as=0.1218 pd=1.42 ps=1.42 nrd=0.69047619047619  nrs=0.69047619047619 sa=0 sb=0 sd=0 mult=1 m=1
XMRD_op1_0900_rtl_raw_0 rbl_op1_0900_rtl_raw sn_op1_0900_rtl_raw_0 rwls_op1_0900_rtl_raw 0 sky130_fd_pr__nfet_01v8 L=0.15 W=0.42 nf=1 ad=0.1218 as=0.1218 pd=1.42 ps=1.42 nrd=0.69047619047619  nrs=0.69047619047619 sa=0 sb=0 sd=0 mult=1 m=1
csn_op1_0900_rtl_raw_0 sn_op1_0900_rtl_raw_0 0 {C_SN}
XMWR_op1_0900_rtl_raw_1 sn_op1_0900_rtl_raw_1 wwl_des wbl_op1_0900_rtl_raw 0 sky130_fd_pr__nfet_01v8 L=0.15 W=0.42 nf=1 ad=0.1218 as=0.1218 pd=1.42 ps=1.42 nrd=0.69047619047619  nrs=0.69047619047619 sa=0 sb=0 sd=0 mult=1 m=1
XMRD_op1_0900_rtl_raw_1 rbl_op1_0900_rtl_raw sn_op1_0900_rtl_raw_1 rwl_des 0 sky130_fd_pr__nfet_01v8 L=0.15 W=0.42 nf=1 ad=0.1218 as=0.1218 pd=1.42 ps=1.42 nrd=0.69047619047619  nrs=0.69047619047619 sa=0 sb=0 sd=0 mult=1 m=1
csn_op1_0900_rtl_raw_1 sn_op1_0900_rtl_raw_1 0 {C_SN}
XMWR_op1_0900_rtl_raw_2 sn_op1_0900_rtl_raw_2 wwl_des wbl_op1_0900_rtl_raw 0 sky130_fd_pr__nfet_01v8 L=0.15 W=0.42 nf=1 ad=0.1218 as=0.1218 pd=1.42 ps=1.42 nrd=0.69047619047619  nrs=0.69047619047619 sa=0 sb=0 sd=0 mult=1 m=1
XMRD_op1_0900_rtl_raw_2 rbl_op1_0900_rtl_raw sn_op1_0900_rtl_raw_2 rwl_des 0 sky130_fd_pr__nfet_01v8 L=0.15 W=0.42 nf=1 ad=0.1218 as=0.1218 pd=1.42 ps=1.42 nrd=0.69047619047619  nrs=0.69047619047619 sa=0 sb=0 sd=0 mult=1 m=1
csn_op1_0900_rtl_raw_2 sn_op1_0900_rtl_raw_2 0 {C_SN}
XMWR_op1_0900_rtl_raw_3 sn_op1_0900_rtl_raw_3 wwl_des wbl_op1_0900_rtl_raw 0 sky130_fd_pr__nfet_01v8 L=0.15 W=0.42 nf=1 ad=0.1218 as=0.1218 pd=1.42 ps=1.42 nrd=0.69047619047619  nrs=0.69047619047619 sa=0 sb=0 sd=0 mult=1 m=1
XMRD_op1_0900_rtl_raw_3 rbl_op1_0900_rtl_raw sn_op1_0900_rtl_raw_3 rwl_des 0 sky130_fd_pr__nfet_01v8 L=0.15 W=0.42 nf=1 ad=0.1218 as=0.1218 pd=1.42 ps=1.42 nrd=0.69047619047619  nrs=0.69047619047619 sa=0 sb=0 sd=0 mult=1 m=1
csn_op1_0900_rtl_raw_3 sn_op1_0900_rtl_raw_3 0 {C_SN}
XMN1_op1_0900_rtl_raw rbl_op1_0900_rtl_raw ref_op1_0900_rtl_raw vn_op1_0900_rtl_raw 0 sky130_fd_pr__nfet_01v8 L=0.15 W=1 nf=1 ad=0.29 as=0.29 pd=2.58 ps=2.58 mult=1 m=1
XMN2_op1_0900_rtl_raw ref_op1_0900_rtl_raw rbl_op1_0900_rtl_raw vn_op1_0900_rtl_raw 0 sky130_fd_pr__nfet_01v8 L=0.15 W=1 nf=1 ad=0.29 as=0.29 pd=2.58 ps=2.58 mult=1 m=1
XMP1_op1_0900_rtl_raw rbl_op1_0900_rtl_raw ref_op1_0900_rtl_raw vp_op1_0900_rtl_raw vdd sky130_fd_pr__pfet_01v8 L=0.15 W=2 nf=1 ad=0.58 as=0.58 pd=4.58 ps=4.58 mult=1 m=1
XMP2_op1_0900_rtl_raw ref_op1_0900_rtl_raw rbl_op1_0900_rtl_raw vp_op1_0900_rtl_raw vdd sky130_fd_pr__pfet_01v8 L=0.15 W=2 nf=1 ad=0.58 as=0.58 pd=4.58 ps=4.58 mult=1 m=1
XMNF_op1_0900_rtl_raw vn_op1_0900_rtl_raw en_op1_0900_rtl_raw 0 0 sky130_fd_pr__nfet_01v8 L=0.15 W=2 nf=1 ad=0.58 as=0.58 pd=4.58 ps=4.58 mult=1 m=1
XMPH_op1_0900_rtl_raw vp_op1_0900_rtl_raw enb_op1_0900_rtl_raw vdd vdd sky130_fd_pr__pfet_01v8 L=0.15 W=4 nf=1 ad=1.16 as=1.16 pd=8.58 ps=8.58 mult=1 m=1
bd_op1_0900_rtl_raw d_op1_0900_rtl_raw 0 v=v(rbl_op1_0900_rtl_raw)-v(ref_op1_0900_rtl_raw)

* ---- instance 5: op1_1000_rtl_raw (variant rtl_raw; probe dec 11.9 ns, release 34 ns, meas 36 ns) ----
vctl_op1_1000_rtl_raw ctl_op1_1000_rtl_raw 0 pwl(0.0000e+00 {VDD} 2.0000e-09 {VDD} 2.1000e-09 0)
vrs_op1_1000_rtl_raw rwls_op1_1000_rtl_raw 0 pwl(0.0000e+00 {VDD} 2.0000e-09 {VDD} 2.1000e-09 0 1.2000e-08 0 1.2100e-08 {VDD})
ven_op1_1000_rtl_raw en_op1_1000_rtl_raw 0 pwl(0.0000e+00 0 1.1000e-08 0 1.1100e-08 {VDD} 1.2000e-08 {VDD} 1.2100e-08 0)
venb_op1_1000_rtl_raw enb_op1_1000_rtl_raw 0 pwl(0.0000e+00 {VDD} 1.1000e-08 {VDD} 1.1100e-08 0 1.2000e-08 0 1.2100e-08 {VDD})
vww_op1_1000_rtl_raw wwl_op1_1000_rtl_raw 0 pwl(0.0000e+00 0 1.2000e-08 0 1.2100e-08 {VDD} 3.2000e-08 {VDD} 3.2100e-08 0)
vwc_op1_1000_rtl_raw wbc_op1_1000_rtl_raw 0 pwl(0.0000e+00 0 1.2000e-08 0 1.2100e-08 {VDD} 3.4000e-08 {VDD} 3.4100e-08 0)
swb_op1_1000_rtl_raw ref_op1_1000_rtl_raw wbl_op1_1000_rtl_raw wbc_op1_1000_rtl_raw 0 swwbl
cwbl_op1_1000_rtl_raw wbl_op1_1000_rtl_raw 0 {C_WBL}
spa_op1_1000_rtl_raw prea rbl_op1_1000_rtl_raw ctl_op1_1000_rtl_raw 0 swpre
spr_op1_1000_rtl_raw pref ref_op1_1000_rtl_raw ctl_op1_1000_rtl_raw 0 swpre
crbl_op1_1000_rtl_raw rbl_op1_1000_rtl_raw 0 {C_RBL}
cref_op1_1000_rtl_raw ref_op1_1000_rtl_raw 0 {C_RBL}   $ ASSUMPTION: ideal matched dummy load
XMWR_op1_1000_rtl_raw_0 sn_op1_1000_rtl_raw_0 wwl_op1_1000_rtl_raw wbl_op1_1000_rtl_raw 0 sky130_fd_pr__nfet_01v8 L=0.15 W=0.42 nf=1 ad=0.1218 as=0.1218 pd=1.42 ps=1.42 nrd=0.69047619047619  nrs=0.69047619047619 sa=0 sb=0 sd=0 mult=1 m=1
XMRD_op1_1000_rtl_raw_0 rbl_op1_1000_rtl_raw sn_op1_1000_rtl_raw_0 rwls_op1_1000_rtl_raw 0 sky130_fd_pr__nfet_01v8 L=0.15 W=0.42 nf=1 ad=0.1218 as=0.1218 pd=1.42 ps=1.42 nrd=0.69047619047619  nrs=0.69047619047619 sa=0 sb=0 sd=0 mult=1 m=1
csn_op1_1000_rtl_raw_0 sn_op1_1000_rtl_raw_0 0 {C_SN}
XMWR_op1_1000_rtl_raw_1 sn_op1_1000_rtl_raw_1 wwl_des wbl_op1_1000_rtl_raw 0 sky130_fd_pr__nfet_01v8 L=0.15 W=0.42 nf=1 ad=0.1218 as=0.1218 pd=1.42 ps=1.42 nrd=0.69047619047619  nrs=0.69047619047619 sa=0 sb=0 sd=0 mult=1 m=1
XMRD_op1_1000_rtl_raw_1 rbl_op1_1000_rtl_raw sn_op1_1000_rtl_raw_1 rwl_des 0 sky130_fd_pr__nfet_01v8 L=0.15 W=0.42 nf=1 ad=0.1218 as=0.1218 pd=1.42 ps=1.42 nrd=0.69047619047619  nrs=0.69047619047619 sa=0 sb=0 sd=0 mult=1 m=1
csn_op1_1000_rtl_raw_1 sn_op1_1000_rtl_raw_1 0 {C_SN}
XMWR_op1_1000_rtl_raw_2 sn_op1_1000_rtl_raw_2 wwl_des wbl_op1_1000_rtl_raw 0 sky130_fd_pr__nfet_01v8 L=0.15 W=0.42 nf=1 ad=0.1218 as=0.1218 pd=1.42 ps=1.42 nrd=0.69047619047619  nrs=0.69047619047619 sa=0 sb=0 sd=0 mult=1 m=1
XMRD_op1_1000_rtl_raw_2 rbl_op1_1000_rtl_raw sn_op1_1000_rtl_raw_2 rwl_des 0 sky130_fd_pr__nfet_01v8 L=0.15 W=0.42 nf=1 ad=0.1218 as=0.1218 pd=1.42 ps=1.42 nrd=0.69047619047619  nrs=0.69047619047619 sa=0 sb=0 sd=0 mult=1 m=1
csn_op1_1000_rtl_raw_2 sn_op1_1000_rtl_raw_2 0 {C_SN}
XMWR_op1_1000_rtl_raw_3 sn_op1_1000_rtl_raw_3 wwl_des wbl_op1_1000_rtl_raw 0 sky130_fd_pr__nfet_01v8 L=0.15 W=0.42 nf=1 ad=0.1218 as=0.1218 pd=1.42 ps=1.42 nrd=0.69047619047619  nrs=0.69047619047619 sa=0 sb=0 sd=0 mult=1 m=1
XMRD_op1_1000_rtl_raw_3 rbl_op1_1000_rtl_raw sn_op1_1000_rtl_raw_3 rwl_des 0 sky130_fd_pr__nfet_01v8 L=0.15 W=0.42 nf=1 ad=0.1218 as=0.1218 pd=1.42 ps=1.42 nrd=0.69047619047619  nrs=0.69047619047619 sa=0 sb=0 sd=0 mult=1 m=1
csn_op1_1000_rtl_raw_3 sn_op1_1000_rtl_raw_3 0 {C_SN}
XMN1_op1_1000_rtl_raw rbl_op1_1000_rtl_raw ref_op1_1000_rtl_raw vn_op1_1000_rtl_raw 0 sky130_fd_pr__nfet_01v8 L=0.15 W=1 nf=1 ad=0.29 as=0.29 pd=2.58 ps=2.58 mult=1 m=1
XMN2_op1_1000_rtl_raw ref_op1_1000_rtl_raw rbl_op1_1000_rtl_raw vn_op1_1000_rtl_raw 0 sky130_fd_pr__nfet_01v8 L=0.15 W=1 nf=1 ad=0.29 as=0.29 pd=2.58 ps=2.58 mult=1 m=1
XMP1_op1_1000_rtl_raw rbl_op1_1000_rtl_raw ref_op1_1000_rtl_raw vp_op1_1000_rtl_raw vdd sky130_fd_pr__pfet_01v8 L=0.15 W=2 nf=1 ad=0.58 as=0.58 pd=4.58 ps=4.58 mult=1 m=1
XMP2_op1_1000_rtl_raw ref_op1_1000_rtl_raw rbl_op1_1000_rtl_raw vp_op1_1000_rtl_raw vdd sky130_fd_pr__pfet_01v8 L=0.15 W=2 nf=1 ad=0.58 as=0.58 pd=4.58 ps=4.58 mult=1 m=1
XMNF_op1_1000_rtl_raw vn_op1_1000_rtl_raw en_op1_1000_rtl_raw 0 0 sky130_fd_pr__nfet_01v8 L=0.15 W=2 nf=1 ad=0.58 as=0.58 pd=4.58 ps=4.58 mult=1 m=1
XMPH_op1_1000_rtl_raw vp_op1_1000_rtl_raw enb_op1_1000_rtl_raw vdd vdd sky130_fd_pr__pfet_01v8 L=0.15 W=4 nf=1 ad=1.16 as=1.16 pd=8.58 ps=8.58 mult=1 m=1
bd_op1_1000_rtl_raw d_op1_1000_rtl_raw 0 v=v(rbl_op1_1000_rtl_raw)-v(ref_op1_1000_rtl_raw)

* ---- instance 6: op0_n100_rtl_raw (variant rtl_raw; probe dec 11.9 ns, release 34 ns, meas 36 ns) ----
vctl_op0_n100_rtl_raw ctl_op0_n100_rtl_raw 0 pwl(0.0000e+00 {VDD} 2.0000e-09 {VDD} 2.1000e-09 0)
vrs_op0_n100_rtl_raw rwls_op0_n100_rtl_raw 0 pwl(0.0000e+00 {VDD} 2.0000e-09 {VDD} 2.1000e-09 0 1.2000e-08 0 1.2100e-08 {VDD})
ven_op0_n100_rtl_raw en_op0_n100_rtl_raw 0 pwl(0.0000e+00 0 1.1000e-08 0 1.1100e-08 {VDD} 1.2000e-08 {VDD} 1.2100e-08 0)
venb_op0_n100_rtl_raw enb_op0_n100_rtl_raw 0 pwl(0.0000e+00 {VDD} 1.1000e-08 {VDD} 1.1100e-08 0 1.2000e-08 0 1.2100e-08 {VDD})
vww_op0_n100_rtl_raw wwl_op0_n100_rtl_raw 0 pwl(0.0000e+00 0 1.2000e-08 0 1.2100e-08 {VDD} 3.2000e-08 {VDD} 3.2100e-08 0)
vwc_op0_n100_rtl_raw wbc_op0_n100_rtl_raw 0 pwl(0.0000e+00 0 1.2000e-08 0 1.2100e-08 {VDD} 3.4000e-08 {VDD} 3.4100e-08 0)
swb_op0_n100_rtl_raw ref_op0_n100_rtl_raw wbl_op0_n100_rtl_raw wbc_op0_n100_rtl_raw 0 swwbl
cwbl_op0_n100_rtl_raw wbl_op0_n100_rtl_raw 0 {C_WBL}
spa_op0_n100_rtl_raw prea rbl_op0_n100_rtl_raw ctl_op0_n100_rtl_raw 0 swpre
spr_op0_n100_rtl_raw pref ref_op0_n100_rtl_raw ctl_op0_n100_rtl_raw 0 swpre
crbl_op0_n100_rtl_raw rbl_op0_n100_rtl_raw 0 {C_RBL}
cref_op0_n100_rtl_raw ref_op0_n100_rtl_raw 0 {C_RBL}   $ ASSUMPTION: ideal matched dummy load
XMWR_op0_n100_rtl_raw_0 sn_op0_n100_rtl_raw_0 wwl_op0_n100_rtl_raw wbl_op0_n100_rtl_raw 0 sky130_fd_pr__nfet_01v8 L=0.15 W=0.42 nf=1 ad=0.1218 as=0.1218 pd=1.42 ps=1.42 nrd=0.69047619047619  nrs=0.69047619047619 sa=0 sb=0 sd=0 mult=1 m=1
XMRD_op0_n100_rtl_raw_0 rbl_op0_n100_rtl_raw sn_op0_n100_rtl_raw_0 rwls_op0_n100_rtl_raw 0 sky130_fd_pr__nfet_01v8 L=0.15 W=0.42 nf=1 ad=0.1218 as=0.1218 pd=1.42 ps=1.42 nrd=0.69047619047619  nrs=0.69047619047619 sa=0 sb=0 sd=0 mult=1 m=1
csn_op0_n100_rtl_raw_0 sn_op0_n100_rtl_raw_0 0 {C_SN}
XMWR_op0_n100_rtl_raw_1 sn_op0_n100_rtl_raw_1 wwl_des wbl_op0_n100_rtl_raw 0 sky130_fd_pr__nfet_01v8 L=0.15 W=0.42 nf=1 ad=0.1218 as=0.1218 pd=1.42 ps=1.42 nrd=0.69047619047619  nrs=0.69047619047619 sa=0 sb=0 sd=0 mult=1 m=1
XMRD_op0_n100_rtl_raw_1 rbl_op0_n100_rtl_raw sn_op0_n100_rtl_raw_1 rwl_des 0 sky130_fd_pr__nfet_01v8 L=0.15 W=0.42 nf=1 ad=0.1218 as=0.1218 pd=1.42 ps=1.42 nrd=0.69047619047619  nrs=0.69047619047619 sa=0 sb=0 sd=0 mult=1 m=1
csn_op0_n100_rtl_raw_1 sn_op0_n100_rtl_raw_1 0 {C_SN}
XMWR_op0_n100_rtl_raw_2 sn_op0_n100_rtl_raw_2 wwl_des wbl_op0_n100_rtl_raw 0 sky130_fd_pr__nfet_01v8 L=0.15 W=0.42 nf=1 ad=0.1218 as=0.1218 pd=1.42 ps=1.42 nrd=0.69047619047619  nrs=0.69047619047619 sa=0 sb=0 sd=0 mult=1 m=1
XMRD_op0_n100_rtl_raw_2 rbl_op0_n100_rtl_raw sn_op0_n100_rtl_raw_2 rwl_des 0 sky130_fd_pr__nfet_01v8 L=0.15 W=0.42 nf=1 ad=0.1218 as=0.1218 pd=1.42 ps=1.42 nrd=0.69047619047619  nrs=0.69047619047619 sa=0 sb=0 sd=0 mult=1 m=1
csn_op0_n100_rtl_raw_2 sn_op0_n100_rtl_raw_2 0 {C_SN}
XMWR_op0_n100_rtl_raw_3 sn_op0_n100_rtl_raw_3 wwl_des wbl_op0_n100_rtl_raw 0 sky130_fd_pr__nfet_01v8 L=0.15 W=0.42 nf=1 ad=0.1218 as=0.1218 pd=1.42 ps=1.42 nrd=0.69047619047619  nrs=0.69047619047619 sa=0 sb=0 sd=0 mult=1 m=1
XMRD_op0_n100_rtl_raw_3 rbl_op0_n100_rtl_raw sn_op0_n100_rtl_raw_3 rwl_des 0 sky130_fd_pr__nfet_01v8 L=0.15 W=0.42 nf=1 ad=0.1218 as=0.1218 pd=1.42 ps=1.42 nrd=0.69047619047619  nrs=0.69047619047619 sa=0 sb=0 sd=0 mult=1 m=1
csn_op0_n100_rtl_raw_3 sn_op0_n100_rtl_raw_3 0 {C_SN}
XMN1_op0_n100_rtl_raw rbl_op0_n100_rtl_raw ref_op0_n100_rtl_raw vn_op0_n100_rtl_raw 0 sky130_fd_pr__nfet_01v8 L=0.15 W=1 nf=1 ad=0.29 as=0.29 pd=2.58 ps=2.58 mult=1 m=1
XMN2_op0_n100_rtl_raw ref_op0_n100_rtl_raw rbl_op0_n100_rtl_raw vn_op0_n100_rtl_raw 0 sky130_fd_pr__nfet_01v8 L=0.15 W=1 nf=1 ad=0.29 as=0.29 pd=2.58 ps=2.58 mult=1 m=1
XMP1_op0_n100_rtl_raw rbl_op0_n100_rtl_raw ref_op0_n100_rtl_raw vp_op0_n100_rtl_raw vdd sky130_fd_pr__pfet_01v8 L=0.15 W=2 nf=1 ad=0.58 as=0.58 pd=4.58 ps=4.58 mult=1 m=1
XMP2_op0_n100_rtl_raw ref_op0_n100_rtl_raw rbl_op0_n100_rtl_raw vp_op0_n100_rtl_raw vdd sky130_fd_pr__pfet_01v8 L=0.15 W=2 nf=1 ad=0.58 as=0.58 pd=4.58 ps=4.58 mult=1 m=1
XMNF_op0_n100_rtl_raw vn_op0_n100_rtl_raw en_op0_n100_rtl_raw 0 0 sky130_fd_pr__nfet_01v8 L=0.15 W=2 nf=1 ad=0.58 as=0.58 pd=4.58 ps=4.58 mult=1 m=1
XMPH_op0_n100_rtl_raw vp_op0_n100_rtl_raw enb_op0_n100_rtl_raw vdd vdd sky130_fd_pr__pfet_01v8 L=0.15 W=4 nf=1 ad=1.16 as=1.16 pd=8.58 ps=8.58 mult=1 m=1
bd_op0_n100_rtl_raw d_op0_n100_rtl_raw 0 v=v(rbl_op0_n100_rtl_raw)-v(ref_op0_n100_rtl_raw)

* ---- instance 7: op0_0000_rtl_raw (variant rtl_raw; probe dec 11.9 ns, release 34 ns, meas 36 ns) ----
vctl_op0_0000_rtl_raw ctl_op0_0000_rtl_raw 0 pwl(0.0000e+00 {VDD} 2.0000e-09 {VDD} 2.1000e-09 0)
vrs_op0_0000_rtl_raw rwls_op0_0000_rtl_raw 0 pwl(0.0000e+00 {VDD} 2.0000e-09 {VDD} 2.1000e-09 0 1.2000e-08 0 1.2100e-08 {VDD})
ven_op0_0000_rtl_raw en_op0_0000_rtl_raw 0 pwl(0.0000e+00 0 1.1000e-08 0 1.1100e-08 {VDD} 1.2000e-08 {VDD} 1.2100e-08 0)
venb_op0_0000_rtl_raw enb_op0_0000_rtl_raw 0 pwl(0.0000e+00 {VDD} 1.1000e-08 {VDD} 1.1100e-08 0 1.2000e-08 0 1.2100e-08 {VDD})
vww_op0_0000_rtl_raw wwl_op0_0000_rtl_raw 0 pwl(0.0000e+00 0 1.2000e-08 0 1.2100e-08 {VDD} 3.2000e-08 {VDD} 3.2100e-08 0)
vwc_op0_0000_rtl_raw wbc_op0_0000_rtl_raw 0 pwl(0.0000e+00 0 1.2000e-08 0 1.2100e-08 {VDD} 3.4000e-08 {VDD} 3.4100e-08 0)
swb_op0_0000_rtl_raw ref_op0_0000_rtl_raw wbl_op0_0000_rtl_raw wbc_op0_0000_rtl_raw 0 swwbl
cwbl_op0_0000_rtl_raw wbl_op0_0000_rtl_raw 0 {C_WBL}
spa_op0_0000_rtl_raw prea rbl_op0_0000_rtl_raw ctl_op0_0000_rtl_raw 0 swpre
spr_op0_0000_rtl_raw pref ref_op0_0000_rtl_raw ctl_op0_0000_rtl_raw 0 swpre
crbl_op0_0000_rtl_raw rbl_op0_0000_rtl_raw 0 {C_RBL}
cref_op0_0000_rtl_raw ref_op0_0000_rtl_raw 0 {C_RBL}   $ ASSUMPTION: ideal matched dummy load
XMWR_op0_0000_rtl_raw_0 sn_op0_0000_rtl_raw_0 wwl_op0_0000_rtl_raw wbl_op0_0000_rtl_raw 0 sky130_fd_pr__nfet_01v8 L=0.15 W=0.42 nf=1 ad=0.1218 as=0.1218 pd=1.42 ps=1.42 nrd=0.69047619047619  nrs=0.69047619047619 sa=0 sb=0 sd=0 mult=1 m=1
XMRD_op0_0000_rtl_raw_0 rbl_op0_0000_rtl_raw sn_op0_0000_rtl_raw_0 rwls_op0_0000_rtl_raw 0 sky130_fd_pr__nfet_01v8 L=0.15 W=0.42 nf=1 ad=0.1218 as=0.1218 pd=1.42 ps=1.42 nrd=0.69047619047619  nrs=0.69047619047619 sa=0 sb=0 sd=0 mult=1 m=1
csn_op0_0000_rtl_raw_0 sn_op0_0000_rtl_raw_0 0 {C_SN}
XMWR_op0_0000_rtl_raw_1 sn_op0_0000_rtl_raw_1 wwl_des wbl_op0_0000_rtl_raw 0 sky130_fd_pr__nfet_01v8 L=0.15 W=0.42 nf=1 ad=0.1218 as=0.1218 pd=1.42 ps=1.42 nrd=0.69047619047619  nrs=0.69047619047619 sa=0 sb=0 sd=0 mult=1 m=1
XMRD_op0_0000_rtl_raw_1 rbl_op0_0000_rtl_raw sn_op0_0000_rtl_raw_1 rwl_des 0 sky130_fd_pr__nfet_01v8 L=0.15 W=0.42 nf=1 ad=0.1218 as=0.1218 pd=1.42 ps=1.42 nrd=0.69047619047619  nrs=0.69047619047619 sa=0 sb=0 sd=0 mult=1 m=1
csn_op0_0000_rtl_raw_1 sn_op0_0000_rtl_raw_1 0 {C_SN}
XMWR_op0_0000_rtl_raw_2 sn_op0_0000_rtl_raw_2 wwl_des wbl_op0_0000_rtl_raw 0 sky130_fd_pr__nfet_01v8 L=0.15 W=0.42 nf=1 ad=0.1218 as=0.1218 pd=1.42 ps=1.42 nrd=0.69047619047619  nrs=0.69047619047619 sa=0 sb=0 sd=0 mult=1 m=1
XMRD_op0_0000_rtl_raw_2 rbl_op0_0000_rtl_raw sn_op0_0000_rtl_raw_2 rwl_des 0 sky130_fd_pr__nfet_01v8 L=0.15 W=0.42 nf=1 ad=0.1218 as=0.1218 pd=1.42 ps=1.42 nrd=0.69047619047619  nrs=0.69047619047619 sa=0 sb=0 sd=0 mult=1 m=1
csn_op0_0000_rtl_raw_2 sn_op0_0000_rtl_raw_2 0 {C_SN}
XMWR_op0_0000_rtl_raw_3 sn_op0_0000_rtl_raw_3 wwl_des wbl_op0_0000_rtl_raw 0 sky130_fd_pr__nfet_01v8 L=0.15 W=0.42 nf=1 ad=0.1218 as=0.1218 pd=1.42 ps=1.42 nrd=0.69047619047619  nrs=0.69047619047619 sa=0 sb=0 sd=0 mult=1 m=1
XMRD_op0_0000_rtl_raw_3 rbl_op0_0000_rtl_raw sn_op0_0000_rtl_raw_3 rwl_des 0 sky130_fd_pr__nfet_01v8 L=0.15 W=0.42 nf=1 ad=0.1218 as=0.1218 pd=1.42 ps=1.42 nrd=0.69047619047619  nrs=0.69047619047619 sa=0 sb=0 sd=0 mult=1 m=1
csn_op0_0000_rtl_raw_3 sn_op0_0000_rtl_raw_3 0 {C_SN}
XMN1_op0_0000_rtl_raw rbl_op0_0000_rtl_raw ref_op0_0000_rtl_raw vn_op0_0000_rtl_raw 0 sky130_fd_pr__nfet_01v8 L=0.15 W=1 nf=1 ad=0.29 as=0.29 pd=2.58 ps=2.58 mult=1 m=1
XMN2_op0_0000_rtl_raw ref_op0_0000_rtl_raw rbl_op0_0000_rtl_raw vn_op0_0000_rtl_raw 0 sky130_fd_pr__nfet_01v8 L=0.15 W=1 nf=1 ad=0.29 as=0.29 pd=2.58 ps=2.58 mult=1 m=1
XMP1_op0_0000_rtl_raw rbl_op0_0000_rtl_raw ref_op0_0000_rtl_raw vp_op0_0000_rtl_raw vdd sky130_fd_pr__pfet_01v8 L=0.15 W=2 nf=1 ad=0.58 as=0.58 pd=4.58 ps=4.58 mult=1 m=1
XMP2_op0_0000_rtl_raw ref_op0_0000_rtl_raw rbl_op0_0000_rtl_raw vp_op0_0000_rtl_raw vdd sky130_fd_pr__pfet_01v8 L=0.15 W=2 nf=1 ad=0.58 as=0.58 pd=4.58 ps=4.58 mult=1 m=1
XMNF_op0_0000_rtl_raw vn_op0_0000_rtl_raw en_op0_0000_rtl_raw 0 0 sky130_fd_pr__nfet_01v8 L=0.15 W=2 nf=1 ad=0.58 as=0.58 pd=4.58 ps=4.58 mult=1 m=1
XMPH_op0_0000_rtl_raw vp_op0_0000_rtl_raw enb_op0_0000_rtl_raw vdd vdd sky130_fd_pr__pfet_01v8 L=0.15 W=4 nf=1 ad=1.16 as=1.16 pd=8.58 ps=8.58 mult=1 m=1
bd_op0_0000_rtl_raw d_op0_0000_rtl_raw 0 v=v(rbl_op0_0000_rtl_raw)-v(ref_op0_0000_rtl_raw)

* ---- instance 8: op1_0900_rtl_hold (variant rtl_hold; probe dec 11.9 ns, release 34 ns, meas 36 ns) ----
vctl_op1_0900_rtl_hold ctl_op1_0900_rtl_hold 0 pwl(0.0000e+00 {VDD} 2.0000e-09 {VDD} 2.1000e-09 0)
vrs_op1_0900_rtl_hold rwls_op1_0900_rtl_hold 0 pwl(0.0000e+00 {VDD} 2.0000e-09 {VDD} 2.1000e-09 0 1.2000e-08 0 1.2100e-08 {VDD})
ven_op1_0900_rtl_hold en_op1_0900_rtl_hold 0 pwl(0.0000e+00 0 1.1000e-08 0 1.1100e-08 {VDD} 3.4000e-08 {VDD} 3.4100e-08 0)
venb_op1_0900_rtl_hold enb_op1_0900_rtl_hold 0 pwl(0.0000e+00 {VDD} 1.1000e-08 {VDD} 1.1100e-08 0 3.4000e-08 0 3.4100e-08 {VDD})
vww_op1_0900_rtl_hold wwl_op1_0900_rtl_hold 0 pwl(0.0000e+00 0 1.2000e-08 0 1.2100e-08 {VDD} 3.2000e-08 {VDD} 3.2100e-08 0)
vwc_op1_0900_rtl_hold wbc_op1_0900_rtl_hold 0 pwl(0.0000e+00 0 1.2000e-08 0 1.2100e-08 {VDD} 3.4000e-08 {VDD} 3.4100e-08 0)
swb_op1_0900_rtl_hold ref_op1_0900_rtl_hold wbl_op1_0900_rtl_hold wbc_op1_0900_rtl_hold 0 swwbl
cwbl_op1_0900_rtl_hold wbl_op1_0900_rtl_hold 0 {C_WBL}
spa_op1_0900_rtl_hold prea rbl_op1_0900_rtl_hold ctl_op1_0900_rtl_hold 0 swpre
spr_op1_0900_rtl_hold pref ref_op1_0900_rtl_hold ctl_op1_0900_rtl_hold 0 swpre
crbl_op1_0900_rtl_hold rbl_op1_0900_rtl_hold 0 {C_RBL}
cref_op1_0900_rtl_hold ref_op1_0900_rtl_hold 0 {C_RBL}   $ ASSUMPTION: ideal matched dummy load
XMWR_op1_0900_rtl_hold_0 sn_op1_0900_rtl_hold_0 wwl_op1_0900_rtl_hold wbl_op1_0900_rtl_hold 0 sky130_fd_pr__nfet_01v8 L=0.15 W=0.42 nf=1 ad=0.1218 as=0.1218 pd=1.42 ps=1.42 nrd=0.69047619047619  nrs=0.69047619047619 sa=0 sb=0 sd=0 mult=1 m=1
XMRD_op1_0900_rtl_hold_0 rbl_op1_0900_rtl_hold sn_op1_0900_rtl_hold_0 rwls_op1_0900_rtl_hold 0 sky130_fd_pr__nfet_01v8 L=0.15 W=0.42 nf=1 ad=0.1218 as=0.1218 pd=1.42 ps=1.42 nrd=0.69047619047619  nrs=0.69047619047619 sa=0 sb=0 sd=0 mult=1 m=1
csn_op1_0900_rtl_hold_0 sn_op1_0900_rtl_hold_0 0 {C_SN}
XMWR_op1_0900_rtl_hold_1 sn_op1_0900_rtl_hold_1 wwl_des wbl_op1_0900_rtl_hold 0 sky130_fd_pr__nfet_01v8 L=0.15 W=0.42 nf=1 ad=0.1218 as=0.1218 pd=1.42 ps=1.42 nrd=0.69047619047619  nrs=0.69047619047619 sa=0 sb=0 sd=0 mult=1 m=1
XMRD_op1_0900_rtl_hold_1 rbl_op1_0900_rtl_hold sn_op1_0900_rtl_hold_1 rwl_des 0 sky130_fd_pr__nfet_01v8 L=0.15 W=0.42 nf=1 ad=0.1218 as=0.1218 pd=1.42 ps=1.42 nrd=0.69047619047619  nrs=0.69047619047619 sa=0 sb=0 sd=0 mult=1 m=1
csn_op1_0900_rtl_hold_1 sn_op1_0900_rtl_hold_1 0 {C_SN}
XMWR_op1_0900_rtl_hold_2 sn_op1_0900_rtl_hold_2 wwl_des wbl_op1_0900_rtl_hold 0 sky130_fd_pr__nfet_01v8 L=0.15 W=0.42 nf=1 ad=0.1218 as=0.1218 pd=1.42 ps=1.42 nrd=0.69047619047619  nrs=0.69047619047619 sa=0 sb=0 sd=0 mult=1 m=1
XMRD_op1_0900_rtl_hold_2 rbl_op1_0900_rtl_hold sn_op1_0900_rtl_hold_2 rwl_des 0 sky130_fd_pr__nfet_01v8 L=0.15 W=0.42 nf=1 ad=0.1218 as=0.1218 pd=1.42 ps=1.42 nrd=0.69047619047619  nrs=0.69047619047619 sa=0 sb=0 sd=0 mult=1 m=1
csn_op1_0900_rtl_hold_2 sn_op1_0900_rtl_hold_2 0 {C_SN}
XMWR_op1_0900_rtl_hold_3 sn_op1_0900_rtl_hold_3 wwl_des wbl_op1_0900_rtl_hold 0 sky130_fd_pr__nfet_01v8 L=0.15 W=0.42 nf=1 ad=0.1218 as=0.1218 pd=1.42 ps=1.42 nrd=0.69047619047619  nrs=0.69047619047619 sa=0 sb=0 sd=0 mult=1 m=1
XMRD_op1_0900_rtl_hold_3 rbl_op1_0900_rtl_hold sn_op1_0900_rtl_hold_3 rwl_des 0 sky130_fd_pr__nfet_01v8 L=0.15 W=0.42 nf=1 ad=0.1218 as=0.1218 pd=1.42 ps=1.42 nrd=0.69047619047619  nrs=0.69047619047619 sa=0 sb=0 sd=0 mult=1 m=1
csn_op1_0900_rtl_hold_3 sn_op1_0900_rtl_hold_3 0 {C_SN}
XMN1_op1_0900_rtl_hold rbl_op1_0900_rtl_hold ref_op1_0900_rtl_hold vn_op1_0900_rtl_hold 0 sky130_fd_pr__nfet_01v8 L=0.15 W=1 nf=1 ad=0.29 as=0.29 pd=2.58 ps=2.58 mult=1 m=1
XMN2_op1_0900_rtl_hold ref_op1_0900_rtl_hold rbl_op1_0900_rtl_hold vn_op1_0900_rtl_hold 0 sky130_fd_pr__nfet_01v8 L=0.15 W=1 nf=1 ad=0.29 as=0.29 pd=2.58 ps=2.58 mult=1 m=1
XMP1_op1_0900_rtl_hold rbl_op1_0900_rtl_hold ref_op1_0900_rtl_hold vp_op1_0900_rtl_hold vdd sky130_fd_pr__pfet_01v8 L=0.15 W=2 nf=1 ad=0.58 as=0.58 pd=4.58 ps=4.58 mult=1 m=1
XMP2_op1_0900_rtl_hold ref_op1_0900_rtl_hold rbl_op1_0900_rtl_hold vp_op1_0900_rtl_hold vdd sky130_fd_pr__pfet_01v8 L=0.15 W=2 nf=1 ad=0.58 as=0.58 pd=4.58 ps=4.58 mult=1 m=1
XMNF_op1_0900_rtl_hold vn_op1_0900_rtl_hold en_op1_0900_rtl_hold 0 0 sky130_fd_pr__nfet_01v8 L=0.15 W=2 nf=1 ad=0.58 as=0.58 pd=4.58 ps=4.58 mult=1 m=1
XMPH_op1_0900_rtl_hold vp_op1_0900_rtl_hold enb_op1_0900_rtl_hold vdd vdd sky130_fd_pr__pfet_01v8 L=0.15 W=4 nf=1 ad=1.16 as=1.16 pd=8.58 ps=8.58 mult=1 m=1
bd_op1_0900_rtl_hold d_op1_0900_rtl_hold 0 v=v(rbl_op1_0900_rtl_hold)-v(ref_op1_0900_rtl_hold)

* ---- instance 9: op1_1000_rtl_hold (variant rtl_hold; probe dec 11.9 ns, release 34 ns, meas 36 ns) ----
vctl_op1_1000_rtl_hold ctl_op1_1000_rtl_hold 0 pwl(0.0000e+00 {VDD} 2.0000e-09 {VDD} 2.1000e-09 0)
vrs_op1_1000_rtl_hold rwls_op1_1000_rtl_hold 0 pwl(0.0000e+00 {VDD} 2.0000e-09 {VDD} 2.1000e-09 0 1.2000e-08 0 1.2100e-08 {VDD})
ven_op1_1000_rtl_hold en_op1_1000_rtl_hold 0 pwl(0.0000e+00 0 1.1000e-08 0 1.1100e-08 {VDD} 3.4000e-08 {VDD} 3.4100e-08 0)
venb_op1_1000_rtl_hold enb_op1_1000_rtl_hold 0 pwl(0.0000e+00 {VDD} 1.1000e-08 {VDD} 1.1100e-08 0 3.4000e-08 0 3.4100e-08 {VDD})
vww_op1_1000_rtl_hold wwl_op1_1000_rtl_hold 0 pwl(0.0000e+00 0 1.2000e-08 0 1.2100e-08 {VDD} 3.2000e-08 {VDD} 3.2100e-08 0)
vwc_op1_1000_rtl_hold wbc_op1_1000_rtl_hold 0 pwl(0.0000e+00 0 1.2000e-08 0 1.2100e-08 {VDD} 3.4000e-08 {VDD} 3.4100e-08 0)
swb_op1_1000_rtl_hold ref_op1_1000_rtl_hold wbl_op1_1000_rtl_hold wbc_op1_1000_rtl_hold 0 swwbl
cwbl_op1_1000_rtl_hold wbl_op1_1000_rtl_hold 0 {C_WBL}
spa_op1_1000_rtl_hold prea rbl_op1_1000_rtl_hold ctl_op1_1000_rtl_hold 0 swpre
spr_op1_1000_rtl_hold pref ref_op1_1000_rtl_hold ctl_op1_1000_rtl_hold 0 swpre
crbl_op1_1000_rtl_hold rbl_op1_1000_rtl_hold 0 {C_RBL}
cref_op1_1000_rtl_hold ref_op1_1000_rtl_hold 0 {C_RBL}   $ ASSUMPTION: ideal matched dummy load
XMWR_op1_1000_rtl_hold_0 sn_op1_1000_rtl_hold_0 wwl_op1_1000_rtl_hold wbl_op1_1000_rtl_hold 0 sky130_fd_pr__nfet_01v8 L=0.15 W=0.42 nf=1 ad=0.1218 as=0.1218 pd=1.42 ps=1.42 nrd=0.69047619047619  nrs=0.69047619047619 sa=0 sb=0 sd=0 mult=1 m=1
XMRD_op1_1000_rtl_hold_0 rbl_op1_1000_rtl_hold sn_op1_1000_rtl_hold_0 rwls_op1_1000_rtl_hold 0 sky130_fd_pr__nfet_01v8 L=0.15 W=0.42 nf=1 ad=0.1218 as=0.1218 pd=1.42 ps=1.42 nrd=0.69047619047619  nrs=0.69047619047619 sa=0 sb=0 sd=0 mult=1 m=1
csn_op1_1000_rtl_hold_0 sn_op1_1000_rtl_hold_0 0 {C_SN}
XMWR_op1_1000_rtl_hold_1 sn_op1_1000_rtl_hold_1 wwl_des wbl_op1_1000_rtl_hold 0 sky130_fd_pr__nfet_01v8 L=0.15 W=0.42 nf=1 ad=0.1218 as=0.1218 pd=1.42 ps=1.42 nrd=0.69047619047619  nrs=0.69047619047619 sa=0 sb=0 sd=0 mult=1 m=1
XMRD_op1_1000_rtl_hold_1 rbl_op1_1000_rtl_hold sn_op1_1000_rtl_hold_1 rwl_des 0 sky130_fd_pr__nfet_01v8 L=0.15 W=0.42 nf=1 ad=0.1218 as=0.1218 pd=1.42 ps=1.42 nrd=0.69047619047619  nrs=0.69047619047619 sa=0 sb=0 sd=0 mult=1 m=1
csn_op1_1000_rtl_hold_1 sn_op1_1000_rtl_hold_1 0 {C_SN}
XMWR_op1_1000_rtl_hold_2 sn_op1_1000_rtl_hold_2 wwl_des wbl_op1_1000_rtl_hold 0 sky130_fd_pr__nfet_01v8 L=0.15 W=0.42 nf=1 ad=0.1218 as=0.1218 pd=1.42 ps=1.42 nrd=0.69047619047619  nrs=0.69047619047619 sa=0 sb=0 sd=0 mult=1 m=1
XMRD_op1_1000_rtl_hold_2 rbl_op1_1000_rtl_hold sn_op1_1000_rtl_hold_2 rwl_des 0 sky130_fd_pr__nfet_01v8 L=0.15 W=0.42 nf=1 ad=0.1218 as=0.1218 pd=1.42 ps=1.42 nrd=0.69047619047619  nrs=0.69047619047619 sa=0 sb=0 sd=0 mult=1 m=1
csn_op1_1000_rtl_hold_2 sn_op1_1000_rtl_hold_2 0 {C_SN}
XMWR_op1_1000_rtl_hold_3 sn_op1_1000_rtl_hold_3 wwl_des wbl_op1_1000_rtl_hold 0 sky130_fd_pr__nfet_01v8 L=0.15 W=0.42 nf=1 ad=0.1218 as=0.1218 pd=1.42 ps=1.42 nrd=0.69047619047619  nrs=0.69047619047619 sa=0 sb=0 sd=0 mult=1 m=1
XMRD_op1_1000_rtl_hold_3 rbl_op1_1000_rtl_hold sn_op1_1000_rtl_hold_3 rwl_des 0 sky130_fd_pr__nfet_01v8 L=0.15 W=0.42 nf=1 ad=0.1218 as=0.1218 pd=1.42 ps=1.42 nrd=0.69047619047619  nrs=0.69047619047619 sa=0 sb=0 sd=0 mult=1 m=1
csn_op1_1000_rtl_hold_3 sn_op1_1000_rtl_hold_3 0 {C_SN}
XMN1_op1_1000_rtl_hold rbl_op1_1000_rtl_hold ref_op1_1000_rtl_hold vn_op1_1000_rtl_hold 0 sky130_fd_pr__nfet_01v8 L=0.15 W=1 nf=1 ad=0.29 as=0.29 pd=2.58 ps=2.58 mult=1 m=1
XMN2_op1_1000_rtl_hold ref_op1_1000_rtl_hold rbl_op1_1000_rtl_hold vn_op1_1000_rtl_hold 0 sky130_fd_pr__nfet_01v8 L=0.15 W=1 nf=1 ad=0.29 as=0.29 pd=2.58 ps=2.58 mult=1 m=1
XMP1_op1_1000_rtl_hold rbl_op1_1000_rtl_hold ref_op1_1000_rtl_hold vp_op1_1000_rtl_hold vdd sky130_fd_pr__pfet_01v8 L=0.15 W=2 nf=1 ad=0.58 as=0.58 pd=4.58 ps=4.58 mult=1 m=1
XMP2_op1_1000_rtl_hold ref_op1_1000_rtl_hold rbl_op1_1000_rtl_hold vp_op1_1000_rtl_hold vdd sky130_fd_pr__pfet_01v8 L=0.15 W=2 nf=1 ad=0.58 as=0.58 pd=4.58 ps=4.58 mult=1 m=1
XMNF_op1_1000_rtl_hold vn_op1_1000_rtl_hold en_op1_1000_rtl_hold 0 0 sky130_fd_pr__nfet_01v8 L=0.15 W=2 nf=1 ad=0.58 as=0.58 pd=4.58 ps=4.58 mult=1 m=1
XMPH_op1_1000_rtl_hold vp_op1_1000_rtl_hold enb_op1_1000_rtl_hold vdd vdd sky130_fd_pr__pfet_01v8 L=0.15 W=4 nf=1 ad=1.16 as=1.16 pd=8.58 ps=8.58 mult=1 m=1
bd_op1_1000_rtl_hold d_op1_1000_rtl_hold 0 v=v(rbl_op1_1000_rtl_hold)-v(ref_op1_1000_rtl_hold)

* ---- instance 10: op0_n100_rtl_hold (variant rtl_hold; probe dec 11.9 ns, release 34 ns, meas 36 ns) ----
vctl_op0_n100_rtl_hold ctl_op0_n100_rtl_hold 0 pwl(0.0000e+00 {VDD} 2.0000e-09 {VDD} 2.1000e-09 0)
vrs_op0_n100_rtl_hold rwls_op0_n100_rtl_hold 0 pwl(0.0000e+00 {VDD} 2.0000e-09 {VDD} 2.1000e-09 0 1.2000e-08 0 1.2100e-08 {VDD})
ven_op0_n100_rtl_hold en_op0_n100_rtl_hold 0 pwl(0.0000e+00 0 1.1000e-08 0 1.1100e-08 {VDD} 3.4000e-08 {VDD} 3.4100e-08 0)
venb_op0_n100_rtl_hold enb_op0_n100_rtl_hold 0 pwl(0.0000e+00 {VDD} 1.1000e-08 {VDD} 1.1100e-08 0 3.4000e-08 0 3.4100e-08 {VDD})
vww_op0_n100_rtl_hold wwl_op0_n100_rtl_hold 0 pwl(0.0000e+00 0 1.2000e-08 0 1.2100e-08 {VDD} 3.2000e-08 {VDD} 3.2100e-08 0)
vwc_op0_n100_rtl_hold wbc_op0_n100_rtl_hold 0 pwl(0.0000e+00 0 1.2000e-08 0 1.2100e-08 {VDD} 3.4000e-08 {VDD} 3.4100e-08 0)
swb_op0_n100_rtl_hold ref_op0_n100_rtl_hold wbl_op0_n100_rtl_hold wbc_op0_n100_rtl_hold 0 swwbl
cwbl_op0_n100_rtl_hold wbl_op0_n100_rtl_hold 0 {C_WBL}
spa_op0_n100_rtl_hold prea rbl_op0_n100_rtl_hold ctl_op0_n100_rtl_hold 0 swpre
spr_op0_n100_rtl_hold pref ref_op0_n100_rtl_hold ctl_op0_n100_rtl_hold 0 swpre
crbl_op0_n100_rtl_hold rbl_op0_n100_rtl_hold 0 {C_RBL}
cref_op0_n100_rtl_hold ref_op0_n100_rtl_hold 0 {C_RBL}   $ ASSUMPTION: ideal matched dummy load
XMWR_op0_n100_rtl_hold_0 sn_op0_n100_rtl_hold_0 wwl_op0_n100_rtl_hold wbl_op0_n100_rtl_hold 0 sky130_fd_pr__nfet_01v8 L=0.15 W=0.42 nf=1 ad=0.1218 as=0.1218 pd=1.42 ps=1.42 nrd=0.69047619047619  nrs=0.69047619047619 sa=0 sb=0 sd=0 mult=1 m=1
XMRD_op0_n100_rtl_hold_0 rbl_op0_n100_rtl_hold sn_op0_n100_rtl_hold_0 rwls_op0_n100_rtl_hold 0 sky130_fd_pr__nfet_01v8 L=0.15 W=0.42 nf=1 ad=0.1218 as=0.1218 pd=1.42 ps=1.42 nrd=0.69047619047619  nrs=0.69047619047619 sa=0 sb=0 sd=0 mult=1 m=1
csn_op0_n100_rtl_hold_0 sn_op0_n100_rtl_hold_0 0 {C_SN}
XMWR_op0_n100_rtl_hold_1 sn_op0_n100_rtl_hold_1 wwl_des wbl_op0_n100_rtl_hold 0 sky130_fd_pr__nfet_01v8 L=0.15 W=0.42 nf=1 ad=0.1218 as=0.1218 pd=1.42 ps=1.42 nrd=0.69047619047619  nrs=0.69047619047619 sa=0 sb=0 sd=0 mult=1 m=1
XMRD_op0_n100_rtl_hold_1 rbl_op0_n100_rtl_hold sn_op0_n100_rtl_hold_1 rwl_des 0 sky130_fd_pr__nfet_01v8 L=0.15 W=0.42 nf=1 ad=0.1218 as=0.1218 pd=1.42 ps=1.42 nrd=0.69047619047619  nrs=0.69047619047619 sa=0 sb=0 sd=0 mult=1 m=1
csn_op0_n100_rtl_hold_1 sn_op0_n100_rtl_hold_1 0 {C_SN}
XMWR_op0_n100_rtl_hold_2 sn_op0_n100_rtl_hold_2 wwl_des wbl_op0_n100_rtl_hold 0 sky130_fd_pr__nfet_01v8 L=0.15 W=0.42 nf=1 ad=0.1218 as=0.1218 pd=1.42 ps=1.42 nrd=0.69047619047619  nrs=0.69047619047619 sa=0 sb=0 sd=0 mult=1 m=1
XMRD_op0_n100_rtl_hold_2 rbl_op0_n100_rtl_hold sn_op0_n100_rtl_hold_2 rwl_des 0 sky130_fd_pr__nfet_01v8 L=0.15 W=0.42 nf=1 ad=0.1218 as=0.1218 pd=1.42 ps=1.42 nrd=0.69047619047619  nrs=0.69047619047619 sa=0 sb=0 sd=0 mult=1 m=1
csn_op0_n100_rtl_hold_2 sn_op0_n100_rtl_hold_2 0 {C_SN}
XMWR_op0_n100_rtl_hold_3 sn_op0_n100_rtl_hold_3 wwl_des wbl_op0_n100_rtl_hold 0 sky130_fd_pr__nfet_01v8 L=0.15 W=0.42 nf=1 ad=0.1218 as=0.1218 pd=1.42 ps=1.42 nrd=0.69047619047619  nrs=0.69047619047619 sa=0 sb=0 sd=0 mult=1 m=1
XMRD_op0_n100_rtl_hold_3 rbl_op0_n100_rtl_hold sn_op0_n100_rtl_hold_3 rwl_des 0 sky130_fd_pr__nfet_01v8 L=0.15 W=0.42 nf=1 ad=0.1218 as=0.1218 pd=1.42 ps=1.42 nrd=0.69047619047619  nrs=0.69047619047619 sa=0 sb=0 sd=0 mult=1 m=1
csn_op0_n100_rtl_hold_3 sn_op0_n100_rtl_hold_3 0 {C_SN}
XMN1_op0_n100_rtl_hold rbl_op0_n100_rtl_hold ref_op0_n100_rtl_hold vn_op0_n100_rtl_hold 0 sky130_fd_pr__nfet_01v8 L=0.15 W=1 nf=1 ad=0.29 as=0.29 pd=2.58 ps=2.58 mult=1 m=1
XMN2_op0_n100_rtl_hold ref_op0_n100_rtl_hold rbl_op0_n100_rtl_hold vn_op0_n100_rtl_hold 0 sky130_fd_pr__nfet_01v8 L=0.15 W=1 nf=1 ad=0.29 as=0.29 pd=2.58 ps=2.58 mult=1 m=1
XMP1_op0_n100_rtl_hold rbl_op0_n100_rtl_hold ref_op0_n100_rtl_hold vp_op0_n100_rtl_hold vdd sky130_fd_pr__pfet_01v8 L=0.15 W=2 nf=1 ad=0.58 as=0.58 pd=4.58 ps=4.58 mult=1 m=1
XMP2_op0_n100_rtl_hold ref_op0_n100_rtl_hold rbl_op0_n100_rtl_hold vp_op0_n100_rtl_hold vdd sky130_fd_pr__pfet_01v8 L=0.15 W=2 nf=1 ad=0.58 as=0.58 pd=4.58 ps=4.58 mult=1 m=1
XMNF_op0_n100_rtl_hold vn_op0_n100_rtl_hold en_op0_n100_rtl_hold 0 0 sky130_fd_pr__nfet_01v8 L=0.15 W=2 nf=1 ad=0.58 as=0.58 pd=4.58 ps=4.58 mult=1 m=1
XMPH_op0_n100_rtl_hold vp_op0_n100_rtl_hold enb_op0_n100_rtl_hold vdd vdd sky130_fd_pr__pfet_01v8 L=0.15 W=4 nf=1 ad=1.16 as=1.16 pd=8.58 ps=8.58 mult=1 m=1
bd_op0_n100_rtl_hold d_op0_n100_rtl_hold 0 v=v(rbl_op0_n100_rtl_hold)-v(ref_op0_n100_rtl_hold)

* ---- instance 11: op0_0000_rtl_hold (variant rtl_hold; probe dec 11.9 ns, release 34 ns, meas 36 ns) ----
vctl_op0_0000_rtl_hold ctl_op0_0000_rtl_hold 0 pwl(0.0000e+00 {VDD} 2.0000e-09 {VDD} 2.1000e-09 0)
vrs_op0_0000_rtl_hold rwls_op0_0000_rtl_hold 0 pwl(0.0000e+00 {VDD} 2.0000e-09 {VDD} 2.1000e-09 0 1.2000e-08 0 1.2100e-08 {VDD})
ven_op0_0000_rtl_hold en_op0_0000_rtl_hold 0 pwl(0.0000e+00 0 1.1000e-08 0 1.1100e-08 {VDD} 3.4000e-08 {VDD} 3.4100e-08 0)
venb_op0_0000_rtl_hold enb_op0_0000_rtl_hold 0 pwl(0.0000e+00 {VDD} 1.1000e-08 {VDD} 1.1100e-08 0 3.4000e-08 0 3.4100e-08 {VDD})
vww_op0_0000_rtl_hold wwl_op0_0000_rtl_hold 0 pwl(0.0000e+00 0 1.2000e-08 0 1.2100e-08 {VDD} 3.2000e-08 {VDD} 3.2100e-08 0)
vwc_op0_0000_rtl_hold wbc_op0_0000_rtl_hold 0 pwl(0.0000e+00 0 1.2000e-08 0 1.2100e-08 {VDD} 3.4000e-08 {VDD} 3.4100e-08 0)
swb_op0_0000_rtl_hold ref_op0_0000_rtl_hold wbl_op0_0000_rtl_hold wbc_op0_0000_rtl_hold 0 swwbl
cwbl_op0_0000_rtl_hold wbl_op0_0000_rtl_hold 0 {C_WBL}
spa_op0_0000_rtl_hold prea rbl_op0_0000_rtl_hold ctl_op0_0000_rtl_hold 0 swpre
spr_op0_0000_rtl_hold pref ref_op0_0000_rtl_hold ctl_op0_0000_rtl_hold 0 swpre
crbl_op0_0000_rtl_hold rbl_op0_0000_rtl_hold 0 {C_RBL}
cref_op0_0000_rtl_hold ref_op0_0000_rtl_hold 0 {C_RBL}   $ ASSUMPTION: ideal matched dummy load
XMWR_op0_0000_rtl_hold_0 sn_op0_0000_rtl_hold_0 wwl_op0_0000_rtl_hold wbl_op0_0000_rtl_hold 0 sky130_fd_pr__nfet_01v8 L=0.15 W=0.42 nf=1 ad=0.1218 as=0.1218 pd=1.42 ps=1.42 nrd=0.69047619047619  nrs=0.69047619047619 sa=0 sb=0 sd=0 mult=1 m=1
XMRD_op0_0000_rtl_hold_0 rbl_op0_0000_rtl_hold sn_op0_0000_rtl_hold_0 rwls_op0_0000_rtl_hold 0 sky130_fd_pr__nfet_01v8 L=0.15 W=0.42 nf=1 ad=0.1218 as=0.1218 pd=1.42 ps=1.42 nrd=0.69047619047619  nrs=0.69047619047619 sa=0 sb=0 sd=0 mult=1 m=1
csn_op0_0000_rtl_hold_0 sn_op0_0000_rtl_hold_0 0 {C_SN}
XMWR_op0_0000_rtl_hold_1 sn_op0_0000_rtl_hold_1 wwl_des wbl_op0_0000_rtl_hold 0 sky130_fd_pr__nfet_01v8 L=0.15 W=0.42 nf=1 ad=0.1218 as=0.1218 pd=1.42 ps=1.42 nrd=0.69047619047619  nrs=0.69047619047619 sa=0 sb=0 sd=0 mult=1 m=1
XMRD_op0_0000_rtl_hold_1 rbl_op0_0000_rtl_hold sn_op0_0000_rtl_hold_1 rwl_des 0 sky130_fd_pr__nfet_01v8 L=0.15 W=0.42 nf=1 ad=0.1218 as=0.1218 pd=1.42 ps=1.42 nrd=0.69047619047619  nrs=0.69047619047619 sa=0 sb=0 sd=0 mult=1 m=1
csn_op0_0000_rtl_hold_1 sn_op0_0000_rtl_hold_1 0 {C_SN}
XMWR_op0_0000_rtl_hold_2 sn_op0_0000_rtl_hold_2 wwl_des wbl_op0_0000_rtl_hold 0 sky130_fd_pr__nfet_01v8 L=0.15 W=0.42 nf=1 ad=0.1218 as=0.1218 pd=1.42 ps=1.42 nrd=0.69047619047619  nrs=0.69047619047619 sa=0 sb=0 sd=0 mult=1 m=1
XMRD_op0_0000_rtl_hold_2 rbl_op0_0000_rtl_hold sn_op0_0000_rtl_hold_2 rwl_des 0 sky130_fd_pr__nfet_01v8 L=0.15 W=0.42 nf=1 ad=0.1218 as=0.1218 pd=1.42 ps=1.42 nrd=0.69047619047619  nrs=0.69047619047619 sa=0 sb=0 sd=0 mult=1 m=1
csn_op0_0000_rtl_hold_2 sn_op0_0000_rtl_hold_2 0 {C_SN}
XMWR_op0_0000_rtl_hold_3 sn_op0_0000_rtl_hold_3 wwl_des wbl_op0_0000_rtl_hold 0 sky130_fd_pr__nfet_01v8 L=0.15 W=0.42 nf=1 ad=0.1218 as=0.1218 pd=1.42 ps=1.42 nrd=0.69047619047619  nrs=0.69047619047619 sa=0 sb=0 sd=0 mult=1 m=1
XMRD_op0_0000_rtl_hold_3 rbl_op0_0000_rtl_hold sn_op0_0000_rtl_hold_3 rwl_des 0 sky130_fd_pr__nfet_01v8 L=0.15 W=0.42 nf=1 ad=0.1218 as=0.1218 pd=1.42 ps=1.42 nrd=0.69047619047619  nrs=0.69047619047619 sa=0 sb=0 sd=0 mult=1 m=1
csn_op0_0000_rtl_hold_3 sn_op0_0000_rtl_hold_3 0 {C_SN}
XMN1_op0_0000_rtl_hold rbl_op0_0000_rtl_hold ref_op0_0000_rtl_hold vn_op0_0000_rtl_hold 0 sky130_fd_pr__nfet_01v8 L=0.15 W=1 nf=1 ad=0.29 as=0.29 pd=2.58 ps=2.58 mult=1 m=1
XMN2_op0_0000_rtl_hold ref_op0_0000_rtl_hold rbl_op0_0000_rtl_hold vn_op0_0000_rtl_hold 0 sky130_fd_pr__nfet_01v8 L=0.15 W=1 nf=1 ad=0.29 as=0.29 pd=2.58 ps=2.58 mult=1 m=1
XMP1_op0_0000_rtl_hold rbl_op0_0000_rtl_hold ref_op0_0000_rtl_hold vp_op0_0000_rtl_hold vdd sky130_fd_pr__pfet_01v8 L=0.15 W=2 nf=1 ad=0.58 as=0.58 pd=4.58 ps=4.58 mult=1 m=1
XMP2_op0_0000_rtl_hold ref_op0_0000_rtl_hold rbl_op0_0000_rtl_hold vp_op0_0000_rtl_hold vdd sky130_fd_pr__pfet_01v8 L=0.15 W=2 nf=1 ad=0.58 as=0.58 pd=4.58 ps=4.58 mult=1 m=1
XMNF_op0_0000_rtl_hold vn_op0_0000_rtl_hold en_op0_0000_rtl_hold 0 0 sky130_fd_pr__nfet_01v8 L=0.15 W=2 nf=1 ad=0.58 as=0.58 pd=4.58 ps=4.58 mult=1 m=1
XMPH_op0_0000_rtl_hold vp_op0_0000_rtl_hold enb_op0_0000_rtl_hold vdd vdd sky130_fd_pr__pfet_01v8 L=0.15 W=4 nf=1 ad=1.16 as=1.16 pd=8.58 ps=8.58 mult=1 m=1
bd_op0_0000_rtl_hold d_op0_0000_rtl_hold 0 v=v(rbl_op0_0000_rtl_hold)-v(ref_op0_0000_rtl_hold)

* ---- instance 12: op1_0900_neg_missing_wb (variant neg_missing_wb; probe dec 11.9 ns, release 34 ns, meas 36 ns) ----
vctl_op1_0900_neg_missing_wb ctl_op1_0900_neg_missing_wb 0 pwl(0.0000e+00 {VDD} 2.0000e-09 {VDD} 2.1000e-09 0)
vrs_op1_0900_neg_missing_wb rwls_op1_0900_neg_missing_wb 0 pwl(0.0000e+00 {VDD} 2.0000e-09 {VDD} 2.1000e-09 0 1.2000e-08 0 1.2100e-08 {VDD})
ven_op1_0900_neg_missing_wb en_op1_0900_neg_missing_wb 0 pwl(0.0000e+00 0 1.1000e-08 0 1.1100e-08 {VDD} 3.4000e-08 {VDD} 3.4100e-08 0)
venb_op1_0900_neg_missing_wb enb_op1_0900_neg_missing_wb 0 pwl(0.0000e+00 {VDD} 1.1000e-08 {VDD} 1.1100e-08 0 3.4000e-08 0 3.4100e-08 {VDD})
vww_op1_0900_neg_missing_wb wwl_op1_0900_neg_missing_wb 0 pwl(0.0000e+00 0)
vwc_op1_0900_neg_missing_wb wbc_op1_0900_neg_missing_wb 0 pwl(0.0000e+00 0)
swb_op1_0900_neg_missing_wb ref_op1_0900_neg_missing_wb wbl_op1_0900_neg_missing_wb wbc_op1_0900_neg_missing_wb 0 swwbl
cwbl_op1_0900_neg_missing_wb wbl_op1_0900_neg_missing_wb 0 {C_WBL}
spa_op1_0900_neg_missing_wb prea rbl_op1_0900_neg_missing_wb ctl_op1_0900_neg_missing_wb 0 swpre
spr_op1_0900_neg_missing_wb pref ref_op1_0900_neg_missing_wb ctl_op1_0900_neg_missing_wb 0 swpre
crbl_op1_0900_neg_missing_wb rbl_op1_0900_neg_missing_wb 0 {C_RBL}
cref_op1_0900_neg_missing_wb ref_op1_0900_neg_missing_wb 0 {C_RBL}   $ ASSUMPTION: ideal matched dummy load
XMWR_op1_0900_neg_missing_wb_0 sn_op1_0900_neg_missing_wb_0 wwl_op1_0900_neg_missing_wb wbl_op1_0900_neg_missing_wb 0 sky130_fd_pr__nfet_01v8 L=0.15 W=0.42 nf=1 ad=0.1218 as=0.1218 pd=1.42 ps=1.42 nrd=0.69047619047619  nrs=0.69047619047619 sa=0 sb=0 sd=0 mult=1 m=1
XMRD_op1_0900_neg_missing_wb_0 rbl_op1_0900_neg_missing_wb sn_op1_0900_neg_missing_wb_0 rwls_op1_0900_neg_missing_wb 0 sky130_fd_pr__nfet_01v8 L=0.15 W=0.42 nf=1 ad=0.1218 as=0.1218 pd=1.42 ps=1.42 nrd=0.69047619047619  nrs=0.69047619047619 sa=0 sb=0 sd=0 mult=1 m=1
csn_op1_0900_neg_missing_wb_0 sn_op1_0900_neg_missing_wb_0 0 {C_SN}
XMWR_op1_0900_neg_missing_wb_1 sn_op1_0900_neg_missing_wb_1 wwl_des wbl_op1_0900_neg_missing_wb 0 sky130_fd_pr__nfet_01v8 L=0.15 W=0.42 nf=1 ad=0.1218 as=0.1218 pd=1.42 ps=1.42 nrd=0.69047619047619  nrs=0.69047619047619 sa=0 sb=0 sd=0 mult=1 m=1
XMRD_op1_0900_neg_missing_wb_1 rbl_op1_0900_neg_missing_wb sn_op1_0900_neg_missing_wb_1 rwl_des 0 sky130_fd_pr__nfet_01v8 L=0.15 W=0.42 nf=1 ad=0.1218 as=0.1218 pd=1.42 ps=1.42 nrd=0.69047619047619  nrs=0.69047619047619 sa=0 sb=0 sd=0 mult=1 m=1
csn_op1_0900_neg_missing_wb_1 sn_op1_0900_neg_missing_wb_1 0 {C_SN}
XMWR_op1_0900_neg_missing_wb_2 sn_op1_0900_neg_missing_wb_2 wwl_des wbl_op1_0900_neg_missing_wb 0 sky130_fd_pr__nfet_01v8 L=0.15 W=0.42 nf=1 ad=0.1218 as=0.1218 pd=1.42 ps=1.42 nrd=0.69047619047619  nrs=0.69047619047619 sa=0 sb=0 sd=0 mult=1 m=1
XMRD_op1_0900_neg_missing_wb_2 rbl_op1_0900_neg_missing_wb sn_op1_0900_neg_missing_wb_2 rwl_des 0 sky130_fd_pr__nfet_01v8 L=0.15 W=0.42 nf=1 ad=0.1218 as=0.1218 pd=1.42 ps=1.42 nrd=0.69047619047619  nrs=0.69047619047619 sa=0 sb=0 sd=0 mult=1 m=1
csn_op1_0900_neg_missing_wb_2 sn_op1_0900_neg_missing_wb_2 0 {C_SN}
XMWR_op1_0900_neg_missing_wb_3 sn_op1_0900_neg_missing_wb_3 wwl_des wbl_op1_0900_neg_missing_wb 0 sky130_fd_pr__nfet_01v8 L=0.15 W=0.42 nf=1 ad=0.1218 as=0.1218 pd=1.42 ps=1.42 nrd=0.69047619047619  nrs=0.69047619047619 sa=0 sb=0 sd=0 mult=1 m=1
XMRD_op1_0900_neg_missing_wb_3 rbl_op1_0900_neg_missing_wb sn_op1_0900_neg_missing_wb_3 rwl_des 0 sky130_fd_pr__nfet_01v8 L=0.15 W=0.42 nf=1 ad=0.1218 as=0.1218 pd=1.42 ps=1.42 nrd=0.69047619047619  nrs=0.69047619047619 sa=0 sb=0 sd=0 mult=1 m=1
csn_op1_0900_neg_missing_wb_3 sn_op1_0900_neg_missing_wb_3 0 {C_SN}
XMN1_op1_0900_neg_missing_wb rbl_op1_0900_neg_missing_wb ref_op1_0900_neg_missing_wb vn_op1_0900_neg_missing_wb 0 sky130_fd_pr__nfet_01v8 L=0.15 W=1 nf=1 ad=0.29 as=0.29 pd=2.58 ps=2.58 mult=1 m=1
XMN2_op1_0900_neg_missing_wb ref_op1_0900_neg_missing_wb rbl_op1_0900_neg_missing_wb vn_op1_0900_neg_missing_wb 0 sky130_fd_pr__nfet_01v8 L=0.15 W=1 nf=1 ad=0.29 as=0.29 pd=2.58 ps=2.58 mult=1 m=1
XMP1_op1_0900_neg_missing_wb rbl_op1_0900_neg_missing_wb ref_op1_0900_neg_missing_wb vp_op1_0900_neg_missing_wb vdd sky130_fd_pr__pfet_01v8 L=0.15 W=2 nf=1 ad=0.58 as=0.58 pd=4.58 ps=4.58 mult=1 m=1
XMP2_op1_0900_neg_missing_wb ref_op1_0900_neg_missing_wb rbl_op1_0900_neg_missing_wb vp_op1_0900_neg_missing_wb vdd sky130_fd_pr__pfet_01v8 L=0.15 W=2 nf=1 ad=0.58 as=0.58 pd=4.58 ps=4.58 mult=1 m=1
XMNF_op1_0900_neg_missing_wb vn_op1_0900_neg_missing_wb en_op1_0900_neg_missing_wb 0 0 sky130_fd_pr__nfet_01v8 L=0.15 W=2 nf=1 ad=0.58 as=0.58 pd=4.58 ps=4.58 mult=1 m=1
XMPH_op1_0900_neg_missing_wb vp_op1_0900_neg_missing_wb enb_op1_0900_neg_missing_wb vdd vdd sky130_fd_pr__pfet_01v8 L=0.15 W=4 nf=1 ad=1.16 as=1.16 pd=8.58 ps=8.58 mult=1 m=1
bd_op1_0900_neg_missing_wb d_op1_0900_neg_missing_wb 0 v=v(rbl_op1_0900_neg_missing_wb)-v(ref_op1_0900_neg_missing_wb)

* ---- instance 13: op1_1000_neg_missing_wb (variant neg_missing_wb; probe dec 11.9 ns, release 34 ns, meas 36 ns) ----
vctl_op1_1000_neg_missing_wb ctl_op1_1000_neg_missing_wb 0 pwl(0.0000e+00 {VDD} 2.0000e-09 {VDD} 2.1000e-09 0)
vrs_op1_1000_neg_missing_wb rwls_op1_1000_neg_missing_wb 0 pwl(0.0000e+00 {VDD} 2.0000e-09 {VDD} 2.1000e-09 0 1.2000e-08 0 1.2100e-08 {VDD})
ven_op1_1000_neg_missing_wb en_op1_1000_neg_missing_wb 0 pwl(0.0000e+00 0 1.1000e-08 0 1.1100e-08 {VDD} 3.4000e-08 {VDD} 3.4100e-08 0)
venb_op1_1000_neg_missing_wb enb_op1_1000_neg_missing_wb 0 pwl(0.0000e+00 {VDD} 1.1000e-08 {VDD} 1.1100e-08 0 3.4000e-08 0 3.4100e-08 {VDD})
vww_op1_1000_neg_missing_wb wwl_op1_1000_neg_missing_wb 0 pwl(0.0000e+00 0)
vwc_op1_1000_neg_missing_wb wbc_op1_1000_neg_missing_wb 0 pwl(0.0000e+00 0)
swb_op1_1000_neg_missing_wb ref_op1_1000_neg_missing_wb wbl_op1_1000_neg_missing_wb wbc_op1_1000_neg_missing_wb 0 swwbl
cwbl_op1_1000_neg_missing_wb wbl_op1_1000_neg_missing_wb 0 {C_WBL}
spa_op1_1000_neg_missing_wb prea rbl_op1_1000_neg_missing_wb ctl_op1_1000_neg_missing_wb 0 swpre
spr_op1_1000_neg_missing_wb pref ref_op1_1000_neg_missing_wb ctl_op1_1000_neg_missing_wb 0 swpre
crbl_op1_1000_neg_missing_wb rbl_op1_1000_neg_missing_wb 0 {C_RBL}
cref_op1_1000_neg_missing_wb ref_op1_1000_neg_missing_wb 0 {C_RBL}   $ ASSUMPTION: ideal matched dummy load
XMWR_op1_1000_neg_missing_wb_0 sn_op1_1000_neg_missing_wb_0 wwl_op1_1000_neg_missing_wb wbl_op1_1000_neg_missing_wb 0 sky130_fd_pr__nfet_01v8 L=0.15 W=0.42 nf=1 ad=0.1218 as=0.1218 pd=1.42 ps=1.42 nrd=0.69047619047619  nrs=0.69047619047619 sa=0 sb=0 sd=0 mult=1 m=1
XMRD_op1_1000_neg_missing_wb_0 rbl_op1_1000_neg_missing_wb sn_op1_1000_neg_missing_wb_0 rwls_op1_1000_neg_missing_wb 0 sky130_fd_pr__nfet_01v8 L=0.15 W=0.42 nf=1 ad=0.1218 as=0.1218 pd=1.42 ps=1.42 nrd=0.69047619047619  nrs=0.69047619047619 sa=0 sb=0 sd=0 mult=1 m=1
csn_op1_1000_neg_missing_wb_0 sn_op1_1000_neg_missing_wb_0 0 {C_SN}
XMWR_op1_1000_neg_missing_wb_1 sn_op1_1000_neg_missing_wb_1 wwl_des wbl_op1_1000_neg_missing_wb 0 sky130_fd_pr__nfet_01v8 L=0.15 W=0.42 nf=1 ad=0.1218 as=0.1218 pd=1.42 ps=1.42 nrd=0.69047619047619  nrs=0.69047619047619 sa=0 sb=0 sd=0 mult=1 m=1
XMRD_op1_1000_neg_missing_wb_1 rbl_op1_1000_neg_missing_wb sn_op1_1000_neg_missing_wb_1 rwl_des 0 sky130_fd_pr__nfet_01v8 L=0.15 W=0.42 nf=1 ad=0.1218 as=0.1218 pd=1.42 ps=1.42 nrd=0.69047619047619  nrs=0.69047619047619 sa=0 sb=0 sd=0 mult=1 m=1
csn_op1_1000_neg_missing_wb_1 sn_op1_1000_neg_missing_wb_1 0 {C_SN}
XMWR_op1_1000_neg_missing_wb_2 sn_op1_1000_neg_missing_wb_2 wwl_des wbl_op1_1000_neg_missing_wb 0 sky130_fd_pr__nfet_01v8 L=0.15 W=0.42 nf=1 ad=0.1218 as=0.1218 pd=1.42 ps=1.42 nrd=0.69047619047619  nrs=0.69047619047619 sa=0 sb=0 sd=0 mult=1 m=1
XMRD_op1_1000_neg_missing_wb_2 rbl_op1_1000_neg_missing_wb sn_op1_1000_neg_missing_wb_2 rwl_des 0 sky130_fd_pr__nfet_01v8 L=0.15 W=0.42 nf=1 ad=0.1218 as=0.1218 pd=1.42 ps=1.42 nrd=0.69047619047619  nrs=0.69047619047619 sa=0 sb=0 sd=0 mult=1 m=1
csn_op1_1000_neg_missing_wb_2 sn_op1_1000_neg_missing_wb_2 0 {C_SN}
XMWR_op1_1000_neg_missing_wb_3 sn_op1_1000_neg_missing_wb_3 wwl_des wbl_op1_1000_neg_missing_wb 0 sky130_fd_pr__nfet_01v8 L=0.15 W=0.42 nf=1 ad=0.1218 as=0.1218 pd=1.42 ps=1.42 nrd=0.69047619047619  nrs=0.69047619047619 sa=0 sb=0 sd=0 mult=1 m=1
XMRD_op1_1000_neg_missing_wb_3 rbl_op1_1000_neg_missing_wb sn_op1_1000_neg_missing_wb_3 rwl_des 0 sky130_fd_pr__nfet_01v8 L=0.15 W=0.42 nf=1 ad=0.1218 as=0.1218 pd=1.42 ps=1.42 nrd=0.69047619047619  nrs=0.69047619047619 sa=0 sb=0 sd=0 mult=1 m=1
csn_op1_1000_neg_missing_wb_3 sn_op1_1000_neg_missing_wb_3 0 {C_SN}
XMN1_op1_1000_neg_missing_wb rbl_op1_1000_neg_missing_wb ref_op1_1000_neg_missing_wb vn_op1_1000_neg_missing_wb 0 sky130_fd_pr__nfet_01v8 L=0.15 W=1 nf=1 ad=0.29 as=0.29 pd=2.58 ps=2.58 mult=1 m=1
XMN2_op1_1000_neg_missing_wb ref_op1_1000_neg_missing_wb rbl_op1_1000_neg_missing_wb vn_op1_1000_neg_missing_wb 0 sky130_fd_pr__nfet_01v8 L=0.15 W=1 nf=1 ad=0.29 as=0.29 pd=2.58 ps=2.58 mult=1 m=1
XMP1_op1_1000_neg_missing_wb rbl_op1_1000_neg_missing_wb ref_op1_1000_neg_missing_wb vp_op1_1000_neg_missing_wb vdd sky130_fd_pr__pfet_01v8 L=0.15 W=2 nf=1 ad=0.58 as=0.58 pd=4.58 ps=4.58 mult=1 m=1
XMP2_op1_1000_neg_missing_wb ref_op1_1000_neg_missing_wb rbl_op1_1000_neg_missing_wb vp_op1_1000_neg_missing_wb vdd sky130_fd_pr__pfet_01v8 L=0.15 W=2 nf=1 ad=0.58 as=0.58 pd=4.58 ps=4.58 mult=1 m=1
XMNF_op1_1000_neg_missing_wb vn_op1_1000_neg_missing_wb en_op1_1000_neg_missing_wb 0 0 sky130_fd_pr__nfet_01v8 L=0.15 W=2 nf=1 ad=0.58 as=0.58 pd=4.58 ps=4.58 mult=1 m=1
XMPH_op1_1000_neg_missing_wb vp_op1_1000_neg_missing_wb enb_op1_1000_neg_missing_wb vdd vdd sky130_fd_pr__pfet_01v8 L=0.15 W=4 nf=1 ad=1.16 as=1.16 pd=8.58 ps=8.58 mult=1 m=1
bd_op1_1000_neg_missing_wb d_op1_1000_neg_missing_wb 0 v=v(rbl_op1_1000_neg_missing_wb)-v(ref_op1_1000_neg_missing_wb)

* ---- instance 14: op0_n100_neg_missing_wb (variant neg_missing_wb; probe dec 11.9 ns, release 34 ns, meas 36 ns) ----
vctl_op0_n100_neg_missing_wb ctl_op0_n100_neg_missing_wb 0 pwl(0.0000e+00 {VDD} 2.0000e-09 {VDD} 2.1000e-09 0)
vrs_op0_n100_neg_missing_wb rwls_op0_n100_neg_missing_wb 0 pwl(0.0000e+00 {VDD} 2.0000e-09 {VDD} 2.1000e-09 0 1.2000e-08 0 1.2100e-08 {VDD})
ven_op0_n100_neg_missing_wb en_op0_n100_neg_missing_wb 0 pwl(0.0000e+00 0 1.1000e-08 0 1.1100e-08 {VDD} 3.4000e-08 {VDD} 3.4100e-08 0)
venb_op0_n100_neg_missing_wb enb_op0_n100_neg_missing_wb 0 pwl(0.0000e+00 {VDD} 1.1000e-08 {VDD} 1.1100e-08 0 3.4000e-08 0 3.4100e-08 {VDD})
vww_op0_n100_neg_missing_wb wwl_op0_n100_neg_missing_wb 0 pwl(0.0000e+00 0)
vwc_op0_n100_neg_missing_wb wbc_op0_n100_neg_missing_wb 0 pwl(0.0000e+00 0)
swb_op0_n100_neg_missing_wb ref_op0_n100_neg_missing_wb wbl_op0_n100_neg_missing_wb wbc_op0_n100_neg_missing_wb 0 swwbl
cwbl_op0_n100_neg_missing_wb wbl_op0_n100_neg_missing_wb 0 {C_WBL}
spa_op0_n100_neg_missing_wb prea rbl_op0_n100_neg_missing_wb ctl_op0_n100_neg_missing_wb 0 swpre
spr_op0_n100_neg_missing_wb pref ref_op0_n100_neg_missing_wb ctl_op0_n100_neg_missing_wb 0 swpre
crbl_op0_n100_neg_missing_wb rbl_op0_n100_neg_missing_wb 0 {C_RBL}
cref_op0_n100_neg_missing_wb ref_op0_n100_neg_missing_wb 0 {C_RBL}   $ ASSUMPTION: ideal matched dummy load
XMWR_op0_n100_neg_missing_wb_0 sn_op0_n100_neg_missing_wb_0 wwl_op0_n100_neg_missing_wb wbl_op0_n100_neg_missing_wb 0 sky130_fd_pr__nfet_01v8 L=0.15 W=0.42 nf=1 ad=0.1218 as=0.1218 pd=1.42 ps=1.42 nrd=0.69047619047619  nrs=0.69047619047619 sa=0 sb=0 sd=0 mult=1 m=1
XMRD_op0_n100_neg_missing_wb_0 rbl_op0_n100_neg_missing_wb sn_op0_n100_neg_missing_wb_0 rwls_op0_n100_neg_missing_wb 0 sky130_fd_pr__nfet_01v8 L=0.15 W=0.42 nf=1 ad=0.1218 as=0.1218 pd=1.42 ps=1.42 nrd=0.69047619047619  nrs=0.69047619047619 sa=0 sb=0 sd=0 mult=1 m=1
csn_op0_n100_neg_missing_wb_0 sn_op0_n100_neg_missing_wb_0 0 {C_SN}
XMWR_op0_n100_neg_missing_wb_1 sn_op0_n100_neg_missing_wb_1 wwl_des wbl_op0_n100_neg_missing_wb 0 sky130_fd_pr__nfet_01v8 L=0.15 W=0.42 nf=1 ad=0.1218 as=0.1218 pd=1.42 ps=1.42 nrd=0.69047619047619  nrs=0.69047619047619 sa=0 sb=0 sd=0 mult=1 m=1
XMRD_op0_n100_neg_missing_wb_1 rbl_op0_n100_neg_missing_wb sn_op0_n100_neg_missing_wb_1 rwl_des 0 sky130_fd_pr__nfet_01v8 L=0.15 W=0.42 nf=1 ad=0.1218 as=0.1218 pd=1.42 ps=1.42 nrd=0.69047619047619  nrs=0.69047619047619 sa=0 sb=0 sd=0 mult=1 m=1
csn_op0_n100_neg_missing_wb_1 sn_op0_n100_neg_missing_wb_1 0 {C_SN}
XMWR_op0_n100_neg_missing_wb_2 sn_op0_n100_neg_missing_wb_2 wwl_des wbl_op0_n100_neg_missing_wb 0 sky130_fd_pr__nfet_01v8 L=0.15 W=0.42 nf=1 ad=0.1218 as=0.1218 pd=1.42 ps=1.42 nrd=0.69047619047619  nrs=0.69047619047619 sa=0 sb=0 sd=0 mult=1 m=1
XMRD_op0_n100_neg_missing_wb_2 rbl_op0_n100_neg_missing_wb sn_op0_n100_neg_missing_wb_2 rwl_des 0 sky130_fd_pr__nfet_01v8 L=0.15 W=0.42 nf=1 ad=0.1218 as=0.1218 pd=1.42 ps=1.42 nrd=0.69047619047619  nrs=0.69047619047619 sa=0 sb=0 sd=0 mult=1 m=1
csn_op0_n100_neg_missing_wb_2 sn_op0_n100_neg_missing_wb_2 0 {C_SN}
XMWR_op0_n100_neg_missing_wb_3 sn_op0_n100_neg_missing_wb_3 wwl_des wbl_op0_n100_neg_missing_wb 0 sky130_fd_pr__nfet_01v8 L=0.15 W=0.42 nf=1 ad=0.1218 as=0.1218 pd=1.42 ps=1.42 nrd=0.69047619047619  nrs=0.69047619047619 sa=0 sb=0 sd=0 mult=1 m=1
XMRD_op0_n100_neg_missing_wb_3 rbl_op0_n100_neg_missing_wb sn_op0_n100_neg_missing_wb_3 rwl_des 0 sky130_fd_pr__nfet_01v8 L=0.15 W=0.42 nf=1 ad=0.1218 as=0.1218 pd=1.42 ps=1.42 nrd=0.69047619047619  nrs=0.69047619047619 sa=0 sb=0 sd=0 mult=1 m=1
csn_op0_n100_neg_missing_wb_3 sn_op0_n100_neg_missing_wb_3 0 {C_SN}
XMN1_op0_n100_neg_missing_wb rbl_op0_n100_neg_missing_wb ref_op0_n100_neg_missing_wb vn_op0_n100_neg_missing_wb 0 sky130_fd_pr__nfet_01v8 L=0.15 W=1 nf=1 ad=0.29 as=0.29 pd=2.58 ps=2.58 mult=1 m=1
XMN2_op0_n100_neg_missing_wb ref_op0_n100_neg_missing_wb rbl_op0_n100_neg_missing_wb vn_op0_n100_neg_missing_wb 0 sky130_fd_pr__nfet_01v8 L=0.15 W=1 nf=1 ad=0.29 as=0.29 pd=2.58 ps=2.58 mult=1 m=1
XMP1_op0_n100_neg_missing_wb rbl_op0_n100_neg_missing_wb ref_op0_n100_neg_missing_wb vp_op0_n100_neg_missing_wb vdd sky130_fd_pr__pfet_01v8 L=0.15 W=2 nf=1 ad=0.58 as=0.58 pd=4.58 ps=4.58 mult=1 m=1
XMP2_op0_n100_neg_missing_wb ref_op0_n100_neg_missing_wb rbl_op0_n100_neg_missing_wb vp_op0_n100_neg_missing_wb vdd sky130_fd_pr__pfet_01v8 L=0.15 W=2 nf=1 ad=0.58 as=0.58 pd=4.58 ps=4.58 mult=1 m=1
XMNF_op0_n100_neg_missing_wb vn_op0_n100_neg_missing_wb en_op0_n100_neg_missing_wb 0 0 sky130_fd_pr__nfet_01v8 L=0.15 W=2 nf=1 ad=0.58 as=0.58 pd=4.58 ps=4.58 mult=1 m=1
XMPH_op0_n100_neg_missing_wb vp_op0_n100_neg_missing_wb enb_op0_n100_neg_missing_wb vdd vdd sky130_fd_pr__pfet_01v8 L=0.15 W=4 nf=1 ad=1.16 as=1.16 pd=8.58 ps=8.58 mult=1 m=1
bd_op0_n100_neg_missing_wb d_op0_n100_neg_missing_wb 0 v=v(rbl_op0_n100_neg_missing_wb)-v(ref_op0_n100_neg_missing_wb)

* ---- instance 15: op0_0000_neg_missing_wb (variant neg_missing_wb; probe dec 11.9 ns, release 34 ns, meas 36 ns) ----
vctl_op0_0000_neg_missing_wb ctl_op0_0000_neg_missing_wb 0 pwl(0.0000e+00 {VDD} 2.0000e-09 {VDD} 2.1000e-09 0)
vrs_op0_0000_neg_missing_wb rwls_op0_0000_neg_missing_wb 0 pwl(0.0000e+00 {VDD} 2.0000e-09 {VDD} 2.1000e-09 0 1.2000e-08 0 1.2100e-08 {VDD})
ven_op0_0000_neg_missing_wb en_op0_0000_neg_missing_wb 0 pwl(0.0000e+00 0 1.1000e-08 0 1.1100e-08 {VDD} 3.4000e-08 {VDD} 3.4100e-08 0)
venb_op0_0000_neg_missing_wb enb_op0_0000_neg_missing_wb 0 pwl(0.0000e+00 {VDD} 1.1000e-08 {VDD} 1.1100e-08 0 3.4000e-08 0 3.4100e-08 {VDD})
vww_op0_0000_neg_missing_wb wwl_op0_0000_neg_missing_wb 0 pwl(0.0000e+00 0)
vwc_op0_0000_neg_missing_wb wbc_op0_0000_neg_missing_wb 0 pwl(0.0000e+00 0)
swb_op0_0000_neg_missing_wb ref_op0_0000_neg_missing_wb wbl_op0_0000_neg_missing_wb wbc_op0_0000_neg_missing_wb 0 swwbl
cwbl_op0_0000_neg_missing_wb wbl_op0_0000_neg_missing_wb 0 {C_WBL}
spa_op0_0000_neg_missing_wb prea rbl_op0_0000_neg_missing_wb ctl_op0_0000_neg_missing_wb 0 swpre
spr_op0_0000_neg_missing_wb pref ref_op0_0000_neg_missing_wb ctl_op0_0000_neg_missing_wb 0 swpre
crbl_op0_0000_neg_missing_wb rbl_op0_0000_neg_missing_wb 0 {C_RBL}
cref_op0_0000_neg_missing_wb ref_op0_0000_neg_missing_wb 0 {C_RBL}   $ ASSUMPTION: ideal matched dummy load
XMWR_op0_0000_neg_missing_wb_0 sn_op0_0000_neg_missing_wb_0 wwl_op0_0000_neg_missing_wb wbl_op0_0000_neg_missing_wb 0 sky130_fd_pr__nfet_01v8 L=0.15 W=0.42 nf=1 ad=0.1218 as=0.1218 pd=1.42 ps=1.42 nrd=0.69047619047619  nrs=0.69047619047619 sa=0 sb=0 sd=0 mult=1 m=1
XMRD_op0_0000_neg_missing_wb_0 rbl_op0_0000_neg_missing_wb sn_op0_0000_neg_missing_wb_0 rwls_op0_0000_neg_missing_wb 0 sky130_fd_pr__nfet_01v8 L=0.15 W=0.42 nf=1 ad=0.1218 as=0.1218 pd=1.42 ps=1.42 nrd=0.69047619047619  nrs=0.69047619047619 sa=0 sb=0 sd=0 mult=1 m=1
csn_op0_0000_neg_missing_wb_0 sn_op0_0000_neg_missing_wb_0 0 {C_SN}
XMWR_op0_0000_neg_missing_wb_1 sn_op0_0000_neg_missing_wb_1 wwl_des wbl_op0_0000_neg_missing_wb 0 sky130_fd_pr__nfet_01v8 L=0.15 W=0.42 nf=1 ad=0.1218 as=0.1218 pd=1.42 ps=1.42 nrd=0.69047619047619  nrs=0.69047619047619 sa=0 sb=0 sd=0 mult=1 m=1
XMRD_op0_0000_neg_missing_wb_1 rbl_op0_0000_neg_missing_wb sn_op0_0000_neg_missing_wb_1 rwl_des 0 sky130_fd_pr__nfet_01v8 L=0.15 W=0.42 nf=1 ad=0.1218 as=0.1218 pd=1.42 ps=1.42 nrd=0.69047619047619  nrs=0.69047619047619 sa=0 sb=0 sd=0 mult=1 m=1
csn_op0_0000_neg_missing_wb_1 sn_op0_0000_neg_missing_wb_1 0 {C_SN}
XMWR_op0_0000_neg_missing_wb_2 sn_op0_0000_neg_missing_wb_2 wwl_des wbl_op0_0000_neg_missing_wb 0 sky130_fd_pr__nfet_01v8 L=0.15 W=0.42 nf=1 ad=0.1218 as=0.1218 pd=1.42 ps=1.42 nrd=0.69047619047619  nrs=0.69047619047619 sa=0 sb=0 sd=0 mult=1 m=1
XMRD_op0_0000_neg_missing_wb_2 rbl_op0_0000_neg_missing_wb sn_op0_0000_neg_missing_wb_2 rwl_des 0 sky130_fd_pr__nfet_01v8 L=0.15 W=0.42 nf=1 ad=0.1218 as=0.1218 pd=1.42 ps=1.42 nrd=0.69047619047619  nrs=0.69047619047619 sa=0 sb=0 sd=0 mult=1 m=1
csn_op0_0000_neg_missing_wb_2 sn_op0_0000_neg_missing_wb_2 0 {C_SN}
XMWR_op0_0000_neg_missing_wb_3 sn_op0_0000_neg_missing_wb_3 wwl_des wbl_op0_0000_neg_missing_wb 0 sky130_fd_pr__nfet_01v8 L=0.15 W=0.42 nf=1 ad=0.1218 as=0.1218 pd=1.42 ps=1.42 nrd=0.69047619047619  nrs=0.69047619047619 sa=0 sb=0 sd=0 mult=1 m=1
XMRD_op0_0000_neg_missing_wb_3 rbl_op0_0000_neg_missing_wb sn_op0_0000_neg_missing_wb_3 rwl_des 0 sky130_fd_pr__nfet_01v8 L=0.15 W=0.42 nf=1 ad=0.1218 as=0.1218 pd=1.42 ps=1.42 nrd=0.69047619047619  nrs=0.69047619047619 sa=0 sb=0 sd=0 mult=1 m=1
csn_op0_0000_neg_missing_wb_3 sn_op0_0000_neg_missing_wb_3 0 {C_SN}
XMN1_op0_0000_neg_missing_wb rbl_op0_0000_neg_missing_wb ref_op0_0000_neg_missing_wb vn_op0_0000_neg_missing_wb 0 sky130_fd_pr__nfet_01v8 L=0.15 W=1 nf=1 ad=0.29 as=0.29 pd=2.58 ps=2.58 mult=1 m=1
XMN2_op0_0000_neg_missing_wb ref_op0_0000_neg_missing_wb rbl_op0_0000_neg_missing_wb vn_op0_0000_neg_missing_wb 0 sky130_fd_pr__nfet_01v8 L=0.15 W=1 nf=1 ad=0.29 as=0.29 pd=2.58 ps=2.58 mult=1 m=1
XMP1_op0_0000_neg_missing_wb rbl_op0_0000_neg_missing_wb ref_op0_0000_neg_missing_wb vp_op0_0000_neg_missing_wb vdd sky130_fd_pr__pfet_01v8 L=0.15 W=2 nf=1 ad=0.58 as=0.58 pd=4.58 ps=4.58 mult=1 m=1
XMP2_op0_0000_neg_missing_wb ref_op0_0000_neg_missing_wb rbl_op0_0000_neg_missing_wb vp_op0_0000_neg_missing_wb vdd sky130_fd_pr__pfet_01v8 L=0.15 W=2 nf=1 ad=0.58 as=0.58 pd=4.58 ps=4.58 mult=1 m=1
XMNF_op0_0000_neg_missing_wb vn_op0_0000_neg_missing_wb en_op0_0000_neg_missing_wb 0 0 sky130_fd_pr__nfet_01v8 L=0.15 W=2 nf=1 ad=0.58 as=0.58 pd=4.58 ps=4.58 mult=1 m=1
XMPH_op0_0000_neg_missing_wb vp_op0_0000_neg_missing_wb enb_op0_0000_neg_missing_wb vdd vdd sky130_fd_pr__pfet_01v8 L=0.15 W=4 nf=1 ad=1.16 as=1.16 pd=8.58 ps=8.58 mult=1 m=1
bd_op0_0000_neg_missing_wb d_op0_0000_neg_missing_wb 0 v=v(rbl_op0_0000_neg_missing_wb)-v(ref_op0_0000_neg_missing_wb)

* ---- instance 16: op1_0900_neg_short_wb (variant neg_short_wb; probe dec 11.9 ns, release 34 ns, meas 36 ns) ----
vctl_op1_0900_neg_short_wb ctl_op1_0900_neg_short_wb 0 pwl(0.0000e+00 {VDD} 2.0000e-09 {VDD} 2.1000e-09 0)
vrs_op1_0900_neg_short_wb rwls_op1_0900_neg_short_wb 0 pwl(0.0000e+00 {VDD} 2.0000e-09 {VDD} 2.1000e-09 0 1.2000e-08 0 1.2100e-08 {VDD})
ven_op1_0900_neg_short_wb en_op1_0900_neg_short_wb 0 pwl(0.0000e+00 0 1.1000e-08 0 1.1100e-08 {VDD} 3.4000e-08 {VDD} 3.4100e-08 0)
venb_op1_0900_neg_short_wb enb_op1_0900_neg_short_wb 0 pwl(0.0000e+00 {VDD} 1.1000e-08 {VDD} 1.1100e-08 0 3.4000e-08 0 3.4100e-08 {VDD})
vww_op1_0900_neg_short_wb wwl_op1_0900_neg_short_wb 0 pwl(0.0000e+00 0 1.2000e-08 0 1.2100e-08 {VDD} 1.2200e-08 {VDD} 1.2300e-08 0)
vwc_op1_0900_neg_short_wb wbc_op1_0900_neg_short_wb 0 pwl(0.0000e+00 0 1.2000e-08 0 1.2100e-08 {VDD} 1.2200e-08 {VDD} 1.2300e-08 0)
swb_op1_0900_neg_short_wb ref_op1_0900_neg_short_wb wbl_op1_0900_neg_short_wb wbc_op1_0900_neg_short_wb 0 swwbl
cwbl_op1_0900_neg_short_wb wbl_op1_0900_neg_short_wb 0 {C_WBL}
spa_op1_0900_neg_short_wb prea rbl_op1_0900_neg_short_wb ctl_op1_0900_neg_short_wb 0 swpre
spr_op1_0900_neg_short_wb pref ref_op1_0900_neg_short_wb ctl_op1_0900_neg_short_wb 0 swpre
crbl_op1_0900_neg_short_wb rbl_op1_0900_neg_short_wb 0 {C_RBL}
cref_op1_0900_neg_short_wb ref_op1_0900_neg_short_wb 0 {C_RBL}   $ ASSUMPTION: ideal matched dummy load
XMWR_op1_0900_neg_short_wb_0 sn_op1_0900_neg_short_wb_0 wwl_op1_0900_neg_short_wb wbl_op1_0900_neg_short_wb 0 sky130_fd_pr__nfet_01v8 L=0.15 W=0.42 nf=1 ad=0.1218 as=0.1218 pd=1.42 ps=1.42 nrd=0.69047619047619  nrs=0.69047619047619 sa=0 sb=0 sd=0 mult=1 m=1
XMRD_op1_0900_neg_short_wb_0 rbl_op1_0900_neg_short_wb sn_op1_0900_neg_short_wb_0 rwls_op1_0900_neg_short_wb 0 sky130_fd_pr__nfet_01v8 L=0.15 W=0.42 nf=1 ad=0.1218 as=0.1218 pd=1.42 ps=1.42 nrd=0.69047619047619  nrs=0.69047619047619 sa=0 sb=0 sd=0 mult=1 m=1
csn_op1_0900_neg_short_wb_0 sn_op1_0900_neg_short_wb_0 0 {C_SN}
XMWR_op1_0900_neg_short_wb_1 sn_op1_0900_neg_short_wb_1 wwl_des wbl_op1_0900_neg_short_wb 0 sky130_fd_pr__nfet_01v8 L=0.15 W=0.42 nf=1 ad=0.1218 as=0.1218 pd=1.42 ps=1.42 nrd=0.69047619047619  nrs=0.69047619047619 sa=0 sb=0 sd=0 mult=1 m=1
XMRD_op1_0900_neg_short_wb_1 rbl_op1_0900_neg_short_wb sn_op1_0900_neg_short_wb_1 rwl_des 0 sky130_fd_pr__nfet_01v8 L=0.15 W=0.42 nf=1 ad=0.1218 as=0.1218 pd=1.42 ps=1.42 nrd=0.69047619047619  nrs=0.69047619047619 sa=0 sb=0 sd=0 mult=1 m=1
csn_op1_0900_neg_short_wb_1 sn_op1_0900_neg_short_wb_1 0 {C_SN}
XMWR_op1_0900_neg_short_wb_2 sn_op1_0900_neg_short_wb_2 wwl_des wbl_op1_0900_neg_short_wb 0 sky130_fd_pr__nfet_01v8 L=0.15 W=0.42 nf=1 ad=0.1218 as=0.1218 pd=1.42 ps=1.42 nrd=0.69047619047619  nrs=0.69047619047619 sa=0 sb=0 sd=0 mult=1 m=1
XMRD_op1_0900_neg_short_wb_2 rbl_op1_0900_neg_short_wb sn_op1_0900_neg_short_wb_2 rwl_des 0 sky130_fd_pr__nfet_01v8 L=0.15 W=0.42 nf=1 ad=0.1218 as=0.1218 pd=1.42 ps=1.42 nrd=0.69047619047619  nrs=0.69047619047619 sa=0 sb=0 sd=0 mult=1 m=1
csn_op1_0900_neg_short_wb_2 sn_op1_0900_neg_short_wb_2 0 {C_SN}
XMWR_op1_0900_neg_short_wb_3 sn_op1_0900_neg_short_wb_3 wwl_des wbl_op1_0900_neg_short_wb 0 sky130_fd_pr__nfet_01v8 L=0.15 W=0.42 nf=1 ad=0.1218 as=0.1218 pd=1.42 ps=1.42 nrd=0.69047619047619  nrs=0.69047619047619 sa=0 sb=0 sd=0 mult=1 m=1
XMRD_op1_0900_neg_short_wb_3 rbl_op1_0900_neg_short_wb sn_op1_0900_neg_short_wb_3 rwl_des 0 sky130_fd_pr__nfet_01v8 L=0.15 W=0.42 nf=1 ad=0.1218 as=0.1218 pd=1.42 ps=1.42 nrd=0.69047619047619  nrs=0.69047619047619 sa=0 sb=0 sd=0 mult=1 m=1
csn_op1_0900_neg_short_wb_3 sn_op1_0900_neg_short_wb_3 0 {C_SN}
XMN1_op1_0900_neg_short_wb rbl_op1_0900_neg_short_wb ref_op1_0900_neg_short_wb vn_op1_0900_neg_short_wb 0 sky130_fd_pr__nfet_01v8 L=0.15 W=1 nf=1 ad=0.29 as=0.29 pd=2.58 ps=2.58 mult=1 m=1
XMN2_op1_0900_neg_short_wb ref_op1_0900_neg_short_wb rbl_op1_0900_neg_short_wb vn_op1_0900_neg_short_wb 0 sky130_fd_pr__nfet_01v8 L=0.15 W=1 nf=1 ad=0.29 as=0.29 pd=2.58 ps=2.58 mult=1 m=1
XMP1_op1_0900_neg_short_wb rbl_op1_0900_neg_short_wb ref_op1_0900_neg_short_wb vp_op1_0900_neg_short_wb vdd sky130_fd_pr__pfet_01v8 L=0.15 W=2 nf=1 ad=0.58 as=0.58 pd=4.58 ps=4.58 mult=1 m=1
XMP2_op1_0900_neg_short_wb ref_op1_0900_neg_short_wb rbl_op1_0900_neg_short_wb vp_op1_0900_neg_short_wb vdd sky130_fd_pr__pfet_01v8 L=0.15 W=2 nf=1 ad=0.58 as=0.58 pd=4.58 ps=4.58 mult=1 m=1
XMNF_op1_0900_neg_short_wb vn_op1_0900_neg_short_wb en_op1_0900_neg_short_wb 0 0 sky130_fd_pr__nfet_01v8 L=0.15 W=2 nf=1 ad=0.58 as=0.58 pd=4.58 ps=4.58 mult=1 m=1
XMPH_op1_0900_neg_short_wb vp_op1_0900_neg_short_wb enb_op1_0900_neg_short_wb vdd vdd sky130_fd_pr__pfet_01v8 L=0.15 W=4 nf=1 ad=1.16 as=1.16 pd=8.58 ps=8.58 mult=1 m=1
bd_op1_0900_neg_short_wb d_op1_0900_neg_short_wb 0 v=v(rbl_op1_0900_neg_short_wb)-v(ref_op1_0900_neg_short_wb)

* ---- instance 17: op1_1000_neg_short_wb (variant neg_short_wb; probe dec 11.9 ns, release 34 ns, meas 36 ns) ----
vctl_op1_1000_neg_short_wb ctl_op1_1000_neg_short_wb 0 pwl(0.0000e+00 {VDD} 2.0000e-09 {VDD} 2.1000e-09 0)
vrs_op1_1000_neg_short_wb rwls_op1_1000_neg_short_wb 0 pwl(0.0000e+00 {VDD} 2.0000e-09 {VDD} 2.1000e-09 0 1.2000e-08 0 1.2100e-08 {VDD})
ven_op1_1000_neg_short_wb en_op1_1000_neg_short_wb 0 pwl(0.0000e+00 0 1.1000e-08 0 1.1100e-08 {VDD} 3.4000e-08 {VDD} 3.4100e-08 0)
venb_op1_1000_neg_short_wb enb_op1_1000_neg_short_wb 0 pwl(0.0000e+00 {VDD} 1.1000e-08 {VDD} 1.1100e-08 0 3.4000e-08 0 3.4100e-08 {VDD})
vww_op1_1000_neg_short_wb wwl_op1_1000_neg_short_wb 0 pwl(0.0000e+00 0 1.2000e-08 0 1.2100e-08 {VDD} 1.2200e-08 {VDD} 1.2300e-08 0)
vwc_op1_1000_neg_short_wb wbc_op1_1000_neg_short_wb 0 pwl(0.0000e+00 0 1.2000e-08 0 1.2100e-08 {VDD} 1.2200e-08 {VDD} 1.2300e-08 0)
swb_op1_1000_neg_short_wb ref_op1_1000_neg_short_wb wbl_op1_1000_neg_short_wb wbc_op1_1000_neg_short_wb 0 swwbl
cwbl_op1_1000_neg_short_wb wbl_op1_1000_neg_short_wb 0 {C_WBL}
spa_op1_1000_neg_short_wb prea rbl_op1_1000_neg_short_wb ctl_op1_1000_neg_short_wb 0 swpre
spr_op1_1000_neg_short_wb pref ref_op1_1000_neg_short_wb ctl_op1_1000_neg_short_wb 0 swpre
crbl_op1_1000_neg_short_wb rbl_op1_1000_neg_short_wb 0 {C_RBL}
cref_op1_1000_neg_short_wb ref_op1_1000_neg_short_wb 0 {C_RBL}   $ ASSUMPTION: ideal matched dummy load
XMWR_op1_1000_neg_short_wb_0 sn_op1_1000_neg_short_wb_0 wwl_op1_1000_neg_short_wb wbl_op1_1000_neg_short_wb 0 sky130_fd_pr__nfet_01v8 L=0.15 W=0.42 nf=1 ad=0.1218 as=0.1218 pd=1.42 ps=1.42 nrd=0.69047619047619  nrs=0.69047619047619 sa=0 sb=0 sd=0 mult=1 m=1
XMRD_op1_1000_neg_short_wb_0 rbl_op1_1000_neg_short_wb sn_op1_1000_neg_short_wb_0 rwls_op1_1000_neg_short_wb 0 sky130_fd_pr__nfet_01v8 L=0.15 W=0.42 nf=1 ad=0.1218 as=0.1218 pd=1.42 ps=1.42 nrd=0.69047619047619  nrs=0.69047619047619 sa=0 sb=0 sd=0 mult=1 m=1
csn_op1_1000_neg_short_wb_0 sn_op1_1000_neg_short_wb_0 0 {C_SN}
XMWR_op1_1000_neg_short_wb_1 sn_op1_1000_neg_short_wb_1 wwl_des wbl_op1_1000_neg_short_wb 0 sky130_fd_pr__nfet_01v8 L=0.15 W=0.42 nf=1 ad=0.1218 as=0.1218 pd=1.42 ps=1.42 nrd=0.69047619047619  nrs=0.69047619047619 sa=0 sb=0 sd=0 mult=1 m=1
XMRD_op1_1000_neg_short_wb_1 rbl_op1_1000_neg_short_wb sn_op1_1000_neg_short_wb_1 rwl_des 0 sky130_fd_pr__nfet_01v8 L=0.15 W=0.42 nf=1 ad=0.1218 as=0.1218 pd=1.42 ps=1.42 nrd=0.69047619047619  nrs=0.69047619047619 sa=0 sb=0 sd=0 mult=1 m=1
csn_op1_1000_neg_short_wb_1 sn_op1_1000_neg_short_wb_1 0 {C_SN}
XMWR_op1_1000_neg_short_wb_2 sn_op1_1000_neg_short_wb_2 wwl_des wbl_op1_1000_neg_short_wb 0 sky130_fd_pr__nfet_01v8 L=0.15 W=0.42 nf=1 ad=0.1218 as=0.1218 pd=1.42 ps=1.42 nrd=0.69047619047619  nrs=0.69047619047619 sa=0 sb=0 sd=0 mult=1 m=1
XMRD_op1_1000_neg_short_wb_2 rbl_op1_1000_neg_short_wb sn_op1_1000_neg_short_wb_2 rwl_des 0 sky130_fd_pr__nfet_01v8 L=0.15 W=0.42 nf=1 ad=0.1218 as=0.1218 pd=1.42 ps=1.42 nrd=0.69047619047619  nrs=0.69047619047619 sa=0 sb=0 sd=0 mult=1 m=1
csn_op1_1000_neg_short_wb_2 sn_op1_1000_neg_short_wb_2 0 {C_SN}
XMWR_op1_1000_neg_short_wb_3 sn_op1_1000_neg_short_wb_3 wwl_des wbl_op1_1000_neg_short_wb 0 sky130_fd_pr__nfet_01v8 L=0.15 W=0.42 nf=1 ad=0.1218 as=0.1218 pd=1.42 ps=1.42 nrd=0.69047619047619  nrs=0.69047619047619 sa=0 sb=0 sd=0 mult=1 m=1
XMRD_op1_1000_neg_short_wb_3 rbl_op1_1000_neg_short_wb sn_op1_1000_neg_short_wb_3 rwl_des 0 sky130_fd_pr__nfet_01v8 L=0.15 W=0.42 nf=1 ad=0.1218 as=0.1218 pd=1.42 ps=1.42 nrd=0.69047619047619  nrs=0.69047619047619 sa=0 sb=0 sd=0 mult=1 m=1
csn_op1_1000_neg_short_wb_3 sn_op1_1000_neg_short_wb_3 0 {C_SN}
XMN1_op1_1000_neg_short_wb rbl_op1_1000_neg_short_wb ref_op1_1000_neg_short_wb vn_op1_1000_neg_short_wb 0 sky130_fd_pr__nfet_01v8 L=0.15 W=1 nf=1 ad=0.29 as=0.29 pd=2.58 ps=2.58 mult=1 m=1
XMN2_op1_1000_neg_short_wb ref_op1_1000_neg_short_wb rbl_op1_1000_neg_short_wb vn_op1_1000_neg_short_wb 0 sky130_fd_pr__nfet_01v8 L=0.15 W=1 nf=1 ad=0.29 as=0.29 pd=2.58 ps=2.58 mult=1 m=1
XMP1_op1_1000_neg_short_wb rbl_op1_1000_neg_short_wb ref_op1_1000_neg_short_wb vp_op1_1000_neg_short_wb vdd sky130_fd_pr__pfet_01v8 L=0.15 W=2 nf=1 ad=0.58 as=0.58 pd=4.58 ps=4.58 mult=1 m=1
XMP2_op1_1000_neg_short_wb ref_op1_1000_neg_short_wb rbl_op1_1000_neg_short_wb vp_op1_1000_neg_short_wb vdd sky130_fd_pr__pfet_01v8 L=0.15 W=2 nf=1 ad=0.58 as=0.58 pd=4.58 ps=4.58 mult=1 m=1
XMNF_op1_1000_neg_short_wb vn_op1_1000_neg_short_wb en_op1_1000_neg_short_wb 0 0 sky130_fd_pr__nfet_01v8 L=0.15 W=2 nf=1 ad=0.58 as=0.58 pd=4.58 ps=4.58 mult=1 m=1
XMPH_op1_1000_neg_short_wb vp_op1_1000_neg_short_wb enb_op1_1000_neg_short_wb vdd vdd sky130_fd_pr__pfet_01v8 L=0.15 W=4 nf=1 ad=1.16 as=1.16 pd=8.58 ps=8.58 mult=1 m=1
bd_op1_1000_neg_short_wb d_op1_1000_neg_short_wb 0 v=v(rbl_op1_1000_neg_short_wb)-v(ref_op1_1000_neg_short_wb)

* ---- instance 18: op0_n100_neg_short_wb (variant neg_short_wb; probe dec 11.9 ns, release 34 ns, meas 36 ns) ----
vctl_op0_n100_neg_short_wb ctl_op0_n100_neg_short_wb 0 pwl(0.0000e+00 {VDD} 2.0000e-09 {VDD} 2.1000e-09 0)
vrs_op0_n100_neg_short_wb rwls_op0_n100_neg_short_wb 0 pwl(0.0000e+00 {VDD} 2.0000e-09 {VDD} 2.1000e-09 0 1.2000e-08 0 1.2100e-08 {VDD})
ven_op0_n100_neg_short_wb en_op0_n100_neg_short_wb 0 pwl(0.0000e+00 0 1.1000e-08 0 1.1100e-08 {VDD} 3.4000e-08 {VDD} 3.4100e-08 0)
venb_op0_n100_neg_short_wb enb_op0_n100_neg_short_wb 0 pwl(0.0000e+00 {VDD} 1.1000e-08 {VDD} 1.1100e-08 0 3.4000e-08 0 3.4100e-08 {VDD})
vww_op0_n100_neg_short_wb wwl_op0_n100_neg_short_wb 0 pwl(0.0000e+00 0 1.2000e-08 0 1.2100e-08 {VDD} 1.2200e-08 {VDD} 1.2300e-08 0)
vwc_op0_n100_neg_short_wb wbc_op0_n100_neg_short_wb 0 pwl(0.0000e+00 0 1.2000e-08 0 1.2100e-08 {VDD} 1.2200e-08 {VDD} 1.2300e-08 0)
swb_op0_n100_neg_short_wb ref_op0_n100_neg_short_wb wbl_op0_n100_neg_short_wb wbc_op0_n100_neg_short_wb 0 swwbl
cwbl_op0_n100_neg_short_wb wbl_op0_n100_neg_short_wb 0 {C_WBL}
spa_op0_n100_neg_short_wb prea rbl_op0_n100_neg_short_wb ctl_op0_n100_neg_short_wb 0 swpre
spr_op0_n100_neg_short_wb pref ref_op0_n100_neg_short_wb ctl_op0_n100_neg_short_wb 0 swpre
crbl_op0_n100_neg_short_wb rbl_op0_n100_neg_short_wb 0 {C_RBL}
cref_op0_n100_neg_short_wb ref_op0_n100_neg_short_wb 0 {C_RBL}   $ ASSUMPTION: ideal matched dummy load
XMWR_op0_n100_neg_short_wb_0 sn_op0_n100_neg_short_wb_0 wwl_op0_n100_neg_short_wb wbl_op0_n100_neg_short_wb 0 sky130_fd_pr__nfet_01v8 L=0.15 W=0.42 nf=1 ad=0.1218 as=0.1218 pd=1.42 ps=1.42 nrd=0.69047619047619  nrs=0.69047619047619 sa=0 sb=0 sd=0 mult=1 m=1
XMRD_op0_n100_neg_short_wb_0 rbl_op0_n100_neg_short_wb sn_op0_n100_neg_short_wb_0 rwls_op0_n100_neg_short_wb 0 sky130_fd_pr__nfet_01v8 L=0.15 W=0.42 nf=1 ad=0.1218 as=0.1218 pd=1.42 ps=1.42 nrd=0.69047619047619  nrs=0.69047619047619 sa=0 sb=0 sd=0 mult=1 m=1
csn_op0_n100_neg_short_wb_0 sn_op0_n100_neg_short_wb_0 0 {C_SN}
XMWR_op0_n100_neg_short_wb_1 sn_op0_n100_neg_short_wb_1 wwl_des wbl_op0_n100_neg_short_wb 0 sky130_fd_pr__nfet_01v8 L=0.15 W=0.42 nf=1 ad=0.1218 as=0.1218 pd=1.42 ps=1.42 nrd=0.69047619047619  nrs=0.69047619047619 sa=0 sb=0 sd=0 mult=1 m=1
XMRD_op0_n100_neg_short_wb_1 rbl_op0_n100_neg_short_wb sn_op0_n100_neg_short_wb_1 rwl_des 0 sky130_fd_pr__nfet_01v8 L=0.15 W=0.42 nf=1 ad=0.1218 as=0.1218 pd=1.42 ps=1.42 nrd=0.69047619047619  nrs=0.69047619047619 sa=0 sb=0 sd=0 mult=1 m=1
csn_op0_n100_neg_short_wb_1 sn_op0_n100_neg_short_wb_1 0 {C_SN}
XMWR_op0_n100_neg_short_wb_2 sn_op0_n100_neg_short_wb_2 wwl_des wbl_op0_n100_neg_short_wb 0 sky130_fd_pr__nfet_01v8 L=0.15 W=0.42 nf=1 ad=0.1218 as=0.1218 pd=1.42 ps=1.42 nrd=0.69047619047619  nrs=0.69047619047619 sa=0 sb=0 sd=0 mult=1 m=1
XMRD_op0_n100_neg_short_wb_2 rbl_op0_n100_neg_short_wb sn_op0_n100_neg_short_wb_2 rwl_des 0 sky130_fd_pr__nfet_01v8 L=0.15 W=0.42 nf=1 ad=0.1218 as=0.1218 pd=1.42 ps=1.42 nrd=0.69047619047619  nrs=0.69047619047619 sa=0 sb=0 sd=0 mult=1 m=1
csn_op0_n100_neg_short_wb_2 sn_op0_n100_neg_short_wb_2 0 {C_SN}
XMWR_op0_n100_neg_short_wb_3 sn_op0_n100_neg_short_wb_3 wwl_des wbl_op0_n100_neg_short_wb 0 sky130_fd_pr__nfet_01v8 L=0.15 W=0.42 nf=1 ad=0.1218 as=0.1218 pd=1.42 ps=1.42 nrd=0.69047619047619  nrs=0.69047619047619 sa=0 sb=0 sd=0 mult=1 m=1
XMRD_op0_n100_neg_short_wb_3 rbl_op0_n100_neg_short_wb sn_op0_n100_neg_short_wb_3 rwl_des 0 sky130_fd_pr__nfet_01v8 L=0.15 W=0.42 nf=1 ad=0.1218 as=0.1218 pd=1.42 ps=1.42 nrd=0.69047619047619  nrs=0.69047619047619 sa=0 sb=0 sd=0 mult=1 m=1
csn_op0_n100_neg_short_wb_3 sn_op0_n100_neg_short_wb_3 0 {C_SN}
XMN1_op0_n100_neg_short_wb rbl_op0_n100_neg_short_wb ref_op0_n100_neg_short_wb vn_op0_n100_neg_short_wb 0 sky130_fd_pr__nfet_01v8 L=0.15 W=1 nf=1 ad=0.29 as=0.29 pd=2.58 ps=2.58 mult=1 m=1
XMN2_op0_n100_neg_short_wb ref_op0_n100_neg_short_wb rbl_op0_n100_neg_short_wb vn_op0_n100_neg_short_wb 0 sky130_fd_pr__nfet_01v8 L=0.15 W=1 nf=1 ad=0.29 as=0.29 pd=2.58 ps=2.58 mult=1 m=1
XMP1_op0_n100_neg_short_wb rbl_op0_n100_neg_short_wb ref_op0_n100_neg_short_wb vp_op0_n100_neg_short_wb vdd sky130_fd_pr__pfet_01v8 L=0.15 W=2 nf=1 ad=0.58 as=0.58 pd=4.58 ps=4.58 mult=1 m=1
XMP2_op0_n100_neg_short_wb ref_op0_n100_neg_short_wb rbl_op0_n100_neg_short_wb vp_op0_n100_neg_short_wb vdd sky130_fd_pr__pfet_01v8 L=0.15 W=2 nf=1 ad=0.58 as=0.58 pd=4.58 ps=4.58 mult=1 m=1
XMNF_op0_n100_neg_short_wb vn_op0_n100_neg_short_wb en_op0_n100_neg_short_wb 0 0 sky130_fd_pr__nfet_01v8 L=0.15 W=2 nf=1 ad=0.58 as=0.58 pd=4.58 ps=4.58 mult=1 m=1
XMPH_op0_n100_neg_short_wb vp_op0_n100_neg_short_wb enb_op0_n100_neg_short_wb vdd vdd sky130_fd_pr__pfet_01v8 L=0.15 W=4 nf=1 ad=1.16 as=1.16 pd=8.58 ps=8.58 mult=1 m=1
bd_op0_n100_neg_short_wb d_op0_n100_neg_short_wb 0 v=v(rbl_op0_n100_neg_short_wb)-v(ref_op0_n100_neg_short_wb)

* ---- instance 19: op0_0000_neg_short_wb (variant neg_short_wb; probe dec 11.9 ns, release 34 ns, meas 36 ns) ----
vctl_op0_0000_neg_short_wb ctl_op0_0000_neg_short_wb 0 pwl(0.0000e+00 {VDD} 2.0000e-09 {VDD} 2.1000e-09 0)
vrs_op0_0000_neg_short_wb rwls_op0_0000_neg_short_wb 0 pwl(0.0000e+00 {VDD} 2.0000e-09 {VDD} 2.1000e-09 0 1.2000e-08 0 1.2100e-08 {VDD})
ven_op0_0000_neg_short_wb en_op0_0000_neg_short_wb 0 pwl(0.0000e+00 0 1.1000e-08 0 1.1100e-08 {VDD} 3.4000e-08 {VDD} 3.4100e-08 0)
venb_op0_0000_neg_short_wb enb_op0_0000_neg_short_wb 0 pwl(0.0000e+00 {VDD} 1.1000e-08 {VDD} 1.1100e-08 0 3.4000e-08 0 3.4100e-08 {VDD})
vww_op0_0000_neg_short_wb wwl_op0_0000_neg_short_wb 0 pwl(0.0000e+00 0 1.2000e-08 0 1.2100e-08 {VDD} 1.2200e-08 {VDD} 1.2300e-08 0)
vwc_op0_0000_neg_short_wb wbc_op0_0000_neg_short_wb 0 pwl(0.0000e+00 0 1.2000e-08 0 1.2100e-08 {VDD} 1.2200e-08 {VDD} 1.2300e-08 0)
swb_op0_0000_neg_short_wb ref_op0_0000_neg_short_wb wbl_op0_0000_neg_short_wb wbc_op0_0000_neg_short_wb 0 swwbl
cwbl_op0_0000_neg_short_wb wbl_op0_0000_neg_short_wb 0 {C_WBL}
spa_op0_0000_neg_short_wb prea rbl_op0_0000_neg_short_wb ctl_op0_0000_neg_short_wb 0 swpre
spr_op0_0000_neg_short_wb pref ref_op0_0000_neg_short_wb ctl_op0_0000_neg_short_wb 0 swpre
crbl_op0_0000_neg_short_wb rbl_op0_0000_neg_short_wb 0 {C_RBL}
cref_op0_0000_neg_short_wb ref_op0_0000_neg_short_wb 0 {C_RBL}   $ ASSUMPTION: ideal matched dummy load
XMWR_op0_0000_neg_short_wb_0 sn_op0_0000_neg_short_wb_0 wwl_op0_0000_neg_short_wb wbl_op0_0000_neg_short_wb 0 sky130_fd_pr__nfet_01v8 L=0.15 W=0.42 nf=1 ad=0.1218 as=0.1218 pd=1.42 ps=1.42 nrd=0.69047619047619  nrs=0.69047619047619 sa=0 sb=0 sd=0 mult=1 m=1
XMRD_op0_0000_neg_short_wb_0 rbl_op0_0000_neg_short_wb sn_op0_0000_neg_short_wb_0 rwls_op0_0000_neg_short_wb 0 sky130_fd_pr__nfet_01v8 L=0.15 W=0.42 nf=1 ad=0.1218 as=0.1218 pd=1.42 ps=1.42 nrd=0.69047619047619  nrs=0.69047619047619 sa=0 sb=0 sd=0 mult=1 m=1
csn_op0_0000_neg_short_wb_0 sn_op0_0000_neg_short_wb_0 0 {C_SN}
XMWR_op0_0000_neg_short_wb_1 sn_op0_0000_neg_short_wb_1 wwl_des wbl_op0_0000_neg_short_wb 0 sky130_fd_pr__nfet_01v8 L=0.15 W=0.42 nf=1 ad=0.1218 as=0.1218 pd=1.42 ps=1.42 nrd=0.69047619047619  nrs=0.69047619047619 sa=0 sb=0 sd=0 mult=1 m=1
XMRD_op0_0000_neg_short_wb_1 rbl_op0_0000_neg_short_wb sn_op0_0000_neg_short_wb_1 rwl_des 0 sky130_fd_pr__nfet_01v8 L=0.15 W=0.42 nf=1 ad=0.1218 as=0.1218 pd=1.42 ps=1.42 nrd=0.69047619047619  nrs=0.69047619047619 sa=0 sb=0 sd=0 mult=1 m=1
csn_op0_0000_neg_short_wb_1 sn_op0_0000_neg_short_wb_1 0 {C_SN}
XMWR_op0_0000_neg_short_wb_2 sn_op0_0000_neg_short_wb_2 wwl_des wbl_op0_0000_neg_short_wb 0 sky130_fd_pr__nfet_01v8 L=0.15 W=0.42 nf=1 ad=0.1218 as=0.1218 pd=1.42 ps=1.42 nrd=0.69047619047619  nrs=0.69047619047619 sa=0 sb=0 sd=0 mult=1 m=1
XMRD_op0_0000_neg_short_wb_2 rbl_op0_0000_neg_short_wb sn_op0_0000_neg_short_wb_2 rwl_des 0 sky130_fd_pr__nfet_01v8 L=0.15 W=0.42 nf=1 ad=0.1218 as=0.1218 pd=1.42 ps=1.42 nrd=0.69047619047619  nrs=0.69047619047619 sa=0 sb=0 sd=0 mult=1 m=1
csn_op0_0000_neg_short_wb_2 sn_op0_0000_neg_short_wb_2 0 {C_SN}
XMWR_op0_0000_neg_short_wb_3 sn_op0_0000_neg_short_wb_3 wwl_des wbl_op0_0000_neg_short_wb 0 sky130_fd_pr__nfet_01v8 L=0.15 W=0.42 nf=1 ad=0.1218 as=0.1218 pd=1.42 ps=1.42 nrd=0.69047619047619  nrs=0.69047619047619 sa=0 sb=0 sd=0 mult=1 m=1
XMRD_op0_0000_neg_short_wb_3 rbl_op0_0000_neg_short_wb sn_op0_0000_neg_short_wb_3 rwl_des 0 sky130_fd_pr__nfet_01v8 L=0.15 W=0.42 nf=1 ad=0.1218 as=0.1218 pd=1.42 ps=1.42 nrd=0.69047619047619  nrs=0.69047619047619 sa=0 sb=0 sd=0 mult=1 m=1
csn_op0_0000_neg_short_wb_3 sn_op0_0000_neg_short_wb_3 0 {C_SN}
XMN1_op0_0000_neg_short_wb rbl_op0_0000_neg_short_wb ref_op0_0000_neg_short_wb vn_op0_0000_neg_short_wb 0 sky130_fd_pr__nfet_01v8 L=0.15 W=1 nf=1 ad=0.29 as=0.29 pd=2.58 ps=2.58 mult=1 m=1
XMN2_op0_0000_neg_short_wb ref_op0_0000_neg_short_wb rbl_op0_0000_neg_short_wb vn_op0_0000_neg_short_wb 0 sky130_fd_pr__nfet_01v8 L=0.15 W=1 nf=1 ad=0.29 as=0.29 pd=2.58 ps=2.58 mult=1 m=1
XMP1_op0_0000_neg_short_wb rbl_op0_0000_neg_short_wb ref_op0_0000_neg_short_wb vp_op0_0000_neg_short_wb vdd sky130_fd_pr__pfet_01v8 L=0.15 W=2 nf=1 ad=0.58 as=0.58 pd=4.58 ps=4.58 mult=1 m=1
XMP2_op0_0000_neg_short_wb ref_op0_0000_neg_short_wb rbl_op0_0000_neg_short_wb vp_op0_0000_neg_short_wb vdd sky130_fd_pr__pfet_01v8 L=0.15 W=2 nf=1 ad=0.58 as=0.58 pd=4.58 ps=4.58 mult=1 m=1
XMNF_op0_0000_neg_short_wb vn_op0_0000_neg_short_wb en_op0_0000_neg_short_wb 0 0 sky130_fd_pr__nfet_01v8 L=0.15 W=2 nf=1 ad=0.58 as=0.58 pd=4.58 ps=4.58 mult=1 m=1
XMPH_op0_0000_neg_short_wb vp_op0_0000_neg_short_wb enb_op0_0000_neg_short_wb vdd vdd sky130_fd_pr__pfet_01v8 L=0.15 W=4 nf=1 ad=1.16 as=1.16 pd=8.58 ps=8.58 mult=1 m=1
bd_op0_0000_neg_short_wb d_op0_0000_neg_short_wb 0 v=v(rbl_op0_0000_neg_short_wb)-v(ref_op0_0000_neg_short_wb)

* ---- instance 20: op1_0900_rwl_late_raw (variant rwl_late_raw; probe dec 11.9 ns, release 34 ns, meas 36 ns) ----
vctl_op1_0900_rwl_late_raw ctl_op1_0900_rwl_late_raw 0 pwl(0.0000e+00 {VDD} 2.0000e-09 {VDD} 2.1000e-09 0)
vrs_op1_0900_rwl_late_raw rwls_op1_0900_rwl_late_raw 0 pwl(0.0000e+00 {VDD} 2.0000e-09 {VDD} 2.1000e-09 0 3.4000e-08 0 3.4100e-08 {VDD})
ven_op1_0900_rwl_late_raw en_op1_0900_rwl_late_raw 0 pwl(0.0000e+00 0 1.1000e-08 0 1.1100e-08 {VDD} 1.2000e-08 {VDD} 1.2100e-08 0)
venb_op1_0900_rwl_late_raw enb_op1_0900_rwl_late_raw 0 pwl(0.0000e+00 {VDD} 1.1000e-08 {VDD} 1.1100e-08 0 1.2000e-08 0 1.2100e-08 {VDD})
vww_op1_0900_rwl_late_raw wwl_op1_0900_rwl_late_raw 0 pwl(0.0000e+00 0 1.2000e-08 0 1.2100e-08 {VDD} 3.2000e-08 {VDD} 3.2100e-08 0)
vwc_op1_0900_rwl_late_raw wbc_op1_0900_rwl_late_raw 0 pwl(0.0000e+00 0 1.2000e-08 0 1.2100e-08 {VDD} 3.4000e-08 {VDD} 3.4100e-08 0)
swb_op1_0900_rwl_late_raw ref_op1_0900_rwl_late_raw wbl_op1_0900_rwl_late_raw wbc_op1_0900_rwl_late_raw 0 swwbl
cwbl_op1_0900_rwl_late_raw wbl_op1_0900_rwl_late_raw 0 {C_WBL}
spa_op1_0900_rwl_late_raw prea rbl_op1_0900_rwl_late_raw ctl_op1_0900_rwl_late_raw 0 swpre
spr_op1_0900_rwl_late_raw pref ref_op1_0900_rwl_late_raw ctl_op1_0900_rwl_late_raw 0 swpre
crbl_op1_0900_rwl_late_raw rbl_op1_0900_rwl_late_raw 0 {C_RBL}
cref_op1_0900_rwl_late_raw ref_op1_0900_rwl_late_raw 0 {C_RBL}   $ ASSUMPTION: ideal matched dummy load
XMWR_op1_0900_rwl_late_raw_0 sn_op1_0900_rwl_late_raw_0 wwl_op1_0900_rwl_late_raw wbl_op1_0900_rwl_late_raw 0 sky130_fd_pr__nfet_01v8 L=0.15 W=0.42 nf=1 ad=0.1218 as=0.1218 pd=1.42 ps=1.42 nrd=0.69047619047619  nrs=0.69047619047619 sa=0 sb=0 sd=0 mult=1 m=1
XMRD_op1_0900_rwl_late_raw_0 rbl_op1_0900_rwl_late_raw sn_op1_0900_rwl_late_raw_0 rwls_op1_0900_rwl_late_raw 0 sky130_fd_pr__nfet_01v8 L=0.15 W=0.42 nf=1 ad=0.1218 as=0.1218 pd=1.42 ps=1.42 nrd=0.69047619047619  nrs=0.69047619047619 sa=0 sb=0 sd=0 mult=1 m=1
csn_op1_0900_rwl_late_raw_0 sn_op1_0900_rwl_late_raw_0 0 {C_SN}
XMWR_op1_0900_rwl_late_raw_1 sn_op1_0900_rwl_late_raw_1 wwl_des wbl_op1_0900_rwl_late_raw 0 sky130_fd_pr__nfet_01v8 L=0.15 W=0.42 nf=1 ad=0.1218 as=0.1218 pd=1.42 ps=1.42 nrd=0.69047619047619  nrs=0.69047619047619 sa=0 sb=0 sd=0 mult=1 m=1
XMRD_op1_0900_rwl_late_raw_1 rbl_op1_0900_rwl_late_raw sn_op1_0900_rwl_late_raw_1 rwl_des 0 sky130_fd_pr__nfet_01v8 L=0.15 W=0.42 nf=1 ad=0.1218 as=0.1218 pd=1.42 ps=1.42 nrd=0.69047619047619  nrs=0.69047619047619 sa=0 sb=0 sd=0 mult=1 m=1
csn_op1_0900_rwl_late_raw_1 sn_op1_0900_rwl_late_raw_1 0 {C_SN}
XMWR_op1_0900_rwl_late_raw_2 sn_op1_0900_rwl_late_raw_2 wwl_des wbl_op1_0900_rwl_late_raw 0 sky130_fd_pr__nfet_01v8 L=0.15 W=0.42 nf=1 ad=0.1218 as=0.1218 pd=1.42 ps=1.42 nrd=0.69047619047619  nrs=0.69047619047619 sa=0 sb=0 sd=0 mult=1 m=1
XMRD_op1_0900_rwl_late_raw_2 rbl_op1_0900_rwl_late_raw sn_op1_0900_rwl_late_raw_2 rwl_des 0 sky130_fd_pr__nfet_01v8 L=0.15 W=0.42 nf=1 ad=0.1218 as=0.1218 pd=1.42 ps=1.42 nrd=0.69047619047619  nrs=0.69047619047619 sa=0 sb=0 sd=0 mult=1 m=1
csn_op1_0900_rwl_late_raw_2 sn_op1_0900_rwl_late_raw_2 0 {C_SN}
XMWR_op1_0900_rwl_late_raw_3 sn_op1_0900_rwl_late_raw_3 wwl_des wbl_op1_0900_rwl_late_raw 0 sky130_fd_pr__nfet_01v8 L=0.15 W=0.42 nf=1 ad=0.1218 as=0.1218 pd=1.42 ps=1.42 nrd=0.69047619047619  nrs=0.69047619047619 sa=0 sb=0 sd=0 mult=1 m=1
XMRD_op1_0900_rwl_late_raw_3 rbl_op1_0900_rwl_late_raw sn_op1_0900_rwl_late_raw_3 rwl_des 0 sky130_fd_pr__nfet_01v8 L=0.15 W=0.42 nf=1 ad=0.1218 as=0.1218 pd=1.42 ps=1.42 nrd=0.69047619047619  nrs=0.69047619047619 sa=0 sb=0 sd=0 mult=1 m=1
csn_op1_0900_rwl_late_raw_3 sn_op1_0900_rwl_late_raw_3 0 {C_SN}
XMN1_op1_0900_rwl_late_raw rbl_op1_0900_rwl_late_raw ref_op1_0900_rwl_late_raw vn_op1_0900_rwl_late_raw 0 sky130_fd_pr__nfet_01v8 L=0.15 W=1 nf=1 ad=0.29 as=0.29 pd=2.58 ps=2.58 mult=1 m=1
XMN2_op1_0900_rwl_late_raw ref_op1_0900_rwl_late_raw rbl_op1_0900_rwl_late_raw vn_op1_0900_rwl_late_raw 0 sky130_fd_pr__nfet_01v8 L=0.15 W=1 nf=1 ad=0.29 as=0.29 pd=2.58 ps=2.58 mult=1 m=1
XMP1_op1_0900_rwl_late_raw rbl_op1_0900_rwl_late_raw ref_op1_0900_rwl_late_raw vp_op1_0900_rwl_late_raw vdd sky130_fd_pr__pfet_01v8 L=0.15 W=2 nf=1 ad=0.58 as=0.58 pd=4.58 ps=4.58 mult=1 m=1
XMP2_op1_0900_rwl_late_raw ref_op1_0900_rwl_late_raw rbl_op1_0900_rwl_late_raw vp_op1_0900_rwl_late_raw vdd sky130_fd_pr__pfet_01v8 L=0.15 W=2 nf=1 ad=0.58 as=0.58 pd=4.58 ps=4.58 mult=1 m=1
XMNF_op1_0900_rwl_late_raw vn_op1_0900_rwl_late_raw en_op1_0900_rwl_late_raw 0 0 sky130_fd_pr__nfet_01v8 L=0.15 W=2 nf=1 ad=0.58 as=0.58 pd=4.58 ps=4.58 mult=1 m=1
XMPH_op1_0900_rwl_late_raw vp_op1_0900_rwl_late_raw enb_op1_0900_rwl_late_raw vdd vdd sky130_fd_pr__pfet_01v8 L=0.15 W=4 nf=1 ad=1.16 as=1.16 pd=8.58 ps=8.58 mult=1 m=1
bd_op1_0900_rwl_late_raw d_op1_0900_rwl_late_raw 0 v=v(rbl_op1_0900_rwl_late_raw)-v(ref_op1_0900_rwl_late_raw)

* ---- instance 21: op1_1000_rwl_late_raw (variant rwl_late_raw; probe dec 11.9 ns, release 34 ns, meas 36 ns) ----
vctl_op1_1000_rwl_late_raw ctl_op1_1000_rwl_late_raw 0 pwl(0.0000e+00 {VDD} 2.0000e-09 {VDD} 2.1000e-09 0)
vrs_op1_1000_rwl_late_raw rwls_op1_1000_rwl_late_raw 0 pwl(0.0000e+00 {VDD} 2.0000e-09 {VDD} 2.1000e-09 0 3.4000e-08 0 3.4100e-08 {VDD})
ven_op1_1000_rwl_late_raw en_op1_1000_rwl_late_raw 0 pwl(0.0000e+00 0 1.1000e-08 0 1.1100e-08 {VDD} 1.2000e-08 {VDD} 1.2100e-08 0)
venb_op1_1000_rwl_late_raw enb_op1_1000_rwl_late_raw 0 pwl(0.0000e+00 {VDD} 1.1000e-08 {VDD} 1.1100e-08 0 1.2000e-08 0 1.2100e-08 {VDD})
vww_op1_1000_rwl_late_raw wwl_op1_1000_rwl_late_raw 0 pwl(0.0000e+00 0 1.2000e-08 0 1.2100e-08 {VDD} 3.2000e-08 {VDD} 3.2100e-08 0)
vwc_op1_1000_rwl_late_raw wbc_op1_1000_rwl_late_raw 0 pwl(0.0000e+00 0 1.2000e-08 0 1.2100e-08 {VDD} 3.4000e-08 {VDD} 3.4100e-08 0)
swb_op1_1000_rwl_late_raw ref_op1_1000_rwl_late_raw wbl_op1_1000_rwl_late_raw wbc_op1_1000_rwl_late_raw 0 swwbl
cwbl_op1_1000_rwl_late_raw wbl_op1_1000_rwl_late_raw 0 {C_WBL}
spa_op1_1000_rwl_late_raw prea rbl_op1_1000_rwl_late_raw ctl_op1_1000_rwl_late_raw 0 swpre
spr_op1_1000_rwl_late_raw pref ref_op1_1000_rwl_late_raw ctl_op1_1000_rwl_late_raw 0 swpre
crbl_op1_1000_rwl_late_raw rbl_op1_1000_rwl_late_raw 0 {C_RBL}
cref_op1_1000_rwl_late_raw ref_op1_1000_rwl_late_raw 0 {C_RBL}   $ ASSUMPTION: ideal matched dummy load
XMWR_op1_1000_rwl_late_raw_0 sn_op1_1000_rwl_late_raw_0 wwl_op1_1000_rwl_late_raw wbl_op1_1000_rwl_late_raw 0 sky130_fd_pr__nfet_01v8 L=0.15 W=0.42 nf=1 ad=0.1218 as=0.1218 pd=1.42 ps=1.42 nrd=0.69047619047619  nrs=0.69047619047619 sa=0 sb=0 sd=0 mult=1 m=1
XMRD_op1_1000_rwl_late_raw_0 rbl_op1_1000_rwl_late_raw sn_op1_1000_rwl_late_raw_0 rwls_op1_1000_rwl_late_raw 0 sky130_fd_pr__nfet_01v8 L=0.15 W=0.42 nf=1 ad=0.1218 as=0.1218 pd=1.42 ps=1.42 nrd=0.69047619047619  nrs=0.69047619047619 sa=0 sb=0 sd=0 mult=1 m=1
csn_op1_1000_rwl_late_raw_0 sn_op1_1000_rwl_late_raw_0 0 {C_SN}
XMWR_op1_1000_rwl_late_raw_1 sn_op1_1000_rwl_late_raw_1 wwl_des wbl_op1_1000_rwl_late_raw 0 sky130_fd_pr__nfet_01v8 L=0.15 W=0.42 nf=1 ad=0.1218 as=0.1218 pd=1.42 ps=1.42 nrd=0.69047619047619  nrs=0.69047619047619 sa=0 sb=0 sd=0 mult=1 m=1
XMRD_op1_1000_rwl_late_raw_1 rbl_op1_1000_rwl_late_raw sn_op1_1000_rwl_late_raw_1 rwl_des 0 sky130_fd_pr__nfet_01v8 L=0.15 W=0.42 nf=1 ad=0.1218 as=0.1218 pd=1.42 ps=1.42 nrd=0.69047619047619  nrs=0.69047619047619 sa=0 sb=0 sd=0 mult=1 m=1
csn_op1_1000_rwl_late_raw_1 sn_op1_1000_rwl_late_raw_1 0 {C_SN}
XMWR_op1_1000_rwl_late_raw_2 sn_op1_1000_rwl_late_raw_2 wwl_des wbl_op1_1000_rwl_late_raw 0 sky130_fd_pr__nfet_01v8 L=0.15 W=0.42 nf=1 ad=0.1218 as=0.1218 pd=1.42 ps=1.42 nrd=0.69047619047619  nrs=0.69047619047619 sa=0 sb=0 sd=0 mult=1 m=1
XMRD_op1_1000_rwl_late_raw_2 rbl_op1_1000_rwl_late_raw sn_op1_1000_rwl_late_raw_2 rwl_des 0 sky130_fd_pr__nfet_01v8 L=0.15 W=0.42 nf=1 ad=0.1218 as=0.1218 pd=1.42 ps=1.42 nrd=0.69047619047619  nrs=0.69047619047619 sa=0 sb=0 sd=0 mult=1 m=1
csn_op1_1000_rwl_late_raw_2 sn_op1_1000_rwl_late_raw_2 0 {C_SN}
XMWR_op1_1000_rwl_late_raw_3 sn_op1_1000_rwl_late_raw_3 wwl_des wbl_op1_1000_rwl_late_raw 0 sky130_fd_pr__nfet_01v8 L=0.15 W=0.42 nf=1 ad=0.1218 as=0.1218 pd=1.42 ps=1.42 nrd=0.69047619047619  nrs=0.69047619047619 sa=0 sb=0 sd=0 mult=1 m=1
XMRD_op1_1000_rwl_late_raw_3 rbl_op1_1000_rwl_late_raw sn_op1_1000_rwl_late_raw_3 rwl_des 0 sky130_fd_pr__nfet_01v8 L=0.15 W=0.42 nf=1 ad=0.1218 as=0.1218 pd=1.42 ps=1.42 nrd=0.69047619047619  nrs=0.69047619047619 sa=0 sb=0 sd=0 mult=1 m=1
csn_op1_1000_rwl_late_raw_3 sn_op1_1000_rwl_late_raw_3 0 {C_SN}
XMN1_op1_1000_rwl_late_raw rbl_op1_1000_rwl_late_raw ref_op1_1000_rwl_late_raw vn_op1_1000_rwl_late_raw 0 sky130_fd_pr__nfet_01v8 L=0.15 W=1 nf=1 ad=0.29 as=0.29 pd=2.58 ps=2.58 mult=1 m=1
XMN2_op1_1000_rwl_late_raw ref_op1_1000_rwl_late_raw rbl_op1_1000_rwl_late_raw vn_op1_1000_rwl_late_raw 0 sky130_fd_pr__nfet_01v8 L=0.15 W=1 nf=1 ad=0.29 as=0.29 pd=2.58 ps=2.58 mult=1 m=1
XMP1_op1_1000_rwl_late_raw rbl_op1_1000_rwl_late_raw ref_op1_1000_rwl_late_raw vp_op1_1000_rwl_late_raw vdd sky130_fd_pr__pfet_01v8 L=0.15 W=2 nf=1 ad=0.58 as=0.58 pd=4.58 ps=4.58 mult=1 m=1
XMP2_op1_1000_rwl_late_raw ref_op1_1000_rwl_late_raw rbl_op1_1000_rwl_late_raw vp_op1_1000_rwl_late_raw vdd sky130_fd_pr__pfet_01v8 L=0.15 W=2 nf=1 ad=0.58 as=0.58 pd=4.58 ps=4.58 mult=1 m=1
XMNF_op1_1000_rwl_late_raw vn_op1_1000_rwl_late_raw en_op1_1000_rwl_late_raw 0 0 sky130_fd_pr__nfet_01v8 L=0.15 W=2 nf=1 ad=0.58 as=0.58 pd=4.58 ps=4.58 mult=1 m=1
XMPH_op1_1000_rwl_late_raw vp_op1_1000_rwl_late_raw enb_op1_1000_rwl_late_raw vdd vdd sky130_fd_pr__pfet_01v8 L=0.15 W=4 nf=1 ad=1.16 as=1.16 pd=8.58 ps=8.58 mult=1 m=1
bd_op1_1000_rwl_late_raw d_op1_1000_rwl_late_raw 0 v=v(rbl_op1_1000_rwl_late_raw)-v(ref_op1_1000_rwl_late_raw)

* ---- instance 22: op0_n100_rwl_late_raw (variant rwl_late_raw; probe dec 11.9 ns, release 34 ns, meas 36 ns) ----
vctl_op0_n100_rwl_late_raw ctl_op0_n100_rwl_late_raw 0 pwl(0.0000e+00 {VDD} 2.0000e-09 {VDD} 2.1000e-09 0)
vrs_op0_n100_rwl_late_raw rwls_op0_n100_rwl_late_raw 0 pwl(0.0000e+00 {VDD} 2.0000e-09 {VDD} 2.1000e-09 0 3.4000e-08 0 3.4100e-08 {VDD})
ven_op0_n100_rwl_late_raw en_op0_n100_rwl_late_raw 0 pwl(0.0000e+00 0 1.1000e-08 0 1.1100e-08 {VDD} 1.2000e-08 {VDD} 1.2100e-08 0)
venb_op0_n100_rwl_late_raw enb_op0_n100_rwl_late_raw 0 pwl(0.0000e+00 {VDD} 1.1000e-08 {VDD} 1.1100e-08 0 1.2000e-08 0 1.2100e-08 {VDD})
vww_op0_n100_rwl_late_raw wwl_op0_n100_rwl_late_raw 0 pwl(0.0000e+00 0 1.2000e-08 0 1.2100e-08 {VDD} 3.2000e-08 {VDD} 3.2100e-08 0)
vwc_op0_n100_rwl_late_raw wbc_op0_n100_rwl_late_raw 0 pwl(0.0000e+00 0 1.2000e-08 0 1.2100e-08 {VDD} 3.4000e-08 {VDD} 3.4100e-08 0)
swb_op0_n100_rwl_late_raw ref_op0_n100_rwl_late_raw wbl_op0_n100_rwl_late_raw wbc_op0_n100_rwl_late_raw 0 swwbl
cwbl_op0_n100_rwl_late_raw wbl_op0_n100_rwl_late_raw 0 {C_WBL}
spa_op0_n100_rwl_late_raw prea rbl_op0_n100_rwl_late_raw ctl_op0_n100_rwl_late_raw 0 swpre
spr_op0_n100_rwl_late_raw pref ref_op0_n100_rwl_late_raw ctl_op0_n100_rwl_late_raw 0 swpre
crbl_op0_n100_rwl_late_raw rbl_op0_n100_rwl_late_raw 0 {C_RBL}
cref_op0_n100_rwl_late_raw ref_op0_n100_rwl_late_raw 0 {C_RBL}   $ ASSUMPTION: ideal matched dummy load
XMWR_op0_n100_rwl_late_raw_0 sn_op0_n100_rwl_late_raw_0 wwl_op0_n100_rwl_late_raw wbl_op0_n100_rwl_late_raw 0 sky130_fd_pr__nfet_01v8 L=0.15 W=0.42 nf=1 ad=0.1218 as=0.1218 pd=1.42 ps=1.42 nrd=0.69047619047619  nrs=0.69047619047619 sa=0 sb=0 sd=0 mult=1 m=1
XMRD_op0_n100_rwl_late_raw_0 rbl_op0_n100_rwl_late_raw sn_op0_n100_rwl_late_raw_0 rwls_op0_n100_rwl_late_raw 0 sky130_fd_pr__nfet_01v8 L=0.15 W=0.42 nf=1 ad=0.1218 as=0.1218 pd=1.42 ps=1.42 nrd=0.69047619047619  nrs=0.69047619047619 sa=0 sb=0 sd=0 mult=1 m=1
csn_op0_n100_rwl_late_raw_0 sn_op0_n100_rwl_late_raw_0 0 {C_SN}
XMWR_op0_n100_rwl_late_raw_1 sn_op0_n100_rwl_late_raw_1 wwl_des wbl_op0_n100_rwl_late_raw 0 sky130_fd_pr__nfet_01v8 L=0.15 W=0.42 nf=1 ad=0.1218 as=0.1218 pd=1.42 ps=1.42 nrd=0.69047619047619  nrs=0.69047619047619 sa=0 sb=0 sd=0 mult=1 m=1
XMRD_op0_n100_rwl_late_raw_1 rbl_op0_n100_rwl_late_raw sn_op0_n100_rwl_late_raw_1 rwl_des 0 sky130_fd_pr__nfet_01v8 L=0.15 W=0.42 nf=1 ad=0.1218 as=0.1218 pd=1.42 ps=1.42 nrd=0.69047619047619  nrs=0.69047619047619 sa=0 sb=0 sd=0 mult=1 m=1
csn_op0_n100_rwl_late_raw_1 sn_op0_n100_rwl_late_raw_1 0 {C_SN}
XMWR_op0_n100_rwl_late_raw_2 sn_op0_n100_rwl_late_raw_2 wwl_des wbl_op0_n100_rwl_late_raw 0 sky130_fd_pr__nfet_01v8 L=0.15 W=0.42 nf=1 ad=0.1218 as=0.1218 pd=1.42 ps=1.42 nrd=0.69047619047619  nrs=0.69047619047619 sa=0 sb=0 sd=0 mult=1 m=1
XMRD_op0_n100_rwl_late_raw_2 rbl_op0_n100_rwl_late_raw sn_op0_n100_rwl_late_raw_2 rwl_des 0 sky130_fd_pr__nfet_01v8 L=0.15 W=0.42 nf=1 ad=0.1218 as=0.1218 pd=1.42 ps=1.42 nrd=0.69047619047619  nrs=0.69047619047619 sa=0 sb=0 sd=0 mult=1 m=1
csn_op0_n100_rwl_late_raw_2 sn_op0_n100_rwl_late_raw_2 0 {C_SN}
XMWR_op0_n100_rwl_late_raw_3 sn_op0_n100_rwl_late_raw_3 wwl_des wbl_op0_n100_rwl_late_raw 0 sky130_fd_pr__nfet_01v8 L=0.15 W=0.42 nf=1 ad=0.1218 as=0.1218 pd=1.42 ps=1.42 nrd=0.69047619047619  nrs=0.69047619047619 sa=0 sb=0 sd=0 mult=1 m=1
XMRD_op0_n100_rwl_late_raw_3 rbl_op0_n100_rwl_late_raw sn_op0_n100_rwl_late_raw_3 rwl_des 0 sky130_fd_pr__nfet_01v8 L=0.15 W=0.42 nf=1 ad=0.1218 as=0.1218 pd=1.42 ps=1.42 nrd=0.69047619047619  nrs=0.69047619047619 sa=0 sb=0 sd=0 mult=1 m=1
csn_op0_n100_rwl_late_raw_3 sn_op0_n100_rwl_late_raw_3 0 {C_SN}
XMN1_op0_n100_rwl_late_raw rbl_op0_n100_rwl_late_raw ref_op0_n100_rwl_late_raw vn_op0_n100_rwl_late_raw 0 sky130_fd_pr__nfet_01v8 L=0.15 W=1 nf=1 ad=0.29 as=0.29 pd=2.58 ps=2.58 mult=1 m=1
XMN2_op0_n100_rwl_late_raw ref_op0_n100_rwl_late_raw rbl_op0_n100_rwl_late_raw vn_op0_n100_rwl_late_raw 0 sky130_fd_pr__nfet_01v8 L=0.15 W=1 nf=1 ad=0.29 as=0.29 pd=2.58 ps=2.58 mult=1 m=1
XMP1_op0_n100_rwl_late_raw rbl_op0_n100_rwl_late_raw ref_op0_n100_rwl_late_raw vp_op0_n100_rwl_late_raw vdd sky130_fd_pr__pfet_01v8 L=0.15 W=2 nf=1 ad=0.58 as=0.58 pd=4.58 ps=4.58 mult=1 m=1
XMP2_op0_n100_rwl_late_raw ref_op0_n100_rwl_late_raw rbl_op0_n100_rwl_late_raw vp_op0_n100_rwl_late_raw vdd sky130_fd_pr__pfet_01v8 L=0.15 W=2 nf=1 ad=0.58 as=0.58 pd=4.58 ps=4.58 mult=1 m=1
XMNF_op0_n100_rwl_late_raw vn_op0_n100_rwl_late_raw en_op0_n100_rwl_late_raw 0 0 sky130_fd_pr__nfet_01v8 L=0.15 W=2 nf=1 ad=0.58 as=0.58 pd=4.58 ps=4.58 mult=1 m=1
XMPH_op0_n100_rwl_late_raw vp_op0_n100_rwl_late_raw enb_op0_n100_rwl_late_raw vdd vdd sky130_fd_pr__pfet_01v8 L=0.15 W=4 nf=1 ad=1.16 as=1.16 pd=8.58 ps=8.58 mult=1 m=1
bd_op0_n100_rwl_late_raw d_op0_n100_rwl_late_raw 0 v=v(rbl_op0_n100_rwl_late_raw)-v(ref_op0_n100_rwl_late_raw)

* ---- instance 23: op0_0000_rwl_late_raw (variant rwl_late_raw; probe dec 11.9 ns, release 34 ns, meas 36 ns) ----
vctl_op0_0000_rwl_late_raw ctl_op0_0000_rwl_late_raw 0 pwl(0.0000e+00 {VDD} 2.0000e-09 {VDD} 2.1000e-09 0)
vrs_op0_0000_rwl_late_raw rwls_op0_0000_rwl_late_raw 0 pwl(0.0000e+00 {VDD} 2.0000e-09 {VDD} 2.1000e-09 0 3.4000e-08 0 3.4100e-08 {VDD})
ven_op0_0000_rwl_late_raw en_op0_0000_rwl_late_raw 0 pwl(0.0000e+00 0 1.1000e-08 0 1.1100e-08 {VDD} 1.2000e-08 {VDD} 1.2100e-08 0)
venb_op0_0000_rwl_late_raw enb_op0_0000_rwl_late_raw 0 pwl(0.0000e+00 {VDD} 1.1000e-08 {VDD} 1.1100e-08 0 1.2000e-08 0 1.2100e-08 {VDD})
vww_op0_0000_rwl_late_raw wwl_op0_0000_rwl_late_raw 0 pwl(0.0000e+00 0 1.2000e-08 0 1.2100e-08 {VDD} 3.2000e-08 {VDD} 3.2100e-08 0)
vwc_op0_0000_rwl_late_raw wbc_op0_0000_rwl_late_raw 0 pwl(0.0000e+00 0 1.2000e-08 0 1.2100e-08 {VDD} 3.4000e-08 {VDD} 3.4100e-08 0)
swb_op0_0000_rwl_late_raw ref_op0_0000_rwl_late_raw wbl_op0_0000_rwl_late_raw wbc_op0_0000_rwl_late_raw 0 swwbl
cwbl_op0_0000_rwl_late_raw wbl_op0_0000_rwl_late_raw 0 {C_WBL}
spa_op0_0000_rwl_late_raw prea rbl_op0_0000_rwl_late_raw ctl_op0_0000_rwl_late_raw 0 swpre
spr_op0_0000_rwl_late_raw pref ref_op0_0000_rwl_late_raw ctl_op0_0000_rwl_late_raw 0 swpre
crbl_op0_0000_rwl_late_raw rbl_op0_0000_rwl_late_raw 0 {C_RBL}
cref_op0_0000_rwl_late_raw ref_op0_0000_rwl_late_raw 0 {C_RBL}   $ ASSUMPTION: ideal matched dummy load
XMWR_op0_0000_rwl_late_raw_0 sn_op0_0000_rwl_late_raw_0 wwl_op0_0000_rwl_late_raw wbl_op0_0000_rwl_late_raw 0 sky130_fd_pr__nfet_01v8 L=0.15 W=0.42 nf=1 ad=0.1218 as=0.1218 pd=1.42 ps=1.42 nrd=0.69047619047619  nrs=0.69047619047619 sa=0 sb=0 sd=0 mult=1 m=1
XMRD_op0_0000_rwl_late_raw_0 rbl_op0_0000_rwl_late_raw sn_op0_0000_rwl_late_raw_0 rwls_op0_0000_rwl_late_raw 0 sky130_fd_pr__nfet_01v8 L=0.15 W=0.42 nf=1 ad=0.1218 as=0.1218 pd=1.42 ps=1.42 nrd=0.69047619047619  nrs=0.69047619047619 sa=0 sb=0 sd=0 mult=1 m=1
csn_op0_0000_rwl_late_raw_0 sn_op0_0000_rwl_late_raw_0 0 {C_SN}
XMWR_op0_0000_rwl_late_raw_1 sn_op0_0000_rwl_late_raw_1 wwl_des wbl_op0_0000_rwl_late_raw 0 sky130_fd_pr__nfet_01v8 L=0.15 W=0.42 nf=1 ad=0.1218 as=0.1218 pd=1.42 ps=1.42 nrd=0.69047619047619  nrs=0.69047619047619 sa=0 sb=0 sd=0 mult=1 m=1
XMRD_op0_0000_rwl_late_raw_1 rbl_op0_0000_rwl_late_raw sn_op0_0000_rwl_late_raw_1 rwl_des 0 sky130_fd_pr__nfet_01v8 L=0.15 W=0.42 nf=1 ad=0.1218 as=0.1218 pd=1.42 ps=1.42 nrd=0.69047619047619  nrs=0.69047619047619 sa=0 sb=0 sd=0 mult=1 m=1
csn_op0_0000_rwl_late_raw_1 sn_op0_0000_rwl_late_raw_1 0 {C_SN}
XMWR_op0_0000_rwl_late_raw_2 sn_op0_0000_rwl_late_raw_2 wwl_des wbl_op0_0000_rwl_late_raw 0 sky130_fd_pr__nfet_01v8 L=0.15 W=0.42 nf=1 ad=0.1218 as=0.1218 pd=1.42 ps=1.42 nrd=0.69047619047619  nrs=0.69047619047619 sa=0 sb=0 sd=0 mult=1 m=1
XMRD_op0_0000_rwl_late_raw_2 rbl_op0_0000_rwl_late_raw sn_op0_0000_rwl_late_raw_2 rwl_des 0 sky130_fd_pr__nfet_01v8 L=0.15 W=0.42 nf=1 ad=0.1218 as=0.1218 pd=1.42 ps=1.42 nrd=0.69047619047619  nrs=0.69047619047619 sa=0 sb=0 sd=0 mult=1 m=1
csn_op0_0000_rwl_late_raw_2 sn_op0_0000_rwl_late_raw_2 0 {C_SN}
XMWR_op0_0000_rwl_late_raw_3 sn_op0_0000_rwl_late_raw_3 wwl_des wbl_op0_0000_rwl_late_raw 0 sky130_fd_pr__nfet_01v8 L=0.15 W=0.42 nf=1 ad=0.1218 as=0.1218 pd=1.42 ps=1.42 nrd=0.69047619047619  nrs=0.69047619047619 sa=0 sb=0 sd=0 mult=1 m=1
XMRD_op0_0000_rwl_late_raw_3 rbl_op0_0000_rwl_late_raw sn_op0_0000_rwl_late_raw_3 rwl_des 0 sky130_fd_pr__nfet_01v8 L=0.15 W=0.42 nf=1 ad=0.1218 as=0.1218 pd=1.42 ps=1.42 nrd=0.69047619047619  nrs=0.69047619047619 sa=0 sb=0 sd=0 mult=1 m=1
csn_op0_0000_rwl_late_raw_3 sn_op0_0000_rwl_late_raw_3 0 {C_SN}
XMN1_op0_0000_rwl_late_raw rbl_op0_0000_rwl_late_raw ref_op0_0000_rwl_late_raw vn_op0_0000_rwl_late_raw 0 sky130_fd_pr__nfet_01v8 L=0.15 W=1 nf=1 ad=0.29 as=0.29 pd=2.58 ps=2.58 mult=1 m=1
XMN2_op0_0000_rwl_late_raw ref_op0_0000_rwl_late_raw rbl_op0_0000_rwl_late_raw vn_op0_0000_rwl_late_raw 0 sky130_fd_pr__nfet_01v8 L=0.15 W=1 nf=1 ad=0.29 as=0.29 pd=2.58 ps=2.58 mult=1 m=1
XMP1_op0_0000_rwl_late_raw rbl_op0_0000_rwl_late_raw ref_op0_0000_rwl_late_raw vp_op0_0000_rwl_late_raw vdd sky130_fd_pr__pfet_01v8 L=0.15 W=2 nf=1 ad=0.58 as=0.58 pd=4.58 ps=4.58 mult=1 m=1
XMP2_op0_0000_rwl_late_raw ref_op0_0000_rwl_late_raw rbl_op0_0000_rwl_late_raw vp_op0_0000_rwl_late_raw vdd sky130_fd_pr__pfet_01v8 L=0.15 W=2 nf=1 ad=0.58 as=0.58 pd=4.58 ps=4.58 mult=1 m=1
XMNF_op0_0000_rwl_late_raw vn_op0_0000_rwl_late_raw en_op0_0000_rwl_late_raw 0 0 sky130_fd_pr__nfet_01v8 L=0.15 W=2 nf=1 ad=0.58 as=0.58 pd=4.58 ps=4.58 mult=1 m=1
XMPH_op0_0000_rwl_late_raw vp_op0_0000_rwl_late_raw enb_op0_0000_rwl_late_raw vdd vdd sky130_fd_pr__pfet_01v8 L=0.15 W=4 nf=1 ad=1.16 as=1.16 pd=8.58 ps=8.58 mult=1 m=1
bd_op0_0000_rwl_late_raw d_op0_0000_rwl_late_raw 0 v=v(rbl_op0_0000_rwl_late_raw)-v(ref_op0_0000_rwl_late_raw)

* ---- instance 24: op1_0900_rwl_late_hold (variant rwl_late_hold; probe dec 11.9 ns, release 34 ns, meas 36 ns) ----
vctl_op1_0900_rwl_late_hold ctl_op1_0900_rwl_late_hold 0 pwl(0.0000e+00 {VDD} 2.0000e-09 {VDD} 2.1000e-09 0)
vrs_op1_0900_rwl_late_hold rwls_op1_0900_rwl_late_hold 0 pwl(0.0000e+00 {VDD} 2.0000e-09 {VDD} 2.1000e-09 0 3.4000e-08 0 3.4100e-08 {VDD})
ven_op1_0900_rwl_late_hold en_op1_0900_rwl_late_hold 0 pwl(0.0000e+00 0 1.1000e-08 0 1.1100e-08 {VDD} 3.4000e-08 {VDD} 3.4100e-08 0)
venb_op1_0900_rwl_late_hold enb_op1_0900_rwl_late_hold 0 pwl(0.0000e+00 {VDD} 1.1000e-08 {VDD} 1.1100e-08 0 3.4000e-08 0 3.4100e-08 {VDD})
vww_op1_0900_rwl_late_hold wwl_op1_0900_rwl_late_hold 0 pwl(0.0000e+00 0 1.2000e-08 0 1.2100e-08 {VDD} 3.2000e-08 {VDD} 3.2100e-08 0)
vwc_op1_0900_rwl_late_hold wbc_op1_0900_rwl_late_hold 0 pwl(0.0000e+00 0 1.2000e-08 0 1.2100e-08 {VDD} 3.4000e-08 {VDD} 3.4100e-08 0)
swb_op1_0900_rwl_late_hold ref_op1_0900_rwl_late_hold wbl_op1_0900_rwl_late_hold wbc_op1_0900_rwl_late_hold 0 swwbl
cwbl_op1_0900_rwl_late_hold wbl_op1_0900_rwl_late_hold 0 {C_WBL}
spa_op1_0900_rwl_late_hold prea rbl_op1_0900_rwl_late_hold ctl_op1_0900_rwl_late_hold 0 swpre
spr_op1_0900_rwl_late_hold pref ref_op1_0900_rwl_late_hold ctl_op1_0900_rwl_late_hold 0 swpre
crbl_op1_0900_rwl_late_hold rbl_op1_0900_rwl_late_hold 0 {C_RBL}
cref_op1_0900_rwl_late_hold ref_op1_0900_rwl_late_hold 0 {C_RBL}   $ ASSUMPTION: ideal matched dummy load
XMWR_op1_0900_rwl_late_hold_0 sn_op1_0900_rwl_late_hold_0 wwl_op1_0900_rwl_late_hold wbl_op1_0900_rwl_late_hold 0 sky130_fd_pr__nfet_01v8 L=0.15 W=0.42 nf=1 ad=0.1218 as=0.1218 pd=1.42 ps=1.42 nrd=0.69047619047619  nrs=0.69047619047619 sa=0 sb=0 sd=0 mult=1 m=1
XMRD_op1_0900_rwl_late_hold_0 rbl_op1_0900_rwl_late_hold sn_op1_0900_rwl_late_hold_0 rwls_op1_0900_rwl_late_hold 0 sky130_fd_pr__nfet_01v8 L=0.15 W=0.42 nf=1 ad=0.1218 as=0.1218 pd=1.42 ps=1.42 nrd=0.69047619047619  nrs=0.69047619047619 sa=0 sb=0 sd=0 mult=1 m=1
csn_op1_0900_rwl_late_hold_0 sn_op1_0900_rwl_late_hold_0 0 {C_SN}
XMWR_op1_0900_rwl_late_hold_1 sn_op1_0900_rwl_late_hold_1 wwl_des wbl_op1_0900_rwl_late_hold 0 sky130_fd_pr__nfet_01v8 L=0.15 W=0.42 nf=1 ad=0.1218 as=0.1218 pd=1.42 ps=1.42 nrd=0.69047619047619  nrs=0.69047619047619 sa=0 sb=0 sd=0 mult=1 m=1
XMRD_op1_0900_rwl_late_hold_1 rbl_op1_0900_rwl_late_hold sn_op1_0900_rwl_late_hold_1 rwl_des 0 sky130_fd_pr__nfet_01v8 L=0.15 W=0.42 nf=1 ad=0.1218 as=0.1218 pd=1.42 ps=1.42 nrd=0.69047619047619  nrs=0.69047619047619 sa=0 sb=0 sd=0 mult=1 m=1
csn_op1_0900_rwl_late_hold_1 sn_op1_0900_rwl_late_hold_1 0 {C_SN}
XMWR_op1_0900_rwl_late_hold_2 sn_op1_0900_rwl_late_hold_2 wwl_des wbl_op1_0900_rwl_late_hold 0 sky130_fd_pr__nfet_01v8 L=0.15 W=0.42 nf=1 ad=0.1218 as=0.1218 pd=1.42 ps=1.42 nrd=0.69047619047619  nrs=0.69047619047619 sa=0 sb=0 sd=0 mult=1 m=1
XMRD_op1_0900_rwl_late_hold_2 rbl_op1_0900_rwl_late_hold sn_op1_0900_rwl_late_hold_2 rwl_des 0 sky130_fd_pr__nfet_01v8 L=0.15 W=0.42 nf=1 ad=0.1218 as=0.1218 pd=1.42 ps=1.42 nrd=0.69047619047619  nrs=0.69047619047619 sa=0 sb=0 sd=0 mult=1 m=1
csn_op1_0900_rwl_late_hold_2 sn_op1_0900_rwl_late_hold_2 0 {C_SN}
XMWR_op1_0900_rwl_late_hold_3 sn_op1_0900_rwl_late_hold_3 wwl_des wbl_op1_0900_rwl_late_hold 0 sky130_fd_pr__nfet_01v8 L=0.15 W=0.42 nf=1 ad=0.1218 as=0.1218 pd=1.42 ps=1.42 nrd=0.69047619047619  nrs=0.69047619047619 sa=0 sb=0 sd=0 mult=1 m=1
XMRD_op1_0900_rwl_late_hold_3 rbl_op1_0900_rwl_late_hold sn_op1_0900_rwl_late_hold_3 rwl_des 0 sky130_fd_pr__nfet_01v8 L=0.15 W=0.42 nf=1 ad=0.1218 as=0.1218 pd=1.42 ps=1.42 nrd=0.69047619047619  nrs=0.69047619047619 sa=0 sb=0 sd=0 mult=1 m=1
csn_op1_0900_rwl_late_hold_3 sn_op1_0900_rwl_late_hold_3 0 {C_SN}
XMN1_op1_0900_rwl_late_hold rbl_op1_0900_rwl_late_hold ref_op1_0900_rwl_late_hold vn_op1_0900_rwl_late_hold 0 sky130_fd_pr__nfet_01v8 L=0.15 W=1 nf=1 ad=0.29 as=0.29 pd=2.58 ps=2.58 mult=1 m=1
XMN2_op1_0900_rwl_late_hold ref_op1_0900_rwl_late_hold rbl_op1_0900_rwl_late_hold vn_op1_0900_rwl_late_hold 0 sky130_fd_pr__nfet_01v8 L=0.15 W=1 nf=1 ad=0.29 as=0.29 pd=2.58 ps=2.58 mult=1 m=1
XMP1_op1_0900_rwl_late_hold rbl_op1_0900_rwl_late_hold ref_op1_0900_rwl_late_hold vp_op1_0900_rwl_late_hold vdd sky130_fd_pr__pfet_01v8 L=0.15 W=2 nf=1 ad=0.58 as=0.58 pd=4.58 ps=4.58 mult=1 m=1
XMP2_op1_0900_rwl_late_hold ref_op1_0900_rwl_late_hold rbl_op1_0900_rwl_late_hold vp_op1_0900_rwl_late_hold vdd sky130_fd_pr__pfet_01v8 L=0.15 W=2 nf=1 ad=0.58 as=0.58 pd=4.58 ps=4.58 mult=1 m=1
XMNF_op1_0900_rwl_late_hold vn_op1_0900_rwl_late_hold en_op1_0900_rwl_late_hold 0 0 sky130_fd_pr__nfet_01v8 L=0.15 W=2 nf=1 ad=0.58 as=0.58 pd=4.58 ps=4.58 mult=1 m=1
XMPH_op1_0900_rwl_late_hold vp_op1_0900_rwl_late_hold enb_op1_0900_rwl_late_hold vdd vdd sky130_fd_pr__pfet_01v8 L=0.15 W=4 nf=1 ad=1.16 as=1.16 pd=8.58 ps=8.58 mult=1 m=1
bd_op1_0900_rwl_late_hold d_op1_0900_rwl_late_hold 0 v=v(rbl_op1_0900_rwl_late_hold)-v(ref_op1_0900_rwl_late_hold)

* ---- instance 25: op1_1000_rwl_late_hold (variant rwl_late_hold; probe dec 11.9 ns, release 34 ns, meas 36 ns) ----
vctl_op1_1000_rwl_late_hold ctl_op1_1000_rwl_late_hold 0 pwl(0.0000e+00 {VDD} 2.0000e-09 {VDD} 2.1000e-09 0)
vrs_op1_1000_rwl_late_hold rwls_op1_1000_rwl_late_hold 0 pwl(0.0000e+00 {VDD} 2.0000e-09 {VDD} 2.1000e-09 0 3.4000e-08 0 3.4100e-08 {VDD})
ven_op1_1000_rwl_late_hold en_op1_1000_rwl_late_hold 0 pwl(0.0000e+00 0 1.1000e-08 0 1.1100e-08 {VDD} 3.4000e-08 {VDD} 3.4100e-08 0)
venb_op1_1000_rwl_late_hold enb_op1_1000_rwl_late_hold 0 pwl(0.0000e+00 {VDD} 1.1000e-08 {VDD} 1.1100e-08 0 3.4000e-08 0 3.4100e-08 {VDD})
vww_op1_1000_rwl_late_hold wwl_op1_1000_rwl_late_hold 0 pwl(0.0000e+00 0 1.2000e-08 0 1.2100e-08 {VDD} 3.2000e-08 {VDD} 3.2100e-08 0)
vwc_op1_1000_rwl_late_hold wbc_op1_1000_rwl_late_hold 0 pwl(0.0000e+00 0 1.2000e-08 0 1.2100e-08 {VDD} 3.4000e-08 {VDD} 3.4100e-08 0)
swb_op1_1000_rwl_late_hold ref_op1_1000_rwl_late_hold wbl_op1_1000_rwl_late_hold wbc_op1_1000_rwl_late_hold 0 swwbl
cwbl_op1_1000_rwl_late_hold wbl_op1_1000_rwl_late_hold 0 {C_WBL}
spa_op1_1000_rwl_late_hold prea rbl_op1_1000_rwl_late_hold ctl_op1_1000_rwl_late_hold 0 swpre
spr_op1_1000_rwl_late_hold pref ref_op1_1000_rwl_late_hold ctl_op1_1000_rwl_late_hold 0 swpre
crbl_op1_1000_rwl_late_hold rbl_op1_1000_rwl_late_hold 0 {C_RBL}
cref_op1_1000_rwl_late_hold ref_op1_1000_rwl_late_hold 0 {C_RBL}   $ ASSUMPTION: ideal matched dummy load
XMWR_op1_1000_rwl_late_hold_0 sn_op1_1000_rwl_late_hold_0 wwl_op1_1000_rwl_late_hold wbl_op1_1000_rwl_late_hold 0 sky130_fd_pr__nfet_01v8 L=0.15 W=0.42 nf=1 ad=0.1218 as=0.1218 pd=1.42 ps=1.42 nrd=0.69047619047619  nrs=0.69047619047619 sa=0 sb=0 sd=0 mult=1 m=1
XMRD_op1_1000_rwl_late_hold_0 rbl_op1_1000_rwl_late_hold sn_op1_1000_rwl_late_hold_0 rwls_op1_1000_rwl_late_hold 0 sky130_fd_pr__nfet_01v8 L=0.15 W=0.42 nf=1 ad=0.1218 as=0.1218 pd=1.42 ps=1.42 nrd=0.69047619047619  nrs=0.69047619047619 sa=0 sb=0 sd=0 mult=1 m=1
csn_op1_1000_rwl_late_hold_0 sn_op1_1000_rwl_late_hold_0 0 {C_SN}
XMWR_op1_1000_rwl_late_hold_1 sn_op1_1000_rwl_late_hold_1 wwl_des wbl_op1_1000_rwl_late_hold 0 sky130_fd_pr__nfet_01v8 L=0.15 W=0.42 nf=1 ad=0.1218 as=0.1218 pd=1.42 ps=1.42 nrd=0.69047619047619  nrs=0.69047619047619 sa=0 sb=0 sd=0 mult=1 m=1
XMRD_op1_1000_rwl_late_hold_1 rbl_op1_1000_rwl_late_hold sn_op1_1000_rwl_late_hold_1 rwl_des 0 sky130_fd_pr__nfet_01v8 L=0.15 W=0.42 nf=1 ad=0.1218 as=0.1218 pd=1.42 ps=1.42 nrd=0.69047619047619  nrs=0.69047619047619 sa=0 sb=0 sd=0 mult=1 m=1
csn_op1_1000_rwl_late_hold_1 sn_op1_1000_rwl_late_hold_1 0 {C_SN}
XMWR_op1_1000_rwl_late_hold_2 sn_op1_1000_rwl_late_hold_2 wwl_des wbl_op1_1000_rwl_late_hold 0 sky130_fd_pr__nfet_01v8 L=0.15 W=0.42 nf=1 ad=0.1218 as=0.1218 pd=1.42 ps=1.42 nrd=0.69047619047619  nrs=0.69047619047619 sa=0 sb=0 sd=0 mult=1 m=1
XMRD_op1_1000_rwl_late_hold_2 rbl_op1_1000_rwl_late_hold sn_op1_1000_rwl_late_hold_2 rwl_des 0 sky130_fd_pr__nfet_01v8 L=0.15 W=0.42 nf=1 ad=0.1218 as=0.1218 pd=1.42 ps=1.42 nrd=0.69047619047619  nrs=0.69047619047619 sa=0 sb=0 sd=0 mult=1 m=1
csn_op1_1000_rwl_late_hold_2 sn_op1_1000_rwl_late_hold_2 0 {C_SN}
XMWR_op1_1000_rwl_late_hold_3 sn_op1_1000_rwl_late_hold_3 wwl_des wbl_op1_1000_rwl_late_hold 0 sky130_fd_pr__nfet_01v8 L=0.15 W=0.42 nf=1 ad=0.1218 as=0.1218 pd=1.42 ps=1.42 nrd=0.69047619047619  nrs=0.69047619047619 sa=0 sb=0 sd=0 mult=1 m=1
XMRD_op1_1000_rwl_late_hold_3 rbl_op1_1000_rwl_late_hold sn_op1_1000_rwl_late_hold_3 rwl_des 0 sky130_fd_pr__nfet_01v8 L=0.15 W=0.42 nf=1 ad=0.1218 as=0.1218 pd=1.42 ps=1.42 nrd=0.69047619047619  nrs=0.69047619047619 sa=0 sb=0 sd=0 mult=1 m=1
csn_op1_1000_rwl_late_hold_3 sn_op1_1000_rwl_late_hold_3 0 {C_SN}
XMN1_op1_1000_rwl_late_hold rbl_op1_1000_rwl_late_hold ref_op1_1000_rwl_late_hold vn_op1_1000_rwl_late_hold 0 sky130_fd_pr__nfet_01v8 L=0.15 W=1 nf=1 ad=0.29 as=0.29 pd=2.58 ps=2.58 mult=1 m=1
XMN2_op1_1000_rwl_late_hold ref_op1_1000_rwl_late_hold rbl_op1_1000_rwl_late_hold vn_op1_1000_rwl_late_hold 0 sky130_fd_pr__nfet_01v8 L=0.15 W=1 nf=1 ad=0.29 as=0.29 pd=2.58 ps=2.58 mult=1 m=1
XMP1_op1_1000_rwl_late_hold rbl_op1_1000_rwl_late_hold ref_op1_1000_rwl_late_hold vp_op1_1000_rwl_late_hold vdd sky130_fd_pr__pfet_01v8 L=0.15 W=2 nf=1 ad=0.58 as=0.58 pd=4.58 ps=4.58 mult=1 m=1
XMP2_op1_1000_rwl_late_hold ref_op1_1000_rwl_late_hold rbl_op1_1000_rwl_late_hold vp_op1_1000_rwl_late_hold vdd sky130_fd_pr__pfet_01v8 L=0.15 W=2 nf=1 ad=0.58 as=0.58 pd=4.58 ps=4.58 mult=1 m=1
XMNF_op1_1000_rwl_late_hold vn_op1_1000_rwl_late_hold en_op1_1000_rwl_late_hold 0 0 sky130_fd_pr__nfet_01v8 L=0.15 W=2 nf=1 ad=0.58 as=0.58 pd=4.58 ps=4.58 mult=1 m=1
XMPH_op1_1000_rwl_late_hold vp_op1_1000_rwl_late_hold enb_op1_1000_rwl_late_hold vdd vdd sky130_fd_pr__pfet_01v8 L=0.15 W=4 nf=1 ad=1.16 as=1.16 pd=8.58 ps=8.58 mult=1 m=1
bd_op1_1000_rwl_late_hold d_op1_1000_rwl_late_hold 0 v=v(rbl_op1_1000_rwl_late_hold)-v(ref_op1_1000_rwl_late_hold)

* ---- instance 26: op0_n100_rwl_late_hold (variant rwl_late_hold; probe dec 11.9 ns, release 34 ns, meas 36 ns) ----
vctl_op0_n100_rwl_late_hold ctl_op0_n100_rwl_late_hold 0 pwl(0.0000e+00 {VDD} 2.0000e-09 {VDD} 2.1000e-09 0)
vrs_op0_n100_rwl_late_hold rwls_op0_n100_rwl_late_hold 0 pwl(0.0000e+00 {VDD} 2.0000e-09 {VDD} 2.1000e-09 0 3.4000e-08 0 3.4100e-08 {VDD})
ven_op0_n100_rwl_late_hold en_op0_n100_rwl_late_hold 0 pwl(0.0000e+00 0 1.1000e-08 0 1.1100e-08 {VDD} 3.4000e-08 {VDD} 3.4100e-08 0)
venb_op0_n100_rwl_late_hold enb_op0_n100_rwl_late_hold 0 pwl(0.0000e+00 {VDD} 1.1000e-08 {VDD} 1.1100e-08 0 3.4000e-08 0 3.4100e-08 {VDD})
vww_op0_n100_rwl_late_hold wwl_op0_n100_rwl_late_hold 0 pwl(0.0000e+00 0 1.2000e-08 0 1.2100e-08 {VDD} 3.2000e-08 {VDD} 3.2100e-08 0)
vwc_op0_n100_rwl_late_hold wbc_op0_n100_rwl_late_hold 0 pwl(0.0000e+00 0 1.2000e-08 0 1.2100e-08 {VDD} 3.4000e-08 {VDD} 3.4100e-08 0)
swb_op0_n100_rwl_late_hold ref_op0_n100_rwl_late_hold wbl_op0_n100_rwl_late_hold wbc_op0_n100_rwl_late_hold 0 swwbl
cwbl_op0_n100_rwl_late_hold wbl_op0_n100_rwl_late_hold 0 {C_WBL}
spa_op0_n100_rwl_late_hold prea rbl_op0_n100_rwl_late_hold ctl_op0_n100_rwl_late_hold 0 swpre
spr_op0_n100_rwl_late_hold pref ref_op0_n100_rwl_late_hold ctl_op0_n100_rwl_late_hold 0 swpre
crbl_op0_n100_rwl_late_hold rbl_op0_n100_rwl_late_hold 0 {C_RBL}
cref_op0_n100_rwl_late_hold ref_op0_n100_rwl_late_hold 0 {C_RBL}   $ ASSUMPTION: ideal matched dummy load
XMWR_op0_n100_rwl_late_hold_0 sn_op0_n100_rwl_late_hold_0 wwl_op0_n100_rwl_late_hold wbl_op0_n100_rwl_late_hold 0 sky130_fd_pr__nfet_01v8 L=0.15 W=0.42 nf=1 ad=0.1218 as=0.1218 pd=1.42 ps=1.42 nrd=0.69047619047619  nrs=0.69047619047619 sa=0 sb=0 sd=0 mult=1 m=1
XMRD_op0_n100_rwl_late_hold_0 rbl_op0_n100_rwl_late_hold sn_op0_n100_rwl_late_hold_0 rwls_op0_n100_rwl_late_hold 0 sky130_fd_pr__nfet_01v8 L=0.15 W=0.42 nf=1 ad=0.1218 as=0.1218 pd=1.42 ps=1.42 nrd=0.69047619047619  nrs=0.69047619047619 sa=0 sb=0 sd=0 mult=1 m=1
csn_op0_n100_rwl_late_hold_0 sn_op0_n100_rwl_late_hold_0 0 {C_SN}
XMWR_op0_n100_rwl_late_hold_1 sn_op0_n100_rwl_late_hold_1 wwl_des wbl_op0_n100_rwl_late_hold 0 sky130_fd_pr__nfet_01v8 L=0.15 W=0.42 nf=1 ad=0.1218 as=0.1218 pd=1.42 ps=1.42 nrd=0.69047619047619  nrs=0.69047619047619 sa=0 sb=0 sd=0 mult=1 m=1
XMRD_op0_n100_rwl_late_hold_1 rbl_op0_n100_rwl_late_hold sn_op0_n100_rwl_late_hold_1 rwl_des 0 sky130_fd_pr__nfet_01v8 L=0.15 W=0.42 nf=1 ad=0.1218 as=0.1218 pd=1.42 ps=1.42 nrd=0.69047619047619  nrs=0.69047619047619 sa=0 sb=0 sd=0 mult=1 m=1
csn_op0_n100_rwl_late_hold_1 sn_op0_n100_rwl_late_hold_1 0 {C_SN}
XMWR_op0_n100_rwl_late_hold_2 sn_op0_n100_rwl_late_hold_2 wwl_des wbl_op0_n100_rwl_late_hold 0 sky130_fd_pr__nfet_01v8 L=0.15 W=0.42 nf=1 ad=0.1218 as=0.1218 pd=1.42 ps=1.42 nrd=0.69047619047619  nrs=0.69047619047619 sa=0 sb=0 sd=0 mult=1 m=1
XMRD_op0_n100_rwl_late_hold_2 rbl_op0_n100_rwl_late_hold sn_op0_n100_rwl_late_hold_2 rwl_des 0 sky130_fd_pr__nfet_01v8 L=0.15 W=0.42 nf=1 ad=0.1218 as=0.1218 pd=1.42 ps=1.42 nrd=0.69047619047619  nrs=0.69047619047619 sa=0 sb=0 sd=0 mult=1 m=1
csn_op0_n100_rwl_late_hold_2 sn_op0_n100_rwl_late_hold_2 0 {C_SN}
XMWR_op0_n100_rwl_late_hold_3 sn_op0_n100_rwl_late_hold_3 wwl_des wbl_op0_n100_rwl_late_hold 0 sky130_fd_pr__nfet_01v8 L=0.15 W=0.42 nf=1 ad=0.1218 as=0.1218 pd=1.42 ps=1.42 nrd=0.69047619047619  nrs=0.69047619047619 sa=0 sb=0 sd=0 mult=1 m=1
XMRD_op0_n100_rwl_late_hold_3 rbl_op0_n100_rwl_late_hold sn_op0_n100_rwl_late_hold_3 rwl_des 0 sky130_fd_pr__nfet_01v8 L=0.15 W=0.42 nf=1 ad=0.1218 as=0.1218 pd=1.42 ps=1.42 nrd=0.69047619047619  nrs=0.69047619047619 sa=0 sb=0 sd=0 mult=1 m=1
csn_op0_n100_rwl_late_hold_3 sn_op0_n100_rwl_late_hold_3 0 {C_SN}
XMN1_op0_n100_rwl_late_hold rbl_op0_n100_rwl_late_hold ref_op0_n100_rwl_late_hold vn_op0_n100_rwl_late_hold 0 sky130_fd_pr__nfet_01v8 L=0.15 W=1 nf=1 ad=0.29 as=0.29 pd=2.58 ps=2.58 mult=1 m=1
XMN2_op0_n100_rwl_late_hold ref_op0_n100_rwl_late_hold rbl_op0_n100_rwl_late_hold vn_op0_n100_rwl_late_hold 0 sky130_fd_pr__nfet_01v8 L=0.15 W=1 nf=1 ad=0.29 as=0.29 pd=2.58 ps=2.58 mult=1 m=1
XMP1_op0_n100_rwl_late_hold rbl_op0_n100_rwl_late_hold ref_op0_n100_rwl_late_hold vp_op0_n100_rwl_late_hold vdd sky130_fd_pr__pfet_01v8 L=0.15 W=2 nf=1 ad=0.58 as=0.58 pd=4.58 ps=4.58 mult=1 m=1
XMP2_op0_n100_rwl_late_hold ref_op0_n100_rwl_late_hold rbl_op0_n100_rwl_late_hold vp_op0_n100_rwl_late_hold vdd sky130_fd_pr__pfet_01v8 L=0.15 W=2 nf=1 ad=0.58 as=0.58 pd=4.58 ps=4.58 mult=1 m=1
XMNF_op0_n100_rwl_late_hold vn_op0_n100_rwl_late_hold en_op0_n100_rwl_late_hold 0 0 sky130_fd_pr__nfet_01v8 L=0.15 W=2 nf=1 ad=0.58 as=0.58 pd=4.58 ps=4.58 mult=1 m=1
XMPH_op0_n100_rwl_late_hold vp_op0_n100_rwl_late_hold enb_op0_n100_rwl_late_hold vdd vdd sky130_fd_pr__pfet_01v8 L=0.15 W=4 nf=1 ad=1.16 as=1.16 pd=8.58 ps=8.58 mult=1 m=1
bd_op0_n100_rwl_late_hold d_op0_n100_rwl_late_hold 0 v=v(rbl_op0_n100_rwl_late_hold)-v(ref_op0_n100_rwl_late_hold)

* ---- instance 27: op0_0000_rwl_late_hold (variant rwl_late_hold; probe dec 11.9 ns, release 34 ns, meas 36 ns) ----
vctl_op0_0000_rwl_late_hold ctl_op0_0000_rwl_late_hold 0 pwl(0.0000e+00 {VDD} 2.0000e-09 {VDD} 2.1000e-09 0)
vrs_op0_0000_rwl_late_hold rwls_op0_0000_rwl_late_hold 0 pwl(0.0000e+00 {VDD} 2.0000e-09 {VDD} 2.1000e-09 0 3.4000e-08 0 3.4100e-08 {VDD})
ven_op0_0000_rwl_late_hold en_op0_0000_rwl_late_hold 0 pwl(0.0000e+00 0 1.1000e-08 0 1.1100e-08 {VDD} 3.4000e-08 {VDD} 3.4100e-08 0)
venb_op0_0000_rwl_late_hold enb_op0_0000_rwl_late_hold 0 pwl(0.0000e+00 {VDD} 1.1000e-08 {VDD} 1.1100e-08 0 3.4000e-08 0 3.4100e-08 {VDD})
vww_op0_0000_rwl_late_hold wwl_op0_0000_rwl_late_hold 0 pwl(0.0000e+00 0 1.2000e-08 0 1.2100e-08 {VDD} 3.2000e-08 {VDD} 3.2100e-08 0)
vwc_op0_0000_rwl_late_hold wbc_op0_0000_rwl_late_hold 0 pwl(0.0000e+00 0 1.2000e-08 0 1.2100e-08 {VDD} 3.4000e-08 {VDD} 3.4100e-08 0)
swb_op0_0000_rwl_late_hold ref_op0_0000_rwl_late_hold wbl_op0_0000_rwl_late_hold wbc_op0_0000_rwl_late_hold 0 swwbl
cwbl_op0_0000_rwl_late_hold wbl_op0_0000_rwl_late_hold 0 {C_WBL}
spa_op0_0000_rwl_late_hold prea rbl_op0_0000_rwl_late_hold ctl_op0_0000_rwl_late_hold 0 swpre
spr_op0_0000_rwl_late_hold pref ref_op0_0000_rwl_late_hold ctl_op0_0000_rwl_late_hold 0 swpre
crbl_op0_0000_rwl_late_hold rbl_op0_0000_rwl_late_hold 0 {C_RBL}
cref_op0_0000_rwl_late_hold ref_op0_0000_rwl_late_hold 0 {C_RBL}   $ ASSUMPTION: ideal matched dummy load
XMWR_op0_0000_rwl_late_hold_0 sn_op0_0000_rwl_late_hold_0 wwl_op0_0000_rwl_late_hold wbl_op0_0000_rwl_late_hold 0 sky130_fd_pr__nfet_01v8 L=0.15 W=0.42 nf=1 ad=0.1218 as=0.1218 pd=1.42 ps=1.42 nrd=0.69047619047619  nrs=0.69047619047619 sa=0 sb=0 sd=0 mult=1 m=1
XMRD_op0_0000_rwl_late_hold_0 rbl_op0_0000_rwl_late_hold sn_op0_0000_rwl_late_hold_0 rwls_op0_0000_rwl_late_hold 0 sky130_fd_pr__nfet_01v8 L=0.15 W=0.42 nf=1 ad=0.1218 as=0.1218 pd=1.42 ps=1.42 nrd=0.69047619047619  nrs=0.69047619047619 sa=0 sb=0 sd=0 mult=1 m=1
csn_op0_0000_rwl_late_hold_0 sn_op0_0000_rwl_late_hold_0 0 {C_SN}
XMWR_op0_0000_rwl_late_hold_1 sn_op0_0000_rwl_late_hold_1 wwl_des wbl_op0_0000_rwl_late_hold 0 sky130_fd_pr__nfet_01v8 L=0.15 W=0.42 nf=1 ad=0.1218 as=0.1218 pd=1.42 ps=1.42 nrd=0.69047619047619  nrs=0.69047619047619 sa=0 sb=0 sd=0 mult=1 m=1
XMRD_op0_0000_rwl_late_hold_1 rbl_op0_0000_rwl_late_hold sn_op0_0000_rwl_late_hold_1 rwl_des 0 sky130_fd_pr__nfet_01v8 L=0.15 W=0.42 nf=1 ad=0.1218 as=0.1218 pd=1.42 ps=1.42 nrd=0.69047619047619  nrs=0.69047619047619 sa=0 sb=0 sd=0 mult=1 m=1
csn_op0_0000_rwl_late_hold_1 sn_op0_0000_rwl_late_hold_1 0 {C_SN}
XMWR_op0_0000_rwl_late_hold_2 sn_op0_0000_rwl_late_hold_2 wwl_des wbl_op0_0000_rwl_late_hold 0 sky130_fd_pr__nfet_01v8 L=0.15 W=0.42 nf=1 ad=0.1218 as=0.1218 pd=1.42 ps=1.42 nrd=0.69047619047619  nrs=0.69047619047619 sa=0 sb=0 sd=0 mult=1 m=1
XMRD_op0_0000_rwl_late_hold_2 rbl_op0_0000_rwl_late_hold sn_op0_0000_rwl_late_hold_2 rwl_des 0 sky130_fd_pr__nfet_01v8 L=0.15 W=0.42 nf=1 ad=0.1218 as=0.1218 pd=1.42 ps=1.42 nrd=0.69047619047619  nrs=0.69047619047619 sa=0 sb=0 sd=0 mult=1 m=1
csn_op0_0000_rwl_late_hold_2 sn_op0_0000_rwl_late_hold_2 0 {C_SN}
XMWR_op0_0000_rwl_late_hold_3 sn_op0_0000_rwl_late_hold_3 wwl_des wbl_op0_0000_rwl_late_hold 0 sky130_fd_pr__nfet_01v8 L=0.15 W=0.42 nf=1 ad=0.1218 as=0.1218 pd=1.42 ps=1.42 nrd=0.69047619047619  nrs=0.69047619047619 sa=0 sb=0 sd=0 mult=1 m=1
XMRD_op0_0000_rwl_late_hold_3 rbl_op0_0000_rwl_late_hold sn_op0_0000_rwl_late_hold_3 rwl_des 0 sky130_fd_pr__nfet_01v8 L=0.15 W=0.42 nf=1 ad=0.1218 as=0.1218 pd=1.42 ps=1.42 nrd=0.69047619047619  nrs=0.69047619047619 sa=0 sb=0 sd=0 mult=1 m=1
csn_op0_0000_rwl_late_hold_3 sn_op0_0000_rwl_late_hold_3 0 {C_SN}
XMN1_op0_0000_rwl_late_hold rbl_op0_0000_rwl_late_hold ref_op0_0000_rwl_late_hold vn_op0_0000_rwl_late_hold 0 sky130_fd_pr__nfet_01v8 L=0.15 W=1 nf=1 ad=0.29 as=0.29 pd=2.58 ps=2.58 mult=1 m=1
XMN2_op0_0000_rwl_late_hold ref_op0_0000_rwl_late_hold rbl_op0_0000_rwl_late_hold vn_op0_0000_rwl_late_hold 0 sky130_fd_pr__nfet_01v8 L=0.15 W=1 nf=1 ad=0.29 as=0.29 pd=2.58 ps=2.58 mult=1 m=1
XMP1_op0_0000_rwl_late_hold rbl_op0_0000_rwl_late_hold ref_op0_0000_rwl_late_hold vp_op0_0000_rwl_late_hold vdd sky130_fd_pr__pfet_01v8 L=0.15 W=2 nf=1 ad=0.58 as=0.58 pd=4.58 ps=4.58 mult=1 m=1
XMP2_op0_0000_rwl_late_hold ref_op0_0000_rwl_late_hold rbl_op0_0000_rwl_late_hold vp_op0_0000_rwl_late_hold vdd sky130_fd_pr__pfet_01v8 L=0.15 W=2 nf=1 ad=0.58 as=0.58 pd=4.58 ps=4.58 mult=1 m=1
XMNF_op0_0000_rwl_late_hold vn_op0_0000_rwl_late_hold en_op0_0000_rwl_late_hold 0 0 sky130_fd_pr__nfet_01v8 L=0.15 W=2 nf=1 ad=0.58 as=0.58 pd=4.58 ps=4.58 mult=1 m=1
XMPH_op0_0000_rwl_late_hold vp_op0_0000_rwl_late_hold enb_op0_0000_rwl_late_hold vdd vdd sky130_fd_pr__pfet_01v8 L=0.15 W=4 nf=1 ad=1.16 as=1.16 pd=8.58 ps=8.58 mult=1 m=1
bd_op0_0000_rwl_late_hold d_op0_0000_rwl_late_hold 0 v=v(rbl_op0_0000_rwl_late_hold)-v(ref_op0_0000_rwl_late_hold)

* ---- instance 28: op1_0900_latch_early_hold (variant latch_early_hold; probe dec 11.9 ns, release 34 ns, meas 36 ns) ----
vctl_op1_0900_latch_early_hold ctl_op1_0900_latch_early_hold 0 pwl(0.0000e+00 {VDD} 2.0000e-09 {VDD} 2.1000e-09 0)
vrs_op1_0900_latch_early_hold rwls_op1_0900_latch_early_hold 0 pwl(0.0000e+00 {VDD} 2.0000e-09 {VDD} 2.1000e-09 0 1.2000e-08 0 1.2100e-08 {VDD})
ven_op1_0900_latch_early_hold en_op1_0900_latch_early_hold 0 pwl(0.0000e+00 0 1.1000e-08 0 1.1100e-08 {VDD} 3.0000e-08 {VDD} 3.0100e-08 0)
venb_op1_0900_latch_early_hold enb_op1_0900_latch_early_hold 0 pwl(0.0000e+00 {VDD} 1.1000e-08 {VDD} 1.1100e-08 0 3.0000e-08 0 3.0100e-08 {VDD})
vww_op1_0900_latch_early_hold wwl_op1_0900_latch_early_hold 0 pwl(0.0000e+00 0 1.2000e-08 0 1.2100e-08 {VDD} 3.2000e-08 {VDD} 3.2100e-08 0)
vwc_op1_0900_latch_early_hold wbc_op1_0900_latch_early_hold 0 pwl(0.0000e+00 0 1.2000e-08 0 1.2100e-08 {VDD} 3.4000e-08 {VDD} 3.4100e-08 0)
swb_op1_0900_latch_early_hold ref_op1_0900_latch_early_hold wbl_op1_0900_latch_early_hold wbc_op1_0900_latch_early_hold 0 swwbl
cwbl_op1_0900_latch_early_hold wbl_op1_0900_latch_early_hold 0 {C_WBL}
spa_op1_0900_latch_early_hold prea rbl_op1_0900_latch_early_hold ctl_op1_0900_latch_early_hold 0 swpre
spr_op1_0900_latch_early_hold pref ref_op1_0900_latch_early_hold ctl_op1_0900_latch_early_hold 0 swpre
crbl_op1_0900_latch_early_hold rbl_op1_0900_latch_early_hold 0 {C_RBL}
cref_op1_0900_latch_early_hold ref_op1_0900_latch_early_hold 0 {C_RBL}   $ ASSUMPTION: ideal matched dummy load
XMWR_op1_0900_latch_early_hold_0 sn_op1_0900_latch_early_hold_0 wwl_op1_0900_latch_early_hold wbl_op1_0900_latch_early_hold 0 sky130_fd_pr__nfet_01v8 L=0.15 W=0.42 nf=1 ad=0.1218 as=0.1218 pd=1.42 ps=1.42 nrd=0.69047619047619  nrs=0.69047619047619 sa=0 sb=0 sd=0 mult=1 m=1
XMRD_op1_0900_latch_early_hold_0 rbl_op1_0900_latch_early_hold sn_op1_0900_latch_early_hold_0 rwls_op1_0900_latch_early_hold 0 sky130_fd_pr__nfet_01v8 L=0.15 W=0.42 nf=1 ad=0.1218 as=0.1218 pd=1.42 ps=1.42 nrd=0.69047619047619  nrs=0.69047619047619 sa=0 sb=0 sd=0 mult=1 m=1
csn_op1_0900_latch_early_hold_0 sn_op1_0900_latch_early_hold_0 0 {C_SN}
XMWR_op1_0900_latch_early_hold_1 sn_op1_0900_latch_early_hold_1 wwl_des wbl_op1_0900_latch_early_hold 0 sky130_fd_pr__nfet_01v8 L=0.15 W=0.42 nf=1 ad=0.1218 as=0.1218 pd=1.42 ps=1.42 nrd=0.69047619047619  nrs=0.69047619047619 sa=0 sb=0 sd=0 mult=1 m=1
XMRD_op1_0900_latch_early_hold_1 rbl_op1_0900_latch_early_hold sn_op1_0900_latch_early_hold_1 rwl_des 0 sky130_fd_pr__nfet_01v8 L=0.15 W=0.42 nf=1 ad=0.1218 as=0.1218 pd=1.42 ps=1.42 nrd=0.69047619047619  nrs=0.69047619047619 sa=0 sb=0 sd=0 mult=1 m=1
csn_op1_0900_latch_early_hold_1 sn_op1_0900_latch_early_hold_1 0 {C_SN}
XMWR_op1_0900_latch_early_hold_2 sn_op1_0900_latch_early_hold_2 wwl_des wbl_op1_0900_latch_early_hold 0 sky130_fd_pr__nfet_01v8 L=0.15 W=0.42 nf=1 ad=0.1218 as=0.1218 pd=1.42 ps=1.42 nrd=0.69047619047619  nrs=0.69047619047619 sa=0 sb=0 sd=0 mult=1 m=1
XMRD_op1_0900_latch_early_hold_2 rbl_op1_0900_latch_early_hold sn_op1_0900_latch_early_hold_2 rwl_des 0 sky130_fd_pr__nfet_01v8 L=0.15 W=0.42 nf=1 ad=0.1218 as=0.1218 pd=1.42 ps=1.42 nrd=0.69047619047619  nrs=0.69047619047619 sa=0 sb=0 sd=0 mult=1 m=1
csn_op1_0900_latch_early_hold_2 sn_op1_0900_latch_early_hold_2 0 {C_SN}
XMWR_op1_0900_latch_early_hold_3 sn_op1_0900_latch_early_hold_3 wwl_des wbl_op1_0900_latch_early_hold 0 sky130_fd_pr__nfet_01v8 L=0.15 W=0.42 nf=1 ad=0.1218 as=0.1218 pd=1.42 ps=1.42 nrd=0.69047619047619  nrs=0.69047619047619 sa=0 sb=0 sd=0 mult=1 m=1
XMRD_op1_0900_latch_early_hold_3 rbl_op1_0900_latch_early_hold sn_op1_0900_latch_early_hold_3 rwl_des 0 sky130_fd_pr__nfet_01v8 L=0.15 W=0.42 nf=1 ad=0.1218 as=0.1218 pd=1.42 ps=1.42 nrd=0.69047619047619  nrs=0.69047619047619 sa=0 sb=0 sd=0 mult=1 m=1
csn_op1_0900_latch_early_hold_3 sn_op1_0900_latch_early_hold_3 0 {C_SN}
XMN1_op1_0900_latch_early_hold rbl_op1_0900_latch_early_hold ref_op1_0900_latch_early_hold vn_op1_0900_latch_early_hold 0 sky130_fd_pr__nfet_01v8 L=0.15 W=1 nf=1 ad=0.29 as=0.29 pd=2.58 ps=2.58 mult=1 m=1
XMN2_op1_0900_latch_early_hold ref_op1_0900_latch_early_hold rbl_op1_0900_latch_early_hold vn_op1_0900_latch_early_hold 0 sky130_fd_pr__nfet_01v8 L=0.15 W=1 nf=1 ad=0.29 as=0.29 pd=2.58 ps=2.58 mult=1 m=1
XMP1_op1_0900_latch_early_hold rbl_op1_0900_latch_early_hold ref_op1_0900_latch_early_hold vp_op1_0900_latch_early_hold vdd sky130_fd_pr__pfet_01v8 L=0.15 W=2 nf=1 ad=0.58 as=0.58 pd=4.58 ps=4.58 mult=1 m=1
XMP2_op1_0900_latch_early_hold ref_op1_0900_latch_early_hold rbl_op1_0900_latch_early_hold vp_op1_0900_latch_early_hold vdd sky130_fd_pr__pfet_01v8 L=0.15 W=2 nf=1 ad=0.58 as=0.58 pd=4.58 ps=4.58 mult=1 m=1
XMNF_op1_0900_latch_early_hold vn_op1_0900_latch_early_hold en_op1_0900_latch_early_hold 0 0 sky130_fd_pr__nfet_01v8 L=0.15 W=2 nf=1 ad=0.58 as=0.58 pd=4.58 ps=4.58 mult=1 m=1
XMPH_op1_0900_latch_early_hold vp_op1_0900_latch_early_hold enb_op1_0900_latch_early_hold vdd vdd sky130_fd_pr__pfet_01v8 L=0.15 W=4 nf=1 ad=1.16 as=1.16 pd=8.58 ps=8.58 mult=1 m=1
bd_op1_0900_latch_early_hold d_op1_0900_latch_early_hold 0 v=v(rbl_op1_0900_latch_early_hold)-v(ref_op1_0900_latch_early_hold)

* ---- instance 29: op1_1000_latch_early_hold (variant latch_early_hold; probe dec 11.9 ns, release 34 ns, meas 36 ns) ----
vctl_op1_1000_latch_early_hold ctl_op1_1000_latch_early_hold 0 pwl(0.0000e+00 {VDD} 2.0000e-09 {VDD} 2.1000e-09 0)
vrs_op1_1000_latch_early_hold rwls_op1_1000_latch_early_hold 0 pwl(0.0000e+00 {VDD} 2.0000e-09 {VDD} 2.1000e-09 0 1.2000e-08 0 1.2100e-08 {VDD})
ven_op1_1000_latch_early_hold en_op1_1000_latch_early_hold 0 pwl(0.0000e+00 0 1.1000e-08 0 1.1100e-08 {VDD} 3.0000e-08 {VDD} 3.0100e-08 0)
venb_op1_1000_latch_early_hold enb_op1_1000_latch_early_hold 0 pwl(0.0000e+00 {VDD} 1.1000e-08 {VDD} 1.1100e-08 0 3.0000e-08 0 3.0100e-08 {VDD})
vww_op1_1000_latch_early_hold wwl_op1_1000_latch_early_hold 0 pwl(0.0000e+00 0 1.2000e-08 0 1.2100e-08 {VDD} 3.2000e-08 {VDD} 3.2100e-08 0)
vwc_op1_1000_latch_early_hold wbc_op1_1000_latch_early_hold 0 pwl(0.0000e+00 0 1.2000e-08 0 1.2100e-08 {VDD} 3.4000e-08 {VDD} 3.4100e-08 0)
swb_op1_1000_latch_early_hold ref_op1_1000_latch_early_hold wbl_op1_1000_latch_early_hold wbc_op1_1000_latch_early_hold 0 swwbl
cwbl_op1_1000_latch_early_hold wbl_op1_1000_latch_early_hold 0 {C_WBL}
spa_op1_1000_latch_early_hold prea rbl_op1_1000_latch_early_hold ctl_op1_1000_latch_early_hold 0 swpre
spr_op1_1000_latch_early_hold pref ref_op1_1000_latch_early_hold ctl_op1_1000_latch_early_hold 0 swpre
crbl_op1_1000_latch_early_hold rbl_op1_1000_latch_early_hold 0 {C_RBL}
cref_op1_1000_latch_early_hold ref_op1_1000_latch_early_hold 0 {C_RBL}   $ ASSUMPTION: ideal matched dummy load
XMWR_op1_1000_latch_early_hold_0 sn_op1_1000_latch_early_hold_0 wwl_op1_1000_latch_early_hold wbl_op1_1000_latch_early_hold 0 sky130_fd_pr__nfet_01v8 L=0.15 W=0.42 nf=1 ad=0.1218 as=0.1218 pd=1.42 ps=1.42 nrd=0.69047619047619  nrs=0.69047619047619 sa=0 sb=0 sd=0 mult=1 m=1
XMRD_op1_1000_latch_early_hold_0 rbl_op1_1000_latch_early_hold sn_op1_1000_latch_early_hold_0 rwls_op1_1000_latch_early_hold 0 sky130_fd_pr__nfet_01v8 L=0.15 W=0.42 nf=1 ad=0.1218 as=0.1218 pd=1.42 ps=1.42 nrd=0.69047619047619  nrs=0.69047619047619 sa=0 sb=0 sd=0 mult=1 m=1
csn_op1_1000_latch_early_hold_0 sn_op1_1000_latch_early_hold_0 0 {C_SN}
XMWR_op1_1000_latch_early_hold_1 sn_op1_1000_latch_early_hold_1 wwl_des wbl_op1_1000_latch_early_hold 0 sky130_fd_pr__nfet_01v8 L=0.15 W=0.42 nf=1 ad=0.1218 as=0.1218 pd=1.42 ps=1.42 nrd=0.69047619047619  nrs=0.69047619047619 sa=0 sb=0 sd=0 mult=1 m=1
XMRD_op1_1000_latch_early_hold_1 rbl_op1_1000_latch_early_hold sn_op1_1000_latch_early_hold_1 rwl_des 0 sky130_fd_pr__nfet_01v8 L=0.15 W=0.42 nf=1 ad=0.1218 as=0.1218 pd=1.42 ps=1.42 nrd=0.69047619047619  nrs=0.69047619047619 sa=0 sb=0 sd=0 mult=1 m=1
csn_op1_1000_latch_early_hold_1 sn_op1_1000_latch_early_hold_1 0 {C_SN}
XMWR_op1_1000_latch_early_hold_2 sn_op1_1000_latch_early_hold_2 wwl_des wbl_op1_1000_latch_early_hold 0 sky130_fd_pr__nfet_01v8 L=0.15 W=0.42 nf=1 ad=0.1218 as=0.1218 pd=1.42 ps=1.42 nrd=0.69047619047619  nrs=0.69047619047619 sa=0 sb=0 sd=0 mult=1 m=1
XMRD_op1_1000_latch_early_hold_2 rbl_op1_1000_latch_early_hold sn_op1_1000_latch_early_hold_2 rwl_des 0 sky130_fd_pr__nfet_01v8 L=0.15 W=0.42 nf=1 ad=0.1218 as=0.1218 pd=1.42 ps=1.42 nrd=0.69047619047619  nrs=0.69047619047619 sa=0 sb=0 sd=0 mult=1 m=1
csn_op1_1000_latch_early_hold_2 sn_op1_1000_latch_early_hold_2 0 {C_SN}
XMWR_op1_1000_latch_early_hold_3 sn_op1_1000_latch_early_hold_3 wwl_des wbl_op1_1000_latch_early_hold 0 sky130_fd_pr__nfet_01v8 L=0.15 W=0.42 nf=1 ad=0.1218 as=0.1218 pd=1.42 ps=1.42 nrd=0.69047619047619  nrs=0.69047619047619 sa=0 sb=0 sd=0 mult=1 m=1
XMRD_op1_1000_latch_early_hold_3 rbl_op1_1000_latch_early_hold sn_op1_1000_latch_early_hold_3 rwl_des 0 sky130_fd_pr__nfet_01v8 L=0.15 W=0.42 nf=1 ad=0.1218 as=0.1218 pd=1.42 ps=1.42 nrd=0.69047619047619  nrs=0.69047619047619 sa=0 sb=0 sd=0 mult=1 m=1
csn_op1_1000_latch_early_hold_3 sn_op1_1000_latch_early_hold_3 0 {C_SN}
XMN1_op1_1000_latch_early_hold rbl_op1_1000_latch_early_hold ref_op1_1000_latch_early_hold vn_op1_1000_latch_early_hold 0 sky130_fd_pr__nfet_01v8 L=0.15 W=1 nf=1 ad=0.29 as=0.29 pd=2.58 ps=2.58 mult=1 m=1
XMN2_op1_1000_latch_early_hold ref_op1_1000_latch_early_hold rbl_op1_1000_latch_early_hold vn_op1_1000_latch_early_hold 0 sky130_fd_pr__nfet_01v8 L=0.15 W=1 nf=1 ad=0.29 as=0.29 pd=2.58 ps=2.58 mult=1 m=1
XMP1_op1_1000_latch_early_hold rbl_op1_1000_latch_early_hold ref_op1_1000_latch_early_hold vp_op1_1000_latch_early_hold vdd sky130_fd_pr__pfet_01v8 L=0.15 W=2 nf=1 ad=0.58 as=0.58 pd=4.58 ps=4.58 mult=1 m=1
XMP2_op1_1000_latch_early_hold ref_op1_1000_latch_early_hold rbl_op1_1000_latch_early_hold vp_op1_1000_latch_early_hold vdd sky130_fd_pr__pfet_01v8 L=0.15 W=2 nf=1 ad=0.58 as=0.58 pd=4.58 ps=4.58 mult=1 m=1
XMNF_op1_1000_latch_early_hold vn_op1_1000_latch_early_hold en_op1_1000_latch_early_hold 0 0 sky130_fd_pr__nfet_01v8 L=0.15 W=2 nf=1 ad=0.58 as=0.58 pd=4.58 ps=4.58 mult=1 m=1
XMPH_op1_1000_latch_early_hold vp_op1_1000_latch_early_hold enb_op1_1000_latch_early_hold vdd vdd sky130_fd_pr__pfet_01v8 L=0.15 W=4 nf=1 ad=1.16 as=1.16 pd=8.58 ps=8.58 mult=1 m=1
bd_op1_1000_latch_early_hold d_op1_1000_latch_early_hold 0 v=v(rbl_op1_1000_latch_early_hold)-v(ref_op1_1000_latch_early_hold)

* ---- instance 30: op0_n100_latch_early_hold (variant latch_early_hold; probe dec 11.9 ns, release 34 ns, meas 36 ns) ----
vctl_op0_n100_latch_early_hold ctl_op0_n100_latch_early_hold 0 pwl(0.0000e+00 {VDD} 2.0000e-09 {VDD} 2.1000e-09 0)
vrs_op0_n100_latch_early_hold rwls_op0_n100_latch_early_hold 0 pwl(0.0000e+00 {VDD} 2.0000e-09 {VDD} 2.1000e-09 0 1.2000e-08 0 1.2100e-08 {VDD})
ven_op0_n100_latch_early_hold en_op0_n100_latch_early_hold 0 pwl(0.0000e+00 0 1.1000e-08 0 1.1100e-08 {VDD} 3.0000e-08 {VDD} 3.0100e-08 0)
venb_op0_n100_latch_early_hold enb_op0_n100_latch_early_hold 0 pwl(0.0000e+00 {VDD} 1.1000e-08 {VDD} 1.1100e-08 0 3.0000e-08 0 3.0100e-08 {VDD})
vww_op0_n100_latch_early_hold wwl_op0_n100_latch_early_hold 0 pwl(0.0000e+00 0 1.2000e-08 0 1.2100e-08 {VDD} 3.2000e-08 {VDD} 3.2100e-08 0)
vwc_op0_n100_latch_early_hold wbc_op0_n100_latch_early_hold 0 pwl(0.0000e+00 0 1.2000e-08 0 1.2100e-08 {VDD} 3.4000e-08 {VDD} 3.4100e-08 0)
swb_op0_n100_latch_early_hold ref_op0_n100_latch_early_hold wbl_op0_n100_latch_early_hold wbc_op0_n100_latch_early_hold 0 swwbl
cwbl_op0_n100_latch_early_hold wbl_op0_n100_latch_early_hold 0 {C_WBL}
spa_op0_n100_latch_early_hold prea rbl_op0_n100_latch_early_hold ctl_op0_n100_latch_early_hold 0 swpre
spr_op0_n100_latch_early_hold pref ref_op0_n100_latch_early_hold ctl_op0_n100_latch_early_hold 0 swpre
crbl_op0_n100_latch_early_hold rbl_op0_n100_latch_early_hold 0 {C_RBL}
cref_op0_n100_latch_early_hold ref_op0_n100_latch_early_hold 0 {C_RBL}   $ ASSUMPTION: ideal matched dummy load
XMWR_op0_n100_latch_early_hold_0 sn_op0_n100_latch_early_hold_0 wwl_op0_n100_latch_early_hold wbl_op0_n100_latch_early_hold 0 sky130_fd_pr__nfet_01v8 L=0.15 W=0.42 nf=1 ad=0.1218 as=0.1218 pd=1.42 ps=1.42 nrd=0.69047619047619  nrs=0.69047619047619 sa=0 sb=0 sd=0 mult=1 m=1
XMRD_op0_n100_latch_early_hold_0 rbl_op0_n100_latch_early_hold sn_op0_n100_latch_early_hold_0 rwls_op0_n100_latch_early_hold 0 sky130_fd_pr__nfet_01v8 L=0.15 W=0.42 nf=1 ad=0.1218 as=0.1218 pd=1.42 ps=1.42 nrd=0.69047619047619  nrs=0.69047619047619 sa=0 sb=0 sd=0 mult=1 m=1
csn_op0_n100_latch_early_hold_0 sn_op0_n100_latch_early_hold_0 0 {C_SN}
XMWR_op0_n100_latch_early_hold_1 sn_op0_n100_latch_early_hold_1 wwl_des wbl_op0_n100_latch_early_hold 0 sky130_fd_pr__nfet_01v8 L=0.15 W=0.42 nf=1 ad=0.1218 as=0.1218 pd=1.42 ps=1.42 nrd=0.69047619047619  nrs=0.69047619047619 sa=0 sb=0 sd=0 mult=1 m=1
XMRD_op0_n100_latch_early_hold_1 rbl_op0_n100_latch_early_hold sn_op0_n100_latch_early_hold_1 rwl_des 0 sky130_fd_pr__nfet_01v8 L=0.15 W=0.42 nf=1 ad=0.1218 as=0.1218 pd=1.42 ps=1.42 nrd=0.69047619047619  nrs=0.69047619047619 sa=0 sb=0 sd=0 mult=1 m=1
csn_op0_n100_latch_early_hold_1 sn_op0_n100_latch_early_hold_1 0 {C_SN}
XMWR_op0_n100_latch_early_hold_2 sn_op0_n100_latch_early_hold_2 wwl_des wbl_op0_n100_latch_early_hold 0 sky130_fd_pr__nfet_01v8 L=0.15 W=0.42 nf=1 ad=0.1218 as=0.1218 pd=1.42 ps=1.42 nrd=0.69047619047619  nrs=0.69047619047619 sa=0 sb=0 sd=0 mult=1 m=1
XMRD_op0_n100_latch_early_hold_2 rbl_op0_n100_latch_early_hold sn_op0_n100_latch_early_hold_2 rwl_des 0 sky130_fd_pr__nfet_01v8 L=0.15 W=0.42 nf=1 ad=0.1218 as=0.1218 pd=1.42 ps=1.42 nrd=0.69047619047619  nrs=0.69047619047619 sa=0 sb=0 sd=0 mult=1 m=1
csn_op0_n100_latch_early_hold_2 sn_op0_n100_latch_early_hold_2 0 {C_SN}
XMWR_op0_n100_latch_early_hold_3 sn_op0_n100_latch_early_hold_3 wwl_des wbl_op0_n100_latch_early_hold 0 sky130_fd_pr__nfet_01v8 L=0.15 W=0.42 nf=1 ad=0.1218 as=0.1218 pd=1.42 ps=1.42 nrd=0.69047619047619  nrs=0.69047619047619 sa=0 sb=0 sd=0 mult=1 m=1
XMRD_op0_n100_latch_early_hold_3 rbl_op0_n100_latch_early_hold sn_op0_n100_latch_early_hold_3 rwl_des 0 sky130_fd_pr__nfet_01v8 L=0.15 W=0.42 nf=1 ad=0.1218 as=0.1218 pd=1.42 ps=1.42 nrd=0.69047619047619  nrs=0.69047619047619 sa=0 sb=0 sd=0 mult=1 m=1
csn_op0_n100_latch_early_hold_3 sn_op0_n100_latch_early_hold_3 0 {C_SN}
XMN1_op0_n100_latch_early_hold rbl_op0_n100_latch_early_hold ref_op0_n100_latch_early_hold vn_op0_n100_latch_early_hold 0 sky130_fd_pr__nfet_01v8 L=0.15 W=1 nf=1 ad=0.29 as=0.29 pd=2.58 ps=2.58 mult=1 m=1
XMN2_op0_n100_latch_early_hold ref_op0_n100_latch_early_hold rbl_op0_n100_latch_early_hold vn_op0_n100_latch_early_hold 0 sky130_fd_pr__nfet_01v8 L=0.15 W=1 nf=1 ad=0.29 as=0.29 pd=2.58 ps=2.58 mult=1 m=1
XMP1_op0_n100_latch_early_hold rbl_op0_n100_latch_early_hold ref_op0_n100_latch_early_hold vp_op0_n100_latch_early_hold vdd sky130_fd_pr__pfet_01v8 L=0.15 W=2 nf=1 ad=0.58 as=0.58 pd=4.58 ps=4.58 mult=1 m=1
XMP2_op0_n100_latch_early_hold ref_op0_n100_latch_early_hold rbl_op0_n100_latch_early_hold vp_op0_n100_latch_early_hold vdd sky130_fd_pr__pfet_01v8 L=0.15 W=2 nf=1 ad=0.58 as=0.58 pd=4.58 ps=4.58 mult=1 m=1
XMNF_op0_n100_latch_early_hold vn_op0_n100_latch_early_hold en_op0_n100_latch_early_hold 0 0 sky130_fd_pr__nfet_01v8 L=0.15 W=2 nf=1 ad=0.58 as=0.58 pd=4.58 ps=4.58 mult=1 m=1
XMPH_op0_n100_latch_early_hold vp_op0_n100_latch_early_hold enb_op0_n100_latch_early_hold vdd vdd sky130_fd_pr__pfet_01v8 L=0.15 W=4 nf=1 ad=1.16 as=1.16 pd=8.58 ps=8.58 mult=1 m=1
bd_op0_n100_latch_early_hold d_op0_n100_latch_early_hold 0 v=v(rbl_op0_n100_latch_early_hold)-v(ref_op0_n100_latch_early_hold)

* ---- instance 31: op0_0000_latch_early_hold (variant latch_early_hold; probe dec 11.9 ns, release 34 ns, meas 36 ns) ----
vctl_op0_0000_latch_early_hold ctl_op0_0000_latch_early_hold 0 pwl(0.0000e+00 {VDD} 2.0000e-09 {VDD} 2.1000e-09 0)
vrs_op0_0000_latch_early_hold rwls_op0_0000_latch_early_hold 0 pwl(0.0000e+00 {VDD} 2.0000e-09 {VDD} 2.1000e-09 0 1.2000e-08 0 1.2100e-08 {VDD})
ven_op0_0000_latch_early_hold en_op0_0000_latch_early_hold 0 pwl(0.0000e+00 0 1.1000e-08 0 1.1100e-08 {VDD} 3.0000e-08 {VDD} 3.0100e-08 0)
venb_op0_0000_latch_early_hold enb_op0_0000_latch_early_hold 0 pwl(0.0000e+00 {VDD} 1.1000e-08 {VDD} 1.1100e-08 0 3.0000e-08 0 3.0100e-08 {VDD})
vww_op0_0000_latch_early_hold wwl_op0_0000_latch_early_hold 0 pwl(0.0000e+00 0 1.2000e-08 0 1.2100e-08 {VDD} 3.2000e-08 {VDD} 3.2100e-08 0)
vwc_op0_0000_latch_early_hold wbc_op0_0000_latch_early_hold 0 pwl(0.0000e+00 0 1.2000e-08 0 1.2100e-08 {VDD} 3.4000e-08 {VDD} 3.4100e-08 0)
swb_op0_0000_latch_early_hold ref_op0_0000_latch_early_hold wbl_op0_0000_latch_early_hold wbc_op0_0000_latch_early_hold 0 swwbl
cwbl_op0_0000_latch_early_hold wbl_op0_0000_latch_early_hold 0 {C_WBL}
spa_op0_0000_latch_early_hold prea rbl_op0_0000_latch_early_hold ctl_op0_0000_latch_early_hold 0 swpre
spr_op0_0000_latch_early_hold pref ref_op0_0000_latch_early_hold ctl_op0_0000_latch_early_hold 0 swpre
crbl_op0_0000_latch_early_hold rbl_op0_0000_latch_early_hold 0 {C_RBL}
cref_op0_0000_latch_early_hold ref_op0_0000_latch_early_hold 0 {C_RBL}   $ ASSUMPTION: ideal matched dummy load
XMWR_op0_0000_latch_early_hold_0 sn_op0_0000_latch_early_hold_0 wwl_op0_0000_latch_early_hold wbl_op0_0000_latch_early_hold 0 sky130_fd_pr__nfet_01v8 L=0.15 W=0.42 nf=1 ad=0.1218 as=0.1218 pd=1.42 ps=1.42 nrd=0.69047619047619  nrs=0.69047619047619 sa=0 sb=0 sd=0 mult=1 m=1
XMRD_op0_0000_latch_early_hold_0 rbl_op0_0000_latch_early_hold sn_op0_0000_latch_early_hold_0 rwls_op0_0000_latch_early_hold 0 sky130_fd_pr__nfet_01v8 L=0.15 W=0.42 nf=1 ad=0.1218 as=0.1218 pd=1.42 ps=1.42 nrd=0.69047619047619  nrs=0.69047619047619 sa=0 sb=0 sd=0 mult=1 m=1
csn_op0_0000_latch_early_hold_0 sn_op0_0000_latch_early_hold_0 0 {C_SN}
XMWR_op0_0000_latch_early_hold_1 sn_op0_0000_latch_early_hold_1 wwl_des wbl_op0_0000_latch_early_hold 0 sky130_fd_pr__nfet_01v8 L=0.15 W=0.42 nf=1 ad=0.1218 as=0.1218 pd=1.42 ps=1.42 nrd=0.69047619047619  nrs=0.69047619047619 sa=0 sb=0 sd=0 mult=1 m=1
XMRD_op0_0000_latch_early_hold_1 rbl_op0_0000_latch_early_hold sn_op0_0000_latch_early_hold_1 rwl_des 0 sky130_fd_pr__nfet_01v8 L=0.15 W=0.42 nf=1 ad=0.1218 as=0.1218 pd=1.42 ps=1.42 nrd=0.69047619047619  nrs=0.69047619047619 sa=0 sb=0 sd=0 mult=1 m=1
csn_op0_0000_latch_early_hold_1 sn_op0_0000_latch_early_hold_1 0 {C_SN}
XMWR_op0_0000_latch_early_hold_2 sn_op0_0000_latch_early_hold_2 wwl_des wbl_op0_0000_latch_early_hold 0 sky130_fd_pr__nfet_01v8 L=0.15 W=0.42 nf=1 ad=0.1218 as=0.1218 pd=1.42 ps=1.42 nrd=0.69047619047619  nrs=0.69047619047619 sa=0 sb=0 sd=0 mult=1 m=1
XMRD_op0_0000_latch_early_hold_2 rbl_op0_0000_latch_early_hold sn_op0_0000_latch_early_hold_2 rwl_des 0 sky130_fd_pr__nfet_01v8 L=0.15 W=0.42 nf=1 ad=0.1218 as=0.1218 pd=1.42 ps=1.42 nrd=0.69047619047619  nrs=0.69047619047619 sa=0 sb=0 sd=0 mult=1 m=1
csn_op0_0000_latch_early_hold_2 sn_op0_0000_latch_early_hold_2 0 {C_SN}
XMWR_op0_0000_latch_early_hold_3 sn_op0_0000_latch_early_hold_3 wwl_des wbl_op0_0000_latch_early_hold 0 sky130_fd_pr__nfet_01v8 L=0.15 W=0.42 nf=1 ad=0.1218 as=0.1218 pd=1.42 ps=1.42 nrd=0.69047619047619  nrs=0.69047619047619 sa=0 sb=0 sd=0 mult=1 m=1
XMRD_op0_0000_latch_early_hold_3 rbl_op0_0000_latch_early_hold sn_op0_0000_latch_early_hold_3 rwl_des 0 sky130_fd_pr__nfet_01v8 L=0.15 W=0.42 nf=1 ad=0.1218 as=0.1218 pd=1.42 ps=1.42 nrd=0.69047619047619  nrs=0.69047619047619 sa=0 sb=0 sd=0 mult=1 m=1
csn_op0_0000_latch_early_hold_3 sn_op0_0000_latch_early_hold_3 0 {C_SN}
XMN1_op0_0000_latch_early_hold rbl_op0_0000_latch_early_hold ref_op0_0000_latch_early_hold vn_op0_0000_latch_early_hold 0 sky130_fd_pr__nfet_01v8 L=0.15 W=1 nf=1 ad=0.29 as=0.29 pd=2.58 ps=2.58 mult=1 m=1
XMN2_op0_0000_latch_early_hold ref_op0_0000_latch_early_hold rbl_op0_0000_latch_early_hold vn_op0_0000_latch_early_hold 0 sky130_fd_pr__nfet_01v8 L=0.15 W=1 nf=1 ad=0.29 as=0.29 pd=2.58 ps=2.58 mult=1 m=1
XMP1_op0_0000_latch_early_hold rbl_op0_0000_latch_early_hold ref_op0_0000_latch_early_hold vp_op0_0000_latch_early_hold vdd sky130_fd_pr__pfet_01v8 L=0.15 W=2 nf=1 ad=0.58 as=0.58 pd=4.58 ps=4.58 mult=1 m=1
XMP2_op0_0000_latch_early_hold ref_op0_0000_latch_early_hold rbl_op0_0000_latch_early_hold vp_op0_0000_latch_early_hold vdd sky130_fd_pr__pfet_01v8 L=0.15 W=2 nf=1 ad=0.58 as=0.58 pd=4.58 ps=4.58 mult=1 m=1
XMNF_op0_0000_latch_early_hold vn_op0_0000_latch_early_hold en_op0_0000_latch_early_hold 0 0 sky130_fd_pr__nfet_01v8 L=0.15 W=2 nf=1 ad=0.58 as=0.58 pd=4.58 ps=4.58 mult=1 m=1
XMPH_op0_0000_latch_early_hold vp_op0_0000_latch_early_hold enb_op0_0000_latch_early_hold vdd vdd sky130_fd_pr__pfet_01v8 L=0.15 W=4 nf=1 ad=1.16 as=1.16 pd=8.58 ps=8.58 mult=1 m=1
bd_op0_0000_latch_early_hold d_op0_0000_latch_early_hold 0 v=v(rbl_op0_0000_latch_early_hold)-v(ref_op0_0000_latch_early_hold)

* ---- instance 32: op1_0900_latch_late_hold (variant latch_late_hold; probe dec 11.9 ns, release 36 ns, meas 38 ns) ----
vctl_op1_0900_latch_late_hold ctl_op1_0900_latch_late_hold 0 pwl(0.0000e+00 {VDD} 2.0000e-09 {VDD} 2.1000e-09 0)
vrs_op1_0900_latch_late_hold rwls_op1_0900_latch_late_hold 0 pwl(0.0000e+00 {VDD} 2.0000e-09 {VDD} 2.1000e-09 0 1.2000e-08 0 1.2100e-08 {VDD})
ven_op1_0900_latch_late_hold en_op1_0900_latch_late_hold 0 pwl(0.0000e+00 0 1.1000e-08 0 1.1100e-08 {VDD} 3.6000e-08 {VDD} 3.6100e-08 0)
venb_op1_0900_latch_late_hold enb_op1_0900_latch_late_hold 0 pwl(0.0000e+00 {VDD} 1.1000e-08 {VDD} 1.1100e-08 0 3.6000e-08 0 3.6100e-08 {VDD})
vww_op1_0900_latch_late_hold wwl_op1_0900_latch_late_hold 0 pwl(0.0000e+00 0 1.2000e-08 0 1.2100e-08 {VDD} 3.2000e-08 {VDD} 3.2100e-08 0)
vwc_op1_0900_latch_late_hold wbc_op1_0900_latch_late_hold 0 pwl(0.0000e+00 0 1.2000e-08 0 1.2100e-08 {VDD} 3.4000e-08 {VDD} 3.4100e-08 0)
swb_op1_0900_latch_late_hold ref_op1_0900_latch_late_hold wbl_op1_0900_latch_late_hold wbc_op1_0900_latch_late_hold 0 swwbl
cwbl_op1_0900_latch_late_hold wbl_op1_0900_latch_late_hold 0 {C_WBL}
spa_op1_0900_latch_late_hold prea rbl_op1_0900_latch_late_hold ctl_op1_0900_latch_late_hold 0 swpre
spr_op1_0900_latch_late_hold pref ref_op1_0900_latch_late_hold ctl_op1_0900_latch_late_hold 0 swpre
crbl_op1_0900_latch_late_hold rbl_op1_0900_latch_late_hold 0 {C_RBL}
cref_op1_0900_latch_late_hold ref_op1_0900_latch_late_hold 0 {C_RBL}   $ ASSUMPTION: ideal matched dummy load
XMWR_op1_0900_latch_late_hold_0 sn_op1_0900_latch_late_hold_0 wwl_op1_0900_latch_late_hold wbl_op1_0900_latch_late_hold 0 sky130_fd_pr__nfet_01v8 L=0.15 W=0.42 nf=1 ad=0.1218 as=0.1218 pd=1.42 ps=1.42 nrd=0.69047619047619  nrs=0.69047619047619 sa=0 sb=0 sd=0 mult=1 m=1
XMRD_op1_0900_latch_late_hold_0 rbl_op1_0900_latch_late_hold sn_op1_0900_latch_late_hold_0 rwls_op1_0900_latch_late_hold 0 sky130_fd_pr__nfet_01v8 L=0.15 W=0.42 nf=1 ad=0.1218 as=0.1218 pd=1.42 ps=1.42 nrd=0.69047619047619  nrs=0.69047619047619 sa=0 sb=0 sd=0 mult=1 m=1
csn_op1_0900_latch_late_hold_0 sn_op1_0900_latch_late_hold_0 0 {C_SN}
XMWR_op1_0900_latch_late_hold_1 sn_op1_0900_latch_late_hold_1 wwl_des wbl_op1_0900_latch_late_hold 0 sky130_fd_pr__nfet_01v8 L=0.15 W=0.42 nf=1 ad=0.1218 as=0.1218 pd=1.42 ps=1.42 nrd=0.69047619047619  nrs=0.69047619047619 sa=0 sb=0 sd=0 mult=1 m=1
XMRD_op1_0900_latch_late_hold_1 rbl_op1_0900_latch_late_hold sn_op1_0900_latch_late_hold_1 rwl_des 0 sky130_fd_pr__nfet_01v8 L=0.15 W=0.42 nf=1 ad=0.1218 as=0.1218 pd=1.42 ps=1.42 nrd=0.69047619047619  nrs=0.69047619047619 sa=0 sb=0 sd=0 mult=1 m=1
csn_op1_0900_latch_late_hold_1 sn_op1_0900_latch_late_hold_1 0 {C_SN}
XMWR_op1_0900_latch_late_hold_2 sn_op1_0900_latch_late_hold_2 wwl_des wbl_op1_0900_latch_late_hold 0 sky130_fd_pr__nfet_01v8 L=0.15 W=0.42 nf=1 ad=0.1218 as=0.1218 pd=1.42 ps=1.42 nrd=0.69047619047619  nrs=0.69047619047619 sa=0 sb=0 sd=0 mult=1 m=1
XMRD_op1_0900_latch_late_hold_2 rbl_op1_0900_latch_late_hold sn_op1_0900_latch_late_hold_2 rwl_des 0 sky130_fd_pr__nfet_01v8 L=0.15 W=0.42 nf=1 ad=0.1218 as=0.1218 pd=1.42 ps=1.42 nrd=0.69047619047619  nrs=0.69047619047619 sa=0 sb=0 sd=0 mult=1 m=1
csn_op1_0900_latch_late_hold_2 sn_op1_0900_latch_late_hold_2 0 {C_SN}
XMWR_op1_0900_latch_late_hold_3 sn_op1_0900_latch_late_hold_3 wwl_des wbl_op1_0900_latch_late_hold 0 sky130_fd_pr__nfet_01v8 L=0.15 W=0.42 nf=1 ad=0.1218 as=0.1218 pd=1.42 ps=1.42 nrd=0.69047619047619  nrs=0.69047619047619 sa=0 sb=0 sd=0 mult=1 m=1
XMRD_op1_0900_latch_late_hold_3 rbl_op1_0900_latch_late_hold sn_op1_0900_latch_late_hold_3 rwl_des 0 sky130_fd_pr__nfet_01v8 L=0.15 W=0.42 nf=1 ad=0.1218 as=0.1218 pd=1.42 ps=1.42 nrd=0.69047619047619  nrs=0.69047619047619 sa=0 sb=0 sd=0 mult=1 m=1
csn_op1_0900_latch_late_hold_3 sn_op1_0900_latch_late_hold_3 0 {C_SN}
XMN1_op1_0900_latch_late_hold rbl_op1_0900_latch_late_hold ref_op1_0900_latch_late_hold vn_op1_0900_latch_late_hold 0 sky130_fd_pr__nfet_01v8 L=0.15 W=1 nf=1 ad=0.29 as=0.29 pd=2.58 ps=2.58 mult=1 m=1
XMN2_op1_0900_latch_late_hold ref_op1_0900_latch_late_hold rbl_op1_0900_latch_late_hold vn_op1_0900_latch_late_hold 0 sky130_fd_pr__nfet_01v8 L=0.15 W=1 nf=1 ad=0.29 as=0.29 pd=2.58 ps=2.58 mult=1 m=1
XMP1_op1_0900_latch_late_hold rbl_op1_0900_latch_late_hold ref_op1_0900_latch_late_hold vp_op1_0900_latch_late_hold vdd sky130_fd_pr__pfet_01v8 L=0.15 W=2 nf=1 ad=0.58 as=0.58 pd=4.58 ps=4.58 mult=1 m=1
XMP2_op1_0900_latch_late_hold ref_op1_0900_latch_late_hold rbl_op1_0900_latch_late_hold vp_op1_0900_latch_late_hold vdd sky130_fd_pr__pfet_01v8 L=0.15 W=2 nf=1 ad=0.58 as=0.58 pd=4.58 ps=4.58 mult=1 m=1
XMNF_op1_0900_latch_late_hold vn_op1_0900_latch_late_hold en_op1_0900_latch_late_hold 0 0 sky130_fd_pr__nfet_01v8 L=0.15 W=2 nf=1 ad=0.58 as=0.58 pd=4.58 ps=4.58 mult=1 m=1
XMPH_op1_0900_latch_late_hold vp_op1_0900_latch_late_hold enb_op1_0900_latch_late_hold vdd vdd sky130_fd_pr__pfet_01v8 L=0.15 W=4 nf=1 ad=1.16 as=1.16 pd=8.58 ps=8.58 mult=1 m=1
bd_op1_0900_latch_late_hold d_op1_0900_latch_late_hold 0 v=v(rbl_op1_0900_latch_late_hold)-v(ref_op1_0900_latch_late_hold)

* ---- instance 33: op1_1000_latch_late_hold (variant latch_late_hold; probe dec 11.9 ns, release 36 ns, meas 38 ns) ----
vctl_op1_1000_latch_late_hold ctl_op1_1000_latch_late_hold 0 pwl(0.0000e+00 {VDD} 2.0000e-09 {VDD} 2.1000e-09 0)
vrs_op1_1000_latch_late_hold rwls_op1_1000_latch_late_hold 0 pwl(0.0000e+00 {VDD} 2.0000e-09 {VDD} 2.1000e-09 0 1.2000e-08 0 1.2100e-08 {VDD})
ven_op1_1000_latch_late_hold en_op1_1000_latch_late_hold 0 pwl(0.0000e+00 0 1.1000e-08 0 1.1100e-08 {VDD} 3.6000e-08 {VDD} 3.6100e-08 0)
venb_op1_1000_latch_late_hold enb_op1_1000_latch_late_hold 0 pwl(0.0000e+00 {VDD} 1.1000e-08 {VDD} 1.1100e-08 0 3.6000e-08 0 3.6100e-08 {VDD})
vww_op1_1000_latch_late_hold wwl_op1_1000_latch_late_hold 0 pwl(0.0000e+00 0 1.2000e-08 0 1.2100e-08 {VDD} 3.2000e-08 {VDD} 3.2100e-08 0)
vwc_op1_1000_latch_late_hold wbc_op1_1000_latch_late_hold 0 pwl(0.0000e+00 0 1.2000e-08 0 1.2100e-08 {VDD} 3.4000e-08 {VDD} 3.4100e-08 0)
swb_op1_1000_latch_late_hold ref_op1_1000_latch_late_hold wbl_op1_1000_latch_late_hold wbc_op1_1000_latch_late_hold 0 swwbl
cwbl_op1_1000_latch_late_hold wbl_op1_1000_latch_late_hold 0 {C_WBL}
spa_op1_1000_latch_late_hold prea rbl_op1_1000_latch_late_hold ctl_op1_1000_latch_late_hold 0 swpre
spr_op1_1000_latch_late_hold pref ref_op1_1000_latch_late_hold ctl_op1_1000_latch_late_hold 0 swpre
crbl_op1_1000_latch_late_hold rbl_op1_1000_latch_late_hold 0 {C_RBL}
cref_op1_1000_latch_late_hold ref_op1_1000_latch_late_hold 0 {C_RBL}   $ ASSUMPTION: ideal matched dummy load
XMWR_op1_1000_latch_late_hold_0 sn_op1_1000_latch_late_hold_0 wwl_op1_1000_latch_late_hold wbl_op1_1000_latch_late_hold 0 sky130_fd_pr__nfet_01v8 L=0.15 W=0.42 nf=1 ad=0.1218 as=0.1218 pd=1.42 ps=1.42 nrd=0.69047619047619  nrs=0.69047619047619 sa=0 sb=0 sd=0 mult=1 m=1
XMRD_op1_1000_latch_late_hold_0 rbl_op1_1000_latch_late_hold sn_op1_1000_latch_late_hold_0 rwls_op1_1000_latch_late_hold 0 sky130_fd_pr__nfet_01v8 L=0.15 W=0.42 nf=1 ad=0.1218 as=0.1218 pd=1.42 ps=1.42 nrd=0.69047619047619  nrs=0.69047619047619 sa=0 sb=0 sd=0 mult=1 m=1
csn_op1_1000_latch_late_hold_0 sn_op1_1000_latch_late_hold_0 0 {C_SN}
XMWR_op1_1000_latch_late_hold_1 sn_op1_1000_latch_late_hold_1 wwl_des wbl_op1_1000_latch_late_hold 0 sky130_fd_pr__nfet_01v8 L=0.15 W=0.42 nf=1 ad=0.1218 as=0.1218 pd=1.42 ps=1.42 nrd=0.69047619047619  nrs=0.69047619047619 sa=0 sb=0 sd=0 mult=1 m=1
XMRD_op1_1000_latch_late_hold_1 rbl_op1_1000_latch_late_hold sn_op1_1000_latch_late_hold_1 rwl_des 0 sky130_fd_pr__nfet_01v8 L=0.15 W=0.42 nf=1 ad=0.1218 as=0.1218 pd=1.42 ps=1.42 nrd=0.69047619047619  nrs=0.69047619047619 sa=0 sb=0 sd=0 mult=1 m=1
csn_op1_1000_latch_late_hold_1 sn_op1_1000_latch_late_hold_1 0 {C_SN}
XMWR_op1_1000_latch_late_hold_2 sn_op1_1000_latch_late_hold_2 wwl_des wbl_op1_1000_latch_late_hold 0 sky130_fd_pr__nfet_01v8 L=0.15 W=0.42 nf=1 ad=0.1218 as=0.1218 pd=1.42 ps=1.42 nrd=0.69047619047619  nrs=0.69047619047619 sa=0 sb=0 sd=0 mult=1 m=1
XMRD_op1_1000_latch_late_hold_2 rbl_op1_1000_latch_late_hold sn_op1_1000_latch_late_hold_2 rwl_des 0 sky130_fd_pr__nfet_01v8 L=0.15 W=0.42 nf=1 ad=0.1218 as=0.1218 pd=1.42 ps=1.42 nrd=0.69047619047619  nrs=0.69047619047619 sa=0 sb=0 sd=0 mult=1 m=1
csn_op1_1000_latch_late_hold_2 sn_op1_1000_latch_late_hold_2 0 {C_SN}
XMWR_op1_1000_latch_late_hold_3 sn_op1_1000_latch_late_hold_3 wwl_des wbl_op1_1000_latch_late_hold 0 sky130_fd_pr__nfet_01v8 L=0.15 W=0.42 nf=1 ad=0.1218 as=0.1218 pd=1.42 ps=1.42 nrd=0.69047619047619  nrs=0.69047619047619 sa=0 sb=0 sd=0 mult=1 m=1
XMRD_op1_1000_latch_late_hold_3 rbl_op1_1000_latch_late_hold sn_op1_1000_latch_late_hold_3 rwl_des 0 sky130_fd_pr__nfet_01v8 L=0.15 W=0.42 nf=1 ad=0.1218 as=0.1218 pd=1.42 ps=1.42 nrd=0.69047619047619  nrs=0.69047619047619 sa=0 sb=0 sd=0 mult=1 m=1
csn_op1_1000_latch_late_hold_3 sn_op1_1000_latch_late_hold_3 0 {C_SN}
XMN1_op1_1000_latch_late_hold rbl_op1_1000_latch_late_hold ref_op1_1000_latch_late_hold vn_op1_1000_latch_late_hold 0 sky130_fd_pr__nfet_01v8 L=0.15 W=1 nf=1 ad=0.29 as=0.29 pd=2.58 ps=2.58 mult=1 m=1
XMN2_op1_1000_latch_late_hold ref_op1_1000_latch_late_hold rbl_op1_1000_latch_late_hold vn_op1_1000_latch_late_hold 0 sky130_fd_pr__nfet_01v8 L=0.15 W=1 nf=1 ad=0.29 as=0.29 pd=2.58 ps=2.58 mult=1 m=1
XMP1_op1_1000_latch_late_hold rbl_op1_1000_latch_late_hold ref_op1_1000_latch_late_hold vp_op1_1000_latch_late_hold vdd sky130_fd_pr__pfet_01v8 L=0.15 W=2 nf=1 ad=0.58 as=0.58 pd=4.58 ps=4.58 mult=1 m=1
XMP2_op1_1000_latch_late_hold ref_op1_1000_latch_late_hold rbl_op1_1000_latch_late_hold vp_op1_1000_latch_late_hold vdd sky130_fd_pr__pfet_01v8 L=0.15 W=2 nf=1 ad=0.58 as=0.58 pd=4.58 ps=4.58 mult=1 m=1
XMNF_op1_1000_latch_late_hold vn_op1_1000_latch_late_hold en_op1_1000_latch_late_hold 0 0 sky130_fd_pr__nfet_01v8 L=0.15 W=2 nf=1 ad=0.58 as=0.58 pd=4.58 ps=4.58 mult=1 m=1
XMPH_op1_1000_latch_late_hold vp_op1_1000_latch_late_hold enb_op1_1000_latch_late_hold vdd vdd sky130_fd_pr__pfet_01v8 L=0.15 W=4 nf=1 ad=1.16 as=1.16 pd=8.58 ps=8.58 mult=1 m=1
bd_op1_1000_latch_late_hold d_op1_1000_latch_late_hold 0 v=v(rbl_op1_1000_latch_late_hold)-v(ref_op1_1000_latch_late_hold)

* ---- instance 34: op0_n100_latch_late_hold (variant latch_late_hold; probe dec 11.9 ns, release 36 ns, meas 38 ns) ----
vctl_op0_n100_latch_late_hold ctl_op0_n100_latch_late_hold 0 pwl(0.0000e+00 {VDD} 2.0000e-09 {VDD} 2.1000e-09 0)
vrs_op0_n100_latch_late_hold rwls_op0_n100_latch_late_hold 0 pwl(0.0000e+00 {VDD} 2.0000e-09 {VDD} 2.1000e-09 0 1.2000e-08 0 1.2100e-08 {VDD})
ven_op0_n100_latch_late_hold en_op0_n100_latch_late_hold 0 pwl(0.0000e+00 0 1.1000e-08 0 1.1100e-08 {VDD} 3.6000e-08 {VDD} 3.6100e-08 0)
venb_op0_n100_latch_late_hold enb_op0_n100_latch_late_hold 0 pwl(0.0000e+00 {VDD} 1.1000e-08 {VDD} 1.1100e-08 0 3.6000e-08 0 3.6100e-08 {VDD})
vww_op0_n100_latch_late_hold wwl_op0_n100_latch_late_hold 0 pwl(0.0000e+00 0 1.2000e-08 0 1.2100e-08 {VDD} 3.2000e-08 {VDD} 3.2100e-08 0)
vwc_op0_n100_latch_late_hold wbc_op0_n100_latch_late_hold 0 pwl(0.0000e+00 0 1.2000e-08 0 1.2100e-08 {VDD} 3.4000e-08 {VDD} 3.4100e-08 0)
swb_op0_n100_latch_late_hold ref_op0_n100_latch_late_hold wbl_op0_n100_latch_late_hold wbc_op0_n100_latch_late_hold 0 swwbl
cwbl_op0_n100_latch_late_hold wbl_op0_n100_latch_late_hold 0 {C_WBL}
spa_op0_n100_latch_late_hold prea rbl_op0_n100_latch_late_hold ctl_op0_n100_latch_late_hold 0 swpre
spr_op0_n100_latch_late_hold pref ref_op0_n100_latch_late_hold ctl_op0_n100_latch_late_hold 0 swpre
crbl_op0_n100_latch_late_hold rbl_op0_n100_latch_late_hold 0 {C_RBL}
cref_op0_n100_latch_late_hold ref_op0_n100_latch_late_hold 0 {C_RBL}   $ ASSUMPTION: ideal matched dummy load
XMWR_op0_n100_latch_late_hold_0 sn_op0_n100_latch_late_hold_0 wwl_op0_n100_latch_late_hold wbl_op0_n100_latch_late_hold 0 sky130_fd_pr__nfet_01v8 L=0.15 W=0.42 nf=1 ad=0.1218 as=0.1218 pd=1.42 ps=1.42 nrd=0.69047619047619  nrs=0.69047619047619 sa=0 sb=0 sd=0 mult=1 m=1
XMRD_op0_n100_latch_late_hold_0 rbl_op0_n100_latch_late_hold sn_op0_n100_latch_late_hold_0 rwls_op0_n100_latch_late_hold 0 sky130_fd_pr__nfet_01v8 L=0.15 W=0.42 nf=1 ad=0.1218 as=0.1218 pd=1.42 ps=1.42 nrd=0.69047619047619  nrs=0.69047619047619 sa=0 sb=0 sd=0 mult=1 m=1
csn_op0_n100_latch_late_hold_0 sn_op0_n100_latch_late_hold_0 0 {C_SN}
XMWR_op0_n100_latch_late_hold_1 sn_op0_n100_latch_late_hold_1 wwl_des wbl_op0_n100_latch_late_hold 0 sky130_fd_pr__nfet_01v8 L=0.15 W=0.42 nf=1 ad=0.1218 as=0.1218 pd=1.42 ps=1.42 nrd=0.69047619047619  nrs=0.69047619047619 sa=0 sb=0 sd=0 mult=1 m=1
XMRD_op0_n100_latch_late_hold_1 rbl_op0_n100_latch_late_hold sn_op0_n100_latch_late_hold_1 rwl_des 0 sky130_fd_pr__nfet_01v8 L=0.15 W=0.42 nf=1 ad=0.1218 as=0.1218 pd=1.42 ps=1.42 nrd=0.69047619047619  nrs=0.69047619047619 sa=0 sb=0 sd=0 mult=1 m=1
csn_op0_n100_latch_late_hold_1 sn_op0_n100_latch_late_hold_1 0 {C_SN}
XMWR_op0_n100_latch_late_hold_2 sn_op0_n100_latch_late_hold_2 wwl_des wbl_op0_n100_latch_late_hold 0 sky130_fd_pr__nfet_01v8 L=0.15 W=0.42 nf=1 ad=0.1218 as=0.1218 pd=1.42 ps=1.42 nrd=0.69047619047619  nrs=0.69047619047619 sa=0 sb=0 sd=0 mult=1 m=1
XMRD_op0_n100_latch_late_hold_2 rbl_op0_n100_latch_late_hold sn_op0_n100_latch_late_hold_2 rwl_des 0 sky130_fd_pr__nfet_01v8 L=0.15 W=0.42 nf=1 ad=0.1218 as=0.1218 pd=1.42 ps=1.42 nrd=0.69047619047619  nrs=0.69047619047619 sa=0 sb=0 sd=0 mult=1 m=1
csn_op0_n100_latch_late_hold_2 sn_op0_n100_latch_late_hold_2 0 {C_SN}
XMWR_op0_n100_latch_late_hold_3 sn_op0_n100_latch_late_hold_3 wwl_des wbl_op0_n100_latch_late_hold 0 sky130_fd_pr__nfet_01v8 L=0.15 W=0.42 nf=1 ad=0.1218 as=0.1218 pd=1.42 ps=1.42 nrd=0.69047619047619  nrs=0.69047619047619 sa=0 sb=0 sd=0 mult=1 m=1
XMRD_op0_n100_latch_late_hold_3 rbl_op0_n100_latch_late_hold sn_op0_n100_latch_late_hold_3 rwl_des 0 sky130_fd_pr__nfet_01v8 L=0.15 W=0.42 nf=1 ad=0.1218 as=0.1218 pd=1.42 ps=1.42 nrd=0.69047619047619  nrs=0.69047619047619 sa=0 sb=0 sd=0 mult=1 m=1
csn_op0_n100_latch_late_hold_3 sn_op0_n100_latch_late_hold_3 0 {C_SN}
XMN1_op0_n100_latch_late_hold rbl_op0_n100_latch_late_hold ref_op0_n100_latch_late_hold vn_op0_n100_latch_late_hold 0 sky130_fd_pr__nfet_01v8 L=0.15 W=1 nf=1 ad=0.29 as=0.29 pd=2.58 ps=2.58 mult=1 m=1
XMN2_op0_n100_latch_late_hold ref_op0_n100_latch_late_hold rbl_op0_n100_latch_late_hold vn_op0_n100_latch_late_hold 0 sky130_fd_pr__nfet_01v8 L=0.15 W=1 nf=1 ad=0.29 as=0.29 pd=2.58 ps=2.58 mult=1 m=1
XMP1_op0_n100_latch_late_hold rbl_op0_n100_latch_late_hold ref_op0_n100_latch_late_hold vp_op0_n100_latch_late_hold vdd sky130_fd_pr__pfet_01v8 L=0.15 W=2 nf=1 ad=0.58 as=0.58 pd=4.58 ps=4.58 mult=1 m=1
XMP2_op0_n100_latch_late_hold ref_op0_n100_latch_late_hold rbl_op0_n100_latch_late_hold vp_op0_n100_latch_late_hold vdd sky130_fd_pr__pfet_01v8 L=0.15 W=2 nf=1 ad=0.58 as=0.58 pd=4.58 ps=4.58 mult=1 m=1
XMNF_op0_n100_latch_late_hold vn_op0_n100_latch_late_hold en_op0_n100_latch_late_hold 0 0 sky130_fd_pr__nfet_01v8 L=0.15 W=2 nf=1 ad=0.58 as=0.58 pd=4.58 ps=4.58 mult=1 m=1
XMPH_op0_n100_latch_late_hold vp_op0_n100_latch_late_hold enb_op0_n100_latch_late_hold vdd vdd sky130_fd_pr__pfet_01v8 L=0.15 W=4 nf=1 ad=1.16 as=1.16 pd=8.58 ps=8.58 mult=1 m=1
bd_op0_n100_latch_late_hold d_op0_n100_latch_late_hold 0 v=v(rbl_op0_n100_latch_late_hold)-v(ref_op0_n100_latch_late_hold)

* ---- instance 35: op0_0000_latch_late_hold (variant latch_late_hold; probe dec 11.9 ns, release 36 ns, meas 38 ns) ----
vctl_op0_0000_latch_late_hold ctl_op0_0000_latch_late_hold 0 pwl(0.0000e+00 {VDD} 2.0000e-09 {VDD} 2.1000e-09 0)
vrs_op0_0000_latch_late_hold rwls_op0_0000_latch_late_hold 0 pwl(0.0000e+00 {VDD} 2.0000e-09 {VDD} 2.1000e-09 0 1.2000e-08 0 1.2100e-08 {VDD})
ven_op0_0000_latch_late_hold en_op0_0000_latch_late_hold 0 pwl(0.0000e+00 0 1.1000e-08 0 1.1100e-08 {VDD} 3.6000e-08 {VDD} 3.6100e-08 0)
venb_op0_0000_latch_late_hold enb_op0_0000_latch_late_hold 0 pwl(0.0000e+00 {VDD} 1.1000e-08 {VDD} 1.1100e-08 0 3.6000e-08 0 3.6100e-08 {VDD})
vww_op0_0000_latch_late_hold wwl_op0_0000_latch_late_hold 0 pwl(0.0000e+00 0 1.2000e-08 0 1.2100e-08 {VDD} 3.2000e-08 {VDD} 3.2100e-08 0)
vwc_op0_0000_latch_late_hold wbc_op0_0000_latch_late_hold 0 pwl(0.0000e+00 0 1.2000e-08 0 1.2100e-08 {VDD} 3.4000e-08 {VDD} 3.4100e-08 0)
swb_op0_0000_latch_late_hold ref_op0_0000_latch_late_hold wbl_op0_0000_latch_late_hold wbc_op0_0000_latch_late_hold 0 swwbl
cwbl_op0_0000_latch_late_hold wbl_op0_0000_latch_late_hold 0 {C_WBL}
spa_op0_0000_latch_late_hold prea rbl_op0_0000_latch_late_hold ctl_op0_0000_latch_late_hold 0 swpre
spr_op0_0000_latch_late_hold pref ref_op0_0000_latch_late_hold ctl_op0_0000_latch_late_hold 0 swpre
crbl_op0_0000_latch_late_hold rbl_op0_0000_latch_late_hold 0 {C_RBL}
cref_op0_0000_latch_late_hold ref_op0_0000_latch_late_hold 0 {C_RBL}   $ ASSUMPTION: ideal matched dummy load
XMWR_op0_0000_latch_late_hold_0 sn_op0_0000_latch_late_hold_0 wwl_op0_0000_latch_late_hold wbl_op0_0000_latch_late_hold 0 sky130_fd_pr__nfet_01v8 L=0.15 W=0.42 nf=1 ad=0.1218 as=0.1218 pd=1.42 ps=1.42 nrd=0.69047619047619  nrs=0.69047619047619 sa=0 sb=0 sd=0 mult=1 m=1
XMRD_op0_0000_latch_late_hold_0 rbl_op0_0000_latch_late_hold sn_op0_0000_latch_late_hold_0 rwls_op0_0000_latch_late_hold 0 sky130_fd_pr__nfet_01v8 L=0.15 W=0.42 nf=1 ad=0.1218 as=0.1218 pd=1.42 ps=1.42 nrd=0.69047619047619  nrs=0.69047619047619 sa=0 sb=0 sd=0 mult=1 m=1
csn_op0_0000_latch_late_hold_0 sn_op0_0000_latch_late_hold_0 0 {C_SN}
XMWR_op0_0000_latch_late_hold_1 sn_op0_0000_latch_late_hold_1 wwl_des wbl_op0_0000_latch_late_hold 0 sky130_fd_pr__nfet_01v8 L=0.15 W=0.42 nf=1 ad=0.1218 as=0.1218 pd=1.42 ps=1.42 nrd=0.69047619047619  nrs=0.69047619047619 sa=0 sb=0 sd=0 mult=1 m=1
XMRD_op0_0000_latch_late_hold_1 rbl_op0_0000_latch_late_hold sn_op0_0000_latch_late_hold_1 rwl_des 0 sky130_fd_pr__nfet_01v8 L=0.15 W=0.42 nf=1 ad=0.1218 as=0.1218 pd=1.42 ps=1.42 nrd=0.69047619047619  nrs=0.69047619047619 sa=0 sb=0 sd=0 mult=1 m=1
csn_op0_0000_latch_late_hold_1 sn_op0_0000_latch_late_hold_1 0 {C_SN}
XMWR_op0_0000_latch_late_hold_2 sn_op0_0000_latch_late_hold_2 wwl_des wbl_op0_0000_latch_late_hold 0 sky130_fd_pr__nfet_01v8 L=0.15 W=0.42 nf=1 ad=0.1218 as=0.1218 pd=1.42 ps=1.42 nrd=0.69047619047619  nrs=0.69047619047619 sa=0 sb=0 sd=0 mult=1 m=1
XMRD_op0_0000_latch_late_hold_2 rbl_op0_0000_latch_late_hold sn_op0_0000_latch_late_hold_2 rwl_des 0 sky130_fd_pr__nfet_01v8 L=0.15 W=0.42 nf=1 ad=0.1218 as=0.1218 pd=1.42 ps=1.42 nrd=0.69047619047619  nrs=0.69047619047619 sa=0 sb=0 sd=0 mult=1 m=1
csn_op0_0000_latch_late_hold_2 sn_op0_0000_latch_late_hold_2 0 {C_SN}
XMWR_op0_0000_latch_late_hold_3 sn_op0_0000_latch_late_hold_3 wwl_des wbl_op0_0000_latch_late_hold 0 sky130_fd_pr__nfet_01v8 L=0.15 W=0.42 nf=1 ad=0.1218 as=0.1218 pd=1.42 ps=1.42 nrd=0.69047619047619  nrs=0.69047619047619 sa=0 sb=0 sd=0 mult=1 m=1
XMRD_op0_0000_latch_late_hold_3 rbl_op0_0000_latch_late_hold sn_op0_0000_latch_late_hold_3 rwl_des 0 sky130_fd_pr__nfet_01v8 L=0.15 W=0.42 nf=1 ad=0.1218 as=0.1218 pd=1.42 ps=1.42 nrd=0.69047619047619  nrs=0.69047619047619 sa=0 sb=0 sd=0 mult=1 m=1
csn_op0_0000_latch_late_hold_3 sn_op0_0000_latch_late_hold_3 0 {C_SN}
XMN1_op0_0000_latch_late_hold rbl_op0_0000_latch_late_hold ref_op0_0000_latch_late_hold vn_op0_0000_latch_late_hold 0 sky130_fd_pr__nfet_01v8 L=0.15 W=1 nf=1 ad=0.29 as=0.29 pd=2.58 ps=2.58 mult=1 m=1
XMN2_op0_0000_latch_late_hold ref_op0_0000_latch_late_hold rbl_op0_0000_latch_late_hold vn_op0_0000_latch_late_hold 0 sky130_fd_pr__nfet_01v8 L=0.15 W=1 nf=1 ad=0.29 as=0.29 pd=2.58 ps=2.58 mult=1 m=1
XMP1_op0_0000_latch_late_hold rbl_op0_0000_latch_late_hold ref_op0_0000_latch_late_hold vp_op0_0000_latch_late_hold vdd sky130_fd_pr__pfet_01v8 L=0.15 W=2 nf=1 ad=0.58 as=0.58 pd=4.58 ps=4.58 mult=1 m=1
XMP2_op0_0000_latch_late_hold ref_op0_0000_latch_late_hold rbl_op0_0000_latch_late_hold vp_op0_0000_latch_late_hold vdd sky130_fd_pr__pfet_01v8 L=0.15 W=2 nf=1 ad=0.58 as=0.58 pd=4.58 ps=4.58 mult=1 m=1
XMNF_op0_0000_latch_late_hold vn_op0_0000_latch_late_hold en_op0_0000_latch_late_hold 0 0 sky130_fd_pr__nfet_01v8 L=0.15 W=2 nf=1 ad=0.58 as=0.58 pd=4.58 ps=4.58 mult=1 m=1
XMPH_op0_0000_latch_late_hold vp_op0_0000_latch_late_hold enb_op0_0000_latch_late_hold vdd vdd sky130_fd_pr__pfet_01v8 L=0.15 W=4 nf=1 ad=1.16 as=1.16 pd=8.58 ps=8.58 mult=1 m=1
bd_op0_0000_latch_late_hold d_op0_0000_latch_late_hold 0 v=v(rbl_op0_0000_latch_late_hold)-v(ref_op0_0000_latch_late_hold)

* ---- instance 36: op1_0900_combined_hold (variant combined_hold; probe dec 11.9 ns, release 36 ns, meas 38 ns) ----
vctl_op1_0900_combined_hold ctl_op1_0900_combined_hold 0 pwl(0.0000e+00 {VDD} 2.0000e-09 {VDD} 2.1000e-09 0)
vrs_op1_0900_combined_hold rwls_op1_0900_combined_hold 0 pwl(0.0000e+00 {VDD} 2.0000e-09 {VDD} 2.1000e-09 0 3.4000e-08 0 3.4100e-08 {VDD})
ven_op1_0900_combined_hold en_op1_0900_combined_hold 0 pwl(0.0000e+00 0 1.1000e-08 0 1.1100e-08 {VDD} 3.6000e-08 {VDD} 3.6100e-08 0)
venb_op1_0900_combined_hold enb_op1_0900_combined_hold 0 pwl(0.0000e+00 {VDD} 1.1000e-08 {VDD} 1.1100e-08 0 3.6000e-08 0 3.6100e-08 {VDD})
vww_op1_0900_combined_hold wwl_op1_0900_combined_hold 0 pwl(0.0000e+00 0 1.2000e-08 0 1.2100e-08 {VDD} 3.2000e-08 {VDD} 3.2100e-08 0)
vwc_op1_0900_combined_hold wbc_op1_0900_combined_hold 0 pwl(0.0000e+00 0 1.2000e-08 0 1.2100e-08 {VDD} 3.4000e-08 {VDD} 3.4100e-08 0)
swb_op1_0900_combined_hold ref_op1_0900_combined_hold wbl_op1_0900_combined_hold wbc_op1_0900_combined_hold 0 swwbl
cwbl_op1_0900_combined_hold wbl_op1_0900_combined_hold 0 {C_WBL}
spa_op1_0900_combined_hold prea rbl_op1_0900_combined_hold ctl_op1_0900_combined_hold 0 swpre
spr_op1_0900_combined_hold pref ref_op1_0900_combined_hold ctl_op1_0900_combined_hold 0 swpre
crbl_op1_0900_combined_hold rbl_op1_0900_combined_hold 0 {C_RBL}
cref_op1_0900_combined_hold ref_op1_0900_combined_hold 0 {C_RBL}   $ ASSUMPTION: ideal matched dummy load
XMWR_op1_0900_combined_hold_0 sn_op1_0900_combined_hold_0 wwl_op1_0900_combined_hold wbl_op1_0900_combined_hold 0 sky130_fd_pr__nfet_01v8 L=0.15 W=0.42 nf=1 ad=0.1218 as=0.1218 pd=1.42 ps=1.42 nrd=0.69047619047619  nrs=0.69047619047619 sa=0 sb=0 sd=0 mult=1 m=1
XMRD_op1_0900_combined_hold_0 rbl_op1_0900_combined_hold sn_op1_0900_combined_hold_0 rwls_op1_0900_combined_hold 0 sky130_fd_pr__nfet_01v8 L=0.15 W=0.42 nf=1 ad=0.1218 as=0.1218 pd=1.42 ps=1.42 nrd=0.69047619047619  nrs=0.69047619047619 sa=0 sb=0 sd=0 mult=1 m=1
csn_op1_0900_combined_hold_0 sn_op1_0900_combined_hold_0 0 {C_SN}
XMWR_op1_0900_combined_hold_1 sn_op1_0900_combined_hold_1 wwl_des wbl_op1_0900_combined_hold 0 sky130_fd_pr__nfet_01v8 L=0.15 W=0.42 nf=1 ad=0.1218 as=0.1218 pd=1.42 ps=1.42 nrd=0.69047619047619  nrs=0.69047619047619 sa=0 sb=0 sd=0 mult=1 m=1
XMRD_op1_0900_combined_hold_1 rbl_op1_0900_combined_hold sn_op1_0900_combined_hold_1 rwl_des 0 sky130_fd_pr__nfet_01v8 L=0.15 W=0.42 nf=1 ad=0.1218 as=0.1218 pd=1.42 ps=1.42 nrd=0.69047619047619  nrs=0.69047619047619 sa=0 sb=0 sd=0 mult=1 m=1
csn_op1_0900_combined_hold_1 sn_op1_0900_combined_hold_1 0 {C_SN}
XMWR_op1_0900_combined_hold_2 sn_op1_0900_combined_hold_2 wwl_des wbl_op1_0900_combined_hold 0 sky130_fd_pr__nfet_01v8 L=0.15 W=0.42 nf=1 ad=0.1218 as=0.1218 pd=1.42 ps=1.42 nrd=0.69047619047619  nrs=0.69047619047619 sa=0 sb=0 sd=0 mult=1 m=1
XMRD_op1_0900_combined_hold_2 rbl_op1_0900_combined_hold sn_op1_0900_combined_hold_2 rwl_des 0 sky130_fd_pr__nfet_01v8 L=0.15 W=0.42 nf=1 ad=0.1218 as=0.1218 pd=1.42 ps=1.42 nrd=0.69047619047619  nrs=0.69047619047619 sa=0 sb=0 sd=0 mult=1 m=1
csn_op1_0900_combined_hold_2 sn_op1_0900_combined_hold_2 0 {C_SN}
XMWR_op1_0900_combined_hold_3 sn_op1_0900_combined_hold_3 wwl_des wbl_op1_0900_combined_hold 0 sky130_fd_pr__nfet_01v8 L=0.15 W=0.42 nf=1 ad=0.1218 as=0.1218 pd=1.42 ps=1.42 nrd=0.69047619047619  nrs=0.69047619047619 sa=0 sb=0 sd=0 mult=1 m=1
XMRD_op1_0900_combined_hold_3 rbl_op1_0900_combined_hold sn_op1_0900_combined_hold_3 rwl_des 0 sky130_fd_pr__nfet_01v8 L=0.15 W=0.42 nf=1 ad=0.1218 as=0.1218 pd=1.42 ps=1.42 nrd=0.69047619047619  nrs=0.69047619047619 sa=0 sb=0 sd=0 mult=1 m=1
csn_op1_0900_combined_hold_3 sn_op1_0900_combined_hold_3 0 {C_SN}
XMN1_op1_0900_combined_hold rbl_op1_0900_combined_hold ref_op1_0900_combined_hold vn_op1_0900_combined_hold 0 sky130_fd_pr__nfet_01v8 L=0.15 W=1 nf=1 ad=0.29 as=0.29 pd=2.58 ps=2.58 mult=1 m=1
XMN2_op1_0900_combined_hold ref_op1_0900_combined_hold rbl_op1_0900_combined_hold vn_op1_0900_combined_hold 0 sky130_fd_pr__nfet_01v8 L=0.15 W=1 nf=1 ad=0.29 as=0.29 pd=2.58 ps=2.58 mult=1 m=1
XMP1_op1_0900_combined_hold rbl_op1_0900_combined_hold ref_op1_0900_combined_hold vp_op1_0900_combined_hold vdd sky130_fd_pr__pfet_01v8 L=0.15 W=2 nf=1 ad=0.58 as=0.58 pd=4.58 ps=4.58 mult=1 m=1
XMP2_op1_0900_combined_hold ref_op1_0900_combined_hold rbl_op1_0900_combined_hold vp_op1_0900_combined_hold vdd sky130_fd_pr__pfet_01v8 L=0.15 W=2 nf=1 ad=0.58 as=0.58 pd=4.58 ps=4.58 mult=1 m=1
XMNF_op1_0900_combined_hold vn_op1_0900_combined_hold en_op1_0900_combined_hold 0 0 sky130_fd_pr__nfet_01v8 L=0.15 W=2 nf=1 ad=0.58 as=0.58 pd=4.58 ps=4.58 mult=1 m=1
XMPH_op1_0900_combined_hold vp_op1_0900_combined_hold enb_op1_0900_combined_hold vdd vdd sky130_fd_pr__pfet_01v8 L=0.15 W=4 nf=1 ad=1.16 as=1.16 pd=8.58 ps=8.58 mult=1 m=1
bd_op1_0900_combined_hold d_op1_0900_combined_hold 0 v=v(rbl_op1_0900_combined_hold)-v(ref_op1_0900_combined_hold)

* ---- instance 37: op1_1000_combined_hold (variant combined_hold; probe dec 11.9 ns, release 36 ns, meas 38 ns) ----
vctl_op1_1000_combined_hold ctl_op1_1000_combined_hold 0 pwl(0.0000e+00 {VDD} 2.0000e-09 {VDD} 2.1000e-09 0)
vrs_op1_1000_combined_hold rwls_op1_1000_combined_hold 0 pwl(0.0000e+00 {VDD} 2.0000e-09 {VDD} 2.1000e-09 0 3.4000e-08 0 3.4100e-08 {VDD})
ven_op1_1000_combined_hold en_op1_1000_combined_hold 0 pwl(0.0000e+00 0 1.1000e-08 0 1.1100e-08 {VDD} 3.6000e-08 {VDD} 3.6100e-08 0)
venb_op1_1000_combined_hold enb_op1_1000_combined_hold 0 pwl(0.0000e+00 {VDD} 1.1000e-08 {VDD} 1.1100e-08 0 3.6000e-08 0 3.6100e-08 {VDD})
vww_op1_1000_combined_hold wwl_op1_1000_combined_hold 0 pwl(0.0000e+00 0 1.2000e-08 0 1.2100e-08 {VDD} 3.2000e-08 {VDD} 3.2100e-08 0)
vwc_op1_1000_combined_hold wbc_op1_1000_combined_hold 0 pwl(0.0000e+00 0 1.2000e-08 0 1.2100e-08 {VDD} 3.4000e-08 {VDD} 3.4100e-08 0)
swb_op1_1000_combined_hold ref_op1_1000_combined_hold wbl_op1_1000_combined_hold wbc_op1_1000_combined_hold 0 swwbl
cwbl_op1_1000_combined_hold wbl_op1_1000_combined_hold 0 {C_WBL}
spa_op1_1000_combined_hold prea rbl_op1_1000_combined_hold ctl_op1_1000_combined_hold 0 swpre
spr_op1_1000_combined_hold pref ref_op1_1000_combined_hold ctl_op1_1000_combined_hold 0 swpre
crbl_op1_1000_combined_hold rbl_op1_1000_combined_hold 0 {C_RBL}
cref_op1_1000_combined_hold ref_op1_1000_combined_hold 0 {C_RBL}   $ ASSUMPTION: ideal matched dummy load
XMWR_op1_1000_combined_hold_0 sn_op1_1000_combined_hold_0 wwl_op1_1000_combined_hold wbl_op1_1000_combined_hold 0 sky130_fd_pr__nfet_01v8 L=0.15 W=0.42 nf=1 ad=0.1218 as=0.1218 pd=1.42 ps=1.42 nrd=0.69047619047619  nrs=0.69047619047619 sa=0 sb=0 sd=0 mult=1 m=1
XMRD_op1_1000_combined_hold_0 rbl_op1_1000_combined_hold sn_op1_1000_combined_hold_0 rwls_op1_1000_combined_hold 0 sky130_fd_pr__nfet_01v8 L=0.15 W=0.42 nf=1 ad=0.1218 as=0.1218 pd=1.42 ps=1.42 nrd=0.69047619047619  nrs=0.69047619047619 sa=0 sb=0 sd=0 mult=1 m=1
csn_op1_1000_combined_hold_0 sn_op1_1000_combined_hold_0 0 {C_SN}
XMWR_op1_1000_combined_hold_1 sn_op1_1000_combined_hold_1 wwl_des wbl_op1_1000_combined_hold 0 sky130_fd_pr__nfet_01v8 L=0.15 W=0.42 nf=1 ad=0.1218 as=0.1218 pd=1.42 ps=1.42 nrd=0.69047619047619  nrs=0.69047619047619 sa=0 sb=0 sd=0 mult=1 m=1
XMRD_op1_1000_combined_hold_1 rbl_op1_1000_combined_hold sn_op1_1000_combined_hold_1 rwl_des 0 sky130_fd_pr__nfet_01v8 L=0.15 W=0.42 nf=1 ad=0.1218 as=0.1218 pd=1.42 ps=1.42 nrd=0.69047619047619  nrs=0.69047619047619 sa=0 sb=0 sd=0 mult=1 m=1
csn_op1_1000_combined_hold_1 sn_op1_1000_combined_hold_1 0 {C_SN}
XMWR_op1_1000_combined_hold_2 sn_op1_1000_combined_hold_2 wwl_des wbl_op1_1000_combined_hold 0 sky130_fd_pr__nfet_01v8 L=0.15 W=0.42 nf=1 ad=0.1218 as=0.1218 pd=1.42 ps=1.42 nrd=0.69047619047619  nrs=0.69047619047619 sa=0 sb=0 sd=0 mult=1 m=1
XMRD_op1_1000_combined_hold_2 rbl_op1_1000_combined_hold sn_op1_1000_combined_hold_2 rwl_des 0 sky130_fd_pr__nfet_01v8 L=0.15 W=0.42 nf=1 ad=0.1218 as=0.1218 pd=1.42 ps=1.42 nrd=0.69047619047619  nrs=0.69047619047619 sa=0 sb=0 sd=0 mult=1 m=1
csn_op1_1000_combined_hold_2 sn_op1_1000_combined_hold_2 0 {C_SN}
XMWR_op1_1000_combined_hold_3 sn_op1_1000_combined_hold_3 wwl_des wbl_op1_1000_combined_hold 0 sky130_fd_pr__nfet_01v8 L=0.15 W=0.42 nf=1 ad=0.1218 as=0.1218 pd=1.42 ps=1.42 nrd=0.69047619047619  nrs=0.69047619047619 sa=0 sb=0 sd=0 mult=1 m=1
XMRD_op1_1000_combined_hold_3 rbl_op1_1000_combined_hold sn_op1_1000_combined_hold_3 rwl_des 0 sky130_fd_pr__nfet_01v8 L=0.15 W=0.42 nf=1 ad=0.1218 as=0.1218 pd=1.42 ps=1.42 nrd=0.69047619047619  nrs=0.69047619047619 sa=0 sb=0 sd=0 mult=1 m=1
csn_op1_1000_combined_hold_3 sn_op1_1000_combined_hold_3 0 {C_SN}
XMN1_op1_1000_combined_hold rbl_op1_1000_combined_hold ref_op1_1000_combined_hold vn_op1_1000_combined_hold 0 sky130_fd_pr__nfet_01v8 L=0.15 W=1 nf=1 ad=0.29 as=0.29 pd=2.58 ps=2.58 mult=1 m=1
XMN2_op1_1000_combined_hold ref_op1_1000_combined_hold rbl_op1_1000_combined_hold vn_op1_1000_combined_hold 0 sky130_fd_pr__nfet_01v8 L=0.15 W=1 nf=1 ad=0.29 as=0.29 pd=2.58 ps=2.58 mult=1 m=1
XMP1_op1_1000_combined_hold rbl_op1_1000_combined_hold ref_op1_1000_combined_hold vp_op1_1000_combined_hold vdd sky130_fd_pr__pfet_01v8 L=0.15 W=2 nf=1 ad=0.58 as=0.58 pd=4.58 ps=4.58 mult=1 m=1
XMP2_op1_1000_combined_hold ref_op1_1000_combined_hold rbl_op1_1000_combined_hold vp_op1_1000_combined_hold vdd sky130_fd_pr__pfet_01v8 L=0.15 W=2 nf=1 ad=0.58 as=0.58 pd=4.58 ps=4.58 mult=1 m=1
XMNF_op1_1000_combined_hold vn_op1_1000_combined_hold en_op1_1000_combined_hold 0 0 sky130_fd_pr__nfet_01v8 L=0.15 W=2 nf=1 ad=0.58 as=0.58 pd=4.58 ps=4.58 mult=1 m=1
XMPH_op1_1000_combined_hold vp_op1_1000_combined_hold enb_op1_1000_combined_hold vdd vdd sky130_fd_pr__pfet_01v8 L=0.15 W=4 nf=1 ad=1.16 as=1.16 pd=8.58 ps=8.58 mult=1 m=1
bd_op1_1000_combined_hold d_op1_1000_combined_hold 0 v=v(rbl_op1_1000_combined_hold)-v(ref_op1_1000_combined_hold)

* ---- instance 38: op0_n100_combined_hold (variant combined_hold; probe dec 11.9 ns, release 36 ns, meas 38 ns) ----
vctl_op0_n100_combined_hold ctl_op0_n100_combined_hold 0 pwl(0.0000e+00 {VDD} 2.0000e-09 {VDD} 2.1000e-09 0)
vrs_op0_n100_combined_hold rwls_op0_n100_combined_hold 0 pwl(0.0000e+00 {VDD} 2.0000e-09 {VDD} 2.1000e-09 0 3.4000e-08 0 3.4100e-08 {VDD})
ven_op0_n100_combined_hold en_op0_n100_combined_hold 0 pwl(0.0000e+00 0 1.1000e-08 0 1.1100e-08 {VDD} 3.6000e-08 {VDD} 3.6100e-08 0)
venb_op0_n100_combined_hold enb_op0_n100_combined_hold 0 pwl(0.0000e+00 {VDD} 1.1000e-08 {VDD} 1.1100e-08 0 3.6000e-08 0 3.6100e-08 {VDD})
vww_op0_n100_combined_hold wwl_op0_n100_combined_hold 0 pwl(0.0000e+00 0 1.2000e-08 0 1.2100e-08 {VDD} 3.2000e-08 {VDD} 3.2100e-08 0)
vwc_op0_n100_combined_hold wbc_op0_n100_combined_hold 0 pwl(0.0000e+00 0 1.2000e-08 0 1.2100e-08 {VDD} 3.4000e-08 {VDD} 3.4100e-08 0)
swb_op0_n100_combined_hold ref_op0_n100_combined_hold wbl_op0_n100_combined_hold wbc_op0_n100_combined_hold 0 swwbl
cwbl_op0_n100_combined_hold wbl_op0_n100_combined_hold 0 {C_WBL}
spa_op0_n100_combined_hold prea rbl_op0_n100_combined_hold ctl_op0_n100_combined_hold 0 swpre
spr_op0_n100_combined_hold pref ref_op0_n100_combined_hold ctl_op0_n100_combined_hold 0 swpre
crbl_op0_n100_combined_hold rbl_op0_n100_combined_hold 0 {C_RBL}
cref_op0_n100_combined_hold ref_op0_n100_combined_hold 0 {C_RBL}   $ ASSUMPTION: ideal matched dummy load
XMWR_op0_n100_combined_hold_0 sn_op0_n100_combined_hold_0 wwl_op0_n100_combined_hold wbl_op0_n100_combined_hold 0 sky130_fd_pr__nfet_01v8 L=0.15 W=0.42 nf=1 ad=0.1218 as=0.1218 pd=1.42 ps=1.42 nrd=0.69047619047619  nrs=0.69047619047619 sa=0 sb=0 sd=0 mult=1 m=1
XMRD_op0_n100_combined_hold_0 rbl_op0_n100_combined_hold sn_op0_n100_combined_hold_0 rwls_op0_n100_combined_hold 0 sky130_fd_pr__nfet_01v8 L=0.15 W=0.42 nf=1 ad=0.1218 as=0.1218 pd=1.42 ps=1.42 nrd=0.69047619047619  nrs=0.69047619047619 sa=0 sb=0 sd=0 mult=1 m=1
csn_op0_n100_combined_hold_0 sn_op0_n100_combined_hold_0 0 {C_SN}
XMWR_op0_n100_combined_hold_1 sn_op0_n100_combined_hold_1 wwl_des wbl_op0_n100_combined_hold 0 sky130_fd_pr__nfet_01v8 L=0.15 W=0.42 nf=1 ad=0.1218 as=0.1218 pd=1.42 ps=1.42 nrd=0.69047619047619  nrs=0.69047619047619 sa=0 sb=0 sd=0 mult=1 m=1
XMRD_op0_n100_combined_hold_1 rbl_op0_n100_combined_hold sn_op0_n100_combined_hold_1 rwl_des 0 sky130_fd_pr__nfet_01v8 L=0.15 W=0.42 nf=1 ad=0.1218 as=0.1218 pd=1.42 ps=1.42 nrd=0.69047619047619  nrs=0.69047619047619 sa=0 sb=0 sd=0 mult=1 m=1
csn_op0_n100_combined_hold_1 sn_op0_n100_combined_hold_1 0 {C_SN}
XMWR_op0_n100_combined_hold_2 sn_op0_n100_combined_hold_2 wwl_des wbl_op0_n100_combined_hold 0 sky130_fd_pr__nfet_01v8 L=0.15 W=0.42 nf=1 ad=0.1218 as=0.1218 pd=1.42 ps=1.42 nrd=0.69047619047619  nrs=0.69047619047619 sa=0 sb=0 sd=0 mult=1 m=1
XMRD_op0_n100_combined_hold_2 rbl_op0_n100_combined_hold sn_op0_n100_combined_hold_2 rwl_des 0 sky130_fd_pr__nfet_01v8 L=0.15 W=0.42 nf=1 ad=0.1218 as=0.1218 pd=1.42 ps=1.42 nrd=0.69047619047619  nrs=0.69047619047619 sa=0 sb=0 sd=0 mult=1 m=1
csn_op0_n100_combined_hold_2 sn_op0_n100_combined_hold_2 0 {C_SN}
XMWR_op0_n100_combined_hold_3 sn_op0_n100_combined_hold_3 wwl_des wbl_op0_n100_combined_hold 0 sky130_fd_pr__nfet_01v8 L=0.15 W=0.42 nf=1 ad=0.1218 as=0.1218 pd=1.42 ps=1.42 nrd=0.69047619047619  nrs=0.69047619047619 sa=0 sb=0 sd=0 mult=1 m=1
XMRD_op0_n100_combined_hold_3 rbl_op0_n100_combined_hold sn_op0_n100_combined_hold_3 rwl_des 0 sky130_fd_pr__nfet_01v8 L=0.15 W=0.42 nf=1 ad=0.1218 as=0.1218 pd=1.42 ps=1.42 nrd=0.69047619047619  nrs=0.69047619047619 sa=0 sb=0 sd=0 mult=1 m=1
csn_op0_n100_combined_hold_3 sn_op0_n100_combined_hold_3 0 {C_SN}
XMN1_op0_n100_combined_hold rbl_op0_n100_combined_hold ref_op0_n100_combined_hold vn_op0_n100_combined_hold 0 sky130_fd_pr__nfet_01v8 L=0.15 W=1 nf=1 ad=0.29 as=0.29 pd=2.58 ps=2.58 mult=1 m=1
XMN2_op0_n100_combined_hold ref_op0_n100_combined_hold rbl_op0_n100_combined_hold vn_op0_n100_combined_hold 0 sky130_fd_pr__nfet_01v8 L=0.15 W=1 nf=1 ad=0.29 as=0.29 pd=2.58 ps=2.58 mult=1 m=1
XMP1_op0_n100_combined_hold rbl_op0_n100_combined_hold ref_op0_n100_combined_hold vp_op0_n100_combined_hold vdd sky130_fd_pr__pfet_01v8 L=0.15 W=2 nf=1 ad=0.58 as=0.58 pd=4.58 ps=4.58 mult=1 m=1
XMP2_op0_n100_combined_hold ref_op0_n100_combined_hold rbl_op0_n100_combined_hold vp_op0_n100_combined_hold vdd sky130_fd_pr__pfet_01v8 L=0.15 W=2 nf=1 ad=0.58 as=0.58 pd=4.58 ps=4.58 mult=1 m=1
XMNF_op0_n100_combined_hold vn_op0_n100_combined_hold en_op0_n100_combined_hold 0 0 sky130_fd_pr__nfet_01v8 L=0.15 W=2 nf=1 ad=0.58 as=0.58 pd=4.58 ps=4.58 mult=1 m=1
XMPH_op0_n100_combined_hold vp_op0_n100_combined_hold enb_op0_n100_combined_hold vdd vdd sky130_fd_pr__pfet_01v8 L=0.15 W=4 nf=1 ad=1.16 as=1.16 pd=8.58 ps=8.58 mult=1 m=1
bd_op0_n100_combined_hold d_op0_n100_combined_hold 0 v=v(rbl_op0_n100_combined_hold)-v(ref_op0_n100_combined_hold)

* ---- instance 39: op0_0000_combined_hold (variant combined_hold; probe dec 11.9 ns, release 36 ns, meas 38 ns) ----
vctl_op0_0000_combined_hold ctl_op0_0000_combined_hold 0 pwl(0.0000e+00 {VDD} 2.0000e-09 {VDD} 2.1000e-09 0)
vrs_op0_0000_combined_hold rwls_op0_0000_combined_hold 0 pwl(0.0000e+00 {VDD} 2.0000e-09 {VDD} 2.1000e-09 0 3.4000e-08 0 3.4100e-08 {VDD})
ven_op0_0000_combined_hold en_op0_0000_combined_hold 0 pwl(0.0000e+00 0 1.1000e-08 0 1.1100e-08 {VDD} 3.6000e-08 {VDD} 3.6100e-08 0)
venb_op0_0000_combined_hold enb_op0_0000_combined_hold 0 pwl(0.0000e+00 {VDD} 1.1000e-08 {VDD} 1.1100e-08 0 3.6000e-08 0 3.6100e-08 {VDD})
vww_op0_0000_combined_hold wwl_op0_0000_combined_hold 0 pwl(0.0000e+00 0 1.2000e-08 0 1.2100e-08 {VDD} 3.2000e-08 {VDD} 3.2100e-08 0)
vwc_op0_0000_combined_hold wbc_op0_0000_combined_hold 0 pwl(0.0000e+00 0 1.2000e-08 0 1.2100e-08 {VDD} 3.4000e-08 {VDD} 3.4100e-08 0)
swb_op0_0000_combined_hold ref_op0_0000_combined_hold wbl_op0_0000_combined_hold wbc_op0_0000_combined_hold 0 swwbl
cwbl_op0_0000_combined_hold wbl_op0_0000_combined_hold 0 {C_WBL}
spa_op0_0000_combined_hold prea rbl_op0_0000_combined_hold ctl_op0_0000_combined_hold 0 swpre
spr_op0_0000_combined_hold pref ref_op0_0000_combined_hold ctl_op0_0000_combined_hold 0 swpre
crbl_op0_0000_combined_hold rbl_op0_0000_combined_hold 0 {C_RBL}
cref_op0_0000_combined_hold ref_op0_0000_combined_hold 0 {C_RBL}   $ ASSUMPTION: ideal matched dummy load
XMWR_op0_0000_combined_hold_0 sn_op0_0000_combined_hold_0 wwl_op0_0000_combined_hold wbl_op0_0000_combined_hold 0 sky130_fd_pr__nfet_01v8 L=0.15 W=0.42 nf=1 ad=0.1218 as=0.1218 pd=1.42 ps=1.42 nrd=0.69047619047619  nrs=0.69047619047619 sa=0 sb=0 sd=0 mult=1 m=1
XMRD_op0_0000_combined_hold_0 rbl_op0_0000_combined_hold sn_op0_0000_combined_hold_0 rwls_op0_0000_combined_hold 0 sky130_fd_pr__nfet_01v8 L=0.15 W=0.42 nf=1 ad=0.1218 as=0.1218 pd=1.42 ps=1.42 nrd=0.69047619047619  nrs=0.69047619047619 sa=0 sb=0 sd=0 mult=1 m=1
csn_op0_0000_combined_hold_0 sn_op0_0000_combined_hold_0 0 {C_SN}
XMWR_op0_0000_combined_hold_1 sn_op0_0000_combined_hold_1 wwl_des wbl_op0_0000_combined_hold 0 sky130_fd_pr__nfet_01v8 L=0.15 W=0.42 nf=1 ad=0.1218 as=0.1218 pd=1.42 ps=1.42 nrd=0.69047619047619  nrs=0.69047619047619 sa=0 sb=0 sd=0 mult=1 m=1
XMRD_op0_0000_combined_hold_1 rbl_op0_0000_combined_hold sn_op0_0000_combined_hold_1 rwl_des 0 sky130_fd_pr__nfet_01v8 L=0.15 W=0.42 nf=1 ad=0.1218 as=0.1218 pd=1.42 ps=1.42 nrd=0.69047619047619  nrs=0.69047619047619 sa=0 sb=0 sd=0 mult=1 m=1
csn_op0_0000_combined_hold_1 sn_op0_0000_combined_hold_1 0 {C_SN}
XMWR_op0_0000_combined_hold_2 sn_op0_0000_combined_hold_2 wwl_des wbl_op0_0000_combined_hold 0 sky130_fd_pr__nfet_01v8 L=0.15 W=0.42 nf=1 ad=0.1218 as=0.1218 pd=1.42 ps=1.42 nrd=0.69047619047619  nrs=0.69047619047619 sa=0 sb=0 sd=0 mult=1 m=1
XMRD_op0_0000_combined_hold_2 rbl_op0_0000_combined_hold sn_op0_0000_combined_hold_2 rwl_des 0 sky130_fd_pr__nfet_01v8 L=0.15 W=0.42 nf=1 ad=0.1218 as=0.1218 pd=1.42 ps=1.42 nrd=0.69047619047619  nrs=0.69047619047619 sa=0 sb=0 sd=0 mult=1 m=1
csn_op0_0000_combined_hold_2 sn_op0_0000_combined_hold_2 0 {C_SN}
XMWR_op0_0000_combined_hold_3 sn_op0_0000_combined_hold_3 wwl_des wbl_op0_0000_combined_hold 0 sky130_fd_pr__nfet_01v8 L=0.15 W=0.42 nf=1 ad=0.1218 as=0.1218 pd=1.42 ps=1.42 nrd=0.69047619047619  nrs=0.69047619047619 sa=0 sb=0 sd=0 mult=1 m=1
XMRD_op0_0000_combined_hold_3 rbl_op0_0000_combined_hold sn_op0_0000_combined_hold_3 rwl_des 0 sky130_fd_pr__nfet_01v8 L=0.15 W=0.42 nf=1 ad=0.1218 as=0.1218 pd=1.42 ps=1.42 nrd=0.69047619047619  nrs=0.69047619047619 sa=0 sb=0 sd=0 mult=1 m=1
csn_op0_0000_combined_hold_3 sn_op0_0000_combined_hold_3 0 {C_SN}
XMN1_op0_0000_combined_hold rbl_op0_0000_combined_hold ref_op0_0000_combined_hold vn_op0_0000_combined_hold 0 sky130_fd_pr__nfet_01v8 L=0.15 W=1 nf=1 ad=0.29 as=0.29 pd=2.58 ps=2.58 mult=1 m=1
XMN2_op0_0000_combined_hold ref_op0_0000_combined_hold rbl_op0_0000_combined_hold vn_op0_0000_combined_hold 0 sky130_fd_pr__nfet_01v8 L=0.15 W=1 nf=1 ad=0.29 as=0.29 pd=2.58 ps=2.58 mult=1 m=1
XMP1_op0_0000_combined_hold rbl_op0_0000_combined_hold ref_op0_0000_combined_hold vp_op0_0000_combined_hold vdd sky130_fd_pr__pfet_01v8 L=0.15 W=2 nf=1 ad=0.58 as=0.58 pd=4.58 ps=4.58 mult=1 m=1
XMP2_op0_0000_combined_hold ref_op0_0000_combined_hold rbl_op0_0000_combined_hold vp_op0_0000_combined_hold vdd sky130_fd_pr__pfet_01v8 L=0.15 W=2 nf=1 ad=0.58 as=0.58 pd=4.58 ps=4.58 mult=1 m=1
XMNF_op0_0000_combined_hold vn_op0_0000_combined_hold en_op0_0000_combined_hold 0 0 sky130_fd_pr__nfet_01v8 L=0.15 W=2 nf=1 ad=0.58 as=0.58 pd=4.58 ps=4.58 mult=1 m=1
XMPH_op0_0000_combined_hold vp_op0_0000_combined_hold enb_op0_0000_combined_hold vdd vdd sky130_fd_pr__pfet_01v8 L=0.15 W=4 nf=1 ad=1.16 as=1.16 pd=8.58 ps=8.58 mult=1 m=1
bd_op0_0000_combined_hold d_op0_0000_combined_hold 0 v=v(rbl_op0_0000_combined_hold)-v(ref_op0_0000_combined_hold)

* ---- instance 40: refw (variant reference_write; probe dec 14.9 ns, release 37 ns, meas 39 ns) ----
vctl_refw ctl_refw 0 pwl(0.0000e+00 {VDD} 2.0000e-09 {VDD} 2.1000e-09 0)
vrs_refw rwls_refw 0 pwl(0.0000e+00 {VDD} 4.0000e-09 {VDD} 4.1000e-09 0 3.7000e-08 0 3.7100e-08 {VDD})
ven_refw en_refw 0 pwl(0.0000e+00 0 1.4000e-08 0 1.4100e-08 {VDD} 3.7000e-08 {VDD} 3.7100e-08 0)
venb_refw enb_refw 0 pwl(0.0000e+00 {VDD} 1.4000e-08 {VDD} 1.4100e-08 0 3.7000e-08 0 3.7100e-08 {VDD})
vww_refw wwl_refw 0 pwl(0.0000e+00 0 1.5000e-08 0 1.5100e-08 {VDD} 3.5000e-08 {VDD} 3.5100e-08 0)
vwc_refw wbc_refw 0 pwl(0.0000e+00 0 1.5000e-08 0 1.5100e-08 {VDD} 3.7000e-08 {VDD} 3.7100e-08 0)
* reference write: ideal 1.8 V WBL; rbl/ref/latch idle (no read)
vwbr_refw wbl_refw 0 dc {VDD}
cwbl_refw wbl_refw 0 {C_WBL}
spa_refw prea rbl_refw ctl_refw 0 swpre
spr_refw pref ref_refw ctl_refw 0 swpre
crbl_refw rbl_refw 0 {C_RBL}
cref_refw ref_refw 0 {C_RBL}   $ ASSUMPTION: ideal matched dummy load
XMWR_refw_0 sn_refw_0 wwl_refw wbl_refw 0 sky130_fd_pr__nfet_01v8 L=0.15 W=0.42 nf=1 ad=0.1218 as=0.1218 pd=1.42 ps=1.42 nrd=0.69047619047619  nrs=0.69047619047619 sa=0 sb=0 sd=0 mult=1 m=1
XMRD_refw_0 rbl_refw sn_refw_0 rwls_refw 0 sky130_fd_pr__nfet_01v8 L=0.15 W=0.42 nf=1 ad=0.1218 as=0.1218 pd=1.42 ps=1.42 nrd=0.69047619047619  nrs=0.69047619047619 sa=0 sb=0 sd=0 mult=1 m=1
csn_refw_0 sn_refw_0 0 {C_SN}
XMWR_refw_1 sn_refw_1 wwl_des wbl_refw 0 sky130_fd_pr__nfet_01v8 L=0.15 W=0.42 nf=1 ad=0.1218 as=0.1218 pd=1.42 ps=1.42 nrd=0.69047619047619  nrs=0.69047619047619 sa=0 sb=0 sd=0 mult=1 m=1
XMRD_refw_1 rbl_refw sn_refw_1 rwl_des 0 sky130_fd_pr__nfet_01v8 L=0.15 W=0.42 nf=1 ad=0.1218 as=0.1218 pd=1.42 ps=1.42 nrd=0.69047619047619  nrs=0.69047619047619 sa=0 sb=0 sd=0 mult=1 m=1
csn_refw_1 sn_refw_1 0 {C_SN}
XMWR_refw_2 sn_refw_2 wwl_des wbl_refw 0 sky130_fd_pr__nfet_01v8 L=0.15 W=0.42 nf=1 ad=0.1218 as=0.1218 pd=1.42 ps=1.42 nrd=0.69047619047619  nrs=0.69047619047619 sa=0 sb=0 sd=0 mult=1 m=1
XMRD_refw_2 rbl_refw sn_refw_2 rwl_des 0 sky130_fd_pr__nfet_01v8 L=0.15 W=0.42 nf=1 ad=0.1218 as=0.1218 pd=1.42 ps=1.42 nrd=0.69047619047619  nrs=0.69047619047619 sa=0 sb=0 sd=0 mult=1 m=1
csn_refw_2 sn_refw_2 0 {C_SN}
XMWR_refw_3 sn_refw_3 wwl_des wbl_refw 0 sky130_fd_pr__nfet_01v8 L=0.15 W=0.42 nf=1 ad=0.1218 as=0.1218 pd=1.42 ps=1.42 nrd=0.69047619047619  nrs=0.69047619047619 sa=0 sb=0 sd=0 mult=1 m=1
XMRD_refw_3 rbl_refw sn_refw_3 rwl_des 0 sky130_fd_pr__nfet_01v8 L=0.15 W=0.42 nf=1 ad=0.1218 as=0.1218 pd=1.42 ps=1.42 nrd=0.69047619047619  nrs=0.69047619047619 sa=0 sb=0 sd=0 mult=1 m=1
csn_refw_3 sn_refw_3 0 {C_SN}
XMN1_refw rbl_refw ref_refw vn_refw 0 sky130_fd_pr__nfet_01v8 L=0.15 W=1 nf=1 ad=0.29 as=0.29 pd=2.58 ps=2.58 mult=1 m=1
XMN2_refw ref_refw rbl_refw vn_refw 0 sky130_fd_pr__nfet_01v8 L=0.15 W=1 nf=1 ad=0.29 as=0.29 pd=2.58 ps=2.58 mult=1 m=1
XMP1_refw rbl_refw ref_refw vp_refw vdd sky130_fd_pr__pfet_01v8 L=0.15 W=2 nf=1 ad=0.58 as=0.58 pd=4.58 ps=4.58 mult=1 m=1
XMP2_refw ref_refw rbl_refw vp_refw vdd sky130_fd_pr__pfet_01v8 L=0.15 W=2 nf=1 ad=0.58 as=0.58 pd=4.58 ps=4.58 mult=1 m=1
XMNF_refw vn_refw en_refw 0 0 sky130_fd_pr__nfet_01v8 L=0.15 W=2 nf=1 ad=0.58 as=0.58 pd=4.58 ps=4.58 mult=1 m=1
XMPH_refw vp_refw enb_refw vdd vdd sky130_fd_pr__pfet_01v8 L=0.15 W=4 nf=1 ad=1.16 as=1.16 pd=8.58 ps=8.58 mult=1 m=1
bd_refw d_refw 0 v=v(rbl_refw)-v(ref_refw)

* ---- instance 41: op1_0900_an_s0p5_r0 (variant an_s0p5_r0; probe dec 14.9 ns, release 37 ns, meas 39 ns) ----
vctl_op1_0900_an_s0p5_r0 ctl_op1_0900_an_s0p5_r0 0 pwl(0.0000e+00 {VDD} 2.0000e-09 {VDD} 2.1000e-09 0)
* RWL driver model (EXPERIMENTAL): slew 0.5 ns, series R 0 ohm; cell pin = rwls_op1_0900_an_s0p5_r0
vrs_op1_0900_an_s0p5_r0 rwls_op1_0900_an_s0p5_r0 0 pwl(0.0000e+00 {VDD} 4.0000e-09 {VDD} 4.5000e-09 0 3.7000e-08 0 3.7500e-08 {VDD})
ven_op1_0900_an_s0p5_r0 en_op1_0900_an_s0p5_r0 0 pwl(0.0000e+00 0 1.4000e-08 0 1.4100e-08 {VDD} 3.7000e-08 {VDD} 3.7100e-08 0)
venb_op1_0900_an_s0p5_r0 enb_op1_0900_an_s0p5_r0 0 pwl(0.0000e+00 {VDD} 1.4000e-08 {VDD} 1.4100e-08 0 3.7000e-08 0 3.7100e-08 {VDD})
vww_op1_0900_an_s0p5_r0 wwl_op1_0900_an_s0p5_r0 0 pwl(0.0000e+00 0 1.5000e-08 0 1.5100e-08 {VDD} 3.5000e-08 {VDD} 3.5100e-08 0)
vwc_op1_0900_an_s0p5_r0 wbc_op1_0900_an_s0p5_r0 0 pwl(0.0000e+00 0 1.5000e-08 0 1.5100e-08 {VDD} 3.7000e-08 {VDD} 3.7100e-08 0)
swb_op1_0900_an_s0p5_r0 ref_op1_0900_an_s0p5_r0 wbl_op1_0900_an_s0p5_r0 wbc_op1_0900_an_s0p5_r0 0 swwbl
cwbl_op1_0900_an_s0p5_r0 wbl_op1_0900_an_s0p5_r0 0 {C_WBL}
spa_op1_0900_an_s0p5_r0 prea rbl_op1_0900_an_s0p5_r0 ctl_op1_0900_an_s0p5_r0 0 swpre
spr_op1_0900_an_s0p5_r0 pref ref_op1_0900_an_s0p5_r0 ctl_op1_0900_an_s0p5_r0 0 swpre
crbl_op1_0900_an_s0p5_r0 rbl_op1_0900_an_s0p5_r0 0 {C_RBL}
cref_op1_0900_an_s0p5_r0 ref_op1_0900_an_s0p5_r0 0 {C_RBL}   $ ASSUMPTION: ideal matched dummy load
XMWR_op1_0900_an_s0p5_r0_0 sn_op1_0900_an_s0p5_r0_0 wwl_op1_0900_an_s0p5_r0 wbl_op1_0900_an_s0p5_r0 0 sky130_fd_pr__nfet_01v8 L=0.15 W=0.42 nf=1 ad=0.1218 as=0.1218 pd=1.42 ps=1.42 nrd=0.69047619047619  nrs=0.69047619047619 sa=0 sb=0 sd=0 mult=1 m=1
XMRD_op1_0900_an_s0p5_r0_0 rbl_op1_0900_an_s0p5_r0 sn_op1_0900_an_s0p5_r0_0 rwls_op1_0900_an_s0p5_r0 0 sky130_fd_pr__nfet_01v8 L=0.15 W=0.42 nf=1 ad=0.1218 as=0.1218 pd=1.42 ps=1.42 nrd=0.69047619047619  nrs=0.69047619047619 sa=0 sb=0 sd=0 mult=1 m=1
csn_op1_0900_an_s0p5_r0_0 sn_op1_0900_an_s0p5_r0_0 0 {C_SN}
XMWR_op1_0900_an_s0p5_r0_1 sn_op1_0900_an_s0p5_r0_1 wwl_des wbl_op1_0900_an_s0p5_r0 0 sky130_fd_pr__nfet_01v8 L=0.15 W=0.42 nf=1 ad=0.1218 as=0.1218 pd=1.42 ps=1.42 nrd=0.69047619047619  nrs=0.69047619047619 sa=0 sb=0 sd=0 mult=1 m=1
XMRD_op1_0900_an_s0p5_r0_1 rbl_op1_0900_an_s0p5_r0 sn_op1_0900_an_s0p5_r0_1 rwl_des 0 sky130_fd_pr__nfet_01v8 L=0.15 W=0.42 nf=1 ad=0.1218 as=0.1218 pd=1.42 ps=1.42 nrd=0.69047619047619  nrs=0.69047619047619 sa=0 sb=0 sd=0 mult=1 m=1
csn_op1_0900_an_s0p5_r0_1 sn_op1_0900_an_s0p5_r0_1 0 {C_SN}
XMWR_op1_0900_an_s0p5_r0_2 sn_op1_0900_an_s0p5_r0_2 wwl_des wbl_op1_0900_an_s0p5_r0 0 sky130_fd_pr__nfet_01v8 L=0.15 W=0.42 nf=1 ad=0.1218 as=0.1218 pd=1.42 ps=1.42 nrd=0.69047619047619  nrs=0.69047619047619 sa=0 sb=0 sd=0 mult=1 m=1
XMRD_op1_0900_an_s0p5_r0_2 rbl_op1_0900_an_s0p5_r0 sn_op1_0900_an_s0p5_r0_2 rwl_des 0 sky130_fd_pr__nfet_01v8 L=0.15 W=0.42 nf=1 ad=0.1218 as=0.1218 pd=1.42 ps=1.42 nrd=0.69047619047619  nrs=0.69047619047619 sa=0 sb=0 sd=0 mult=1 m=1
csn_op1_0900_an_s0p5_r0_2 sn_op1_0900_an_s0p5_r0_2 0 {C_SN}
XMWR_op1_0900_an_s0p5_r0_3 sn_op1_0900_an_s0p5_r0_3 wwl_des wbl_op1_0900_an_s0p5_r0 0 sky130_fd_pr__nfet_01v8 L=0.15 W=0.42 nf=1 ad=0.1218 as=0.1218 pd=1.42 ps=1.42 nrd=0.69047619047619  nrs=0.69047619047619 sa=0 sb=0 sd=0 mult=1 m=1
XMRD_op1_0900_an_s0p5_r0_3 rbl_op1_0900_an_s0p5_r0 sn_op1_0900_an_s0p5_r0_3 rwl_des 0 sky130_fd_pr__nfet_01v8 L=0.15 W=0.42 nf=1 ad=0.1218 as=0.1218 pd=1.42 ps=1.42 nrd=0.69047619047619  nrs=0.69047619047619 sa=0 sb=0 sd=0 mult=1 m=1
csn_op1_0900_an_s0p5_r0_3 sn_op1_0900_an_s0p5_r0_3 0 {C_SN}
XMN1_op1_0900_an_s0p5_r0 rbl_op1_0900_an_s0p5_r0 ref_op1_0900_an_s0p5_r0 vn_op1_0900_an_s0p5_r0 0 sky130_fd_pr__nfet_01v8 L=0.15 W=1 nf=1 ad=0.29 as=0.29 pd=2.58 ps=2.58 mult=1 m=1
XMN2_op1_0900_an_s0p5_r0 ref_op1_0900_an_s0p5_r0 rbl_op1_0900_an_s0p5_r0 vn_op1_0900_an_s0p5_r0 0 sky130_fd_pr__nfet_01v8 L=0.15 W=1 nf=1 ad=0.29 as=0.29 pd=2.58 ps=2.58 mult=1 m=1
XMP1_op1_0900_an_s0p5_r0 rbl_op1_0900_an_s0p5_r0 ref_op1_0900_an_s0p5_r0 vp_op1_0900_an_s0p5_r0 vdd sky130_fd_pr__pfet_01v8 L=0.15 W=2 nf=1 ad=0.58 as=0.58 pd=4.58 ps=4.58 mult=1 m=1
XMP2_op1_0900_an_s0p5_r0 ref_op1_0900_an_s0p5_r0 rbl_op1_0900_an_s0p5_r0 vp_op1_0900_an_s0p5_r0 vdd sky130_fd_pr__pfet_01v8 L=0.15 W=2 nf=1 ad=0.58 as=0.58 pd=4.58 ps=4.58 mult=1 m=1
XMNF_op1_0900_an_s0p5_r0 vn_op1_0900_an_s0p5_r0 en_op1_0900_an_s0p5_r0 0 0 sky130_fd_pr__nfet_01v8 L=0.15 W=2 nf=1 ad=0.58 as=0.58 pd=4.58 ps=4.58 mult=1 m=1
XMPH_op1_0900_an_s0p5_r0 vp_op1_0900_an_s0p5_r0 enb_op1_0900_an_s0p5_r0 vdd vdd sky130_fd_pr__pfet_01v8 L=0.15 W=4 nf=1 ad=1.16 as=1.16 pd=8.58 ps=8.58 mult=1 m=1
bd_op1_0900_an_s0p5_r0 d_op1_0900_an_s0p5_r0 0 v=v(rbl_op1_0900_an_s0p5_r0)-v(ref_op1_0900_an_s0p5_r0)

* ---- instance 42: op1_1000_an_s0p5_r0 (variant an_s0p5_r0; probe dec 14.9 ns, release 37 ns, meas 39 ns) ----
vctl_op1_1000_an_s0p5_r0 ctl_op1_1000_an_s0p5_r0 0 pwl(0.0000e+00 {VDD} 2.0000e-09 {VDD} 2.1000e-09 0)
* RWL driver model (EXPERIMENTAL): slew 0.5 ns, series R 0 ohm; cell pin = rwls_op1_1000_an_s0p5_r0
vrs_op1_1000_an_s0p5_r0 rwls_op1_1000_an_s0p5_r0 0 pwl(0.0000e+00 {VDD} 4.0000e-09 {VDD} 4.5000e-09 0 3.7000e-08 0 3.7500e-08 {VDD})
ven_op1_1000_an_s0p5_r0 en_op1_1000_an_s0p5_r0 0 pwl(0.0000e+00 0 1.4000e-08 0 1.4100e-08 {VDD} 3.7000e-08 {VDD} 3.7100e-08 0)
venb_op1_1000_an_s0p5_r0 enb_op1_1000_an_s0p5_r0 0 pwl(0.0000e+00 {VDD} 1.4000e-08 {VDD} 1.4100e-08 0 3.7000e-08 0 3.7100e-08 {VDD})
vww_op1_1000_an_s0p5_r0 wwl_op1_1000_an_s0p5_r0 0 pwl(0.0000e+00 0 1.5000e-08 0 1.5100e-08 {VDD} 3.5000e-08 {VDD} 3.5100e-08 0)
vwc_op1_1000_an_s0p5_r0 wbc_op1_1000_an_s0p5_r0 0 pwl(0.0000e+00 0 1.5000e-08 0 1.5100e-08 {VDD} 3.7000e-08 {VDD} 3.7100e-08 0)
swb_op1_1000_an_s0p5_r0 ref_op1_1000_an_s0p5_r0 wbl_op1_1000_an_s0p5_r0 wbc_op1_1000_an_s0p5_r0 0 swwbl
cwbl_op1_1000_an_s0p5_r0 wbl_op1_1000_an_s0p5_r0 0 {C_WBL}
spa_op1_1000_an_s0p5_r0 prea rbl_op1_1000_an_s0p5_r0 ctl_op1_1000_an_s0p5_r0 0 swpre
spr_op1_1000_an_s0p5_r0 pref ref_op1_1000_an_s0p5_r0 ctl_op1_1000_an_s0p5_r0 0 swpre
crbl_op1_1000_an_s0p5_r0 rbl_op1_1000_an_s0p5_r0 0 {C_RBL}
cref_op1_1000_an_s0p5_r0 ref_op1_1000_an_s0p5_r0 0 {C_RBL}   $ ASSUMPTION: ideal matched dummy load
XMWR_op1_1000_an_s0p5_r0_0 sn_op1_1000_an_s0p5_r0_0 wwl_op1_1000_an_s0p5_r0 wbl_op1_1000_an_s0p5_r0 0 sky130_fd_pr__nfet_01v8 L=0.15 W=0.42 nf=1 ad=0.1218 as=0.1218 pd=1.42 ps=1.42 nrd=0.69047619047619  nrs=0.69047619047619 sa=0 sb=0 sd=0 mult=1 m=1
XMRD_op1_1000_an_s0p5_r0_0 rbl_op1_1000_an_s0p5_r0 sn_op1_1000_an_s0p5_r0_0 rwls_op1_1000_an_s0p5_r0 0 sky130_fd_pr__nfet_01v8 L=0.15 W=0.42 nf=1 ad=0.1218 as=0.1218 pd=1.42 ps=1.42 nrd=0.69047619047619  nrs=0.69047619047619 sa=0 sb=0 sd=0 mult=1 m=1
csn_op1_1000_an_s0p5_r0_0 sn_op1_1000_an_s0p5_r0_0 0 {C_SN}
XMWR_op1_1000_an_s0p5_r0_1 sn_op1_1000_an_s0p5_r0_1 wwl_des wbl_op1_1000_an_s0p5_r0 0 sky130_fd_pr__nfet_01v8 L=0.15 W=0.42 nf=1 ad=0.1218 as=0.1218 pd=1.42 ps=1.42 nrd=0.69047619047619  nrs=0.69047619047619 sa=0 sb=0 sd=0 mult=1 m=1
XMRD_op1_1000_an_s0p5_r0_1 rbl_op1_1000_an_s0p5_r0 sn_op1_1000_an_s0p5_r0_1 rwl_des 0 sky130_fd_pr__nfet_01v8 L=0.15 W=0.42 nf=1 ad=0.1218 as=0.1218 pd=1.42 ps=1.42 nrd=0.69047619047619  nrs=0.69047619047619 sa=0 sb=0 sd=0 mult=1 m=1
csn_op1_1000_an_s0p5_r0_1 sn_op1_1000_an_s0p5_r0_1 0 {C_SN}
XMWR_op1_1000_an_s0p5_r0_2 sn_op1_1000_an_s0p5_r0_2 wwl_des wbl_op1_1000_an_s0p5_r0 0 sky130_fd_pr__nfet_01v8 L=0.15 W=0.42 nf=1 ad=0.1218 as=0.1218 pd=1.42 ps=1.42 nrd=0.69047619047619  nrs=0.69047619047619 sa=0 sb=0 sd=0 mult=1 m=1
XMRD_op1_1000_an_s0p5_r0_2 rbl_op1_1000_an_s0p5_r0 sn_op1_1000_an_s0p5_r0_2 rwl_des 0 sky130_fd_pr__nfet_01v8 L=0.15 W=0.42 nf=1 ad=0.1218 as=0.1218 pd=1.42 ps=1.42 nrd=0.69047619047619  nrs=0.69047619047619 sa=0 sb=0 sd=0 mult=1 m=1
csn_op1_1000_an_s0p5_r0_2 sn_op1_1000_an_s0p5_r0_2 0 {C_SN}
XMWR_op1_1000_an_s0p5_r0_3 sn_op1_1000_an_s0p5_r0_3 wwl_des wbl_op1_1000_an_s0p5_r0 0 sky130_fd_pr__nfet_01v8 L=0.15 W=0.42 nf=1 ad=0.1218 as=0.1218 pd=1.42 ps=1.42 nrd=0.69047619047619  nrs=0.69047619047619 sa=0 sb=0 sd=0 mult=1 m=1
XMRD_op1_1000_an_s0p5_r0_3 rbl_op1_1000_an_s0p5_r0 sn_op1_1000_an_s0p5_r0_3 rwl_des 0 sky130_fd_pr__nfet_01v8 L=0.15 W=0.42 nf=1 ad=0.1218 as=0.1218 pd=1.42 ps=1.42 nrd=0.69047619047619  nrs=0.69047619047619 sa=0 sb=0 sd=0 mult=1 m=1
csn_op1_1000_an_s0p5_r0_3 sn_op1_1000_an_s0p5_r0_3 0 {C_SN}
XMN1_op1_1000_an_s0p5_r0 rbl_op1_1000_an_s0p5_r0 ref_op1_1000_an_s0p5_r0 vn_op1_1000_an_s0p5_r0 0 sky130_fd_pr__nfet_01v8 L=0.15 W=1 nf=1 ad=0.29 as=0.29 pd=2.58 ps=2.58 mult=1 m=1
XMN2_op1_1000_an_s0p5_r0 ref_op1_1000_an_s0p5_r0 rbl_op1_1000_an_s0p5_r0 vn_op1_1000_an_s0p5_r0 0 sky130_fd_pr__nfet_01v8 L=0.15 W=1 nf=1 ad=0.29 as=0.29 pd=2.58 ps=2.58 mult=1 m=1
XMP1_op1_1000_an_s0p5_r0 rbl_op1_1000_an_s0p5_r0 ref_op1_1000_an_s0p5_r0 vp_op1_1000_an_s0p5_r0 vdd sky130_fd_pr__pfet_01v8 L=0.15 W=2 nf=1 ad=0.58 as=0.58 pd=4.58 ps=4.58 mult=1 m=1
XMP2_op1_1000_an_s0p5_r0 ref_op1_1000_an_s0p5_r0 rbl_op1_1000_an_s0p5_r0 vp_op1_1000_an_s0p5_r0 vdd sky130_fd_pr__pfet_01v8 L=0.15 W=2 nf=1 ad=0.58 as=0.58 pd=4.58 ps=4.58 mult=1 m=1
XMNF_op1_1000_an_s0p5_r0 vn_op1_1000_an_s0p5_r0 en_op1_1000_an_s0p5_r0 0 0 sky130_fd_pr__nfet_01v8 L=0.15 W=2 nf=1 ad=0.58 as=0.58 pd=4.58 ps=4.58 mult=1 m=1
XMPH_op1_1000_an_s0p5_r0 vp_op1_1000_an_s0p5_r0 enb_op1_1000_an_s0p5_r0 vdd vdd sky130_fd_pr__pfet_01v8 L=0.15 W=4 nf=1 ad=1.16 as=1.16 pd=8.58 ps=8.58 mult=1 m=1
bd_op1_1000_an_s0p5_r0 d_op1_1000_an_s0p5_r0 0 v=v(rbl_op1_1000_an_s0p5_r0)-v(ref_op1_1000_an_s0p5_r0)

* ---- instance 43: op0_n100_an_s0p5_r0 (variant an_s0p5_r0; probe dec 14.9 ns, release 37 ns, meas 39 ns) ----
vctl_op0_n100_an_s0p5_r0 ctl_op0_n100_an_s0p5_r0 0 pwl(0.0000e+00 {VDD} 2.0000e-09 {VDD} 2.1000e-09 0)
* RWL driver model (EXPERIMENTAL): slew 0.5 ns, series R 0 ohm; cell pin = rwls_op0_n100_an_s0p5_r0
vrs_op0_n100_an_s0p5_r0 rwls_op0_n100_an_s0p5_r0 0 pwl(0.0000e+00 {VDD} 4.0000e-09 {VDD} 4.5000e-09 0 3.7000e-08 0 3.7500e-08 {VDD})
ven_op0_n100_an_s0p5_r0 en_op0_n100_an_s0p5_r0 0 pwl(0.0000e+00 0 1.4000e-08 0 1.4100e-08 {VDD} 3.7000e-08 {VDD} 3.7100e-08 0)
venb_op0_n100_an_s0p5_r0 enb_op0_n100_an_s0p5_r0 0 pwl(0.0000e+00 {VDD} 1.4000e-08 {VDD} 1.4100e-08 0 3.7000e-08 0 3.7100e-08 {VDD})
vww_op0_n100_an_s0p5_r0 wwl_op0_n100_an_s0p5_r0 0 pwl(0.0000e+00 0 1.5000e-08 0 1.5100e-08 {VDD} 3.5000e-08 {VDD} 3.5100e-08 0)
vwc_op0_n100_an_s0p5_r0 wbc_op0_n100_an_s0p5_r0 0 pwl(0.0000e+00 0 1.5000e-08 0 1.5100e-08 {VDD} 3.7000e-08 {VDD} 3.7100e-08 0)
swb_op0_n100_an_s0p5_r0 ref_op0_n100_an_s0p5_r0 wbl_op0_n100_an_s0p5_r0 wbc_op0_n100_an_s0p5_r0 0 swwbl
cwbl_op0_n100_an_s0p5_r0 wbl_op0_n100_an_s0p5_r0 0 {C_WBL}
spa_op0_n100_an_s0p5_r0 prea rbl_op0_n100_an_s0p5_r0 ctl_op0_n100_an_s0p5_r0 0 swpre
spr_op0_n100_an_s0p5_r0 pref ref_op0_n100_an_s0p5_r0 ctl_op0_n100_an_s0p5_r0 0 swpre
crbl_op0_n100_an_s0p5_r0 rbl_op0_n100_an_s0p5_r0 0 {C_RBL}
cref_op0_n100_an_s0p5_r0 ref_op0_n100_an_s0p5_r0 0 {C_RBL}   $ ASSUMPTION: ideal matched dummy load
XMWR_op0_n100_an_s0p5_r0_0 sn_op0_n100_an_s0p5_r0_0 wwl_op0_n100_an_s0p5_r0 wbl_op0_n100_an_s0p5_r0 0 sky130_fd_pr__nfet_01v8 L=0.15 W=0.42 nf=1 ad=0.1218 as=0.1218 pd=1.42 ps=1.42 nrd=0.69047619047619  nrs=0.69047619047619 sa=0 sb=0 sd=0 mult=1 m=1
XMRD_op0_n100_an_s0p5_r0_0 rbl_op0_n100_an_s0p5_r0 sn_op0_n100_an_s0p5_r0_0 rwls_op0_n100_an_s0p5_r0 0 sky130_fd_pr__nfet_01v8 L=0.15 W=0.42 nf=1 ad=0.1218 as=0.1218 pd=1.42 ps=1.42 nrd=0.69047619047619  nrs=0.69047619047619 sa=0 sb=0 sd=0 mult=1 m=1
csn_op0_n100_an_s0p5_r0_0 sn_op0_n100_an_s0p5_r0_0 0 {C_SN}
XMWR_op0_n100_an_s0p5_r0_1 sn_op0_n100_an_s0p5_r0_1 wwl_des wbl_op0_n100_an_s0p5_r0 0 sky130_fd_pr__nfet_01v8 L=0.15 W=0.42 nf=1 ad=0.1218 as=0.1218 pd=1.42 ps=1.42 nrd=0.69047619047619  nrs=0.69047619047619 sa=0 sb=0 sd=0 mult=1 m=1
XMRD_op0_n100_an_s0p5_r0_1 rbl_op0_n100_an_s0p5_r0 sn_op0_n100_an_s0p5_r0_1 rwl_des 0 sky130_fd_pr__nfet_01v8 L=0.15 W=0.42 nf=1 ad=0.1218 as=0.1218 pd=1.42 ps=1.42 nrd=0.69047619047619  nrs=0.69047619047619 sa=0 sb=0 sd=0 mult=1 m=1
csn_op0_n100_an_s0p5_r0_1 sn_op0_n100_an_s0p5_r0_1 0 {C_SN}
XMWR_op0_n100_an_s0p5_r0_2 sn_op0_n100_an_s0p5_r0_2 wwl_des wbl_op0_n100_an_s0p5_r0 0 sky130_fd_pr__nfet_01v8 L=0.15 W=0.42 nf=1 ad=0.1218 as=0.1218 pd=1.42 ps=1.42 nrd=0.69047619047619  nrs=0.69047619047619 sa=0 sb=0 sd=0 mult=1 m=1
XMRD_op0_n100_an_s0p5_r0_2 rbl_op0_n100_an_s0p5_r0 sn_op0_n100_an_s0p5_r0_2 rwl_des 0 sky130_fd_pr__nfet_01v8 L=0.15 W=0.42 nf=1 ad=0.1218 as=0.1218 pd=1.42 ps=1.42 nrd=0.69047619047619  nrs=0.69047619047619 sa=0 sb=0 sd=0 mult=1 m=1
csn_op0_n100_an_s0p5_r0_2 sn_op0_n100_an_s0p5_r0_2 0 {C_SN}
XMWR_op0_n100_an_s0p5_r0_3 sn_op0_n100_an_s0p5_r0_3 wwl_des wbl_op0_n100_an_s0p5_r0 0 sky130_fd_pr__nfet_01v8 L=0.15 W=0.42 nf=1 ad=0.1218 as=0.1218 pd=1.42 ps=1.42 nrd=0.69047619047619  nrs=0.69047619047619 sa=0 sb=0 sd=0 mult=1 m=1
XMRD_op0_n100_an_s0p5_r0_3 rbl_op0_n100_an_s0p5_r0 sn_op0_n100_an_s0p5_r0_3 rwl_des 0 sky130_fd_pr__nfet_01v8 L=0.15 W=0.42 nf=1 ad=0.1218 as=0.1218 pd=1.42 ps=1.42 nrd=0.69047619047619  nrs=0.69047619047619 sa=0 sb=0 sd=0 mult=1 m=1
csn_op0_n100_an_s0p5_r0_3 sn_op0_n100_an_s0p5_r0_3 0 {C_SN}
XMN1_op0_n100_an_s0p5_r0 rbl_op0_n100_an_s0p5_r0 ref_op0_n100_an_s0p5_r0 vn_op0_n100_an_s0p5_r0 0 sky130_fd_pr__nfet_01v8 L=0.15 W=1 nf=1 ad=0.29 as=0.29 pd=2.58 ps=2.58 mult=1 m=1
XMN2_op0_n100_an_s0p5_r0 ref_op0_n100_an_s0p5_r0 rbl_op0_n100_an_s0p5_r0 vn_op0_n100_an_s0p5_r0 0 sky130_fd_pr__nfet_01v8 L=0.15 W=1 nf=1 ad=0.29 as=0.29 pd=2.58 ps=2.58 mult=1 m=1
XMP1_op0_n100_an_s0p5_r0 rbl_op0_n100_an_s0p5_r0 ref_op0_n100_an_s0p5_r0 vp_op0_n100_an_s0p5_r0 vdd sky130_fd_pr__pfet_01v8 L=0.15 W=2 nf=1 ad=0.58 as=0.58 pd=4.58 ps=4.58 mult=1 m=1
XMP2_op0_n100_an_s0p5_r0 ref_op0_n100_an_s0p5_r0 rbl_op0_n100_an_s0p5_r0 vp_op0_n100_an_s0p5_r0 vdd sky130_fd_pr__pfet_01v8 L=0.15 W=2 nf=1 ad=0.58 as=0.58 pd=4.58 ps=4.58 mult=1 m=1
XMNF_op0_n100_an_s0p5_r0 vn_op0_n100_an_s0p5_r0 en_op0_n100_an_s0p5_r0 0 0 sky130_fd_pr__nfet_01v8 L=0.15 W=2 nf=1 ad=0.58 as=0.58 pd=4.58 ps=4.58 mult=1 m=1
XMPH_op0_n100_an_s0p5_r0 vp_op0_n100_an_s0p5_r0 enb_op0_n100_an_s0p5_r0 vdd vdd sky130_fd_pr__pfet_01v8 L=0.15 W=4 nf=1 ad=1.16 as=1.16 pd=8.58 ps=8.58 mult=1 m=1
bd_op0_n100_an_s0p5_r0 d_op0_n100_an_s0p5_r0 0 v=v(rbl_op0_n100_an_s0p5_r0)-v(ref_op0_n100_an_s0p5_r0)

* ---- instance 44: op0_0000_an_s0p5_r0 (variant an_s0p5_r0; probe dec 14.9 ns, release 37 ns, meas 39 ns) ----
vctl_op0_0000_an_s0p5_r0 ctl_op0_0000_an_s0p5_r0 0 pwl(0.0000e+00 {VDD} 2.0000e-09 {VDD} 2.1000e-09 0)
* RWL driver model (EXPERIMENTAL): slew 0.5 ns, series R 0 ohm; cell pin = rwls_op0_0000_an_s0p5_r0
vrs_op0_0000_an_s0p5_r0 rwls_op0_0000_an_s0p5_r0 0 pwl(0.0000e+00 {VDD} 4.0000e-09 {VDD} 4.5000e-09 0 3.7000e-08 0 3.7500e-08 {VDD})
ven_op0_0000_an_s0p5_r0 en_op0_0000_an_s0p5_r0 0 pwl(0.0000e+00 0 1.4000e-08 0 1.4100e-08 {VDD} 3.7000e-08 {VDD} 3.7100e-08 0)
venb_op0_0000_an_s0p5_r0 enb_op0_0000_an_s0p5_r0 0 pwl(0.0000e+00 {VDD} 1.4000e-08 {VDD} 1.4100e-08 0 3.7000e-08 0 3.7100e-08 {VDD})
vww_op0_0000_an_s0p5_r0 wwl_op0_0000_an_s0p5_r0 0 pwl(0.0000e+00 0 1.5000e-08 0 1.5100e-08 {VDD} 3.5000e-08 {VDD} 3.5100e-08 0)
vwc_op0_0000_an_s0p5_r0 wbc_op0_0000_an_s0p5_r0 0 pwl(0.0000e+00 0 1.5000e-08 0 1.5100e-08 {VDD} 3.7000e-08 {VDD} 3.7100e-08 0)
swb_op0_0000_an_s0p5_r0 ref_op0_0000_an_s0p5_r0 wbl_op0_0000_an_s0p5_r0 wbc_op0_0000_an_s0p5_r0 0 swwbl
cwbl_op0_0000_an_s0p5_r0 wbl_op0_0000_an_s0p5_r0 0 {C_WBL}
spa_op0_0000_an_s0p5_r0 prea rbl_op0_0000_an_s0p5_r0 ctl_op0_0000_an_s0p5_r0 0 swpre
spr_op0_0000_an_s0p5_r0 pref ref_op0_0000_an_s0p5_r0 ctl_op0_0000_an_s0p5_r0 0 swpre
crbl_op0_0000_an_s0p5_r0 rbl_op0_0000_an_s0p5_r0 0 {C_RBL}
cref_op0_0000_an_s0p5_r0 ref_op0_0000_an_s0p5_r0 0 {C_RBL}   $ ASSUMPTION: ideal matched dummy load
XMWR_op0_0000_an_s0p5_r0_0 sn_op0_0000_an_s0p5_r0_0 wwl_op0_0000_an_s0p5_r0 wbl_op0_0000_an_s0p5_r0 0 sky130_fd_pr__nfet_01v8 L=0.15 W=0.42 nf=1 ad=0.1218 as=0.1218 pd=1.42 ps=1.42 nrd=0.69047619047619  nrs=0.69047619047619 sa=0 sb=0 sd=0 mult=1 m=1
XMRD_op0_0000_an_s0p5_r0_0 rbl_op0_0000_an_s0p5_r0 sn_op0_0000_an_s0p5_r0_0 rwls_op0_0000_an_s0p5_r0 0 sky130_fd_pr__nfet_01v8 L=0.15 W=0.42 nf=1 ad=0.1218 as=0.1218 pd=1.42 ps=1.42 nrd=0.69047619047619  nrs=0.69047619047619 sa=0 sb=0 sd=0 mult=1 m=1
csn_op0_0000_an_s0p5_r0_0 sn_op0_0000_an_s0p5_r0_0 0 {C_SN}
XMWR_op0_0000_an_s0p5_r0_1 sn_op0_0000_an_s0p5_r0_1 wwl_des wbl_op0_0000_an_s0p5_r0 0 sky130_fd_pr__nfet_01v8 L=0.15 W=0.42 nf=1 ad=0.1218 as=0.1218 pd=1.42 ps=1.42 nrd=0.69047619047619  nrs=0.69047619047619 sa=0 sb=0 sd=0 mult=1 m=1
XMRD_op0_0000_an_s0p5_r0_1 rbl_op0_0000_an_s0p5_r0 sn_op0_0000_an_s0p5_r0_1 rwl_des 0 sky130_fd_pr__nfet_01v8 L=0.15 W=0.42 nf=1 ad=0.1218 as=0.1218 pd=1.42 ps=1.42 nrd=0.69047619047619  nrs=0.69047619047619 sa=0 sb=0 sd=0 mult=1 m=1
csn_op0_0000_an_s0p5_r0_1 sn_op0_0000_an_s0p5_r0_1 0 {C_SN}
XMWR_op0_0000_an_s0p5_r0_2 sn_op0_0000_an_s0p5_r0_2 wwl_des wbl_op0_0000_an_s0p5_r0 0 sky130_fd_pr__nfet_01v8 L=0.15 W=0.42 nf=1 ad=0.1218 as=0.1218 pd=1.42 ps=1.42 nrd=0.69047619047619  nrs=0.69047619047619 sa=0 sb=0 sd=0 mult=1 m=1
XMRD_op0_0000_an_s0p5_r0_2 rbl_op0_0000_an_s0p5_r0 sn_op0_0000_an_s0p5_r0_2 rwl_des 0 sky130_fd_pr__nfet_01v8 L=0.15 W=0.42 nf=1 ad=0.1218 as=0.1218 pd=1.42 ps=1.42 nrd=0.69047619047619  nrs=0.69047619047619 sa=0 sb=0 sd=0 mult=1 m=1
csn_op0_0000_an_s0p5_r0_2 sn_op0_0000_an_s0p5_r0_2 0 {C_SN}
XMWR_op0_0000_an_s0p5_r0_3 sn_op0_0000_an_s0p5_r0_3 wwl_des wbl_op0_0000_an_s0p5_r0 0 sky130_fd_pr__nfet_01v8 L=0.15 W=0.42 nf=1 ad=0.1218 as=0.1218 pd=1.42 ps=1.42 nrd=0.69047619047619  nrs=0.69047619047619 sa=0 sb=0 sd=0 mult=1 m=1
XMRD_op0_0000_an_s0p5_r0_3 rbl_op0_0000_an_s0p5_r0 sn_op0_0000_an_s0p5_r0_3 rwl_des 0 sky130_fd_pr__nfet_01v8 L=0.15 W=0.42 nf=1 ad=0.1218 as=0.1218 pd=1.42 ps=1.42 nrd=0.69047619047619  nrs=0.69047619047619 sa=0 sb=0 sd=0 mult=1 m=1
csn_op0_0000_an_s0p5_r0_3 sn_op0_0000_an_s0p5_r0_3 0 {C_SN}
XMN1_op0_0000_an_s0p5_r0 rbl_op0_0000_an_s0p5_r0 ref_op0_0000_an_s0p5_r0 vn_op0_0000_an_s0p5_r0 0 sky130_fd_pr__nfet_01v8 L=0.15 W=1 nf=1 ad=0.29 as=0.29 pd=2.58 ps=2.58 mult=1 m=1
XMN2_op0_0000_an_s0p5_r0 ref_op0_0000_an_s0p5_r0 rbl_op0_0000_an_s0p5_r0 vn_op0_0000_an_s0p5_r0 0 sky130_fd_pr__nfet_01v8 L=0.15 W=1 nf=1 ad=0.29 as=0.29 pd=2.58 ps=2.58 mult=1 m=1
XMP1_op0_0000_an_s0p5_r0 rbl_op0_0000_an_s0p5_r0 ref_op0_0000_an_s0p5_r0 vp_op0_0000_an_s0p5_r0 vdd sky130_fd_pr__pfet_01v8 L=0.15 W=2 nf=1 ad=0.58 as=0.58 pd=4.58 ps=4.58 mult=1 m=1
XMP2_op0_0000_an_s0p5_r0 ref_op0_0000_an_s0p5_r0 rbl_op0_0000_an_s0p5_r0 vp_op0_0000_an_s0p5_r0 vdd sky130_fd_pr__pfet_01v8 L=0.15 W=2 nf=1 ad=0.58 as=0.58 pd=4.58 ps=4.58 mult=1 m=1
XMNF_op0_0000_an_s0p5_r0 vn_op0_0000_an_s0p5_r0 en_op0_0000_an_s0p5_r0 0 0 sky130_fd_pr__nfet_01v8 L=0.15 W=2 nf=1 ad=0.58 as=0.58 pd=4.58 ps=4.58 mult=1 m=1
XMPH_op0_0000_an_s0p5_r0 vp_op0_0000_an_s0p5_r0 enb_op0_0000_an_s0p5_r0 vdd vdd sky130_fd_pr__pfet_01v8 L=0.15 W=4 nf=1 ad=1.16 as=1.16 pd=8.58 ps=8.58 mult=1 m=1
bd_op0_0000_an_s0p5_r0 d_op0_0000_an_s0p5_r0 0 v=v(rbl_op0_0000_an_s0p5_r0)-v(ref_op0_0000_an_s0p5_r0)

* ---- instance 45: op1_0900_an_s1_r0 (variant an_s1_r0; probe dec 14.9 ns, release 37 ns, meas 39 ns) ----
vctl_op1_0900_an_s1_r0 ctl_op1_0900_an_s1_r0 0 pwl(0.0000e+00 {VDD} 2.0000e-09 {VDD} 2.1000e-09 0)
* RWL driver model (EXPERIMENTAL): slew 1 ns, series R 0 ohm; cell pin = rwls_op1_0900_an_s1_r0
vrs_op1_0900_an_s1_r0 rwls_op1_0900_an_s1_r0 0 pwl(0.0000e+00 {VDD} 4.0000e-09 {VDD} 5.0000e-09 0 3.7000e-08 0 3.8000e-08 {VDD})
ven_op1_0900_an_s1_r0 en_op1_0900_an_s1_r0 0 pwl(0.0000e+00 0 1.4000e-08 0 1.4100e-08 {VDD} 3.7000e-08 {VDD} 3.7100e-08 0)
venb_op1_0900_an_s1_r0 enb_op1_0900_an_s1_r0 0 pwl(0.0000e+00 {VDD} 1.4000e-08 {VDD} 1.4100e-08 0 3.7000e-08 0 3.7100e-08 {VDD})
vww_op1_0900_an_s1_r0 wwl_op1_0900_an_s1_r0 0 pwl(0.0000e+00 0 1.5000e-08 0 1.5100e-08 {VDD} 3.5000e-08 {VDD} 3.5100e-08 0)
vwc_op1_0900_an_s1_r0 wbc_op1_0900_an_s1_r0 0 pwl(0.0000e+00 0 1.5000e-08 0 1.5100e-08 {VDD} 3.7000e-08 {VDD} 3.7100e-08 0)
swb_op1_0900_an_s1_r0 ref_op1_0900_an_s1_r0 wbl_op1_0900_an_s1_r0 wbc_op1_0900_an_s1_r0 0 swwbl
cwbl_op1_0900_an_s1_r0 wbl_op1_0900_an_s1_r0 0 {C_WBL}
spa_op1_0900_an_s1_r0 prea rbl_op1_0900_an_s1_r0 ctl_op1_0900_an_s1_r0 0 swpre
spr_op1_0900_an_s1_r0 pref ref_op1_0900_an_s1_r0 ctl_op1_0900_an_s1_r0 0 swpre
crbl_op1_0900_an_s1_r0 rbl_op1_0900_an_s1_r0 0 {C_RBL}
cref_op1_0900_an_s1_r0 ref_op1_0900_an_s1_r0 0 {C_RBL}   $ ASSUMPTION: ideal matched dummy load
XMWR_op1_0900_an_s1_r0_0 sn_op1_0900_an_s1_r0_0 wwl_op1_0900_an_s1_r0 wbl_op1_0900_an_s1_r0 0 sky130_fd_pr__nfet_01v8 L=0.15 W=0.42 nf=1 ad=0.1218 as=0.1218 pd=1.42 ps=1.42 nrd=0.69047619047619  nrs=0.69047619047619 sa=0 sb=0 sd=0 mult=1 m=1
XMRD_op1_0900_an_s1_r0_0 rbl_op1_0900_an_s1_r0 sn_op1_0900_an_s1_r0_0 rwls_op1_0900_an_s1_r0 0 sky130_fd_pr__nfet_01v8 L=0.15 W=0.42 nf=1 ad=0.1218 as=0.1218 pd=1.42 ps=1.42 nrd=0.69047619047619  nrs=0.69047619047619 sa=0 sb=0 sd=0 mult=1 m=1
csn_op1_0900_an_s1_r0_0 sn_op1_0900_an_s1_r0_0 0 {C_SN}
XMWR_op1_0900_an_s1_r0_1 sn_op1_0900_an_s1_r0_1 wwl_des wbl_op1_0900_an_s1_r0 0 sky130_fd_pr__nfet_01v8 L=0.15 W=0.42 nf=1 ad=0.1218 as=0.1218 pd=1.42 ps=1.42 nrd=0.69047619047619  nrs=0.69047619047619 sa=0 sb=0 sd=0 mult=1 m=1
XMRD_op1_0900_an_s1_r0_1 rbl_op1_0900_an_s1_r0 sn_op1_0900_an_s1_r0_1 rwl_des 0 sky130_fd_pr__nfet_01v8 L=0.15 W=0.42 nf=1 ad=0.1218 as=0.1218 pd=1.42 ps=1.42 nrd=0.69047619047619  nrs=0.69047619047619 sa=0 sb=0 sd=0 mult=1 m=1
csn_op1_0900_an_s1_r0_1 sn_op1_0900_an_s1_r0_1 0 {C_SN}
XMWR_op1_0900_an_s1_r0_2 sn_op1_0900_an_s1_r0_2 wwl_des wbl_op1_0900_an_s1_r0 0 sky130_fd_pr__nfet_01v8 L=0.15 W=0.42 nf=1 ad=0.1218 as=0.1218 pd=1.42 ps=1.42 nrd=0.69047619047619  nrs=0.69047619047619 sa=0 sb=0 sd=0 mult=1 m=1
XMRD_op1_0900_an_s1_r0_2 rbl_op1_0900_an_s1_r0 sn_op1_0900_an_s1_r0_2 rwl_des 0 sky130_fd_pr__nfet_01v8 L=0.15 W=0.42 nf=1 ad=0.1218 as=0.1218 pd=1.42 ps=1.42 nrd=0.69047619047619  nrs=0.69047619047619 sa=0 sb=0 sd=0 mult=1 m=1
csn_op1_0900_an_s1_r0_2 sn_op1_0900_an_s1_r0_2 0 {C_SN}
XMWR_op1_0900_an_s1_r0_3 sn_op1_0900_an_s1_r0_3 wwl_des wbl_op1_0900_an_s1_r0 0 sky130_fd_pr__nfet_01v8 L=0.15 W=0.42 nf=1 ad=0.1218 as=0.1218 pd=1.42 ps=1.42 nrd=0.69047619047619  nrs=0.69047619047619 sa=0 sb=0 sd=0 mult=1 m=1
XMRD_op1_0900_an_s1_r0_3 rbl_op1_0900_an_s1_r0 sn_op1_0900_an_s1_r0_3 rwl_des 0 sky130_fd_pr__nfet_01v8 L=0.15 W=0.42 nf=1 ad=0.1218 as=0.1218 pd=1.42 ps=1.42 nrd=0.69047619047619  nrs=0.69047619047619 sa=0 sb=0 sd=0 mult=1 m=1
csn_op1_0900_an_s1_r0_3 sn_op1_0900_an_s1_r0_3 0 {C_SN}
XMN1_op1_0900_an_s1_r0 rbl_op1_0900_an_s1_r0 ref_op1_0900_an_s1_r0 vn_op1_0900_an_s1_r0 0 sky130_fd_pr__nfet_01v8 L=0.15 W=1 nf=1 ad=0.29 as=0.29 pd=2.58 ps=2.58 mult=1 m=1
XMN2_op1_0900_an_s1_r0 ref_op1_0900_an_s1_r0 rbl_op1_0900_an_s1_r0 vn_op1_0900_an_s1_r0 0 sky130_fd_pr__nfet_01v8 L=0.15 W=1 nf=1 ad=0.29 as=0.29 pd=2.58 ps=2.58 mult=1 m=1
XMP1_op1_0900_an_s1_r0 rbl_op1_0900_an_s1_r0 ref_op1_0900_an_s1_r0 vp_op1_0900_an_s1_r0 vdd sky130_fd_pr__pfet_01v8 L=0.15 W=2 nf=1 ad=0.58 as=0.58 pd=4.58 ps=4.58 mult=1 m=1
XMP2_op1_0900_an_s1_r0 ref_op1_0900_an_s1_r0 rbl_op1_0900_an_s1_r0 vp_op1_0900_an_s1_r0 vdd sky130_fd_pr__pfet_01v8 L=0.15 W=2 nf=1 ad=0.58 as=0.58 pd=4.58 ps=4.58 mult=1 m=1
XMNF_op1_0900_an_s1_r0 vn_op1_0900_an_s1_r0 en_op1_0900_an_s1_r0 0 0 sky130_fd_pr__nfet_01v8 L=0.15 W=2 nf=1 ad=0.58 as=0.58 pd=4.58 ps=4.58 mult=1 m=1
XMPH_op1_0900_an_s1_r0 vp_op1_0900_an_s1_r0 enb_op1_0900_an_s1_r0 vdd vdd sky130_fd_pr__pfet_01v8 L=0.15 W=4 nf=1 ad=1.16 as=1.16 pd=8.58 ps=8.58 mult=1 m=1
bd_op1_0900_an_s1_r0 d_op1_0900_an_s1_r0 0 v=v(rbl_op1_0900_an_s1_r0)-v(ref_op1_0900_an_s1_r0)

* ---- instance 46: op1_1000_an_s1_r0 (variant an_s1_r0; probe dec 14.9 ns, release 37 ns, meas 39 ns) ----
vctl_op1_1000_an_s1_r0 ctl_op1_1000_an_s1_r0 0 pwl(0.0000e+00 {VDD} 2.0000e-09 {VDD} 2.1000e-09 0)
* RWL driver model (EXPERIMENTAL): slew 1 ns, series R 0 ohm; cell pin = rwls_op1_1000_an_s1_r0
vrs_op1_1000_an_s1_r0 rwls_op1_1000_an_s1_r0 0 pwl(0.0000e+00 {VDD} 4.0000e-09 {VDD} 5.0000e-09 0 3.7000e-08 0 3.8000e-08 {VDD})
ven_op1_1000_an_s1_r0 en_op1_1000_an_s1_r0 0 pwl(0.0000e+00 0 1.4000e-08 0 1.4100e-08 {VDD} 3.7000e-08 {VDD} 3.7100e-08 0)
venb_op1_1000_an_s1_r0 enb_op1_1000_an_s1_r0 0 pwl(0.0000e+00 {VDD} 1.4000e-08 {VDD} 1.4100e-08 0 3.7000e-08 0 3.7100e-08 {VDD})
vww_op1_1000_an_s1_r0 wwl_op1_1000_an_s1_r0 0 pwl(0.0000e+00 0 1.5000e-08 0 1.5100e-08 {VDD} 3.5000e-08 {VDD} 3.5100e-08 0)
vwc_op1_1000_an_s1_r0 wbc_op1_1000_an_s1_r0 0 pwl(0.0000e+00 0 1.5000e-08 0 1.5100e-08 {VDD} 3.7000e-08 {VDD} 3.7100e-08 0)
swb_op1_1000_an_s1_r0 ref_op1_1000_an_s1_r0 wbl_op1_1000_an_s1_r0 wbc_op1_1000_an_s1_r0 0 swwbl
cwbl_op1_1000_an_s1_r0 wbl_op1_1000_an_s1_r0 0 {C_WBL}
spa_op1_1000_an_s1_r0 prea rbl_op1_1000_an_s1_r0 ctl_op1_1000_an_s1_r0 0 swpre
spr_op1_1000_an_s1_r0 pref ref_op1_1000_an_s1_r0 ctl_op1_1000_an_s1_r0 0 swpre
crbl_op1_1000_an_s1_r0 rbl_op1_1000_an_s1_r0 0 {C_RBL}
cref_op1_1000_an_s1_r0 ref_op1_1000_an_s1_r0 0 {C_RBL}   $ ASSUMPTION: ideal matched dummy load
XMWR_op1_1000_an_s1_r0_0 sn_op1_1000_an_s1_r0_0 wwl_op1_1000_an_s1_r0 wbl_op1_1000_an_s1_r0 0 sky130_fd_pr__nfet_01v8 L=0.15 W=0.42 nf=1 ad=0.1218 as=0.1218 pd=1.42 ps=1.42 nrd=0.69047619047619  nrs=0.69047619047619 sa=0 sb=0 sd=0 mult=1 m=1
XMRD_op1_1000_an_s1_r0_0 rbl_op1_1000_an_s1_r0 sn_op1_1000_an_s1_r0_0 rwls_op1_1000_an_s1_r0 0 sky130_fd_pr__nfet_01v8 L=0.15 W=0.42 nf=1 ad=0.1218 as=0.1218 pd=1.42 ps=1.42 nrd=0.69047619047619  nrs=0.69047619047619 sa=0 sb=0 sd=0 mult=1 m=1
csn_op1_1000_an_s1_r0_0 sn_op1_1000_an_s1_r0_0 0 {C_SN}
XMWR_op1_1000_an_s1_r0_1 sn_op1_1000_an_s1_r0_1 wwl_des wbl_op1_1000_an_s1_r0 0 sky130_fd_pr__nfet_01v8 L=0.15 W=0.42 nf=1 ad=0.1218 as=0.1218 pd=1.42 ps=1.42 nrd=0.69047619047619  nrs=0.69047619047619 sa=0 sb=0 sd=0 mult=1 m=1
XMRD_op1_1000_an_s1_r0_1 rbl_op1_1000_an_s1_r0 sn_op1_1000_an_s1_r0_1 rwl_des 0 sky130_fd_pr__nfet_01v8 L=0.15 W=0.42 nf=1 ad=0.1218 as=0.1218 pd=1.42 ps=1.42 nrd=0.69047619047619  nrs=0.69047619047619 sa=0 sb=0 sd=0 mult=1 m=1
csn_op1_1000_an_s1_r0_1 sn_op1_1000_an_s1_r0_1 0 {C_SN}
XMWR_op1_1000_an_s1_r0_2 sn_op1_1000_an_s1_r0_2 wwl_des wbl_op1_1000_an_s1_r0 0 sky130_fd_pr__nfet_01v8 L=0.15 W=0.42 nf=1 ad=0.1218 as=0.1218 pd=1.42 ps=1.42 nrd=0.69047619047619  nrs=0.69047619047619 sa=0 sb=0 sd=0 mult=1 m=1
XMRD_op1_1000_an_s1_r0_2 rbl_op1_1000_an_s1_r0 sn_op1_1000_an_s1_r0_2 rwl_des 0 sky130_fd_pr__nfet_01v8 L=0.15 W=0.42 nf=1 ad=0.1218 as=0.1218 pd=1.42 ps=1.42 nrd=0.69047619047619  nrs=0.69047619047619 sa=0 sb=0 sd=0 mult=1 m=1
csn_op1_1000_an_s1_r0_2 sn_op1_1000_an_s1_r0_2 0 {C_SN}
XMWR_op1_1000_an_s1_r0_3 sn_op1_1000_an_s1_r0_3 wwl_des wbl_op1_1000_an_s1_r0 0 sky130_fd_pr__nfet_01v8 L=0.15 W=0.42 nf=1 ad=0.1218 as=0.1218 pd=1.42 ps=1.42 nrd=0.69047619047619  nrs=0.69047619047619 sa=0 sb=0 sd=0 mult=1 m=1
XMRD_op1_1000_an_s1_r0_3 rbl_op1_1000_an_s1_r0 sn_op1_1000_an_s1_r0_3 rwl_des 0 sky130_fd_pr__nfet_01v8 L=0.15 W=0.42 nf=1 ad=0.1218 as=0.1218 pd=1.42 ps=1.42 nrd=0.69047619047619  nrs=0.69047619047619 sa=0 sb=0 sd=0 mult=1 m=1
csn_op1_1000_an_s1_r0_3 sn_op1_1000_an_s1_r0_3 0 {C_SN}
XMN1_op1_1000_an_s1_r0 rbl_op1_1000_an_s1_r0 ref_op1_1000_an_s1_r0 vn_op1_1000_an_s1_r0 0 sky130_fd_pr__nfet_01v8 L=0.15 W=1 nf=1 ad=0.29 as=0.29 pd=2.58 ps=2.58 mult=1 m=1
XMN2_op1_1000_an_s1_r0 ref_op1_1000_an_s1_r0 rbl_op1_1000_an_s1_r0 vn_op1_1000_an_s1_r0 0 sky130_fd_pr__nfet_01v8 L=0.15 W=1 nf=1 ad=0.29 as=0.29 pd=2.58 ps=2.58 mult=1 m=1
XMP1_op1_1000_an_s1_r0 rbl_op1_1000_an_s1_r0 ref_op1_1000_an_s1_r0 vp_op1_1000_an_s1_r0 vdd sky130_fd_pr__pfet_01v8 L=0.15 W=2 nf=1 ad=0.58 as=0.58 pd=4.58 ps=4.58 mult=1 m=1
XMP2_op1_1000_an_s1_r0 ref_op1_1000_an_s1_r0 rbl_op1_1000_an_s1_r0 vp_op1_1000_an_s1_r0 vdd sky130_fd_pr__pfet_01v8 L=0.15 W=2 nf=1 ad=0.58 as=0.58 pd=4.58 ps=4.58 mult=1 m=1
XMNF_op1_1000_an_s1_r0 vn_op1_1000_an_s1_r0 en_op1_1000_an_s1_r0 0 0 sky130_fd_pr__nfet_01v8 L=0.15 W=2 nf=1 ad=0.58 as=0.58 pd=4.58 ps=4.58 mult=1 m=1
XMPH_op1_1000_an_s1_r0 vp_op1_1000_an_s1_r0 enb_op1_1000_an_s1_r0 vdd vdd sky130_fd_pr__pfet_01v8 L=0.15 W=4 nf=1 ad=1.16 as=1.16 pd=8.58 ps=8.58 mult=1 m=1
bd_op1_1000_an_s1_r0 d_op1_1000_an_s1_r0 0 v=v(rbl_op1_1000_an_s1_r0)-v(ref_op1_1000_an_s1_r0)

* ---- instance 47: op0_n100_an_s1_r0 (variant an_s1_r0; probe dec 14.9 ns, release 37 ns, meas 39 ns) ----
vctl_op0_n100_an_s1_r0 ctl_op0_n100_an_s1_r0 0 pwl(0.0000e+00 {VDD} 2.0000e-09 {VDD} 2.1000e-09 0)
* RWL driver model (EXPERIMENTAL): slew 1 ns, series R 0 ohm; cell pin = rwls_op0_n100_an_s1_r0
vrs_op0_n100_an_s1_r0 rwls_op0_n100_an_s1_r0 0 pwl(0.0000e+00 {VDD} 4.0000e-09 {VDD} 5.0000e-09 0 3.7000e-08 0 3.8000e-08 {VDD})
ven_op0_n100_an_s1_r0 en_op0_n100_an_s1_r0 0 pwl(0.0000e+00 0 1.4000e-08 0 1.4100e-08 {VDD} 3.7000e-08 {VDD} 3.7100e-08 0)
venb_op0_n100_an_s1_r0 enb_op0_n100_an_s1_r0 0 pwl(0.0000e+00 {VDD} 1.4000e-08 {VDD} 1.4100e-08 0 3.7000e-08 0 3.7100e-08 {VDD})
vww_op0_n100_an_s1_r0 wwl_op0_n100_an_s1_r0 0 pwl(0.0000e+00 0 1.5000e-08 0 1.5100e-08 {VDD} 3.5000e-08 {VDD} 3.5100e-08 0)
vwc_op0_n100_an_s1_r0 wbc_op0_n100_an_s1_r0 0 pwl(0.0000e+00 0 1.5000e-08 0 1.5100e-08 {VDD} 3.7000e-08 {VDD} 3.7100e-08 0)
swb_op0_n100_an_s1_r0 ref_op0_n100_an_s1_r0 wbl_op0_n100_an_s1_r0 wbc_op0_n100_an_s1_r0 0 swwbl
cwbl_op0_n100_an_s1_r0 wbl_op0_n100_an_s1_r0 0 {C_WBL}
spa_op0_n100_an_s1_r0 prea rbl_op0_n100_an_s1_r0 ctl_op0_n100_an_s1_r0 0 swpre
spr_op0_n100_an_s1_r0 pref ref_op0_n100_an_s1_r0 ctl_op0_n100_an_s1_r0 0 swpre
crbl_op0_n100_an_s1_r0 rbl_op0_n100_an_s1_r0 0 {C_RBL}
cref_op0_n100_an_s1_r0 ref_op0_n100_an_s1_r0 0 {C_RBL}   $ ASSUMPTION: ideal matched dummy load
XMWR_op0_n100_an_s1_r0_0 sn_op0_n100_an_s1_r0_0 wwl_op0_n100_an_s1_r0 wbl_op0_n100_an_s1_r0 0 sky130_fd_pr__nfet_01v8 L=0.15 W=0.42 nf=1 ad=0.1218 as=0.1218 pd=1.42 ps=1.42 nrd=0.69047619047619  nrs=0.69047619047619 sa=0 sb=0 sd=0 mult=1 m=1
XMRD_op0_n100_an_s1_r0_0 rbl_op0_n100_an_s1_r0 sn_op0_n100_an_s1_r0_0 rwls_op0_n100_an_s1_r0 0 sky130_fd_pr__nfet_01v8 L=0.15 W=0.42 nf=1 ad=0.1218 as=0.1218 pd=1.42 ps=1.42 nrd=0.69047619047619  nrs=0.69047619047619 sa=0 sb=0 sd=0 mult=1 m=1
csn_op0_n100_an_s1_r0_0 sn_op0_n100_an_s1_r0_0 0 {C_SN}
XMWR_op0_n100_an_s1_r0_1 sn_op0_n100_an_s1_r0_1 wwl_des wbl_op0_n100_an_s1_r0 0 sky130_fd_pr__nfet_01v8 L=0.15 W=0.42 nf=1 ad=0.1218 as=0.1218 pd=1.42 ps=1.42 nrd=0.69047619047619  nrs=0.69047619047619 sa=0 sb=0 sd=0 mult=1 m=1
XMRD_op0_n100_an_s1_r0_1 rbl_op0_n100_an_s1_r0 sn_op0_n100_an_s1_r0_1 rwl_des 0 sky130_fd_pr__nfet_01v8 L=0.15 W=0.42 nf=1 ad=0.1218 as=0.1218 pd=1.42 ps=1.42 nrd=0.69047619047619  nrs=0.69047619047619 sa=0 sb=0 sd=0 mult=1 m=1
csn_op0_n100_an_s1_r0_1 sn_op0_n100_an_s1_r0_1 0 {C_SN}
XMWR_op0_n100_an_s1_r0_2 sn_op0_n100_an_s1_r0_2 wwl_des wbl_op0_n100_an_s1_r0 0 sky130_fd_pr__nfet_01v8 L=0.15 W=0.42 nf=1 ad=0.1218 as=0.1218 pd=1.42 ps=1.42 nrd=0.69047619047619  nrs=0.69047619047619 sa=0 sb=0 sd=0 mult=1 m=1
XMRD_op0_n100_an_s1_r0_2 rbl_op0_n100_an_s1_r0 sn_op0_n100_an_s1_r0_2 rwl_des 0 sky130_fd_pr__nfet_01v8 L=0.15 W=0.42 nf=1 ad=0.1218 as=0.1218 pd=1.42 ps=1.42 nrd=0.69047619047619  nrs=0.69047619047619 sa=0 sb=0 sd=0 mult=1 m=1
csn_op0_n100_an_s1_r0_2 sn_op0_n100_an_s1_r0_2 0 {C_SN}
XMWR_op0_n100_an_s1_r0_3 sn_op0_n100_an_s1_r0_3 wwl_des wbl_op0_n100_an_s1_r0 0 sky130_fd_pr__nfet_01v8 L=0.15 W=0.42 nf=1 ad=0.1218 as=0.1218 pd=1.42 ps=1.42 nrd=0.69047619047619  nrs=0.69047619047619 sa=0 sb=0 sd=0 mult=1 m=1
XMRD_op0_n100_an_s1_r0_3 rbl_op0_n100_an_s1_r0 sn_op0_n100_an_s1_r0_3 rwl_des 0 sky130_fd_pr__nfet_01v8 L=0.15 W=0.42 nf=1 ad=0.1218 as=0.1218 pd=1.42 ps=1.42 nrd=0.69047619047619  nrs=0.69047619047619 sa=0 sb=0 sd=0 mult=1 m=1
csn_op0_n100_an_s1_r0_3 sn_op0_n100_an_s1_r0_3 0 {C_SN}
XMN1_op0_n100_an_s1_r0 rbl_op0_n100_an_s1_r0 ref_op0_n100_an_s1_r0 vn_op0_n100_an_s1_r0 0 sky130_fd_pr__nfet_01v8 L=0.15 W=1 nf=1 ad=0.29 as=0.29 pd=2.58 ps=2.58 mult=1 m=1
XMN2_op0_n100_an_s1_r0 ref_op0_n100_an_s1_r0 rbl_op0_n100_an_s1_r0 vn_op0_n100_an_s1_r0 0 sky130_fd_pr__nfet_01v8 L=0.15 W=1 nf=1 ad=0.29 as=0.29 pd=2.58 ps=2.58 mult=1 m=1
XMP1_op0_n100_an_s1_r0 rbl_op0_n100_an_s1_r0 ref_op0_n100_an_s1_r0 vp_op0_n100_an_s1_r0 vdd sky130_fd_pr__pfet_01v8 L=0.15 W=2 nf=1 ad=0.58 as=0.58 pd=4.58 ps=4.58 mult=1 m=1
XMP2_op0_n100_an_s1_r0 ref_op0_n100_an_s1_r0 rbl_op0_n100_an_s1_r0 vp_op0_n100_an_s1_r0 vdd sky130_fd_pr__pfet_01v8 L=0.15 W=2 nf=1 ad=0.58 as=0.58 pd=4.58 ps=4.58 mult=1 m=1
XMNF_op0_n100_an_s1_r0 vn_op0_n100_an_s1_r0 en_op0_n100_an_s1_r0 0 0 sky130_fd_pr__nfet_01v8 L=0.15 W=2 nf=1 ad=0.58 as=0.58 pd=4.58 ps=4.58 mult=1 m=1
XMPH_op0_n100_an_s1_r0 vp_op0_n100_an_s1_r0 enb_op0_n100_an_s1_r0 vdd vdd sky130_fd_pr__pfet_01v8 L=0.15 W=4 nf=1 ad=1.16 as=1.16 pd=8.58 ps=8.58 mult=1 m=1
bd_op0_n100_an_s1_r0 d_op0_n100_an_s1_r0 0 v=v(rbl_op0_n100_an_s1_r0)-v(ref_op0_n100_an_s1_r0)

* ---- instance 48: op0_0000_an_s1_r0 (variant an_s1_r0; probe dec 14.9 ns, release 37 ns, meas 39 ns) ----
vctl_op0_0000_an_s1_r0 ctl_op0_0000_an_s1_r0 0 pwl(0.0000e+00 {VDD} 2.0000e-09 {VDD} 2.1000e-09 0)
* RWL driver model (EXPERIMENTAL): slew 1 ns, series R 0 ohm; cell pin = rwls_op0_0000_an_s1_r0
vrs_op0_0000_an_s1_r0 rwls_op0_0000_an_s1_r0 0 pwl(0.0000e+00 {VDD} 4.0000e-09 {VDD} 5.0000e-09 0 3.7000e-08 0 3.8000e-08 {VDD})
ven_op0_0000_an_s1_r0 en_op0_0000_an_s1_r0 0 pwl(0.0000e+00 0 1.4000e-08 0 1.4100e-08 {VDD} 3.7000e-08 {VDD} 3.7100e-08 0)
venb_op0_0000_an_s1_r0 enb_op0_0000_an_s1_r0 0 pwl(0.0000e+00 {VDD} 1.4000e-08 {VDD} 1.4100e-08 0 3.7000e-08 0 3.7100e-08 {VDD})
vww_op0_0000_an_s1_r0 wwl_op0_0000_an_s1_r0 0 pwl(0.0000e+00 0 1.5000e-08 0 1.5100e-08 {VDD} 3.5000e-08 {VDD} 3.5100e-08 0)
vwc_op0_0000_an_s1_r0 wbc_op0_0000_an_s1_r0 0 pwl(0.0000e+00 0 1.5000e-08 0 1.5100e-08 {VDD} 3.7000e-08 {VDD} 3.7100e-08 0)
swb_op0_0000_an_s1_r0 ref_op0_0000_an_s1_r0 wbl_op0_0000_an_s1_r0 wbc_op0_0000_an_s1_r0 0 swwbl
cwbl_op0_0000_an_s1_r0 wbl_op0_0000_an_s1_r0 0 {C_WBL}
spa_op0_0000_an_s1_r0 prea rbl_op0_0000_an_s1_r0 ctl_op0_0000_an_s1_r0 0 swpre
spr_op0_0000_an_s1_r0 pref ref_op0_0000_an_s1_r0 ctl_op0_0000_an_s1_r0 0 swpre
crbl_op0_0000_an_s1_r0 rbl_op0_0000_an_s1_r0 0 {C_RBL}
cref_op0_0000_an_s1_r0 ref_op0_0000_an_s1_r0 0 {C_RBL}   $ ASSUMPTION: ideal matched dummy load
XMWR_op0_0000_an_s1_r0_0 sn_op0_0000_an_s1_r0_0 wwl_op0_0000_an_s1_r0 wbl_op0_0000_an_s1_r0 0 sky130_fd_pr__nfet_01v8 L=0.15 W=0.42 nf=1 ad=0.1218 as=0.1218 pd=1.42 ps=1.42 nrd=0.69047619047619  nrs=0.69047619047619 sa=0 sb=0 sd=0 mult=1 m=1
XMRD_op0_0000_an_s1_r0_0 rbl_op0_0000_an_s1_r0 sn_op0_0000_an_s1_r0_0 rwls_op0_0000_an_s1_r0 0 sky130_fd_pr__nfet_01v8 L=0.15 W=0.42 nf=1 ad=0.1218 as=0.1218 pd=1.42 ps=1.42 nrd=0.69047619047619  nrs=0.69047619047619 sa=0 sb=0 sd=0 mult=1 m=1
csn_op0_0000_an_s1_r0_0 sn_op0_0000_an_s1_r0_0 0 {C_SN}
XMWR_op0_0000_an_s1_r0_1 sn_op0_0000_an_s1_r0_1 wwl_des wbl_op0_0000_an_s1_r0 0 sky130_fd_pr__nfet_01v8 L=0.15 W=0.42 nf=1 ad=0.1218 as=0.1218 pd=1.42 ps=1.42 nrd=0.69047619047619  nrs=0.69047619047619 sa=0 sb=0 sd=0 mult=1 m=1
XMRD_op0_0000_an_s1_r0_1 rbl_op0_0000_an_s1_r0 sn_op0_0000_an_s1_r0_1 rwl_des 0 sky130_fd_pr__nfet_01v8 L=0.15 W=0.42 nf=1 ad=0.1218 as=0.1218 pd=1.42 ps=1.42 nrd=0.69047619047619  nrs=0.69047619047619 sa=0 sb=0 sd=0 mult=1 m=1
csn_op0_0000_an_s1_r0_1 sn_op0_0000_an_s1_r0_1 0 {C_SN}
XMWR_op0_0000_an_s1_r0_2 sn_op0_0000_an_s1_r0_2 wwl_des wbl_op0_0000_an_s1_r0 0 sky130_fd_pr__nfet_01v8 L=0.15 W=0.42 nf=1 ad=0.1218 as=0.1218 pd=1.42 ps=1.42 nrd=0.69047619047619  nrs=0.69047619047619 sa=0 sb=0 sd=0 mult=1 m=1
XMRD_op0_0000_an_s1_r0_2 rbl_op0_0000_an_s1_r0 sn_op0_0000_an_s1_r0_2 rwl_des 0 sky130_fd_pr__nfet_01v8 L=0.15 W=0.42 nf=1 ad=0.1218 as=0.1218 pd=1.42 ps=1.42 nrd=0.69047619047619  nrs=0.69047619047619 sa=0 sb=0 sd=0 mult=1 m=1
csn_op0_0000_an_s1_r0_2 sn_op0_0000_an_s1_r0_2 0 {C_SN}
XMWR_op0_0000_an_s1_r0_3 sn_op0_0000_an_s1_r0_3 wwl_des wbl_op0_0000_an_s1_r0 0 sky130_fd_pr__nfet_01v8 L=0.15 W=0.42 nf=1 ad=0.1218 as=0.1218 pd=1.42 ps=1.42 nrd=0.69047619047619  nrs=0.69047619047619 sa=0 sb=0 sd=0 mult=1 m=1
XMRD_op0_0000_an_s1_r0_3 rbl_op0_0000_an_s1_r0 sn_op0_0000_an_s1_r0_3 rwl_des 0 sky130_fd_pr__nfet_01v8 L=0.15 W=0.42 nf=1 ad=0.1218 as=0.1218 pd=1.42 ps=1.42 nrd=0.69047619047619  nrs=0.69047619047619 sa=0 sb=0 sd=0 mult=1 m=1
csn_op0_0000_an_s1_r0_3 sn_op0_0000_an_s1_r0_3 0 {C_SN}
XMN1_op0_0000_an_s1_r0 rbl_op0_0000_an_s1_r0 ref_op0_0000_an_s1_r0 vn_op0_0000_an_s1_r0 0 sky130_fd_pr__nfet_01v8 L=0.15 W=1 nf=1 ad=0.29 as=0.29 pd=2.58 ps=2.58 mult=1 m=1
XMN2_op0_0000_an_s1_r0 ref_op0_0000_an_s1_r0 rbl_op0_0000_an_s1_r0 vn_op0_0000_an_s1_r0 0 sky130_fd_pr__nfet_01v8 L=0.15 W=1 nf=1 ad=0.29 as=0.29 pd=2.58 ps=2.58 mult=1 m=1
XMP1_op0_0000_an_s1_r0 rbl_op0_0000_an_s1_r0 ref_op0_0000_an_s1_r0 vp_op0_0000_an_s1_r0 vdd sky130_fd_pr__pfet_01v8 L=0.15 W=2 nf=1 ad=0.58 as=0.58 pd=4.58 ps=4.58 mult=1 m=1
XMP2_op0_0000_an_s1_r0 ref_op0_0000_an_s1_r0 rbl_op0_0000_an_s1_r0 vp_op0_0000_an_s1_r0 vdd sky130_fd_pr__pfet_01v8 L=0.15 W=2 nf=1 ad=0.58 as=0.58 pd=4.58 ps=4.58 mult=1 m=1
XMNF_op0_0000_an_s1_r0 vn_op0_0000_an_s1_r0 en_op0_0000_an_s1_r0 0 0 sky130_fd_pr__nfet_01v8 L=0.15 W=2 nf=1 ad=0.58 as=0.58 pd=4.58 ps=4.58 mult=1 m=1
XMPH_op0_0000_an_s1_r0 vp_op0_0000_an_s1_r0 enb_op0_0000_an_s1_r0 vdd vdd sky130_fd_pr__pfet_01v8 L=0.15 W=4 nf=1 ad=1.16 as=1.16 pd=8.58 ps=8.58 mult=1 m=1
bd_op0_0000_an_s1_r0 d_op0_0000_an_s1_r0 0 v=v(rbl_op0_0000_an_s1_r0)-v(ref_op0_0000_an_s1_r0)

* ---- instance 49: op1_0900_an_s2_r0 (variant an_s2_r0; probe dec 14.9 ns, release 37 ns, meas 39 ns) ----
vctl_op1_0900_an_s2_r0 ctl_op1_0900_an_s2_r0 0 pwl(0.0000e+00 {VDD} 2.0000e-09 {VDD} 2.1000e-09 0)
* RWL driver model (EXPERIMENTAL): slew 2 ns, series R 0 ohm; cell pin = rwls_op1_0900_an_s2_r0
vrs_op1_0900_an_s2_r0 rwls_op1_0900_an_s2_r0 0 pwl(0.0000e+00 {VDD} 4.0000e-09 {VDD} 6.0000e-09 0 3.7000e-08 0 3.9000e-08 {VDD})
ven_op1_0900_an_s2_r0 en_op1_0900_an_s2_r0 0 pwl(0.0000e+00 0 1.4000e-08 0 1.4100e-08 {VDD} 3.7000e-08 {VDD} 3.7100e-08 0)
venb_op1_0900_an_s2_r0 enb_op1_0900_an_s2_r0 0 pwl(0.0000e+00 {VDD} 1.4000e-08 {VDD} 1.4100e-08 0 3.7000e-08 0 3.7100e-08 {VDD})
vww_op1_0900_an_s2_r0 wwl_op1_0900_an_s2_r0 0 pwl(0.0000e+00 0 1.5000e-08 0 1.5100e-08 {VDD} 3.5000e-08 {VDD} 3.5100e-08 0)
vwc_op1_0900_an_s2_r0 wbc_op1_0900_an_s2_r0 0 pwl(0.0000e+00 0 1.5000e-08 0 1.5100e-08 {VDD} 3.7000e-08 {VDD} 3.7100e-08 0)
swb_op1_0900_an_s2_r0 ref_op1_0900_an_s2_r0 wbl_op1_0900_an_s2_r0 wbc_op1_0900_an_s2_r0 0 swwbl
cwbl_op1_0900_an_s2_r0 wbl_op1_0900_an_s2_r0 0 {C_WBL}
spa_op1_0900_an_s2_r0 prea rbl_op1_0900_an_s2_r0 ctl_op1_0900_an_s2_r0 0 swpre
spr_op1_0900_an_s2_r0 pref ref_op1_0900_an_s2_r0 ctl_op1_0900_an_s2_r0 0 swpre
crbl_op1_0900_an_s2_r0 rbl_op1_0900_an_s2_r0 0 {C_RBL}
cref_op1_0900_an_s2_r0 ref_op1_0900_an_s2_r0 0 {C_RBL}   $ ASSUMPTION: ideal matched dummy load
XMWR_op1_0900_an_s2_r0_0 sn_op1_0900_an_s2_r0_0 wwl_op1_0900_an_s2_r0 wbl_op1_0900_an_s2_r0 0 sky130_fd_pr__nfet_01v8 L=0.15 W=0.42 nf=1 ad=0.1218 as=0.1218 pd=1.42 ps=1.42 nrd=0.69047619047619  nrs=0.69047619047619 sa=0 sb=0 sd=0 mult=1 m=1
XMRD_op1_0900_an_s2_r0_0 rbl_op1_0900_an_s2_r0 sn_op1_0900_an_s2_r0_0 rwls_op1_0900_an_s2_r0 0 sky130_fd_pr__nfet_01v8 L=0.15 W=0.42 nf=1 ad=0.1218 as=0.1218 pd=1.42 ps=1.42 nrd=0.69047619047619  nrs=0.69047619047619 sa=0 sb=0 sd=0 mult=1 m=1
csn_op1_0900_an_s2_r0_0 sn_op1_0900_an_s2_r0_0 0 {C_SN}
XMWR_op1_0900_an_s2_r0_1 sn_op1_0900_an_s2_r0_1 wwl_des wbl_op1_0900_an_s2_r0 0 sky130_fd_pr__nfet_01v8 L=0.15 W=0.42 nf=1 ad=0.1218 as=0.1218 pd=1.42 ps=1.42 nrd=0.69047619047619  nrs=0.69047619047619 sa=0 sb=0 sd=0 mult=1 m=1
XMRD_op1_0900_an_s2_r0_1 rbl_op1_0900_an_s2_r0 sn_op1_0900_an_s2_r0_1 rwl_des 0 sky130_fd_pr__nfet_01v8 L=0.15 W=0.42 nf=1 ad=0.1218 as=0.1218 pd=1.42 ps=1.42 nrd=0.69047619047619  nrs=0.69047619047619 sa=0 sb=0 sd=0 mult=1 m=1
csn_op1_0900_an_s2_r0_1 sn_op1_0900_an_s2_r0_1 0 {C_SN}
XMWR_op1_0900_an_s2_r0_2 sn_op1_0900_an_s2_r0_2 wwl_des wbl_op1_0900_an_s2_r0 0 sky130_fd_pr__nfet_01v8 L=0.15 W=0.42 nf=1 ad=0.1218 as=0.1218 pd=1.42 ps=1.42 nrd=0.69047619047619  nrs=0.69047619047619 sa=0 sb=0 sd=0 mult=1 m=1
XMRD_op1_0900_an_s2_r0_2 rbl_op1_0900_an_s2_r0 sn_op1_0900_an_s2_r0_2 rwl_des 0 sky130_fd_pr__nfet_01v8 L=0.15 W=0.42 nf=1 ad=0.1218 as=0.1218 pd=1.42 ps=1.42 nrd=0.69047619047619  nrs=0.69047619047619 sa=0 sb=0 sd=0 mult=1 m=1
csn_op1_0900_an_s2_r0_2 sn_op1_0900_an_s2_r0_2 0 {C_SN}
XMWR_op1_0900_an_s2_r0_3 sn_op1_0900_an_s2_r0_3 wwl_des wbl_op1_0900_an_s2_r0 0 sky130_fd_pr__nfet_01v8 L=0.15 W=0.42 nf=1 ad=0.1218 as=0.1218 pd=1.42 ps=1.42 nrd=0.69047619047619  nrs=0.69047619047619 sa=0 sb=0 sd=0 mult=1 m=1
XMRD_op1_0900_an_s2_r0_3 rbl_op1_0900_an_s2_r0 sn_op1_0900_an_s2_r0_3 rwl_des 0 sky130_fd_pr__nfet_01v8 L=0.15 W=0.42 nf=1 ad=0.1218 as=0.1218 pd=1.42 ps=1.42 nrd=0.69047619047619  nrs=0.69047619047619 sa=0 sb=0 sd=0 mult=1 m=1
csn_op1_0900_an_s2_r0_3 sn_op1_0900_an_s2_r0_3 0 {C_SN}
XMN1_op1_0900_an_s2_r0 rbl_op1_0900_an_s2_r0 ref_op1_0900_an_s2_r0 vn_op1_0900_an_s2_r0 0 sky130_fd_pr__nfet_01v8 L=0.15 W=1 nf=1 ad=0.29 as=0.29 pd=2.58 ps=2.58 mult=1 m=1
XMN2_op1_0900_an_s2_r0 ref_op1_0900_an_s2_r0 rbl_op1_0900_an_s2_r0 vn_op1_0900_an_s2_r0 0 sky130_fd_pr__nfet_01v8 L=0.15 W=1 nf=1 ad=0.29 as=0.29 pd=2.58 ps=2.58 mult=1 m=1
XMP1_op1_0900_an_s2_r0 rbl_op1_0900_an_s2_r0 ref_op1_0900_an_s2_r0 vp_op1_0900_an_s2_r0 vdd sky130_fd_pr__pfet_01v8 L=0.15 W=2 nf=1 ad=0.58 as=0.58 pd=4.58 ps=4.58 mult=1 m=1
XMP2_op1_0900_an_s2_r0 ref_op1_0900_an_s2_r0 rbl_op1_0900_an_s2_r0 vp_op1_0900_an_s2_r0 vdd sky130_fd_pr__pfet_01v8 L=0.15 W=2 nf=1 ad=0.58 as=0.58 pd=4.58 ps=4.58 mult=1 m=1
XMNF_op1_0900_an_s2_r0 vn_op1_0900_an_s2_r0 en_op1_0900_an_s2_r0 0 0 sky130_fd_pr__nfet_01v8 L=0.15 W=2 nf=1 ad=0.58 as=0.58 pd=4.58 ps=4.58 mult=1 m=1
XMPH_op1_0900_an_s2_r0 vp_op1_0900_an_s2_r0 enb_op1_0900_an_s2_r0 vdd vdd sky130_fd_pr__pfet_01v8 L=0.15 W=4 nf=1 ad=1.16 as=1.16 pd=8.58 ps=8.58 mult=1 m=1
bd_op1_0900_an_s2_r0 d_op1_0900_an_s2_r0 0 v=v(rbl_op1_0900_an_s2_r0)-v(ref_op1_0900_an_s2_r0)

* ---- instance 50: op1_1000_an_s2_r0 (variant an_s2_r0; probe dec 14.9 ns, release 37 ns, meas 39 ns) ----
vctl_op1_1000_an_s2_r0 ctl_op1_1000_an_s2_r0 0 pwl(0.0000e+00 {VDD} 2.0000e-09 {VDD} 2.1000e-09 0)
* RWL driver model (EXPERIMENTAL): slew 2 ns, series R 0 ohm; cell pin = rwls_op1_1000_an_s2_r0
vrs_op1_1000_an_s2_r0 rwls_op1_1000_an_s2_r0 0 pwl(0.0000e+00 {VDD} 4.0000e-09 {VDD} 6.0000e-09 0 3.7000e-08 0 3.9000e-08 {VDD})
ven_op1_1000_an_s2_r0 en_op1_1000_an_s2_r0 0 pwl(0.0000e+00 0 1.4000e-08 0 1.4100e-08 {VDD} 3.7000e-08 {VDD} 3.7100e-08 0)
venb_op1_1000_an_s2_r0 enb_op1_1000_an_s2_r0 0 pwl(0.0000e+00 {VDD} 1.4000e-08 {VDD} 1.4100e-08 0 3.7000e-08 0 3.7100e-08 {VDD})
vww_op1_1000_an_s2_r0 wwl_op1_1000_an_s2_r0 0 pwl(0.0000e+00 0 1.5000e-08 0 1.5100e-08 {VDD} 3.5000e-08 {VDD} 3.5100e-08 0)
vwc_op1_1000_an_s2_r0 wbc_op1_1000_an_s2_r0 0 pwl(0.0000e+00 0 1.5000e-08 0 1.5100e-08 {VDD} 3.7000e-08 {VDD} 3.7100e-08 0)
swb_op1_1000_an_s2_r0 ref_op1_1000_an_s2_r0 wbl_op1_1000_an_s2_r0 wbc_op1_1000_an_s2_r0 0 swwbl
cwbl_op1_1000_an_s2_r0 wbl_op1_1000_an_s2_r0 0 {C_WBL}
spa_op1_1000_an_s2_r0 prea rbl_op1_1000_an_s2_r0 ctl_op1_1000_an_s2_r0 0 swpre
spr_op1_1000_an_s2_r0 pref ref_op1_1000_an_s2_r0 ctl_op1_1000_an_s2_r0 0 swpre
crbl_op1_1000_an_s2_r0 rbl_op1_1000_an_s2_r0 0 {C_RBL}
cref_op1_1000_an_s2_r0 ref_op1_1000_an_s2_r0 0 {C_RBL}   $ ASSUMPTION: ideal matched dummy load
XMWR_op1_1000_an_s2_r0_0 sn_op1_1000_an_s2_r0_0 wwl_op1_1000_an_s2_r0 wbl_op1_1000_an_s2_r0 0 sky130_fd_pr__nfet_01v8 L=0.15 W=0.42 nf=1 ad=0.1218 as=0.1218 pd=1.42 ps=1.42 nrd=0.69047619047619  nrs=0.69047619047619 sa=0 sb=0 sd=0 mult=1 m=1
XMRD_op1_1000_an_s2_r0_0 rbl_op1_1000_an_s2_r0 sn_op1_1000_an_s2_r0_0 rwls_op1_1000_an_s2_r0 0 sky130_fd_pr__nfet_01v8 L=0.15 W=0.42 nf=1 ad=0.1218 as=0.1218 pd=1.42 ps=1.42 nrd=0.69047619047619  nrs=0.69047619047619 sa=0 sb=0 sd=0 mult=1 m=1
csn_op1_1000_an_s2_r0_0 sn_op1_1000_an_s2_r0_0 0 {C_SN}
XMWR_op1_1000_an_s2_r0_1 sn_op1_1000_an_s2_r0_1 wwl_des wbl_op1_1000_an_s2_r0 0 sky130_fd_pr__nfet_01v8 L=0.15 W=0.42 nf=1 ad=0.1218 as=0.1218 pd=1.42 ps=1.42 nrd=0.69047619047619  nrs=0.69047619047619 sa=0 sb=0 sd=0 mult=1 m=1
XMRD_op1_1000_an_s2_r0_1 rbl_op1_1000_an_s2_r0 sn_op1_1000_an_s2_r0_1 rwl_des 0 sky130_fd_pr__nfet_01v8 L=0.15 W=0.42 nf=1 ad=0.1218 as=0.1218 pd=1.42 ps=1.42 nrd=0.69047619047619  nrs=0.69047619047619 sa=0 sb=0 sd=0 mult=1 m=1
csn_op1_1000_an_s2_r0_1 sn_op1_1000_an_s2_r0_1 0 {C_SN}
XMWR_op1_1000_an_s2_r0_2 sn_op1_1000_an_s2_r0_2 wwl_des wbl_op1_1000_an_s2_r0 0 sky130_fd_pr__nfet_01v8 L=0.15 W=0.42 nf=1 ad=0.1218 as=0.1218 pd=1.42 ps=1.42 nrd=0.69047619047619  nrs=0.69047619047619 sa=0 sb=0 sd=0 mult=1 m=1
XMRD_op1_1000_an_s2_r0_2 rbl_op1_1000_an_s2_r0 sn_op1_1000_an_s2_r0_2 rwl_des 0 sky130_fd_pr__nfet_01v8 L=0.15 W=0.42 nf=1 ad=0.1218 as=0.1218 pd=1.42 ps=1.42 nrd=0.69047619047619  nrs=0.69047619047619 sa=0 sb=0 sd=0 mult=1 m=1
csn_op1_1000_an_s2_r0_2 sn_op1_1000_an_s2_r0_2 0 {C_SN}
XMWR_op1_1000_an_s2_r0_3 sn_op1_1000_an_s2_r0_3 wwl_des wbl_op1_1000_an_s2_r0 0 sky130_fd_pr__nfet_01v8 L=0.15 W=0.42 nf=1 ad=0.1218 as=0.1218 pd=1.42 ps=1.42 nrd=0.69047619047619  nrs=0.69047619047619 sa=0 sb=0 sd=0 mult=1 m=1
XMRD_op1_1000_an_s2_r0_3 rbl_op1_1000_an_s2_r0 sn_op1_1000_an_s2_r0_3 rwl_des 0 sky130_fd_pr__nfet_01v8 L=0.15 W=0.42 nf=1 ad=0.1218 as=0.1218 pd=1.42 ps=1.42 nrd=0.69047619047619  nrs=0.69047619047619 sa=0 sb=0 sd=0 mult=1 m=1
csn_op1_1000_an_s2_r0_3 sn_op1_1000_an_s2_r0_3 0 {C_SN}
XMN1_op1_1000_an_s2_r0 rbl_op1_1000_an_s2_r0 ref_op1_1000_an_s2_r0 vn_op1_1000_an_s2_r0 0 sky130_fd_pr__nfet_01v8 L=0.15 W=1 nf=1 ad=0.29 as=0.29 pd=2.58 ps=2.58 mult=1 m=1
XMN2_op1_1000_an_s2_r0 ref_op1_1000_an_s2_r0 rbl_op1_1000_an_s2_r0 vn_op1_1000_an_s2_r0 0 sky130_fd_pr__nfet_01v8 L=0.15 W=1 nf=1 ad=0.29 as=0.29 pd=2.58 ps=2.58 mult=1 m=1
XMP1_op1_1000_an_s2_r0 rbl_op1_1000_an_s2_r0 ref_op1_1000_an_s2_r0 vp_op1_1000_an_s2_r0 vdd sky130_fd_pr__pfet_01v8 L=0.15 W=2 nf=1 ad=0.58 as=0.58 pd=4.58 ps=4.58 mult=1 m=1
XMP2_op1_1000_an_s2_r0 ref_op1_1000_an_s2_r0 rbl_op1_1000_an_s2_r0 vp_op1_1000_an_s2_r0 vdd sky130_fd_pr__pfet_01v8 L=0.15 W=2 nf=1 ad=0.58 as=0.58 pd=4.58 ps=4.58 mult=1 m=1
XMNF_op1_1000_an_s2_r0 vn_op1_1000_an_s2_r0 en_op1_1000_an_s2_r0 0 0 sky130_fd_pr__nfet_01v8 L=0.15 W=2 nf=1 ad=0.58 as=0.58 pd=4.58 ps=4.58 mult=1 m=1
XMPH_op1_1000_an_s2_r0 vp_op1_1000_an_s2_r0 enb_op1_1000_an_s2_r0 vdd vdd sky130_fd_pr__pfet_01v8 L=0.15 W=4 nf=1 ad=1.16 as=1.16 pd=8.58 ps=8.58 mult=1 m=1
bd_op1_1000_an_s2_r0 d_op1_1000_an_s2_r0 0 v=v(rbl_op1_1000_an_s2_r0)-v(ref_op1_1000_an_s2_r0)

* ---- instance 51: op0_n100_an_s2_r0 (variant an_s2_r0; probe dec 14.9 ns, release 37 ns, meas 39 ns) ----
vctl_op0_n100_an_s2_r0 ctl_op0_n100_an_s2_r0 0 pwl(0.0000e+00 {VDD} 2.0000e-09 {VDD} 2.1000e-09 0)
* RWL driver model (EXPERIMENTAL): slew 2 ns, series R 0 ohm; cell pin = rwls_op0_n100_an_s2_r0
vrs_op0_n100_an_s2_r0 rwls_op0_n100_an_s2_r0 0 pwl(0.0000e+00 {VDD} 4.0000e-09 {VDD} 6.0000e-09 0 3.7000e-08 0 3.9000e-08 {VDD})
ven_op0_n100_an_s2_r0 en_op0_n100_an_s2_r0 0 pwl(0.0000e+00 0 1.4000e-08 0 1.4100e-08 {VDD} 3.7000e-08 {VDD} 3.7100e-08 0)
venb_op0_n100_an_s2_r0 enb_op0_n100_an_s2_r0 0 pwl(0.0000e+00 {VDD} 1.4000e-08 {VDD} 1.4100e-08 0 3.7000e-08 0 3.7100e-08 {VDD})
vww_op0_n100_an_s2_r0 wwl_op0_n100_an_s2_r0 0 pwl(0.0000e+00 0 1.5000e-08 0 1.5100e-08 {VDD} 3.5000e-08 {VDD} 3.5100e-08 0)
vwc_op0_n100_an_s2_r0 wbc_op0_n100_an_s2_r0 0 pwl(0.0000e+00 0 1.5000e-08 0 1.5100e-08 {VDD} 3.7000e-08 {VDD} 3.7100e-08 0)
swb_op0_n100_an_s2_r0 ref_op0_n100_an_s2_r0 wbl_op0_n100_an_s2_r0 wbc_op0_n100_an_s2_r0 0 swwbl
cwbl_op0_n100_an_s2_r0 wbl_op0_n100_an_s2_r0 0 {C_WBL}
spa_op0_n100_an_s2_r0 prea rbl_op0_n100_an_s2_r0 ctl_op0_n100_an_s2_r0 0 swpre
spr_op0_n100_an_s2_r0 pref ref_op0_n100_an_s2_r0 ctl_op0_n100_an_s2_r0 0 swpre
crbl_op0_n100_an_s2_r0 rbl_op0_n100_an_s2_r0 0 {C_RBL}
cref_op0_n100_an_s2_r0 ref_op0_n100_an_s2_r0 0 {C_RBL}   $ ASSUMPTION: ideal matched dummy load
XMWR_op0_n100_an_s2_r0_0 sn_op0_n100_an_s2_r0_0 wwl_op0_n100_an_s2_r0 wbl_op0_n100_an_s2_r0 0 sky130_fd_pr__nfet_01v8 L=0.15 W=0.42 nf=1 ad=0.1218 as=0.1218 pd=1.42 ps=1.42 nrd=0.69047619047619  nrs=0.69047619047619 sa=0 sb=0 sd=0 mult=1 m=1
XMRD_op0_n100_an_s2_r0_0 rbl_op0_n100_an_s2_r0 sn_op0_n100_an_s2_r0_0 rwls_op0_n100_an_s2_r0 0 sky130_fd_pr__nfet_01v8 L=0.15 W=0.42 nf=1 ad=0.1218 as=0.1218 pd=1.42 ps=1.42 nrd=0.69047619047619  nrs=0.69047619047619 sa=0 sb=0 sd=0 mult=1 m=1
csn_op0_n100_an_s2_r0_0 sn_op0_n100_an_s2_r0_0 0 {C_SN}
XMWR_op0_n100_an_s2_r0_1 sn_op0_n100_an_s2_r0_1 wwl_des wbl_op0_n100_an_s2_r0 0 sky130_fd_pr__nfet_01v8 L=0.15 W=0.42 nf=1 ad=0.1218 as=0.1218 pd=1.42 ps=1.42 nrd=0.69047619047619  nrs=0.69047619047619 sa=0 sb=0 sd=0 mult=1 m=1
XMRD_op0_n100_an_s2_r0_1 rbl_op0_n100_an_s2_r0 sn_op0_n100_an_s2_r0_1 rwl_des 0 sky130_fd_pr__nfet_01v8 L=0.15 W=0.42 nf=1 ad=0.1218 as=0.1218 pd=1.42 ps=1.42 nrd=0.69047619047619  nrs=0.69047619047619 sa=0 sb=0 sd=0 mult=1 m=1
csn_op0_n100_an_s2_r0_1 sn_op0_n100_an_s2_r0_1 0 {C_SN}
XMWR_op0_n100_an_s2_r0_2 sn_op0_n100_an_s2_r0_2 wwl_des wbl_op0_n100_an_s2_r0 0 sky130_fd_pr__nfet_01v8 L=0.15 W=0.42 nf=1 ad=0.1218 as=0.1218 pd=1.42 ps=1.42 nrd=0.69047619047619  nrs=0.69047619047619 sa=0 sb=0 sd=0 mult=1 m=1
XMRD_op0_n100_an_s2_r0_2 rbl_op0_n100_an_s2_r0 sn_op0_n100_an_s2_r0_2 rwl_des 0 sky130_fd_pr__nfet_01v8 L=0.15 W=0.42 nf=1 ad=0.1218 as=0.1218 pd=1.42 ps=1.42 nrd=0.69047619047619  nrs=0.69047619047619 sa=0 sb=0 sd=0 mult=1 m=1
csn_op0_n100_an_s2_r0_2 sn_op0_n100_an_s2_r0_2 0 {C_SN}
XMWR_op0_n100_an_s2_r0_3 sn_op0_n100_an_s2_r0_3 wwl_des wbl_op0_n100_an_s2_r0 0 sky130_fd_pr__nfet_01v8 L=0.15 W=0.42 nf=1 ad=0.1218 as=0.1218 pd=1.42 ps=1.42 nrd=0.69047619047619  nrs=0.69047619047619 sa=0 sb=0 sd=0 mult=1 m=1
XMRD_op0_n100_an_s2_r0_3 rbl_op0_n100_an_s2_r0 sn_op0_n100_an_s2_r0_3 rwl_des 0 sky130_fd_pr__nfet_01v8 L=0.15 W=0.42 nf=1 ad=0.1218 as=0.1218 pd=1.42 ps=1.42 nrd=0.69047619047619  nrs=0.69047619047619 sa=0 sb=0 sd=0 mult=1 m=1
csn_op0_n100_an_s2_r0_3 sn_op0_n100_an_s2_r0_3 0 {C_SN}
XMN1_op0_n100_an_s2_r0 rbl_op0_n100_an_s2_r0 ref_op0_n100_an_s2_r0 vn_op0_n100_an_s2_r0 0 sky130_fd_pr__nfet_01v8 L=0.15 W=1 nf=1 ad=0.29 as=0.29 pd=2.58 ps=2.58 mult=1 m=1
XMN2_op0_n100_an_s2_r0 ref_op0_n100_an_s2_r0 rbl_op0_n100_an_s2_r0 vn_op0_n100_an_s2_r0 0 sky130_fd_pr__nfet_01v8 L=0.15 W=1 nf=1 ad=0.29 as=0.29 pd=2.58 ps=2.58 mult=1 m=1
XMP1_op0_n100_an_s2_r0 rbl_op0_n100_an_s2_r0 ref_op0_n100_an_s2_r0 vp_op0_n100_an_s2_r0 vdd sky130_fd_pr__pfet_01v8 L=0.15 W=2 nf=1 ad=0.58 as=0.58 pd=4.58 ps=4.58 mult=1 m=1
XMP2_op0_n100_an_s2_r0 ref_op0_n100_an_s2_r0 rbl_op0_n100_an_s2_r0 vp_op0_n100_an_s2_r0 vdd sky130_fd_pr__pfet_01v8 L=0.15 W=2 nf=1 ad=0.58 as=0.58 pd=4.58 ps=4.58 mult=1 m=1
XMNF_op0_n100_an_s2_r0 vn_op0_n100_an_s2_r0 en_op0_n100_an_s2_r0 0 0 sky130_fd_pr__nfet_01v8 L=0.15 W=2 nf=1 ad=0.58 as=0.58 pd=4.58 ps=4.58 mult=1 m=1
XMPH_op0_n100_an_s2_r0 vp_op0_n100_an_s2_r0 enb_op0_n100_an_s2_r0 vdd vdd sky130_fd_pr__pfet_01v8 L=0.15 W=4 nf=1 ad=1.16 as=1.16 pd=8.58 ps=8.58 mult=1 m=1
bd_op0_n100_an_s2_r0 d_op0_n100_an_s2_r0 0 v=v(rbl_op0_n100_an_s2_r0)-v(ref_op0_n100_an_s2_r0)

* ---- instance 52: op0_0000_an_s2_r0 (variant an_s2_r0; probe dec 14.9 ns, release 37 ns, meas 39 ns) ----
vctl_op0_0000_an_s2_r0 ctl_op0_0000_an_s2_r0 0 pwl(0.0000e+00 {VDD} 2.0000e-09 {VDD} 2.1000e-09 0)
* RWL driver model (EXPERIMENTAL): slew 2 ns, series R 0 ohm; cell pin = rwls_op0_0000_an_s2_r0
vrs_op0_0000_an_s2_r0 rwls_op0_0000_an_s2_r0 0 pwl(0.0000e+00 {VDD} 4.0000e-09 {VDD} 6.0000e-09 0 3.7000e-08 0 3.9000e-08 {VDD})
ven_op0_0000_an_s2_r0 en_op0_0000_an_s2_r0 0 pwl(0.0000e+00 0 1.4000e-08 0 1.4100e-08 {VDD} 3.7000e-08 {VDD} 3.7100e-08 0)
venb_op0_0000_an_s2_r0 enb_op0_0000_an_s2_r0 0 pwl(0.0000e+00 {VDD} 1.4000e-08 {VDD} 1.4100e-08 0 3.7000e-08 0 3.7100e-08 {VDD})
vww_op0_0000_an_s2_r0 wwl_op0_0000_an_s2_r0 0 pwl(0.0000e+00 0 1.5000e-08 0 1.5100e-08 {VDD} 3.5000e-08 {VDD} 3.5100e-08 0)
vwc_op0_0000_an_s2_r0 wbc_op0_0000_an_s2_r0 0 pwl(0.0000e+00 0 1.5000e-08 0 1.5100e-08 {VDD} 3.7000e-08 {VDD} 3.7100e-08 0)
swb_op0_0000_an_s2_r0 ref_op0_0000_an_s2_r0 wbl_op0_0000_an_s2_r0 wbc_op0_0000_an_s2_r0 0 swwbl
cwbl_op0_0000_an_s2_r0 wbl_op0_0000_an_s2_r0 0 {C_WBL}
spa_op0_0000_an_s2_r0 prea rbl_op0_0000_an_s2_r0 ctl_op0_0000_an_s2_r0 0 swpre
spr_op0_0000_an_s2_r0 pref ref_op0_0000_an_s2_r0 ctl_op0_0000_an_s2_r0 0 swpre
crbl_op0_0000_an_s2_r0 rbl_op0_0000_an_s2_r0 0 {C_RBL}
cref_op0_0000_an_s2_r0 ref_op0_0000_an_s2_r0 0 {C_RBL}   $ ASSUMPTION: ideal matched dummy load
XMWR_op0_0000_an_s2_r0_0 sn_op0_0000_an_s2_r0_0 wwl_op0_0000_an_s2_r0 wbl_op0_0000_an_s2_r0 0 sky130_fd_pr__nfet_01v8 L=0.15 W=0.42 nf=1 ad=0.1218 as=0.1218 pd=1.42 ps=1.42 nrd=0.69047619047619  nrs=0.69047619047619 sa=0 sb=0 sd=0 mult=1 m=1
XMRD_op0_0000_an_s2_r0_0 rbl_op0_0000_an_s2_r0 sn_op0_0000_an_s2_r0_0 rwls_op0_0000_an_s2_r0 0 sky130_fd_pr__nfet_01v8 L=0.15 W=0.42 nf=1 ad=0.1218 as=0.1218 pd=1.42 ps=1.42 nrd=0.69047619047619  nrs=0.69047619047619 sa=0 sb=0 sd=0 mult=1 m=1
csn_op0_0000_an_s2_r0_0 sn_op0_0000_an_s2_r0_0 0 {C_SN}
XMWR_op0_0000_an_s2_r0_1 sn_op0_0000_an_s2_r0_1 wwl_des wbl_op0_0000_an_s2_r0 0 sky130_fd_pr__nfet_01v8 L=0.15 W=0.42 nf=1 ad=0.1218 as=0.1218 pd=1.42 ps=1.42 nrd=0.69047619047619  nrs=0.69047619047619 sa=0 sb=0 sd=0 mult=1 m=1
XMRD_op0_0000_an_s2_r0_1 rbl_op0_0000_an_s2_r0 sn_op0_0000_an_s2_r0_1 rwl_des 0 sky130_fd_pr__nfet_01v8 L=0.15 W=0.42 nf=1 ad=0.1218 as=0.1218 pd=1.42 ps=1.42 nrd=0.69047619047619  nrs=0.69047619047619 sa=0 sb=0 sd=0 mult=1 m=1
csn_op0_0000_an_s2_r0_1 sn_op0_0000_an_s2_r0_1 0 {C_SN}
XMWR_op0_0000_an_s2_r0_2 sn_op0_0000_an_s2_r0_2 wwl_des wbl_op0_0000_an_s2_r0 0 sky130_fd_pr__nfet_01v8 L=0.15 W=0.42 nf=1 ad=0.1218 as=0.1218 pd=1.42 ps=1.42 nrd=0.69047619047619  nrs=0.69047619047619 sa=0 sb=0 sd=0 mult=1 m=1
XMRD_op0_0000_an_s2_r0_2 rbl_op0_0000_an_s2_r0 sn_op0_0000_an_s2_r0_2 rwl_des 0 sky130_fd_pr__nfet_01v8 L=0.15 W=0.42 nf=1 ad=0.1218 as=0.1218 pd=1.42 ps=1.42 nrd=0.69047619047619  nrs=0.69047619047619 sa=0 sb=0 sd=0 mult=1 m=1
csn_op0_0000_an_s2_r0_2 sn_op0_0000_an_s2_r0_2 0 {C_SN}
XMWR_op0_0000_an_s2_r0_3 sn_op0_0000_an_s2_r0_3 wwl_des wbl_op0_0000_an_s2_r0 0 sky130_fd_pr__nfet_01v8 L=0.15 W=0.42 nf=1 ad=0.1218 as=0.1218 pd=1.42 ps=1.42 nrd=0.69047619047619  nrs=0.69047619047619 sa=0 sb=0 sd=0 mult=1 m=1
XMRD_op0_0000_an_s2_r0_3 rbl_op0_0000_an_s2_r0 sn_op0_0000_an_s2_r0_3 rwl_des 0 sky130_fd_pr__nfet_01v8 L=0.15 W=0.42 nf=1 ad=0.1218 as=0.1218 pd=1.42 ps=1.42 nrd=0.69047619047619  nrs=0.69047619047619 sa=0 sb=0 sd=0 mult=1 m=1
csn_op0_0000_an_s2_r0_3 sn_op0_0000_an_s2_r0_3 0 {C_SN}
XMN1_op0_0000_an_s2_r0 rbl_op0_0000_an_s2_r0 ref_op0_0000_an_s2_r0 vn_op0_0000_an_s2_r0 0 sky130_fd_pr__nfet_01v8 L=0.15 W=1 nf=1 ad=0.29 as=0.29 pd=2.58 ps=2.58 mult=1 m=1
XMN2_op0_0000_an_s2_r0 ref_op0_0000_an_s2_r0 rbl_op0_0000_an_s2_r0 vn_op0_0000_an_s2_r0 0 sky130_fd_pr__nfet_01v8 L=0.15 W=1 nf=1 ad=0.29 as=0.29 pd=2.58 ps=2.58 mult=1 m=1
XMP1_op0_0000_an_s2_r0 rbl_op0_0000_an_s2_r0 ref_op0_0000_an_s2_r0 vp_op0_0000_an_s2_r0 vdd sky130_fd_pr__pfet_01v8 L=0.15 W=2 nf=1 ad=0.58 as=0.58 pd=4.58 ps=4.58 mult=1 m=1
XMP2_op0_0000_an_s2_r0 ref_op0_0000_an_s2_r0 rbl_op0_0000_an_s2_r0 vp_op0_0000_an_s2_r0 vdd sky130_fd_pr__pfet_01v8 L=0.15 W=2 nf=1 ad=0.58 as=0.58 pd=4.58 ps=4.58 mult=1 m=1
XMNF_op0_0000_an_s2_r0 vn_op0_0000_an_s2_r0 en_op0_0000_an_s2_r0 0 0 sky130_fd_pr__nfet_01v8 L=0.15 W=2 nf=1 ad=0.58 as=0.58 pd=4.58 ps=4.58 mult=1 m=1
XMPH_op0_0000_an_s2_r0 vp_op0_0000_an_s2_r0 enb_op0_0000_an_s2_r0 vdd vdd sky130_fd_pr__pfet_01v8 L=0.15 W=4 nf=1 ad=1.16 as=1.16 pd=8.58 ps=8.58 mult=1 m=1
bd_op0_0000_an_s2_r0 d_op0_0000_an_s2_r0 0 v=v(rbl_op0_0000_an_s2_r0)-v(ref_op0_0000_an_s2_r0)

* ---- instance 53: op1_0900_an_s5_r0 (variant an_s5_r0; probe dec 14.9 ns, release 37 ns, meas 39 ns) ----
vctl_op1_0900_an_s5_r0 ctl_op1_0900_an_s5_r0 0 pwl(0.0000e+00 {VDD} 2.0000e-09 {VDD} 2.1000e-09 0)
* RWL driver model (EXPERIMENTAL): slew 5 ns, series R 0 ohm; cell pin = rwls_op1_0900_an_s5_r0
vrs_op1_0900_an_s5_r0 rwls_op1_0900_an_s5_r0 0 pwl(0.0000e+00 {VDD} 4.0000e-09 {VDD} 9.0000e-09 0 3.7000e-08 0 4.2000e-08 {VDD})
ven_op1_0900_an_s5_r0 en_op1_0900_an_s5_r0 0 pwl(0.0000e+00 0 1.4000e-08 0 1.4100e-08 {VDD} 3.7000e-08 {VDD} 3.7100e-08 0)
venb_op1_0900_an_s5_r0 enb_op1_0900_an_s5_r0 0 pwl(0.0000e+00 {VDD} 1.4000e-08 {VDD} 1.4100e-08 0 3.7000e-08 0 3.7100e-08 {VDD})
vww_op1_0900_an_s5_r0 wwl_op1_0900_an_s5_r0 0 pwl(0.0000e+00 0 1.5000e-08 0 1.5100e-08 {VDD} 3.5000e-08 {VDD} 3.5100e-08 0)
vwc_op1_0900_an_s5_r0 wbc_op1_0900_an_s5_r0 0 pwl(0.0000e+00 0 1.5000e-08 0 1.5100e-08 {VDD} 3.7000e-08 {VDD} 3.7100e-08 0)
swb_op1_0900_an_s5_r0 ref_op1_0900_an_s5_r0 wbl_op1_0900_an_s5_r0 wbc_op1_0900_an_s5_r0 0 swwbl
cwbl_op1_0900_an_s5_r0 wbl_op1_0900_an_s5_r0 0 {C_WBL}
spa_op1_0900_an_s5_r0 prea rbl_op1_0900_an_s5_r0 ctl_op1_0900_an_s5_r0 0 swpre
spr_op1_0900_an_s5_r0 pref ref_op1_0900_an_s5_r0 ctl_op1_0900_an_s5_r0 0 swpre
crbl_op1_0900_an_s5_r0 rbl_op1_0900_an_s5_r0 0 {C_RBL}
cref_op1_0900_an_s5_r0 ref_op1_0900_an_s5_r0 0 {C_RBL}   $ ASSUMPTION: ideal matched dummy load
XMWR_op1_0900_an_s5_r0_0 sn_op1_0900_an_s5_r0_0 wwl_op1_0900_an_s5_r0 wbl_op1_0900_an_s5_r0 0 sky130_fd_pr__nfet_01v8 L=0.15 W=0.42 nf=1 ad=0.1218 as=0.1218 pd=1.42 ps=1.42 nrd=0.69047619047619  nrs=0.69047619047619 sa=0 sb=0 sd=0 mult=1 m=1
XMRD_op1_0900_an_s5_r0_0 rbl_op1_0900_an_s5_r0 sn_op1_0900_an_s5_r0_0 rwls_op1_0900_an_s5_r0 0 sky130_fd_pr__nfet_01v8 L=0.15 W=0.42 nf=1 ad=0.1218 as=0.1218 pd=1.42 ps=1.42 nrd=0.69047619047619  nrs=0.69047619047619 sa=0 sb=0 sd=0 mult=1 m=1
csn_op1_0900_an_s5_r0_0 sn_op1_0900_an_s5_r0_0 0 {C_SN}
XMWR_op1_0900_an_s5_r0_1 sn_op1_0900_an_s5_r0_1 wwl_des wbl_op1_0900_an_s5_r0 0 sky130_fd_pr__nfet_01v8 L=0.15 W=0.42 nf=1 ad=0.1218 as=0.1218 pd=1.42 ps=1.42 nrd=0.69047619047619  nrs=0.69047619047619 sa=0 sb=0 sd=0 mult=1 m=1
XMRD_op1_0900_an_s5_r0_1 rbl_op1_0900_an_s5_r0 sn_op1_0900_an_s5_r0_1 rwl_des 0 sky130_fd_pr__nfet_01v8 L=0.15 W=0.42 nf=1 ad=0.1218 as=0.1218 pd=1.42 ps=1.42 nrd=0.69047619047619  nrs=0.69047619047619 sa=0 sb=0 sd=0 mult=1 m=1
csn_op1_0900_an_s5_r0_1 sn_op1_0900_an_s5_r0_1 0 {C_SN}
XMWR_op1_0900_an_s5_r0_2 sn_op1_0900_an_s5_r0_2 wwl_des wbl_op1_0900_an_s5_r0 0 sky130_fd_pr__nfet_01v8 L=0.15 W=0.42 nf=1 ad=0.1218 as=0.1218 pd=1.42 ps=1.42 nrd=0.69047619047619  nrs=0.69047619047619 sa=0 sb=0 sd=0 mult=1 m=1
XMRD_op1_0900_an_s5_r0_2 rbl_op1_0900_an_s5_r0 sn_op1_0900_an_s5_r0_2 rwl_des 0 sky130_fd_pr__nfet_01v8 L=0.15 W=0.42 nf=1 ad=0.1218 as=0.1218 pd=1.42 ps=1.42 nrd=0.69047619047619  nrs=0.69047619047619 sa=0 sb=0 sd=0 mult=1 m=1
csn_op1_0900_an_s5_r0_2 sn_op1_0900_an_s5_r0_2 0 {C_SN}
XMWR_op1_0900_an_s5_r0_3 sn_op1_0900_an_s5_r0_3 wwl_des wbl_op1_0900_an_s5_r0 0 sky130_fd_pr__nfet_01v8 L=0.15 W=0.42 nf=1 ad=0.1218 as=0.1218 pd=1.42 ps=1.42 nrd=0.69047619047619  nrs=0.69047619047619 sa=0 sb=0 sd=0 mult=1 m=1
XMRD_op1_0900_an_s5_r0_3 rbl_op1_0900_an_s5_r0 sn_op1_0900_an_s5_r0_3 rwl_des 0 sky130_fd_pr__nfet_01v8 L=0.15 W=0.42 nf=1 ad=0.1218 as=0.1218 pd=1.42 ps=1.42 nrd=0.69047619047619  nrs=0.69047619047619 sa=0 sb=0 sd=0 mult=1 m=1
csn_op1_0900_an_s5_r0_3 sn_op1_0900_an_s5_r0_3 0 {C_SN}
XMN1_op1_0900_an_s5_r0 rbl_op1_0900_an_s5_r0 ref_op1_0900_an_s5_r0 vn_op1_0900_an_s5_r0 0 sky130_fd_pr__nfet_01v8 L=0.15 W=1 nf=1 ad=0.29 as=0.29 pd=2.58 ps=2.58 mult=1 m=1
XMN2_op1_0900_an_s5_r0 ref_op1_0900_an_s5_r0 rbl_op1_0900_an_s5_r0 vn_op1_0900_an_s5_r0 0 sky130_fd_pr__nfet_01v8 L=0.15 W=1 nf=1 ad=0.29 as=0.29 pd=2.58 ps=2.58 mult=1 m=1
XMP1_op1_0900_an_s5_r0 rbl_op1_0900_an_s5_r0 ref_op1_0900_an_s5_r0 vp_op1_0900_an_s5_r0 vdd sky130_fd_pr__pfet_01v8 L=0.15 W=2 nf=1 ad=0.58 as=0.58 pd=4.58 ps=4.58 mult=1 m=1
XMP2_op1_0900_an_s5_r0 ref_op1_0900_an_s5_r0 rbl_op1_0900_an_s5_r0 vp_op1_0900_an_s5_r0 vdd sky130_fd_pr__pfet_01v8 L=0.15 W=2 nf=1 ad=0.58 as=0.58 pd=4.58 ps=4.58 mult=1 m=1
XMNF_op1_0900_an_s5_r0 vn_op1_0900_an_s5_r0 en_op1_0900_an_s5_r0 0 0 sky130_fd_pr__nfet_01v8 L=0.15 W=2 nf=1 ad=0.58 as=0.58 pd=4.58 ps=4.58 mult=1 m=1
XMPH_op1_0900_an_s5_r0 vp_op1_0900_an_s5_r0 enb_op1_0900_an_s5_r0 vdd vdd sky130_fd_pr__pfet_01v8 L=0.15 W=4 nf=1 ad=1.16 as=1.16 pd=8.58 ps=8.58 mult=1 m=1
bd_op1_0900_an_s5_r0 d_op1_0900_an_s5_r0 0 v=v(rbl_op1_0900_an_s5_r0)-v(ref_op1_0900_an_s5_r0)

* ---- instance 54: op1_1000_an_s5_r0 (variant an_s5_r0; probe dec 14.9 ns, release 37 ns, meas 39 ns) ----
vctl_op1_1000_an_s5_r0 ctl_op1_1000_an_s5_r0 0 pwl(0.0000e+00 {VDD} 2.0000e-09 {VDD} 2.1000e-09 0)
* RWL driver model (EXPERIMENTAL): slew 5 ns, series R 0 ohm; cell pin = rwls_op1_1000_an_s5_r0
vrs_op1_1000_an_s5_r0 rwls_op1_1000_an_s5_r0 0 pwl(0.0000e+00 {VDD} 4.0000e-09 {VDD} 9.0000e-09 0 3.7000e-08 0 4.2000e-08 {VDD})
ven_op1_1000_an_s5_r0 en_op1_1000_an_s5_r0 0 pwl(0.0000e+00 0 1.4000e-08 0 1.4100e-08 {VDD} 3.7000e-08 {VDD} 3.7100e-08 0)
venb_op1_1000_an_s5_r0 enb_op1_1000_an_s5_r0 0 pwl(0.0000e+00 {VDD} 1.4000e-08 {VDD} 1.4100e-08 0 3.7000e-08 0 3.7100e-08 {VDD})
vww_op1_1000_an_s5_r0 wwl_op1_1000_an_s5_r0 0 pwl(0.0000e+00 0 1.5000e-08 0 1.5100e-08 {VDD} 3.5000e-08 {VDD} 3.5100e-08 0)
vwc_op1_1000_an_s5_r0 wbc_op1_1000_an_s5_r0 0 pwl(0.0000e+00 0 1.5000e-08 0 1.5100e-08 {VDD} 3.7000e-08 {VDD} 3.7100e-08 0)
swb_op1_1000_an_s5_r0 ref_op1_1000_an_s5_r0 wbl_op1_1000_an_s5_r0 wbc_op1_1000_an_s5_r0 0 swwbl
cwbl_op1_1000_an_s5_r0 wbl_op1_1000_an_s5_r0 0 {C_WBL}
spa_op1_1000_an_s5_r0 prea rbl_op1_1000_an_s5_r0 ctl_op1_1000_an_s5_r0 0 swpre
spr_op1_1000_an_s5_r0 pref ref_op1_1000_an_s5_r0 ctl_op1_1000_an_s5_r0 0 swpre
crbl_op1_1000_an_s5_r0 rbl_op1_1000_an_s5_r0 0 {C_RBL}
cref_op1_1000_an_s5_r0 ref_op1_1000_an_s5_r0 0 {C_RBL}   $ ASSUMPTION: ideal matched dummy load
XMWR_op1_1000_an_s5_r0_0 sn_op1_1000_an_s5_r0_0 wwl_op1_1000_an_s5_r0 wbl_op1_1000_an_s5_r0 0 sky130_fd_pr__nfet_01v8 L=0.15 W=0.42 nf=1 ad=0.1218 as=0.1218 pd=1.42 ps=1.42 nrd=0.69047619047619  nrs=0.69047619047619 sa=0 sb=0 sd=0 mult=1 m=1
XMRD_op1_1000_an_s5_r0_0 rbl_op1_1000_an_s5_r0 sn_op1_1000_an_s5_r0_0 rwls_op1_1000_an_s5_r0 0 sky130_fd_pr__nfet_01v8 L=0.15 W=0.42 nf=1 ad=0.1218 as=0.1218 pd=1.42 ps=1.42 nrd=0.69047619047619  nrs=0.69047619047619 sa=0 sb=0 sd=0 mult=1 m=1
csn_op1_1000_an_s5_r0_0 sn_op1_1000_an_s5_r0_0 0 {C_SN}
XMWR_op1_1000_an_s5_r0_1 sn_op1_1000_an_s5_r0_1 wwl_des wbl_op1_1000_an_s5_r0 0 sky130_fd_pr__nfet_01v8 L=0.15 W=0.42 nf=1 ad=0.1218 as=0.1218 pd=1.42 ps=1.42 nrd=0.69047619047619  nrs=0.69047619047619 sa=0 sb=0 sd=0 mult=1 m=1
XMRD_op1_1000_an_s5_r0_1 rbl_op1_1000_an_s5_r0 sn_op1_1000_an_s5_r0_1 rwl_des 0 sky130_fd_pr__nfet_01v8 L=0.15 W=0.42 nf=1 ad=0.1218 as=0.1218 pd=1.42 ps=1.42 nrd=0.69047619047619  nrs=0.69047619047619 sa=0 sb=0 sd=0 mult=1 m=1
csn_op1_1000_an_s5_r0_1 sn_op1_1000_an_s5_r0_1 0 {C_SN}
XMWR_op1_1000_an_s5_r0_2 sn_op1_1000_an_s5_r0_2 wwl_des wbl_op1_1000_an_s5_r0 0 sky130_fd_pr__nfet_01v8 L=0.15 W=0.42 nf=1 ad=0.1218 as=0.1218 pd=1.42 ps=1.42 nrd=0.69047619047619  nrs=0.69047619047619 sa=0 sb=0 sd=0 mult=1 m=1
XMRD_op1_1000_an_s5_r0_2 rbl_op1_1000_an_s5_r0 sn_op1_1000_an_s5_r0_2 rwl_des 0 sky130_fd_pr__nfet_01v8 L=0.15 W=0.42 nf=1 ad=0.1218 as=0.1218 pd=1.42 ps=1.42 nrd=0.69047619047619  nrs=0.69047619047619 sa=0 sb=0 sd=0 mult=1 m=1
csn_op1_1000_an_s5_r0_2 sn_op1_1000_an_s5_r0_2 0 {C_SN}
XMWR_op1_1000_an_s5_r0_3 sn_op1_1000_an_s5_r0_3 wwl_des wbl_op1_1000_an_s5_r0 0 sky130_fd_pr__nfet_01v8 L=0.15 W=0.42 nf=1 ad=0.1218 as=0.1218 pd=1.42 ps=1.42 nrd=0.69047619047619  nrs=0.69047619047619 sa=0 sb=0 sd=0 mult=1 m=1
XMRD_op1_1000_an_s5_r0_3 rbl_op1_1000_an_s5_r0 sn_op1_1000_an_s5_r0_3 rwl_des 0 sky130_fd_pr__nfet_01v8 L=0.15 W=0.42 nf=1 ad=0.1218 as=0.1218 pd=1.42 ps=1.42 nrd=0.69047619047619  nrs=0.69047619047619 sa=0 sb=0 sd=0 mult=1 m=1
csn_op1_1000_an_s5_r0_3 sn_op1_1000_an_s5_r0_3 0 {C_SN}
XMN1_op1_1000_an_s5_r0 rbl_op1_1000_an_s5_r0 ref_op1_1000_an_s5_r0 vn_op1_1000_an_s5_r0 0 sky130_fd_pr__nfet_01v8 L=0.15 W=1 nf=1 ad=0.29 as=0.29 pd=2.58 ps=2.58 mult=1 m=1
XMN2_op1_1000_an_s5_r0 ref_op1_1000_an_s5_r0 rbl_op1_1000_an_s5_r0 vn_op1_1000_an_s5_r0 0 sky130_fd_pr__nfet_01v8 L=0.15 W=1 nf=1 ad=0.29 as=0.29 pd=2.58 ps=2.58 mult=1 m=1
XMP1_op1_1000_an_s5_r0 rbl_op1_1000_an_s5_r0 ref_op1_1000_an_s5_r0 vp_op1_1000_an_s5_r0 vdd sky130_fd_pr__pfet_01v8 L=0.15 W=2 nf=1 ad=0.58 as=0.58 pd=4.58 ps=4.58 mult=1 m=1
XMP2_op1_1000_an_s5_r0 ref_op1_1000_an_s5_r0 rbl_op1_1000_an_s5_r0 vp_op1_1000_an_s5_r0 vdd sky130_fd_pr__pfet_01v8 L=0.15 W=2 nf=1 ad=0.58 as=0.58 pd=4.58 ps=4.58 mult=1 m=1
XMNF_op1_1000_an_s5_r0 vn_op1_1000_an_s5_r0 en_op1_1000_an_s5_r0 0 0 sky130_fd_pr__nfet_01v8 L=0.15 W=2 nf=1 ad=0.58 as=0.58 pd=4.58 ps=4.58 mult=1 m=1
XMPH_op1_1000_an_s5_r0 vp_op1_1000_an_s5_r0 enb_op1_1000_an_s5_r0 vdd vdd sky130_fd_pr__pfet_01v8 L=0.15 W=4 nf=1 ad=1.16 as=1.16 pd=8.58 ps=8.58 mult=1 m=1
bd_op1_1000_an_s5_r0 d_op1_1000_an_s5_r0 0 v=v(rbl_op1_1000_an_s5_r0)-v(ref_op1_1000_an_s5_r0)

* ---- instance 55: op0_n100_an_s5_r0 (variant an_s5_r0; probe dec 14.9 ns, release 37 ns, meas 39 ns) ----
vctl_op0_n100_an_s5_r0 ctl_op0_n100_an_s5_r0 0 pwl(0.0000e+00 {VDD} 2.0000e-09 {VDD} 2.1000e-09 0)
* RWL driver model (EXPERIMENTAL): slew 5 ns, series R 0 ohm; cell pin = rwls_op0_n100_an_s5_r0
vrs_op0_n100_an_s5_r0 rwls_op0_n100_an_s5_r0 0 pwl(0.0000e+00 {VDD} 4.0000e-09 {VDD} 9.0000e-09 0 3.7000e-08 0 4.2000e-08 {VDD})
ven_op0_n100_an_s5_r0 en_op0_n100_an_s5_r0 0 pwl(0.0000e+00 0 1.4000e-08 0 1.4100e-08 {VDD} 3.7000e-08 {VDD} 3.7100e-08 0)
venb_op0_n100_an_s5_r0 enb_op0_n100_an_s5_r0 0 pwl(0.0000e+00 {VDD} 1.4000e-08 {VDD} 1.4100e-08 0 3.7000e-08 0 3.7100e-08 {VDD})
vww_op0_n100_an_s5_r0 wwl_op0_n100_an_s5_r0 0 pwl(0.0000e+00 0 1.5000e-08 0 1.5100e-08 {VDD} 3.5000e-08 {VDD} 3.5100e-08 0)
vwc_op0_n100_an_s5_r0 wbc_op0_n100_an_s5_r0 0 pwl(0.0000e+00 0 1.5000e-08 0 1.5100e-08 {VDD} 3.7000e-08 {VDD} 3.7100e-08 0)
swb_op0_n100_an_s5_r0 ref_op0_n100_an_s5_r0 wbl_op0_n100_an_s5_r0 wbc_op0_n100_an_s5_r0 0 swwbl
cwbl_op0_n100_an_s5_r0 wbl_op0_n100_an_s5_r0 0 {C_WBL}
spa_op0_n100_an_s5_r0 prea rbl_op0_n100_an_s5_r0 ctl_op0_n100_an_s5_r0 0 swpre
spr_op0_n100_an_s5_r0 pref ref_op0_n100_an_s5_r0 ctl_op0_n100_an_s5_r0 0 swpre
crbl_op0_n100_an_s5_r0 rbl_op0_n100_an_s5_r0 0 {C_RBL}
cref_op0_n100_an_s5_r0 ref_op0_n100_an_s5_r0 0 {C_RBL}   $ ASSUMPTION: ideal matched dummy load
XMWR_op0_n100_an_s5_r0_0 sn_op0_n100_an_s5_r0_0 wwl_op0_n100_an_s5_r0 wbl_op0_n100_an_s5_r0 0 sky130_fd_pr__nfet_01v8 L=0.15 W=0.42 nf=1 ad=0.1218 as=0.1218 pd=1.42 ps=1.42 nrd=0.69047619047619  nrs=0.69047619047619 sa=0 sb=0 sd=0 mult=1 m=1
XMRD_op0_n100_an_s5_r0_0 rbl_op0_n100_an_s5_r0 sn_op0_n100_an_s5_r0_0 rwls_op0_n100_an_s5_r0 0 sky130_fd_pr__nfet_01v8 L=0.15 W=0.42 nf=1 ad=0.1218 as=0.1218 pd=1.42 ps=1.42 nrd=0.69047619047619  nrs=0.69047619047619 sa=0 sb=0 sd=0 mult=1 m=1
csn_op0_n100_an_s5_r0_0 sn_op0_n100_an_s5_r0_0 0 {C_SN}
XMWR_op0_n100_an_s5_r0_1 sn_op0_n100_an_s5_r0_1 wwl_des wbl_op0_n100_an_s5_r0 0 sky130_fd_pr__nfet_01v8 L=0.15 W=0.42 nf=1 ad=0.1218 as=0.1218 pd=1.42 ps=1.42 nrd=0.69047619047619  nrs=0.69047619047619 sa=0 sb=0 sd=0 mult=1 m=1
XMRD_op0_n100_an_s5_r0_1 rbl_op0_n100_an_s5_r0 sn_op0_n100_an_s5_r0_1 rwl_des 0 sky130_fd_pr__nfet_01v8 L=0.15 W=0.42 nf=1 ad=0.1218 as=0.1218 pd=1.42 ps=1.42 nrd=0.69047619047619  nrs=0.69047619047619 sa=0 sb=0 sd=0 mult=1 m=1
csn_op0_n100_an_s5_r0_1 sn_op0_n100_an_s5_r0_1 0 {C_SN}
XMWR_op0_n100_an_s5_r0_2 sn_op0_n100_an_s5_r0_2 wwl_des wbl_op0_n100_an_s5_r0 0 sky130_fd_pr__nfet_01v8 L=0.15 W=0.42 nf=1 ad=0.1218 as=0.1218 pd=1.42 ps=1.42 nrd=0.69047619047619  nrs=0.69047619047619 sa=0 sb=0 sd=0 mult=1 m=1
XMRD_op0_n100_an_s5_r0_2 rbl_op0_n100_an_s5_r0 sn_op0_n100_an_s5_r0_2 rwl_des 0 sky130_fd_pr__nfet_01v8 L=0.15 W=0.42 nf=1 ad=0.1218 as=0.1218 pd=1.42 ps=1.42 nrd=0.69047619047619  nrs=0.69047619047619 sa=0 sb=0 sd=0 mult=1 m=1
csn_op0_n100_an_s5_r0_2 sn_op0_n100_an_s5_r0_2 0 {C_SN}
XMWR_op0_n100_an_s5_r0_3 sn_op0_n100_an_s5_r0_3 wwl_des wbl_op0_n100_an_s5_r0 0 sky130_fd_pr__nfet_01v8 L=0.15 W=0.42 nf=1 ad=0.1218 as=0.1218 pd=1.42 ps=1.42 nrd=0.69047619047619  nrs=0.69047619047619 sa=0 sb=0 sd=0 mult=1 m=1
XMRD_op0_n100_an_s5_r0_3 rbl_op0_n100_an_s5_r0 sn_op0_n100_an_s5_r0_3 rwl_des 0 sky130_fd_pr__nfet_01v8 L=0.15 W=0.42 nf=1 ad=0.1218 as=0.1218 pd=1.42 ps=1.42 nrd=0.69047619047619  nrs=0.69047619047619 sa=0 sb=0 sd=0 mult=1 m=1
csn_op0_n100_an_s5_r0_3 sn_op0_n100_an_s5_r0_3 0 {C_SN}
XMN1_op0_n100_an_s5_r0 rbl_op0_n100_an_s5_r0 ref_op0_n100_an_s5_r0 vn_op0_n100_an_s5_r0 0 sky130_fd_pr__nfet_01v8 L=0.15 W=1 nf=1 ad=0.29 as=0.29 pd=2.58 ps=2.58 mult=1 m=1
XMN2_op0_n100_an_s5_r0 ref_op0_n100_an_s5_r0 rbl_op0_n100_an_s5_r0 vn_op0_n100_an_s5_r0 0 sky130_fd_pr__nfet_01v8 L=0.15 W=1 nf=1 ad=0.29 as=0.29 pd=2.58 ps=2.58 mult=1 m=1
XMP1_op0_n100_an_s5_r0 rbl_op0_n100_an_s5_r0 ref_op0_n100_an_s5_r0 vp_op0_n100_an_s5_r0 vdd sky130_fd_pr__pfet_01v8 L=0.15 W=2 nf=1 ad=0.58 as=0.58 pd=4.58 ps=4.58 mult=1 m=1
XMP2_op0_n100_an_s5_r0 ref_op0_n100_an_s5_r0 rbl_op0_n100_an_s5_r0 vp_op0_n100_an_s5_r0 vdd sky130_fd_pr__pfet_01v8 L=0.15 W=2 nf=1 ad=0.58 as=0.58 pd=4.58 ps=4.58 mult=1 m=1
XMNF_op0_n100_an_s5_r0 vn_op0_n100_an_s5_r0 en_op0_n100_an_s5_r0 0 0 sky130_fd_pr__nfet_01v8 L=0.15 W=2 nf=1 ad=0.58 as=0.58 pd=4.58 ps=4.58 mult=1 m=1
XMPH_op0_n100_an_s5_r0 vp_op0_n100_an_s5_r0 enb_op0_n100_an_s5_r0 vdd vdd sky130_fd_pr__pfet_01v8 L=0.15 W=4 nf=1 ad=1.16 as=1.16 pd=8.58 ps=8.58 mult=1 m=1
bd_op0_n100_an_s5_r0 d_op0_n100_an_s5_r0 0 v=v(rbl_op0_n100_an_s5_r0)-v(ref_op0_n100_an_s5_r0)

* ---- instance 56: op0_0000_an_s5_r0 (variant an_s5_r0; probe dec 14.9 ns, release 37 ns, meas 39 ns) ----
vctl_op0_0000_an_s5_r0 ctl_op0_0000_an_s5_r0 0 pwl(0.0000e+00 {VDD} 2.0000e-09 {VDD} 2.1000e-09 0)
* RWL driver model (EXPERIMENTAL): slew 5 ns, series R 0 ohm; cell pin = rwls_op0_0000_an_s5_r0
vrs_op0_0000_an_s5_r0 rwls_op0_0000_an_s5_r0 0 pwl(0.0000e+00 {VDD} 4.0000e-09 {VDD} 9.0000e-09 0 3.7000e-08 0 4.2000e-08 {VDD})
ven_op0_0000_an_s5_r0 en_op0_0000_an_s5_r0 0 pwl(0.0000e+00 0 1.4000e-08 0 1.4100e-08 {VDD} 3.7000e-08 {VDD} 3.7100e-08 0)
venb_op0_0000_an_s5_r0 enb_op0_0000_an_s5_r0 0 pwl(0.0000e+00 {VDD} 1.4000e-08 {VDD} 1.4100e-08 0 3.7000e-08 0 3.7100e-08 {VDD})
vww_op0_0000_an_s5_r0 wwl_op0_0000_an_s5_r0 0 pwl(0.0000e+00 0 1.5000e-08 0 1.5100e-08 {VDD} 3.5000e-08 {VDD} 3.5100e-08 0)
vwc_op0_0000_an_s5_r0 wbc_op0_0000_an_s5_r0 0 pwl(0.0000e+00 0 1.5000e-08 0 1.5100e-08 {VDD} 3.7000e-08 {VDD} 3.7100e-08 0)
swb_op0_0000_an_s5_r0 ref_op0_0000_an_s5_r0 wbl_op0_0000_an_s5_r0 wbc_op0_0000_an_s5_r0 0 swwbl
cwbl_op0_0000_an_s5_r0 wbl_op0_0000_an_s5_r0 0 {C_WBL}
spa_op0_0000_an_s5_r0 prea rbl_op0_0000_an_s5_r0 ctl_op0_0000_an_s5_r0 0 swpre
spr_op0_0000_an_s5_r0 pref ref_op0_0000_an_s5_r0 ctl_op0_0000_an_s5_r0 0 swpre
crbl_op0_0000_an_s5_r0 rbl_op0_0000_an_s5_r0 0 {C_RBL}
cref_op0_0000_an_s5_r0 ref_op0_0000_an_s5_r0 0 {C_RBL}   $ ASSUMPTION: ideal matched dummy load
XMWR_op0_0000_an_s5_r0_0 sn_op0_0000_an_s5_r0_0 wwl_op0_0000_an_s5_r0 wbl_op0_0000_an_s5_r0 0 sky130_fd_pr__nfet_01v8 L=0.15 W=0.42 nf=1 ad=0.1218 as=0.1218 pd=1.42 ps=1.42 nrd=0.69047619047619  nrs=0.69047619047619 sa=0 sb=0 sd=0 mult=1 m=1
XMRD_op0_0000_an_s5_r0_0 rbl_op0_0000_an_s5_r0 sn_op0_0000_an_s5_r0_0 rwls_op0_0000_an_s5_r0 0 sky130_fd_pr__nfet_01v8 L=0.15 W=0.42 nf=1 ad=0.1218 as=0.1218 pd=1.42 ps=1.42 nrd=0.69047619047619  nrs=0.69047619047619 sa=0 sb=0 sd=0 mult=1 m=1
csn_op0_0000_an_s5_r0_0 sn_op0_0000_an_s5_r0_0 0 {C_SN}
XMWR_op0_0000_an_s5_r0_1 sn_op0_0000_an_s5_r0_1 wwl_des wbl_op0_0000_an_s5_r0 0 sky130_fd_pr__nfet_01v8 L=0.15 W=0.42 nf=1 ad=0.1218 as=0.1218 pd=1.42 ps=1.42 nrd=0.69047619047619  nrs=0.69047619047619 sa=0 sb=0 sd=0 mult=1 m=1
XMRD_op0_0000_an_s5_r0_1 rbl_op0_0000_an_s5_r0 sn_op0_0000_an_s5_r0_1 rwl_des 0 sky130_fd_pr__nfet_01v8 L=0.15 W=0.42 nf=1 ad=0.1218 as=0.1218 pd=1.42 ps=1.42 nrd=0.69047619047619  nrs=0.69047619047619 sa=0 sb=0 sd=0 mult=1 m=1
csn_op0_0000_an_s5_r0_1 sn_op0_0000_an_s5_r0_1 0 {C_SN}
XMWR_op0_0000_an_s5_r0_2 sn_op0_0000_an_s5_r0_2 wwl_des wbl_op0_0000_an_s5_r0 0 sky130_fd_pr__nfet_01v8 L=0.15 W=0.42 nf=1 ad=0.1218 as=0.1218 pd=1.42 ps=1.42 nrd=0.69047619047619  nrs=0.69047619047619 sa=0 sb=0 sd=0 mult=1 m=1
XMRD_op0_0000_an_s5_r0_2 rbl_op0_0000_an_s5_r0 sn_op0_0000_an_s5_r0_2 rwl_des 0 sky130_fd_pr__nfet_01v8 L=0.15 W=0.42 nf=1 ad=0.1218 as=0.1218 pd=1.42 ps=1.42 nrd=0.69047619047619  nrs=0.69047619047619 sa=0 sb=0 sd=0 mult=1 m=1
csn_op0_0000_an_s5_r0_2 sn_op0_0000_an_s5_r0_2 0 {C_SN}
XMWR_op0_0000_an_s5_r0_3 sn_op0_0000_an_s5_r0_3 wwl_des wbl_op0_0000_an_s5_r0 0 sky130_fd_pr__nfet_01v8 L=0.15 W=0.42 nf=1 ad=0.1218 as=0.1218 pd=1.42 ps=1.42 nrd=0.69047619047619  nrs=0.69047619047619 sa=0 sb=0 sd=0 mult=1 m=1
XMRD_op0_0000_an_s5_r0_3 rbl_op0_0000_an_s5_r0 sn_op0_0000_an_s5_r0_3 rwl_des 0 sky130_fd_pr__nfet_01v8 L=0.15 W=0.42 nf=1 ad=0.1218 as=0.1218 pd=1.42 ps=1.42 nrd=0.69047619047619  nrs=0.69047619047619 sa=0 sb=0 sd=0 mult=1 m=1
csn_op0_0000_an_s5_r0_3 sn_op0_0000_an_s5_r0_3 0 {C_SN}
XMN1_op0_0000_an_s5_r0 rbl_op0_0000_an_s5_r0 ref_op0_0000_an_s5_r0 vn_op0_0000_an_s5_r0 0 sky130_fd_pr__nfet_01v8 L=0.15 W=1 nf=1 ad=0.29 as=0.29 pd=2.58 ps=2.58 mult=1 m=1
XMN2_op0_0000_an_s5_r0 ref_op0_0000_an_s5_r0 rbl_op0_0000_an_s5_r0 vn_op0_0000_an_s5_r0 0 sky130_fd_pr__nfet_01v8 L=0.15 W=1 nf=1 ad=0.29 as=0.29 pd=2.58 ps=2.58 mult=1 m=1
XMP1_op0_0000_an_s5_r0 rbl_op0_0000_an_s5_r0 ref_op0_0000_an_s5_r0 vp_op0_0000_an_s5_r0 vdd sky130_fd_pr__pfet_01v8 L=0.15 W=2 nf=1 ad=0.58 as=0.58 pd=4.58 ps=4.58 mult=1 m=1
XMP2_op0_0000_an_s5_r0 ref_op0_0000_an_s5_r0 rbl_op0_0000_an_s5_r0 vp_op0_0000_an_s5_r0 vdd sky130_fd_pr__pfet_01v8 L=0.15 W=2 nf=1 ad=0.58 as=0.58 pd=4.58 ps=4.58 mult=1 m=1
XMNF_op0_0000_an_s5_r0 vn_op0_0000_an_s5_r0 en_op0_0000_an_s5_r0 0 0 sky130_fd_pr__nfet_01v8 L=0.15 W=2 nf=1 ad=0.58 as=0.58 pd=4.58 ps=4.58 mult=1 m=1
XMPH_op0_0000_an_s5_r0 vp_op0_0000_an_s5_r0 enb_op0_0000_an_s5_r0 vdd vdd sky130_fd_pr__pfet_01v8 L=0.15 W=4 nf=1 ad=1.16 as=1.16 pd=8.58 ps=8.58 mult=1 m=1
bd_op0_0000_an_s5_r0 d_op0_0000_an_s5_r0 0 v=v(rbl_op0_0000_an_s5_r0)-v(ref_op0_0000_an_s5_r0)

* ---- instance 57: op1_0900_an_s0p1_r1k (variant an_s0p1_r1k; probe dec 14.9 ns, release 37 ns, meas 39 ns) ----
vctl_op1_0900_an_s0p1_r1k ctl_op1_0900_an_s0p1_r1k 0 pwl(0.0000e+00 {VDD} 2.0000e-09 {VDD} 2.1000e-09 0)
* RWL driver model (EXPERIMENTAL): slew 0.1 ns, series R 1000 ohm; cell pin = rwls_op1_0900_an_s0p1_r1k
vrs_op1_0900_an_s0p1_r1k rwlsrc_op1_0900_an_s0p1_r1k 0 pwl(0.0000e+00 {VDD} 4.0000e-09 {VDD} 4.1000e-09 0 3.7000e-08 0 3.7100e-08 {VDD})
rdrv_op1_0900_an_s0p1_r1k rwlsrc_op1_0900_an_s0p1_r1k rwls_op1_0900_an_s0p1_r1k 1000
ven_op1_0900_an_s0p1_r1k en_op1_0900_an_s0p1_r1k 0 pwl(0.0000e+00 0 1.4000e-08 0 1.4100e-08 {VDD} 3.7000e-08 {VDD} 3.7100e-08 0)
venb_op1_0900_an_s0p1_r1k enb_op1_0900_an_s0p1_r1k 0 pwl(0.0000e+00 {VDD} 1.4000e-08 {VDD} 1.4100e-08 0 3.7000e-08 0 3.7100e-08 {VDD})
vww_op1_0900_an_s0p1_r1k wwl_op1_0900_an_s0p1_r1k 0 pwl(0.0000e+00 0 1.5000e-08 0 1.5100e-08 {VDD} 3.5000e-08 {VDD} 3.5100e-08 0)
vwc_op1_0900_an_s0p1_r1k wbc_op1_0900_an_s0p1_r1k 0 pwl(0.0000e+00 0 1.5000e-08 0 1.5100e-08 {VDD} 3.7000e-08 {VDD} 3.7100e-08 0)
swb_op1_0900_an_s0p1_r1k ref_op1_0900_an_s0p1_r1k wbl_op1_0900_an_s0p1_r1k wbc_op1_0900_an_s0p1_r1k 0 swwbl
cwbl_op1_0900_an_s0p1_r1k wbl_op1_0900_an_s0p1_r1k 0 {C_WBL}
spa_op1_0900_an_s0p1_r1k prea rbl_op1_0900_an_s0p1_r1k ctl_op1_0900_an_s0p1_r1k 0 swpre
spr_op1_0900_an_s0p1_r1k pref ref_op1_0900_an_s0p1_r1k ctl_op1_0900_an_s0p1_r1k 0 swpre
crbl_op1_0900_an_s0p1_r1k rbl_op1_0900_an_s0p1_r1k 0 {C_RBL}
cref_op1_0900_an_s0p1_r1k ref_op1_0900_an_s0p1_r1k 0 {C_RBL}   $ ASSUMPTION: ideal matched dummy load
XMWR_op1_0900_an_s0p1_r1k_0 sn_op1_0900_an_s0p1_r1k_0 wwl_op1_0900_an_s0p1_r1k wbl_op1_0900_an_s0p1_r1k 0 sky130_fd_pr__nfet_01v8 L=0.15 W=0.42 nf=1 ad=0.1218 as=0.1218 pd=1.42 ps=1.42 nrd=0.69047619047619  nrs=0.69047619047619 sa=0 sb=0 sd=0 mult=1 m=1
XMRD_op1_0900_an_s0p1_r1k_0 rbl_op1_0900_an_s0p1_r1k sn_op1_0900_an_s0p1_r1k_0 rwls_op1_0900_an_s0p1_r1k 0 sky130_fd_pr__nfet_01v8 L=0.15 W=0.42 nf=1 ad=0.1218 as=0.1218 pd=1.42 ps=1.42 nrd=0.69047619047619  nrs=0.69047619047619 sa=0 sb=0 sd=0 mult=1 m=1
csn_op1_0900_an_s0p1_r1k_0 sn_op1_0900_an_s0p1_r1k_0 0 {C_SN}
XMWR_op1_0900_an_s0p1_r1k_1 sn_op1_0900_an_s0p1_r1k_1 wwl_des wbl_op1_0900_an_s0p1_r1k 0 sky130_fd_pr__nfet_01v8 L=0.15 W=0.42 nf=1 ad=0.1218 as=0.1218 pd=1.42 ps=1.42 nrd=0.69047619047619  nrs=0.69047619047619 sa=0 sb=0 sd=0 mult=1 m=1
XMRD_op1_0900_an_s0p1_r1k_1 rbl_op1_0900_an_s0p1_r1k sn_op1_0900_an_s0p1_r1k_1 rwl_des 0 sky130_fd_pr__nfet_01v8 L=0.15 W=0.42 nf=1 ad=0.1218 as=0.1218 pd=1.42 ps=1.42 nrd=0.69047619047619  nrs=0.69047619047619 sa=0 sb=0 sd=0 mult=1 m=1
csn_op1_0900_an_s0p1_r1k_1 sn_op1_0900_an_s0p1_r1k_1 0 {C_SN}
XMWR_op1_0900_an_s0p1_r1k_2 sn_op1_0900_an_s0p1_r1k_2 wwl_des wbl_op1_0900_an_s0p1_r1k 0 sky130_fd_pr__nfet_01v8 L=0.15 W=0.42 nf=1 ad=0.1218 as=0.1218 pd=1.42 ps=1.42 nrd=0.69047619047619  nrs=0.69047619047619 sa=0 sb=0 sd=0 mult=1 m=1
XMRD_op1_0900_an_s0p1_r1k_2 rbl_op1_0900_an_s0p1_r1k sn_op1_0900_an_s0p1_r1k_2 rwl_des 0 sky130_fd_pr__nfet_01v8 L=0.15 W=0.42 nf=1 ad=0.1218 as=0.1218 pd=1.42 ps=1.42 nrd=0.69047619047619  nrs=0.69047619047619 sa=0 sb=0 sd=0 mult=1 m=1
csn_op1_0900_an_s0p1_r1k_2 sn_op1_0900_an_s0p1_r1k_2 0 {C_SN}
XMWR_op1_0900_an_s0p1_r1k_3 sn_op1_0900_an_s0p1_r1k_3 wwl_des wbl_op1_0900_an_s0p1_r1k 0 sky130_fd_pr__nfet_01v8 L=0.15 W=0.42 nf=1 ad=0.1218 as=0.1218 pd=1.42 ps=1.42 nrd=0.69047619047619  nrs=0.69047619047619 sa=0 sb=0 sd=0 mult=1 m=1
XMRD_op1_0900_an_s0p1_r1k_3 rbl_op1_0900_an_s0p1_r1k sn_op1_0900_an_s0p1_r1k_3 rwl_des 0 sky130_fd_pr__nfet_01v8 L=0.15 W=0.42 nf=1 ad=0.1218 as=0.1218 pd=1.42 ps=1.42 nrd=0.69047619047619  nrs=0.69047619047619 sa=0 sb=0 sd=0 mult=1 m=1
csn_op1_0900_an_s0p1_r1k_3 sn_op1_0900_an_s0p1_r1k_3 0 {C_SN}
XMN1_op1_0900_an_s0p1_r1k rbl_op1_0900_an_s0p1_r1k ref_op1_0900_an_s0p1_r1k vn_op1_0900_an_s0p1_r1k 0 sky130_fd_pr__nfet_01v8 L=0.15 W=1 nf=1 ad=0.29 as=0.29 pd=2.58 ps=2.58 mult=1 m=1
XMN2_op1_0900_an_s0p1_r1k ref_op1_0900_an_s0p1_r1k rbl_op1_0900_an_s0p1_r1k vn_op1_0900_an_s0p1_r1k 0 sky130_fd_pr__nfet_01v8 L=0.15 W=1 nf=1 ad=0.29 as=0.29 pd=2.58 ps=2.58 mult=1 m=1
XMP1_op1_0900_an_s0p1_r1k rbl_op1_0900_an_s0p1_r1k ref_op1_0900_an_s0p1_r1k vp_op1_0900_an_s0p1_r1k vdd sky130_fd_pr__pfet_01v8 L=0.15 W=2 nf=1 ad=0.58 as=0.58 pd=4.58 ps=4.58 mult=1 m=1
XMP2_op1_0900_an_s0p1_r1k ref_op1_0900_an_s0p1_r1k rbl_op1_0900_an_s0p1_r1k vp_op1_0900_an_s0p1_r1k vdd sky130_fd_pr__pfet_01v8 L=0.15 W=2 nf=1 ad=0.58 as=0.58 pd=4.58 ps=4.58 mult=1 m=1
XMNF_op1_0900_an_s0p1_r1k vn_op1_0900_an_s0p1_r1k en_op1_0900_an_s0p1_r1k 0 0 sky130_fd_pr__nfet_01v8 L=0.15 W=2 nf=1 ad=0.58 as=0.58 pd=4.58 ps=4.58 mult=1 m=1
XMPH_op1_0900_an_s0p1_r1k vp_op1_0900_an_s0p1_r1k enb_op1_0900_an_s0p1_r1k vdd vdd sky130_fd_pr__pfet_01v8 L=0.15 W=4 nf=1 ad=1.16 as=1.16 pd=8.58 ps=8.58 mult=1 m=1
bd_op1_0900_an_s0p1_r1k d_op1_0900_an_s0p1_r1k 0 v=v(rbl_op1_0900_an_s0p1_r1k)-v(ref_op1_0900_an_s0p1_r1k)

* ---- instance 58: op1_1000_an_s0p1_r1k (variant an_s0p1_r1k; probe dec 14.9 ns, release 37 ns, meas 39 ns) ----
vctl_op1_1000_an_s0p1_r1k ctl_op1_1000_an_s0p1_r1k 0 pwl(0.0000e+00 {VDD} 2.0000e-09 {VDD} 2.1000e-09 0)
* RWL driver model (EXPERIMENTAL): slew 0.1 ns, series R 1000 ohm; cell pin = rwls_op1_1000_an_s0p1_r1k
vrs_op1_1000_an_s0p1_r1k rwlsrc_op1_1000_an_s0p1_r1k 0 pwl(0.0000e+00 {VDD} 4.0000e-09 {VDD} 4.1000e-09 0 3.7000e-08 0 3.7100e-08 {VDD})
rdrv_op1_1000_an_s0p1_r1k rwlsrc_op1_1000_an_s0p1_r1k rwls_op1_1000_an_s0p1_r1k 1000
ven_op1_1000_an_s0p1_r1k en_op1_1000_an_s0p1_r1k 0 pwl(0.0000e+00 0 1.4000e-08 0 1.4100e-08 {VDD} 3.7000e-08 {VDD} 3.7100e-08 0)
venb_op1_1000_an_s0p1_r1k enb_op1_1000_an_s0p1_r1k 0 pwl(0.0000e+00 {VDD} 1.4000e-08 {VDD} 1.4100e-08 0 3.7000e-08 0 3.7100e-08 {VDD})
vww_op1_1000_an_s0p1_r1k wwl_op1_1000_an_s0p1_r1k 0 pwl(0.0000e+00 0 1.5000e-08 0 1.5100e-08 {VDD} 3.5000e-08 {VDD} 3.5100e-08 0)
vwc_op1_1000_an_s0p1_r1k wbc_op1_1000_an_s0p1_r1k 0 pwl(0.0000e+00 0 1.5000e-08 0 1.5100e-08 {VDD} 3.7000e-08 {VDD} 3.7100e-08 0)
swb_op1_1000_an_s0p1_r1k ref_op1_1000_an_s0p1_r1k wbl_op1_1000_an_s0p1_r1k wbc_op1_1000_an_s0p1_r1k 0 swwbl
cwbl_op1_1000_an_s0p1_r1k wbl_op1_1000_an_s0p1_r1k 0 {C_WBL}
spa_op1_1000_an_s0p1_r1k prea rbl_op1_1000_an_s0p1_r1k ctl_op1_1000_an_s0p1_r1k 0 swpre
spr_op1_1000_an_s0p1_r1k pref ref_op1_1000_an_s0p1_r1k ctl_op1_1000_an_s0p1_r1k 0 swpre
crbl_op1_1000_an_s0p1_r1k rbl_op1_1000_an_s0p1_r1k 0 {C_RBL}
cref_op1_1000_an_s0p1_r1k ref_op1_1000_an_s0p1_r1k 0 {C_RBL}   $ ASSUMPTION: ideal matched dummy load
XMWR_op1_1000_an_s0p1_r1k_0 sn_op1_1000_an_s0p1_r1k_0 wwl_op1_1000_an_s0p1_r1k wbl_op1_1000_an_s0p1_r1k 0 sky130_fd_pr__nfet_01v8 L=0.15 W=0.42 nf=1 ad=0.1218 as=0.1218 pd=1.42 ps=1.42 nrd=0.69047619047619  nrs=0.69047619047619 sa=0 sb=0 sd=0 mult=1 m=1
XMRD_op1_1000_an_s0p1_r1k_0 rbl_op1_1000_an_s0p1_r1k sn_op1_1000_an_s0p1_r1k_0 rwls_op1_1000_an_s0p1_r1k 0 sky130_fd_pr__nfet_01v8 L=0.15 W=0.42 nf=1 ad=0.1218 as=0.1218 pd=1.42 ps=1.42 nrd=0.69047619047619  nrs=0.69047619047619 sa=0 sb=0 sd=0 mult=1 m=1
csn_op1_1000_an_s0p1_r1k_0 sn_op1_1000_an_s0p1_r1k_0 0 {C_SN}
XMWR_op1_1000_an_s0p1_r1k_1 sn_op1_1000_an_s0p1_r1k_1 wwl_des wbl_op1_1000_an_s0p1_r1k 0 sky130_fd_pr__nfet_01v8 L=0.15 W=0.42 nf=1 ad=0.1218 as=0.1218 pd=1.42 ps=1.42 nrd=0.69047619047619  nrs=0.69047619047619 sa=0 sb=0 sd=0 mult=1 m=1
XMRD_op1_1000_an_s0p1_r1k_1 rbl_op1_1000_an_s0p1_r1k sn_op1_1000_an_s0p1_r1k_1 rwl_des 0 sky130_fd_pr__nfet_01v8 L=0.15 W=0.42 nf=1 ad=0.1218 as=0.1218 pd=1.42 ps=1.42 nrd=0.69047619047619  nrs=0.69047619047619 sa=0 sb=0 sd=0 mult=1 m=1
csn_op1_1000_an_s0p1_r1k_1 sn_op1_1000_an_s0p1_r1k_1 0 {C_SN}
XMWR_op1_1000_an_s0p1_r1k_2 sn_op1_1000_an_s0p1_r1k_2 wwl_des wbl_op1_1000_an_s0p1_r1k 0 sky130_fd_pr__nfet_01v8 L=0.15 W=0.42 nf=1 ad=0.1218 as=0.1218 pd=1.42 ps=1.42 nrd=0.69047619047619  nrs=0.69047619047619 sa=0 sb=0 sd=0 mult=1 m=1
XMRD_op1_1000_an_s0p1_r1k_2 rbl_op1_1000_an_s0p1_r1k sn_op1_1000_an_s0p1_r1k_2 rwl_des 0 sky130_fd_pr__nfet_01v8 L=0.15 W=0.42 nf=1 ad=0.1218 as=0.1218 pd=1.42 ps=1.42 nrd=0.69047619047619  nrs=0.69047619047619 sa=0 sb=0 sd=0 mult=1 m=1
csn_op1_1000_an_s0p1_r1k_2 sn_op1_1000_an_s0p1_r1k_2 0 {C_SN}
XMWR_op1_1000_an_s0p1_r1k_3 sn_op1_1000_an_s0p1_r1k_3 wwl_des wbl_op1_1000_an_s0p1_r1k 0 sky130_fd_pr__nfet_01v8 L=0.15 W=0.42 nf=1 ad=0.1218 as=0.1218 pd=1.42 ps=1.42 nrd=0.69047619047619  nrs=0.69047619047619 sa=0 sb=0 sd=0 mult=1 m=1
XMRD_op1_1000_an_s0p1_r1k_3 rbl_op1_1000_an_s0p1_r1k sn_op1_1000_an_s0p1_r1k_3 rwl_des 0 sky130_fd_pr__nfet_01v8 L=0.15 W=0.42 nf=1 ad=0.1218 as=0.1218 pd=1.42 ps=1.42 nrd=0.69047619047619  nrs=0.69047619047619 sa=0 sb=0 sd=0 mult=1 m=1
csn_op1_1000_an_s0p1_r1k_3 sn_op1_1000_an_s0p1_r1k_3 0 {C_SN}
XMN1_op1_1000_an_s0p1_r1k rbl_op1_1000_an_s0p1_r1k ref_op1_1000_an_s0p1_r1k vn_op1_1000_an_s0p1_r1k 0 sky130_fd_pr__nfet_01v8 L=0.15 W=1 nf=1 ad=0.29 as=0.29 pd=2.58 ps=2.58 mult=1 m=1
XMN2_op1_1000_an_s0p1_r1k ref_op1_1000_an_s0p1_r1k rbl_op1_1000_an_s0p1_r1k vn_op1_1000_an_s0p1_r1k 0 sky130_fd_pr__nfet_01v8 L=0.15 W=1 nf=1 ad=0.29 as=0.29 pd=2.58 ps=2.58 mult=1 m=1
XMP1_op1_1000_an_s0p1_r1k rbl_op1_1000_an_s0p1_r1k ref_op1_1000_an_s0p1_r1k vp_op1_1000_an_s0p1_r1k vdd sky130_fd_pr__pfet_01v8 L=0.15 W=2 nf=1 ad=0.58 as=0.58 pd=4.58 ps=4.58 mult=1 m=1
XMP2_op1_1000_an_s0p1_r1k ref_op1_1000_an_s0p1_r1k rbl_op1_1000_an_s0p1_r1k vp_op1_1000_an_s0p1_r1k vdd sky130_fd_pr__pfet_01v8 L=0.15 W=2 nf=1 ad=0.58 as=0.58 pd=4.58 ps=4.58 mult=1 m=1
XMNF_op1_1000_an_s0p1_r1k vn_op1_1000_an_s0p1_r1k en_op1_1000_an_s0p1_r1k 0 0 sky130_fd_pr__nfet_01v8 L=0.15 W=2 nf=1 ad=0.58 as=0.58 pd=4.58 ps=4.58 mult=1 m=1
XMPH_op1_1000_an_s0p1_r1k vp_op1_1000_an_s0p1_r1k enb_op1_1000_an_s0p1_r1k vdd vdd sky130_fd_pr__pfet_01v8 L=0.15 W=4 nf=1 ad=1.16 as=1.16 pd=8.58 ps=8.58 mult=1 m=1
bd_op1_1000_an_s0p1_r1k d_op1_1000_an_s0p1_r1k 0 v=v(rbl_op1_1000_an_s0p1_r1k)-v(ref_op1_1000_an_s0p1_r1k)

* ---- instance 59: op0_n100_an_s0p1_r1k (variant an_s0p1_r1k; probe dec 14.9 ns, release 37 ns, meas 39 ns) ----
vctl_op0_n100_an_s0p1_r1k ctl_op0_n100_an_s0p1_r1k 0 pwl(0.0000e+00 {VDD} 2.0000e-09 {VDD} 2.1000e-09 0)
* RWL driver model (EXPERIMENTAL): slew 0.1 ns, series R 1000 ohm; cell pin = rwls_op0_n100_an_s0p1_r1k
vrs_op0_n100_an_s0p1_r1k rwlsrc_op0_n100_an_s0p1_r1k 0 pwl(0.0000e+00 {VDD} 4.0000e-09 {VDD} 4.1000e-09 0 3.7000e-08 0 3.7100e-08 {VDD})
rdrv_op0_n100_an_s0p1_r1k rwlsrc_op0_n100_an_s0p1_r1k rwls_op0_n100_an_s0p1_r1k 1000
ven_op0_n100_an_s0p1_r1k en_op0_n100_an_s0p1_r1k 0 pwl(0.0000e+00 0 1.4000e-08 0 1.4100e-08 {VDD} 3.7000e-08 {VDD} 3.7100e-08 0)
venb_op0_n100_an_s0p1_r1k enb_op0_n100_an_s0p1_r1k 0 pwl(0.0000e+00 {VDD} 1.4000e-08 {VDD} 1.4100e-08 0 3.7000e-08 0 3.7100e-08 {VDD})
vww_op0_n100_an_s0p1_r1k wwl_op0_n100_an_s0p1_r1k 0 pwl(0.0000e+00 0 1.5000e-08 0 1.5100e-08 {VDD} 3.5000e-08 {VDD} 3.5100e-08 0)
vwc_op0_n100_an_s0p1_r1k wbc_op0_n100_an_s0p1_r1k 0 pwl(0.0000e+00 0 1.5000e-08 0 1.5100e-08 {VDD} 3.7000e-08 {VDD} 3.7100e-08 0)
swb_op0_n100_an_s0p1_r1k ref_op0_n100_an_s0p1_r1k wbl_op0_n100_an_s0p1_r1k wbc_op0_n100_an_s0p1_r1k 0 swwbl
cwbl_op0_n100_an_s0p1_r1k wbl_op0_n100_an_s0p1_r1k 0 {C_WBL}
spa_op0_n100_an_s0p1_r1k prea rbl_op0_n100_an_s0p1_r1k ctl_op0_n100_an_s0p1_r1k 0 swpre
spr_op0_n100_an_s0p1_r1k pref ref_op0_n100_an_s0p1_r1k ctl_op0_n100_an_s0p1_r1k 0 swpre
crbl_op0_n100_an_s0p1_r1k rbl_op0_n100_an_s0p1_r1k 0 {C_RBL}
cref_op0_n100_an_s0p1_r1k ref_op0_n100_an_s0p1_r1k 0 {C_RBL}   $ ASSUMPTION: ideal matched dummy load
XMWR_op0_n100_an_s0p1_r1k_0 sn_op0_n100_an_s0p1_r1k_0 wwl_op0_n100_an_s0p1_r1k wbl_op0_n100_an_s0p1_r1k 0 sky130_fd_pr__nfet_01v8 L=0.15 W=0.42 nf=1 ad=0.1218 as=0.1218 pd=1.42 ps=1.42 nrd=0.69047619047619  nrs=0.69047619047619 sa=0 sb=0 sd=0 mult=1 m=1
XMRD_op0_n100_an_s0p1_r1k_0 rbl_op0_n100_an_s0p1_r1k sn_op0_n100_an_s0p1_r1k_0 rwls_op0_n100_an_s0p1_r1k 0 sky130_fd_pr__nfet_01v8 L=0.15 W=0.42 nf=1 ad=0.1218 as=0.1218 pd=1.42 ps=1.42 nrd=0.69047619047619  nrs=0.69047619047619 sa=0 sb=0 sd=0 mult=1 m=1
csn_op0_n100_an_s0p1_r1k_0 sn_op0_n100_an_s0p1_r1k_0 0 {C_SN}
XMWR_op0_n100_an_s0p1_r1k_1 sn_op0_n100_an_s0p1_r1k_1 wwl_des wbl_op0_n100_an_s0p1_r1k 0 sky130_fd_pr__nfet_01v8 L=0.15 W=0.42 nf=1 ad=0.1218 as=0.1218 pd=1.42 ps=1.42 nrd=0.69047619047619  nrs=0.69047619047619 sa=0 sb=0 sd=0 mult=1 m=1
XMRD_op0_n100_an_s0p1_r1k_1 rbl_op0_n100_an_s0p1_r1k sn_op0_n100_an_s0p1_r1k_1 rwl_des 0 sky130_fd_pr__nfet_01v8 L=0.15 W=0.42 nf=1 ad=0.1218 as=0.1218 pd=1.42 ps=1.42 nrd=0.69047619047619  nrs=0.69047619047619 sa=0 sb=0 sd=0 mult=1 m=1
csn_op0_n100_an_s0p1_r1k_1 sn_op0_n100_an_s0p1_r1k_1 0 {C_SN}
XMWR_op0_n100_an_s0p1_r1k_2 sn_op0_n100_an_s0p1_r1k_2 wwl_des wbl_op0_n100_an_s0p1_r1k 0 sky130_fd_pr__nfet_01v8 L=0.15 W=0.42 nf=1 ad=0.1218 as=0.1218 pd=1.42 ps=1.42 nrd=0.69047619047619  nrs=0.69047619047619 sa=0 sb=0 sd=0 mult=1 m=1
XMRD_op0_n100_an_s0p1_r1k_2 rbl_op0_n100_an_s0p1_r1k sn_op0_n100_an_s0p1_r1k_2 rwl_des 0 sky130_fd_pr__nfet_01v8 L=0.15 W=0.42 nf=1 ad=0.1218 as=0.1218 pd=1.42 ps=1.42 nrd=0.69047619047619  nrs=0.69047619047619 sa=0 sb=0 sd=0 mult=1 m=1
csn_op0_n100_an_s0p1_r1k_2 sn_op0_n100_an_s0p1_r1k_2 0 {C_SN}
XMWR_op0_n100_an_s0p1_r1k_3 sn_op0_n100_an_s0p1_r1k_3 wwl_des wbl_op0_n100_an_s0p1_r1k 0 sky130_fd_pr__nfet_01v8 L=0.15 W=0.42 nf=1 ad=0.1218 as=0.1218 pd=1.42 ps=1.42 nrd=0.69047619047619  nrs=0.69047619047619 sa=0 sb=0 sd=0 mult=1 m=1
XMRD_op0_n100_an_s0p1_r1k_3 rbl_op0_n100_an_s0p1_r1k sn_op0_n100_an_s0p1_r1k_3 rwl_des 0 sky130_fd_pr__nfet_01v8 L=0.15 W=0.42 nf=1 ad=0.1218 as=0.1218 pd=1.42 ps=1.42 nrd=0.69047619047619  nrs=0.69047619047619 sa=0 sb=0 sd=0 mult=1 m=1
csn_op0_n100_an_s0p1_r1k_3 sn_op0_n100_an_s0p1_r1k_3 0 {C_SN}
XMN1_op0_n100_an_s0p1_r1k rbl_op0_n100_an_s0p1_r1k ref_op0_n100_an_s0p1_r1k vn_op0_n100_an_s0p1_r1k 0 sky130_fd_pr__nfet_01v8 L=0.15 W=1 nf=1 ad=0.29 as=0.29 pd=2.58 ps=2.58 mult=1 m=1
XMN2_op0_n100_an_s0p1_r1k ref_op0_n100_an_s0p1_r1k rbl_op0_n100_an_s0p1_r1k vn_op0_n100_an_s0p1_r1k 0 sky130_fd_pr__nfet_01v8 L=0.15 W=1 nf=1 ad=0.29 as=0.29 pd=2.58 ps=2.58 mult=1 m=1
XMP1_op0_n100_an_s0p1_r1k rbl_op0_n100_an_s0p1_r1k ref_op0_n100_an_s0p1_r1k vp_op0_n100_an_s0p1_r1k vdd sky130_fd_pr__pfet_01v8 L=0.15 W=2 nf=1 ad=0.58 as=0.58 pd=4.58 ps=4.58 mult=1 m=1
XMP2_op0_n100_an_s0p1_r1k ref_op0_n100_an_s0p1_r1k rbl_op0_n100_an_s0p1_r1k vp_op0_n100_an_s0p1_r1k vdd sky130_fd_pr__pfet_01v8 L=0.15 W=2 nf=1 ad=0.58 as=0.58 pd=4.58 ps=4.58 mult=1 m=1
XMNF_op0_n100_an_s0p1_r1k vn_op0_n100_an_s0p1_r1k en_op0_n100_an_s0p1_r1k 0 0 sky130_fd_pr__nfet_01v8 L=0.15 W=2 nf=1 ad=0.58 as=0.58 pd=4.58 ps=4.58 mult=1 m=1
XMPH_op0_n100_an_s0p1_r1k vp_op0_n100_an_s0p1_r1k enb_op0_n100_an_s0p1_r1k vdd vdd sky130_fd_pr__pfet_01v8 L=0.15 W=4 nf=1 ad=1.16 as=1.16 pd=8.58 ps=8.58 mult=1 m=1
bd_op0_n100_an_s0p1_r1k d_op0_n100_an_s0p1_r1k 0 v=v(rbl_op0_n100_an_s0p1_r1k)-v(ref_op0_n100_an_s0p1_r1k)

* ---- instance 60: op0_0000_an_s0p1_r1k (variant an_s0p1_r1k; probe dec 14.9 ns, release 37 ns, meas 39 ns) ----
vctl_op0_0000_an_s0p1_r1k ctl_op0_0000_an_s0p1_r1k 0 pwl(0.0000e+00 {VDD} 2.0000e-09 {VDD} 2.1000e-09 0)
* RWL driver model (EXPERIMENTAL): slew 0.1 ns, series R 1000 ohm; cell pin = rwls_op0_0000_an_s0p1_r1k
vrs_op0_0000_an_s0p1_r1k rwlsrc_op0_0000_an_s0p1_r1k 0 pwl(0.0000e+00 {VDD} 4.0000e-09 {VDD} 4.1000e-09 0 3.7000e-08 0 3.7100e-08 {VDD})
rdrv_op0_0000_an_s0p1_r1k rwlsrc_op0_0000_an_s0p1_r1k rwls_op0_0000_an_s0p1_r1k 1000
ven_op0_0000_an_s0p1_r1k en_op0_0000_an_s0p1_r1k 0 pwl(0.0000e+00 0 1.4000e-08 0 1.4100e-08 {VDD} 3.7000e-08 {VDD} 3.7100e-08 0)
venb_op0_0000_an_s0p1_r1k enb_op0_0000_an_s0p1_r1k 0 pwl(0.0000e+00 {VDD} 1.4000e-08 {VDD} 1.4100e-08 0 3.7000e-08 0 3.7100e-08 {VDD})
vww_op0_0000_an_s0p1_r1k wwl_op0_0000_an_s0p1_r1k 0 pwl(0.0000e+00 0 1.5000e-08 0 1.5100e-08 {VDD} 3.5000e-08 {VDD} 3.5100e-08 0)
vwc_op0_0000_an_s0p1_r1k wbc_op0_0000_an_s0p1_r1k 0 pwl(0.0000e+00 0 1.5000e-08 0 1.5100e-08 {VDD} 3.7000e-08 {VDD} 3.7100e-08 0)
swb_op0_0000_an_s0p1_r1k ref_op0_0000_an_s0p1_r1k wbl_op0_0000_an_s0p1_r1k wbc_op0_0000_an_s0p1_r1k 0 swwbl
cwbl_op0_0000_an_s0p1_r1k wbl_op0_0000_an_s0p1_r1k 0 {C_WBL}
spa_op0_0000_an_s0p1_r1k prea rbl_op0_0000_an_s0p1_r1k ctl_op0_0000_an_s0p1_r1k 0 swpre
spr_op0_0000_an_s0p1_r1k pref ref_op0_0000_an_s0p1_r1k ctl_op0_0000_an_s0p1_r1k 0 swpre
crbl_op0_0000_an_s0p1_r1k rbl_op0_0000_an_s0p1_r1k 0 {C_RBL}
cref_op0_0000_an_s0p1_r1k ref_op0_0000_an_s0p1_r1k 0 {C_RBL}   $ ASSUMPTION: ideal matched dummy load
XMWR_op0_0000_an_s0p1_r1k_0 sn_op0_0000_an_s0p1_r1k_0 wwl_op0_0000_an_s0p1_r1k wbl_op0_0000_an_s0p1_r1k 0 sky130_fd_pr__nfet_01v8 L=0.15 W=0.42 nf=1 ad=0.1218 as=0.1218 pd=1.42 ps=1.42 nrd=0.69047619047619  nrs=0.69047619047619 sa=0 sb=0 sd=0 mult=1 m=1
XMRD_op0_0000_an_s0p1_r1k_0 rbl_op0_0000_an_s0p1_r1k sn_op0_0000_an_s0p1_r1k_0 rwls_op0_0000_an_s0p1_r1k 0 sky130_fd_pr__nfet_01v8 L=0.15 W=0.42 nf=1 ad=0.1218 as=0.1218 pd=1.42 ps=1.42 nrd=0.69047619047619  nrs=0.69047619047619 sa=0 sb=0 sd=0 mult=1 m=1
csn_op0_0000_an_s0p1_r1k_0 sn_op0_0000_an_s0p1_r1k_0 0 {C_SN}
XMWR_op0_0000_an_s0p1_r1k_1 sn_op0_0000_an_s0p1_r1k_1 wwl_des wbl_op0_0000_an_s0p1_r1k 0 sky130_fd_pr__nfet_01v8 L=0.15 W=0.42 nf=1 ad=0.1218 as=0.1218 pd=1.42 ps=1.42 nrd=0.69047619047619  nrs=0.69047619047619 sa=0 sb=0 sd=0 mult=1 m=1
XMRD_op0_0000_an_s0p1_r1k_1 rbl_op0_0000_an_s0p1_r1k sn_op0_0000_an_s0p1_r1k_1 rwl_des 0 sky130_fd_pr__nfet_01v8 L=0.15 W=0.42 nf=1 ad=0.1218 as=0.1218 pd=1.42 ps=1.42 nrd=0.69047619047619  nrs=0.69047619047619 sa=0 sb=0 sd=0 mult=1 m=1
csn_op0_0000_an_s0p1_r1k_1 sn_op0_0000_an_s0p1_r1k_1 0 {C_SN}
XMWR_op0_0000_an_s0p1_r1k_2 sn_op0_0000_an_s0p1_r1k_2 wwl_des wbl_op0_0000_an_s0p1_r1k 0 sky130_fd_pr__nfet_01v8 L=0.15 W=0.42 nf=1 ad=0.1218 as=0.1218 pd=1.42 ps=1.42 nrd=0.69047619047619  nrs=0.69047619047619 sa=0 sb=0 sd=0 mult=1 m=1
XMRD_op0_0000_an_s0p1_r1k_2 rbl_op0_0000_an_s0p1_r1k sn_op0_0000_an_s0p1_r1k_2 rwl_des 0 sky130_fd_pr__nfet_01v8 L=0.15 W=0.42 nf=1 ad=0.1218 as=0.1218 pd=1.42 ps=1.42 nrd=0.69047619047619  nrs=0.69047619047619 sa=0 sb=0 sd=0 mult=1 m=1
csn_op0_0000_an_s0p1_r1k_2 sn_op0_0000_an_s0p1_r1k_2 0 {C_SN}
XMWR_op0_0000_an_s0p1_r1k_3 sn_op0_0000_an_s0p1_r1k_3 wwl_des wbl_op0_0000_an_s0p1_r1k 0 sky130_fd_pr__nfet_01v8 L=0.15 W=0.42 nf=1 ad=0.1218 as=0.1218 pd=1.42 ps=1.42 nrd=0.69047619047619  nrs=0.69047619047619 sa=0 sb=0 sd=0 mult=1 m=1
XMRD_op0_0000_an_s0p1_r1k_3 rbl_op0_0000_an_s0p1_r1k sn_op0_0000_an_s0p1_r1k_3 rwl_des 0 sky130_fd_pr__nfet_01v8 L=0.15 W=0.42 nf=1 ad=0.1218 as=0.1218 pd=1.42 ps=1.42 nrd=0.69047619047619  nrs=0.69047619047619 sa=0 sb=0 sd=0 mult=1 m=1
csn_op0_0000_an_s0p1_r1k_3 sn_op0_0000_an_s0p1_r1k_3 0 {C_SN}
XMN1_op0_0000_an_s0p1_r1k rbl_op0_0000_an_s0p1_r1k ref_op0_0000_an_s0p1_r1k vn_op0_0000_an_s0p1_r1k 0 sky130_fd_pr__nfet_01v8 L=0.15 W=1 nf=1 ad=0.29 as=0.29 pd=2.58 ps=2.58 mult=1 m=1
XMN2_op0_0000_an_s0p1_r1k ref_op0_0000_an_s0p1_r1k rbl_op0_0000_an_s0p1_r1k vn_op0_0000_an_s0p1_r1k 0 sky130_fd_pr__nfet_01v8 L=0.15 W=1 nf=1 ad=0.29 as=0.29 pd=2.58 ps=2.58 mult=1 m=1
XMP1_op0_0000_an_s0p1_r1k rbl_op0_0000_an_s0p1_r1k ref_op0_0000_an_s0p1_r1k vp_op0_0000_an_s0p1_r1k vdd sky130_fd_pr__pfet_01v8 L=0.15 W=2 nf=1 ad=0.58 as=0.58 pd=4.58 ps=4.58 mult=1 m=1
XMP2_op0_0000_an_s0p1_r1k ref_op0_0000_an_s0p1_r1k rbl_op0_0000_an_s0p1_r1k vp_op0_0000_an_s0p1_r1k vdd sky130_fd_pr__pfet_01v8 L=0.15 W=2 nf=1 ad=0.58 as=0.58 pd=4.58 ps=4.58 mult=1 m=1
XMNF_op0_0000_an_s0p1_r1k vn_op0_0000_an_s0p1_r1k en_op0_0000_an_s0p1_r1k 0 0 sky130_fd_pr__nfet_01v8 L=0.15 W=2 nf=1 ad=0.58 as=0.58 pd=4.58 ps=4.58 mult=1 m=1
XMPH_op0_0000_an_s0p1_r1k vp_op0_0000_an_s0p1_r1k enb_op0_0000_an_s0p1_r1k vdd vdd sky130_fd_pr__pfet_01v8 L=0.15 W=4 nf=1 ad=1.16 as=1.16 pd=8.58 ps=8.58 mult=1 m=1
bd_op0_0000_an_s0p1_r1k d_op0_0000_an_s0p1_r1k 0 v=v(rbl_op0_0000_an_s0p1_r1k)-v(ref_op0_0000_an_s0p1_r1k)

* ---- instance 61: op1_0900_an_s0p1_r3k (variant an_s0p1_r3k; probe dec 14.9 ns, release 37 ns, meas 39 ns) ----
vctl_op1_0900_an_s0p1_r3k ctl_op1_0900_an_s0p1_r3k 0 pwl(0.0000e+00 {VDD} 2.0000e-09 {VDD} 2.1000e-09 0)
* RWL driver model (EXPERIMENTAL): slew 0.1 ns, series R 3000 ohm; cell pin = rwls_op1_0900_an_s0p1_r3k
vrs_op1_0900_an_s0p1_r3k rwlsrc_op1_0900_an_s0p1_r3k 0 pwl(0.0000e+00 {VDD} 4.0000e-09 {VDD} 4.1000e-09 0 3.7000e-08 0 3.7100e-08 {VDD})
rdrv_op1_0900_an_s0p1_r3k rwlsrc_op1_0900_an_s0p1_r3k rwls_op1_0900_an_s0p1_r3k 3000
ven_op1_0900_an_s0p1_r3k en_op1_0900_an_s0p1_r3k 0 pwl(0.0000e+00 0 1.4000e-08 0 1.4100e-08 {VDD} 3.7000e-08 {VDD} 3.7100e-08 0)
venb_op1_0900_an_s0p1_r3k enb_op1_0900_an_s0p1_r3k 0 pwl(0.0000e+00 {VDD} 1.4000e-08 {VDD} 1.4100e-08 0 3.7000e-08 0 3.7100e-08 {VDD})
vww_op1_0900_an_s0p1_r3k wwl_op1_0900_an_s0p1_r3k 0 pwl(0.0000e+00 0 1.5000e-08 0 1.5100e-08 {VDD} 3.5000e-08 {VDD} 3.5100e-08 0)
vwc_op1_0900_an_s0p1_r3k wbc_op1_0900_an_s0p1_r3k 0 pwl(0.0000e+00 0 1.5000e-08 0 1.5100e-08 {VDD} 3.7000e-08 {VDD} 3.7100e-08 0)
swb_op1_0900_an_s0p1_r3k ref_op1_0900_an_s0p1_r3k wbl_op1_0900_an_s0p1_r3k wbc_op1_0900_an_s0p1_r3k 0 swwbl
cwbl_op1_0900_an_s0p1_r3k wbl_op1_0900_an_s0p1_r3k 0 {C_WBL}
spa_op1_0900_an_s0p1_r3k prea rbl_op1_0900_an_s0p1_r3k ctl_op1_0900_an_s0p1_r3k 0 swpre
spr_op1_0900_an_s0p1_r3k pref ref_op1_0900_an_s0p1_r3k ctl_op1_0900_an_s0p1_r3k 0 swpre
crbl_op1_0900_an_s0p1_r3k rbl_op1_0900_an_s0p1_r3k 0 {C_RBL}
cref_op1_0900_an_s0p1_r3k ref_op1_0900_an_s0p1_r3k 0 {C_RBL}   $ ASSUMPTION: ideal matched dummy load
XMWR_op1_0900_an_s0p1_r3k_0 sn_op1_0900_an_s0p1_r3k_0 wwl_op1_0900_an_s0p1_r3k wbl_op1_0900_an_s0p1_r3k 0 sky130_fd_pr__nfet_01v8 L=0.15 W=0.42 nf=1 ad=0.1218 as=0.1218 pd=1.42 ps=1.42 nrd=0.69047619047619  nrs=0.69047619047619 sa=0 sb=0 sd=0 mult=1 m=1
XMRD_op1_0900_an_s0p1_r3k_0 rbl_op1_0900_an_s0p1_r3k sn_op1_0900_an_s0p1_r3k_0 rwls_op1_0900_an_s0p1_r3k 0 sky130_fd_pr__nfet_01v8 L=0.15 W=0.42 nf=1 ad=0.1218 as=0.1218 pd=1.42 ps=1.42 nrd=0.69047619047619  nrs=0.69047619047619 sa=0 sb=0 sd=0 mult=1 m=1
csn_op1_0900_an_s0p1_r3k_0 sn_op1_0900_an_s0p1_r3k_0 0 {C_SN}
XMWR_op1_0900_an_s0p1_r3k_1 sn_op1_0900_an_s0p1_r3k_1 wwl_des wbl_op1_0900_an_s0p1_r3k 0 sky130_fd_pr__nfet_01v8 L=0.15 W=0.42 nf=1 ad=0.1218 as=0.1218 pd=1.42 ps=1.42 nrd=0.69047619047619  nrs=0.69047619047619 sa=0 sb=0 sd=0 mult=1 m=1
XMRD_op1_0900_an_s0p1_r3k_1 rbl_op1_0900_an_s0p1_r3k sn_op1_0900_an_s0p1_r3k_1 rwl_des 0 sky130_fd_pr__nfet_01v8 L=0.15 W=0.42 nf=1 ad=0.1218 as=0.1218 pd=1.42 ps=1.42 nrd=0.69047619047619  nrs=0.69047619047619 sa=0 sb=0 sd=0 mult=1 m=1
csn_op1_0900_an_s0p1_r3k_1 sn_op1_0900_an_s0p1_r3k_1 0 {C_SN}
XMWR_op1_0900_an_s0p1_r3k_2 sn_op1_0900_an_s0p1_r3k_2 wwl_des wbl_op1_0900_an_s0p1_r3k 0 sky130_fd_pr__nfet_01v8 L=0.15 W=0.42 nf=1 ad=0.1218 as=0.1218 pd=1.42 ps=1.42 nrd=0.69047619047619  nrs=0.69047619047619 sa=0 sb=0 sd=0 mult=1 m=1
XMRD_op1_0900_an_s0p1_r3k_2 rbl_op1_0900_an_s0p1_r3k sn_op1_0900_an_s0p1_r3k_2 rwl_des 0 sky130_fd_pr__nfet_01v8 L=0.15 W=0.42 nf=1 ad=0.1218 as=0.1218 pd=1.42 ps=1.42 nrd=0.69047619047619  nrs=0.69047619047619 sa=0 sb=0 sd=0 mult=1 m=1
csn_op1_0900_an_s0p1_r3k_2 sn_op1_0900_an_s0p1_r3k_2 0 {C_SN}
XMWR_op1_0900_an_s0p1_r3k_3 sn_op1_0900_an_s0p1_r3k_3 wwl_des wbl_op1_0900_an_s0p1_r3k 0 sky130_fd_pr__nfet_01v8 L=0.15 W=0.42 nf=1 ad=0.1218 as=0.1218 pd=1.42 ps=1.42 nrd=0.69047619047619  nrs=0.69047619047619 sa=0 sb=0 sd=0 mult=1 m=1
XMRD_op1_0900_an_s0p1_r3k_3 rbl_op1_0900_an_s0p1_r3k sn_op1_0900_an_s0p1_r3k_3 rwl_des 0 sky130_fd_pr__nfet_01v8 L=0.15 W=0.42 nf=1 ad=0.1218 as=0.1218 pd=1.42 ps=1.42 nrd=0.69047619047619  nrs=0.69047619047619 sa=0 sb=0 sd=0 mult=1 m=1
csn_op1_0900_an_s0p1_r3k_3 sn_op1_0900_an_s0p1_r3k_3 0 {C_SN}
XMN1_op1_0900_an_s0p1_r3k rbl_op1_0900_an_s0p1_r3k ref_op1_0900_an_s0p1_r3k vn_op1_0900_an_s0p1_r3k 0 sky130_fd_pr__nfet_01v8 L=0.15 W=1 nf=1 ad=0.29 as=0.29 pd=2.58 ps=2.58 mult=1 m=1
XMN2_op1_0900_an_s0p1_r3k ref_op1_0900_an_s0p1_r3k rbl_op1_0900_an_s0p1_r3k vn_op1_0900_an_s0p1_r3k 0 sky130_fd_pr__nfet_01v8 L=0.15 W=1 nf=1 ad=0.29 as=0.29 pd=2.58 ps=2.58 mult=1 m=1
XMP1_op1_0900_an_s0p1_r3k rbl_op1_0900_an_s0p1_r3k ref_op1_0900_an_s0p1_r3k vp_op1_0900_an_s0p1_r3k vdd sky130_fd_pr__pfet_01v8 L=0.15 W=2 nf=1 ad=0.58 as=0.58 pd=4.58 ps=4.58 mult=1 m=1
XMP2_op1_0900_an_s0p1_r3k ref_op1_0900_an_s0p1_r3k rbl_op1_0900_an_s0p1_r3k vp_op1_0900_an_s0p1_r3k vdd sky130_fd_pr__pfet_01v8 L=0.15 W=2 nf=1 ad=0.58 as=0.58 pd=4.58 ps=4.58 mult=1 m=1
XMNF_op1_0900_an_s0p1_r3k vn_op1_0900_an_s0p1_r3k en_op1_0900_an_s0p1_r3k 0 0 sky130_fd_pr__nfet_01v8 L=0.15 W=2 nf=1 ad=0.58 as=0.58 pd=4.58 ps=4.58 mult=1 m=1
XMPH_op1_0900_an_s0p1_r3k vp_op1_0900_an_s0p1_r3k enb_op1_0900_an_s0p1_r3k vdd vdd sky130_fd_pr__pfet_01v8 L=0.15 W=4 nf=1 ad=1.16 as=1.16 pd=8.58 ps=8.58 mult=1 m=1
bd_op1_0900_an_s0p1_r3k d_op1_0900_an_s0p1_r3k 0 v=v(rbl_op1_0900_an_s0p1_r3k)-v(ref_op1_0900_an_s0p1_r3k)

* ---- instance 62: op1_1000_an_s0p1_r3k (variant an_s0p1_r3k; probe dec 14.9 ns, release 37 ns, meas 39 ns) ----
vctl_op1_1000_an_s0p1_r3k ctl_op1_1000_an_s0p1_r3k 0 pwl(0.0000e+00 {VDD} 2.0000e-09 {VDD} 2.1000e-09 0)
* RWL driver model (EXPERIMENTAL): slew 0.1 ns, series R 3000 ohm; cell pin = rwls_op1_1000_an_s0p1_r3k
vrs_op1_1000_an_s0p1_r3k rwlsrc_op1_1000_an_s0p1_r3k 0 pwl(0.0000e+00 {VDD} 4.0000e-09 {VDD} 4.1000e-09 0 3.7000e-08 0 3.7100e-08 {VDD})
rdrv_op1_1000_an_s0p1_r3k rwlsrc_op1_1000_an_s0p1_r3k rwls_op1_1000_an_s0p1_r3k 3000
ven_op1_1000_an_s0p1_r3k en_op1_1000_an_s0p1_r3k 0 pwl(0.0000e+00 0 1.4000e-08 0 1.4100e-08 {VDD} 3.7000e-08 {VDD} 3.7100e-08 0)
venb_op1_1000_an_s0p1_r3k enb_op1_1000_an_s0p1_r3k 0 pwl(0.0000e+00 {VDD} 1.4000e-08 {VDD} 1.4100e-08 0 3.7000e-08 0 3.7100e-08 {VDD})
vww_op1_1000_an_s0p1_r3k wwl_op1_1000_an_s0p1_r3k 0 pwl(0.0000e+00 0 1.5000e-08 0 1.5100e-08 {VDD} 3.5000e-08 {VDD} 3.5100e-08 0)
vwc_op1_1000_an_s0p1_r3k wbc_op1_1000_an_s0p1_r3k 0 pwl(0.0000e+00 0 1.5000e-08 0 1.5100e-08 {VDD} 3.7000e-08 {VDD} 3.7100e-08 0)
swb_op1_1000_an_s0p1_r3k ref_op1_1000_an_s0p1_r3k wbl_op1_1000_an_s0p1_r3k wbc_op1_1000_an_s0p1_r3k 0 swwbl
cwbl_op1_1000_an_s0p1_r3k wbl_op1_1000_an_s0p1_r3k 0 {C_WBL}
spa_op1_1000_an_s0p1_r3k prea rbl_op1_1000_an_s0p1_r3k ctl_op1_1000_an_s0p1_r3k 0 swpre
spr_op1_1000_an_s0p1_r3k pref ref_op1_1000_an_s0p1_r3k ctl_op1_1000_an_s0p1_r3k 0 swpre
crbl_op1_1000_an_s0p1_r3k rbl_op1_1000_an_s0p1_r3k 0 {C_RBL}
cref_op1_1000_an_s0p1_r3k ref_op1_1000_an_s0p1_r3k 0 {C_RBL}   $ ASSUMPTION: ideal matched dummy load
XMWR_op1_1000_an_s0p1_r3k_0 sn_op1_1000_an_s0p1_r3k_0 wwl_op1_1000_an_s0p1_r3k wbl_op1_1000_an_s0p1_r3k 0 sky130_fd_pr__nfet_01v8 L=0.15 W=0.42 nf=1 ad=0.1218 as=0.1218 pd=1.42 ps=1.42 nrd=0.69047619047619  nrs=0.69047619047619 sa=0 sb=0 sd=0 mult=1 m=1
XMRD_op1_1000_an_s0p1_r3k_0 rbl_op1_1000_an_s0p1_r3k sn_op1_1000_an_s0p1_r3k_0 rwls_op1_1000_an_s0p1_r3k 0 sky130_fd_pr__nfet_01v8 L=0.15 W=0.42 nf=1 ad=0.1218 as=0.1218 pd=1.42 ps=1.42 nrd=0.69047619047619  nrs=0.69047619047619 sa=0 sb=0 sd=0 mult=1 m=1
csn_op1_1000_an_s0p1_r3k_0 sn_op1_1000_an_s0p1_r3k_0 0 {C_SN}
XMWR_op1_1000_an_s0p1_r3k_1 sn_op1_1000_an_s0p1_r3k_1 wwl_des wbl_op1_1000_an_s0p1_r3k 0 sky130_fd_pr__nfet_01v8 L=0.15 W=0.42 nf=1 ad=0.1218 as=0.1218 pd=1.42 ps=1.42 nrd=0.69047619047619  nrs=0.69047619047619 sa=0 sb=0 sd=0 mult=1 m=1
XMRD_op1_1000_an_s0p1_r3k_1 rbl_op1_1000_an_s0p1_r3k sn_op1_1000_an_s0p1_r3k_1 rwl_des 0 sky130_fd_pr__nfet_01v8 L=0.15 W=0.42 nf=1 ad=0.1218 as=0.1218 pd=1.42 ps=1.42 nrd=0.69047619047619  nrs=0.69047619047619 sa=0 sb=0 sd=0 mult=1 m=1
csn_op1_1000_an_s0p1_r3k_1 sn_op1_1000_an_s0p1_r3k_1 0 {C_SN}
XMWR_op1_1000_an_s0p1_r3k_2 sn_op1_1000_an_s0p1_r3k_2 wwl_des wbl_op1_1000_an_s0p1_r3k 0 sky130_fd_pr__nfet_01v8 L=0.15 W=0.42 nf=1 ad=0.1218 as=0.1218 pd=1.42 ps=1.42 nrd=0.69047619047619  nrs=0.69047619047619 sa=0 sb=0 sd=0 mult=1 m=1
XMRD_op1_1000_an_s0p1_r3k_2 rbl_op1_1000_an_s0p1_r3k sn_op1_1000_an_s0p1_r3k_2 rwl_des 0 sky130_fd_pr__nfet_01v8 L=0.15 W=0.42 nf=1 ad=0.1218 as=0.1218 pd=1.42 ps=1.42 nrd=0.69047619047619  nrs=0.69047619047619 sa=0 sb=0 sd=0 mult=1 m=1
csn_op1_1000_an_s0p1_r3k_2 sn_op1_1000_an_s0p1_r3k_2 0 {C_SN}
XMWR_op1_1000_an_s0p1_r3k_3 sn_op1_1000_an_s0p1_r3k_3 wwl_des wbl_op1_1000_an_s0p1_r3k 0 sky130_fd_pr__nfet_01v8 L=0.15 W=0.42 nf=1 ad=0.1218 as=0.1218 pd=1.42 ps=1.42 nrd=0.69047619047619  nrs=0.69047619047619 sa=0 sb=0 sd=0 mult=1 m=1
XMRD_op1_1000_an_s0p1_r3k_3 rbl_op1_1000_an_s0p1_r3k sn_op1_1000_an_s0p1_r3k_3 rwl_des 0 sky130_fd_pr__nfet_01v8 L=0.15 W=0.42 nf=1 ad=0.1218 as=0.1218 pd=1.42 ps=1.42 nrd=0.69047619047619  nrs=0.69047619047619 sa=0 sb=0 sd=0 mult=1 m=1
csn_op1_1000_an_s0p1_r3k_3 sn_op1_1000_an_s0p1_r3k_3 0 {C_SN}
XMN1_op1_1000_an_s0p1_r3k rbl_op1_1000_an_s0p1_r3k ref_op1_1000_an_s0p1_r3k vn_op1_1000_an_s0p1_r3k 0 sky130_fd_pr__nfet_01v8 L=0.15 W=1 nf=1 ad=0.29 as=0.29 pd=2.58 ps=2.58 mult=1 m=1
XMN2_op1_1000_an_s0p1_r3k ref_op1_1000_an_s0p1_r3k rbl_op1_1000_an_s0p1_r3k vn_op1_1000_an_s0p1_r3k 0 sky130_fd_pr__nfet_01v8 L=0.15 W=1 nf=1 ad=0.29 as=0.29 pd=2.58 ps=2.58 mult=1 m=1
XMP1_op1_1000_an_s0p1_r3k rbl_op1_1000_an_s0p1_r3k ref_op1_1000_an_s0p1_r3k vp_op1_1000_an_s0p1_r3k vdd sky130_fd_pr__pfet_01v8 L=0.15 W=2 nf=1 ad=0.58 as=0.58 pd=4.58 ps=4.58 mult=1 m=1
XMP2_op1_1000_an_s0p1_r3k ref_op1_1000_an_s0p1_r3k rbl_op1_1000_an_s0p1_r3k vp_op1_1000_an_s0p1_r3k vdd sky130_fd_pr__pfet_01v8 L=0.15 W=2 nf=1 ad=0.58 as=0.58 pd=4.58 ps=4.58 mult=1 m=1
XMNF_op1_1000_an_s0p1_r3k vn_op1_1000_an_s0p1_r3k en_op1_1000_an_s0p1_r3k 0 0 sky130_fd_pr__nfet_01v8 L=0.15 W=2 nf=1 ad=0.58 as=0.58 pd=4.58 ps=4.58 mult=1 m=1
XMPH_op1_1000_an_s0p1_r3k vp_op1_1000_an_s0p1_r3k enb_op1_1000_an_s0p1_r3k vdd vdd sky130_fd_pr__pfet_01v8 L=0.15 W=4 nf=1 ad=1.16 as=1.16 pd=8.58 ps=8.58 mult=1 m=1
bd_op1_1000_an_s0p1_r3k d_op1_1000_an_s0p1_r3k 0 v=v(rbl_op1_1000_an_s0p1_r3k)-v(ref_op1_1000_an_s0p1_r3k)

* ---- instance 63: op0_n100_an_s0p1_r3k (variant an_s0p1_r3k; probe dec 14.9 ns, release 37 ns, meas 39 ns) ----
vctl_op0_n100_an_s0p1_r3k ctl_op0_n100_an_s0p1_r3k 0 pwl(0.0000e+00 {VDD} 2.0000e-09 {VDD} 2.1000e-09 0)
* RWL driver model (EXPERIMENTAL): slew 0.1 ns, series R 3000 ohm; cell pin = rwls_op0_n100_an_s0p1_r3k
vrs_op0_n100_an_s0p1_r3k rwlsrc_op0_n100_an_s0p1_r3k 0 pwl(0.0000e+00 {VDD} 4.0000e-09 {VDD} 4.1000e-09 0 3.7000e-08 0 3.7100e-08 {VDD})
rdrv_op0_n100_an_s0p1_r3k rwlsrc_op0_n100_an_s0p1_r3k rwls_op0_n100_an_s0p1_r3k 3000
ven_op0_n100_an_s0p1_r3k en_op0_n100_an_s0p1_r3k 0 pwl(0.0000e+00 0 1.4000e-08 0 1.4100e-08 {VDD} 3.7000e-08 {VDD} 3.7100e-08 0)
venb_op0_n100_an_s0p1_r3k enb_op0_n100_an_s0p1_r3k 0 pwl(0.0000e+00 {VDD} 1.4000e-08 {VDD} 1.4100e-08 0 3.7000e-08 0 3.7100e-08 {VDD})
vww_op0_n100_an_s0p1_r3k wwl_op0_n100_an_s0p1_r3k 0 pwl(0.0000e+00 0 1.5000e-08 0 1.5100e-08 {VDD} 3.5000e-08 {VDD} 3.5100e-08 0)
vwc_op0_n100_an_s0p1_r3k wbc_op0_n100_an_s0p1_r3k 0 pwl(0.0000e+00 0 1.5000e-08 0 1.5100e-08 {VDD} 3.7000e-08 {VDD} 3.7100e-08 0)
swb_op0_n100_an_s0p1_r3k ref_op0_n100_an_s0p1_r3k wbl_op0_n100_an_s0p1_r3k wbc_op0_n100_an_s0p1_r3k 0 swwbl
cwbl_op0_n100_an_s0p1_r3k wbl_op0_n100_an_s0p1_r3k 0 {C_WBL}
spa_op0_n100_an_s0p1_r3k prea rbl_op0_n100_an_s0p1_r3k ctl_op0_n100_an_s0p1_r3k 0 swpre
spr_op0_n100_an_s0p1_r3k pref ref_op0_n100_an_s0p1_r3k ctl_op0_n100_an_s0p1_r3k 0 swpre
crbl_op0_n100_an_s0p1_r3k rbl_op0_n100_an_s0p1_r3k 0 {C_RBL}
cref_op0_n100_an_s0p1_r3k ref_op0_n100_an_s0p1_r3k 0 {C_RBL}   $ ASSUMPTION: ideal matched dummy load
XMWR_op0_n100_an_s0p1_r3k_0 sn_op0_n100_an_s0p1_r3k_0 wwl_op0_n100_an_s0p1_r3k wbl_op0_n100_an_s0p1_r3k 0 sky130_fd_pr__nfet_01v8 L=0.15 W=0.42 nf=1 ad=0.1218 as=0.1218 pd=1.42 ps=1.42 nrd=0.69047619047619  nrs=0.69047619047619 sa=0 sb=0 sd=0 mult=1 m=1
XMRD_op0_n100_an_s0p1_r3k_0 rbl_op0_n100_an_s0p1_r3k sn_op0_n100_an_s0p1_r3k_0 rwls_op0_n100_an_s0p1_r3k 0 sky130_fd_pr__nfet_01v8 L=0.15 W=0.42 nf=1 ad=0.1218 as=0.1218 pd=1.42 ps=1.42 nrd=0.69047619047619  nrs=0.69047619047619 sa=0 sb=0 sd=0 mult=1 m=1
csn_op0_n100_an_s0p1_r3k_0 sn_op0_n100_an_s0p1_r3k_0 0 {C_SN}
XMWR_op0_n100_an_s0p1_r3k_1 sn_op0_n100_an_s0p1_r3k_1 wwl_des wbl_op0_n100_an_s0p1_r3k 0 sky130_fd_pr__nfet_01v8 L=0.15 W=0.42 nf=1 ad=0.1218 as=0.1218 pd=1.42 ps=1.42 nrd=0.69047619047619  nrs=0.69047619047619 sa=0 sb=0 sd=0 mult=1 m=1
XMRD_op0_n100_an_s0p1_r3k_1 rbl_op0_n100_an_s0p1_r3k sn_op0_n100_an_s0p1_r3k_1 rwl_des 0 sky130_fd_pr__nfet_01v8 L=0.15 W=0.42 nf=1 ad=0.1218 as=0.1218 pd=1.42 ps=1.42 nrd=0.69047619047619  nrs=0.69047619047619 sa=0 sb=0 sd=0 mult=1 m=1
csn_op0_n100_an_s0p1_r3k_1 sn_op0_n100_an_s0p1_r3k_1 0 {C_SN}
XMWR_op0_n100_an_s0p1_r3k_2 sn_op0_n100_an_s0p1_r3k_2 wwl_des wbl_op0_n100_an_s0p1_r3k 0 sky130_fd_pr__nfet_01v8 L=0.15 W=0.42 nf=1 ad=0.1218 as=0.1218 pd=1.42 ps=1.42 nrd=0.69047619047619  nrs=0.69047619047619 sa=0 sb=0 sd=0 mult=1 m=1
XMRD_op0_n100_an_s0p1_r3k_2 rbl_op0_n100_an_s0p1_r3k sn_op0_n100_an_s0p1_r3k_2 rwl_des 0 sky130_fd_pr__nfet_01v8 L=0.15 W=0.42 nf=1 ad=0.1218 as=0.1218 pd=1.42 ps=1.42 nrd=0.69047619047619  nrs=0.69047619047619 sa=0 sb=0 sd=0 mult=1 m=1
csn_op0_n100_an_s0p1_r3k_2 sn_op0_n100_an_s0p1_r3k_2 0 {C_SN}
XMWR_op0_n100_an_s0p1_r3k_3 sn_op0_n100_an_s0p1_r3k_3 wwl_des wbl_op0_n100_an_s0p1_r3k 0 sky130_fd_pr__nfet_01v8 L=0.15 W=0.42 nf=1 ad=0.1218 as=0.1218 pd=1.42 ps=1.42 nrd=0.69047619047619  nrs=0.69047619047619 sa=0 sb=0 sd=0 mult=1 m=1
XMRD_op0_n100_an_s0p1_r3k_3 rbl_op0_n100_an_s0p1_r3k sn_op0_n100_an_s0p1_r3k_3 rwl_des 0 sky130_fd_pr__nfet_01v8 L=0.15 W=0.42 nf=1 ad=0.1218 as=0.1218 pd=1.42 ps=1.42 nrd=0.69047619047619  nrs=0.69047619047619 sa=0 sb=0 sd=0 mult=1 m=1
csn_op0_n100_an_s0p1_r3k_3 sn_op0_n100_an_s0p1_r3k_3 0 {C_SN}
XMN1_op0_n100_an_s0p1_r3k rbl_op0_n100_an_s0p1_r3k ref_op0_n100_an_s0p1_r3k vn_op0_n100_an_s0p1_r3k 0 sky130_fd_pr__nfet_01v8 L=0.15 W=1 nf=1 ad=0.29 as=0.29 pd=2.58 ps=2.58 mult=1 m=1
XMN2_op0_n100_an_s0p1_r3k ref_op0_n100_an_s0p1_r3k rbl_op0_n100_an_s0p1_r3k vn_op0_n100_an_s0p1_r3k 0 sky130_fd_pr__nfet_01v8 L=0.15 W=1 nf=1 ad=0.29 as=0.29 pd=2.58 ps=2.58 mult=1 m=1
XMP1_op0_n100_an_s0p1_r3k rbl_op0_n100_an_s0p1_r3k ref_op0_n100_an_s0p1_r3k vp_op0_n100_an_s0p1_r3k vdd sky130_fd_pr__pfet_01v8 L=0.15 W=2 nf=1 ad=0.58 as=0.58 pd=4.58 ps=4.58 mult=1 m=1
XMP2_op0_n100_an_s0p1_r3k ref_op0_n100_an_s0p1_r3k rbl_op0_n100_an_s0p1_r3k vp_op0_n100_an_s0p1_r3k vdd sky130_fd_pr__pfet_01v8 L=0.15 W=2 nf=1 ad=0.58 as=0.58 pd=4.58 ps=4.58 mult=1 m=1
XMNF_op0_n100_an_s0p1_r3k vn_op0_n100_an_s0p1_r3k en_op0_n100_an_s0p1_r3k 0 0 sky130_fd_pr__nfet_01v8 L=0.15 W=2 nf=1 ad=0.58 as=0.58 pd=4.58 ps=4.58 mult=1 m=1
XMPH_op0_n100_an_s0p1_r3k vp_op0_n100_an_s0p1_r3k enb_op0_n100_an_s0p1_r3k vdd vdd sky130_fd_pr__pfet_01v8 L=0.15 W=4 nf=1 ad=1.16 as=1.16 pd=8.58 ps=8.58 mult=1 m=1
bd_op0_n100_an_s0p1_r3k d_op0_n100_an_s0p1_r3k 0 v=v(rbl_op0_n100_an_s0p1_r3k)-v(ref_op0_n100_an_s0p1_r3k)

* ---- instance 64: op0_0000_an_s0p1_r3k (variant an_s0p1_r3k; probe dec 14.9 ns, release 37 ns, meas 39 ns) ----
vctl_op0_0000_an_s0p1_r3k ctl_op0_0000_an_s0p1_r3k 0 pwl(0.0000e+00 {VDD} 2.0000e-09 {VDD} 2.1000e-09 0)
* RWL driver model (EXPERIMENTAL): slew 0.1 ns, series R 3000 ohm; cell pin = rwls_op0_0000_an_s0p1_r3k
vrs_op0_0000_an_s0p1_r3k rwlsrc_op0_0000_an_s0p1_r3k 0 pwl(0.0000e+00 {VDD} 4.0000e-09 {VDD} 4.1000e-09 0 3.7000e-08 0 3.7100e-08 {VDD})
rdrv_op0_0000_an_s0p1_r3k rwlsrc_op0_0000_an_s0p1_r3k rwls_op0_0000_an_s0p1_r3k 3000
ven_op0_0000_an_s0p1_r3k en_op0_0000_an_s0p1_r3k 0 pwl(0.0000e+00 0 1.4000e-08 0 1.4100e-08 {VDD} 3.7000e-08 {VDD} 3.7100e-08 0)
venb_op0_0000_an_s0p1_r3k enb_op0_0000_an_s0p1_r3k 0 pwl(0.0000e+00 {VDD} 1.4000e-08 {VDD} 1.4100e-08 0 3.7000e-08 0 3.7100e-08 {VDD})
vww_op0_0000_an_s0p1_r3k wwl_op0_0000_an_s0p1_r3k 0 pwl(0.0000e+00 0 1.5000e-08 0 1.5100e-08 {VDD} 3.5000e-08 {VDD} 3.5100e-08 0)
vwc_op0_0000_an_s0p1_r3k wbc_op0_0000_an_s0p1_r3k 0 pwl(0.0000e+00 0 1.5000e-08 0 1.5100e-08 {VDD} 3.7000e-08 {VDD} 3.7100e-08 0)
swb_op0_0000_an_s0p1_r3k ref_op0_0000_an_s0p1_r3k wbl_op0_0000_an_s0p1_r3k wbc_op0_0000_an_s0p1_r3k 0 swwbl
cwbl_op0_0000_an_s0p1_r3k wbl_op0_0000_an_s0p1_r3k 0 {C_WBL}
spa_op0_0000_an_s0p1_r3k prea rbl_op0_0000_an_s0p1_r3k ctl_op0_0000_an_s0p1_r3k 0 swpre
spr_op0_0000_an_s0p1_r3k pref ref_op0_0000_an_s0p1_r3k ctl_op0_0000_an_s0p1_r3k 0 swpre
crbl_op0_0000_an_s0p1_r3k rbl_op0_0000_an_s0p1_r3k 0 {C_RBL}
cref_op0_0000_an_s0p1_r3k ref_op0_0000_an_s0p1_r3k 0 {C_RBL}   $ ASSUMPTION: ideal matched dummy load
XMWR_op0_0000_an_s0p1_r3k_0 sn_op0_0000_an_s0p1_r3k_0 wwl_op0_0000_an_s0p1_r3k wbl_op0_0000_an_s0p1_r3k 0 sky130_fd_pr__nfet_01v8 L=0.15 W=0.42 nf=1 ad=0.1218 as=0.1218 pd=1.42 ps=1.42 nrd=0.69047619047619  nrs=0.69047619047619 sa=0 sb=0 sd=0 mult=1 m=1
XMRD_op0_0000_an_s0p1_r3k_0 rbl_op0_0000_an_s0p1_r3k sn_op0_0000_an_s0p1_r3k_0 rwls_op0_0000_an_s0p1_r3k 0 sky130_fd_pr__nfet_01v8 L=0.15 W=0.42 nf=1 ad=0.1218 as=0.1218 pd=1.42 ps=1.42 nrd=0.69047619047619  nrs=0.69047619047619 sa=0 sb=0 sd=0 mult=1 m=1
csn_op0_0000_an_s0p1_r3k_0 sn_op0_0000_an_s0p1_r3k_0 0 {C_SN}
XMWR_op0_0000_an_s0p1_r3k_1 sn_op0_0000_an_s0p1_r3k_1 wwl_des wbl_op0_0000_an_s0p1_r3k 0 sky130_fd_pr__nfet_01v8 L=0.15 W=0.42 nf=1 ad=0.1218 as=0.1218 pd=1.42 ps=1.42 nrd=0.69047619047619  nrs=0.69047619047619 sa=0 sb=0 sd=0 mult=1 m=1
XMRD_op0_0000_an_s0p1_r3k_1 rbl_op0_0000_an_s0p1_r3k sn_op0_0000_an_s0p1_r3k_1 rwl_des 0 sky130_fd_pr__nfet_01v8 L=0.15 W=0.42 nf=1 ad=0.1218 as=0.1218 pd=1.42 ps=1.42 nrd=0.69047619047619  nrs=0.69047619047619 sa=0 sb=0 sd=0 mult=1 m=1
csn_op0_0000_an_s0p1_r3k_1 sn_op0_0000_an_s0p1_r3k_1 0 {C_SN}
XMWR_op0_0000_an_s0p1_r3k_2 sn_op0_0000_an_s0p1_r3k_2 wwl_des wbl_op0_0000_an_s0p1_r3k 0 sky130_fd_pr__nfet_01v8 L=0.15 W=0.42 nf=1 ad=0.1218 as=0.1218 pd=1.42 ps=1.42 nrd=0.69047619047619  nrs=0.69047619047619 sa=0 sb=0 sd=0 mult=1 m=1
XMRD_op0_0000_an_s0p1_r3k_2 rbl_op0_0000_an_s0p1_r3k sn_op0_0000_an_s0p1_r3k_2 rwl_des 0 sky130_fd_pr__nfet_01v8 L=0.15 W=0.42 nf=1 ad=0.1218 as=0.1218 pd=1.42 ps=1.42 nrd=0.69047619047619  nrs=0.69047619047619 sa=0 sb=0 sd=0 mult=1 m=1
csn_op0_0000_an_s0p1_r3k_2 sn_op0_0000_an_s0p1_r3k_2 0 {C_SN}
XMWR_op0_0000_an_s0p1_r3k_3 sn_op0_0000_an_s0p1_r3k_3 wwl_des wbl_op0_0000_an_s0p1_r3k 0 sky130_fd_pr__nfet_01v8 L=0.15 W=0.42 nf=1 ad=0.1218 as=0.1218 pd=1.42 ps=1.42 nrd=0.69047619047619  nrs=0.69047619047619 sa=0 sb=0 sd=0 mult=1 m=1
XMRD_op0_0000_an_s0p1_r3k_3 rbl_op0_0000_an_s0p1_r3k sn_op0_0000_an_s0p1_r3k_3 rwl_des 0 sky130_fd_pr__nfet_01v8 L=0.15 W=0.42 nf=1 ad=0.1218 as=0.1218 pd=1.42 ps=1.42 nrd=0.69047619047619  nrs=0.69047619047619 sa=0 sb=0 sd=0 mult=1 m=1
csn_op0_0000_an_s0p1_r3k_3 sn_op0_0000_an_s0p1_r3k_3 0 {C_SN}
XMN1_op0_0000_an_s0p1_r3k rbl_op0_0000_an_s0p1_r3k ref_op0_0000_an_s0p1_r3k vn_op0_0000_an_s0p1_r3k 0 sky130_fd_pr__nfet_01v8 L=0.15 W=1 nf=1 ad=0.29 as=0.29 pd=2.58 ps=2.58 mult=1 m=1
XMN2_op0_0000_an_s0p1_r3k ref_op0_0000_an_s0p1_r3k rbl_op0_0000_an_s0p1_r3k vn_op0_0000_an_s0p1_r3k 0 sky130_fd_pr__nfet_01v8 L=0.15 W=1 nf=1 ad=0.29 as=0.29 pd=2.58 ps=2.58 mult=1 m=1
XMP1_op0_0000_an_s0p1_r3k rbl_op0_0000_an_s0p1_r3k ref_op0_0000_an_s0p1_r3k vp_op0_0000_an_s0p1_r3k vdd sky130_fd_pr__pfet_01v8 L=0.15 W=2 nf=1 ad=0.58 as=0.58 pd=4.58 ps=4.58 mult=1 m=1
XMP2_op0_0000_an_s0p1_r3k ref_op0_0000_an_s0p1_r3k rbl_op0_0000_an_s0p1_r3k vp_op0_0000_an_s0p1_r3k vdd sky130_fd_pr__pfet_01v8 L=0.15 W=2 nf=1 ad=0.58 as=0.58 pd=4.58 ps=4.58 mult=1 m=1
XMNF_op0_0000_an_s0p1_r3k vn_op0_0000_an_s0p1_r3k en_op0_0000_an_s0p1_r3k 0 0 sky130_fd_pr__nfet_01v8 L=0.15 W=2 nf=1 ad=0.58 as=0.58 pd=4.58 ps=4.58 mult=1 m=1
XMPH_op0_0000_an_s0p1_r3k vp_op0_0000_an_s0p1_r3k enb_op0_0000_an_s0p1_r3k vdd vdd sky130_fd_pr__pfet_01v8 L=0.15 W=4 nf=1 ad=1.16 as=1.16 pd=8.58 ps=8.58 mult=1 m=1
bd_op0_0000_an_s0p1_r3k d_op0_0000_an_s0p1_r3k 0 v=v(rbl_op0_0000_an_s0p1_r3k)-v(ref_op0_0000_an_s0p1_r3k)

* ---- instance 65: op1_0900_an_s0p1_r10k (variant an_s0p1_r10k; probe dec 14.9 ns, release 37 ns, meas 39 ns) ----
vctl_op1_0900_an_s0p1_r10k ctl_op1_0900_an_s0p1_r10k 0 pwl(0.0000e+00 {VDD} 2.0000e-09 {VDD} 2.1000e-09 0)
* RWL driver model (EXPERIMENTAL): slew 0.1 ns, series R 10000 ohm; cell pin = rwls_op1_0900_an_s0p1_r10k
vrs_op1_0900_an_s0p1_r10k rwlsrc_op1_0900_an_s0p1_r10k 0 pwl(0.0000e+00 {VDD} 4.0000e-09 {VDD} 4.1000e-09 0 3.7000e-08 0 3.7100e-08 {VDD})
rdrv_op1_0900_an_s0p1_r10k rwlsrc_op1_0900_an_s0p1_r10k rwls_op1_0900_an_s0p1_r10k 10000
ven_op1_0900_an_s0p1_r10k en_op1_0900_an_s0p1_r10k 0 pwl(0.0000e+00 0 1.4000e-08 0 1.4100e-08 {VDD} 3.7000e-08 {VDD} 3.7100e-08 0)
venb_op1_0900_an_s0p1_r10k enb_op1_0900_an_s0p1_r10k 0 pwl(0.0000e+00 {VDD} 1.4000e-08 {VDD} 1.4100e-08 0 3.7000e-08 0 3.7100e-08 {VDD})
vww_op1_0900_an_s0p1_r10k wwl_op1_0900_an_s0p1_r10k 0 pwl(0.0000e+00 0 1.5000e-08 0 1.5100e-08 {VDD} 3.5000e-08 {VDD} 3.5100e-08 0)
vwc_op1_0900_an_s0p1_r10k wbc_op1_0900_an_s0p1_r10k 0 pwl(0.0000e+00 0 1.5000e-08 0 1.5100e-08 {VDD} 3.7000e-08 {VDD} 3.7100e-08 0)
swb_op1_0900_an_s0p1_r10k ref_op1_0900_an_s0p1_r10k wbl_op1_0900_an_s0p1_r10k wbc_op1_0900_an_s0p1_r10k 0 swwbl
cwbl_op1_0900_an_s0p1_r10k wbl_op1_0900_an_s0p1_r10k 0 {C_WBL}
spa_op1_0900_an_s0p1_r10k prea rbl_op1_0900_an_s0p1_r10k ctl_op1_0900_an_s0p1_r10k 0 swpre
spr_op1_0900_an_s0p1_r10k pref ref_op1_0900_an_s0p1_r10k ctl_op1_0900_an_s0p1_r10k 0 swpre
crbl_op1_0900_an_s0p1_r10k rbl_op1_0900_an_s0p1_r10k 0 {C_RBL}
cref_op1_0900_an_s0p1_r10k ref_op1_0900_an_s0p1_r10k 0 {C_RBL}   $ ASSUMPTION: ideal matched dummy load
XMWR_op1_0900_an_s0p1_r10k_0 sn_op1_0900_an_s0p1_r10k_0 wwl_op1_0900_an_s0p1_r10k wbl_op1_0900_an_s0p1_r10k 0 sky130_fd_pr__nfet_01v8 L=0.15 W=0.42 nf=1 ad=0.1218 as=0.1218 pd=1.42 ps=1.42 nrd=0.69047619047619  nrs=0.69047619047619 sa=0 sb=0 sd=0 mult=1 m=1
XMRD_op1_0900_an_s0p1_r10k_0 rbl_op1_0900_an_s0p1_r10k sn_op1_0900_an_s0p1_r10k_0 rwls_op1_0900_an_s0p1_r10k 0 sky130_fd_pr__nfet_01v8 L=0.15 W=0.42 nf=1 ad=0.1218 as=0.1218 pd=1.42 ps=1.42 nrd=0.69047619047619  nrs=0.69047619047619 sa=0 sb=0 sd=0 mult=1 m=1
csn_op1_0900_an_s0p1_r10k_0 sn_op1_0900_an_s0p1_r10k_0 0 {C_SN}
XMWR_op1_0900_an_s0p1_r10k_1 sn_op1_0900_an_s0p1_r10k_1 wwl_des wbl_op1_0900_an_s0p1_r10k 0 sky130_fd_pr__nfet_01v8 L=0.15 W=0.42 nf=1 ad=0.1218 as=0.1218 pd=1.42 ps=1.42 nrd=0.69047619047619  nrs=0.69047619047619 sa=0 sb=0 sd=0 mult=1 m=1
XMRD_op1_0900_an_s0p1_r10k_1 rbl_op1_0900_an_s0p1_r10k sn_op1_0900_an_s0p1_r10k_1 rwl_des 0 sky130_fd_pr__nfet_01v8 L=0.15 W=0.42 nf=1 ad=0.1218 as=0.1218 pd=1.42 ps=1.42 nrd=0.69047619047619  nrs=0.69047619047619 sa=0 sb=0 sd=0 mult=1 m=1
csn_op1_0900_an_s0p1_r10k_1 sn_op1_0900_an_s0p1_r10k_1 0 {C_SN}
XMWR_op1_0900_an_s0p1_r10k_2 sn_op1_0900_an_s0p1_r10k_2 wwl_des wbl_op1_0900_an_s0p1_r10k 0 sky130_fd_pr__nfet_01v8 L=0.15 W=0.42 nf=1 ad=0.1218 as=0.1218 pd=1.42 ps=1.42 nrd=0.69047619047619  nrs=0.69047619047619 sa=0 sb=0 sd=0 mult=1 m=1
XMRD_op1_0900_an_s0p1_r10k_2 rbl_op1_0900_an_s0p1_r10k sn_op1_0900_an_s0p1_r10k_2 rwl_des 0 sky130_fd_pr__nfet_01v8 L=0.15 W=0.42 nf=1 ad=0.1218 as=0.1218 pd=1.42 ps=1.42 nrd=0.69047619047619  nrs=0.69047619047619 sa=0 sb=0 sd=0 mult=1 m=1
csn_op1_0900_an_s0p1_r10k_2 sn_op1_0900_an_s0p1_r10k_2 0 {C_SN}
XMWR_op1_0900_an_s0p1_r10k_3 sn_op1_0900_an_s0p1_r10k_3 wwl_des wbl_op1_0900_an_s0p1_r10k 0 sky130_fd_pr__nfet_01v8 L=0.15 W=0.42 nf=1 ad=0.1218 as=0.1218 pd=1.42 ps=1.42 nrd=0.69047619047619  nrs=0.69047619047619 sa=0 sb=0 sd=0 mult=1 m=1
XMRD_op1_0900_an_s0p1_r10k_3 rbl_op1_0900_an_s0p1_r10k sn_op1_0900_an_s0p1_r10k_3 rwl_des 0 sky130_fd_pr__nfet_01v8 L=0.15 W=0.42 nf=1 ad=0.1218 as=0.1218 pd=1.42 ps=1.42 nrd=0.69047619047619  nrs=0.69047619047619 sa=0 sb=0 sd=0 mult=1 m=1
csn_op1_0900_an_s0p1_r10k_3 sn_op1_0900_an_s0p1_r10k_3 0 {C_SN}
XMN1_op1_0900_an_s0p1_r10k rbl_op1_0900_an_s0p1_r10k ref_op1_0900_an_s0p1_r10k vn_op1_0900_an_s0p1_r10k 0 sky130_fd_pr__nfet_01v8 L=0.15 W=1 nf=1 ad=0.29 as=0.29 pd=2.58 ps=2.58 mult=1 m=1
XMN2_op1_0900_an_s0p1_r10k ref_op1_0900_an_s0p1_r10k rbl_op1_0900_an_s0p1_r10k vn_op1_0900_an_s0p1_r10k 0 sky130_fd_pr__nfet_01v8 L=0.15 W=1 nf=1 ad=0.29 as=0.29 pd=2.58 ps=2.58 mult=1 m=1
XMP1_op1_0900_an_s0p1_r10k rbl_op1_0900_an_s0p1_r10k ref_op1_0900_an_s0p1_r10k vp_op1_0900_an_s0p1_r10k vdd sky130_fd_pr__pfet_01v8 L=0.15 W=2 nf=1 ad=0.58 as=0.58 pd=4.58 ps=4.58 mult=1 m=1
XMP2_op1_0900_an_s0p1_r10k ref_op1_0900_an_s0p1_r10k rbl_op1_0900_an_s0p1_r10k vp_op1_0900_an_s0p1_r10k vdd sky130_fd_pr__pfet_01v8 L=0.15 W=2 nf=1 ad=0.58 as=0.58 pd=4.58 ps=4.58 mult=1 m=1
XMNF_op1_0900_an_s0p1_r10k vn_op1_0900_an_s0p1_r10k en_op1_0900_an_s0p1_r10k 0 0 sky130_fd_pr__nfet_01v8 L=0.15 W=2 nf=1 ad=0.58 as=0.58 pd=4.58 ps=4.58 mult=1 m=1
XMPH_op1_0900_an_s0p1_r10k vp_op1_0900_an_s0p1_r10k enb_op1_0900_an_s0p1_r10k vdd vdd sky130_fd_pr__pfet_01v8 L=0.15 W=4 nf=1 ad=1.16 as=1.16 pd=8.58 ps=8.58 mult=1 m=1
bd_op1_0900_an_s0p1_r10k d_op1_0900_an_s0p1_r10k 0 v=v(rbl_op1_0900_an_s0p1_r10k)-v(ref_op1_0900_an_s0p1_r10k)

* ---- instance 66: op1_1000_an_s0p1_r10k (variant an_s0p1_r10k; probe dec 14.9 ns, release 37 ns, meas 39 ns) ----
vctl_op1_1000_an_s0p1_r10k ctl_op1_1000_an_s0p1_r10k 0 pwl(0.0000e+00 {VDD} 2.0000e-09 {VDD} 2.1000e-09 0)
* RWL driver model (EXPERIMENTAL): slew 0.1 ns, series R 10000 ohm; cell pin = rwls_op1_1000_an_s0p1_r10k
vrs_op1_1000_an_s0p1_r10k rwlsrc_op1_1000_an_s0p1_r10k 0 pwl(0.0000e+00 {VDD} 4.0000e-09 {VDD} 4.1000e-09 0 3.7000e-08 0 3.7100e-08 {VDD})
rdrv_op1_1000_an_s0p1_r10k rwlsrc_op1_1000_an_s0p1_r10k rwls_op1_1000_an_s0p1_r10k 10000
ven_op1_1000_an_s0p1_r10k en_op1_1000_an_s0p1_r10k 0 pwl(0.0000e+00 0 1.4000e-08 0 1.4100e-08 {VDD} 3.7000e-08 {VDD} 3.7100e-08 0)
venb_op1_1000_an_s0p1_r10k enb_op1_1000_an_s0p1_r10k 0 pwl(0.0000e+00 {VDD} 1.4000e-08 {VDD} 1.4100e-08 0 3.7000e-08 0 3.7100e-08 {VDD})
vww_op1_1000_an_s0p1_r10k wwl_op1_1000_an_s0p1_r10k 0 pwl(0.0000e+00 0 1.5000e-08 0 1.5100e-08 {VDD} 3.5000e-08 {VDD} 3.5100e-08 0)
vwc_op1_1000_an_s0p1_r10k wbc_op1_1000_an_s0p1_r10k 0 pwl(0.0000e+00 0 1.5000e-08 0 1.5100e-08 {VDD} 3.7000e-08 {VDD} 3.7100e-08 0)
swb_op1_1000_an_s0p1_r10k ref_op1_1000_an_s0p1_r10k wbl_op1_1000_an_s0p1_r10k wbc_op1_1000_an_s0p1_r10k 0 swwbl
cwbl_op1_1000_an_s0p1_r10k wbl_op1_1000_an_s0p1_r10k 0 {C_WBL}
spa_op1_1000_an_s0p1_r10k prea rbl_op1_1000_an_s0p1_r10k ctl_op1_1000_an_s0p1_r10k 0 swpre
spr_op1_1000_an_s0p1_r10k pref ref_op1_1000_an_s0p1_r10k ctl_op1_1000_an_s0p1_r10k 0 swpre
crbl_op1_1000_an_s0p1_r10k rbl_op1_1000_an_s0p1_r10k 0 {C_RBL}
cref_op1_1000_an_s0p1_r10k ref_op1_1000_an_s0p1_r10k 0 {C_RBL}   $ ASSUMPTION: ideal matched dummy load
XMWR_op1_1000_an_s0p1_r10k_0 sn_op1_1000_an_s0p1_r10k_0 wwl_op1_1000_an_s0p1_r10k wbl_op1_1000_an_s0p1_r10k 0 sky130_fd_pr__nfet_01v8 L=0.15 W=0.42 nf=1 ad=0.1218 as=0.1218 pd=1.42 ps=1.42 nrd=0.69047619047619  nrs=0.69047619047619 sa=0 sb=0 sd=0 mult=1 m=1
XMRD_op1_1000_an_s0p1_r10k_0 rbl_op1_1000_an_s0p1_r10k sn_op1_1000_an_s0p1_r10k_0 rwls_op1_1000_an_s0p1_r10k 0 sky130_fd_pr__nfet_01v8 L=0.15 W=0.42 nf=1 ad=0.1218 as=0.1218 pd=1.42 ps=1.42 nrd=0.69047619047619  nrs=0.69047619047619 sa=0 sb=0 sd=0 mult=1 m=1
csn_op1_1000_an_s0p1_r10k_0 sn_op1_1000_an_s0p1_r10k_0 0 {C_SN}
XMWR_op1_1000_an_s0p1_r10k_1 sn_op1_1000_an_s0p1_r10k_1 wwl_des wbl_op1_1000_an_s0p1_r10k 0 sky130_fd_pr__nfet_01v8 L=0.15 W=0.42 nf=1 ad=0.1218 as=0.1218 pd=1.42 ps=1.42 nrd=0.69047619047619  nrs=0.69047619047619 sa=0 sb=0 sd=0 mult=1 m=1
XMRD_op1_1000_an_s0p1_r10k_1 rbl_op1_1000_an_s0p1_r10k sn_op1_1000_an_s0p1_r10k_1 rwl_des 0 sky130_fd_pr__nfet_01v8 L=0.15 W=0.42 nf=1 ad=0.1218 as=0.1218 pd=1.42 ps=1.42 nrd=0.69047619047619  nrs=0.69047619047619 sa=0 sb=0 sd=0 mult=1 m=1
csn_op1_1000_an_s0p1_r10k_1 sn_op1_1000_an_s0p1_r10k_1 0 {C_SN}
XMWR_op1_1000_an_s0p1_r10k_2 sn_op1_1000_an_s0p1_r10k_2 wwl_des wbl_op1_1000_an_s0p1_r10k 0 sky130_fd_pr__nfet_01v8 L=0.15 W=0.42 nf=1 ad=0.1218 as=0.1218 pd=1.42 ps=1.42 nrd=0.69047619047619  nrs=0.69047619047619 sa=0 sb=0 sd=0 mult=1 m=1
XMRD_op1_1000_an_s0p1_r10k_2 rbl_op1_1000_an_s0p1_r10k sn_op1_1000_an_s0p1_r10k_2 rwl_des 0 sky130_fd_pr__nfet_01v8 L=0.15 W=0.42 nf=1 ad=0.1218 as=0.1218 pd=1.42 ps=1.42 nrd=0.69047619047619  nrs=0.69047619047619 sa=0 sb=0 sd=0 mult=1 m=1
csn_op1_1000_an_s0p1_r10k_2 sn_op1_1000_an_s0p1_r10k_2 0 {C_SN}
XMWR_op1_1000_an_s0p1_r10k_3 sn_op1_1000_an_s0p1_r10k_3 wwl_des wbl_op1_1000_an_s0p1_r10k 0 sky130_fd_pr__nfet_01v8 L=0.15 W=0.42 nf=1 ad=0.1218 as=0.1218 pd=1.42 ps=1.42 nrd=0.69047619047619  nrs=0.69047619047619 sa=0 sb=0 sd=0 mult=1 m=1
XMRD_op1_1000_an_s0p1_r10k_3 rbl_op1_1000_an_s0p1_r10k sn_op1_1000_an_s0p1_r10k_3 rwl_des 0 sky130_fd_pr__nfet_01v8 L=0.15 W=0.42 nf=1 ad=0.1218 as=0.1218 pd=1.42 ps=1.42 nrd=0.69047619047619  nrs=0.69047619047619 sa=0 sb=0 sd=0 mult=1 m=1
csn_op1_1000_an_s0p1_r10k_3 sn_op1_1000_an_s0p1_r10k_3 0 {C_SN}
XMN1_op1_1000_an_s0p1_r10k rbl_op1_1000_an_s0p1_r10k ref_op1_1000_an_s0p1_r10k vn_op1_1000_an_s0p1_r10k 0 sky130_fd_pr__nfet_01v8 L=0.15 W=1 nf=1 ad=0.29 as=0.29 pd=2.58 ps=2.58 mult=1 m=1
XMN2_op1_1000_an_s0p1_r10k ref_op1_1000_an_s0p1_r10k rbl_op1_1000_an_s0p1_r10k vn_op1_1000_an_s0p1_r10k 0 sky130_fd_pr__nfet_01v8 L=0.15 W=1 nf=1 ad=0.29 as=0.29 pd=2.58 ps=2.58 mult=1 m=1
XMP1_op1_1000_an_s0p1_r10k rbl_op1_1000_an_s0p1_r10k ref_op1_1000_an_s0p1_r10k vp_op1_1000_an_s0p1_r10k vdd sky130_fd_pr__pfet_01v8 L=0.15 W=2 nf=1 ad=0.58 as=0.58 pd=4.58 ps=4.58 mult=1 m=1
XMP2_op1_1000_an_s0p1_r10k ref_op1_1000_an_s0p1_r10k rbl_op1_1000_an_s0p1_r10k vp_op1_1000_an_s0p1_r10k vdd sky130_fd_pr__pfet_01v8 L=0.15 W=2 nf=1 ad=0.58 as=0.58 pd=4.58 ps=4.58 mult=1 m=1
XMNF_op1_1000_an_s0p1_r10k vn_op1_1000_an_s0p1_r10k en_op1_1000_an_s0p1_r10k 0 0 sky130_fd_pr__nfet_01v8 L=0.15 W=2 nf=1 ad=0.58 as=0.58 pd=4.58 ps=4.58 mult=1 m=1
XMPH_op1_1000_an_s0p1_r10k vp_op1_1000_an_s0p1_r10k enb_op1_1000_an_s0p1_r10k vdd vdd sky130_fd_pr__pfet_01v8 L=0.15 W=4 nf=1 ad=1.16 as=1.16 pd=8.58 ps=8.58 mult=1 m=1
bd_op1_1000_an_s0p1_r10k d_op1_1000_an_s0p1_r10k 0 v=v(rbl_op1_1000_an_s0p1_r10k)-v(ref_op1_1000_an_s0p1_r10k)

* ---- instance 67: op0_n100_an_s0p1_r10k (variant an_s0p1_r10k; probe dec 14.9 ns, release 37 ns, meas 39 ns) ----
vctl_op0_n100_an_s0p1_r10k ctl_op0_n100_an_s0p1_r10k 0 pwl(0.0000e+00 {VDD} 2.0000e-09 {VDD} 2.1000e-09 0)
* RWL driver model (EXPERIMENTAL): slew 0.1 ns, series R 10000 ohm; cell pin = rwls_op0_n100_an_s0p1_r10k
vrs_op0_n100_an_s0p1_r10k rwlsrc_op0_n100_an_s0p1_r10k 0 pwl(0.0000e+00 {VDD} 4.0000e-09 {VDD} 4.1000e-09 0 3.7000e-08 0 3.7100e-08 {VDD})
rdrv_op0_n100_an_s0p1_r10k rwlsrc_op0_n100_an_s0p1_r10k rwls_op0_n100_an_s0p1_r10k 10000
ven_op0_n100_an_s0p1_r10k en_op0_n100_an_s0p1_r10k 0 pwl(0.0000e+00 0 1.4000e-08 0 1.4100e-08 {VDD} 3.7000e-08 {VDD} 3.7100e-08 0)
venb_op0_n100_an_s0p1_r10k enb_op0_n100_an_s0p1_r10k 0 pwl(0.0000e+00 {VDD} 1.4000e-08 {VDD} 1.4100e-08 0 3.7000e-08 0 3.7100e-08 {VDD})
vww_op0_n100_an_s0p1_r10k wwl_op0_n100_an_s0p1_r10k 0 pwl(0.0000e+00 0 1.5000e-08 0 1.5100e-08 {VDD} 3.5000e-08 {VDD} 3.5100e-08 0)
vwc_op0_n100_an_s0p1_r10k wbc_op0_n100_an_s0p1_r10k 0 pwl(0.0000e+00 0 1.5000e-08 0 1.5100e-08 {VDD} 3.7000e-08 {VDD} 3.7100e-08 0)
swb_op0_n100_an_s0p1_r10k ref_op0_n100_an_s0p1_r10k wbl_op0_n100_an_s0p1_r10k wbc_op0_n100_an_s0p1_r10k 0 swwbl
cwbl_op0_n100_an_s0p1_r10k wbl_op0_n100_an_s0p1_r10k 0 {C_WBL}
spa_op0_n100_an_s0p1_r10k prea rbl_op0_n100_an_s0p1_r10k ctl_op0_n100_an_s0p1_r10k 0 swpre
spr_op0_n100_an_s0p1_r10k pref ref_op0_n100_an_s0p1_r10k ctl_op0_n100_an_s0p1_r10k 0 swpre
crbl_op0_n100_an_s0p1_r10k rbl_op0_n100_an_s0p1_r10k 0 {C_RBL}
cref_op0_n100_an_s0p1_r10k ref_op0_n100_an_s0p1_r10k 0 {C_RBL}   $ ASSUMPTION: ideal matched dummy load
XMWR_op0_n100_an_s0p1_r10k_0 sn_op0_n100_an_s0p1_r10k_0 wwl_op0_n100_an_s0p1_r10k wbl_op0_n100_an_s0p1_r10k 0 sky130_fd_pr__nfet_01v8 L=0.15 W=0.42 nf=1 ad=0.1218 as=0.1218 pd=1.42 ps=1.42 nrd=0.69047619047619  nrs=0.69047619047619 sa=0 sb=0 sd=0 mult=1 m=1
XMRD_op0_n100_an_s0p1_r10k_0 rbl_op0_n100_an_s0p1_r10k sn_op0_n100_an_s0p1_r10k_0 rwls_op0_n100_an_s0p1_r10k 0 sky130_fd_pr__nfet_01v8 L=0.15 W=0.42 nf=1 ad=0.1218 as=0.1218 pd=1.42 ps=1.42 nrd=0.69047619047619  nrs=0.69047619047619 sa=0 sb=0 sd=0 mult=1 m=1
csn_op0_n100_an_s0p1_r10k_0 sn_op0_n100_an_s0p1_r10k_0 0 {C_SN}
XMWR_op0_n100_an_s0p1_r10k_1 sn_op0_n100_an_s0p1_r10k_1 wwl_des wbl_op0_n100_an_s0p1_r10k 0 sky130_fd_pr__nfet_01v8 L=0.15 W=0.42 nf=1 ad=0.1218 as=0.1218 pd=1.42 ps=1.42 nrd=0.69047619047619  nrs=0.69047619047619 sa=0 sb=0 sd=0 mult=1 m=1
XMRD_op0_n100_an_s0p1_r10k_1 rbl_op0_n100_an_s0p1_r10k sn_op0_n100_an_s0p1_r10k_1 rwl_des 0 sky130_fd_pr__nfet_01v8 L=0.15 W=0.42 nf=1 ad=0.1218 as=0.1218 pd=1.42 ps=1.42 nrd=0.69047619047619  nrs=0.69047619047619 sa=0 sb=0 sd=0 mult=1 m=1
csn_op0_n100_an_s0p1_r10k_1 sn_op0_n100_an_s0p1_r10k_1 0 {C_SN}
XMWR_op0_n100_an_s0p1_r10k_2 sn_op0_n100_an_s0p1_r10k_2 wwl_des wbl_op0_n100_an_s0p1_r10k 0 sky130_fd_pr__nfet_01v8 L=0.15 W=0.42 nf=1 ad=0.1218 as=0.1218 pd=1.42 ps=1.42 nrd=0.69047619047619  nrs=0.69047619047619 sa=0 sb=0 sd=0 mult=1 m=1
XMRD_op0_n100_an_s0p1_r10k_2 rbl_op0_n100_an_s0p1_r10k sn_op0_n100_an_s0p1_r10k_2 rwl_des 0 sky130_fd_pr__nfet_01v8 L=0.15 W=0.42 nf=1 ad=0.1218 as=0.1218 pd=1.42 ps=1.42 nrd=0.69047619047619  nrs=0.69047619047619 sa=0 sb=0 sd=0 mult=1 m=1
csn_op0_n100_an_s0p1_r10k_2 sn_op0_n100_an_s0p1_r10k_2 0 {C_SN}
XMWR_op0_n100_an_s0p1_r10k_3 sn_op0_n100_an_s0p1_r10k_3 wwl_des wbl_op0_n100_an_s0p1_r10k 0 sky130_fd_pr__nfet_01v8 L=0.15 W=0.42 nf=1 ad=0.1218 as=0.1218 pd=1.42 ps=1.42 nrd=0.69047619047619  nrs=0.69047619047619 sa=0 sb=0 sd=0 mult=1 m=1
XMRD_op0_n100_an_s0p1_r10k_3 rbl_op0_n100_an_s0p1_r10k sn_op0_n100_an_s0p1_r10k_3 rwl_des 0 sky130_fd_pr__nfet_01v8 L=0.15 W=0.42 nf=1 ad=0.1218 as=0.1218 pd=1.42 ps=1.42 nrd=0.69047619047619  nrs=0.69047619047619 sa=0 sb=0 sd=0 mult=1 m=1
csn_op0_n100_an_s0p1_r10k_3 sn_op0_n100_an_s0p1_r10k_3 0 {C_SN}
XMN1_op0_n100_an_s0p1_r10k rbl_op0_n100_an_s0p1_r10k ref_op0_n100_an_s0p1_r10k vn_op0_n100_an_s0p1_r10k 0 sky130_fd_pr__nfet_01v8 L=0.15 W=1 nf=1 ad=0.29 as=0.29 pd=2.58 ps=2.58 mult=1 m=1
XMN2_op0_n100_an_s0p1_r10k ref_op0_n100_an_s0p1_r10k rbl_op0_n100_an_s0p1_r10k vn_op0_n100_an_s0p1_r10k 0 sky130_fd_pr__nfet_01v8 L=0.15 W=1 nf=1 ad=0.29 as=0.29 pd=2.58 ps=2.58 mult=1 m=1
XMP1_op0_n100_an_s0p1_r10k rbl_op0_n100_an_s0p1_r10k ref_op0_n100_an_s0p1_r10k vp_op0_n100_an_s0p1_r10k vdd sky130_fd_pr__pfet_01v8 L=0.15 W=2 nf=1 ad=0.58 as=0.58 pd=4.58 ps=4.58 mult=1 m=1
XMP2_op0_n100_an_s0p1_r10k ref_op0_n100_an_s0p1_r10k rbl_op0_n100_an_s0p1_r10k vp_op0_n100_an_s0p1_r10k vdd sky130_fd_pr__pfet_01v8 L=0.15 W=2 nf=1 ad=0.58 as=0.58 pd=4.58 ps=4.58 mult=1 m=1
XMNF_op0_n100_an_s0p1_r10k vn_op0_n100_an_s0p1_r10k en_op0_n100_an_s0p1_r10k 0 0 sky130_fd_pr__nfet_01v8 L=0.15 W=2 nf=1 ad=0.58 as=0.58 pd=4.58 ps=4.58 mult=1 m=1
XMPH_op0_n100_an_s0p1_r10k vp_op0_n100_an_s0p1_r10k enb_op0_n100_an_s0p1_r10k vdd vdd sky130_fd_pr__pfet_01v8 L=0.15 W=4 nf=1 ad=1.16 as=1.16 pd=8.58 ps=8.58 mult=1 m=1
bd_op0_n100_an_s0p1_r10k d_op0_n100_an_s0p1_r10k 0 v=v(rbl_op0_n100_an_s0p1_r10k)-v(ref_op0_n100_an_s0p1_r10k)

* ---- instance 68: op0_0000_an_s0p1_r10k (variant an_s0p1_r10k; probe dec 14.9 ns, release 37 ns, meas 39 ns) ----
vctl_op0_0000_an_s0p1_r10k ctl_op0_0000_an_s0p1_r10k 0 pwl(0.0000e+00 {VDD} 2.0000e-09 {VDD} 2.1000e-09 0)
* RWL driver model (EXPERIMENTAL): slew 0.1 ns, series R 10000 ohm; cell pin = rwls_op0_0000_an_s0p1_r10k
vrs_op0_0000_an_s0p1_r10k rwlsrc_op0_0000_an_s0p1_r10k 0 pwl(0.0000e+00 {VDD} 4.0000e-09 {VDD} 4.1000e-09 0 3.7000e-08 0 3.7100e-08 {VDD})
rdrv_op0_0000_an_s0p1_r10k rwlsrc_op0_0000_an_s0p1_r10k rwls_op0_0000_an_s0p1_r10k 10000
ven_op0_0000_an_s0p1_r10k en_op0_0000_an_s0p1_r10k 0 pwl(0.0000e+00 0 1.4000e-08 0 1.4100e-08 {VDD} 3.7000e-08 {VDD} 3.7100e-08 0)
venb_op0_0000_an_s0p1_r10k enb_op0_0000_an_s0p1_r10k 0 pwl(0.0000e+00 {VDD} 1.4000e-08 {VDD} 1.4100e-08 0 3.7000e-08 0 3.7100e-08 {VDD})
vww_op0_0000_an_s0p1_r10k wwl_op0_0000_an_s0p1_r10k 0 pwl(0.0000e+00 0 1.5000e-08 0 1.5100e-08 {VDD} 3.5000e-08 {VDD} 3.5100e-08 0)
vwc_op0_0000_an_s0p1_r10k wbc_op0_0000_an_s0p1_r10k 0 pwl(0.0000e+00 0 1.5000e-08 0 1.5100e-08 {VDD} 3.7000e-08 {VDD} 3.7100e-08 0)
swb_op0_0000_an_s0p1_r10k ref_op0_0000_an_s0p1_r10k wbl_op0_0000_an_s0p1_r10k wbc_op0_0000_an_s0p1_r10k 0 swwbl
cwbl_op0_0000_an_s0p1_r10k wbl_op0_0000_an_s0p1_r10k 0 {C_WBL}
spa_op0_0000_an_s0p1_r10k prea rbl_op0_0000_an_s0p1_r10k ctl_op0_0000_an_s0p1_r10k 0 swpre
spr_op0_0000_an_s0p1_r10k pref ref_op0_0000_an_s0p1_r10k ctl_op0_0000_an_s0p1_r10k 0 swpre
crbl_op0_0000_an_s0p1_r10k rbl_op0_0000_an_s0p1_r10k 0 {C_RBL}
cref_op0_0000_an_s0p1_r10k ref_op0_0000_an_s0p1_r10k 0 {C_RBL}   $ ASSUMPTION: ideal matched dummy load
XMWR_op0_0000_an_s0p1_r10k_0 sn_op0_0000_an_s0p1_r10k_0 wwl_op0_0000_an_s0p1_r10k wbl_op0_0000_an_s0p1_r10k 0 sky130_fd_pr__nfet_01v8 L=0.15 W=0.42 nf=1 ad=0.1218 as=0.1218 pd=1.42 ps=1.42 nrd=0.69047619047619  nrs=0.69047619047619 sa=0 sb=0 sd=0 mult=1 m=1
XMRD_op0_0000_an_s0p1_r10k_0 rbl_op0_0000_an_s0p1_r10k sn_op0_0000_an_s0p1_r10k_0 rwls_op0_0000_an_s0p1_r10k 0 sky130_fd_pr__nfet_01v8 L=0.15 W=0.42 nf=1 ad=0.1218 as=0.1218 pd=1.42 ps=1.42 nrd=0.69047619047619  nrs=0.69047619047619 sa=0 sb=0 sd=0 mult=1 m=1
csn_op0_0000_an_s0p1_r10k_0 sn_op0_0000_an_s0p1_r10k_0 0 {C_SN}
XMWR_op0_0000_an_s0p1_r10k_1 sn_op0_0000_an_s0p1_r10k_1 wwl_des wbl_op0_0000_an_s0p1_r10k 0 sky130_fd_pr__nfet_01v8 L=0.15 W=0.42 nf=1 ad=0.1218 as=0.1218 pd=1.42 ps=1.42 nrd=0.69047619047619  nrs=0.69047619047619 sa=0 sb=0 sd=0 mult=1 m=1
XMRD_op0_0000_an_s0p1_r10k_1 rbl_op0_0000_an_s0p1_r10k sn_op0_0000_an_s0p1_r10k_1 rwl_des 0 sky130_fd_pr__nfet_01v8 L=0.15 W=0.42 nf=1 ad=0.1218 as=0.1218 pd=1.42 ps=1.42 nrd=0.69047619047619  nrs=0.69047619047619 sa=0 sb=0 sd=0 mult=1 m=1
csn_op0_0000_an_s0p1_r10k_1 sn_op0_0000_an_s0p1_r10k_1 0 {C_SN}
XMWR_op0_0000_an_s0p1_r10k_2 sn_op0_0000_an_s0p1_r10k_2 wwl_des wbl_op0_0000_an_s0p1_r10k 0 sky130_fd_pr__nfet_01v8 L=0.15 W=0.42 nf=1 ad=0.1218 as=0.1218 pd=1.42 ps=1.42 nrd=0.69047619047619  nrs=0.69047619047619 sa=0 sb=0 sd=0 mult=1 m=1
XMRD_op0_0000_an_s0p1_r10k_2 rbl_op0_0000_an_s0p1_r10k sn_op0_0000_an_s0p1_r10k_2 rwl_des 0 sky130_fd_pr__nfet_01v8 L=0.15 W=0.42 nf=1 ad=0.1218 as=0.1218 pd=1.42 ps=1.42 nrd=0.69047619047619  nrs=0.69047619047619 sa=0 sb=0 sd=0 mult=1 m=1
csn_op0_0000_an_s0p1_r10k_2 sn_op0_0000_an_s0p1_r10k_2 0 {C_SN}
XMWR_op0_0000_an_s0p1_r10k_3 sn_op0_0000_an_s0p1_r10k_3 wwl_des wbl_op0_0000_an_s0p1_r10k 0 sky130_fd_pr__nfet_01v8 L=0.15 W=0.42 nf=1 ad=0.1218 as=0.1218 pd=1.42 ps=1.42 nrd=0.69047619047619  nrs=0.69047619047619 sa=0 sb=0 sd=0 mult=1 m=1
XMRD_op0_0000_an_s0p1_r10k_3 rbl_op0_0000_an_s0p1_r10k sn_op0_0000_an_s0p1_r10k_3 rwl_des 0 sky130_fd_pr__nfet_01v8 L=0.15 W=0.42 nf=1 ad=0.1218 as=0.1218 pd=1.42 ps=1.42 nrd=0.69047619047619  nrs=0.69047619047619 sa=0 sb=0 sd=0 mult=1 m=1
csn_op0_0000_an_s0p1_r10k_3 sn_op0_0000_an_s0p1_r10k_3 0 {C_SN}
XMN1_op0_0000_an_s0p1_r10k rbl_op0_0000_an_s0p1_r10k ref_op0_0000_an_s0p1_r10k vn_op0_0000_an_s0p1_r10k 0 sky130_fd_pr__nfet_01v8 L=0.15 W=1 nf=1 ad=0.29 as=0.29 pd=2.58 ps=2.58 mult=1 m=1
XMN2_op0_0000_an_s0p1_r10k ref_op0_0000_an_s0p1_r10k rbl_op0_0000_an_s0p1_r10k vn_op0_0000_an_s0p1_r10k 0 sky130_fd_pr__nfet_01v8 L=0.15 W=1 nf=1 ad=0.29 as=0.29 pd=2.58 ps=2.58 mult=1 m=1
XMP1_op0_0000_an_s0p1_r10k rbl_op0_0000_an_s0p1_r10k ref_op0_0000_an_s0p1_r10k vp_op0_0000_an_s0p1_r10k vdd sky130_fd_pr__pfet_01v8 L=0.15 W=2 nf=1 ad=0.58 as=0.58 pd=4.58 ps=4.58 mult=1 m=1
XMP2_op0_0000_an_s0p1_r10k ref_op0_0000_an_s0p1_r10k rbl_op0_0000_an_s0p1_r10k vp_op0_0000_an_s0p1_r10k vdd sky130_fd_pr__pfet_01v8 L=0.15 W=2 nf=1 ad=0.58 as=0.58 pd=4.58 ps=4.58 mult=1 m=1
XMNF_op0_0000_an_s0p1_r10k vn_op0_0000_an_s0p1_r10k en_op0_0000_an_s0p1_r10k 0 0 sky130_fd_pr__nfet_01v8 L=0.15 W=2 nf=1 ad=0.58 as=0.58 pd=4.58 ps=4.58 mult=1 m=1
XMPH_op0_0000_an_s0p1_r10k vp_op0_0000_an_s0p1_r10k enb_op0_0000_an_s0p1_r10k vdd vdd sky130_fd_pr__pfet_01v8 L=0.15 W=4 nf=1 ad=1.16 as=1.16 pd=8.58 ps=8.58 mult=1 m=1
bd_op0_0000_an_s0p1_r10k d_op0_0000_an_s0p1_r10k 0 v=v(rbl_op0_0000_an_s0p1_r10k)-v(ref_op0_0000_an_s0p1_r10k)

* ---- instance 69: op1_0900_an_s0p1_r30k (variant an_s0p1_r30k; probe dec 14.9 ns, release 37 ns, meas 39 ns) ----
vctl_op1_0900_an_s0p1_r30k ctl_op1_0900_an_s0p1_r30k 0 pwl(0.0000e+00 {VDD} 2.0000e-09 {VDD} 2.1000e-09 0)
* RWL driver model (EXPERIMENTAL): slew 0.1 ns, series R 30000 ohm; cell pin = rwls_op1_0900_an_s0p1_r30k
vrs_op1_0900_an_s0p1_r30k rwlsrc_op1_0900_an_s0p1_r30k 0 pwl(0.0000e+00 {VDD} 4.0000e-09 {VDD} 4.1000e-09 0 3.7000e-08 0 3.7100e-08 {VDD})
rdrv_op1_0900_an_s0p1_r30k rwlsrc_op1_0900_an_s0p1_r30k rwls_op1_0900_an_s0p1_r30k 30000
ven_op1_0900_an_s0p1_r30k en_op1_0900_an_s0p1_r30k 0 pwl(0.0000e+00 0 1.4000e-08 0 1.4100e-08 {VDD} 3.7000e-08 {VDD} 3.7100e-08 0)
venb_op1_0900_an_s0p1_r30k enb_op1_0900_an_s0p1_r30k 0 pwl(0.0000e+00 {VDD} 1.4000e-08 {VDD} 1.4100e-08 0 3.7000e-08 0 3.7100e-08 {VDD})
vww_op1_0900_an_s0p1_r30k wwl_op1_0900_an_s0p1_r30k 0 pwl(0.0000e+00 0 1.5000e-08 0 1.5100e-08 {VDD} 3.5000e-08 {VDD} 3.5100e-08 0)
vwc_op1_0900_an_s0p1_r30k wbc_op1_0900_an_s0p1_r30k 0 pwl(0.0000e+00 0 1.5000e-08 0 1.5100e-08 {VDD} 3.7000e-08 {VDD} 3.7100e-08 0)
swb_op1_0900_an_s0p1_r30k ref_op1_0900_an_s0p1_r30k wbl_op1_0900_an_s0p1_r30k wbc_op1_0900_an_s0p1_r30k 0 swwbl
cwbl_op1_0900_an_s0p1_r30k wbl_op1_0900_an_s0p1_r30k 0 {C_WBL}
spa_op1_0900_an_s0p1_r30k prea rbl_op1_0900_an_s0p1_r30k ctl_op1_0900_an_s0p1_r30k 0 swpre
spr_op1_0900_an_s0p1_r30k pref ref_op1_0900_an_s0p1_r30k ctl_op1_0900_an_s0p1_r30k 0 swpre
crbl_op1_0900_an_s0p1_r30k rbl_op1_0900_an_s0p1_r30k 0 {C_RBL}
cref_op1_0900_an_s0p1_r30k ref_op1_0900_an_s0p1_r30k 0 {C_RBL}   $ ASSUMPTION: ideal matched dummy load
XMWR_op1_0900_an_s0p1_r30k_0 sn_op1_0900_an_s0p1_r30k_0 wwl_op1_0900_an_s0p1_r30k wbl_op1_0900_an_s0p1_r30k 0 sky130_fd_pr__nfet_01v8 L=0.15 W=0.42 nf=1 ad=0.1218 as=0.1218 pd=1.42 ps=1.42 nrd=0.69047619047619  nrs=0.69047619047619 sa=0 sb=0 sd=0 mult=1 m=1
XMRD_op1_0900_an_s0p1_r30k_0 rbl_op1_0900_an_s0p1_r30k sn_op1_0900_an_s0p1_r30k_0 rwls_op1_0900_an_s0p1_r30k 0 sky130_fd_pr__nfet_01v8 L=0.15 W=0.42 nf=1 ad=0.1218 as=0.1218 pd=1.42 ps=1.42 nrd=0.69047619047619  nrs=0.69047619047619 sa=0 sb=0 sd=0 mult=1 m=1
csn_op1_0900_an_s0p1_r30k_0 sn_op1_0900_an_s0p1_r30k_0 0 {C_SN}
XMWR_op1_0900_an_s0p1_r30k_1 sn_op1_0900_an_s0p1_r30k_1 wwl_des wbl_op1_0900_an_s0p1_r30k 0 sky130_fd_pr__nfet_01v8 L=0.15 W=0.42 nf=1 ad=0.1218 as=0.1218 pd=1.42 ps=1.42 nrd=0.69047619047619  nrs=0.69047619047619 sa=0 sb=0 sd=0 mult=1 m=1
XMRD_op1_0900_an_s0p1_r30k_1 rbl_op1_0900_an_s0p1_r30k sn_op1_0900_an_s0p1_r30k_1 rwl_des 0 sky130_fd_pr__nfet_01v8 L=0.15 W=0.42 nf=1 ad=0.1218 as=0.1218 pd=1.42 ps=1.42 nrd=0.69047619047619  nrs=0.69047619047619 sa=0 sb=0 sd=0 mult=1 m=1
csn_op1_0900_an_s0p1_r30k_1 sn_op1_0900_an_s0p1_r30k_1 0 {C_SN}
XMWR_op1_0900_an_s0p1_r30k_2 sn_op1_0900_an_s0p1_r30k_2 wwl_des wbl_op1_0900_an_s0p1_r30k 0 sky130_fd_pr__nfet_01v8 L=0.15 W=0.42 nf=1 ad=0.1218 as=0.1218 pd=1.42 ps=1.42 nrd=0.69047619047619  nrs=0.69047619047619 sa=0 sb=0 sd=0 mult=1 m=1
XMRD_op1_0900_an_s0p1_r30k_2 rbl_op1_0900_an_s0p1_r30k sn_op1_0900_an_s0p1_r30k_2 rwl_des 0 sky130_fd_pr__nfet_01v8 L=0.15 W=0.42 nf=1 ad=0.1218 as=0.1218 pd=1.42 ps=1.42 nrd=0.69047619047619  nrs=0.69047619047619 sa=0 sb=0 sd=0 mult=1 m=1
csn_op1_0900_an_s0p1_r30k_2 sn_op1_0900_an_s0p1_r30k_2 0 {C_SN}
XMWR_op1_0900_an_s0p1_r30k_3 sn_op1_0900_an_s0p1_r30k_3 wwl_des wbl_op1_0900_an_s0p1_r30k 0 sky130_fd_pr__nfet_01v8 L=0.15 W=0.42 nf=1 ad=0.1218 as=0.1218 pd=1.42 ps=1.42 nrd=0.69047619047619  nrs=0.69047619047619 sa=0 sb=0 sd=0 mult=1 m=1
XMRD_op1_0900_an_s0p1_r30k_3 rbl_op1_0900_an_s0p1_r30k sn_op1_0900_an_s0p1_r30k_3 rwl_des 0 sky130_fd_pr__nfet_01v8 L=0.15 W=0.42 nf=1 ad=0.1218 as=0.1218 pd=1.42 ps=1.42 nrd=0.69047619047619  nrs=0.69047619047619 sa=0 sb=0 sd=0 mult=1 m=1
csn_op1_0900_an_s0p1_r30k_3 sn_op1_0900_an_s0p1_r30k_3 0 {C_SN}
XMN1_op1_0900_an_s0p1_r30k rbl_op1_0900_an_s0p1_r30k ref_op1_0900_an_s0p1_r30k vn_op1_0900_an_s0p1_r30k 0 sky130_fd_pr__nfet_01v8 L=0.15 W=1 nf=1 ad=0.29 as=0.29 pd=2.58 ps=2.58 mult=1 m=1
XMN2_op1_0900_an_s0p1_r30k ref_op1_0900_an_s0p1_r30k rbl_op1_0900_an_s0p1_r30k vn_op1_0900_an_s0p1_r30k 0 sky130_fd_pr__nfet_01v8 L=0.15 W=1 nf=1 ad=0.29 as=0.29 pd=2.58 ps=2.58 mult=1 m=1
XMP1_op1_0900_an_s0p1_r30k rbl_op1_0900_an_s0p1_r30k ref_op1_0900_an_s0p1_r30k vp_op1_0900_an_s0p1_r30k vdd sky130_fd_pr__pfet_01v8 L=0.15 W=2 nf=1 ad=0.58 as=0.58 pd=4.58 ps=4.58 mult=1 m=1
XMP2_op1_0900_an_s0p1_r30k ref_op1_0900_an_s0p1_r30k rbl_op1_0900_an_s0p1_r30k vp_op1_0900_an_s0p1_r30k vdd sky130_fd_pr__pfet_01v8 L=0.15 W=2 nf=1 ad=0.58 as=0.58 pd=4.58 ps=4.58 mult=1 m=1
XMNF_op1_0900_an_s0p1_r30k vn_op1_0900_an_s0p1_r30k en_op1_0900_an_s0p1_r30k 0 0 sky130_fd_pr__nfet_01v8 L=0.15 W=2 nf=1 ad=0.58 as=0.58 pd=4.58 ps=4.58 mult=1 m=1
XMPH_op1_0900_an_s0p1_r30k vp_op1_0900_an_s0p1_r30k enb_op1_0900_an_s0p1_r30k vdd vdd sky130_fd_pr__pfet_01v8 L=0.15 W=4 nf=1 ad=1.16 as=1.16 pd=8.58 ps=8.58 mult=1 m=1
bd_op1_0900_an_s0p1_r30k d_op1_0900_an_s0p1_r30k 0 v=v(rbl_op1_0900_an_s0p1_r30k)-v(ref_op1_0900_an_s0p1_r30k)

* ---- instance 70: op1_1000_an_s0p1_r30k (variant an_s0p1_r30k; probe dec 14.9 ns, release 37 ns, meas 39 ns) ----
vctl_op1_1000_an_s0p1_r30k ctl_op1_1000_an_s0p1_r30k 0 pwl(0.0000e+00 {VDD} 2.0000e-09 {VDD} 2.1000e-09 0)
* RWL driver model (EXPERIMENTAL): slew 0.1 ns, series R 30000 ohm; cell pin = rwls_op1_1000_an_s0p1_r30k
vrs_op1_1000_an_s0p1_r30k rwlsrc_op1_1000_an_s0p1_r30k 0 pwl(0.0000e+00 {VDD} 4.0000e-09 {VDD} 4.1000e-09 0 3.7000e-08 0 3.7100e-08 {VDD})
rdrv_op1_1000_an_s0p1_r30k rwlsrc_op1_1000_an_s0p1_r30k rwls_op1_1000_an_s0p1_r30k 30000
ven_op1_1000_an_s0p1_r30k en_op1_1000_an_s0p1_r30k 0 pwl(0.0000e+00 0 1.4000e-08 0 1.4100e-08 {VDD} 3.7000e-08 {VDD} 3.7100e-08 0)
venb_op1_1000_an_s0p1_r30k enb_op1_1000_an_s0p1_r30k 0 pwl(0.0000e+00 {VDD} 1.4000e-08 {VDD} 1.4100e-08 0 3.7000e-08 0 3.7100e-08 {VDD})
vww_op1_1000_an_s0p1_r30k wwl_op1_1000_an_s0p1_r30k 0 pwl(0.0000e+00 0 1.5000e-08 0 1.5100e-08 {VDD} 3.5000e-08 {VDD} 3.5100e-08 0)
vwc_op1_1000_an_s0p1_r30k wbc_op1_1000_an_s0p1_r30k 0 pwl(0.0000e+00 0 1.5000e-08 0 1.5100e-08 {VDD} 3.7000e-08 {VDD} 3.7100e-08 0)
swb_op1_1000_an_s0p1_r30k ref_op1_1000_an_s0p1_r30k wbl_op1_1000_an_s0p1_r30k wbc_op1_1000_an_s0p1_r30k 0 swwbl
cwbl_op1_1000_an_s0p1_r30k wbl_op1_1000_an_s0p1_r30k 0 {C_WBL}
spa_op1_1000_an_s0p1_r30k prea rbl_op1_1000_an_s0p1_r30k ctl_op1_1000_an_s0p1_r30k 0 swpre
spr_op1_1000_an_s0p1_r30k pref ref_op1_1000_an_s0p1_r30k ctl_op1_1000_an_s0p1_r30k 0 swpre
crbl_op1_1000_an_s0p1_r30k rbl_op1_1000_an_s0p1_r30k 0 {C_RBL}
cref_op1_1000_an_s0p1_r30k ref_op1_1000_an_s0p1_r30k 0 {C_RBL}   $ ASSUMPTION: ideal matched dummy load
XMWR_op1_1000_an_s0p1_r30k_0 sn_op1_1000_an_s0p1_r30k_0 wwl_op1_1000_an_s0p1_r30k wbl_op1_1000_an_s0p1_r30k 0 sky130_fd_pr__nfet_01v8 L=0.15 W=0.42 nf=1 ad=0.1218 as=0.1218 pd=1.42 ps=1.42 nrd=0.69047619047619  nrs=0.69047619047619 sa=0 sb=0 sd=0 mult=1 m=1
XMRD_op1_1000_an_s0p1_r30k_0 rbl_op1_1000_an_s0p1_r30k sn_op1_1000_an_s0p1_r30k_0 rwls_op1_1000_an_s0p1_r30k 0 sky130_fd_pr__nfet_01v8 L=0.15 W=0.42 nf=1 ad=0.1218 as=0.1218 pd=1.42 ps=1.42 nrd=0.69047619047619  nrs=0.69047619047619 sa=0 sb=0 sd=0 mult=1 m=1
csn_op1_1000_an_s0p1_r30k_0 sn_op1_1000_an_s0p1_r30k_0 0 {C_SN}
XMWR_op1_1000_an_s0p1_r30k_1 sn_op1_1000_an_s0p1_r30k_1 wwl_des wbl_op1_1000_an_s0p1_r30k 0 sky130_fd_pr__nfet_01v8 L=0.15 W=0.42 nf=1 ad=0.1218 as=0.1218 pd=1.42 ps=1.42 nrd=0.69047619047619  nrs=0.69047619047619 sa=0 sb=0 sd=0 mult=1 m=1
XMRD_op1_1000_an_s0p1_r30k_1 rbl_op1_1000_an_s0p1_r30k sn_op1_1000_an_s0p1_r30k_1 rwl_des 0 sky130_fd_pr__nfet_01v8 L=0.15 W=0.42 nf=1 ad=0.1218 as=0.1218 pd=1.42 ps=1.42 nrd=0.69047619047619  nrs=0.69047619047619 sa=0 sb=0 sd=0 mult=1 m=1
csn_op1_1000_an_s0p1_r30k_1 sn_op1_1000_an_s0p1_r30k_1 0 {C_SN}
XMWR_op1_1000_an_s0p1_r30k_2 sn_op1_1000_an_s0p1_r30k_2 wwl_des wbl_op1_1000_an_s0p1_r30k 0 sky130_fd_pr__nfet_01v8 L=0.15 W=0.42 nf=1 ad=0.1218 as=0.1218 pd=1.42 ps=1.42 nrd=0.69047619047619  nrs=0.69047619047619 sa=0 sb=0 sd=0 mult=1 m=1
XMRD_op1_1000_an_s0p1_r30k_2 rbl_op1_1000_an_s0p1_r30k sn_op1_1000_an_s0p1_r30k_2 rwl_des 0 sky130_fd_pr__nfet_01v8 L=0.15 W=0.42 nf=1 ad=0.1218 as=0.1218 pd=1.42 ps=1.42 nrd=0.69047619047619  nrs=0.69047619047619 sa=0 sb=0 sd=0 mult=1 m=1
csn_op1_1000_an_s0p1_r30k_2 sn_op1_1000_an_s0p1_r30k_2 0 {C_SN}
XMWR_op1_1000_an_s0p1_r30k_3 sn_op1_1000_an_s0p1_r30k_3 wwl_des wbl_op1_1000_an_s0p1_r30k 0 sky130_fd_pr__nfet_01v8 L=0.15 W=0.42 nf=1 ad=0.1218 as=0.1218 pd=1.42 ps=1.42 nrd=0.69047619047619  nrs=0.69047619047619 sa=0 sb=0 sd=0 mult=1 m=1
XMRD_op1_1000_an_s0p1_r30k_3 rbl_op1_1000_an_s0p1_r30k sn_op1_1000_an_s0p1_r30k_3 rwl_des 0 sky130_fd_pr__nfet_01v8 L=0.15 W=0.42 nf=1 ad=0.1218 as=0.1218 pd=1.42 ps=1.42 nrd=0.69047619047619  nrs=0.69047619047619 sa=0 sb=0 sd=0 mult=1 m=1
csn_op1_1000_an_s0p1_r30k_3 sn_op1_1000_an_s0p1_r30k_3 0 {C_SN}
XMN1_op1_1000_an_s0p1_r30k rbl_op1_1000_an_s0p1_r30k ref_op1_1000_an_s0p1_r30k vn_op1_1000_an_s0p1_r30k 0 sky130_fd_pr__nfet_01v8 L=0.15 W=1 nf=1 ad=0.29 as=0.29 pd=2.58 ps=2.58 mult=1 m=1
XMN2_op1_1000_an_s0p1_r30k ref_op1_1000_an_s0p1_r30k rbl_op1_1000_an_s0p1_r30k vn_op1_1000_an_s0p1_r30k 0 sky130_fd_pr__nfet_01v8 L=0.15 W=1 nf=1 ad=0.29 as=0.29 pd=2.58 ps=2.58 mult=1 m=1
XMP1_op1_1000_an_s0p1_r30k rbl_op1_1000_an_s0p1_r30k ref_op1_1000_an_s0p1_r30k vp_op1_1000_an_s0p1_r30k vdd sky130_fd_pr__pfet_01v8 L=0.15 W=2 nf=1 ad=0.58 as=0.58 pd=4.58 ps=4.58 mult=1 m=1
XMP2_op1_1000_an_s0p1_r30k ref_op1_1000_an_s0p1_r30k rbl_op1_1000_an_s0p1_r30k vp_op1_1000_an_s0p1_r30k vdd sky130_fd_pr__pfet_01v8 L=0.15 W=2 nf=1 ad=0.58 as=0.58 pd=4.58 ps=4.58 mult=1 m=1
XMNF_op1_1000_an_s0p1_r30k vn_op1_1000_an_s0p1_r30k en_op1_1000_an_s0p1_r30k 0 0 sky130_fd_pr__nfet_01v8 L=0.15 W=2 nf=1 ad=0.58 as=0.58 pd=4.58 ps=4.58 mult=1 m=1
XMPH_op1_1000_an_s0p1_r30k vp_op1_1000_an_s0p1_r30k enb_op1_1000_an_s0p1_r30k vdd vdd sky130_fd_pr__pfet_01v8 L=0.15 W=4 nf=1 ad=1.16 as=1.16 pd=8.58 ps=8.58 mult=1 m=1
bd_op1_1000_an_s0p1_r30k d_op1_1000_an_s0p1_r30k 0 v=v(rbl_op1_1000_an_s0p1_r30k)-v(ref_op1_1000_an_s0p1_r30k)

* ---- instance 71: op0_n100_an_s0p1_r30k (variant an_s0p1_r30k; probe dec 14.9 ns, release 37 ns, meas 39 ns) ----
vctl_op0_n100_an_s0p1_r30k ctl_op0_n100_an_s0p1_r30k 0 pwl(0.0000e+00 {VDD} 2.0000e-09 {VDD} 2.1000e-09 0)
* RWL driver model (EXPERIMENTAL): slew 0.1 ns, series R 30000 ohm; cell pin = rwls_op0_n100_an_s0p1_r30k
vrs_op0_n100_an_s0p1_r30k rwlsrc_op0_n100_an_s0p1_r30k 0 pwl(0.0000e+00 {VDD} 4.0000e-09 {VDD} 4.1000e-09 0 3.7000e-08 0 3.7100e-08 {VDD})
rdrv_op0_n100_an_s0p1_r30k rwlsrc_op0_n100_an_s0p1_r30k rwls_op0_n100_an_s0p1_r30k 30000
ven_op0_n100_an_s0p1_r30k en_op0_n100_an_s0p1_r30k 0 pwl(0.0000e+00 0 1.4000e-08 0 1.4100e-08 {VDD} 3.7000e-08 {VDD} 3.7100e-08 0)
venb_op0_n100_an_s0p1_r30k enb_op0_n100_an_s0p1_r30k 0 pwl(0.0000e+00 {VDD} 1.4000e-08 {VDD} 1.4100e-08 0 3.7000e-08 0 3.7100e-08 {VDD})
vww_op0_n100_an_s0p1_r30k wwl_op0_n100_an_s0p1_r30k 0 pwl(0.0000e+00 0 1.5000e-08 0 1.5100e-08 {VDD} 3.5000e-08 {VDD} 3.5100e-08 0)
vwc_op0_n100_an_s0p1_r30k wbc_op0_n100_an_s0p1_r30k 0 pwl(0.0000e+00 0 1.5000e-08 0 1.5100e-08 {VDD} 3.7000e-08 {VDD} 3.7100e-08 0)
swb_op0_n100_an_s0p1_r30k ref_op0_n100_an_s0p1_r30k wbl_op0_n100_an_s0p1_r30k wbc_op0_n100_an_s0p1_r30k 0 swwbl
cwbl_op0_n100_an_s0p1_r30k wbl_op0_n100_an_s0p1_r30k 0 {C_WBL}
spa_op0_n100_an_s0p1_r30k prea rbl_op0_n100_an_s0p1_r30k ctl_op0_n100_an_s0p1_r30k 0 swpre
spr_op0_n100_an_s0p1_r30k pref ref_op0_n100_an_s0p1_r30k ctl_op0_n100_an_s0p1_r30k 0 swpre
crbl_op0_n100_an_s0p1_r30k rbl_op0_n100_an_s0p1_r30k 0 {C_RBL}
cref_op0_n100_an_s0p1_r30k ref_op0_n100_an_s0p1_r30k 0 {C_RBL}   $ ASSUMPTION: ideal matched dummy load
XMWR_op0_n100_an_s0p1_r30k_0 sn_op0_n100_an_s0p1_r30k_0 wwl_op0_n100_an_s0p1_r30k wbl_op0_n100_an_s0p1_r30k 0 sky130_fd_pr__nfet_01v8 L=0.15 W=0.42 nf=1 ad=0.1218 as=0.1218 pd=1.42 ps=1.42 nrd=0.69047619047619  nrs=0.69047619047619 sa=0 sb=0 sd=0 mult=1 m=1
XMRD_op0_n100_an_s0p1_r30k_0 rbl_op0_n100_an_s0p1_r30k sn_op0_n100_an_s0p1_r30k_0 rwls_op0_n100_an_s0p1_r30k 0 sky130_fd_pr__nfet_01v8 L=0.15 W=0.42 nf=1 ad=0.1218 as=0.1218 pd=1.42 ps=1.42 nrd=0.69047619047619  nrs=0.69047619047619 sa=0 sb=0 sd=0 mult=1 m=1
csn_op0_n100_an_s0p1_r30k_0 sn_op0_n100_an_s0p1_r30k_0 0 {C_SN}
XMWR_op0_n100_an_s0p1_r30k_1 sn_op0_n100_an_s0p1_r30k_1 wwl_des wbl_op0_n100_an_s0p1_r30k 0 sky130_fd_pr__nfet_01v8 L=0.15 W=0.42 nf=1 ad=0.1218 as=0.1218 pd=1.42 ps=1.42 nrd=0.69047619047619  nrs=0.69047619047619 sa=0 sb=0 sd=0 mult=1 m=1
XMRD_op0_n100_an_s0p1_r30k_1 rbl_op0_n100_an_s0p1_r30k sn_op0_n100_an_s0p1_r30k_1 rwl_des 0 sky130_fd_pr__nfet_01v8 L=0.15 W=0.42 nf=1 ad=0.1218 as=0.1218 pd=1.42 ps=1.42 nrd=0.69047619047619  nrs=0.69047619047619 sa=0 sb=0 sd=0 mult=1 m=1
csn_op0_n100_an_s0p1_r30k_1 sn_op0_n100_an_s0p1_r30k_1 0 {C_SN}
XMWR_op0_n100_an_s0p1_r30k_2 sn_op0_n100_an_s0p1_r30k_2 wwl_des wbl_op0_n100_an_s0p1_r30k 0 sky130_fd_pr__nfet_01v8 L=0.15 W=0.42 nf=1 ad=0.1218 as=0.1218 pd=1.42 ps=1.42 nrd=0.69047619047619  nrs=0.69047619047619 sa=0 sb=0 sd=0 mult=1 m=1
XMRD_op0_n100_an_s0p1_r30k_2 rbl_op0_n100_an_s0p1_r30k sn_op0_n100_an_s0p1_r30k_2 rwl_des 0 sky130_fd_pr__nfet_01v8 L=0.15 W=0.42 nf=1 ad=0.1218 as=0.1218 pd=1.42 ps=1.42 nrd=0.69047619047619  nrs=0.69047619047619 sa=0 sb=0 sd=0 mult=1 m=1
csn_op0_n100_an_s0p1_r30k_2 sn_op0_n100_an_s0p1_r30k_2 0 {C_SN}
XMWR_op0_n100_an_s0p1_r30k_3 sn_op0_n100_an_s0p1_r30k_3 wwl_des wbl_op0_n100_an_s0p1_r30k 0 sky130_fd_pr__nfet_01v8 L=0.15 W=0.42 nf=1 ad=0.1218 as=0.1218 pd=1.42 ps=1.42 nrd=0.69047619047619  nrs=0.69047619047619 sa=0 sb=0 sd=0 mult=1 m=1
XMRD_op0_n100_an_s0p1_r30k_3 rbl_op0_n100_an_s0p1_r30k sn_op0_n100_an_s0p1_r30k_3 rwl_des 0 sky130_fd_pr__nfet_01v8 L=0.15 W=0.42 nf=1 ad=0.1218 as=0.1218 pd=1.42 ps=1.42 nrd=0.69047619047619  nrs=0.69047619047619 sa=0 sb=0 sd=0 mult=1 m=1
csn_op0_n100_an_s0p1_r30k_3 sn_op0_n100_an_s0p1_r30k_3 0 {C_SN}
XMN1_op0_n100_an_s0p1_r30k rbl_op0_n100_an_s0p1_r30k ref_op0_n100_an_s0p1_r30k vn_op0_n100_an_s0p1_r30k 0 sky130_fd_pr__nfet_01v8 L=0.15 W=1 nf=1 ad=0.29 as=0.29 pd=2.58 ps=2.58 mult=1 m=1
XMN2_op0_n100_an_s0p1_r30k ref_op0_n100_an_s0p1_r30k rbl_op0_n100_an_s0p1_r30k vn_op0_n100_an_s0p1_r30k 0 sky130_fd_pr__nfet_01v8 L=0.15 W=1 nf=1 ad=0.29 as=0.29 pd=2.58 ps=2.58 mult=1 m=1
XMP1_op0_n100_an_s0p1_r30k rbl_op0_n100_an_s0p1_r30k ref_op0_n100_an_s0p1_r30k vp_op0_n100_an_s0p1_r30k vdd sky130_fd_pr__pfet_01v8 L=0.15 W=2 nf=1 ad=0.58 as=0.58 pd=4.58 ps=4.58 mult=1 m=1
XMP2_op0_n100_an_s0p1_r30k ref_op0_n100_an_s0p1_r30k rbl_op0_n100_an_s0p1_r30k vp_op0_n100_an_s0p1_r30k vdd sky130_fd_pr__pfet_01v8 L=0.15 W=2 nf=1 ad=0.58 as=0.58 pd=4.58 ps=4.58 mult=1 m=1
XMNF_op0_n100_an_s0p1_r30k vn_op0_n100_an_s0p1_r30k en_op0_n100_an_s0p1_r30k 0 0 sky130_fd_pr__nfet_01v8 L=0.15 W=2 nf=1 ad=0.58 as=0.58 pd=4.58 ps=4.58 mult=1 m=1
XMPH_op0_n100_an_s0p1_r30k vp_op0_n100_an_s0p1_r30k enb_op0_n100_an_s0p1_r30k vdd vdd sky130_fd_pr__pfet_01v8 L=0.15 W=4 nf=1 ad=1.16 as=1.16 pd=8.58 ps=8.58 mult=1 m=1
bd_op0_n100_an_s0p1_r30k d_op0_n100_an_s0p1_r30k 0 v=v(rbl_op0_n100_an_s0p1_r30k)-v(ref_op0_n100_an_s0p1_r30k)

* ---- instance 72: op0_0000_an_s0p1_r30k (variant an_s0p1_r30k; probe dec 14.9 ns, release 37 ns, meas 39 ns) ----
vctl_op0_0000_an_s0p1_r30k ctl_op0_0000_an_s0p1_r30k 0 pwl(0.0000e+00 {VDD} 2.0000e-09 {VDD} 2.1000e-09 0)
* RWL driver model (EXPERIMENTAL): slew 0.1 ns, series R 30000 ohm; cell pin = rwls_op0_0000_an_s0p1_r30k
vrs_op0_0000_an_s0p1_r30k rwlsrc_op0_0000_an_s0p1_r30k 0 pwl(0.0000e+00 {VDD} 4.0000e-09 {VDD} 4.1000e-09 0 3.7000e-08 0 3.7100e-08 {VDD})
rdrv_op0_0000_an_s0p1_r30k rwlsrc_op0_0000_an_s0p1_r30k rwls_op0_0000_an_s0p1_r30k 30000
ven_op0_0000_an_s0p1_r30k en_op0_0000_an_s0p1_r30k 0 pwl(0.0000e+00 0 1.4000e-08 0 1.4100e-08 {VDD} 3.7000e-08 {VDD} 3.7100e-08 0)
venb_op0_0000_an_s0p1_r30k enb_op0_0000_an_s0p1_r30k 0 pwl(0.0000e+00 {VDD} 1.4000e-08 {VDD} 1.4100e-08 0 3.7000e-08 0 3.7100e-08 {VDD})
vww_op0_0000_an_s0p1_r30k wwl_op0_0000_an_s0p1_r30k 0 pwl(0.0000e+00 0 1.5000e-08 0 1.5100e-08 {VDD} 3.5000e-08 {VDD} 3.5100e-08 0)
vwc_op0_0000_an_s0p1_r30k wbc_op0_0000_an_s0p1_r30k 0 pwl(0.0000e+00 0 1.5000e-08 0 1.5100e-08 {VDD} 3.7000e-08 {VDD} 3.7100e-08 0)
swb_op0_0000_an_s0p1_r30k ref_op0_0000_an_s0p1_r30k wbl_op0_0000_an_s0p1_r30k wbc_op0_0000_an_s0p1_r30k 0 swwbl
cwbl_op0_0000_an_s0p1_r30k wbl_op0_0000_an_s0p1_r30k 0 {C_WBL}
spa_op0_0000_an_s0p1_r30k prea rbl_op0_0000_an_s0p1_r30k ctl_op0_0000_an_s0p1_r30k 0 swpre
spr_op0_0000_an_s0p1_r30k pref ref_op0_0000_an_s0p1_r30k ctl_op0_0000_an_s0p1_r30k 0 swpre
crbl_op0_0000_an_s0p1_r30k rbl_op0_0000_an_s0p1_r30k 0 {C_RBL}
cref_op0_0000_an_s0p1_r30k ref_op0_0000_an_s0p1_r30k 0 {C_RBL}   $ ASSUMPTION: ideal matched dummy load
XMWR_op0_0000_an_s0p1_r30k_0 sn_op0_0000_an_s0p1_r30k_0 wwl_op0_0000_an_s0p1_r30k wbl_op0_0000_an_s0p1_r30k 0 sky130_fd_pr__nfet_01v8 L=0.15 W=0.42 nf=1 ad=0.1218 as=0.1218 pd=1.42 ps=1.42 nrd=0.69047619047619  nrs=0.69047619047619 sa=0 sb=0 sd=0 mult=1 m=1
XMRD_op0_0000_an_s0p1_r30k_0 rbl_op0_0000_an_s0p1_r30k sn_op0_0000_an_s0p1_r30k_0 rwls_op0_0000_an_s0p1_r30k 0 sky130_fd_pr__nfet_01v8 L=0.15 W=0.42 nf=1 ad=0.1218 as=0.1218 pd=1.42 ps=1.42 nrd=0.69047619047619  nrs=0.69047619047619 sa=0 sb=0 sd=0 mult=1 m=1
csn_op0_0000_an_s0p1_r30k_0 sn_op0_0000_an_s0p1_r30k_0 0 {C_SN}
XMWR_op0_0000_an_s0p1_r30k_1 sn_op0_0000_an_s0p1_r30k_1 wwl_des wbl_op0_0000_an_s0p1_r30k 0 sky130_fd_pr__nfet_01v8 L=0.15 W=0.42 nf=1 ad=0.1218 as=0.1218 pd=1.42 ps=1.42 nrd=0.69047619047619  nrs=0.69047619047619 sa=0 sb=0 sd=0 mult=1 m=1
XMRD_op0_0000_an_s0p1_r30k_1 rbl_op0_0000_an_s0p1_r30k sn_op0_0000_an_s0p1_r30k_1 rwl_des 0 sky130_fd_pr__nfet_01v8 L=0.15 W=0.42 nf=1 ad=0.1218 as=0.1218 pd=1.42 ps=1.42 nrd=0.69047619047619  nrs=0.69047619047619 sa=0 sb=0 sd=0 mult=1 m=1
csn_op0_0000_an_s0p1_r30k_1 sn_op0_0000_an_s0p1_r30k_1 0 {C_SN}
XMWR_op0_0000_an_s0p1_r30k_2 sn_op0_0000_an_s0p1_r30k_2 wwl_des wbl_op0_0000_an_s0p1_r30k 0 sky130_fd_pr__nfet_01v8 L=0.15 W=0.42 nf=1 ad=0.1218 as=0.1218 pd=1.42 ps=1.42 nrd=0.69047619047619  nrs=0.69047619047619 sa=0 sb=0 sd=0 mult=1 m=1
XMRD_op0_0000_an_s0p1_r30k_2 rbl_op0_0000_an_s0p1_r30k sn_op0_0000_an_s0p1_r30k_2 rwl_des 0 sky130_fd_pr__nfet_01v8 L=0.15 W=0.42 nf=1 ad=0.1218 as=0.1218 pd=1.42 ps=1.42 nrd=0.69047619047619  nrs=0.69047619047619 sa=0 sb=0 sd=0 mult=1 m=1
csn_op0_0000_an_s0p1_r30k_2 sn_op0_0000_an_s0p1_r30k_2 0 {C_SN}
XMWR_op0_0000_an_s0p1_r30k_3 sn_op0_0000_an_s0p1_r30k_3 wwl_des wbl_op0_0000_an_s0p1_r30k 0 sky130_fd_pr__nfet_01v8 L=0.15 W=0.42 nf=1 ad=0.1218 as=0.1218 pd=1.42 ps=1.42 nrd=0.69047619047619  nrs=0.69047619047619 sa=0 sb=0 sd=0 mult=1 m=1
XMRD_op0_0000_an_s0p1_r30k_3 rbl_op0_0000_an_s0p1_r30k sn_op0_0000_an_s0p1_r30k_3 rwl_des 0 sky130_fd_pr__nfet_01v8 L=0.15 W=0.42 nf=1 ad=0.1218 as=0.1218 pd=1.42 ps=1.42 nrd=0.69047619047619  nrs=0.69047619047619 sa=0 sb=0 sd=0 mult=1 m=1
csn_op0_0000_an_s0p1_r30k_3 sn_op0_0000_an_s0p1_r30k_3 0 {C_SN}
XMN1_op0_0000_an_s0p1_r30k rbl_op0_0000_an_s0p1_r30k ref_op0_0000_an_s0p1_r30k vn_op0_0000_an_s0p1_r30k 0 sky130_fd_pr__nfet_01v8 L=0.15 W=1 nf=1 ad=0.29 as=0.29 pd=2.58 ps=2.58 mult=1 m=1
XMN2_op0_0000_an_s0p1_r30k ref_op0_0000_an_s0p1_r30k rbl_op0_0000_an_s0p1_r30k vn_op0_0000_an_s0p1_r30k 0 sky130_fd_pr__nfet_01v8 L=0.15 W=1 nf=1 ad=0.29 as=0.29 pd=2.58 ps=2.58 mult=1 m=1
XMP1_op0_0000_an_s0p1_r30k rbl_op0_0000_an_s0p1_r30k ref_op0_0000_an_s0p1_r30k vp_op0_0000_an_s0p1_r30k vdd sky130_fd_pr__pfet_01v8 L=0.15 W=2 nf=1 ad=0.58 as=0.58 pd=4.58 ps=4.58 mult=1 m=1
XMP2_op0_0000_an_s0p1_r30k ref_op0_0000_an_s0p1_r30k rbl_op0_0000_an_s0p1_r30k vp_op0_0000_an_s0p1_r30k vdd sky130_fd_pr__pfet_01v8 L=0.15 W=2 nf=1 ad=0.58 as=0.58 pd=4.58 ps=4.58 mult=1 m=1
XMNF_op0_0000_an_s0p1_r30k vn_op0_0000_an_s0p1_r30k en_op0_0000_an_s0p1_r30k 0 0 sky130_fd_pr__nfet_01v8 L=0.15 W=2 nf=1 ad=0.58 as=0.58 pd=4.58 ps=4.58 mult=1 m=1
XMPH_op0_0000_an_s0p1_r30k vp_op0_0000_an_s0p1_r30k enb_op0_0000_an_s0p1_r30k vdd vdd sky130_fd_pr__pfet_01v8 L=0.15 W=4 nf=1 ad=1.16 as=1.16 pd=8.58 ps=8.58 mult=1 m=1
bd_op0_0000_an_s0p1_r30k d_op0_0000_an_s0p1_r30k 0 v=v(rbl_op0_0000_an_s0p1_r30k)-v(ref_op0_0000_an_s0p1_r30k)

* ---- instance 73: op1_0900_an_s0p1_r100k (variant an_s0p1_r100k; probe dec 14.9 ns, release 37 ns, meas 39 ns) ----
vctl_op1_0900_an_s0p1_r100k ctl_op1_0900_an_s0p1_r100k 0 pwl(0.0000e+00 {VDD} 2.0000e-09 {VDD} 2.1000e-09 0)
* RWL driver model (EXPERIMENTAL): slew 0.1 ns, series R 100000 ohm; cell pin = rwls_op1_0900_an_s0p1_r100k
vrs_op1_0900_an_s0p1_r100k rwlsrc_op1_0900_an_s0p1_r100k 0 pwl(0.0000e+00 {VDD} 4.0000e-09 {VDD} 4.1000e-09 0 3.7000e-08 0 3.7100e-08 {VDD})
rdrv_op1_0900_an_s0p1_r100k rwlsrc_op1_0900_an_s0p1_r100k rwls_op1_0900_an_s0p1_r100k 100000
ven_op1_0900_an_s0p1_r100k en_op1_0900_an_s0p1_r100k 0 pwl(0.0000e+00 0 1.4000e-08 0 1.4100e-08 {VDD} 3.7000e-08 {VDD} 3.7100e-08 0)
venb_op1_0900_an_s0p1_r100k enb_op1_0900_an_s0p1_r100k 0 pwl(0.0000e+00 {VDD} 1.4000e-08 {VDD} 1.4100e-08 0 3.7000e-08 0 3.7100e-08 {VDD})
vww_op1_0900_an_s0p1_r100k wwl_op1_0900_an_s0p1_r100k 0 pwl(0.0000e+00 0 1.5000e-08 0 1.5100e-08 {VDD} 3.5000e-08 {VDD} 3.5100e-08 0)
vwc_op1_0900_an_s0p1_r100k wbc_op1_0900_an_s0p1_r100k 0 pwl(0.0000e+00 0 1.5000e-08 0 1.5100e-08 {VDD} 3.7000e-08 {VDD} 3.7100e-08 0)
swb_op1_0900_an_s0p1_r100k ref_op1_0900_an_s0p1_r100k wbl_op1_0900_an_s0p1_r100k wbc_op1_0900_an_s0p1_r100k 0 swwbl
cwbl_op1_0900_an_s0p1_r100k wbl_op1_0900_an_s0p1_r100k 0 {C_WBL}
spa_op1_0900_an_s0p1_r100k prea rbl_op1_0900_an_s0p1_r100k ctl_op1_0900_an_s0p1_r100k 0 swpre
spr_op1_0900_an_s0p1_r100k pref ref_op1_0900_an_s0p1_r100k ctl_op1_0900_an_s0p1_r100k 0 swpre
crbl_op1_0900_an_s0p1_r100k rbl_op1_0900_an_s0p1_r100k 0 {C_RBL}
cref_op1_0900_an_s0p1_r100k ref_op1_0900_an_s0p1_r100k 0 {C_RBL}   $ ASSUMPTION: ideal matched dummy load
XMWR_op1_0900_an_s0p1_r100k_0 sn_op1_0900_an_s0p1_r100k_0 wwl_op1_0900_an_s0p1_r100k wbl_op1_0900_an_s0p1_r100k 0 sky130_fd_pr__nfet_01v8 L=0.15 W=0.42 nf=1 ad=0.1218 as=0.1218 pd=1.42 ps=1.42 nrd=0.69047619047619  nrs=0.69047619047619 sa=0 sb=0 sd=0 mult=1 m=1
XMRD_op1_0900_an_s0p1_r100k_0 rbl_op1_0900_an_s0p1_r100k sn_op1_0900_an_s0p1_r100k_0 rwls_op1_0900_an_s0p1_r100k 0 sky130_fd_pr__nfet_01v8 L=0.15 W=0.42 nf=1 ad=0.1218 as=0.1218 pd=1.42 ps=1.42 nrd=0.69047619047619  nrs=0.69047619047619 sa=0 sb=0 sd=0 mult=1 m=1
csn_op1_0900_an_s0p1_r100k_0 sn_op1_0900_an_s0p1_r100k_0 0 {C_SN}
XMWR_op1_0900_an_s0p1_r100k_1 sn_op1_0900_an_s0p1_r100k_1 wwl_des wbl_op1_0900_an_s0p1_r100k 0 sky130_fd_pr__nfet_01v8 L=0.15 W=0.42 nf=1 ad=0.1218 as=0.1218 pd=1.42 ps=1.42 nrd=0.69047619047619  nrs=0.69047619047619 sa=0 sb=0 sd=0 mult=1 m=1
XMRD_op1_0900_an_s0p1_r100k_1 rbl_op1_0900_an_s0p1_r100k sn_op1_0900_an_s0p1_r100k_1 rwl_des 0 sky130_fd_pr__nfet_01v8 L=0.15 W=0.42 nf=1 ad=0.1218 as=0.1218 pd=1.42 ps=1.42 nrd=0.69047619047619  nrs=0.69047619047619 sa=0 sb=0 sd=0 mult=1 m=1
csn_op1_0900_an_s0p1_r100k_1 sn_op1_0900_an_s0p1_r100k_1 0 {C_SN}
XMWR_op1_0900_an_s0p1_r100k_2 sn_op1_0900_an_s0p1_r100k_2 wwl_des wbl_op1_0900_an_s0p1_r100k 0 sky130_fd_pr__nfet_01v8 L=0.15 W=0.42 nf=1 ad=0.1218 as=0.1218 pd=1.42 ps=1.42 nrd=0.69047619047619  nrs=0.69047619047619 sa=0 sb=0 sd=0 mult=1 m=1
XMRD_op1_0900_an_s0p1_r100k_2 rbl_op1_0900_an_s0p1_r100k sn_op1_0900_an_s0p1_r100k_2 rwl_des 0 sky130_fd_pr__nfet_01v8 L=0.15 W=0.42 nf=1 ad=0.1218 as=0.1218 pd=1.42 ps=1.42 nrd=0.69047619047619  nrs=0.69047619047619 sa=0 sb=0 sd=0 mult=1 m=1
csn_op1_0900_an_s0p1_r100k_2 sn_op1_0900_an_s0p1_r100k_2 0 {C_SN}
XMWR_op1_0900_an_s0p1_r100k_3 sn_op1_0900_an_s0p1_r100k_3 wwl_des wbl_op1_0900_an_s0p1_r100k 0 sky130_fd_pr__nfet_01v8 L=0.15 W=0.42 nf=1 ad=0.1218 as=0.1218 pd=1.42 ps=1.42 nrd=0.69047619047619  nrs=0.69047619047619 sa=0 sb=0 sd=0 mult=1 m=1
XMRD_op1_0900_an_s0p1_r100k_3 rbl_op1_0900_an_s0p1_r100k sn_op1_0900_an_s0p1_r100k_3 rwl_des 0 sky130_fd_pr__nfet_01v8 L=0.15 W=0.42 nf=1 ad=0.1218 as=0.1218 pd=1.42 ps=1.42 nrd=0.69047619047619  nrs=0.69047619047619 sa=0 sb=0 sd=0 mult=1 m=1
csn_op1_0900_an_s0p1_r100k_3 sn_op1_0900_an_s0p1_r100k_3 0 {C_SN}
XMN1_op1_0900_an_s0p1_r100k rbl_op1_0900_an_s0p1_r100k ref_op1_0900_an_s0p1_r100k vn_op1_0900_an_s0p1_r100k 0 sky130_fd_pr__nfet_01v8 L=0.15 W=1 nf=1 ad=0.29 as=0.29 pd=2.58 ps=2.58 mult=1 m=1
XMN2_op1_0900_an_s0p1_r100k ref_op1_0900_an_s0p1_r100k rbl_op1_0900_an_s0p1_r100k vn_op1_0900_an_s0p1_r100k 0 sky130_fd_pr__nfet_01v8 L=0.15 W=1 nf=1 ad=0.29 as=0.29 pd=2.58 ps=2.58 mult=1 m=1
XMP1_op1_0900_an_s0p1_r100k rbl_op1_0900_an_s0p1_r100k ref_op1_0900_an_s0p1_r100k vp_op1_0900_an_s0p1_r100k vdd sky130_fd_pr__pfet_01v8 L=0.15 W=2 nf=1 ad=0.58 as=0.58 pd=4.58 ps=4.58 mult=1 m=1
XMP2_op1_0900_an_s0p1_r100k ref_op1_0900_an_s0p1_r100k rbl_op1_0900_an_s0p1_r100k vp_op1_0900_an_s0p1_r100k vdd sky130_fd_pr__pfet_01v8 L=0.15 W=2 nf=1 ad=0.58 as=0.58 pd=4.58 ps=4.58 mult=1 m=1
XMNF_op1_0900_an_s0p1_r100k vn_op1_0900_an_s0p1_r100k en_op1_0900_an_s0p1_r100k 0 0 sky130_fd_pr__nfet_01v8 L=0.15 W=2 nf=1 ad=0.58 as=0.58 pd=4.58 ps=4.58 mult=1 m=1
XMPH_op1_0900_an_s0p1_r100k vp_op1_0900_an_s0p1_r100k enb_op1_0900_an_s0p1_r100k vdd vdd sky130_fd_pr__pfet_01v8 L=0.15 W=4 nf=1 ad=1.16 as=1.16 pd=8.58 ps=8.58 mult=1 m=1
bd_op1_0900_an_s0p1_r100k d_op1_0900_an_s0p1_r100k 0 v=v(rbl_op1_0900_an_s0p1_r100k)-v(ref_op1_0900_an_s0p1_r100k)

* ---- instance 74: op1_1000_an_s0p1_r100k (variant an_s0p1_r100k; probe dec 14.9 ns, release 37 ns, meas 39 ns) ----
vctl_op1_1000_an_s0p1_r100k ctl_op1_1000_an_s0p1_r100k 0 pwl(0.0000e+00 {VDD} 2.0000e-09 {VDD} 2.1000e-09 0)
* RWL driver model (EXPERIMENTAL): slew 0.1 ns, series R 100000 ohm; cell pin = rwls_op1_1000_an_s0p1_r100k
vrs_op1_1000_an_s0p1_r100k rwlsrc_op1_1000_an_s0p1_r100k 0 pwl(0.0000e+00 {VDD} 4.0000e-09 {VDD} 4.1000e-09 0 3.7000e-08 0 3.7100e-08 {VDD})
rdrv_op1_1000_an_s0p1_r100k rwlsrc_op1_1000_an_s0p1_r100k rwls_op1_1000_an_s0p1_r100k 100000
ven_op1_1000_an_s0p1_r100k en_op1_1000_an_s0p1_r100k 0 pwl(0.0000e+00 0 1.4000e-08 0 1.4100e-08 {VDD} 3.7000e-08 {VDD} 3.7100e-08 0)
venb_op1_1000_an_s0p1_r100k enb_op1_1000_an_s0p1_r100k 0 pwl(0.0000e+00 {VDD} 1.4000e-08 {VDD} 1.4100e-08 0 3.7000e-08 0 3.7100e-08 {VDD})
vww_op1_1000_an_s0p1_r100k wwl_op1_1000_an_s0p1_r100k 0 pwl(0.0000e+00 0 1.5000e-08 0 1.5100e-08 {VDD} 3.5000e-08 {VDD} 3.5100e-08 0)
vwc_op1_1000_an_s0p1_r100k wbc_op1_1000_an_s0p1_r100k 0 pwl(0.0000e+00 0 1.5000e-08 0 1.5100e-08 {VDD} 3.7000e-08 {VDD} 3.7100e-08 0)
swb_op1_1000_an_s0p1_r100k ref_op1_1000_an_s0p1_r100k wbl_op1_1000_an_s0p1_r100k wbc_op1_1000_an_s0p1_r100k 0 swwbl
cwbl_op1_1000_an_s0p1_r100k wbl_op1_1000_an_s0p1_r100k 0 {C_WBL}
spa_op1_1000_an_s0p1_r100k prea rbl_op1_1000_an_s0p1_r100k ctl_op1_1000_an_s0p1_r100k 0 swpre
spr_op1_1000_an_s0p1_r100k pref ref_op1_1000_an_s0p1_r100k ctl_op1_1000_an_s0p1_r100k 0 swpre
crbl_op1_1000_an_s0p1_r100k rbl_op1_1000_an_s0p1_r100k 0 {C_RBL}
cref_op1_1000_an_s0p1_r100k ref_op1_1000_an_s0p1_r100k 0 {C_RBL}   $ ASSUMPTION: ideal matched dummy load
XMWR_op1_1000_an_s0p1_r100k_0 sn_op1_1000_an_s0p1_r100k_0 wwl_op1_1000_an_s0p1_r100k wbl_op1_1000_an_s0p1_r100k 0 sky130_fd_pr__nfet_01v8 L=0.15 W=0.42 nf=1 ad=0.1218 as=0.1218 pd=1.42 ps=1.42 nrd=0.69047619047619  nrs=0.69047619047619 sa=0 sb=0 sd=0 mult=1 m=1
XMRD_op1_1000_an_s0p1_r100k_0 rbl_op1_1000_an_s0p1_r100k sn_op1_1000_an_s0p1_r100k_0 rwls_op1_1000_an_s0p1_r100k 0 sky130_fd_pr__nfet_01v8 L=0.15 W=0.42 nf=1 ad=0.1218 as=0.1218 pd=1.42 ps=1.42 nrd=0.69047619047619  nrs=0.69047619047619 sa=0 sb=0 sd=0 mult=1 m=1
csn_op1_1000_an_s0p1_r100k_0 sn_op1_1000_an_s0p1_r100k_0 0 {C_SN}
XMWR_op1_1000_an_s0p1_r100k_1 sn_op1_1000_an_s0p1_r100k_1 wwl_des wbl_op1_1000_an_s0p1_r100k 0 sky130_fd_pr__nfet_01v8 L=0.15 W=0.42 nf=1 ad=0.1218 as=0.1218 pd=1.42 ps=1.42 nrd=0.69047619047619  nrs=0.69047619047619 sa=0 sb=0 sd=0 mult=1 m=1
XMRD_op1_1000_an_s0p1_r100k_1 rbl_op1_1000_an_s0p1_r100k sn_op1_1000_an_s0p1_r100k_1 rwl_des 0 sky130_fd_pr__nfet_01v8 L=0.15 W=0.42 nf=1 ad=0.1218 as=0.1218 pd=1.42 ps=1.42 nrd=0.69047619047619  nrs=0.69047619047619 sa=0 sb=0 sd=0 mult=1 m=1
csn_op1_1000_an_s0p1_r100k_1 sn_op1_1000_an_s0p1_r100k_1 0 {C_SN}
XMWR_op1_1000_an_s0p1_r100k_2 sn_op1_1000_an_s0p1_r100k_2 wwl_des wbl_op1_1000_an_s0p1_r100k 0 sky130_fd_pr__nfet_01v8 L=0.15 W=0.42 nf=1 ad=0.1218 as=0.1218 pd=1.42 ps=1.42 nrd=0.69047619047619  nrs=0.69047619047619 sa=0 sb=0 sd=0 mult=1 m=1
XMRD_op1_1000_an_s0p1_r100k_2 rbl_op1_1000_an_s0p1_r100k sn_op1_1000_an_s0p1_r100k_2 rwl_des 0 sky130_fd_pr__nfet_01v8 L=0.15 W=0.42 nf=1 ad=0.1218 as=0.1218 pd=1.42 ps=1.42 nrd=0.69047619047619  nrs=0.69047619047619 sa=0 sb=0 sd=0 mult=1 m=1
csn_op1_1000_an_s0p1_r100k_2 sn_op1_1000_an_s0p1_r100k_2 0 {C_SN}
XMWR_op1_1000_an_s0p1_r100k_3 sn_op1_1000_an_s0p1_r100k_3 wwl_des wbl_op1_1000_an_s0p1_r100k 0 sky130_fd_pr__nfet_01v8 L=0.15 W=0.42 nf=1 ad=0.1218 as=0.1218 pd=1.42 ps=1.42 nrd=0.69047619047619  nrs=0.69047619047619 sa=0 sb=0 sd=0 mult=1 m=1
XMRD_op1_1000_an_s0p1_r100k_3 rbl_op1_1000_an_s0p1_r100k sn_op1_1000_an_s0p1_r100k_3 rwl_des 0 sky130_fd_pr__nfet_01v8 L=0.15 W=0.42 nf=1 ad=0.1218 as=0.1218 pd=1.42 ps=1.42 nrd=0.69047619047619  nrs=0.69047619047619 sa=0 sb=0 sd=0 mult=1 m=1
csn_op1_1000_an_s0p1_r100k_3 sn_op1_1000_an_s0p1_r100k_3 0 {C_SN}
XMN1_op1_1000_an_s0p1_r100k rbl_op1_1000_an_s0p1_r100k ref_op1_1000_an_s0p1_r100k vn_op1_1000_an_s0p1_r100k 0 sky130_fd_pr__nfet_01v8 L=0.15 W=1 nf=1 ad=0.29 as=0.29 pd=2.58 ps=2.58 mult=1 m=1
XMN2_op1_1000_an_s0p1_r100k ref_op1_1000_an_s0p1_r100k rbl_op1_1000_an_s0p1_r100k vn_op1_1000_an_s0p1_r100k 0 sky130_fd_pr__nfet_01v8 L=0.15 W=1 nf=1 ad=0.29 as=0.29 pd=2.58 ps=2.58 mult=1 m=1
XMP1_op1_1000_an_s0p1_r100k rbl_op1_1000_an_s0p1_r100k ref_op1_1000_an_s0p1_r100k vp_op1_1000_an_s0p1_r100k vdd sky130_fd_pr__pfet_01v8 L=0.15 W=2 nf=1 ad=0.58 as=0.58 pd=4.58 ps=4.58 mult=1 m=1
XMP2_op1_1000_an_s0p1_r100k ref_op1_1000_an_s0p1_r100k rbl_op1_1000_an_s0p1_r100k vp_op1_1000_an_s0p1_r100k vdd sky130_fd_pr__pfet_01v8 L=0.15 W=2 nf=1 ad=0.58 as=0.58 pd=4.58 ps=4.58 mult=1 m=1
XMNF_op1_1000_an_s0p1_r100k vn_op1_1000_an_s0p1_r100k en_op1_1000_an_s0p1_r100k 0 0 sky130_fd_pr__nfet_01v8 L=0.15 W=2 nf=1 ad=0.58 as=0.58 pd=4.58 ps=4.58 mult=1 m=1
XMPH_op1_1000_an_s0p1_r100k vp_op1_1000_an_s0p1_r100k enb_op1_1000_an_s0p1_r100k vdd vdd sky130_fd_pr__pfet_01v8 L=0.15 W=4 nf=1 ad=1.16 as=1.16 pd=8.58 ps=8.58 mult=1 m=1
bd_op1_1000_an_s0p1_r100k d_op1_1000_an_s0p1_r100k 0 v=v(rbl_op1_1000_an_s0p1_r100k)-v(ref_op1_1000_an_s0p1_r100k)

* ---- instance 75: op0_n100_an_s0p1_r100k (variant an_s0p1_r100k; probe dec 14.9 ns, release 37 ns, meas 39 ns) ----
vctl_op0_n100_an_s0p1_r100k ctl_op0_n100_an_s0p1_r100k 0 pwl(0.0000e+00 {VDD} 2.0000e-09 {VDD} 2.1000e-09 0)
* RWL driver model (EXPERIMENTAL): slew 0.1 ns, series R 100000 ohm; cell pin = rwls_op0_n100_an_s0p1_r100k
vrs_op0_n100_an_s0p1_r100k rwlsrc_op0_n100_an_s0p1_r100k 0 pwl(0.0000e+00 {VDD} 4.0000e-09 {VDD} 4.1000e-09 0 3.7000e-08 0 3.7100e-08 {VDD})
rdrv_op0_n100_an_s0p1_r100k rwlsrc_op0_n100_an_s0p1_r100k rwls_op0_n100_an_s0p1_r100k 100000
ven_op0_n100_an_s0p1_r100k en_op0_n100_an_s0p1_r100k 0 pwl(0.0000e+00 0 1.4000e-08 0 1.4100e-08 {VDD} 3.7000e-08 {VDD} 3.7100e-08 0)
venb_op0_n100_an_s0p1_r100k enb_op0_n100_an_s0p1_r100k 0 pwl(0.0000e+00 {VDD} 1.4000e-08 {VDD} 1.4100e-08 0 3.7000e-08 0 3.7100e-08 {VDD})
vww_op0_n100_an_s0p1_r100k wwl_op0_n100_an_s0p1_r100k 0 pwl(0.0000e+00 0 1.5000e-08 0 1.5100e-08 {VDD} 3.5000e-08 {VDD} 3.5100e-08 0)
vwc_op0_n100_an_s0p1_r100k wbc_op0_n100_an_s0p1_r100k 0 pwl(0.0000e+00 0 1.5000e-08 0 1.5100e-08 {VDD} 3.7000e-08 {VDD} 3.7100e-08 0)
swb_op0_n100_an_s0p1_r100k ref_op0_n100_an_s0p1_r100k wbl_op0_n100_an_s0p1_r100k wbc_op0_n100_an_s0p1_r100k 0 swwbl
cwbl_op0_n100_an_s0p1_r100k wbl_op0_n100_an_s0p1_r100k 0 {C_WBL}
spa_op0_n100_an_s0p1_r100k prea rbl_op0_n100_an_s0p1_r100k ctl_op0_n100_an_s0p1_r100k 0 swpre
spr_op0_n100_an_s0p1_r100k pref ref_op0_n100_an_s0p1_r100k ctl_op0_n100_an_s0p1_r100k 0 swpre
crbl_op0_n100_an_s0p1_r100k rbl_op0_n100_an_s0p1_r100k 0 {C_RBL}
cref_op0_n100_an_s0p1_r100k ref_op0_n100_an_s0p1_r100k 0 {C_RBL}   $ ASSUMPTION: ideal matched dummy load
XMWR_op0_n100_an_s0p1_r100k_0 sn_op0_n100_an_s0p1_r100k_0 wwl_op0_n100_an_s0p1_r100k wbl_op0_n100_an_s0p1_r100k 0 sky130_fd_pr__nfet_01v8 L=0.15 W=0.42 nf=1 ad=0.1218 as=0.1218 pd=1.42 ps=1.42 nrd=0.69047619047619  nrs=0.69047619047619 sa=0 sb=0 sd=0 mult=1 m=1
XMRD_op0_n100_an_s0p1_r100k_0 rbl_op0_n100_an_s0p1_r100k sn_op0_n100_an_s0p1_r100k_0 rwls_op0_n100_an_s0p1_r100k 0 sky130_fd_pr__nfet_01v8 L=0.15 W=0.42 nf=1 ad=0.1218 as=0.1218 pd=1.42 ps=1.42 nrd=0.69047619047619  nrs=0.69047619047619 sa=0 sb=0 sd=0 mult=1 m=1
csn_op0_n100_an_s0p1_r100k_0 sn_op0_n100_an_s0p1_r100k_0 0 {C_SN}
XMWR_op0_n100_an_s0p1_r100k_1 sn_op0_n100_an_s0p1_r100k_1 wwl_des wbl_op0_n100_an_s0p1_r100k 0 sky130_fd_pr__nfet_01v8 L=0.15 W=0.42 nf=1 ad=0.1218 as=0.1218 pd=1.42 ps=1.42 nrd=0.69047619047619  nrs=0.69047619047619 sa=0 sb=0 sd=0 mult=1 m=1
XMRD_op0_n100_an_s0p1_r100k_1 rbl_op0_n100_an_s0p1_r100k sn_op0_n100_an_s0p1_r100k_1 rwl_des 0 sky130_fd_pr__nfet_01v8 L=0.15 W=0.42 nf=1 ad=0.1218 as=0.1218 pd=1.42 ps=1.42 nrd=0.69047619047619  nrs=0.69047619047619 sa=0 sb=0 sd=0 mult=1 m=1
csn_op0_n100_an_s0p1_r100k_1 sn_op0_n100_an_s0p1_r100k_1 0 {C_SN}
XMWR_op0_n100_an_s0p1_r100k_2 sn_op0_n100_an_s0p1_r100k_2 wwl_des wbl_op0_n100_an_s0p1_r100k 0 sky130_fd_pr__nfet_01v8 L=0.15 W=0.42 nf=1 ad=0.1218 as=0.1218 pd=1.42 ps=1.42 nrd=0.69047619047619  nrs=0.69047619047619 sa=0 sb=0 sd=0 mult=1 m=1
XMRD_op0_n100_an_s0p1_r100k_2 rbl_op0_n100_an_s0p1_r100k sn_op0_n100_an_s0p1_r100k_2 rwl_des 0 sky130_fd_pr__nfet_01v8 L=0.15 W=0.42 nf=1 ad=0.1218 as=0.1218 pd=1.42 ps=1.42 nrd=0.69047619047619  nrs=0.69047619047619 sa=0 sb=0 sd=0 mult=1 m=1
csn_op0_n100_an_s0p1_r100k_2 sn_op0_n100_an_s0p1_r100k_2 0 {C_SN}
XMWR_op0_n100_an_s0p1_r100k_3 sn_op0_n100_an_s0p1_r100k_3 wwl_des wbl_op0_n100_an_s0p1_r100k 0 sky130_fd_pr__nfet_01v8 L=0.15 W=0.42 nf=1 ad=0.1218 as=0.1218 pd=1.42 ps=1.42 nrd=0.69047619047619  nrs=0.69047619047619 sa=0 sb=0 sd=0 mult=1 m=1
XMRD_op0_n100_an_s0p1_r100k_3 rbl_op0_n100_an_s0p1_r100k sn_op0_n100_an_s0p1_r100k_3 rwl_des 0 sky130_fd_pr__nfet_01v8 L=0.15 W=0.42 nf=1 ad=0.1218 as=0.1218 pd=1.42 ps=1.42 nrd=0.69047619047619  nrs=0.69047619047619 sa=0 sb=0 sd=0 mult=1 m=1
csn_op0_n100_an_s0p1_r100k_3 sn_op0_n100_an_s0p1_r100k_3 0 {C_SN}
XMN1_op0_n100_an_s0p1_r100k rbl_op0_n100_an_s0p1_r100k ref_op0_n100_an_s0p1_r100k vn_op0_n100_an_s0p1_r100k 0 sky130_fd_pr__nfet_01v8 L=0.15 W=1 nf=1 ad=0.29 as=0.29 pd=2.58 ps=2.58 mult=1 m=1
XMN2_op0_n100_an_s0p1_r100k ref_op0_n100_an_s0p1_r100k rbl_op0_n100_an_s0p1_r100k vn_op0_n100_an_s0p1_r100k 0 sky130_fd_pr__nfet_01v8 L=0.15 W=1 nf=1 ad=0.29 as=0.29 pd=2.58 ps=2.58 mult=1 m=1
XMP1_op0_n100_an_s0p1_r100k rbl_op0_n100_an_s0p1_r100k ref_op0_n100_an_s0p1_r100k vp_op0_n100_an_s0p1_r100k vdd sky130_fd_pr__pfet_01v8 L=0.15 W=2 nf=1 ad=0.58 as=0.58 pd=4.58 ps=4.58 mult=1 m=1
XMP2_op0_n100_an_s0p1_r100k ref_op0_n100_an_s0p1_r100k rbl_op0_n100_an_s0p1_r100k vp_op0_n100_an_s0p1_r100k vdd sky130_fd_pr__pfet_01v8 L=0.15 W=2 nf=1 ad=0.58 as=0.58 pd=4.58 ps=4.58 mult=1 m=1
XMNF_op0_n100_an_s0p1_r100k vn_op0_n100_an_s0p1_r100k en_op0_n100_an_s0p1_r100k 0 0 sky130_fd_pr__nfet_01v8 L=0.15 W=2 nf=1 ad=0.58 as=0.58 pd=4.58 ps=4.58 mult=1 m=1
XMPH_op0_n100_an_s0p1_r100k vp_op0_n100_an_s0p1_r100k enb_op0_n100_an_s0p1_r100k vdd vdd sky130_fd_pr__pfet_01v8 L=0.15 W=4 nf=1 ad=1.16 as=1.16 pd=8.58 ps=8.58 mult=1 m=1
bd_op0_n100_an_s0p1_r100k d_op0_n100_an_s0p1_r100k 0 v=v(rbl_op0_n100_an_s0p1_r100k)-v(ref_op0_n100_an_s0p1_r100k)

* ---- instance 76: op0_0000_an_s0p1_r100k (variant an_s0p1_r100k; probe dec 14.9 ns, release 37 ns, meas 39 ns) ----
vctl_op0_0000_an_s0p1_r100k ctl_op0_0000_an_s0p1_r100k 0 pwl(0.0000e+00 {VDD} 2.0000e-09 {VDD} 2.1000e-09 0)
* RWL driver model (EXPERIMENTAL): slew 0.1 ns, series R 100000 ohm; cell pin = rwls_op0_0000_an_s0p1_r100k
vrs_op0_0000_an_s0p1_r100k rwlsrc_op0_0000_an_s0p1_r100k 0 pwl(0.0000e+00 {VDD} 4.0000e-09 {VDD} 4.1000e-09 0 3.7000e-08 0 3.7100e-08 {VDD})
rdrv_op0_0000_an_s0p1_r100k rwlsrc_op0_0000_an_s0p1_r100k rwls_op0_0000_an_s0p1_r100k 100000
ven_op0_0000_an_s0p1_r100k en_op0_0000_an_s0p1_r100k 0 pwl(0.0000e+00 0 1.4000e-08 0 1.4100e-08 {VDD} 3.7000e-08 {VDD} 3.7100e-08 0)
venb_op0_0000_an_s0p1_r100k enb_op0_0000_an_s0p1_r100k 0 pwl(0.0000e+00 {VDD} 1.4000e-08 {VDD} 1.4100e-08 0 3.7000e-08 0 3.7100e-08 {VDD})
vww_op0_0000_an_s0p1_r100k wwl_op0_0000_an_s0p1_r100k 0 pwl(0.0000e+00 0 1.5000e-08 0 1.5100e-08 {VDD} 3.5000e-08 {VDD} 3.5100e-08 0)
vwc_op0_0000_an_s0p1_r100k wbc_op0_0000_an_s0p1_r100k 0 pwl(0.0000e+00 0 1.5000e-08 0 1.5100e-08 {VDD} 3.7000e-08 {VDD} 3.7100e-08 0)
swb_op0_0000_an_s0p1_r100k ref_op0_0000_an_s0p1_r100k wbl_op0_0000_an_s0p1_r100k wbc_op0_0000_an_s0p1_r100k 0 swwbl
cwbl_op0_0000_an_s0p1_r100k wbl_op0_0000_an_s0p1_r100k 0 {C_WBL}
spa_op0_0000_an_s0p1_r100k prea rbl_op0_0000_an_s0p1_r100k ctl_op0_0000_an_s0p1_r100k 0 swpre
spr_op0_0000_an_s0p1_r100k pref ref_op0_0000_an_s0p1_r100k ctl_op0_0000_an_s0p1_r100k 0 swpre
crbl_op0_0000_an_s0p1_r100k rbl_op0_0000_an_s0p1_r100k 0 {C_RBL}
cref_op0_0000_an_s0p1_r100k ref_op0_0000_an_s0p1_r100k 0 {C_RBL}   $ ASSUMPTION: ideal matched dummy load
XMWR_op0_0000_an_s0p1_r100k_0 sn_op0_0000_an_s0p1_r100k_0 wwl_op0_0000_an_s0p1_r100k wbl_op0_0000_an_s0p1_r100k 0 sky130_fd_pr__nfet_01v8 L=0.15 W=0.42 nf=1 ad=0.1218 as=0.1218 pd=1.42 ps=1.42 nrd=0.69047619047619  nrs=0.69047619047619 sa=0 sb=0 sd=0 mult=1 m=1
XMRD_op0_0000_an_s0p1_r100k_0 rbl_op0_0000_an_s0p1_r100k sn_op0_0000_an_s0p1_r100k_0 rwls_op0_0000_an_s0p1_r100k 0 sky130_fd_pr__nfet_01v8 L=0.15 W=0.42 nf=1 ad=0.1218 as=0.1218 pd=1.42 ps=1.42 nrd=0.69047619047619  nrs=0.69047619047619 sa=0 sb=0 sd=0 mult=1 m=1
csn_op0_0000_an_s0p1_r100k_0 sn_op0_0000_an_s0p1_r100k_0 0 {C_SN}
XMWR_op0_0000_an_s0p1_r100k_1 sn_op0_0000_an_s0p1_r100k_1 wwl_des wbl_op0_0000_an_s0p1_r100k 0 sky130_fd_pr__nfet_01v8 L=0.15 W=0.42 nf=1 ad=0.1218 as=0.1218 pd=1.42 ps=1.42 nrd=0.69047619047619  nrs=0.69047619047619 sa=0 sb=0 sd=0 mult=1 m=1
XMRD_op0_0000_an_s0p1_r100k_1 rbl_op0_0000_an_s0p1_r100k sn_op0_0000_an_s0p1_r100k_1 rwl_des 0 sky130_fd_pr__nfet_01v8 L=0.15 W=0.42 nf=1 ad=0.1218 as=0.1218 pd=1.42 ps=1.42 nrd=0.69047619047619  nrs=0.69047619047619 sa=0 sb=0 sd=0 mult=1 m=1
csn_op0_0000_an_s0p1_r100k_1 sn_op0_0000_an_s0p1_r100k_1 0 {C_SN}
XMWR_op0_0000_an_s0p1_r100k_2 sn_op0_0000_an_s0p1_r100k_2 wwl_des wbl_op0_0000_an_s0p1_r100k 0 sky130_fd_pr__nfet_01v8 L=0.15 W=0.42 nf=1 ad=0.1218 as=0.1218 pd=1.42 ps=1.42 nrd=0.69047619047619  nrs=0.69047619047619 sa=0 sb=0 sd=0 mult=1 m=1
XMRD_op0_0000_an_s0p1_r100k_2 rbl_op0_0000_an_s0p1_r100k sn_op0_0000_an_s0p1_r100k_2 rwl_des 0 sky130_fd_pr__nfet_01v8 L=0.15 W=0.42 nf=1 ad=0.1218 as=0.1218 pd=1.42 ps=1.42 nrd=0.69047619047619  nrs=0.69047619047619 sa=0 sb=0 sd=0 mult=1 m=1
csn_op0_0000_an_s0p1_r100k_2 sn_op0_0000_an_s0p1_r100k_2 0 {C_SN}
XMWR_op0_0000_an_s0p1_r100k_3 sn_op0_0000_an_s0p1_r100k_3 wwl_des wbl_op0_0000_an_s0p1_r100k 0 sky130_fd_pr__nfet_01v8 L=0.15 W=0.42 nf=1 ad=0.1218 as=0.1218 pd=1.42 ps=1.42 nrd=0.69047619047619  nrs=0.69047619047619 sa=0 sb=0 sd=0 mult=1 m=1
XMRD_op0_0000_an_s0p1_r100k_3 rbl_op0_0000_an_s0p1_r100k sn_op0_0000_an_s0p1_r100k_3 rwl_des 0 sky130_fd_pr__nfet_01v8 L=0.15 W=0.42 nf=1 ad=0.1218 as=0.1218 pd=1.42 ps=1.42 nrd=0.69047619047619  nrs=0.69047619047619 sa=0 sb=0 sd=0 mult=1 m=1
csn_op0_0000_an_s0p1_r100k_3 sn_op0_0000_an_s0p1_r100k_3 0 {C_SN}
XMN1_op0_0000_an_s0p1_r100k rbl_op0_0000_an_s0p1_r100k ref_op0_0000_an_s0p1_r100k vn_op0_0000_an_s0p1_r100k 0 sky130_fd_pr__nfet_01v8 L=0.15 W=1 nf=1 ad=0.29 as=0.29 pd=2.58 ps=2.58 mult=1 m=1
XMN2_op0_0000_an_s0p1_r100k ref_op0_0000_an_s0p1_r100k rbl_op0_0000_an_s0p1_r100k vn_op0_0000_an_s0p1_r100k 0 sky130_fd_pr__nfet_01v8 L=0.15 W=1 nf=1 ad=0.29 as=0.29 pd=2.58 ps=2.58 mult=1 m=1
XMP1_op0_0000_an_s0p1_r100k rbl_op0_0000_an_s0p1_r100k ref_op0_0000_an_s0p1_r100k vp_op0_0000_an_s0p1_r100k vdd sky130_fd_pr__pfet_01v8 L=0.15 W=2 nf=1 ad=0.58 as=0.58 pd=4.58 ps=4.58 mult=1 m=1
XMP2_op0_0000_an_s0p1_r100k ref_op0_0000_an_s0p1_r100k rbl_op0_0000_an_s0p1_r100k vp_op0_0000_an_s0p1_r100k vdd sky130_fd_pr__pfet_01v8 L=0.15 W=2 nf=1 ad=0.58 as=0.58 pd=4.58 ps=4.58 mult=1 m=1
XMNF_op0_0000_an_s0p1_r100k vn_op0_0000_an_s0p1_r100k en_op0_0000_an_s0p1_r100k 0 0 sky130_fd_pr__nfet_01v8 L=0.15 W=2 nf=1 ad=0.58 as=0.58 pd=4.58 ps=4.58 mult=1 m=1
XMPH_op0_0000_an_s0p1_r100k vp_op0_0000_an_s0p1_r100k enb_op0_0000_an_s0p1_r100k vdd vdd sky130_fd_pr__pfet_01v8 L=0.15 W=4 nf=1 ad=1.16 as=1.16 pd=8.58 ps=8.58 mult=1 m=1
bd_op0_0000_an_s0p1_r100k d_op0_0000_an_s0p1_r100k 0 v=v(rbl_op0_0000_an_s0p1_r100k)-v(ref_op0_0000_an_s0p1_r100k)

* ---- instance 77: op1_0900_an_s0p1_r300k (variant an_s0p1_r300k; probe dec 14.9 ns, release 37 ns, meas 39 ns) ----
vctl_op1_0900_an_s0p1_r300k ctl_op1_0900_an_s0p1_r300k 0 pwl(0.0000e+00 {VDD} 2.0000e-09 {VDD} 2.1000e-09 0)
* RWL driver model (EXPERIMENTAL): slew 0.1 ns, series R 300000 ohm; cell pin = rwls_op1_0900_an_s0p1_r300k
vrs_op1_0900_an_s0p1_r300k rwlsrc_op1_0900_an_s0p1_r300k 0 pwl(0.0000e+00 {VDD} 4.0000e-09 {VDD} 4.1000e-09 0 3.7000e-08 0 3.7100e-08 {VDD})
rdrv_op1_0900_an_s0p1_r300k rwlsrc_op1_0900_an_s0p1_r300k rwls_op1_0900_an_s0p1_r300k 300000
ven_op1_0900_an_s0p1_r300k en_op1_0900_an_s0p1_r300k 0 pwl(0.0000e+00 0 1.4000e-08 0 1.4100e-08 {VDD} 3.7000e-08 {VDD} 3.7100e-08 0)
venb_op1_0900_an_s0p1_r300k enb_op1_0900_an_s0p1_r300k 0 pwl(0.0000e+00 {VDD} 1.4000e-08 {VDD} 1.4100e-08 0 3.7000e-08 0 3.7100e-08 {VDD})
vww_op1_0900_an_s0p1_r300k wwl_op1_0900_an_s0p1_r300k 0 pwl(0.0000e+00 0 1.5000e-08 0 1.5100e-08 {VDD} 3.5000e-08 {VDD} 3.5100e-08 0)
vwc_op1_0900_an_s0p1_r300k wbc_op1_0900_an_s0p1_r300k 0 pwl(0.0000e+00 0 1.5000e-08 0 1.5100e-08 {VDD} 3.7000e-08 {VDD} 3.7100e-08 0)
swb_op1_0900_an_s0p1_r300k ref_op1_0900_an_s0p1_r300k wbl_op1_0900_an_s0p1_r300k wbc_op1_0900_an_s0p1_r300k 0 swwbl
cwbl_op1_0900_an_s0p1_r300k wbl_op1_0900_an_s0p1_r300k 0 {C_WBL}
spa_op1_0900_an_s0p1_r300k prea rbl_op1_0900_an_s0p1_r300k ctl_op1_0900_an_s0p1_r300k 0 swpre
spr_op1_0900_an_s0p1_r300k pref ref_op1_0900_an_s0p1_r300k ctl_op1_0900_an_s0p1_r300k 0 swpre
crbl_op1_0900_an_s0p1_r300k rbl_op1_0900_an_s0p1_r300k 0 {C_RBL}
cref_op1_0900_an_s0p1_r300k ref_op1_0900_an_s0p1_r300k 0 {C_RBL}   $ ASSUMPTION: ideal matched dummy load
XMWR_op1_0900_an_s0p1_r300k_0 sn_op1_0900_an_s0p1_r300k_0 wwl_op1_0900_an_s0p1_r300k wbl_op1_0900_an_s0p1_r300k 0 sky130_fd_pr__nfet_01v8 L=0.15 W=0.42 nf=1 ad=0.1218 as=0.1218 pd=1.42 ps=1.42 nrd=0.69047619047619  nrs=0.69047619047619 sa=0 sb=0 sd=0 mult=1 m=1
XMRD_op1_0900_an_s0p1_r300k_0 rbl_op1_0900_an_s0p1_r300k sn_op1_0900_an_s0p1_r300k_0 rwls_op1_0900_an_s0p1_r300k 0 sky130_fd_pr__nfet_01v8 L=0.15 W=0.42 nf=1 ad=0.1218 as=0.1218 pd=1.42 ps=1.42 nrd=0.69047619047619  nrs=0.69047619047619 sa=0 sb=0 sd=0 mult=1 m=1
csn_op1_0900_an_s0p1_r300k_0 sn_op1_0900_an_s0p1_r300k_0 0 {C_SN}
XMWR_op1_0900_an_s0p1_r300k_1 sn_op1_0900_an_s0p1_r300k_1 wwl_des wbl_op1_0900_an_s0p1_r300k 0 sky130_fd_pr__nfet_01v8 L=0.15 W=0.42 nf=1 ad=0.1218 as=0.1218 pd=1.42 ps=1.42 nrd=0.69047619047619  nrs=0.69047619047619 sa=0 sb=0 sd=0 mult=1 m=1
XMRD_op1_0900_an_s0p1_r300k_1 rbl_op1_0900_an_s0p1_r300k sn_op1_0900_an_s0p1_r300k_1 rwl_des 0 sky130_fd_pr__nfet_01v8 L=0.15 W=0.42 nf=1 ad=0.1218 as=0.1218 pd=1.42 ps=1.42 nrd=0.69047619047619  nrs=0.69047619047619 sa=0 sb=0 sd=0 mult=1 m=1
csn_op1_0900_an_s0p1_r300k_1 sn_op1_0900_an_s0p1_r300k_1 0 {C_SN}
XMWR_op1_0900_an_s0p1_r300k_2 sn_op1_0900_an_s0p1_r300k_2 wwl_des wbl_op1_0900_an_s0p1_r300k 0 sky130_fd_pr__nfet_01v8 L=0.15 W=0.42 nf=1 ad=0.1218 as=0.1218 pd=1.42 ps=1.42 nrd=0.69047619047619  nrs=0.69047619047619 sa=0 sb=0 sd=0 mult=1 m=1
XMRD_op1_0900_an_s0p1_r300k_2 rbl_op1_0900_an_s0p1_r300k sn_op1_0900_an_s0p1_r300k_2 rwl_des 0 sky130_fd_pr__nfet_01v8 L=0.15 W=0.42 nf=1 ad=0.1218 as=0.1218 pd=1.42 ps=1.42 nrd=0.69047619047619  nrs=0.69047619047619 sa=0 sb=0 sd=0 mult=1 m=1
csn_op1_0900_an_s0p1_r300k_2 sn_op1_0900_an_s0p1_r300k_2 0 {C_SN}
XMWR_op1_0900_an_s0p1_r300k_3 sn_op1_0900_an_s0p1_r300k_3 wwl_des wbl_op1_0900_an_s0p1_r300k 0 sky130_fd_pr__nfet_01v8 L=0.15 W=0.42 nf=1 ad=0.1218 as=0.1218 pd=1.42 ps=1.42 nrd=0.69047619047619  nrs=0.69047619047619 sa=0 sb=0 sd=0 mult=1 m=1
XMRD_op1_0900_an_s0p1_r300k_3 rbl_op1_0900_an_s0p1_r300k sn_op1_0900_an_s0p1_r300k_3 rwl_des 0 sky130_fd_pr__nfet_01v8 L=0.15 W=0.42 nf=1 ad=0.1218 as=0.1218 pd=1.42 ps=1.42 nrd=0.69047619047619  nrs=0.69047619047619 sa=0 sb=0 sd=0 mult=1 m=1
csn_op1_0900_an_s0p1_r300k_3 sn_op1_0900_an_s0p1_r300k_3 0 {C_SN}
XMN1_op1_0900_an_s0p1_r300k rbl_op1_0900_an_s0p1_r300k ref_op1_0900_an_s0p1_r300k vn_op1_0900_an_s0p1_r300k 0 sky130_fd_pr__nfet_01v8 L=0.15 W=1 nf=1 ad=0.29 as=0.29 pd=2.58 ps=2.58 mult=1 m=1
XMN2_op1_0900_an_s0p1_r300k ref_op1_0900_an_s0p1_r300k rbl_op1_0900_an_s0p1_r300k vn_op1_0900_an_s0p1_r300k 0 sky130_fd_pr__nfet_01v8 L=0.15 W=1 nf=1 ad=0.29 as=0.29 pd=2.58 ps=2.58 mult=1 m=1
XMP1_op1_0900_an_s0p1_r300k rbl_op1_0900_an_s0p1_r300k ref_op1_0900_an_s0p1_r300k vp_op1_0900_an_s0p1_r300k vdd sky130_fd_pr__pfet_01v8 L=0.15 W=2 nf=1 ad=0.58 as=0.58 pd=4.58 ps=4.58 mult=1 m=1
XMP2_op1_0900_an_s0p1_r300k ref_op1_0900_an_s0p1_r300k rbl_op1_0900_an_s0p1_r300k vp_op1_0900_an_s0p1_r300k vdd sky130_fd_pr__pfet_01v8 L=0.15 W=2 nf=1 ad=0.58 as=0.58 pd=4.58 ps=4.58 mult=1 m=1
XMNF_op1_0900_an_s0p1_r300k vn_op1_0900_an_s0p1_r300k en_op1_0900_an_s0p1_r300k 0 0 sky130_fd_pr__nfet_01v8 L=0.15 W=2 nf=1 ad=0.58 as=0.58 pd=4.58 ps=4.58 mult=1 m=1
XMPH_op1_0900_an_s0p1_r300k vp_op1_0900_an_s0p1_r300k enb_op1_0900_an_s0p1_r300k vdd vdd sky130_fd_pr__pfet_01v8 L=0.15 W=4 nf=1 ad=1.16 as=1.16 pd=8.58 ps=8.58 mult=1 m=1
bd_op1_0900_an_s0p1_r300k d_op1_0900_an_s0p1_r300k 0 v=v(rbl_op1_0900_an_s0p1_r300k)-v(ref_op1_0900_an_s0p1_r300k)

* ---- instance 78: op1_1000_an_s0p1_r300k (variant an_s0p1_r300k; probe dec 14.9 ns, release 37 ns, meas 39 ns) ----
vctl_op1_1000_an_s0p1_r300k ctl_op1_1000_an_s0p1_r300k 0 pwl(0.0000e+00 {VDD} 2.0000e-09 {VDD} 2.1000e-09 0)
* RWL driver model (EXPERIMENTAL): slew 0.1 ns, series R 300000 ohm; cell pin = rwls_op1_1000_an_s0p1_r300k
vrs_op1_1000_an_s0p1_r300k rwlsrc_op1_1000_an_s0p1_r300k 0 pwl(0.0000e+00 {VDD} 4.0000e-09 {VDD} 4.1000e-09 0 3.7000e-08 0 3.7100e-08 {VDD})
rdrv_op1_1000_an_s0p1_r300k rwlsrc_op1_1000_an_s0p1_r300k rwls_op1_1000_an_s0p1_r300k 300000
ven_op1_1000_an_s0p1_r300k en_op1_1000_an_s0p1_r300k 0 pwl(0.0000e+00 0 1.4000e-08 0 1.4100e-08 {VDD} 3.7000e-08 {VDD} 3.7100e-08 0)
venb_op1_1000_an_s0p1_r300k enb_op1_1000_an_s0p1_r300k 0 pwl(0.0000e+00 {VDD} 1.4000e-08 {VDD} 1.4100e-08 0 3.7000e-08 0 3.7100e-08 {VDD})
vww_op1_1000_an_s0p1_r300k wwl_op1_1000_an_s0p1_r300k 0 pwl(0.0000e+00 0 1.5000e-08 0 1.5100e-08 {VDD} 3.5000e-08 {VDD} 3.5100e-08 0)
vwc_op1_1000_an_s0p1_r300k wbc_op1_1000_an_s0p1_r300k 0 pwl(0.0000e+00 0 1.5000e-08 0 1.5100e-08 {VDD} 3.7000e-08 {VDD} 3.7100e-08 0)
swb_op1_1000_an_s0p1_r300k ref_op1_1000_an_s0p1_r300k wbl_op1_1000_an_s0p1_r300k wbc_op1_1000_an_s0p1_r300k 0 swwbl
cwbl_op1_1000_an_s0p1_r300k wbl_op1_1000_an_s0p1_r300k 0 {C_WBL}
spa_op1_1000_an_s0p1_r300k prea rbl_op1_1000_an_s0p1_r300k ctl_op1_1000_an_s0p1_r300k 0 swpre
spr_op1_1000_an_s0p1_r300k pref ref_op1_1000_an_s0p1_r300k ctl_op1_1000_an_s0p1_r300k 0 swpre
crbl_op1_1000_an_s0p1_r300k rbl_op1_1000_an_s0p1_r300k 0 {C_RBL}
cref_op1_1000_an_s0p1_r300k ref_op1_1000_an_s0p1_r300k 0 {C_RBL}   $ ASSUMPTION: ideal matched dummy load
XMWR_op1_1000_an_s0p1_r300k_0 sn_op1_1000_an_s0p1_r300k_0 wwl_op1_1000_an_s0p1_r300k wbl_op1_1000_an_s0p1_r300k 0 sky130_fd_pr__nfet_01v8 L=0.15 W=0.42 nf=1 ad=0.1218 as=0.1218 pd=1.42 ps=1.42 nrd=0.69047619047619  nrs=0.69047619047619 sa=0 sb=0 sd=0 mult=1 m=1
XMRD_op1_1000_an_s0p1_r300k_0 rbl_op1_1000_an_s0p1_r300k sn_op1_1000_an_s0p1_r300k_0 rwls_op1_1000_an_s0p1_r300k 0 sky130_fd_pr__nfet_01v8 L=0.15 W=0.42 nf=1 ad=0.1218 as=0.1218 pd=1.42 ps=1.42 nrd=0.69047619047619  nrs=0.69047619047619 sa=0 sb=0 sd=0 mult=1 m=1
csn_op1_1000_an_s0p1_r300k_0 sn_op1_1000_an_s0p1_r300k_0 0 {C_SN}
XMWR_op1_1000_an_s0p1_r300k_1 sn_op1_1000_an_s0p1_r300k_1 wwl_des wbl_op1_1000_an_s0p1_r300k 0 sky130_fd_pr__nfet_01v8 L=0.15 W=0.42 nf=1 ad=0.1218 as=0.1218 pd=1.42 ps=1.42 nrd=0.69047619047619  nrs=0.69047619047619 sa=0 sb=0 sd=0 mult=1 m=1
XMRD_op1_1000_an_s0p1_r300k_1 rbl_op1_1000_an_s0p1_r300k sn_op1_1000_an_s0p1_r300k_1 rwl_des 0 sky130_fd_pr__nfet_01v8 L=0.15 W=0.42 nf=1 ad=0.1218 as=0.1218 pd=1.42 ps=1.42 nrd=0.69047619047619  nrs=0.69047619047619 sa=0 sb=0 sd=0 mult=1 m=1
csn_op1_1000_an_s0p1_r300k_1 sn_op1_1000_an_s0p1_r300k_1 0 {C_SN}
XMWR_op1_1000_an_s0p1_r300k_2 sn_op1_1000_an_s0p1_r300k_2 wwl_des wbl_op1_1000_an_s0p1_r300k 0 sky130_fd_pr__nfet_01v8 L=0.15 W=0.42 nf=1 ad=0.1218 as=0.1218 pd=1.42 ps=1.42 nrd=0.69047619047619  nrs=0.69047619047619 sa=0 sb=0 sd=0 mult=1 m=1
XMRD_op1_1000_an_s0p1_r300k_2 rbl_op1_1000_an_s0p1_r300k sn_op1_1000_an_s0p1_r300k_2 rwl_des 0 sky130_fd_pr__nfet_01v8 L=0.15 W=0.42 nf=1 ad=0.1218 as=0.1218 pd=1.42 ps=1.42 nrd=0.69047619047619  nrs=0.69047619047619 sa=0 sb=0 sd=0 mult=1 m=1
csn_op1_1000_an_s0p1_r300k_2 sn_op1_1000_an_s0p1_r300k_2 0 {C_SN}
XMWR_op1_1000_an_s0p1_r300k_3 sn_op1_1000_an_s0p1_r300k_3 wwl_des wbl_op1_1000_an_s0p1_r300k 0 sky130_fd_pr__nfet_01v8 L=0.15 W=0.42 nf=1 ad=0.1218 as=0.1218 pd=1.42 ps=1.42 nrd=0.69047619047619  nrs=0.69047619047619 sa=0 sb=0 sd=0 mult=1 m=1
XMRD_op1_1000_an_s0p1_r300k_3 rbl_op1_1000_an_s0p1_r300k sn_op1_1000_an_s0p1_r300k_3 rwl_des 0 sky130_fd_pr__nfet_01v8 L=0.15 W=0.42 nf=1 ad=0.1218 as=0.1218 pd=1.42 ps=1.42 nrd=0.69047619047619  nrs=0.69047619047619 sa=0 sb=0 sd=0 mult=1 m=1
csn_op1_1000_an_s0p1_r300k_3 sn_op1_1000_an_s0p1_r300k_3 0 {C_SN}
XMN1_op1_1000_an_s0p1_r300k rbl_op1_1000_an_s0p1_r300k ref_op1_1000_an_s0p1_r300k vn_op1_1000_an_s0p1_r300k 0 sky130_fd_pr__nfet_01v8 L=0.15 W=1 nf=1 ad=0.29 as=0.29 pd=2.58 ps=2.58 mult=1 m=1
XMN2_op1_1000_an_s0p1_r300k ref_op1_1000_an_s0p1_r300k rbl_op1_1000_an_s0p1_r300k vn_op1_1000_an_s0p1_r300k 0 sky130_fd_pr__nfet_01v8 L=0.15 W=1 nf=1 ad=0.29 as=0.29 pd=2.58 ps=2.58 mult=1 m=1
XMP1_op1_1000_an_s0p1_r300k rbl_op1_1000_an_s0p1_r300k ref_op1_1000_an_s0p1_r300k vp_op1_1000_an_s0p1_r300k vdd sky130_fd_pr__pfet_01v8 L=0.15 W=2 nf=1 ad=0.58 as=0.58 pd=4.58 ps=4.58 mult=1 m=1
XMP2_op1_1000_an_s0p1_r300k ref_op1_1000_an_s0p1_r300k rbl_op1_1000_an_s0p1_r300k vp_op1_1000_an_s0p1_r300k vdd sky130_fd_pr__pfet_01v8 L=0.15 W=2 nf=1 ad=0.58 as=0.58 pd=4.58 ps=4.58 mult=1 m=1
XMNF_op1_1000_an_s0p1_r300k vn_op1_1000_an_s0p1_r300k en_op1_1000_an_s0p1_r300k 0 0 sky130_fd_pr__nfet_01v8 L=0.15 W=2 nf=1 ad=0.58 as=0.58 pd=4.58 ps=4.58 mult=1 m=1
XMPH_op1_1000_an_s0p1_r300k vp_op1_1000_an_s0p1_r300k enb_op1_1000_an_s0p1_r300k vdd vdd sky130_fd_pr__pfet_01v8 L=0.15 W=4 nf=1 ad=1.16 as=1.16 pd=8.58 ps=8.58 mult=1 m=1
bd_op1_1000_an_s0p1_r300k d_op1_1000_an_s0p1_r300k 0 v=v(rbl_op1_1000_an_s0p1_r300k)-v(ref_op1_1000_an_s0p1_r300k)

* ---- instance 79: op0_n100_an_s0p1_r300k (variant an_s0p1_r300k; probe dec 14.9 ns, release 37 ns, meas 39 ns) ----
vctl_op0_n100_an_s0p1_r300k ctl_op0_n100_an_s0p1_r300k 0 pwl(0.0000e+00 {VDD} 2.0000e-09 {VDD} 2.1000e-09 0)
* RWL driver model (EXPERIMENTAL): slew 0.1 ns, series R 300000 ohm; cell pin = rwls_op0_n100_an_s0p1_r300k
vrs_op0_n100_an_s0p1_r300k rwlsrc_op0_n100_an_s0p1_r300k 0 pwl(0.0000e+00 {VDD} 4.0000e-09 {VDD} 4.1000e-09 0 3.7000e-08 0 3.7100e-08 {VDD})
rdrv_op0_n100_an_s0p1_r300k rwlsrc_op0_n100_an_s0p1_r300k rwls_op0_n100_an_s0p1_r300k 300000
ven_op0_n100_an_s0p1_r300k en_op0_n100_an_s0p1_r300k 0 pwl(0.0000e+00 0 1.4000e-08 0 1.4100e-08 {VDD} 3.7000e-08 {VDD} 3.7100e-08 0)
venb_op0_n100_an_s0p1_r300k enb_op0_n100_an_s0p1_r300k 0 pwl(0.0000e+00 {VDD} 1.4000e-08 {VDD} 1.4100e-08 0 3.7000e-08 0 3.7100e-08 {VDD})
vww_op0_n100_an_s0p1_r300k wwl_op0_n100_an_s0p1_r300k 0 pwl(0.0000e+00 0 1.5000e-08 0 1.5100e-08 {VDD} 3.5000e-08 {VDD} 3.5100e-08 0)
vwc_op0_n100_an_s0p1_r300k wbc_op0_n100_an_s0p1_r300k 0 pwl(0.0000e+00 0 1.5000e-08 0 1.5100e-08 {VDD} 3.7000e-08 {VDD} 3.7100e-08 0)
swb_op0_n100_an_s0p1_r300k ref_op0_n100_an_s0p1_r300k wbl_op0_n100_an_s0p1_r300k wbc_op0_n100_an_s0p1_r300k 0 swwbl
cwbl_op0_n100_an_s0p1_r300k wbl_op0_n100_an_s0p1_r300k 0 {C_WBL}
spa_op0_n100_an_s0p1_r300k prea rbl_op0_n100_an_s0p1_r300k ctl_op0_n100_an_s0p1_r300k 0 swpre
spr_op0_n100_an_s0p1_r300k pref ref_op0_n100_an_s0p1_r300k ctl_op0_n100_an_s0p1_r300k 0 swpre
crbl_op0_n100_an_s0p1_r300k rbl_op0_n100_an_s0p1_r300k 0 {C_RBL}
cref_op0_n100_an_s0p1_r300k ref_op0_n100_an_s0p1_r300k 0 {C_RBL}   $ ASSUMPTION: ideal matched dummy load
XMWR_op0_n100_an_s0p1_r300k_0 sn_op0_n100_an_s0p1_r300k_0 wwl_op0_n100_an_s0p1_r300k wbl_op0_n100_an_s0p1_r300k 0 sky130_fd_pr__nfet_01v8 L=0.15 W=0.42 nf=1 ad=0.1218 as=0.1218 pd=1.42 ps=1.42 nrd=0.69047619047619  nrs=0.69047619047619 sa=0 sb=0 sd=0 mult=1 m=1
XMRD_op0_n100_an_s0p1_r300k_0 rbl_op0_n100_an_s0p1_r300k sn_op0_n100_an_s0p1_r300k_0 rwls_op0_n100_an_s0p1_r300k 0 sky130_fd_pr__nfet_01v8 L=0.15 W=0.42 nf=1 ad=0.1218 as=0.1218 pd=1.42 ps=1.42 nrd=0.69047619047619  nrs=0.69047619047619 sa=0 sb=0 sd=0 mult=1 m=1
csn_op0_n100_an_s0p1_r300k_0 sn_op0_n100_an_s0p1_r300k_0 0 {C_SN}
XMWR_op0_n100_an_s0p1_r300k_1 sn_op0_n100_an_s0p1_r300k_1 wwl_des wbl_op0_n100_an_s0p1_r300k 0 sky130_fd_pr__nfet_01v8 L=0.15 W=0.42 nf=1 ad=0.1218 as=0.1218 pd=1.42 ps=1.42 nrd=0.69047619047619  nrs=0.69047619047619 sa=0 sb=0 sd=0 mult=1 m=1
XMRD_op0_n100_an_s0p1_r300k_1 rbl_op0_n100_an_s0p1_r300k sn_op0_n100_an_s0p1_r300k_1 rwl_des 0 sky130_fd_pr__nfet_01v8 L=0.15 W=0.42 nf=1 ad=0.1218 as=0.1218 pd=1.42 ps=1.42 nrd=0.69047619047619  nrs=0.69047619047619 sa=0 sb=0 sd=0 mult=1 m=1
csn_op0_n100_an_s0p1_r300k_1 sn_op0_n100_an_s0p1_r300k_1 0 {C_SN}
XMWR_op0_n100_an_s0p1_r300k_2 sn_op0_n100_an_s0p1_r300k_2 wwl_des wbl_op0_n100_an_s0p1_r300k 0 sky130_fd_pr__nfet_01v8 L=0.15 W=0.42 nf=1 ad=0.1218 as=0.1218 pd=1.42 ps=1.42 nrd=0.69047619047619  nrs=0.69047619047619 sa=0 sb=0 sd=0 mult=1 m=1
XMRD_op0_n100_an_s0p1_r300k_2 rbl_op0_n100_an_s0p1_r300k sn_op0_n100_an_s0p1_r300k_2 rwl_des 0 sky130_fd_pr__nfet_01v8 L=0.15 W=0.42 nf=1 ad=0.1218 as=0.1218 pd=1.42 ps=1.42 nrd=0.69047619047619  nrs=0.69047619047619 sa=0 sb=0 sd=0 mult=1 m=1
csn_op0_n100_an_s0p1_r300k_2 sn_op0_n100_an_s0p1_r300k_2 0 {C_SN}
XMWR_op0_n100_an_s0p1_r300k_3 sn_op0_n100_an_s0p1_r300k_3 wwl_des wbl_op0_n100_an_s0p1_r300k 0 sky130_fd_pr__nfet_01v8 L=0.15 W=0.42 nf=1 ad=0.1218 as=0.1218 pd=1.42 ps=1.42 nrd=0.69047619047619  nrs=0.69047619047619 sa=0 sb=0 sd=0 mult=1 m=1
XMRD_op0_n100_an_s0p1_r300k_3 rbl_op0_n100_an_s0p1_r300k sn_op0_n100_an_s0p1_r300k_3 rwl_des 0 sky130_fd_pr__nfet_01v8 L=0.15 W=0.42 nf=1 ad=0.1218 as=0.1218 pd=1.42 ps=1.42 nrd=0.69047619047619  nrs=0.69047619047619 sa=0 sb=0 sd=0 mult=1 m=1
csn_op0_n100_an_s0p1_r300k_3 sn_op0_n100_an_s0p1_r300k_3 0 {C_SN}
XMN1_op0_n100_an_s0p1_r300k rbl_op0_n100_an_s0p1_r300k ref_op0_n100_an_s0p1_r300k vn_op0_n100_an_s0p1_r300k 0 sky130_fd_pr__nfet_01v8 L=0.15 W=1 nf=1 ad=0.29 as=0.29 pd=2.58 ps=2.58 mult=1 m=1
XMN2_op0_n100_an_s0p1_r300k ref_op0_n100_an_s0p1_r300k rbl_op0_n100_an_s0p1_r300k vn_op0_n100_an_s0p1_r300k 0 sky130_fd_pr__nfet_01v8 L=0.15 W=1 nf=1 ad=0.29 as=0.29 pd=2.58 ps=2.58 mult=1 m=1
XMP1_op0_n100_an_s0p1_r300k rbl_op0_n100_an_s0p1_r300k ref_op0_n100_an_s0p1_r300k vp_op0_n100_an_s0p1_r300k vdd sky130_fd_pr__pfet_01v8 L=0.15 W=2 nf=1 ad=0.58 as=0.58 pd=4.58 ps=4.58 mult=1 m=1
XMP2_op0_n100_an_s0p1_r300k ref_op0_n100_an_s0p1_r300k rbl_op0_n100_an_s0p1_r300k vp_op0_n100_an_s0p1_r300k vdd sky130_fd_pr__pfet_01v8 L=0.15 W=2 nf=1 ad=0.58 as=0.58 pd=4.58 ps=4.58 mult=1 m=1
XMNF_op0_n100_an_s0p1_r300k vn_op0_n100_an_s0p1_r300k en_op0_n100_an_s0p1_r300k 0 0 sky130_fd_pr__nfet_01v8 L=0.15 W=2 nf=1 ad=0.58 as=0.58 pd=4.58 ps=4.58 mult=1 m=1
XMPH_op0_n100_an_s0p1_r300k vp_op0_n100_an_s0p1_r300k enb_op0_n100_an_s0p1_r300k vdd vdd sky130_fd_pr__pfet_01v8 L=0.15 W=4 nf=1 ad=1.16 as=1.16 pd=8.58 ps=8.58 mult=1 m=1
bd_op0_n100_an_s0p1_r300k d_op0_n100_an_s0p1_r300k 0 v=v(rbl_op0_n100_an_s0p1_r300k)-v(ref_op0_n100_an_s0p1_r300k)

* ---- instance 80: op0_0000_an_s0p1_r300k (variant an_s0p1_r300k; probe dec 14.9 ns, release 37 ns, meas 39 ns) ----
vctl_op0_0000_an_s0p1_r300k ctl_op0_0000_an_s0p1_r300k 0 pwl(0.0000e+00 {VDD} 2.0000e-09 {VDD} 2.1000e-09 0)
* RWL driver model (EXPERIMENTAL): slew 0.1 ns, series R 300000 ohm; cell pin = rwls_op0_0000_an_s0p1_r300k
vrs_op0_0000_an_s0p1_r300k rwlsrc_op0_0000_an_s0p1_r300k 0 pwl(0.0000e+00 {VDD} 4.0000e-09 {VDD} 4.1000e-09 0 3.7000e-08 0 3.7100e-08 {VDD})
rdrv_op0_0000_an_s0p1_r300k rwlsrc_op0_0000_an_s0p1_r300k rwls_op0_0000_an_s0p1_r300k 300000
ven_op0_0000_an_s0p1_r300k en_op0_0000_an_s0p1_r300k 0 pwl(0.0000e+00 0 1.4000e-08 0 1.4100e-08 {VDD} 3.7000e-08 {VDD} 3.7100e-08 0)
venb_op0_0000_an_s0p1_r300k enb_op0_0000_an_s0p1_r300k 0 pwl(0.0000e+00 {VDD} 1.4000e-08 {VDD} 1.4100e-08 0 3.7000e-08 0 3.7100e-08 {VDD})
vww_op0_0000_an_s0p1_r300k wwl_op0_0000_an_s0p1_r300k 0 pwl(0.0000e+00 0 1.5000e-08 0 1.5100e-08 {VDD} 3.5000e-08 {VDD} 3.5100e-08 0)
vwc_op0_0000_an_s0p1_r300k wbc_op0_0000_an_s0p1_r300k 0 pwl(0.0000e+00 0 1.5000e-08 0 1.5100e-08 {VDD} 3.7000e-08 {VDD} 3.7100e-08 0)
swb_op0_0000_an_s0p1_r300k ref_op0_0000_an_s0p1_r300k wbl_op0_0000_an_s0p1_r300k wbc_op0_0000_an_s0p1_r300k 0 swwbl
cwbl_op0_0000_an_s0p1_r300k wbl_op0_0000_an_s0p1_r300k 0 {C_WBL}
spa_op0_0000_an_s0p1_r300k prea rbl_op0_0000_an_s0p1_r300k ctl_op0_0000_an_s0p1_r300k 0 swpre
spr_op0_0000_an_s0p1_r300k pref ref_op0_0000_an_s0p1_r300k ctl_op0_0000_an_s0p1_r300k 0 swpre
crbl_op0_0000_an_s0p1_r300k rbl_op0_0000_an_s0p1_r300k 0 {C_RBL}
cref_op0_0000_an_s0p1_r300k ref_op0_0000_an_s0p1_r300k 0 {C_RBL}   $ ASSUMPTION: ideal matched dummy load
XMWR_op0_0000_an_s0p1_r300k_0 sn_op0_0000_an_s0p1_r300k_0 wwl_op0_0000_an_s0p1_r300k wbl_op0_0000_an_s0p1_r300k 0 sky130_fd_pr__nfet_01v8 L=0.15 W=0.42 nf=1 ad=0.1218 as=0.1218 pd=1.42 ps=1.42 nrd=0.69047619047619  nrs=0.69047619047619 sa=0 sb=0 sd=0 mult=1 m=1
XMRD_op0_0000_an_s0p1_r300k_0 rbl_op0_0000_an_s0p1_r300k sn_op0_0000_an_s0p1_r300k_0 rwls_op0_0000_an_s0p1_r300k 0 sky130_fd_pr__nfet_01v8 L=0.15 W=0.42 nf=1 ad=0.1218 as=0.1218 pd=1.42 ps=1.42 nrd=0.69047619047619  nrs=0.69047619047619 sa=0 sb=0 sd=0 mult=1 m=1
csn_op0_0000_an_s0p1_r300k_0 sn_op0_0000_an_s0p1_r300k_0 0 {C_SN}
XMWR_op0_0000_an_s0p1_r300k_1 sn_op0_0000_an_s0p1_r300k_1 wwl_des wbl_op0_0000_an_s0p1_r300k 0 sky130_fd_pr__nfet_01v8 L=0.15 W=0.42 nf=1 ad=0.1218 as=0.1218 pd=1.42 ps=1.42 nrd=0.69047619047619  nrs=0.69047619047619 sa=0 sb=0 sd=0 mult=1 m=1
XMRD_op0_0000_an_s0p1_r300k_1 rbl_op0_0000_an_s0p1_r300k sn_op0_0000_an_s0p1_r300k_1 rwl_des 0 sky130_fd_pr__nfet_01v8 L=0.15 W=0.42 nf=1 ad=0.1218 as=0.1218 pd=1.42 ps=1.42 nrd=0.69047619047619  nrs=0.69047619047619 sa=0 sb=0 sd=0 mult=1 m=1
csn_op0_0000_an_s0p1_r300k_1 sn_op0_0000_an_s0p1_r300k_1 0 {C_SN}
XMWR_op0_0000_an_s0p1_r300k_2 sn_op0_0000_an_s0p1_r300k_2 wwl_des wbl_op0_0000_an_s0p1_r300k 0 sky130_fd_pr__nfet_01v8 L=0.15 W=0.42 nf=1 ad=0.1218 as=0.1218 pd=1.42 ps=1.42 nrd=0.69047619047619  nrs=0.69047619047619 sa=0 sb=0 sd=0 mult=1 m=1
XMRD_op0_0000_an_s0p1_r300k_2 rbl_op0_0000_an_s0p1_r300k sn_op0_0000_an_s0p1_r300k_2 rwl_des 0 sky130_fd_pr__nfet_01v8 L=0.15 W=0.42 nf=1 ad=0.1218 as=0.1218 pd=1.42 ps=1.42 nrd=0.69047619047619  nrs=0.69047619047619 sa=0 sb=0 sd=0 mult=1 m=1
csn_op0_0000_an_s0p1_r300k_2 sn_op0_0000_an_s0p1_r300k_2 0 {C_SN}
XMWR_op0_0000_an_s0p1_r300k_3 sn_op0_0000_an_s0p1_r300k_3 wwl_des wbl_op0_0000_an_s0p1_r300k 0 sky130_fd_pr__nfet_01v8 L=0.15 W=0.42 nf=1 ad=0.1218 as=0.1218 pd=1.42 ps=1.42 nrd=0.69047619047619  nrs=0.69047619047619 sa=0 sb=0 sd=0 mult=1 m=1
XMRD_op0_0000_an_s0p1_r300k_3 rbl_op0_0000_an_s0p1_r300k sn_op0_0000_an_s0p1_r300k_3 rwl_des 0 sky130_fd_pr__nfet_01v8 L=0.15 W=0.42 nf=1 ad=0.1218 as=0.1218 pd=1.42 ps=1.42 nrd=0.69047619047619  nrs=0.69047619047619 sa=0 sb=0 sd=0 mult=1 m=1
csn_op0_0000_an_s0p1_r300k_3 sn_op0_0000_an_s0p1_r300k_3 0 {C_SN}
XMN1_op0_0000_an_s0p1_r300k rbl_op0_0000_an_s0p1_r300k ref_op0_0000_an_s0p1_r300k vn_op0_0000_an_s0p1_r300k 0 sky130_fd_pr__nfet_01v8 L=0.15 W=1 nf=1 ad=0.29 as=0.29 pd=2.58 ps=2.58 mult=1 m=1
XMN2_op0_0000_an_s0p1_r300k ref_op0_0000_an_s0p1_r300k rbl_op0_0000_an_s0p1_r300k vn_op0_0000_an_s0p1_r300k 0 sky130_fd_pr__nfet_01v8 L=0.15 W=1 nf=1 ad=0.29 as=0.29 pd=2.58 ps=2.58 mult=1 m=1
XMP1_op0_0000_an_s0p1_r300k rbl_op0_0000_an_s0p1_r300k ref_op0_0000_an_s0p1_r300k vp_op0_0000_an_s0p1_r300k vdd sky130_fd_pr__pfet_01v8 L=0.15 W=2 nf=1 ad=0.58 as=0.58 pd=4.58 ps=4.58 mult=1 m=1
XMP2_op0_0000_an_s0p1_r300k ref_op0_0000_an_s0p1_r300k rbl_op0_0000_an_s0p1_r300k vp_op0_0000_an_s0p1_r300k vdd sky130_fd_pr__pfet_01v8 L=0.15 W=2 nf=1 ad=0.58 as=0.58 pd=4.58 ps=4.58 mult=1 m=1
XMNF_op0_0000_an_s0p1_r300k vn_op0_0000_an_s0p1_r300k en_op0_0000_an_s0p1_r300k 0 0 sky130_fd_pr__nfet_01v8 L=0.15 W=2 nf=1 ad=0.58 as=0.58 pd=4.58 ps=4.58 mult=1 m=1
XMPH_op0_0000_an_s0p1_r300k vp_op0_0000_an_s0p1_r300k enb_op0_0000_an_s0p1_r300k vdd vdd sky130_fd_pr__pfet_01v8 L=0.15 W=4 nf=1 ad=1.16 as=1.16 pd=8.58 ps=8.58 mult=1 m=1
bd_op0_0000_an_s0p1_r300k d_op0_0000_an_s0p1_r300k 0 v=v(rbl_op0_0000_an_s0p1_r300k)-v(ref_op0_0000_an_s0p1_r300k)

* ---- instance 81: op1_0900_an_s0p1_r1000k (variant an_s0p1_r1000k; probe dec 14.9 ns, release 37 ns, meas 39 ns) ----
vctl_op1_0900_an_s0p1_r1000k ctl_op1_0900_an_s0p1_r1000k 0 pwl(0.0000e+00 {VDD} 2.0000e-09 {VDD} 2.1000e-09 0)
* RWL driver model (EXPERIMENTAL): slew 0.1 ns, series R 1e+06 ohm; cell pin = rwls_op1_0900_an_s0p1_r1000k
vrs_op1_0900_an_s0p1_r1000k rwlsrc_op1_0900_an_s0p1_r1000k 0 pwl(0.0000e+00 {VDD} 4.0000e-09 {VDD} 4.1000e-09 0 3.7000e-08 0 3.7100e-08 {VDD})
rdrv_op1_0900_an_s0p1_r1000k rwlsrc_op1_0900_an_s0p1_r1000k rwls_op1_0900_an_s0p1_r1000k 1e+06
ven_op1_0900_an_s0p1_r1000k en_op1_0900_an_s0p1_r1000k 0 pwl(0.0000e+00 0 1.4000e-08 0 1.4100e-08 {VDD} 3.7000e-08 {VDD} 3.7100e-08 0)
venb_op1_0900_an_s0p1_r1000k enb_op1_0900_an_s0p1_r1000k 0 pwl(0.0000e+00 {VDD} 1.4000e-08 {VDD} 1.4100e-08 0 3.7000e-08 0 3.7100e-08 {VDD})
vww_op1_0900_an_s0p1_r1000k wwl_op1_0900_an_s0p1_r1000k 0 pwl(0.0000e+00 0 1.5000e-08 0 1.5100e-08 {VDD} 3.5000e-08 {VDD} 3.5100e-08 0)
vwc_op1_0900_an_s0p1_r1000k wbc_op1_0900_an_s0p1_r1000k 0 pwl(0.0000e+00 0 1.5000e-08 0 1.5100e-08 {VDD} 3.7000e-08 {VDD} 3.7100e-08 0)
swb_op1_0900_an_s0p1_r1000k ref_op1_0900_an_s0p1_r1000k wbl_op1_0900_an_s0p1_r1000k wbc_op1_0900_an_s0p1_r1000k 0 swwbl
cwbl_op1_0900_an_s0p1_r1000k wbl_op1_0900_an_s0p1_r1000k 0 {C_WBL}
spa_op1_0900_an_s0p1_r1000k prea rbl_op1_0900_an_s0p1_r1000k ctl_op1_0900_an_s0p1_r1000k 0 swpre
spr_op1_0900_an_s0p1_r1000k pref ref_op1_0900_an_s0p1_r1000k ctl_op1_0900_an_s0p1_r1000k 0 swpre
crbl_op1_0900_an_s0p1_r1000k rbl_op1_0900_an_s0p1_r1000k 0 {C_RBL}
cref_op1_0900_an_s0p1_r1000k ref_op1_0900_an_s0p1_r1000k 0 {C_RBL}   $ ASSUMPTION: ideal matched dummy load
XMWR_op1_0900_an_s0p1_r1000k_0 sn_op1_0900_an_s0p1_r1000k_0 wwl_op1_0900_an_s0p1_r1000k wbl_op1_0900_an_s0p1_r1000k 0 sky130_fd_pr__nfet_01v8 L=0.15 W=0.42 nf=1 ad=0.1218 as=0.1218 pd=1.42 ps=1.42 nrd=0.69047619047619  nrs=0.69047619047619 sa=0 sb=0 sd=0 mult=1 m=1
XMRD_op1_0900_an_s0p1_r1000k_0 rbl_op1_0900_an_s0p1_r1000k sn_op1_0900_an_s0p1_r1000k_0 rwls_op1_0900_an_s0p1_r1000k 0 sky130_fd_pr__nfet_01v8 L=0.15 W=0.42 nf=1 ad=0.1218 as=0.1218 pd=1.42 ps=1.42 nrd=0.69047619047619  nrs=0.69047619047619 sa=0 sb=0 sd=0 mult=1 m=1
csn_op1_0900_an_s0p1_r1000k_0 sn_op1_0900_an_s0p1_r1000k_0 0 {C_SN}
XMWR_op1_0900_an_s0p1_r1000k_1 sn_op1_0900_an_s0p1_r1000k_1 wwl_des wbl_op1_0900_an_s0p1_r1000k 0 sky130_fd_pr__nfet_01v8 L=0.15 W=0.42 nf=1 ad=0.1218 as=0.1218 pd=1.42 ps=1.42 nrd=0.69047619047619  nrs=0.69047619047619 sa=0 sb=0 sd=0 mult=1 m=1
XMRD_op1_0900_an_s0p1_r1000k_1 rbl_op1_0900_an_s0p1_r1000k sn_op1_0900_an_s0p1_r1000k_1 rwl_des 0 sky130_fd_pr__nfet_01v8 L=0.15 W=0.42 nf=1 ad=0.1218 as=0.1218 pd=1.42 ps=1.42 nrd=0.69047619047619  nrs=0.69047619047619 sa=0 sb=0 sd=0 mult=1 m=1
csn_op1_0900_an_s0p1_r1000k_1 sn_op1_0900_an_s0p1_r1000k_1 0 {C_SN}
XMWR_op1_0900_an_s0p1_r1000k_2 sn_op1_0900_an_s0p1_r1000k_2 wwl_des wbl_op1_0900_an_s0p1_r1000k 0 sky130_fd_pr__nfet_01v8 L=0.15 W=0.42 nf=1 ad=0.1218 as=0.1218 pd=1.42 ps=1.42 nrd=0.69047619047619  nrs=0.69047619047619 sa=0 sb=0 sd=0 mult=1 m=1
XMRD_op1_0900_an_s0p1_r1000k_2 rbl_op1_0900_an_s0p1_r1000k sn_op1_0900_an_s0p1_r1000k_2 rwl_des 0 sky130_fd_pr__nfet_01v8 L=0.15 W=0.42 nf=1 ad=0.1218 as=0.1218 pd=1.42 ps=1.42 nrd=0.69047619047619  nrs=0.69047619047619 sa=0 sb=0 sd=0 mult=1 m=1
csn_op1_0900_an_s0p1_r1000k_2 sn_op1_0900_an_s0p1_r1000k_2 0 {C_SN}
XMWR_op1_0900_an_s0p1_r1000k_3 sn_op1_0900_an_s0p1_r1000k_3 wwl_des wbl_op1_0900_an_s0p1_r1000k 0 sky130_fd_pr__nfet_01v8 L=0.15 W=0.42 nf=1 ad=0.1218 as=0.1218 pd=1.42 ps=1.42 nrd=0.69047619047619  nrs=0.69047619047619 sa=0 sb=0 sd=0 mult=1 m=1
XMRD_op1_0900_an_s0p1_r1000k_3 rbl_op1_0900_an_s0p1_r1000k sn_op1_0900_an_s0p1_r1000k_3 rwl_des 0 sky130_fd_pr__nfet_01v8 L=0.15 W=0.42 nf=1 ad=0.1218 as=0.1218 pd=1.42 ps=1.42 nrd=0.69047619047619  nrs=0.69047619047619 sa=0 sb=0 sd=0 mult=1 m=1
csn_op1_0900_an_s0p1_r1000k_3 sn_op1_0900_an_s0p1_r1000k_3 0 {C_SN}
XMN1_op1_0900_an_s0p1_r1000k rbl_op1_0900_an_s0p1_r1000k ref_op1_0900_an_s0p1_r1000k vn_op1_0900_an_s0p1_r1000k 0 sky130_fd_pr__nfet_01v8 L=0.15 W=1 nf=1 ad=0.29 as=0.29 pd=2.58 ps=2.58 mult=1 m=1
XMN2_op1_0900_an_s0p1_r1000k ref_op1_0900_an_s0p1_r1000k rbl_op1_0900_an_s0p1_r1000k vn_op1_0900_an_s0p1_r1000k 0 sky130_fd_pr__nfet_01v8 L=0.15 W=1 nf=1 ad=0.29 as=0.29 pd=2.58 ps=2.58 mult=1 m=1
XMP1_op1_0900_an_s0p1_r1000k rbl_op1_0900_an_s0p1_r1000k ref_op1_0900_an_s0p1_r1000k vp_op1_0900_an_s0p1_r1000k vdd sky130_fd_pr__pfet_01v8 L=0.15 W=2 nf=1 ad=0.58 as=0.58 pd=4.58 ps=4.58 mult=1 m=1
XMP2_op1_0900_an_s0p1_r1000k ref_op1_0900_an_s0p1_r1000k rbl_op1_0900_an_s0p1_r1000k vp_op1_0900_an_s0p1_r1000k vdd sky130_fd_pr__pfet_01v8 L=0.15 W=2 nf=1 ad=0.58 as=0.58 pd=4.58 ps=4.58 mult=1 m=1
XMNF_op1_0900_an_s0p1_r1000k vn_op1_0900_an_s0p1_r1000k en_op1_0900_an_s0p1_r1000k 0 0 sky130_fd_pr__nfet_01v8 L=0.15 W=2 nf=1 ad=0.58 as=0.58 pd=4.58 ps=4.58 mult=1 m=1
XMPH_op1_0900_an_s0p1_r1000k vp_op1_0900_an_s0p1_r1000k enb_op1_0900_an_s0p1_r1000k vdd vdd sky130_fd_pr__pfet_01v8 L=0.15 W=4 nf=1 ad=1.16 as=1.16 pd=8.58 ps=8.58 mult=1 m=1
bd_op1_0900_an_s0p1_r1000k d_op1_0900_an_s0p1_r1000k 0 v=v(rbl_op1_0900_an_s0p1_r1000k)-v(ref_op1_0900_an_s0p1_r1000k)

* ---- instance 82: op1_1000_an_s0p1_r1000k (variant an_s0p1_r1000k; probe dec 14.9 ns, release 37 ns, meas 39 ns) ----
vctl_op1_1000_an_s0p1_r1000k ctl_op1_1000_an_s0p1_r1000k 0 pwl(0.0000e+00 {VDD} 2.0000e-09 {VDD} 2.1000e-09 0)
* RWL driver model (EXPERIMENTAL): slew 0.1 ns, series R 1e+06 ohm; cell pin = rwls_op1_1000_an_s0p1_r1000k
vrs_op1_1000_an_s0p1_r1000k rwlsrc_op1_1000_an_s0p1_r1000k 0 pwl(0.0000e+00 {VDD} 4.0000e-09 {VDD} 4.1000e-09 0 3.7000e-08 0 3.7100e-08 {VDD})
rdrv_op1_1000_an_s0p1_r1000k rwlsrc_op1_1000_an_s0p1_r1000k rwls_op1_1000_an_s0p1_r1000k 1e+06
ven_op1_1000_an_s0p1_r1000k en_op1_1000_an_s0p1_r1000k 0 pwl(0.0000e+00 0 1.4000e-08 0 1.4100e-08 {VDD} 3.7000e-08 {VDD} 3.7100e-08 0)
venb_op1_1000_an_s0p1_r1000k enb_op1_1000_an_s0p1_r1000k 0 pwl(0.0000e+00 {VDD} 1.4000e-08 {VDD} 1.4100e-08 0 3.7000e-08 0 3.7100e-08 {VDD})
vww_op1_1000_an_s0p1_r1000k wwl_op1_1000_an_s0p1_r1000k 0 pwl(0.0000e+00 0 1.5000e-08 0 1.5100e-08 {VDD} 3.5000e-08 {VDD} 3.5100e-08 0)
vwc_op1_1000_an_s0p1_r1000k wbc_op1_1000_an_s0p1_r1000k 0 pwl(0.0000e+00 0 1.5000e-08 0 1.5100e-08 {VDD} 3.7000e-08 {VDD} 3.7100e-08 0)
swb_op1_1000_an_s0p1_r1000k ref_op1_1000_an_s0p1_r1000k wbl_op1_1000_an_s0p1_r1000k wbc_op1_1000_an_s0p1_r1000k 0 swwbl
cwbl_op1_1000_an_s0p1_r1000k wbl_op1_1000_an_s0p1_r1000k 0 {C_WBL}
spa_op1_1000_an_s0p1_r1000k prea rbl_op1_1000_an_s0p1_r1000k ctl_op1_1000_an_s0p1_r1000k 0 swpre
spr_op1_1000_an_s0p1_r1000k pref ref_op1_1000_an_s0p1_r1000k ctl_op1_1000_an_s0p1_r1000k 0 swpre
crbl_op1_1000_an_s0p1_r1000k rbl_op1_1000_an_s0p1_r1000k 0 {C_RBL}
cref_op1_1000_an_s0p1_r1000k ref_op1_1000_an_s0p1_r1000k 0 {C_RBL}   $ ASSUMPTION: ideal matched dummy load
XMWR_op1_1000_an_s0p1_r1000k_0 sn_op1_1000_an_s0p1_r1000k_0 wwl_op1_1000_an_s0p1_r1000k wbl_op1_1000_an_s0p1_r1000k 0 sky130_fd_pr__nfet_01v8 L=0.15 W=0.42 nf=1 ad=0.1218 as=0.1218 pd=1.42 ps=1.42 nrd=0.69047619047619  nrs=0.69047619047619 sa=0 sb=0 sd=0 mult=1 m=1
XMRD_op1_1000_an_s0p1_r1000k_0 rbl_op1_1000_an_s0p1_r1000k sn_op1_1000_an_s0p1_r1000k_0 rwls_op1_1000_an_s0p1_r1000k 0 sky130_fd_pr__nfet_01v8 L=0.15 W=0.42 nf=1 ad=0.1218 as=0.1218 pd=1.42 ps=1.42 nrd=0.69047619047619  nrs=0.69047619047619 sa=0 sb=0 sd=0 mult=1 m=1
csn_op1_1000_an_s0p1_r1000k_0 sn_op1_1000_an_s0p1_r1000k_0 0 {C_SN}
XMWR_op1_1000_an_s0p1_r1000k_1 sn_op1_1000_an_s0p1_r1000k_1 wwl_des wbl_op1_1000_an_s0p1_r1000k 0 sky130_fd_pr__nfet_01v8 L=0.15 W=0.42 nf=1 ad=0.1218 as=0.1218 pd=1.42 ps=1.42 nrd=0.69047619047619  nrs=0.69047619047619 sa=0 sb=0 sd=0 mult=1 m=1
XMRD_op1_1000_an_s0p1_r1000k_1 rbl_op1_1000_an_s0p1_r1000k sn_op1_1000_an_s0p1_r1000k_1 rwl_des 0 sky130_fd_pr__nfet_01v8 L=0.15 W=0.42 nf=1 ad=0.1218 as=0.1218 pd=1.42 ps=1.42 nrd=0.69047619047619  nrs=0.69047619047619 sa=0 sb=0 sd=0 mult=1 m=1
csn_op1_1000_an_s0p1_r1000k_1 sn_op1_1000_an_s0p1_r1000k_1 0 {C_SN}
XMWR_op1_1000_an_s0p1_r1000k_2 sn_op1_1000_an_s0p1_r1000k_2 wwl_des wbl_op1_1000_an_s0p1_r1000k 0 sky130_fd_pr__nfet_01v8 L=0.15 W=0.42 nf=1 ad=0.1218 as=0.1218 pd=1.42 ps=1.42 nrd=0.69047619047619  nrs=0.69047619047619 sa=0 sb=0 sd=0 mult=1 m=1
XMRD_op1_1000_an_s0p1_r1000k_2 rbl_op1_1000_an_s0p1_r1000k sn_op1_1000_an_s0p1_r1000k_2 rwl_des 0 sky130_fd_pr__nfet_01v8 L=0.15 W=0.42 nf=1 ad=0.1218 as=0.1218 pd=1.42 ps=1.42 nrd=0.69047619047619  nrs=0.69047619047619 sa=0 sb=0 sd=0 mult=1 m=1
csn_op1_1000_an_s0p1_r1000k_2 sn_op1_1000_an_s0p1_r1000k_2 0 {C_SN}
XMWR_op1_1000_an_s0p1_r1000k_3 sn_op1_1000_an_s0p1_r1000k_3 wwl_des wbl_op1_1000_an_s0p1_r1000k 0 sky130_fd_pr__nfet_01v8 L=0.15 W=0.42 nf=1 ad=0.1218 as=0.1218 pd=1.42 ps=1.42 nrd=0.69047619047619  nrs=0.69047619047619 sa=0 sb=0 sd=0 mult=1 m=1
XMRD_op1_1000_an_s0p1_r1000k_3 rbl_op1_1000_an_s0p1_r1000k sn_op1_1000_an_s0p1_r1000k_3 rwl_des 0 sky130_fd_pr__nfet_01v8 L=0.15 W=0.42 nf=1 ad=0.1218 as=0.1218 pd=1.42 ps=1.42 nrd=0.69047619047619  nrs=0.69047619047619 sa=0 sb=0 sd=0 mult=1 m=1
csn_op1_1000_an_s0p1_r1000k_3 sn_op1_1000_an_s0p1_r1000k_3 0 {C_SN}
XMN1_op1_1000_an_s0p1_r1000k rbl_op1_1000_an_s0p1_r1000k ref_op1_1000_an_s0p1_r1000k vn_op1_1000_an_s0p1_r1000k 0 sky130_fd_pr__nfet_01v8 L=0.15 W=1 nf=1 ad=0.29 as=0.29 pd=2.58 ps=2.58 mult=1 m=1
XMN2_op1_1000_an_s0p1_r1000k ref_op1_1000_an_s0p1_r1000k rbl_op1_1000_an_s0p1_r1000k vn_op1_1000_an_s0p1_r1000k 0 sky130_fd_pr__nfet_01v8 L=0.15 W=1 nf=1 ad=0.29 as=0.29 pd=2.58 ps=2.58 mult=1 m=1
XMP1_op1_1000_an_s0p1_r1000k rbl_op1_1000_an_s0p1_r1000k ref_op1_1000_an_s0p1_r1000k vp_op1_1000_an_s0p1_r1000k vdd sky130_fd_pr__pfet_01v8 L=0.15 W=2 nf=1 ad=0.58 as=0.58 pd=4.58 ps=4.58 mult=1 m=1
XMP2_op1_1000_an_s0p1_r1000k ref_op1_1000_an_s0p1_r1000k rbl_op1_1000_an_s0p1_r1000k vp_op1_1000_an_s0p1_r1000k vdd sky130_fd_pr__pfet_01v8 L=0.15 W=2 nf=1 ad=0.58 as=0.58 pd=4.58 ps=4.58 mult=1 m=1
XMNF_op1_1000_an_s0p1_r1000k vn_op1_1000_an_s0p1_r1000k en_op1_1000_an_s0p1_r1000k 0 0 sky130_fd_pr__nfet_01v8 L=0.15 W=2 nf=1 ad=0.58 as=0.58 pd=4.58 ps=4.58 mult=1 m=1
XMPH_op1_1000_an_s0p1_r1000k vp_op1_1000_an_s0p1_r1000k enb_op1_1000_an_s0p1_r1000k vdd vdd sky130_fd_pr__pfet_01v8 L=0.15 W=4 nf=1 ad=1.16 as=1.16 pd=8.58 ps=8.58 mult=1 m=1
bd_op1_1000_an_s0p1_r1000k d_op1_1000_an_s0p1_r1000k 0 v=v(rbl_op1_1000_an_s0p1_r1000k)-v(ref_op1_1000_an_s0p1_r1000k)

* ---- instance 83: op0_n100_an_s0p1_r1000k (variant an_s0p1_r1000k; probe dec 14.9 ns, release 37 ns, meas 39 ns) ----
vctl_op0_n100_an_s0p1_r1000k ctl_op0_n100_an_s0p1_r1000k 0 pwl(0.0000e+00 {VDD} 2.0000e-09 {VDD} 2.1000e-09 0)
* RWL driver model (EXPERIMENTAL): slew 0.1 ns, series R 1e+06 ohm; cell pin = rwls_op0_n100_an_s0p1_r1000k
vrs_op0_n100_an_s0p1_r1000k rwlsrc_op0_n100_an_s0p1_r1000k 0 pwl(0.0000e+00 {VDD} 4.0000e-09 {VDD} 4.1000e-09 0 3.7000e-08 0 3.7100e-08 {VDD})
rdrv_op0_n100_an_s0p1_r1000k rwlsrc_op0_n100_an_s0p1_r1000k rwls_op0_n100_an_s0p1_r1000k 1e+06
ven_op0_n100_an_s0p1_r1000k en_op0_n100_an_s0p1_r1000k 0 pwl(0.0000e+00 0 1.4000e-08 0 1.4100e-08 {VDD} 3.7000e-08 {VDD} 3.7100e-08 0)
venb_op0_n100_an_s0p1_r1000k enb_op0_n100_an_s0p1_r1000k 0 pwl(0.0000e+00 {VDD} 1.4000e-08 {VDD} 1.4100e-08 0 3.7000e-08 0 3.7100e-08 {VDD})
vww_op0_n100_an_s0p1_r1000k wwl_op0_n100_an_s0p1_r1000k 0 pwl(0.0000e+00 0 1.5000e-08 0 1.5100e-08 {VDD} 3.5000e-08 {VDD} 3.5100e-08 0)
vwc_op0_n100_an_s0p1_r1000k wbc_op0_n100_an_s0p1_r1000k 0 pwl(0.0000e+00 0 1.5000e-08 0 1.5100e-08 {VDD} 3.7000e-08 {VDD} 3.7100e-08 0)
swb_op0_n100_an_s0p1_r1000k ref_op0_n100_an_s0p1_r1000k wbl_op0_n100_an_s0p1_r1000k wbc_op0_n100_an_s0p1_r1000k 0 swwbl
cwbl_op0_n100_an_s0p1_r1000k wbl_op0_n100_an_s0p1_r1000k 0 {C_WBL}
spa_op0_n100_an_s0p1_r1000k prea rbl_op0_n100_an_s0p1_r1000k ctl_op0_n100_an_s0p1_r1000k 0 swpre
spr_op0_n100_an_s0p1_r1000k pref ref_op0_n100_an_s0p1_r1000k ctl_op0_n100_an_s0p1_r1000k 0 swpre
crbl_op0_n100_an_s0p1_r1000k rbl_op0_n100_an_s0p1_r1000k 0 {C_RBL}
cref_op0_n100_an_s0p1_r1000k ref_op0_n100_an_s0p1_r1000k 0 {C_RBL}   $ ASSUMPTION: ideal matched dummy load
XMWR_op0_n100_an_s0p1_r1000k_0 sn_op0_n100_an_s0p1_r1000k_0 wwl_op0_n100_an_s0p1_r1000k wbl_op0_n100_an_s0p1_r1000k 0 sky130_fd_pr__nfet_01v8 L=0.15 W=0.42 nf=1 ad=0.1218 as=0.1218 pd=1.42 ps=1.42 nrd=0.69047619047619  nrs=0.69047619047619 sa=0 sb=0 sd=0 mult=1 m=1
XMRD_op0_n100_an_s0p1_r1000k_0 rbl_op0_n100_an_s0p1_r1000k sn_op0_n100_an_s0p1_r1000k_0 rwls_op0_n100_an_s0p1_r1000k 0 sky130_fd_pr__nfet_01v8 L=0.15 W=0.42 nf=1 ad=0.1218 as=0.1218 pd=1.42 ps=1.42 nrd=0.69047619047619  nrs=0.69047619047619 sa=0 sb=0 sd=0 mult=1 m=1
csn_op0_n100_an_s0p1_r1000k_0 sn_op0_n100_an_s0p1_r1000k_0 0 {C_SN}
XMWR_op0_n100_an_s0p1_r1000k_1 sn_op0_n100_an_s0p1_r1000k_1 wwl_des wbl_op0_n100_an_s0p1_r1000k 0 sky130_fd_pr__nfet_01v8 L=0.15 W=0.42 nf=1 ad=0.1218 as=0.1218 pd=1.42 ps=1.42 nrd=0.69047619047619  nrs=0.69047619047619 sa=0 sb=0 sd=0 mult=1 m=1
XMRD_op0_n100_an_s0p1_r1000k_1 rbl_op0_n100_an_s0p1_r1000k sn_op0_n100_an_s0p1_r1000k_1 rwl_des 0 sky130_fd_pr__nfet_01v8 L=0.15 W=0.42 nf=1 ad=0.1218 as=0.1218 pd=1.42 ps=1.42 nrd=0.69047619047619  nrs=0.69047619047619 sa=0 sb=0 sd=0 mult=1 m=1
csn_op0_n100_an_s0p1_r1000k_1 sn_op0_n100_an_s0p1_r1000k_1 0 {C_SN}
XMWR_op0_n100_an_s0p1_r1000k_2 sn_op0_n100_an_s0p1_r1000k_2 wwl_des wbl_op0_n100_an_s0p1_r1000k 0 sky130_fd_pr__nfet_01v8 L=0.15 W=0.42 nf=1 ad=0.1218 as=0.1218 pd=1.42 ps=1.42 nrd=0.69047619047619  nrs=0.69047619047619 sa=0 sb=0 sd=0 mult=1 m=1
XMRD_op0_n100_an_s0p1_r1000k_2 rbl_op0_n100_an_s0p1_r1000k sn_op0_n100_an_s0p1_r1000k_2 rwl_des 0 sky130_fd_pr__nfet_01v8 L=0.15 W=0.42 nf=1 ad=0.1218 as=0.1218 pd=1.42 ps=1.42 nrd=0.69047619047619  nrs=0.69047619047619 sa=0 sb=0 sd=0 mult=1 m=1
csn_op0_n100_an_s0p1_r1000k_2 sn_op0_n100_an_s0p1_r1000k_2 0 {C_SN}
XMWR_op0_n100_an_s0p1_r1000k_3 sn_op0_n100_an_s0p1_r1000k_3 wwl_des wbl_op0_n100_an_s0p1_r1000k 0 sky130_fd_pr__nfet_01v8 L=0.15 W=0.42 nf=1 ad=0.1218 as=0.1218 pd=1.42 ps=1.42 nrd=0.69047619047619  nrs=0.69047619047619 sa=0 sb=0 sd=0 mult=1 m=1
XMRD_op0_n100_an_s0p1_r1000k_3 rbl_op0_n100_an_s0p1_r1000k sn_op0_n100_an_s0p1_r1000k_3 rwl_des 0 sky130_fd_pr__nfet_01v8 L=0.15 W=0.42 nf=1 ad=0.1218 as=0.1218 pd=1.42 ps=1.42 nrd=0.69047619047619  nrs=0.69047619047619 sa=0 sb=0 sd=0 mult=1 m=1
csn_op0_n100_an_s0p1_r1000k_3 sn_op0_n100_an_s0p1_r1000k_3 0 {C_SN}
XMN1_op0_n100_an_s0p1_r1000k rbl_op0_n100_an_s0p1_r1000k ref_op0_n100_an_s0p1_r1000k vn_op0_n100_an_s0p1_r1000k 0 sky130_fd_pr__nfet_01v8 L=0.15 W=1 nf=1 ad=0.29 as=0.29 pd=2.58 ps=2.58 mult=1 m=1
XMN2_op0_n100_an_s0p1_r1000k ref_op0_n100_an_s0p1_r1000k rbl_op0_n100_an_s0p1_r1000k vn_op0_n100_an_s0p1_r1000k 0 sky130_fd_pr__nfet_01v8 L=0.15 W=1 nf=1 ad=0.29 as=0.29 pd=2.58 ps=2.58 mult=1 m=1
XMP1_op0_n100_an_s0p1_r1000k rbl_op0_n100_an_s0p1_r1000k ref_op0_n100_an_s0p1_r1000k vp_op0_n100_an_s0p1_r1000k vdd sky130_fd_pr__pfet_01v8 L=0.15 W=2 nf=1 ad=0.58 as=0.58 pd=4.58 ps=4.58 mult=1 m=1
XMP2_op0_n100_an_s0p1_r1000k ref_op0_n100_an_s0p1_r1000k rbl_op0_n100_an_s0p1_r1000k vp_op0_n100_an_s0p1_r1000k vdd sky130_fd_pr__pfet_01v8 L=0.15 W=2 nf=1 ad=0.58 as=0.58 pd=4.58 ps=4.58 mult=1 m=1
XMNF_op0_n100_an_s0p1_r1000k vn_op0_n100_an_s0p1_r1000k en_op0_n100_an_s0p1_r1000k 0 0 sky130_fd_pr__nfet_01v8 L=0.15 W=2 nf=1 ad=0.58 as=0.58 pd=4.58 ps=4.58 mult=1 m=1
XMPH_op0_n100_an_s0p1_r1000k vp_op0_n100_an_s0p1_r1000k enb_op0_n100_an_s0p1_r1000k vdd vdd sky130_fd_pr__pfet_01v8 L=0.15 W=4 nf=1 ad=1.16 as=1.16 pd=8.58 ps=8.58 mult=1 m=1
bd_op0_n100_an_s0p1_r1000k d_op0_n100_an_s0p1_r1000k 0 v=v(rbl_op0_n100_an_s0p1_r1000k)-v(ref_op0_n100_an_s0p1_r1000k)

* ---- instance 84: op0_0000_an_s0p1_r1000k (variant an_s0p1_r1000k; probe dec 14.9 ns, release 37 ns, meas 39 ns) ----
vctl_op0_0000_an_s0p1_r1000k ctl_op0_0000_an_s0p1_r1000k 0 pwl(0.0000e+00 {VDD} 2.0000e-09 {VDD} 2.1000e-09 0)
* RWL driver model (EXPERIMENTAL): slew 0.1 ns, series R 1e+06 ohm; cell pin = rwls_op0_0000_an_s0p1_r1000k
vrs_op0_0000_an_s0p1_r1000k rwlsrc_op0_0000_an_s0p1_r1000k 0 pwl(0.0000e+00 {VDD} 4.0000e-09 {VDD} 4.1000e-09 0 3.7000e-08 0 3.7100e-08 {VDD})
rdrv_op0_0000_an_s0p1_r1000k rwlsrc_op0_0000_an_s0p1_r1000k rwls_op0_0000_an_s0p1_r1000k 1e+06
ven_op0_0000_an_s0p1_r1000k en_op0_0000_an_s0p1_r1000k 0 pwl(0.0000e+00 0 1.4000e-08 0 1.4100e-08 {VDD} 3.7000e-08 {VDD} 3.7100e-08 0)
venb_op0_0000_an_s0p1_r1000k enb_op0_0000_an_s0p1_r1000k 0 pwl(0.0000e+00 {VDD} 1.4000e-08 {VDD} 1.4100e-08 0 3.7000e-08 0 3.7100e-08 {VDD})
vww_op0_0000_an_s0p1_r1000k wwl_op0_0000_an_s0p1_r1000k 0 pwl(0.0000e+00 0 1.5000e-08 0 1.5100e-08 {VDD} 3.5000e-08 {VDD} 3.5100e-08 0)
vwc_op0_0000_an_s0p1_r1000k wbc_op0_0000_an_s0p1_r1000k 0 pwl(0.0000e+00 0 1.5000e-08 0 1.5100e-08 {VDD} 3.7000e-08 {VDD} 3.7100e-08 0)
swb_op0_0000_an_s0p1_r1000k ref_op0_0000_an_s0p1_r1000k wbl_op0_0000_an_s0p1_r1000k wbc_op0_0000_an_s0p1_r1000k 0 swwbl
cwbl_op0_0000_an_s0p1_r1000k wbl_op0_0000_an_s0p1_r1000k 0 {C_WBL}
spa_op0_0000_an_s0p1_r1000k prea rbl_op0_0000_an_s0p1_r1000k ctl_op0_0000_an_s0p1_r1000k 0 swpre
spr_op0_0000_an_s0p1_r1000k pref ref_op0_0000_an_s0p1_r1000k ctl_op0_0000_an_s0p1_r1000k 0 swpre
crbl_op0_0000_an_s0p1_r1000k rbl_op0_0000_an_s0p1_r1000k 0 {C_RBL}
cref_op0_0000_an_s0p1_r1000k ref_op0_0000_an_s0p1_r1000k 0 {C_RBL}   $ ASSUMPTION: ideal matched dummy load
XMWR_op0_0000_an_s0p1_r1000k_0 sn_op0_0000_an_s0p1_r1000k_0 wwl_op0_0000_an_s0p1_r1000k wbl_op0_0000_an_s0p1_r1000k 0 sky130_fd_pr__nfet_01v8 L=0.15 W=0.42 nf=1 ad=0.1218 as=0.1218 pd=1.42 ps=1.42 nrd=0.69047619047619  nrs=0.69047619047619 sa=0 sb=0 sd=0 mult=1 m=1
XMRD_op0_0000_an_s0p1_r1000k_0 rbl_op0_0000_an_s0p1_r1000k sn_op0_0000_an_s0p1_r1000k_0 rwls_op0_0000_an_s0p1_r1000k 0 sky130_fd_pr__nfet_01v8 L=0.15 W=0.42 nf=1 ad=0.1218 as=0.1218 pd=1.42 ps=1.42 nrd=0.69047619047619  nrs=0.69047619047619 sa=0 sb=0 sd=0 mult=1 m=1
csn_op0_0000_an_s0p1_r1000k_0 sn_op0_0000_an_s0p1_r1000k_0 0 {C_SN}
XMWR_op0_0000_an_s0p1_r1000k_1 sn_op0_0000_an_s0p1_r1000k_1 wwl_des wbl_op0_0000_an_s0p1_r1000k 0 sky130_fd_pr__nfet_01v8 L=0.15 W=0.42 nf=1 ad=0.1218 as=0.1218 pd=1.42 ps=1.42 nrd=0.69047619047619  nrs=0.69047619047619 sa=0 sb=0 sd=0 mult=1 m=1
XMRD_op0_0000_an_s0p1_r1000k_1 rbl_op0_0000_an_s0p1_r1000k sn_op0_0000_an_s0p1_r1000k_1 rwl_des 0 sky130_fd_pr__nfet_01v8 L=0.15 W=0.42 nf=1 ad=0.1218 as=0.1218 pd=1.42 ps=1.42 nrd=0.69047619047619  nrs=0.69047619047619 sa=0 sb=0 sd=0 mult=1 m=1
csn_op0_0000_an_s0p1_r1000k_1 sn_op0_0000_an_s0p1_r1000k_1 0 {C_SN}
XMWR_op0_0000_an_s0p1_r1000k_2 sn_op0_0000_an_s0p1_r1000k_2 wwl_des wbl_op0_0000_an_s0p1_r1000k 0 sky130_fd_pr__nfet_01v8 L=0.15 W=0.42 nf=1 ad=0.1218 as=0.1218 pd=1.42 ps=1.42 nrd=0.69047619047619  nrs=0.69047619047619 sa=0 sb=0 sd=0 mult=1 m=1
XMRD_op0_0000_an_s0p1_r1000k_2 rbl_op0_0000_an_s0p1_r1000k sn_op0_0000_an_s0p1_r1000k_2 rwl_des 0 sky130_fd_pr__nfet_01v8 L=0.15 W=0.42 nf=1 ad=0.1218 as=0.1218 pd=1.42 ps=1.42 nrd=0.69047619047619  nrs=0.69047619047619 sa=0 sb=0 sd=0 mult=1 m=1
csn_op0_0000_an_s0p1_r1000k_2 sn_op0_0000_an_s0p1_r1000k_2 0 {C_SN}
XMWR_op0_0000_an_s0p1_r1000k_3 sn_op0_0000_an_s0p1_r1000k_3 wwl_des wbl_op0_0000_an_s0p1_r1000k 0 sky130_fd_pr__nfet_01v8 L=0.15 W=0.42 nf=1 ad=0.1218 as=0.1218 pd=1.42 ps=1.42 nrd=0.69047619047619  nrs=0.69047619047619 sa=0 sb=0 sd=0 mult=1 m=1
XMRD_op0_0000_an_s0p1_r1000k_3 rbl_op0_0000_an_s0p1_r1000k sn_op0_0000_an_s0p1_r1000k_3 rwl_des 0 sky130_fd_pr__nfet_01v8 L=0.15 W=0.42 nf=1 ad=0.1218 as=0.1218 pd=1.42 ps=1.42 nrd=0.69047619047619  nrs=0.69047619047619 sa=0 sb=0 sd=0 mult=1 m=1
csn_op0_0000_an_s0p1_r1000k_3 sn_op0_0000_an_s0p1_r1000k_3 0 {C_SN}
XMN1_op0_0000_an_s0p1_r1000k rbl_op0_0000_an_s0p1_r1000k ref_op0_0000_an_s0p1_r1000k vn_op0_0000_an_s0p1_r1000k 0 sky130_fd_pr__nfet_01v8 L=0.15 W=1 nf=1 ad=0.29 as=0.29 pd=2.58 ps=2.58 mult=1 m=1
XMN2_op0_0000_an_s0p1_r1000k ref_op0_0000_an_s0p1_r1000k rbl_op0_0000_an_s0p1_r1000k vn_op0_0000_an_s0p1_r1000k 0 sky130_fd_pr__nfet_01v8 L=0.15 W=1 nf=1 ad=0.29 as=0.29 pd=2.58 ps=2.58 mult=1 m=1
XMP1_op0_0000_an_s0p1_r1000k rbl_op0_0000_an_s0p1_r1000k ref_op0_0000_an_s0p1_r1000k vp_op0_0000_an_s0p1_r1000k vdd sky130_fd_pr__pfet_01v8 L=0.15 W=2 nf=1 ad=0.58 as=0.58 pd=4.58 ps=4.58 mult=1 m=1
XMP2_op0_0000_an_s0p1_r1000k ref_op0_0000_an_s0p1_r1000k rbl_op0_0000_an_s0p1_r1000k vp_op0_0000_an_s0p1_r1000k vdd sky130_fd_pr__pfet_01v8 L=0.15 W=2 nf=1 ad=0.58 as=0.58 pd=4.58 ps=4.58 mult=1 m=1
XMNF_op0_0000_an_s0p1_r1000k vn_op0_0000_an_s0p1_r1000k en_op0_0000_an_s0p1_r1000k 0 0 sky130_fd_pr__nfet_01v8 L=0.15 W=2 nf=1 ad=0.58 as=0.58 pd=4.58 ps=4.58 mult=1 m=1
XMPH_op0_0000_an_s0p1_r1000k vp_op0_0000_an_s0p1_r1000k enb_op0_0000_an_s0p1_r1000k vdd vdd sky130_fd_pr__pfet_01v8 L=0.15 W=4 nf=1 ad=1.16 as=1.16 pd=8.58 ps=8.58 mult=1 m=1
bd_op0_0000_an_s0p1_r1000k d_op0_0000_an_s0p1_r1000k 0 v=v(rbl_op0_0000_an_s0p1_r1000k)-v(ref_op0_0000_an_s0p1_r1000k)

* ---- instance 85: op1_0900_an_s1_r10k (variant an_s1_r10k; probe dec 14.9 ns, release 37 ns, meas 39 ns) ----
vctl_op1_0900_an_s1_r10k ctl_op1_0900_an_s1_r10k 0 pwl(0.0000e+00 {VDD} 2.0000e-09 {VDD} 2.1000e-09 0)
* RWL driver model (EXPERIMENTAL): slew 1 ns, series R 10000 ohm; cell pin = rwls_op1_0900_an_s1_r10k
vrs_op1_0900_an_s1_r10k rwlsrc_op1_0900_an_s1_r10k 0 pwl(0.0000e+00 {VDD} 4.0000e-09 {VDD} 5.0000e-09 0 3.7000e-08 0 3.8000e-08 {VDD})
rdrv_op1_0900_an_s1_r10k rwlsrc_op1_0900_an_s1_r10k rwls_op1_0900_an_s1_r10k 10000
ven_op1_0900_an_s1_r10k en_op1_0900_an_s1_r10k 0 pwl(0.0000e+00 0 1.4000e-08 0 1.4100e-08 {VDD} 3.7000e-08 {VDD} 3.7100e-08 0)
venb_op1_0900_an_s1_r10k enb_op1_0900_an_s1_r10k 0 pwl(0.0000e+00 {VDD} 1.4000e-08 {VDD} 1.4100e-08 0 3.7000e-08 0 3.7100e-08 {VDD})
vww_op1_0900_an_s1_r10k wwl_op1_0900_an_s1_r10k 0 pwl(0.0000e+00 0 1.5000e-08 0 1.5100e-08 {VDD} 3.5000e-08 {VDD} 3.5100e-08 0)
vwc_op1_0900_an_s1_r10k wbc_op1_0900_an_s1_r10k 0 pwl(0.0000e+00 0 1.5000e-08 0 1.5100e-08 {VDD} 3.7000e-08 {VDD} 3.7100e-08 0)
swb_op1_0900_an_s1_r10k ref_op1_0900_an_s1_r10k wbl_op1_0900_an_s1_r10k wbc_op1_0900_an_s1_r10k 0 swwbl
cwbl_op1_0900_an_s1_r10k wbl_op1_0900_an_s1_r10k 0 {C_WBL}
spa_op1_0900_an_s1_r10k prea rbl_op1_0900_an_s1_r10k ctl_op1_0900_an_s1_r10k 0 swpre
spr_op1_0900_an_s1_r10k pref ref_op1_0900_an_s1_r10k ctl_op1_0900_an_s1_r10k 0 swpre
crbl_op1_0900_an_s1_r10k rbl_op1_0900_an_s1_r10k 0 {C_RBL}
cref_op1_0900_an_s1_r10k ref_op1_0900_an_s1_r10k 0 {C_RBL}   $ ASSUMPTION: ideal matched dummy load
XMWR_op1_0900_an_s1_r10k_0 sn_op1_0900_an_s1_r10k_0 wwl_op1_0900_an_s1_r10k wbl_op1_0900_an_s1_r10k 0 sky130_fd_pr__nfet_01v8 L=0.15 W=0.42 nf=1 ad=0.1218 as=0.1218 pd=1.42 ps=1.42 nrd=0.69047619047619  nrs=0.69047619047619 sa=0 sb=0 sd=0 mult=1 m=1
XMRD_op1_0900_an_s1_r10k_0 rbl_op1_0900_an_s1_r10k sn_op1_0900_an_s1_r10k_0 rwls_op1_0900_an_s1_r10k 0 sky130_fd_pr__nfet_01v8 L=0.15 W=0.42 nf=1 ad=0.1218 as=0.1218 pd=1.42 ps=1.42 nrd=0.69047619047619  nrs=0.69047619047619 sa=0 sb=0 sd=0 mult=1 m=1
csn_op1_0900_an_s1_r10k_0 sn_op1_0900_an_s1_r10k_0 0 {C_SN}
XMWR_op1_0900_an_s1_r10k_1 sn_op1_0900_an_s1_r10k_1 wwl_des wbl_op1_0900_an_s1_r10k 0 sky130_fd_pr__nfet_01v8 L=0.15 W=0.42 nf=1 ad=0.1218 as=0.1218 pd=1.42 ps=1.42 nrd=0.69047619047619  nrs=0.69047619047619 sa=0 sb=0 sd=0 mult=1 m=1
XMRD_op1_0900_an_s1_r10k_1 rbl_op1_0900_an_s1_r10k sn_op1_0900_an_s1_r10k_1 rwl_des 0 sky130_fd_pr__nfet_01v8 L=0.15 W=0.42 nf=1 ad=0.1218 as=0.1218 pd=1.42 ps=1.42 nrd=0.69047619047619  nrs=0.69047619047619 sa=0 sb=0 sd=0 mult=1 m=1
csn_op1_0900_an_s1_r10k_1 sn_op1_0900_an_s1_r10k_1 0 {C_SN}
XMWR_op1_0900_an_s1_r10k_2 sn_op1_0900_an_s1_r10k_2 wwl_des wbl_op1_0900_an_s1_r10k 0 sky130_fd_pr__nfet_01v8 L=0.15 W=0.42 nf=1 ad=0.1218 as=0.1218 pd=1.42 ps=1.42 nrd=0.69047619047619  nrs=0.69047619047619 sa=0 sb=0 sd=0 mult=1 m=1
XMRD_op1_0900_an_s1_r10k_2 rbl_op1_0900_an_s1_r10k sn_op1_0900_an_s1_r10k_2 rwl_des 0 sky130_fd_pr__nfet_01v8 L=0.15 W=0.42 nf=1 ad=0.1218 as=0.1218 pd=1.42 ps=1.42 nrd=0.69047619047619  nrs=0.69047619047619 sa=0 sb=0 sd=0 mult=1 m=1
csn_op1_0900_an_s1_r10k_2 sn_op1_0900_an_s1_r10k_2 0 {C_SN}
XMWR_op1_0900_an_s1_r10k_3 sn_op1_0900_an_s1_r10k_3 wwl_des wbl_op1_0900_an_s1_r10k 0 sky130_fd_pr__nfet_01v8 L=0.15 W=0.42 nf=1 ad=0.1218 as=0.1218 pd=1.42 ps=1.42 nrd=0.69047619047619  nrs=0.69047619047619 sa=0 sb=0 sd=0 mult=1 m=1
XMRD_op1_0900_an_s1_r10k_3 rbl_op1_0900_an_s1_r10k sn_op1_0900_an_s1_r10k_3 rwl_des 0 sky130_fd_pr__nfet_01v8 L=0.15 W=0.42 nf=1 ad=0.1218 as=0.1218 pd=1.42 ps=1.42 nrd=0.69047619047619  nrs=0.69047619047619 sa=0 sb=0 sd=0 mult=1 m=1
csn_op1_0900_an_s1_r10k_3 sn_op1_0900_an_s1_r10k_3 0 {C_SN}
XMN1_op1_0900_an_s1_r10k rbl_op1_0900_an_s1_r10k ref_op1_0900_an_s1_r10k vn_op1_0900_an_s1_r10k 0 sky130_fd_pr__nfet_01v8 L=0.15 W=1 nf=1 ad=0.29 as=0.29 pd=2.58 ps=2.58 mult=1 m=1
XMN2_op1_0900_an_s1_r10k ref_op1_0900_an_s1_r10k rbl_op1_0900_an_s1_r10k vn_op1_0900_an_s1_r10k 0 sky130_fd_pr__nfet_01v8 L=0.15 W=1 nf=1 ad=0.29 as=0.29 pd=2.58 ps=2.58 mult=1 m=1
XMP1_op1_0900_an_s1_r10k rbl_op1_0900_an_s1_r10k ref_op1_0900_an_s1_r10k vp_op1_0900_an_s1_r10k vdd sky130_fd_pr__pfet_01v8 L=0.15 W=2 nf=1 ad=0.58 as=0.58 pd=4.58 ps=4.58 mult=1 m=1
XMP2_op1_0900_an_s1_r10k ref_op1_0900_an_s1_r10k rbl_op1_0900_an_s1_r10k vp_op1_0900_an_s1_r10k vdd sky130_fd_pr__pfet_01v8 L=0.15 W=2 nf=1 ad=0.58 as=0.58 pd=4.58 ps=4.58 mult=1 m=1
XMNF_op1_0900_an_s1_r10k vn_op1_0900_an_s1_r10k en_op1_0900_an_s1_r10k 0 0 sky130_fd_pr__nfet_01v8 L=0.15 W=2 nf=1 ad=0.58 as=0.58 pd=4.58 ps=4.58 mult=1 m=1
XMPH_op1_0900_an_s1_r10k vp_op1_0900_an_s1_r10k enb_op1_0900_an_s1_r10k vdd vdd sky130_fd_pr__pfet_01v8 L=0.15 W=4 nf=1 ad=1.16 as=1.16 pd=8.58 ps=8.58 mult=1 m=1
bd_op1_0900_an_s1_r10k d_op1_0900_an_s1_r10k 0 v=v(rbl_op1_0900_an_s1_r10k)-v(ref_op1_0900_an_s1_r10k)

* ---- instance 86: op1_1000_an_s1_r10k (variant an_s1_r10k; probe dec 14.9 ns, release 37 ns, meas 39 ns) ----
vctl_op1_1000_an_s1_r10k ctl_op1_1000_an_s1_r10k 0 pwl(0.0000e+00 {VDD} 2.0000e-09 {VDD} 2.1000e-09 0)
* RWL driver model (EXPERIMENTAL): slew 1 ns, series R 10000 ohm; cell pin = rwls_op1_1000_an_s1_r10k
vrs_op1_1000_an_s1_r10k rwlsrc_op1_1000_an_s1_r10k 0 pwl(0.0000e+00 {VDD} 4.0000e-09 {VDD} 5.0000e-09 0 3.7000e-08 0 3.8000e-08 {VDD})
rdrv_op1_1000_an_s1_r10k rwlsrc_op1_1000_an_s1_r10k rwls_op1_1000_an_s1_r10k 10000
ven_op1_1000_an_s1_r10k en_op1_1000_an_s1_r10k 0 pwl(0.0000e+00 0 1.4000e-08 0 1.4100e-08 {VDD} 3.7000e-08 {VDD} 3.7100e-08 0)
venb_op1_1000_an_s1_r10k enb_op1_1000_an_s1_r10k 0 pwl(0.0000e+00 {VDD} 1.4000e-08 {VDD} 1.4100e-08 0 3.7000e-08 0 3.7100e-08 {VDD})
vww_op1_1000_an_s1_r10k wwl_op1_1000_an_s1_r10k 0 pwl(0.0000e+00 0 1.5000e-08 0 1.5100e-08 {VDD} 3.5000e-08 {VDD} 3.5100e-08 0)
vwc_op1_1000_an_s1_r10k wbc_op1_1000_an_s1_r10k 0 pwl(0.0000e+00 0 1.5000e-08 0 1.5100e-08 {VDD} 3.7000e-08 {VDD} 3.7100e-08 0)
swb_op1_1000_an_s1_r10k ref_op1_1000_an_s1_r10k wbl_op1_1000_an_s1_r10k wbc_op1_1000_an_s1_r10k 0 swwbl
cwbl_op1_1000_an_s1_r10k wbl_op1_1000_an_s1_r10k 0 {C_WBL}
spa_op1_1000_an_s1_r10k prea rbl_op1_1000_an_s1_r10k ctl_op1_1000_an_s1_r10k 0 swpre
spr_op1_1000_an_s1_r10k pref ref_op1_1000_an_s1_r10k ctl_op1_1000_an_s1_r10k 0 swpre
crbl_op1_1000_an_s1_r10k rbl_op1_1000_an_s1_r10k 0 {C_RBL}
cref_op1_1000_an_s1_r10k ref_op1_1000_an_s1_r10k 0 {C_RBL}   $ ASSUMPTION: ideal matched dummy load
XMWR_op1_1000_an_s1_r10k_0 sn_op1_1000_an_s1_r10k_0 wwl_op1_1000_an_s1_r10k wbl_op1_1000_an_s1_r10k 0 sky130_fd_pr__nfet_01v8 L=0.15 W=0.42 nf=1 ad=0.1218 as=0.1218 pd=1.42 ps=1.42 nrd=0.69047619047619  nrs=0.69047619047619 sa=0 sb=0 sd=0 mult=1 m=1
XMRD_op1_1000_an_s1_r10k_0 rbl_op1_1000_an_s1_r10k sn_op1_1000_an_s1_r10k_0 rwls_op1_1000_an_s1_r10k 0 sky130_fd_pr__nfet_01v8 L=0.15 W=0.42 nf=1 ad=0.1218 as=0.1218 pd=1.42 ps=1.42 nrd=0.69047619047619  nrs=0.69047619047619 sa=0 sb=0 sd=0 mult=1 m=1
csn_op1_1000_an_s1_r10k_0 sn_op1_1000_an_s1_r10k_0 0 {C_SN}
XMWR_op1_1000_an_s1_r10k_1 sn_op1_1000_an_s1_r10k_1 wwl_des wbl_op1_1000_an_s1_r10k 0 sky130_fd_pr__nfet_01v8 L=0.15 W=0.42 nf=1 ad=0.1218 as=0.1218 pd=1.42 ps=1.42 nrd=0.69047619047619  nrs=0.69047619047619 sa=0 sb=0 sd=0 mult=1 m=1
XMRD_op1_1000_an_s1_r10k_1 rbl_op1_1000_an_s1_r10k sn_op1_1000_an_s1_r10k_1 rwl_des 0 sky130_fd_pr__nfet_01v8 L=0.15 W=0.42 nf=1 ad=0.1218 as=0.1218 pd=1.42 ps=1.42 nrd=0.69047619047619  nrs=0.69047619047619 sa=0 sb=0 sd=0 mult=1 m=1
csn_op1_1000_an_s1_r10k_1 sn_op1_1000_an_s1_r10k_1 0 {C_SN}
XMWR_op1_1000_an_s1_r10k_2 sn_op1_1000_an_s1_r10k_2 wwl_des wbl_op1_1000_an_s1_r10k 0 sky130_fd_pr__nfet_01v8 L=0.15 W=0.42 nf=1 ad=0.1218 as=0.1218 pd=1.42 ps=1.42 nrd=0.69047619047619  nrs=0.69047619047619 sa=0 sb=0 sd=0 mult=1 m=1
XMRD_op1_1000_an_s1_r10k_2 rbl_op1_1000_an_s1_r10k sn_op1_1000_an_s1_r10k_2 rwl_des 0 sky130_fd_pr__nfet_01v8 L=0.15 W=0.42 nf=1 ad=0.1218 as=0.1218 pd=1.42 ps=1.42 nrd=0.69047619047619  nrs=0.69047619047619 sa=0 sb=0 sd=0 mult=1 m=1
csn_op1_1000_an_s1_r10k_2 sn_op1_1000_an_s1_r10k_2 0 {C_SN}
XMWR_op1_1000_an_s1_r10k_3 sn_op1_1000_an_s1_r10k_3 wwl_des wbl_op1_1000_an_s1_r10k 0 sky130_fd_pr__nfet_01v8 L=0.15 W=0.42 nf=1 ad=0.1218 as=0.1218 pd=1.42 ps=1.42 nrd=0.69047619047619  nrs=0.69047619047619 sa=0 sb=0 sd=0 mult=1 m=1
XMRD_op1_1000_an_s1_r10k_3 rbl_op1_1000_an_s1_r10k sn_op1_1000_an_s1_r10k_3 rwl_des 0 sky130_fd_pr__nfet_01v8 L=0.15 W=0.42 nf=1 ad=0.1218 as=0.1218 pd=1.42 ps=1.42 nrd=0.69047619047619  nrs=0.69047619047619 sa=0 sb=0 sd=0 mult=1 m=1
csn_op1_1000_an_s1_r10k_3 sn_op1_1000_an_s1_r10k_3 0 {C_SN}
XMN1_op1_1000_an_s1_r10k rbl_op1_1000_an_s1_r10k ref_op1_1000_an_s1_r10k vn_op1_1000_an_s1_r10k 0 sky130_fd_pr__nfet_01v8 L=0.15 W=1 nf=1 ad=0.29 as=0.29 pd=2.58 ps=2.58 mult=1 m=1
XMN2_op1_1000_an_s1_r10k ref_op1_1000_an_s1_r10k rbl_op1_1000_an_s1_r10k vn_op1_1000_an_s1_r10k 0 sky130_fd_pr__nfet_01v8 L=0.15 W=1 nf=1 ad=0.29 as=0.29 pd=2.58 ps=2.58 mult=1 m=1
XMP1_op1_1000_an_s1_r10k rbl_op1_1000_an_s1_r10k ref_op1_1000_an_s1_r10k vp_op1_1000_an_s1_r10k vdd sky130_fd_pr__pfet_01v8 L=0.15 W=2 nf=1 ad=0.58 as=0.58 pd=4.58 ps=4.58 mult=1 m=1
XMP2_op1_1000_an_s1_r10k ref_op1_1000_an_s1_r10k rbl_op1_1000_an_s1_r10k vp_op1_1000_an_s1_r10k vdd sky130_fd_pr__pfet_01v8 L=0.15 W=2 nf=1 ad=0.58 as=0.58 pd=4.58 ps=4.58 mult=1 m=1
XMNF_op1_1000_an_s1_r10k vn_op1_1000_an_s1_r10k en_op1_1000_an_s1_r10k 0 0 sky130_fd_pr__nfet_01v8 L=0.15 W=2 nf=1 ad=0.58 as=0.58 pd=4.58 ps=4.58 mult=1 m=1
XMPH_op1_1000_an_s1_r10k vp_op1_1000_an_s1_r10k enb_op1_1000_an_s1_r10k vdd vdd sky130_fd_pr__pfet_01v8 L=0.15 W=4 nf=1 ad=1.16 as=1.16 pd=8.58 ps=8.58 mult=1 m=1
bd_op1_1000_an_s1_r10k d_op1_1000_an_s1_r10k 0 v=v(rbl_op1_1000_an_s1_r10k)-v(ref_op1_1000_an_s1_r10k)

* ---- instance 87: op0_n100_an_s1_r10k (variant an_s1_r10k; probe dec 14.9 ns, release 37 ns, meas 39 ns) ----
vctl_op0_n100_an_s1_r10k ctl_op0_n100_an_s1_r10k 0 pwl(0.0000e+00 {VDD} 2.0000e-09 {VDD} 2.1000e-09 0)
* RWL driver model (EXPERIMENTAL): slew 1 ns, series R 10000 ohm; cell pin = rwls_op0_n100_an_s1_r10k
vrs_op0_n100_an_s1_r10k rwlsrc_op0_n100_an_s1_r10k 0 pwl(0.0000e+00 {VDD} 4.0000e-09 {VDD} 5.0000e-09 0 3.7000e-08 0 3.8000e-08 {VDD})
rdrv_op0_n100_an_s1_r10k rwlsrc_op0_n100_an_s1_r10k rwls_op0_n100_an_s1_r10k 10000
ven_op0_n100_an_s1_r10k en_op0_n100_an_s1_r10k 0 pwl(0.0000e+00 0 1.4000e-08 0 1.4100e-08 {VDD} 3.7000e-08 {VDD} 3.7100e-08 0)
venb_op0_n100_an_s1_r10k enb_op0_n100_an_s1_r10k 0 pwl(0.0000e+00 {VDD} 1.4000e-08 {VDD} 1.4100e-08 0 3.7000e-08 0 3.7100e-08 {VDD})
vww_op0_n100_an_s1_r10k wwl_op0_n100_an_s1_r10k 0 pwl(0.0000e+00 0 1.5000e-08 0 1.5100e-08 {VDD} 3.5000e-08 {VDD} 3.5100e-08 0)
vwc_op0_n100_an_s1_r10k wbc_op0_n100_an_s1_r10k 0 pwl(0.0000e+00 0 1.5000e-08 0 1.5100e-08 {VDD} 3.7000e-08 {VDD} 3.7100e-08 0)
swb_op0_n100_an_s1_r10k ref_op0_n100_an_s1_r10k wbl_op0_n100_an_s1_r10k wbc_op0_n100_an_s1_r10k 0 swwbl
cwbl_op0_n100_an_s1_r10k wbl_op0_n100_an_s1_r10k 0 {C_WBL}
spa_op0_n100_an_s1_r10k prea rbl_op0_n100_an_s1_r10k ctl_op0_n100_an_s1_r10k 0 swpre
spr_op0_n100_an_s1_r10k pref ref_op0_n100_an_s1_r10k ctl_op0_n100_an_s1_r10k 0 swpre
crbl_op0_n100_an_s1_r10k rbl_op0_n100_an_s1_r10k 0 {C_RBL}
cref_op0_n100_an_s1_r10k ref_op0_n100_an_s1_r10k 0 {C_RBL}   $ ASSUMPTION: ideal matched dummy load
XMWR_op0_n100_an_s1_r10k_0 sn_op0_n100_an_s1_r10k_0 wwl_op0_n100_an_s1_r10k wbl_op0_n100_an_s1_r10k 0 sky130_fd_pr__nfet_01v8 L=0.15 W=0.42 nf=1 ad=0.1218 as=0.1218 pd=1.42 ps=1.42 nrd=0.69047619047619  nrs=0.69047619047619 sa=0 sb=0 sd=0 mult=1 m=1
XMRD_op0_n100_an_s1_r10k_0 rbl_op0_n100_an_s1_r10k sn_op0_n100_an_s1_r10k_0 rwls_op0_n100_an_s1_r10k 0 sky130_fd_pr__nfet_01v8 L=0.15 W=0.42 nf=1 ad=0.1218 as=0.1218 pd=1.42 ps=1.42 nrd=0.69047619047619  nrs=0.69047619047619 sa=0 sb=0 sd=0 mult=1 m=1
csn_op0_n100_an_s1_r10k_0 sn_op0_n100_an_s1_r10k_0 0 {C_SN}
XMWR_op0_n100_an_s1_r10k_1 sn_op0_n100_an_s1_r10k_1 wwl_des wbl_op0_n100_an_s1_r10k 0 sky130_fd_pr__nfet_01v8 L=0.15 W=0.42 nf=1 ad=0.1218 as=0.1218 pd=1.42 ps=1.42 nrd=0.69047619047619  nrs=0.69047619047619 sa=0 sb=0 sd=0 mult=1 m=1
XMRD_op0_n100_an_s1_r10k_1 rbl_op0_n100_an_s1_r10k sn_op0_n100_an_s1_r10k_1 rwl_des 0 sky130_fd_pr__nfet_01v8 L=0.15 W=0.42 nf=1 ad=0.1218 as=0.1218 pd=1.42 ps=1.42 nrd=0.69047619047619  nrs=0.69047619047619 sa=0 sb=0 sd=0 mult=1 m=1
csn_op0_n100_an_s1_r10k_1 sn_op0_n100_an_s1_r10k_1 0 {C_SN}
XMWR_op0_n100_an_s1_r10k_2 sn_op0_n100_an_s1_r10k_2 wwl_des wbl_op0_n100_an_s1_r10k 0 sky130_fd_pr__nfet_01v8 L=0.15 W=0.42 nf=1 ad=0.1218 as=0.1218 pd=1.42 ps=1.42 nrd=0.69047619047619  nrs=0.69047619047619 sa=0 sb=0 sd=0 mult=1 m=1
XMRD_op0_n100_an_s1_r10k_2 rbl_op0_n100_an_s1_r10k sn_op0_n100_an_s1_r10k_2 rwl_des 0 sky130_fd_pr__nfet_01v8 L=0.15 W=0.42 nf=1 ad=0.1218 as=0.1218 pd=1.42 ps=1.42 nrd=0.69047619047619  nrs=0.69047619047619 sa=0 sb=0 sd=0 mult=1 m=1
csn_op0_n100_an_s1_r10k_2 sn_op0_n100_an_s1_r10k_2 0 {C_SN}
XMWR_op0_n100_an_s1_r10k_3 sn_op0_n100_an_s1_r10k_3 wwl_des wbl_op0_n100_an_s1_r10k 0 sky130_fd_pr__nfet_01v8 L=0.15 W=0.42 nf=1 ad=0.1218 as=0.1218 pd=1.42 ps=1.42 nrd=0.69047619047619  nrs=0.69047619047619 sa=0 sb=0 sd=0 mult=1 m=1
XMRD_op0_n100_an_s1_r10k_3 rbl_op0_n100_an_s1_r10k sn_op0_n100_an_s1_r10k_3 rwl_des 0 sky130_fd_pr__nfet_01v8 L=0.15 W=0.42 nf=1 ad=0.1218 as=0.1218 pd=1.42 ps=1.42 nrd=0.69047619047619  nrs=0.69047619047619 sa=0 sb=0 sd=0 mult=1 m=1
csn_op0_n100_an_s1_r10k_3 sn_op0_n100_an_s1_r10k_3 0 {C_SN}
XMN1_op0_n100_an_s1_r10k rbl_op0_n100_an_s1_r10k ref_op0_n100_an_s1_r10k vn_op0_n100_an_s1_r10k 0 sky130_fd_pr__nfet_01v8 L=0.15 W=1 nf=1 ad=0.29 as=0.29 pd=2.58 ps=2.58 mult=1 m=1
XMN2_op0_n100_an_s1_r10k ref_op0_n100_an_s1_r10k rbl_op0_n100_an_s1_r10k vn_op0_n100_an_s1_r10k 0 sky130_fd_pr__nfet_01v8 L=0.15 W=1 nf=1 ad=0.29 as=0.29 pd=2.58 ps=2.58 mult=1 m=1
XMP1_op0_n100_an_s1_r10k rbl_op0_n100_an_s1_r10k ref_op0_n100_an_s1_r10k vp_op0_n100_an_s1_r10k vdd sky130_fd_pr__pfet_01v8 L=0.15 W=2 nf=1 ad=0.58 as=0.58 pd=4.58 ps=4.58 mult=1 m=1
XMP2_op0_n100_an_s1_r10k ref_op0_n100_an_s1_r10k rbl_op0_n100_an_s1_r10k vp_op0_n100_an_s1_r10k vdd sky130_fd_pr__pfet_01v8 L=0.15 W=2 nf=1 ad=0.58 as=0.58 pd=4.58 ps=4.58 mult=1 m=1
XMNF_op0_n100_an_s1_r10k vn_op0_n100_an_s1_r10k en_op0_n100_an_s1_r10k 0 0 sky130_fd_pr__nfet_01v8 L=0.15 W=2 nf=1 ad=0.58 as=0.58 pd=4.58 ps=4.58 mult=1 m=1
XMPH_op0_n100_an_s1_r10k vp_op0_n100_an_s1_r10k enb_op0_n100_an_s1_r10k vdd vdd sky130_fd_pr__pfet_01v8 L=0.15 W=4 nf=1 ad=1.16 as=1.16 pd=8.58 ps=8.58 mult=1 m=1
bd_op0_n100_an_s1_r10k d_op0_n100_an_s1_r10k 0 v=v(rbl_op0_n100_an_s1_r10k)-v(ref_op0_n100_an_s1_r10k)

* ---- instance 88: op0_0000_an_s1_r10k (variant an_s1_r10k; probe dec 14.9 ns, release 37 ns, meas 39 ns) ----
vctl_op0_0000_an_s1_r10k ctl_op0_0000_an_s1_r10k 0 pwl(0.0000e+00 {VDD} 2.0000e-09 {VDD} 2.1000e-09 0)
* RWL driver model (EXPERIMENTAL): slew 1 ns, series R 10000 ohm; cell pin = rwls_op0_0000_an_s1_r10k
vrs_op0_0000_an_s1_r10k rwlsrc_op0_0000_an_s1_r10k 0 pwl(0.0000e+00 {VDD} 4.0000e-09 {VDD} 5.0000e-09 0 3.7000e-08 0 3.8000e-08 {VDD})
rdrv_op0_0000_an_s1_r10k rwlsrc_op0_0000_an_s1_r10k rwls_op0_0000_an_s1_r10k 10000
ven_op0_0000_an_s1_r10k en_op0_0000_an_s1_r10k 0 pwl(0.0000e+00 0 1.4000e-08 0 1.4100e-08 {VDD} 3.7000e-08 {VDD} 3.7100e-08 0)
venb_op0_0000_an_s1_r10k enb_op0_0000_an_s1_r10k 0 pwl(0.0000e+00 {VDD} 1.4000e-08 {VDD} 1.4100e-08 0 3.7000e-08 0 3.7100e-08 {VDD})
vww_op0_0000_an_s1_r10k wwl_op0_0000_an_s1_r10k 0 pwl(0.0000e+00 0 1.5000e-08 0 1.5100e-08 {VDD} 3.5000e-08 {VDD} 3.5100e-08 0)
vwc_op0_0000_an_s1_r10k wbc_op0_0000_an_s1_r10k 0 pwl(0.0000e+00 0 1.5000e-08 0 1.5100e-08 {VDD} 3.7000e-08 {VDD} 3.7100e-08 0)
swb_op0_0000_an_s1_r10k ref_op0_0000_an_s1_r10k wbl_op0_0000_an_s1_r10k wbc_op0_0000_an_s1_r10k 0 swwbl
cwbl_op0_0000_an_s1_r10k wbl_op0_0000_an_s1_r10k 0 {C_WBL}
spa_op0_0000_an_s1_r10k prea rbl_op0_0000_an_s1_r10k ctl_op0_0000_an_s1_r10k 0 swpre
spr_op0_0000_an_s1_r10k pref ref_op0_0000_an_s1_r10k ctl_op0_0000_an_s1_r10k 0 swpre
crbl_op0_0000_an_s1_r10k rbl_op0_0000_an_s1_r10k 0 {C_RBL}
cref_op0_0000_an_s1_r10k ref_op0_0000_an_s1_r10k 0 {C_RBL}   $ ASSUMPTION: ideal matched dummy load
XMWR_op0_0000_an_s1_r10k_0 sn_op0_0000_an_s1_r10k_0 wwl_op0_0000_an_s1_r10k wbl_op0_0000_an_s1_r10k 0 sky130_fd_pr__nfet_01v8 L=0.15 W=0.42 nf=1 ad=0.1218 as=0.1218 pd=1.42 ps=1.42 nrd=0.69047619047619  nrs=0.69047619047619 sa=0 sb=0 sd=0 mult=1 m=1
XMRD_op0_0000_an_s1_r10k_0 rbl_op0_0000_an_s1_r10k sn_op0_0000_an_s1_r10k_0 rwls_op0_0000_an_s1_r10k 0 sky130_fd_pr__nfet_01v8 L=0.15 W=0.42 nf=1 ad=0.1218 as=0.1218 pd=1.42 ps=1.42 nrd=0.69047619047619  nrs=0.69047619047619 sa=0 sb=0 sd=0 mult=1 m=1
csn_op0_0000_an_s1_r10k_0 sn_op0_0000_an_s1_r10k_0 0 {C_SN}
XMWR_op0_0000_an_s1_r10k_1 sn_op0_0000_an_s1_r10k_1 wwl_des wbl_op0_0000_an_s1_r10k 0 sky130_fd_pr__nfet_01v8 L=0.15 W=0.42 nf=1 ad=0.1218 as=0.1218 pd=1.42 ps=1.42 nrd=0.69047619047619  nrs=0.69047619047619 sa=0 sb=0 sd=0 mult=1 m=1
XMRD_op0_0000_an_s1_r10k_1 rbl_op0_0000_an_s1_r10k sn_op0_0000_an_s1_r10k_1 rwl_des 0 sky130_fd_pr__nfet_01v8 L=0.15 W=0.42 nf=1 ad=0.1218 as=0.1218 pd=1.42 ps=1.42 nrd=0.69047619047619  nrs=0.69047619047619 sa=0 sb=0 sd=0 mult=1 m=1
csn_op0_0000_an_s1_r10k_1 sn_op0_0000_an_s1_r10k_1 0 {C_SN}
XMWR_op0_0000_an_s1_r10k_2 sn_op0_0000_an_s1_r10k_2 wwl_des wbl_op0_0000_an_s1_r10k 0 sky130_fd_pr__nfet_01v8 L=0.15 W=0.42 nf=1 ad=0.1218 as=0.1218 pd=1.42 ps=1.42 nrd=0.69047619047619  nrs=0.69047619047619 sa=0 sb=0 sd=0 mult=1 m=1
XMRD_op0_0000_an_s1_r10k_2 rbl_op0_0000_an_s1_r10k sn_op0_0000_an_s1_r10k_2 rwl_des 0 sky130_fd_pr__nfet_01v8 L=0.15 W=0.42 nf=1 ad=0.1218 as=0.1218 pd=1.42 ps=1.42 nrd=0.69047619047619  nrs=0.69047619047619 sa=0 sb=0 sd=0 mult=1 m=1
csn_op0_0000_an_s1_r10k_2 sn_op0_0000_an_s1_r10k_2 0 {C_SN}
XMWR_op0_0000_an_s1_r10k_3 sn_op0_0000_an_s1_r10k_3 wwl_des wbl_op0_0000_an_s1_r10k 0 sky130_fd_pr__nfet_01v8 L=0.15 W=0.42 nf=1 ad=0.1218 as=0.1218 pd=1.42 ps=1.42 nrd=0.69047619047619  nrs=0.69047619047619 sa=0 sb=0 sd=0 mult=1 m=1
XMRD_op0_0000_an_s1_r10k_3 rbl_op0_0000_an_s1_r10k sn_op0_0000_an_s1_r10k_3 rwl_des 0 sky130_fd_pr__nfet_01v8 L=0.15 W=0.42 nf=1 ad=0.1218 as=0.1218 pd=1.42 ps=1.42 nrd=0.69047619047619  nrs=0.69047619047619 sa=0 sb=0 sd=0 mult=1 m=1
csn_op0_0000_an_s1_r10k_3 sn_op0_0000_an_s1_r10k_3 0 {C_SN}
XMN1_op0_0000_an_s1_r10k rbl_op0_0000_an_s1_r10k ref_op0_0000_an_s1_r10k vn_op0_0000_an_s1_r10k 0 sky130_fd_pr__nfet_01v8 L=0.15 W=1 nf=1 ad=0.29 as=0.29 pd=2.58 ps=2.58 mult=1 m=1
XMN2_op0_0000_an_s1_r10k ref_op0_0000_an_s1_r10k rbl_op0_0000_an_s1_r10k vn_op0_0000_an_s1_r10k 0 sky130_fd_pr__nfet_01v8 L=0.15 W=1 nf=1 ad=0.29 as=0.29 pd=2.58 ps=2.58 mult=1 m=1
XMP1_op0_0000_an_s1_r10k rbl_op0_0000_an_s1_r10k ref_op0_0000_an_s1_r10k vp_op0_0000_an_s1_r10k vdd sky130_fd_pr__pfet_01v8 L=0.15 W=2 nf=1 ad=0.58 as=0.58 pd=4.58 ps=4.58 mult=1 m=1
XMP2_op0_0000_an_s1_r10k ref_op0_0000_an_s1_r10k rbl_op0_0000_an_s1_r10k vp_op0_0000_an_s1_r10k vdd sky130_fd_pr__pfet_01v8 L=0.15 W=2 nf=1 ad=0.58 as=0.58 pd=4.58 ps=4.58 mult=1 m=1
XMNF_op0_0000_an_s1_r10k vn_op0_0000_an_s1_r10k en_op0_0000_an_s1_r10k 0 0 sky130_fd_pr__nfet_01v8 L=0.15 W=2 nf=1 ad=0.58 as=0.58 pd=4.58 ps=4.58 mult=1 m=1
XMPH_op0_0000_an_s1_r10k vp_op0_0000_an_s1_r10k enb_op0_0000_an_s1_r10k vdd vdd sky130_fd_pr__pfet_01v8 L=0.15 W=4 nf=1 ad=1.16 as=1.16 pd=8.58 ps=8.58 mult=1 m=1
bd_op0_0000_an_s1_r10k d_op0_0000_an_s1_r10k 0 v=v(rbl_op0_0000_an_s1_r10k)-v(ref_op0_0000_an_s1_r10k)

* ---- instance 89: op1_0900_an_s1_r100k (variant an_s1_r100k; probe dec 14.9 ns, release 37 ns, meas 39 ns) ----
vctl_op1_0900_an_s1_r100k ctl_op1_0900_an_s1_r100k 0 pwl(0.0000e+00 {VDD} 2.0000e-09 {VDD} 2.1000e-09 0)
* RWL driver model (EXPERIMENTAL): slew 1 ns, series R 100000 ohm; cell pin = rwls_op1_0900_an_s1_r100k
vrs_op1_0900_an_s1_r100k rwlsrc_op1_0900_an_s1_r100k 0 pwl(0.0000e+00 {VDD} 4.0000e-09 {VDD} 5.0000e-09 0 3.7000e-08 0 3.8000e-08 {VDD})
rdrv_op1_0900_an_s1_r100k rwlsrc_op1_0900_an_s1_r100k rwls_op1_0900_an_s1_r100k 100000
ven_op1_0900_an_s1_r100k en_op1_0900_an_s1_r100k 0 pwl(0.0000e+00 0 1.4000e-08 0 1.4100e-08 {VDD} 3.7000e-08 {VDD} 3.7100e-08 0)
venb_op1_0900_an_s1_r100k enb_op1_0900_an_s1_r100k 0 pwl(0.0000e+00 {VDD} 1.4000e-08 {VDD} 1.4100e-08 0 3.7000e-08 0 3.7100e-08 {VDD})
vww_op1_0900_an_s1_r100k wwl_op1_0900_an_s1_r100k 0 pwl(0.0000e+00 0 1.5000e-08 0 1.5100e-08 {VDD} 3.5000e-08 {VDD} 3.5100e-08 0)
vwc_op1_0900_an_s1_r100k wbc_op1_0900_an_s1_r100k 0 pwl(0.0000e+00 0 1.5000e-08 0 1.5100e-08 {VDD} 3.7000e-08 {VDD} 3.7100e-08 0)
swb_op1_0900_an_s1_r100k ref_op1_0900_an_s1_r100k wbl_op1_0900_an_s1_r100k wbc_op1_0900_an_s1_r100k 0 swwbl
cwbl_op1_0900_an_s1_r100k wbl_op1_0900_an_s1_r100k 0 {C_WBL}
spa_op1_0900_an_s1_r100k prea rbl_op1_0900_an_s1_r100k ctl_op1_0900_an_s1_r100k 0 swpre
spr_op1_0900_an_s1_r100k pref ref_op1_0900_an_s1_r100k ctl_op1_0900_an_s1_r100k 0 swpre
crbl_op1_0900_an_s1_r100k rbl_op1_0900_an_s1_r100k 0 {C_RBL}
cref_op1_0900_an_s1_r100k ref_op1_0900_an_s1_r100k 0 {C_RBL}   $ ASSUMPTION: ideal matched dummy load
XMWR_op1_0900_an_s1_r100k_0 sn_op1_0900_an_s1_r100k_0 wwl_op1_0900_an_s1_r100k wbl_op1_0900_an_s1_r100k 0 sky130_fd_pr__nfet_01v8 L=0.15 W=0.42 nf=1 ad=0.1218 as=0.1218 pd=1.42 ps=1.42 nrd=0.69047619047619  nrs=0.69047619047619 sa=0 sb=0 sd=0 mult=1 m=1
XMRD_op1_0900_an_s1_r100k_0 rbl_op1_0900_an_s1_r100k sn_op1_0900_an_s1_r100k_0 rwls_op1_0900_an_s1_r100k 0 sky130_fd_pr__nfet_01v8 L=0.15 W=0.42 nf=1 ad=0.1218 as=0.1218 pd=1.42 ps=1.42 nrd=0.69047619047619  nrs=0.69047619047619 sa=0 sb=0 sd=0 mult=1 m=1
csn_op1_0900_an_s1_r100k_0 sn_op1_0900_an_s1_r100k_0 0 {C_SN}
XMWR_op1_0900_an_s1_r100k_1 sn_op1_0900_an_s1_r100k_1 wwl_des wbl_op1_0900_an_s1_r100k 0 sky130_fd_pr__nfet_01v8 L=0.15 W=0.42 nf=1 ad=0.1218 as=0.1218 pd=1.42 ps=1.42 nrd=0.69047619047619  nrs=0.69047619047619 sa=0 sb=0 sd=0 mult=1 m=1
XMRD_op1_0900_an_s1_r100k_1 rbl_op1_0900_an_s1_r100k sn_op1_0900_an_s1_r100k_1 rwl_des 0 sky130_fd_pr__nfet_01v8 L=0.15 W=0.42 nf=1 ad=0.1218 as=0.1218 pd=1.42 ps=1.42 nrd=0.69047619047619  nrs=0.69047619047619 sa=0 sb=0 sd=0 mult=1 m=1
csn_op1_0900_an_s1_r100k_1 sn_op1_0900_an_s1_r100k_1 0 {C_SN}
XMWR_op1_0900_an_s1_r100k_2 sn_op1_0900_an_s1_r100k_2 wwl_des wbl_op1_0900_an_s1_r100k 0 sky130_fd_pr__nfet_01v8 L=0.15 W=0.42 nf=1 ad=0.1218 as=0.1218 pd=1.42 ps=1.42 nrd=0.69047619047619  nrs=0.69047619047619 sa=0 sb=0 sd=0 mult=1 m=1
XMRD_op1_0900_an_s1_r100k_2 rbl_op1_0900_an_s1_r100k sn_op1_0900_an_s1_r100k_2 rwl_des 0 sky130_fd_pr__nfet_01v8 L=0.15 W=0.42 nf=1 ad=0.1218 as=0.1218 pd=1.42 ps=1.42 nrd=0.69047619047619  nrs=0.69047619047619 sa=0 sb=0 sd=0 mult=1 m=1
csn_op1_0900_an_s1_r100k_2 sn_op1_0900_an_s1_r100k_2 0 {C_SN}
XMWR_op1_0900_an_s1_r100k_3 sn_op1_0900_an_s1_r100k_3 wwl_des wbl_op1_0900_an_s1_r100k 0 sky130_fd_pr__nfet_01v8 L=0.15 W=0.42 nf=1 ad=0.1218 as=0.1218 pd=1.42 ps=1.42 nrd=0.69047619047619  nrs=0.69047619047619 sa=0 sb=0 sd=0 mult=1 m=1
XMRD_op1_0900_an_s1_r100k_3 rbl_op1_0900_an_s1_r100k sn_op1_0900_an_s1_r100k_3 rwl_des 0 sky130_fd_pr__nfet_01v8 L=0.15 W=0.42 nf=1 ad=0.1218 as=0.1218 pd=1.42 ps=1.42 nrd=0.69047619047619  nrs=0.69047619047619 sa=0 sb=0 sd=0 mult=1 m=1
csn_op1_0900_an_s1_r100k_3 sn_op1_0900_an_s1_r100k_3 0 {C_SN}
XMN1_op1_0900_an_s1_r100k rbl_op1_0900_an_s1_r100k ref_op1_0900_an_s1_r100k vn_op1_0900_an_s1_r100k 0 sky130_fd_pr__nfet_01v8 L=0.15 W=1 nf=1 ad=0.29 as=0.29 pd=2.58 ps=2.58 mult=1 m=1
XMN2_op1_0900_an_s1_r100k ref_op1_0900_an_s1_r100k rbl_op1_0900_an_s1_r100k vn_op1_0900_an_s1_r100k 0 sky130_fd_pr__nfet_01v8 L=0.15 W=1 nf=1 ad=0.29 as=0.29 pd=2.58 ps=2.58 mult=1 m=1
XMP1_op1_0900_an_s1_r100k rbl_op1_0900_an_s1_r100k ref_op1_0900_an_s1_r100k vp_op1_0900_an_s1_r100k vdd sky130_fd_pr__pfet_01v8 L=0.15 W=2 nf=1 ad=0.58 as=0.58 pd=4.58 ps=4.58 mult=1 m=1
XMP2_op1_0900_an_s1_r100k ref_op1_0900_an_s1_r100k rbl_op1_0900_an_s1_r100k vp_op1_0900_an_s1_r100k vdd sky130_fd_pr__pfet_01v8 L=0.15 W=2 nf=1 ad=0.58 as=0.58 pd=4.58 ps=4.58 mult=1 m=1
XMNF_op1_0900_an_s1_r100k vn_op1_0900_an_s1_r100k en_op1_0900_an_s1_r100k 0 0 sky130_fd_pr__nfet_01v8 L=0.15 W=2 nf=1 ad=0.58 as=0.58 pd=4.58 ps=4.58 mult=1 m=1
XMPH_op1_0900_an_s1_r100k vp_op1_0900_an_s1_r100k enb_op1_0900_an_s1_r100k vdd vdd sky130_fd_pr__pfet_01v8 L=0.15 W=4 nf=1 ad=1.16 as=1.16 pd=8.58 ps=8.58 mult=1 m=1
bd_op1_0900_an_s1_r100k d_op1_0900_an_s1_r100k 0 v=v(rbl_op1_0900_an_s1_r100k)-v(ref_op1_0900_an_s1_r100k)

* ---- instance 90: op1_1000_an_s1_r100k (variant an_s1_r100k; probe dec 14.9 ns, release 37 ns, meas 39 ns) ----
vctl_op1_1000_an_s1_r100k ctl_op1_1000_an_s1_r100k 0 pwl(0.0000e+00 {VDD} 2.0000e-09 {VDD} 2.1000e-09 0)
* RWL driver model (EXPERIMENTAL): slew 1 ns, series R 100000 ohm; cell pin = rwls_op1_1000_an_s1_r100k
vrs_op1_1000_an_s1_r100k rwlsrc_op1_1000_an_s1_r100k 0 pwl(0.0000e+00 {VDD} 4.0000e-09 {VDD} 5.0000e-09 0 3.7000e-08 0 3.8000e-08 {VDD})
rdrv_op1_1000_an_s1_r100k rwlsrc_op1_1000_an_s1_r100k rwls_op1_1000_an_s1_r100k 100000
ven_op1_1000_an_s1_r100k en_op1_1000_an_s1_r100k 0 pwl(0.0000e+00 0 1.4000e-08 0 1.4100e-08 {VDD} 3.7000e-08 {VDD} 3.7100e-08 0)
venb_op1_1000_an_s1_r100k enb_op1_1000_an_s1_r100k 0 pwl(0.0000e+00 {VDD} 1.4000e-08 {VDD} 1.4100e-08 0 3.7000e-08 0 3.7100e-08 {VDD})
vww_op1_1000_an_s1_r100k wwl_op1_1000_an_s1_r100k 0 pwl(0.0000e+00 0 1.5000e-08 0 1.5100e-08 {VDD} 3.5000e-08 {VDD} 3.5100e-08 0)
vwc_op1_1000_an_s1_r100k wbc_op1_1000_an_s1_r100k 0 pwl(0.0000e+00 0 1.5000e-08 0 1.5100e-08 {VDD} 3.7000e-08 {VDD} 3.7100e-08 0)
swb_op1_1000_an_s1_r100k ref_op1_1000_an_s1_r100k wbl_op1_1000_an_s1_r100k wbc_op1_1000_an_s1_r100k 0 swwbl
cwbl_op1_1000_an_s1_r100k wbl_op1_1000_an_s1_r100k 0 {C_WBL}
spa_op1_1000_an_s1_r100k prea rbl_op1_1000_an_s1_r100k ctl_op1_1000_an_s1_r100k 0 swpre
spr_op1_1000_an_s1_r100k pref ref_op1_1000_an_s1_r100k ctl_op1_1000_an_s1_r100k 0 swpre
crbl_op1_1000_an_s1_r100k rbl_op1_1000_an_s1_r100k 0 {C_RBL}
cref_op1_1000_an_s1_r100k ref_op1_1000_an_s1_r100k 0 {C_RBL}   $ ASSUMPTION: ideal matched dummy load
XMWR_op1_1000_an_s1_r100k_0 sn_op1_1000_an_s1_r100k_0 wwl_op1_1000_an_s1_r100k wbl_op1_1000_an_s1_r100k 0 sky130_fd_pr__nfet_01v8 L=0.15 W=0.42 nf=1 ad=0.1218 as=0.1218 pd=1.42 ps=1.42 nrd=0.69047619047619  nrs=0.69047619047619 sa=0 sb=0 sd=0 mult=1 m=1
XMRD_op1_1000_an_s1_r100k_0 rbl_op1_1000_an_s1_r100k sn_op1_1000_an_s1_r100k_0 rwls_op1_1000_an_s1_r100k 0 sky130_fd_pr__nfet_01v8 L=0.15 W=0.42 nf=1 ad=0.1218 as=0.1218 pd=1.42 ps=1.42 nrd=0.69047619047619  nrs=0.69047619047619 sa=0 sb=0 sd=0 mult=1 m=1
csn_op1_1000_an_s1_r100k_0 sn_op1_1000_an_s1_r100k_0 0 {C_SN}
XMWR_op1_1000_an_s1_r100k_1 sn_op1_1000_an_s1_r100k_1 wwl_des wbl_op1_1000_an_s1_r100k 0 sky130_fd_pr__nfet_01v8 L=0.15 W=0.42 nf=1 ad=0.1218 as=0.1218 pd=1.42 ps=1.42 nrd=0.69047619047619  nrs=0.69047619047619 sa=0 sb=0 sd=0 mult=1 m=1
XMRD_op1_1000_an_s1_r100k_1 rbl_op1_1000_an_s1_r100k sn_op1_1000_an_s1_r100k_1 rwl_des 0 sky130_fd_pr__nfet_01v8 L=0.15 W=0.42 nf=1 ad=0.1218 as=0.1218 pd=1.42 ps=1.42 nrd=0.69047619047619  nrs=0.69047619047619 sa=0 sb=0 sd=0 mult=1 m=1
csn_op1_1000_an_s1_r100k_1 sn_op1_1000_an_s1_r100k_1 0 {C_SN}
XMWR_op1_1000_an_s1_r100k_2 sn_op1_1000_an_s1_r100k_2 wwl_des wbl_op1_1000_an_s1_r100k 0 sky130_fd_pr__nfet_01v8 L=0.15 W=0.42 nf=1 ad=0.1218 as=0.1218 pd=1.42 ps=1.42 nrd=0.69047619047619  nrs=0.69047619047619 sa=0 sb=0 sd=0 mult=1 m=1
XMRD_op1_1000_an_s1_r100k_2 rbl_op1_1000_an_s1_r100k sn_op1_1000_an_s1_r100k_2 rwl_des 0 sky130_fd_pr__nfet_01v8 L=0.15 W=0.42 nf=1 ad=0.1218 as=0.1218 pd=1.42 ps=1.42 nrd=0.69047619047619  nrs=0.69047619047619 sa=0 sb=0 sd=0 mult=1 m=1
csn_op1_1000_an_s1_r100k_2 sn_op1_1000_an_s1_r100k_2 0 {C_SN}
XMWR_op1_1000_an_s1_r100k_3 sn_op1_1000_an_s1_r100k_3 wwl_des wbl_op1_1000_an_s1_r100k 0 sky130_fd_pr__nfet_01v8 L=0.15 W=0.42 nf=1 ad=0.1218 as=0.1218 pd=1.42 ps=1.42 nrd=0.69047619047619  nrs=0.69047619047619 sa=0 sb=0 sd=0 mult=1 m=1
XMRD_op1_1000_an_s1_r100k_3 rbl_op1_1000_an_s1_r100k sn_op1_1000_an_s1_r100k_3 rwl_des 0 sky130_fd_pr__nfet_01v8 L=0.15 W=0.42 nf=1 ad=0.1218 as=0.1218 pd=1.42 ps=1.42 nrd=0.69047619047619  nrs=0.69047619047619 sa=0 sb=0 sd=0 mult=1 m=1
csn_op1_1000_an_s1_r100k_3 sn_op1_1000_an_s1_r100k_3 0 {C_SN}
XMN1_op1_1000_an_s1_r100k rbl_op1_1000_an_s1_r100k ref_op1_1000_an_s1_r100k vn_op1_1000_an_s1_r100k 0 sky130_fd_pr__nfet_01v8 L=0.15 W=1 nf=1 ad=0.29 as=0.29 pd=2.58 ps=2.58 mult=1 m=1
XMN2_op1_1000_an_s1_r100k ref_op1_1000_an_s1_r100k rbl_op1_1000_an_s1_r100k vn_op1_1000_an_s1_r100k 0 sky130_fd_pr__nfet_01v8 L=0.15 W=1 nf=1 ad=0.29 as=0.29 pd=2.58 ps=2.58 mult=1 m=1
XMP1_op1_1000_an_s1_r100k rbl_op1_1000_an_s1_r100k ref_op1_1000_an_s1_r100k vp_op1_1000_an_s1_r100k vdd sky130_fd_pr__pfet_01v8 L=0.15 W=2 nf=1 ad=0.58 as=0.58 pd=4.58 ps=4.58 mult=1 m=1
XMP2_op1_1000_an_s1_r100k ref_op1_1000_an_s1_r100k rbl_op1_1000_an_s1_r100k vp_op1_1000_an_s1_r100k vdd sky130_fd_pr__pfet_01v8 L=0.15 W=2 nf=1 ad=0.58 as=0.58 pd=4.58 ps=4.58 mult=1 m=1
XMNF_op1_1000_an_s1_r100k vn_op1_1000_an_s1_r100k en_op1_1000_an_s1_r100k 0 0 sky130_fd_pr__nfet_01v8 L=0.15 W=2 nf=1 ad=0.58 as=0.58 pd=4.58 ps=4.58 mult=1 m=1
XMPH_op1_1000_an_s1_r100k vp_op1_1000_an_s1_r100k enb_op1_1000_an_s1_r100k vdd vdd sky130_fd_pr__pfet_01v8 L=0.15 W=4 nf=1 ad=1.16 as=1.16 pd=8.58 ps=8.58 mult=1 m=1
bd_op1_1000_an_s1_r100k d_op1_1000_an_s1_r100k 0 v=v(rbl_op1_1000_an_s1_r100k)-v(ref_op1_1000_an_s1_r100k)

* ---- instance 91: op0_n100_an_s1_r100k (variant an_s1_r100k; probe dec 14.9 ns, release 37 ns, meas 39 ns) ----
vctl_op0_n100_an_s1_r100k ctl_op0_n100_an_s1_r100k 0 pwl(0.0000e+00 {VDD} 2.0000e-09 {VDD} 2.1000e-09 0)
* RWL driver model (EXPERIMENTAL): slew 1 ns, series R 100000 ohm; cell pin = rwls_op0_n100_an_s1_r100k
vrs_op0_n100_an_s1_r100k rwlsrc_op0_n100_an_s1_r100k 0 pwl(0.0000e+00 {VDD} 4.0000e-09 {VDD} 5.0000e-09 0 3.7000e-08 0 3.8000e-08 {VDD})
rdrv_op0_n100_an_s1_r100k rwlsrc_op0_n100_an_s1_r100k rwls_op0_n100_an_s1_r100k 100000
ven_op0_n100_an_s1_r100k en_op0_n100_an_s1_r100k 0 pwl(0.0000e+00 0 1.4000e-08 0 1.4100e-08 {VDD} 3.7000e-08 {VDD} 3.7100e-08 0)
venb_op0_n100_an_s1_r100k enb_op0_n100_an_s1_r100k 0 pwl(0.0000e+00 {VDD} 1.4000e-08 {VDD} 1.4100e-08 0 3.7000e-08 0 3.7100e-08 {VDD})
vww_op0_n100_an_s1_r100k wwl_op0_n100_an_s1_r100k 0 pwl(0.0000e+00 0 1.5000e-08 0 1.5100e-08 {VDD} 3.5000e-08 {VDD} 3.5100e-08 0)
vwc_op0_n100_an_s1_r100k wbc_op0_n100_an_s1_r100k 0 pwl(0.0000e+00 0 1.5000e-08 0 1.5100e-08 {VDD} 3.7000e-08 {VDD} 3.7100e-08 0)
swb_op0_n100_an_s1_r100k ref_op0_n100_an_s1_r100k wbl_op0_n100_an_s1_r100k wbc_op0_n100_an_s1_r100k 0 swwbl
cwbl_op0_n100_an_s1_r100k wbl_op0_n100_an_s1_r100k 0 {C_WBL}
spa_op0_n100_an_s1_r100k prea rbl_op0_n100_an_s1_r100k ctl_op0_n100_an_s1_r100k 0 swpre
spr_op0_n100_an_s1_r100k pref ref_op0_n100_an_s1_r100k ctl_op0_n100_an_s1_r100k 0 swpre
crbl_op0_n100_an_s1_r100k rbl_op0_n100_an_s1_r100k 0 {C_RBL}
cref_op0_n100_an_s1_r100k ref_op0_n100_an_s1_r100k 0 {C_RBL}   $ ASSUMPTION: ideal matched dummy load
XMWR_op0_n100_an_s1_r100k_0 sn_op0_n100_an_s1_r100k_0 wwl_op0_n100_an_s1_r100k wbl_op0_n100_an_s1_r100k 0 sky130_fd_pr__nfet_01v8 L=0.15 W=0.42 nf=1 ad=0.1218 as=0.1218 pd=1.42 ps=1.42 nrd=0.69047619047619  nrs=0.69047619047619 sa=0 sb=0 sd=0 mult=1 m=1
XMRD_op0_n100_an_s1_r100k_0 rbl_op0_n100_an_s1_r100k sn_op0_n100_an_s1_r100k_0 rwls_op0_n100_an_s1_r100k 0 sky130_fd_pr__nfet_01v8 L=0.15 W=0.42 nf=1 ad=0.1218 as=0.1218 pd=1.42 ps=1.42 nrd=0.69047619047619  nrs=0.69047619047619 sa=0 sb=0 sd=0 mult=1 m=1
csn_op0_n100_an_s1_r100k_0 sn_op0_n100_an_s1_r100k_0 0 {C_SN}
XMWR_op0_n100_an_s1_r100k_1 sn_op0_n100_an_s1_r100k_1 wwl_des wbl_op0_n100_an_s1_r100k 0 sky130_fd_pr__nfet_01v8 L=0.15 W=0.42 nf=1 ad=0.1218 as=0.1218 pd=1.42 ps=1.42 nrd=0.69047619047619  nrs=0.69047619047619 sa=0 sb=0 sd=0 mult=1 m=1
XMRD_op0_n100_an_s1_r100k_1 rbl_op0_n100_an_s1_r100k sn_op0_n100_an_s1_r100k_1 rwl_des 0 sky130_fd_pr__nfet_01v8 L=0.15 W=0.42 nf=1 ad=0.1218 as=0.1218 pd=1.42 ps=1.42 nrd=0.69047619047619  nrs=0.69047619047619 sa=0 sb=0 sd=0 mult=1 m=1
csn_op0_n100_an_s1_r100k_1 sn_op0_n100_an_s1_r100k_1 0 {C_SN}
XMWR_op0_n100_an_s1_r100k_2 sn_op0_n100_an_s1_r100k_2 wwl_des wbl_op0_n100_an_s1_r100k 0 sky130_fd_pr__nfet_01v8 L=0.15 W=0.42 nf=1 ad=0.1218 as=0.1218 pd=1.42 ps=1.42 nrd=0.69047619047619  nrs=0.69047619047619 sa=0 sb=0 sd=0 mult=1 m=1
XMRD_op0_n100_an_s1_r100k_2 rbl_op0_n100_an_s1_r100k sn_op0_n100_an_s1_r100k_2 rwl_des 0 sky130_fd_pr__nfet_01v8 L=0.15 W=0.42 nf=1 ad=0.1218 as=0.1218 pd=1.42 ps=1.42 nrd=0.69047619047619  nrs=0.69047619047619 sa=0 sb=0 sd=0 mult=1 m=1
csn_op0_n100_an_s1_r100k_2 sn_op0_n100_an_s1_r100k_2 0 {C_SN}
XMWR_op0_n100_an_s1_r100k_3 sn_op0_n100_an_s1_r100k_3 wwl_des wbl_op0_n100_an_s1_r100k 0 sky130_fd_pr__nfet_01v8 L=0.15 W=0.42 nf=1 ad=0.1218 as=0.1218 pd=1.42 ps=1.42 nrd=0.69047619047619  nrs=0.69047619047619 sa=0 sb=0 sd=0 mult=1 m=1
XMRD_op0_n100_an_s1_r100k_3 rbl_op0_n100_an_s1_r100k sn_op0_n100_an_s1_r100k_3 rwl_des 0 sky130_fd_pr__nfet_01v8 L=0.15 W=0.42 nf=1 ad=0.1218 as=0.1218 pd=1.42 ps=1.42 nrd=0.69047619047619  nrs=0.69047619047619 sa=0 sb=0 sd=0 mult=1 m=1
csn_op0_n100_an_s1_r100k_3 sn_op0_n100_an_s1_r100k_3 0 {C_SN}
XMN1_op0_n100_an_s1_r100k rbl_op0_n100_an_s1_r100k ref_op0_n100_an_s1_r100k vn_op0_n100_an_s1_r100k 0 sky130_fd_pr__nfet_01v8 L=0.15 W=1 nf=1 ad=0.29 as=0.29 pd=2.58 ps=2.58 mult=1 m=1
XMN2_op0_n100_an_s1_r100k ref_op0_n100_an_s1_r100k rbl_op0_n100_an_s1_r100k vn_op0_n100_an_s1_r100k 0 sky130_fd_pr__nfet_01v8 L=0.15 W=1 nf=1 ad=0.29 as=0.29 pd=2.58 ps=2.58 mult=1 m=1
XMP1_op0_n100_an_s1_r100k rbl_op0_n100_an_s1_r100k ref_op0_n100_an_s1_r100k vp_op0_n100_an_s1_r100k vdd sky130_fd_pr__pfet_01v8 L=0.15 W=2 nf=1 ad=0.58 as=0.58 pd=4.58 ps=4.58 mult=1 m=1
XMP2_op0_n100_an_s1_r100k ref_op0_n100_an_s1_r100k rbl_op0_n100_an_s1_r100k vp_op0_n100_an_s1_r100k vdd sky130_fd_pr__pfet_01v8 L=0.15 W=2 nf=1 ad=0.58 as=0.58 pd=4.58 ps=4.58 mult=1 m=1
XMNF_op0_n100_an_s1_r100k vn_op0_n100_an_s1_r100k en_op0_n100_an_s1_r100k 0 0 sky130_fd_pr__nfet_01v8 L=0.15 W=2 nf=1 ad=0.58 as=0.58 pd=4.58 ps=4.58 mult=1 m=1
XMPH_op0_n100_an_s1_r100k vp_op0_n100_an_s1_r100k enb_op0_n100_an_s1_r100k vdd vdd sky130_fd_pr__pfet_01v8 L=0.15 W=4 nf=1 ad=1.16 as=1.16 pd=8.58 ps=8.58 mult=1 m=1
bd_op0_n100_an_s1_r100k d_op0_n100_an_s1_r100k 0 v=v(rbl_op0_n100_an_s1_r100k)-v(ref_op0_n100_an_s1_r100k)

* ---- instance 92: op0_0000_an_s1_r100k (variant an_s1_r100k; probe dec 14.9 ns, release 37 ns, meas 39 ns) ----
vctl_op0_0000_an_s1_r100k ctl_op0_0000_an_s1_r100k 0 pwl(0.0000e+00 {VDD} 2.0000e-09 {VDD} 2.1000e-09 0)
* RWL driver model (EXPERIMENTAL): slew 1 ns, series R 100000 ohm; cell pin = rwls_op0_0000_an_s1_r100k
vrs_op0_0000_an_s1_r100k rwlsrc_op0_0000_an_s1_r100k 0 pwl(0.0000e+00 {VDD} 4.0000e-09 {VDD} 5.0000e-09 0 3.7000e-08 0 3.8000e-08 {VDD})
rdrv_op0_0000_an_s1_r100k rwlsrc_op0_0000_an_s1_r100k rwls_op0_0000_an_s1_r100k 100000
ven_op0_0000_an_s1_r100k en_op0_0000_an_s1_r100k 0 pwl(0.0000e+00 0 1.4000e-08 0 1.4100e-08 {VDD} 3.7000e-08 {VDD} 3.7100e-08 0)
venb_op0_0000_an_s1_r100k enb_op0_0000_an_s1_r100k 0 pwl(0.0000e+00 {VDD} 1.4000e-08 {VDD} 1.4100e-08 0 3.7000e-08 0 3.7100e-08 {VDD})
vww_op0_0000_an_s1_r100k wwl_op0_0000_an_s1_r100k 0 pwl(0.0000e+00 0 1.5000e-08 0 1.5100e-08 {VDD} 3.5000e-08 {VDD} 3.5100e-08 0)
vwc_op0_0000_an_s1_r100k wbc_op0_0000_an_s1_r100k 0 pwl(0.0000e+00 0 1.5000e-08 0 1.5100e-08 {VDD} 3.7000e-08 {VDD} 3.7100e-08 0)
swb_op0_0000_an_s1_r100k ref_op0_0000_an_s1_r100k wbl_op0_0000_an_s1_r100k wbc_op0_0000_an_s1_r100k 0 swwbl
cwbl_op0_0000_an_s1_r100k wbl_op0_0000_an_s1_r100k 0 {C_WBL}
spa_op0_0000_an_s1_r100k prea rbl_op0_0000_an_s1_r100k ctl_op0_0000_an_s1_r100k 0 swpre
spr_op0_0000_an_s1_r100k pref ref_op0_0000_an_s1_r100k ctl_op0_0000_an_s1_r100k 0 swpre
crbl_op0_0000_an_s1_r100k rbl_op0_0000_an_s1_r100k 0 {C_RBL}
cref_op0_0000_an_s1_r100k ref_op0_0000_an_s1_r100k 0 {C_RBL}   $ ASSUMPTION: ideal matched dummy load
XMWR_op0_0000_an_s1_r100k_0 sn_op0_0000_an_s1_r100k_0 wwl_op0_0000_an_s1_r100k wbl_op0_0000_an_s1_r100k 0 sky130_fd_pr__nfet_01v8 L=0.15 W=0.42 nf=1 ad=0.1218 as=0.1218 pd=1.42 ps=1.42 nrd=0.69047619047619  nrs=0.69047619047619 sa=0 sb=0 sd=0 mult=1 m=1
XMRD_op0_0000_an_s1_r100k_0 rbl_op0_0000_an_s1_r100k sn_op0_0000_an_s1_r100k_0 rwls_op0_0000_an_s1_r100k 0 sky130_fd_pr__nfet_01v8 L=0.15 W=0.42 nf=1 ad=0.1218 as=0.1218 pd=1.42 ps=1.42 nrd=0.69047619047619  nrs=0.69047619047619 sa=0 sb=0 sd=0 mult=1 m=1
csn_op0_0000_an_s1_r100k_0 sn_op0_0000_an_s1_r100k_0 0 {C_SN}
XMWR_op0_0000_an_s1_r100k_1 sn_op0_0000_an_s1_r100k_1 wwl_des wbl_op0_0000_an_s1_r100k 0 sky130_fd_pr__nfet_01v8 L=0.15 W=0.42 nf=1 ad=0.1218 as=0.1218 pd=1.42 ps=1.42 nrd=0.69047619047619  nrs=0.69047619047619 sa=0 sb=0 sd=0 mult=1 m=1
XMRD_op0_0000_an_s1_r100k_1 rbl_op0_0000_an_s1_r100k sn_op0_0000_an_s1_r100k_1 rwl_des 0 sky130_fd_pr__nfet_01v8 L=0.15 W=0.42 nf=1 ad=0.1218 as=0.1218 pd=1.42 ps=1.42 nrd=0.69047619047619  nrs=0.69047619047619 sa=0 sb=0 sd=0 mult=1 m=1
csn_op0_0000_an_s1_r100k_1 sn_op0_0000_an_s1_r100k_1 0 {C_SN}
XMWR_op0_0000_an_s1_r100k_2 sn_op0_0000_an_s1_r100k_2 wwl_des wbl_op0_0000_an_s1_r100k 0 sky130_fd_pr__nfet_01v8 L=0.15 W=0.42 nf=1 ad=0.1218 as=0.1218 pd=1.42 ps=1.42 nrd=0.69047619047619  nrs=0.69047619047619 sa=0 sb=0 sd=0 mult=1 m=1
XMRD_op0_0000_an_s1_r100k_2 rbl_op0_0000_an_s1_r100k sn_op0_0000_an_s1_r100k_2 rwl_des 0 sky130_fd_pr__nfet_01v8 L=0.15 W=0.42 nf=1 ad=0.1218 as=0.1218 pd=1.42 ps=1.42 nrd=0.69047619047619  nrs=0.69047619047619 sa=0 sb=0 sd=0 mult=1 m=1
csn_op0_0000_an_s1_r100k_2 sn_op0_0000_an_s1_r100k_2 0 {C_SN}
XMWR_op0_0000_an_s1_r100k_3 sn_op0_0000_an_s1_r100k_3 wwl_des wbl_op0_0000_an_s1_r100k 0 sky130_fd_pr__nfet_01v8 L=0.15 W=0.42 nf=1 ad=0.1218 as=0.1218 pd=1.42 ps=1.42 nrd=0.69047619047619  nrs=0.69047619047619 sa=0 sb=0 sd=0 mult=1 m=1
XMRD_op0_0000_an_s1_r100k_3 rbl_op0_0000_an_s1_r100k sn_op0_0000_an_s1_r100k_3 rwl_des 0 sky130_fd_pr__nfet_01v8 L=0.15 W=0.42 nf=1 ad=0.1218 as=0.1218 pd=1.42 ps=1.42 nrd=0.69047619047619  nrs=0.69047619047619 sa=0 sb=0 sd=0 mult=1 m=1
csn_op0_0000_an_s1_r100k_3 sn_op0_0000_an_s1_r100k_3 0 {C_SN}
XMN1_op0_0000_an_s1_r100k rbl_op0_0000_an_s1_r100k ref_op0_0000_an_s1_r100k vn_op0_0000_an_s1_r100k 0 sky130_fd_pr__nfet_01v8 L=0.15 W=1 nf=1 ad=0.29 as=0.29 pd=2.58 ps=2.58 mult=1 m=1
XMN2_op0_0000_an_s1_r100k ref_op0_0000_an_s1_r100k rbl_op0_0000_an_s1_r100k vn_op0_0000_an_s1_r100k 0 sky130_fd_pr__nfet_01v8 L=0.15 W=1 nf=1 ad=0.29 as=0.29 pd=2.58 ps=2.58 mult=1 m=1
XMP1_op0_0000_an_s1_r100k rbl_op0_0000_an_s1_r100k ref_op0_0000_an_s1_r100k vp_op0_0000_an_s1_r100k vdd sky130_fd_pr__pfet_01v8 L=0.15 W=2 nf=1 ad=0.58 as=0.58 pd=4.58 ps=4.58 mult=1 m=1
XMP2_op0_0000_an_s1_r100k ref_op0_0000_an_s1_r100k rbl_op0_0000_an_s1_r100k vp_op0_0000_an_s1_r100k vdd sky130_fd_pr__pfet_01v8 L=0.15 W=2 nf=1 ad=0.58 as=0.58 pd=4.58 ps=4.58 mult=1 m=1
XMNF_op0_0000_an_s1_r100k vn_op0_0000_an_s1_r100k en_op0_0000_an_s1_r100k 0 0 sky130_fd_pr__nfet_01v8 L=0.15 W=2 nf=1 ad=0.58 as=0.58 pd=4.58 ps=4.58 mult=1 m=1
XMPH_op0_0000_an_s1_r100k vp_op0_0000_an_s1_r100k enb_op0_0000_an_s1_r100k vdd vdd sky130_fd_pr__pfet_01v8 L=0.15 W=4 nf=1 ad=1.16 as=1.16 pd=8.58 ps=8.58 mult=1 m=1
bd_op0_0000_an_s1_r100k d_op0_0000_an_s1_r100k 0 v=v(rbl_op0_0000_an_s1_r100k)-v(ref_op0_0000_an_s1_r100k)

* ---- instance 93: op1_0900_an_s2_r10k (variant an_s2_r10k; probe dec 14.9 ns, release 37 ns, meas 39 ns) ----
vctl_op1_0900_an_s2_r10k ctl_op1_0900_an_s2_r10k 0 pwl(0.0000e+00 {VDD} 2.0000e-09 {VDD} 2.1000e-09 0)
* RWL driver model (EXPERIMENTAL): slew 2 ns, series R 10000 ohm; cell pin = rwls_op1_0900_an_s2_r10k
vrs_op1_0900_an_s2_r10k rwlsrc_op1_0900_an_s2_r10k 0 pwl(0.0000e+00 {VDD} 4.0000e-09 {VDD} 6.0000e-09 0 3.7000e-08 0 3.9000e-08 {VDD})
rdrv_op1_0900_an_s2_r10k rwlsrc_op1_0900_an_s2_r10k rwls_op1_0900_an_s2_r10k 10000
ven_op1_0900_an_s2_r10k en_op1_0900_an_s2_r10k 0 pwl(0.0000e+00 0 1.4000e-08 0 1.4100e-08 {VDD} 3.7000e-08 {VDD} 3.7100e-08 0)
venb_op1_0900_an_s2_r10k enb_op1_0900_an_s2_r10k 0 pwl(0.0000e+00 {VDD} 1.4000e-08 {VDD} 1.4100e-08 0 3.7000e-08 0 3.7100e-08 {VDD})
vww_op1_0900_an_s2_r10k wwl_op1_0900_an_s2_r10k 0 pwl(0.0000e+00 0 1.5000e-08 0 1.5100e-08 {VDD} 3.5000e-08 {VDD} 3.5100e-08 0)
vwc_op1_0900_an_s2_r10k wbc_op1_0900_an_s2_r10k 0 pwl(0.0000e+00 0 1.5000e-08 0 1.5100e-08 {VDD} 3.7000e-08 {VDD} 3.7100e-08 0)
swb_op1_0900_an_s2_r10k ref_op1_0900_an_s2_r10k wbl_op1_0900_an_s2_r10k wbc_op1_0900_an_s2_r10k 0 swwbl
cwbl_op1_0900_an_s2_r10k wbl_op1_0900_an_s2_r10k 0 {C_WBL}
spa_op1_0900_an_s2_r10k prea rbl_op1_0900_an_s2_r10k ctl_op1_0900_an_s2_r10k 0 swpre
spr_op1_0900_an_s2_r10k pref ref_op1_0900_an_s2_r10k ctl_op1_0900_an_s2_r10k 0 swpre
crbl_op1_0900_an_s2_r10k rbl_op1_0900_an_s2_r10k 0 {C_RBL}
cref_op1_0900_an_s2_r10k ref_op1_0900_an_s2_r10k 0 {C_RBL}   $ ASSUMPTION: ideal matched dummy load
XMWR_op1_0900_an_s2_r10k_0 sn_op1_0900_an_s2_r10k_0 wwl_op1_0900_an_s2_r10k wbl_op1_0900_an_s2_r10k 0 sky130_fd_pr__nfet_01v8 L=0.15 W=0.42 nf=1 ad=0.1218 as=0.1218 pd=1.42 ps=1.42 nrd=0.69047619047619  nrs=0.69047619047619 sa=0 sb=0 sd=0 mult=1 m=1
XMRD_op1_0900_an_s2_r10k_0 rbl_op1_0900_an_s2_r10k sn_op1_0900_an_s2_r10k_0 rwls_op1_0900_an_s2_r10k 0 sky130_fd_pr__nfet_01v8 L=0.15 W=0.42 nf=1 ad=0.1218 as=0.1218 pd=1.42 ps=1.42 nrd=0.69047619047619  nrs=0.69047619047619 sa=0 sb=0 sd=0 mult=1 m=1
csn_op1_0900_an_s2_r10k_0 sn_op1_0900_an_s2_r10k_0 0 {C_SN}
XMWR_op1_0900_an_s2_r10k_1 sn_op1_0900_an_s2_r10k_1 wwl_des wbl_op1_0900_an_s2_r10k 0 sky130_fd_pr__nfet_01v8 L=0.15 W=0.42 nf=1 ad=0.1218 as=0.1218 pd=1.42 ps=1.42 nrd=0.69047619047619  nrs=0.69047619047619 sa=0 sb=0 sd=0 mult=1 m=1
XMRD_op1_0900_an_s2_r10k_1 rbl_op1_0900_an_s2_r10k sn_op1_0900_an_s2_r10k_1 rwl_des 0 sky130_fd_pr__nfet_01v8 L=0.15 W=0.42 nf=1 ad=0.1218 as=0.1218 pd=1.42 ps=1.42 nrd=0.69047619047619  nrs=0.69047619047619 sa=0 sb=0 sd=0 mult=1 m=1
csn_op1_0900_an_s2_r10k_1 sn_op1_0900_an_s2_r10k_1 0 {C_SN}
XMWR_op1_0900_an_s2_r10k_2 sn_op1_0900_an_s2_r10k_2 wwl_des wbl_op1_0900_an_s2_r10k 0 sky130_fd_pr__nfet_01v8 L=0.15 W=0.42 nf=1 ad=0.1218 as=0.1218 pd=1.42 ps=1.42 nrd=0.69047619047619  nrs=0.69047619047619 sa=0 sb=0 sd=0 mult=1 m=1
XMRD_op1_0900_an_s2_r10k_2 rbl_op1_0900_an_s2_r10k sn_op1_0900_an_s2_r10k_2 rwl_des 0 sky130_fd_pr__nfet_01v8 L=0.15 W=0.42 nf=1 ad=0.1218 as=0.1218 pd=1.42 ps=1.42 nrd=0.69047619047619  nrs=0.69047619047619 sa=0 sb=0 sd=0 mult=1 m=1
csn_op1_0900_an_s2_r10k_2 sn_op1_0900_an_s2_r10k_2 0 {C_SN}
XMWR_op1_0900_an_s2_r10k_3 sn_op1_0900_an_s2_r10k_3 wwl_des wbl_op1_0900_an_s2_r10k 0 sky130_fd_pr__nfet_01v8 L=0.15 W=0.42 nf=1 ad=0.1218 as=0.1218 pd=1.42 ps=1.42 nrd=0.69047619047619  nrs=0.69047619047619 sa=0 sb=0 sd=0 mult=1 m=1
XMRD_op1_0900_an_s2_r10k_3 rbl_op1_0900_an_s2_r10k sn_op1_0900_an_s2_r10k_3 rwl_des 0 sky130_fd_pr__nfet_01v8 L=0.15 W=0.42 nf=1 ad=0.1218 as=0.1218 pd=1.42 ps=1.42 nrd=0.69047619047619  nrs=0.69047619047619 sa=0 sb=0 sd=0 mult=1 m=1
csn_op1_0900_an_s2_r10k_3 sn_op1_0900_an_s2_r10k_3 0 {C_SN}
XMN1_op1_0900_an_s2_r10k rbl_op1_0900_an_s2_r10k ref_op1_0900_an_s2_r10k vn_op1_0900_an_s2_r10k 0 sky130_fd_pr__nfet_01v8 L=0.15 W=1 nf=1 ad=0.29 as=0.29 pd=2.58 ps=2.58 mult=1 m=1
XMN2_op1_0900_an_s2_r10k ref_op1_0900_an_s2_r10k rbl_op1_0900_an_s2_r10k vn_op1_0900_an_s2_r10k 0 sky130_fd_pr__nfet_01v8 L=0.15 W=1 nf=1 ad=0.29 as=0.29 pd=2.58 ps=2.58 mult=1 m=1
XMP1_op1_0900_an_s2_r10k rbl_op1_0900_an_s2_r10k ref_op1_0900_an_s2_r10k vp_op1_0900_an_s2_r10k vdd sky130_fd_pr__pfet_01v8 L=0.15 W=2 nf=1 ad=0.58 as=0.58 pd=4.58 ps=4.58 mult=1 m=1
XMP2_op1_0900_an_s2_r10k ref_op1_0900_an_s2_r10k rbl_op1_0900_an_s2_r10k vp_op1_0900_an_s2_r10k vdd sky130_fd_pr__pfet_01v8 L=0.15 W=2 nf=1 ad=0.58 as=0.58 pd=4.58 ps=4.58 mult=1 m=1
XMNF_op1_0900_an_s2_r10k vn_op1_0900_an_s2_r10k en_op1_0900_an_s2_r10k 0 0 sky130_fd_pr__nfet_01v8 L=0.15 W=2 nf=1 ad=0.58 as=0.58 pd=4.58 ps=4.58 mult=1 m=1
XMPH_op1_0900_an_s2_r10k vp_op1_0900_an_s2_r10k enb_op1_0900_an_s2_r10k vdd vdd sky130_fd_pr__pfet_01v8 L=0.15 W=4 nf=1 ad=1.16 as=1.16 pd=8.58 ps=8.58 mult=1 m=1
bd_op1_0900_an_s2_r10k d_op1_0900_an_s2_r10k 0 v=v(rbl_op1_0900_an_s2_r10k)-v(ref_op1_0900_an_s2_r10k)

* ---- instance 94: op1_1000_an_s2_r10k (variant an_s2_r10k; probe dec 14.9 ns, release 37 ns, meas 39 ns) ----
vctl_op1_1000_an_s2_r10k ctl_op1_1000_an_s2_r10k 0 pwl(0.0000e+00 {VDD} 2.0000e-09 {VDD} 2.1000e-09 0)
* RWL driver model (EXPERIMENTAL): slew 2 ns, series R 10000 ohm; cell pin = rwls_op1_1000_an_s2_r10k
vrs_op1_1000_an_s2_r10k rwlsrc_op1_1000_an_s2_r10k 0 pwl(0.0000e+00 {VDD} 4.0000e-09 {VDD} 6.0000e-09 0 3.7000e-08 0 3.9000e-08 {VDD})
rdrv_op1_1000_an_s2_r10k rwlsrc_op1_1000_an_s2_r10k rwls_op1_1000_an_s2_r10k 10000
ven_op1_1000_an_s2_r10k en_op1_1000_an_s2_r10k 0 pwl(0.0000e+00 0 1.4000e-08 0 1.4100e-08 {VDD} 3.7000e-08 {VDD} 3.7100e-08 0)
venb_op1_1000_an_s2_r10k enb_op1_1000_an_s2_r10k 0 pwl(0.0000e+00 {VDD} 1.4000e-08 {VDD} 1.4100e-08 0 3.7000e-08 0 3.7100e-08 {VDD})
vww_op1_1000_an_s2_r10k wwl_op1_1000_an_s2_r10k 0 pwl(0.0000e+00 0 1.5000e-08 0 1.5100e-08 {VDD} 3.5000e-08 {VDD} 3.5100e-08 0)
vwc_op1_1000_an_s2_r10k wbc_op1_1000_an_s2_r10k 0 pwl(0.0000e+00 0 1.5000e-08 0 1.5100e-08 {VDD} 3.7000e-08 {VDD} 3.7100e-08 0)
swb_op1_1000_an_s2_r10k ref_op1_1000_an_s2_r10k wbl_op1_1000_an_s2_r10k wbc_op1_1000_an_s2_r10k 0 swwbl
cwbl_op1_1000_an_s2_r10k wbl_op1_1000_an_s2_r10k 0 {C_WBL}
spa_op1_1000_an_s2_r10k prea rbl_op1_1000_an_s2_r10k ctl_op1_1000_an_s2_r10k 0 swpre
spr_op1_1000_an_s2_r10k pref ref_op1_1000_an_s2_r10k ctl_op1_1000_an_s2_r10k 0 swpre
crbl_op1_1000_an_s2_r10k rbl_op1_1000_an_s2_r10k 0 {C_RBL}
cref_op1_1000_an_s2_r10k ref_op1_1000_an_s2_r10k 0 {C_RBL}   $ ASSUMPTION: ideal matched dummy load
XMWR_op1_1000_an_s2_r10k_0 sn_op1_1000_an_s2_r10k_0 wwl_op1_1000_an_s2_r10k wbl_op1_1000_an_s2_r10k 0 sky130_fd_pr__nfet_01v8 L=0.15 W=0.42 nf=1 ad=0.1218 as=0.1218 pd=1.42 ps=1.42 nrd=0.69047619047619  nrs=0.69047619047619 sa=0 sb=0 sd=0 mult=1 m=1
XMRD_op1_1000_an_s2_r10k_0 rbl_op1_1000_an_s2_r10k sn_op1_1000_an_s2_r10k_0 rwls_op1_1000_an_s2_r10k 0 sky130_fd_pr__nfet_01v8 L=0.15 W=0.42 nf=1 ad=0.1218 as=0.1218 pd=1.42 ps=1.42 nrd=0.69047619047619  nrs=0.69047619047619 sa=0 sb=0 sd=0 mult=1 m=1
csn_op1_1000_an_s2_r10k_0 sn_op1_1000_an_s2_r10k_0 0 {C_SN}
XMWR_op1_1000_an_s2_r10k_1 sn_op1_1000_an_s2_r10k_1 wwl_des wbl_op1_1000_an_s2_r10k 0 sky130_fd_pr__nfet_01v8 L=0.15 W=0.42 nf=1 ad=0.1218 as=0.1218 pd=1.42 ps=1.42 nrd=0.69047619047619  nrs=0.69047619047619 sa=0 sb=0 sd=0 mult=1 m=1
XMRD_op1_1000_an_s2_r10k_1 rbl_op1_1000_an_s2_r10k sn_op1_1000_an_s2_r10k_1 rwl_des 0 sky130_fd_pr__nfet_01v8 L=0.15 W=0.42 nf=1 ad=0.1218 as=0.1218 pd=1.42 ps=1.42 nrd=0.69047619047619  nrs=0.69047619047619 sa=0 sb=0 sd=0 mult=1 m=1
csn_op1_1000_an_s2_r10k_1 sn_op1_1000_an_s2_r10k_1 0 {C_SN}
XMWR_op1_1000_an_s2_r10k_2 sn_op1_1000_an_s2_r10k_2 wwl_des wbl_op1_1000_an_s2_r10k 0 sky130_fd_pr__nfet_01v8 L=0.15 W=0.42 nf=1 ad=0.1218 as=0.1218 pd=1.42 ps=1.42 nrd=0.69047619047619  nrs=0.69047619047619 sa=0 sb=0 sd=0 mult=1 m=1
XMRD_op1_1000_an_s2_r10k_2 rbl_op1_1000_an_s2_r10k sn_op1_1000_an_s2_r10k_2 rwl_des 0 sky130_fd_pr__nfet_01v8 L=0.15 W=0.42 nf=1 ad=0.1218 as=0.1218 pd=1.42 ps=1.42 nrd=0.69047619047619  nrs=0.69047619047619 sa=0 sb=0 sd=0 mult=1 m=1
csn_op1_1000_an_s2_r10k_2 sn_op1_1000_an_s2_r10k_2 0 {C_SN}
XMWR_op1_1000_an_s2_r10k_3 sn_op1_1000_an_s2_r10k_3 wwl_des wbl_op1_1000_an_s2_r10k 0 sky130_fd_pr__nfet_01v8 L=0.15 W=0.42 nf=1 ad=0.1218 as=0.1218 pd=1.42 ps=1.42 nrd=0.69047619047619  nrs=0.69047619047619 sa=0 sb=0 sd=0 mult=1 m=1
XMRD_op1_1000_an_s2_r10k_3 rbl_op1_1000_an_s2_r10k sn_op1_1000_an_s2_r10k_3 rwl_des 0 sky130_fd_pr__nfet_01v8 L=0.15 W=0.42 nf=1 ad=0.1218 as=0.1218 pd=1.42 ps=1.42 nrd=0.69047619047619  nrs=0.69047619047619 sa=0 sb=0 sd=0 mult=1 m=1
csn_op1_1000_an_s2_r10k_3 sn_op1_1000_an_s2_r10k_3 0 {C_SN}
XMN1_op1_1000_an_s2_r10k rbl_op1_1000_an_s2_r10k ref_op1_1000_an_s2_r10k vn_op1_1000_an_s2_r10k 0 sky130_fd_pr__nfet_01v8 L=0.15 W=1 nf=1 ad=0.29 as=0.29 pd=2.58 ps=2.58 mult=1 m=1
XMN2_op1_1000_an_s2_r10k ref_op1_1000_an_s2_r10k rbl_op1_1000_an_s2_r10k vn_op1_1000_an_s2_r10k 0 sky130_fd_pr__nfet_01v8 L=0.15 W=1 nf=1 ad=0.29 as=0.29 pd=2.58 ps=2.58 mult=1 m=1
XMP1_op1_1000_an_s2_r10k rbl_op1_1000_an_s2_r10k ref_op1_1000_an_s2_r10k vp_op1_1000_an_s2_r10k vdd sky130_fd_pr__pfet_01v8 L=0.15 W=2 nf=1 ad=0.58 as=0.58 pd=4.58 ps=4.58 mult=1 m=1
XMP2_op1_1000_an_s2_r10k ref_op1_1000_an_s2_r10k rbl_op1_1000_an_s2_r10k vp_op1_1000_an_s2_r10k vdd sky130_fd_pr__pfet_01v8 L=0.15 W=2 nf=1 ad=0.58 as=0.58 pd=4.58 ps=4.58 mult=1 m=1
XMNF_op1_1000_an_s2_r10k vn_op1_1000_an_s2_r10k en_op1_1000_an_s2_r10k 0 0 sky130_fd_pr__nfet_01v8 L=0.15 W=2 nf=1 ad=0.58 as=0.58 pd=4.58 ps=4.58 mult=1 m=1
XMPH_op1_1000_an_s2_r10k vp_op1_1000_an_s2_r10k enb_op1_1000_an_s2_r10k vdd vdd sky130_fd_pr__pfet_01v8 L=0.15 W=4 nf=1 ad=1.16 as=1.16 pd=8.58 ps=8.58 mult=1 m=1
bd_op1_1000_an_s2_r10k d_op1_1000_an_s2_r10k 0 v=v(rbl_op1_1000_an_s2_r10k)-v(ref_op1_1000_an_s2_r10k)

* ---- instance 95: op0_n100_an_s2_r10k (variant an_s2_r10k; probe dec 14.9 ns, release 37 ns, meas 39 ns) ----
vctl_op0_n100_an_s2_r10k ctl_op0_n100_an_s2_r10k 0 pwl(0.0000e+00 {VDD} 2.0000e-09 {VDD} 2.1000e-09 0)
* RWL driver model (EXPERIMENTAL): slew 2 ns, series R 10000 ohm; cell pin = rwls_op0_n100_an_s2_r10k
vrs_op0_n100_an_s2_r10k rwlsrc_op0_n100_an_s2_r10k 0 pwl(0.0000e+00 {VDD} 4.0000e-09 {VDD} 6.0000e-09 0 3.7000e-08 0 3.9000e-08 {VDD})
rdrv_op0_n100_an_s2_r10k rwlsrc_op0_n100_an_s2_r10k rwls_op0_n100_an_s2_r10k 10000
ven_op0_n100_an_s2_r10k en_op0_n100_an_s2_r10k 0 pwl(0.0000e+00 0 1.4000e-08 0 1.4100e-08 {VDD} 3.7000e-08 {VDD} 3.7100e-08 0)
venb_op0_n100_an_s2_r10k enb_op0_n100_an_s2_r10k 0 pwl(0.0000e+00 {VDD} 1.4000e-08 {VDD} 1.4100e-08 0 3.7000e-08 0 3.7100e-08 {VDD})
vww_op0_n100_an_s2_r10k wwl_op0_n100_an_s2_r10k 0 pwl(0.0000e+00 0 1.5000e-08 0 1.5100e-08 {VDD} 3.5000e-08 {VDD} 3.5100e-08 0)
vwc_op0_n100_an_s2_r10k wbc_op0_n100_an_s2_r10k 0 pwl(0.0000e+00 0 1.5000e-08 0 1.5100e-08 {VDD} 3.7000e-08 {VDD} 3.7100e-08 0)
swb_op0_n100_an_s2_r10k ref_op0_n100_an_s2_r10k wbl_op0_n100_an_s2_r10k wbc_op0_n100_an_s2_r10k 0 swwbl
cwbl_op0_n100_an_s2_r10k wbl_op0_n100_an_s2_r10k 0 {C_WBL}
spa_op0_n100_an_s2_r10k prea rbl_op0_n100_an_s2_r10k ctl_op0_n100_an_s2_r10k 0 swpre
spr_op0_n100_an_s2_r10k pref ref_op0_n100_an_s2_r10k ctl_op0_n100_an_s2_r10k 0 swpre
crbl_op0_n100_an_s2_r10k rbl_op0_n100_an_s2_r10k 0 {C_RBL}
cref_op0_n100_an_s2_r10k ref_op0_n100_an_s2_r10k 0 {C_RBL}   $ ASSUMPTION: ideal matched dummy load
XMWR_op0_n100_an_s2_r10k_0 sn_op0_n100_an_s2_r10k_0 wwl_op0_n100_an_s2_r10k wbl_op0_n100_an_s2_r10k 0 sky130_fd_pr__nfet_01v8 L=0.15 W=0.42 nf=1 ad=0.1218 as=0.1218 pd=1.42 ps=1.42 nrd=0.69047619047619  nrs=0.69047619047619 sa=0 sb=0 sd=0 mult=1 m=1
XMRD_op0_n100_an_s2_r10k_0 rbl_op0_n100_an_s2_r10k sn_op0_n100_an_s2_r10k_0 rwls_op0_n100_an_s2_r10k 0 sky130_fd_pr__nfet_01v8 L=0.15 W=0.42 nf=1 ad=0.1218 as=0.1218 pd=1.42 ps=1.42 nrd=0.69047619047619  nrs=0.69047619047619 sa=0 sb=0 sd=0 mult=1 m=1
csn_op0_n100_an_s2_r10k_0 sn_op0_n100_an_s2_r10k_0 0 {C_SN}
XMWR_op0_n100_an_s2_r10k_1 sn_op0_n100_an_s2_r10k_1 wwl_des wbl_op0_n100_an_s2_r10k 0 sky130_fd_pr__nfet_01v8 L=0.15 W=0.42 nf=1 ad=0.1218 as=0.1218 pd=1.42 ps=1.42 nrd=0.69047619047619  nrs=0.69047619047619 sa=0 sb=0 sd=0 mult=1 m=1
XMRD_op0_n100_an_s2_r10k_1 rbl_op0_n100_an_s2_r10k sn_op0_n100_an_s2_r10k_1 rwl_des 0 sky130_fd_pr__nfet_01v8 L=0.15 W=0.42 nf=1 ad=0.1218 as=0.1218 pd=1.42 ps=1.42 nrd=0.69047619047619  nrs=0.69047619047619 sa=0 sb=0 sd=0 mult=1 m=1
csn_op0_n100_an_s2_r10k_1 sn_op0_n100_an_s2_r10k_1 0 {C_SN}
XMWR_op0_n100_an_s2_r10k_2 sn_op0_n100_an_s2_r10k_2 wwl_des wbl_op0_n100_an_s2_r10k 0 sky130_fd_pr__nfet_01v8 L=0.15 W=0.42 nf=1 ad=0.1218 as=0.1218 pd=1.42 ps=1.42 nrd=0.69047619047619  nrs=0.69047619047619 sa=0 sb=0 sd=0 mult=1 m=1
XMRD_op0_n100_an_s2_r10k_2 rbl_op0_n100_an_s2_r10k sn_op0_n100_an_s2_r10k_2 rwl_des 0 sky130_fd_pr__nfet_01v8 L=0.15 W=0.42 nf=1 ad=0.1218 as=0.1218 pd=1.42 ps=1.42 nrd=0.69047619047619  nrs=0.69047619047619 sa=0 sb=0 sd=0 mult=1 m=1
csn_op0_n100_an_s2_r10k_2 sn_op0_n100_an_s2_r10k_2 0 {C_SN}
XMWR_op0_n100_an_s2_r10k_3 sn_op0_n100_an_s2_r10k_3 wwl_des wbl_op0_n100_an_s2_r10k 0 sky130_fd_pr__nfet_01v8 L=0.15 W=0.42 nf=1 ad=0.1218 as=0.1218 pd=1.42 ps=1.42 nrd=0.69047619047619  nrs=0.69047619047619 sa=0 sb=0 sd=0 mult=1 m=1
XMRD_op0_n100_an_s2_r10k_3 rbl_op0_n100_an_s2_r10k sn_op0_n100_an_s2_r10k_3 rwl_des 0 sky130_fd_pr__nfet_01v8 L=0.15 W=0.42 nf=1 ad=0.1218 as=0.1218 pd=1.42 ps=1.42 nrd=0.69047619047619  nrs=0.69047619047619 sa=0 sb=0 sd=0 mult=1 m=1
csn_op0_n100_an_s2_r10k_3 sn_op0_n100_an_s2_r10k_3 0 {C_SN}
XMN1_op0_n100_an_s2_r10k rbl_op0_n100_an_s2_r10k ref_op0_n100_an_s2_r10k vn_op0_n100_an_s2_r10k 0 sky130_fd_pr__nfet_01v8 L=0.15 W=1 nf=1 ad=0.29 as=0.29 pd=2.58 ps=2.58 mult=1 m=1
XMN2_op0_n100_an_s2_r10k ref_op0_n100_an_s2_r10k rbl_op0_n100_an_s2_r10k vn_op0_n100_an_s2_r10k 0 sky130_fd_pr__nfet_01v8 L=0.15 W=1 nf=1 ad=0.29 as=0.29 pd=2.58 ps=2.58 mult=1 m=1
XMP1_op0_n100_an_s2_r10k rbl_op0_n100_an_s2_r10k ref_op0_n100_an_s2_r10k vp_op0_n100_an_s2_r10k vdd sky130_fd_pr__pfet_01v8 L=0.15 W=2 nf=1 ad=0.58 as=0.58 pd=4.58 ps=4.58 mult=1 m=1
XMP2_op0_n100_an_s2_r10k ref_op0_n100_an_s2_r10k rbl_op0_n100_an_s2_r10k vp_op0_n100_an_s2_r10k vdd sky130_fd_pr__pfet_01v8 L=0.15 W=2 nf=1 ad=0.58 as=0.58 pd=4.58 ps=4.58 mult=1 m=1
XMNF_op0_n100_an_s2_r10k vn_op0_n100_an_s2_r10k en_op0_n100_an_s2_r10k 0 0 sky130_fd_pr__nfet_01v8 L=0.15 W=2 nf=1 ad=0.58 as=0.58 pd=4.58 ps=4.58 mult=1 m=1
XMPH_op0_n100_an_s2_r10k vp_op0_n100_an_s2_r10k enb_op0_n100_an_s2_r10k vdd vdd sky130_fd_pr__pfet_01v8 L=0.15 W=4 nf=1 ad=1.16 as=1.16 pd=8.58 ps=8.58 mult=1 m=1
bd_op0_n100_an_s2_r10k d_op0_n100_an_s2_r10k 0 v=v(rbl_op0_n100_an_s2_r10k)-v(ref_op0_n100_an_s2_r10k)

* ---- instance 96: op0_0000_an_s2_r10k (variant an_s2_r10k; probe dec 14.9 ns, release 37 ns, meas 39 ns) ----
vctl_op0_0000_an_s2_r10k ctl_op0_0000_an_s2_r10k 0 pwl(0.0000e+00 {VDD} 2.0000e-09 {VDD} 2.1000e-09 0)
* RWL driver model (EXPERIMENTAL): slew 2 ns, series R 10000 ohm; cell pin = rwls_op0_0000_an_s2_r10k
vrs_op0_0000_an_s2_r10k rwlsrc_op0_0000_an_s2_r10k 0 pwl(0.0000e+00 {VDD} 4.0000e-09 {VDD} 6.0000e-09 0 3.7000e-08 0 3.9000e-08 {VDD})
rdrv_op0_0000_an_s2_r10k rwlsrc_op0_0000_an_s2_r10k rwls_op0_0000_an_s2_r10k 10000
ven_op0_0000_an_s2_r10k en_op0_0000_an_s2_r10k 0 pwl(0.0000e+00 0 1.4000e-08 0 1.4100e-08 {VDD} 3.7000e-08 {VDD} 3.7100e-08 0)
venb_op0_0000_an_s2_r10k enb_op0_0000_an_s2_r10k 0 pwl(0.0000e+00 {VDD} 1.4000e-08 {VDD} 1.4100e-08 0 3.7000e-08 0 3.7100e-08 {VDD})
vww_op0_0000_an_s2_r10k wwl_op0_0000_an_s2_r10k 0 pwl(0.0000e+00 0 1.5000e-08 0 1.5100e-08 {VDD} 3.5000e-08 {VDD} 3.5100e-08 0)
vwc_op0_0000_an_s2_r10k wbc_op0_0000_an_s2_r10k 0 pwl(0.0000e+00 0 1.5000e-08 0 1.5100e-08 {VDD} 3.7000e-08 {VDD} 3.7100e-08 0)
swb_op0_0000_an_s2_r10k ref_op0_0000_an_s2_r10k wbl_op0_0000_an_s2_r10k wbc_op0_0000_an_s2_r10k 0 swwbl
cwbl_op0_0000_an_s2_r10k wbl_op0_0000_an_s2_r10k 0 {C_WBL}
spa_op0_0000_an_s2_r10k prea rbl_op0_0000_an_s2_r10k ctl_op0_0000_an_s2_r10k 0 swpre
spr_op0_0000_an_s2_r10k pref ref_op0_0000_an_s2_r10k ctl_op0_0000_an_s2_r10k 0 swpre
crbl_op0_0000_an_s2_r10k rbl_op0_0000_an_s2_r10k 0 {C_RBL}
cref_op0_0000_an_s2_r10k ref_op0_0000_an_s2_r10k 0 {C_RBL}   $ ASSUMPTION: ideal matched dummy load
XMWR_op0_0000_an_s2_r10k_0 sn_op0_0000_an_s2_r10k_0 wwl_op0_0000_an_s2_r10k wbl_op0_0000_an_s2_r10k 0 sky130_fd_pr__nfet_01v8 L=0.15 W=0.42 nf=1 ad=0.1218 as=0.1218 pd=1.42 ps=1.42 nrd=0.69047619047619  nrs=0.69047619047619 sa=0 sb=0 sd=0 mult=1 m=1
XMRD_op0_0000_an_s2_r10k_0 rbl_op0_0000_an_s2_r10k sn_op0_0000_an_s2_r10k_0 rwls_op0_0000_an_s2_r10k 0 sky130_fd_pr__nfet_01v8 L=0.15 W=0.42 nf=1 ad=0.1218 as=0.1218 pd=1.42 ps=1.42 nrd=0.69047619047619  nrs=0.69047619047619 sa=0 sb=0 sd=0 mult=1 m=1
csn_op0_0000_an_s2_r10k_0 sn_op0_0000_an_s2_r10k_0 0 {C_SN}
XMWR_op0_0000_an_s2_r10k_1 sn_op0_0000_an_s2_r10k_1 wwl_des wbl_op0_0000_an_s2_r10k 0 sky130_fd_pr__nfet_01v8 L=0.15 W=0.42 nf=1 ad=0.1218 as=0.1218 pd=1.42 ps=1.42 nrd=0.69047619047619  nrs=0.69047619047619 sa=0 sb=0 sd=0 mult=1 m=1
XMRD_op0_0000_an_s2_r10k_1 rbl_op0_0000_an_s2_r10k sn_op0_0000_an_s2_r10k_1 rwl_des 0 sky130_fd_pr__nfet_01v8 L=0.15 W=0.42 nf=1 ad=0.1218 as=0.1218 pd=1.42 ps=1.42 nrd=0.69047619047619  nrs=0.69047619047619 sa=0 sb=0 sd=0 mult=1 m=1
csn_op0_0000_an_s2_r10k_1 sn_op0_0000_an_s2_r10k_1 0 {C_SN}
XMWR_op0_0000_an_s2_r10k_2 sn_op0_0000_an_s2_r10k_2 wwl_des wbl_op0_0000_an_s2_r10k 0 sky130_fd_pr__nfet_01v8 L=0.15 W=0.42 nf=1 ad=0.1218 as=0.1218 pd=1.42 ps=1.42 nrd=0.69047619047619  nrs=0.69047619047619 sa=0 sb=0 sd=0 mult=1 m=1
XMRD_op0_0000_an_s2_r10k_2 rbl_op0_0000_an_s2_r10k sn_op0_0000_an_s2_r10k_2 rwl_des 0 sky130_fd_pr__nfet_01v8 L=0.15 W=0.42 nf=1 ad=0.1218 as=0.1218 pd=1.42 ps=1.42 nrd=0.69047619047619  nrs=0.69047619047619 sa=0 sb=0 sd=0 mult=1 m=1
csn_op0_0000_an_s2_r10k_2 sn_op0_0000_an_s2_r10k_2 0 {C_SN}
XMWR_op0_0000_an_s2_r10k_3 sn_op0_0000_an_s2_r10k_3 wwl_des wbl_op0_0000_an_s2_r10k 0 sky130_fd_pr__nfet_01v8 L=0.15 W=0.42 nf=1 ad=0.1218 as=0.1218 pd=1.42 ps=1.42 nrd=0.69047619047619  nrs=0.69047619047619 sa=0 sb=0 sd=0 mult=1 m=1
XMRD_op0_0000_an_s2_r10k_3 rbl_op0_0000_an_s2_r10k sn_op0_0000_an_s2_r10k_3 rwl_des 0 sky130_fd_pr__nfet_01v8 L=0.15 W=0.42 nf=1 ad=0.1218 as=0.1218 pd=1.42 ps=1.42 nrd=0.69047619047619  nrs=0.69047619047619 sa=0 sb=0 sd=0 mult=1 m=1
csn_op0_0000_an_s2_r10k_3 sn_op0_0000_an_s2_r10k_3 0 {C_SN}
XMN1_op0_0000_an_s2_r10k rbl_op0_0000_an_s2_r10k ref_op0_0000_an_s2_r10k vn_op0_0000_an_s2_r10k 0 sky130_fd_pr__nfet_01v8 L=0.15 W=1 nf=1 ad=0.29 as=0.29 pd=2.58 ps=2.58 mult=1 m=1
XMN2_op0_0000_an_s2_r10k ref_op0_0000_an_s2_r10k rbl_op0_0000_an_s2_r10k vn_op0_0000_an_s2_r10k 0 sky130_fd_pr__nfet_01v8 L=0.15 W=1 nf=1 ad=0.29 as=0.29 pd=2.58 ps=2.58 mult=1 m=1
XMP1_op0_0000_an_s2_r10k rbl_op0_0000_an_s2_r10k ref_op0_0000_an_s2_r10k vp_op0_0000_an_s2_r10k vdd sky130_fd_pr__pfet_01v8 L=0.15 W=2 nf=1 ad=0.58 as=0.58 pd=4.58 ps=4.58 mult=1 m=1
XMP2_op0_0000_an_s2_r10k ref_op0_0000_an_s2_r10k rbl_op0_0000_an_s2_r10k vp_op0_0000_an_s2_r10k vdd sky130_fd_pr__pfet_01v8 L=0.15 W=2 nf=1 ad=0.58 as=0.58 pd=4.58 ps=4.58 mult=1 m=1
XMNF_op0_0000_an_s2_r10k vn_op0_0000_an_s2_r10k en_op0_0000_an_s2_r10k 0 0 sky130_fd_pr__nfet_01v8 L=0.15 W=2 nf=1 ad=0.58 as=0.58 pd=4.58 ps=4.58 mult=1 m=1
XMPH_op0_0000_an_s2_r10k vp_op0_0000_an_s2_r10k enb_op0_0000_an_s2_r10k vdd vdd sky130_fd_pr__pfet_01v8 L=0.15 W=4 nf=1 ad=1.16 as=1.16 pd=8.58 ps=8.58 mult=1 m=1
bd_op0_0000_an_s2_r10k d_op0_0000_an_s2_r10k 0 v=v(rbl_op0_0000_an_s2_r10k)-v(ref_op0_0000_an_s2_r10k)

* ---- instance 97: op1_0900_an_s2_r100k (variant an_s2_r100k; probe dec 14.9 ns, release 37 ns, meas 39 ns) ----
vctl_op1_0900_an_s2_r100k ctl_op1_0900_an_s2_r100k 0 pwl(0.0000e+00 {VDD} 2.0000e-09 {VDD} 2.1000e-09 0)
* RWL driver model (EXPERIMENTAL): slew 2 ns, series R 100000 ohm; cell pin = rwls_op1_0900_an_s2_r100k
vrs_op1_0900_an_s2_r100k rwlsrc_op1_0900_an_s2_r100k 0 pwl(0.0000e+00 {VDD} 4.0000e-09 {VDD} 6.0000e-09 0 3.7000e-08 0 3.9000e-08 {VDD})
rdrv_op1_0900_an_s2_r100k rwlsrc_op1_0900_an_s2_r100k rwls_op1_0900_an_s2_r100k 100000
ven_op1_0900_an_s2_r100k en_op1_0900_an_s2_r100k 0 pwl(0.0000e+00 0 1.4000e-08 0 1.4100e-08 {VDD} 3.7000e-08 {VDD} 3.7100e-08 0)
venb_op1_0900_an_s2_r100k enb_op1_0900_an_s2_r100k 0 pwl(0.0000e+00 {VDD} 1.4000e-08 {VDD} 1.4100e-08 0 3.7000e-08 0 3.7100e-08 {VDD})
vww_op1_0900_an_s2_r100k wwl_op1_0900_an_s2_r100k 0 pwl(0.0000e+00 0 1.5000e-08 0 1.5100e-08 {VDD} 3.5000e-08 {VDD} 3.5100e-08 0)
vwc_op1_0900_an_s2_r100k wbc_op1_0900_an_s2_r100k 0 pwl(0.0000e+00 0 1.5000e-08 0 1.5100e-08 {VDD} 3.7000e-08 {VDD} 3.7100e-08 0)
swb_op1_0900_an_s2_r100k ref_op1_0900_an_s2_r100k wbl_op1_0900_an_s2_r100k wbc_op1_0900_an_s2_r100k 0 swwbl
cwbl_op1_0900_an_s2_r100k wbl_op1_0900_an_s2_r100k 0 {C_WBL}
spa_op1_0900_an_s2_r100k prea rbl_op1_0900_an_s2_r100k ctl_op1_0900_an_s2_r100k 0 swpre
spr_op1_0900_an_s2_r100k pref ref_op1_0900_an_s2_r100k ctl_op1_0900_an_s2_r100k 0 swpre
crbl_op1_0900_an_s2_r100k rbl_op1_0900_an_s2_r100k 0 {C_RBL}
cref_op1_0900_an_s2_r100k ref_op1_0900_an_s2_r100k 0 {C_RBL}   $ ASSUMPTION: ideal matched dummy load
XMWR_op1_0900_an_s2_r100k_0 sn_op1_0900_an_s2_r100k_0 wwl_op1_0900_an_s2_r100k wbl_op1_0900_an_s2_r100k 0 sky130_fd_pr__nfet_01v8 L=0.15 W=0.42 nf=1 ad=0.1218 as=0.1218 pd=1.42 ps=1.42 nrd=0.69047619047619  nrs=0.69047619047619 sa=0 sb=0 sd=0 mult=1 m=1
XMRD_op1_0900_an_s2_r100k_0 rbl_op1_0900_an_s2_r100k sn_op1_0900_an_s2_r100k_0 rwls_op1_0900_an_s2_r100k 0 sky130_fd_pr__nfet_01v8 L=0.15 W=0.42 nf=1 ad=0.1218 as=0.1218 pd=1.42 ps=1.42 nrd=0.69047619047619  nrs=0.69047619047619 sa=0 sb=0 sd=0 mult=1 m=1
csn_op1_0900_an_s2_r100k_0 sn_op1_0900_an_s2_r100k_0 0 {C_SN}
XMWR_op1_0900_an_s2_r100k_1 sn_op1_0900_an_s2_r100k_1 wwl_des wbl_op1_0900_an_s2_r100k 0 sky130_fd_pr__nfet_01v8 L=0.15 W=0.42 nf=1 ad=0.1218 as=0.1218 pd=1.42 ps=1.42 nrd=0.69047619047619  nrs=0.69047619047619 sa=0 sb=0 sd=0 mult=1 m=1
XMRD_op1_0900_an_s2_r100k_1 rbl_op1_0900_an_s2_r100k sn_op1_0900_an_s2_r100k_1 rwl_des 0 sky130_fd_pr__nfet_01v8 L=0.15 W=0.42 nf=1 ad=0.1218 as=0.1218 pd=1.42 ps=1.42 nrd=0.69047619047619  nrs=0.69047619047619 sa=0 sb=0 sd=0 mult=1 m=1
csn_op1_0900_an_s2_r100k_1 sn_op1_0900_an_s2_r100k_1 0 {C_SN}
XMWR_op1_0900_an_s2_r100k_2 sn_op1_0900_an_s2_r100k_2 wwl_des wbl_op1_0900_an_s2_r100k 0 sky130_fd_pr__nfet_01v8 L=0.15 W=0.42 nf=1 ad=0.1218 as=0.1218 pd=1.42 ps=1.42 nrd=0.69047619047619  nrs=0.69047619047619 sa=0 sb=0 sd=0 mult=1 m=1
XMRD_op1_0900_an_s2_r100k_2 rbl_op1_0900_an_s2_r100k sn_op1_0900_an_s2_r100k_2 rwl_des 0 sky130_fd_pr__nfet_01v8 L=0.15 W=0.42 nf=1 ad=0.1218 as=0.1218 pd=1.42 ps=1.42 nrd=0.69047619047619  nrs=0.69047619047619 sa=0 sb=0 sd=0 mult=1 m=1
csn_op1_0900_an_s2_r100k_2 sn_op1_0900_an_s2_r100k_2 0 {C_SN}
XMWR_op1_0900_an_s2_r100k_3 sn_op1_0900_an_s2_r100k_3 wwl_des wbl_op1_0900_an_s2_r100k 0 sky130_fd_pr__nfet_01v8 L=0.15 W=0.42 nf=1 ad=0.1218 as=0.1218 pd=1.42 ps=1.42 nrd=0.69047619047619  nrs=0.69047619047619 sa=0 sb=0 sd=0 mult=1 m=1
XMRD_op1_0900_an_s2_r100k_3 rbl_op1_0900_an_s2_r100k sn_op1_0900_an_s2_r100k_3 rwl_des 0 sky130_fd_pr__nfet_01v8 L=0.15 W=0.42 nf=1 ad=0.1218 as=0.1218 pd=1.42 ps=1.42 nrd=0.69047619047619  nrs=0.69047619047619 sa=0 sb=0 sd=0 mult=1 m=1
csn_op1_0900_an_s2_r100k_3 sn_op1_0900_an_s2_r100k_3 0 {C_SN}
XMN1_op1_0900_an_s2_r100k rbl_op1_0900_an_s2_r100k ref_op1_0900_an_s2_r100k vn_op1_0900_an_s2_r100k 0 sky130_fd_pr__nfet_01v8 L=0.15 W=1 nf=1 ad=0.29 as=0.29 pd=2.58 ps=2.58 mult=1 m=1
XMN2_op1_0900_an_s2_r100k ref_op1_0900_an_s2_r100k rbl_op1_0900_an_s2_r100k vn_op1_0900_an_s2_r100k 0 sky130_fd_pr__nfet_01v8 L=0.15 W=1 nf=1 ad=0.29 as=0.29 pd=2.58 ps=2.58 mult=1 m=1
XMP1_op1_0900_an_s2_r100k rbl_op1_0900_an_s2_r100k ref_op1_0900_an_s2_r100k vp_op1_0900_an_s2_r100k vdd sky130_fd_pr__pfet_01v8 L=0.15 W=2 nf=1 ad=0.58 as=0.58 pd=4.58 ps=4.58 mult=1 m=1
XMP2_op1_0900_an_s2_r100k ref_op1_0900_an_s2_r100k rbl_op1_0900_an_s2_r100k vp_op1_0900_an_s2_r100k vdd sky130_fd_pr__pfet_01v8 L=0.15 W=2 nf=1 ad=0.58 as=0.58 pd=4.58 ps=4.58 mult=1 m=1
XMNF_op1_0900_an_s2_r100k vn_op1_0900_an_s2_r100k en_op1_0900_an_s2_r100k 0 0 sky130_fd_pr__nfet_01v8 L=0.15 W=2 nf=1 ad=0.58 as=0.58 pd=4.58 ps=4.58 mult=1 m=1
XMPH_op1_0900_an_s2_r100k vp_op1_0900_an_s2_r100k enb_op1_0900_an_s2_r100k vdd vdd sky130_fd_pr__pfet_01v8 L=0.15 W=4 nf=1 ad=1.16 as=1.16 pd=8.58 ps=8.58 mult=1 m=1
bd_op1_0900_an_s2_r100k d_op1_0900_an_s2_r100k 0 v=v(rbl_op1_0900_an_s2_r100k)-v(ref_op1_0900_an_s2_r100k)

* ---- instance 98: op1_1000_an_s2_r100k (variant an_s2_r100k; probe dec 14.9 ns, release 37 ns, meas 39 ns) ----
vctl_op1_1000_an_s2_r100k ctl_op1_1000_an_s2_r100k 0 pwl(0.0000e+00 {VDD} 2.0000e-09 {VDD} 2.1000e-09 0)
* RWL driver model (EXPERIMENTAL): slew 2 ns, series R 100000 ohm; cell pin = rwls_op1_1000_an_s2_r100k
vrs_op1_1000_an_s2_r100k rwlsrc_op1_1000_an_s2_r100k 0 pwl(0.0000e+00 {VDD} 4.0000e-09 {VDD} 6.0000e-09 0 3.7000e-08 0 3.9000e-08 {VDD})
rdrv_op1_1000_an_s2_r100k rwlsrc_op1_1000_an_s2_r100k rwls_op1_1000_an_s2_r100k 100000
ven_op1_1000_an_s2_r100k en_op1_1000_an_s2_r100k 0 pwl(0.0000e+00 0 1.4000e-08 0 1.4100e-08 {VDD} 3.7000e-08 {VDD} 3.7100e-08 0)
venb_op1_1000_an_s2_r100k enb_op1_1000_an_s2_r100k 0 pwl(0.0000e+00 {VDD} 1.4000e-08 {VDD} 1.4100e-08 0 3.7000e-08 0 3.7100e-08 {VDD})
vww_op1_1000_an_s2_r100k wwl_op1_1000_an_s2_r100k 0 pwl(0.0000e+00 0 1.5000e-08 0 1.5100e-08 {VDD} 3.5000e-08 {VDD} 3.5100e-08 0)
vwc_op1_1000_an_s2_r100k wbc_op1_1000_an_s2_r100k 0 pwl(0.0000e+00 0 1.5000e-08 0 1.5100e-08 {VDD} 3.7000e-08 {VDD} 3.7100e-08 0)
swb_op1_1000_an_s2_r100k ref_op1_1000_an_s2_r100k wbl_op1_1000_an_s2_r100k wbc_op1_1000_an_s2_r100k 0 swwbl
cwbl_op1_1000_an_s2_r100k wbl_op1_1000_an_s2_r100k 0 {C_WBL}
spa_op1_1000_an_s2_r100k prea rbl_op1_1000_an_s2_r100k ctl_op1_1000_an_s2_r100k 0 swpre
spr_op1_1000_an_s2_r100k pref ref_op1_1000_an_s2_r100k ctl_op1_1000_an_s2_r100k 0 swpre
crbl_op1_1000_an_s2_r100k rbl_op1_1000_an_s2_r100k 0 {C_RBL}
cref_op1_1000_an_s2_r100k ref_op1_1000_an_s2_r100k 0 {C_RBL}   $ ASSUMPTION: ideal matched dummy load
XMWR_op1_1000_an_s2_r100k_0 sn_op1_1000_an_s2_r100k_0 wwl_op1_1000_an_s2_r100k wbl_op1_1000_an_s2_r100k 0 sky130_fd_pr__nfet_01v8 L=0.15 W=0.42 nf=1 ad=0.1218 as=0.1218 pd=1.42 ps=1.42 nrd=0.69047619047619  nrs=0.69047619047619 sa=0 sb=0 sd=0 mult=1 m=1
XMRD_op1_1000_an_s2_r100k_0 rbl_op1_1000_an_s2_r100k sn_op1_1000_an_s2_r100k_0 rwls_op1_1000_an_s2_r100k 0 sky130_fd_pr__nfet_01v8 L=0.15 W=0.42 nf=1 ad=0.1218 as=0.1218 pd=1.42 ps=1.42 nrd=0.69047619047619  nrs=0.69047619047619 sa=0 sb=0 sd=0 mult=1 m=1
csn_op1_1000_an_s2_r100k_0 sn_op1_1000_an_s2_r100k_0 0 {C_SN}
XMWR_op1_1000_an_s2_r100k_1 sn_op1_1000_an_s2_r100k_1 wwl_des wbl_op1_1000_an_s2_r100k 0 sky130_fd_pr__nfet_01v8 L=0.15 W=0.42 nf=1 ad=0.1218 as=0.1218 pd=1.42 ps=1.42 nrd=0.69047619047619  nrs=0.69047619047619 sa=0 sb=0 sd=0 mult=1 m=1
XMRD_op1_1000_an_s2_r100k_1 rbl_op1_1000_an_s2_r100k sn_op1_1000_an_s2_r100k_1 rwl_des 0 sky130_fd_pr__nfet_01v8 L=0.15 W=0.42 nf=1 ad=0.1218 as=0.1218 pd=1.42 ps=1.42 nrd=0.69047619047619  nrs=0.69047619047619 sa=0 sb=0 sd=0 mult=1 m=1
csn_op1_1000_an_s2_r100k_1 sn_op1_1000_an_s2_r100k_1 0 {C_SN}
XMWR_op1_1000_an_s2_r100k_2 sn_op1_1000_an_s2_r100k_2 wwl_des wbl_op1_1000_an_s2_r100k 0 sky130_fd_pr__nfet_01v8 L=0.15 W=0.42 nf=1 ad=0.1218 as=0.1218 pd=1.42 ps=1.42 nrd=0.69047619047619  nrs=0.69047619047619 sa=0 sb=0 sd=0 mult=1 m=1
XMRD_op1_1000_an_s2_r100k_2 rbl_op1_1000_an_s2_r100k sn_op1_1000_an_s2_r100k_2 rwl_des 0 sky130_fd_pr__nfet_01v8 L=0.15 W=0.42 nf=1 ad=0.1218 as=0.1218 pd=1.42 ps=1.42 nrd=0.69047619047619  nrs=0.69047619047619 sa=0 sb=0 sd=0 mult=1 m=1
csn_op1_1000_an_s2_r100k_2 sn_op1_1000_an_s2_r100k_2 0 {C_SN}
XMWR_op1_1000_an_s2_r100k_3 sn_op1_1000_an_s2_r100k_3 wwl_des wbl_op1_1000_an_s2_r100k 0 sky130_fd_pr__nfet_01v8 L=0.15 W=0.42 nf=1 ad=0.1218 as=0.1218 pd=1.42 ps=1.42 nrd=0.69047619047619  nrs=0.69047619047619 sa=0 sb=0 sd=0 mult=1 m=1
XMRD_op1_1000_an_s2_r100k_3 rbl_op1_1000_an_s2_r100k sn_op1_1000_an_s2_r100k_3 rwl_des 0 sky130_fd_pr__nfet_01v8 L=0.15 W=0.42 nf=1 ad=0.1218 as=0.1218 pd=1.42 ps=1.42 nrd=0.69047619047619  nrs=0.69047619047619 sa=0 sb=0 sd=0 mult=1 m=1
csn_op1_1000_an_s2_r100k_3 sn_op1_1000_an_s2_r100k_3 0 {C_SN}
XMN1_op1_1000_an_s2_r100k rbl_op1_1000_an_s2_r100k ref_op1_1000_an_s2_r100k vn_op1_1000_an_s2_r100k 0 sky130_fd_pr__nfet_01v8 L=0.15 W=1 nf=1 ad=0.29 as=0.29 pd=2.58 ps=2.58 mult=1 m=1
XMN2_op1_1000_an_s2_r100k ref_op1_1000_an_s2_r100k rbl_op1_1000_an_s2_r100k vn_op1_1000_an_s2_r100k 0 sky130_fd_pr__nfet_01v8 L=0.15 W=1 nf=1 ad=0.29 as=0.29 pd=2.58 ps=2.58 mult=1 m=1
XMP1_op1_1000_an_s2_r100k rbl_op1_1000_an_s2_r100k ref_op1_1000_an_s2_r100k vp_op1_1000_an_s2_r100k vdd sky130_fd_pr__pfet_01v8 L=0.15 W=2 nf=1 ad=0.58 as=0.58 pd=4.58 ps=4.58 mult=1 m=1
XMP2_op1_1000_an_s2_r100k ref_op1_1000_an_s2_r100k rbl_op1_1000_an_s2_r100k vp_op1_1000_an_s2_r100k vdd sky130_fd_pr__pfet_01v8 L=0.15 W=2 nf=1 ad=0.58 as=0.58 pd=4.58 ps=4.58 mult=1 m=1
XMNF_op1_1000_an_s2_r100k vn_op1_1000_an_s2_r100k en_op1_1000_an_s2_r100k 0 0 sky130_fd_pr__nfet_01v8 L=0.15 W=2 nf=1 ad=0.58 as=0.58 pd=4.58 ps=4.58 mult=1 m=1
XMPH_op1_1000_an_s2_r100k vp_op1_1000_an_s2_r100k enb_op1_1000_an_s2_r100k vdd vdd sky130_fd_pr__pfet_01v8 L=0.15 W=4 nf=1 ad=1.16 as=1.16 pd=8.58 ps=8.58 mult=1 m=1
bd_op1_1000_an_s2_r100k d_op1_1000_an_s2_r100k 0 v=v(rbl_op1_1000_an_s2_r100k)-v(ref_op1_1000_an_s2_r100k)

* ---- instance 99: op0_n100_an_s2_r100k (variant an_s2_r100k; probe dec 14.9 ns, release 37 ns, meas 39 ns) ----
vctl_op0_n100_an_s2_r100k ctl_op0_n100_an_s2_r100k 0 pwl(0.0000e+00 {VDD} 2.0000e-09 {VDD} 2.1000e-09 0)
* RWL driver model (EXPERIMENTAL): slew 2 ns, series R 100000 ohm; cell pin = rwls_op0_n100_an_s2_r100k
vrs_op0_n100_an_s2_r100k rwlsrc_op0_n100_an_s2_r100k 0 pwl(0.0000e+00 {VDD} 4.0000e-09 {VDD} 6.0000e-09 0 3.7000e-08 0 3.9000e-08 {VDD})
rdrv_op0_n100_an_s2_r100k rwlsrc_op0_n100_an_s2_r100k rwls_op0_n100_an_s2_r100k 100000
ven_op0_n100_an_s2_r100k en_op0_n100_an_s2_r100k 0 pwl(0.0000e+00 0 1.4000e-08 0 1.4100e-08 {VDD} 3.7000e-08 {VDD} 3.7100e-08 0)
venb_op0_n100_an_s2_r100k enb_op0_n100_an_s2_r100k 0 pwl(0.0000e+00 {VDD} 1.4000e-08 {VDD} 1.4100e-08 0 3.7000e-08 0 3.7100e-08 {VDD})
vww_op0_n100_an_s2_r100k wwl_op0_n100_an_s2_r100k 0 pwl(0.0000e+00 0 1.5000e-08 0 1.5100e-08 {VDD} 3.5000e-08 {VDD} 3.5100e-08 0)
vwc_op0_n100_an_s2_r100k wbc_op0_n100_an_s2_r100k 0 pwl(0.0000e+00 0 1.5000e-08 0 1.5100e-08 {VDD} 3.7000e-08 {VDD} 3.7100e-08 0)
swb_op0_n100_an_s2_r100k ref_op0_n100_an_s2_r100k wbl_op0_n100_an_s2_r100k wbc_op0_n100_an_s2_r100k 0 swwbl
cwbl_op0_n100_an_s2_r100k wbl_op0_n100_an_s2_r100k 0 {C_WBL}
spa_op0_n100_an_s2_r100k prea rbl_op0_n100_an_s2_r100k ctl_op0_n100_an_s2_r100k 0 swpre
spr_op0_n100_an_s2_r100k pref ref_op0_n100_an_s2_r100k ctl_op0_n100_an_s2_r100k 0 swpre
crbl_op0_n100_an_s2_r100k rbl_op0_n100_an_s2_r100k 0 {C_RBL}
cref_op0_n100_an_s2_r100k ref_op0_n100_an_s2_r100k 0 {C_RBL}   $ ASSUMPTION: ideal matched dummy load
XMWR_op0_n100_an_s2_r100k_0 sn_op0_n100_an_s2_r100k_0 wwl_op0_n100_an_s2_r100k wbl_op0_n100_an_s2_r100k 0 sky130_fd_pr__nfet_01v8 L=0.15 W=0.42 nf=1 ad=0.1218 as=0.1218 pd=1.42 ps=1.42 nrd=0.69047619047619  nrs=0.69047619047619 sa=0 sb=0 sd=0 mult=1 m=1
XMRD_op0_n100_an_s2_r100k_0 rbl_op0_n100_an_s2_r100k sn_op0_n100_an_s2_r100k_0 rwls_op0_n100_an_s2_r100k 0 sky130_fd_pr__nfet_01v8 L=0.15 W=0.42 nf=1 ad=0.1218 as=0.1218 pd=1.42 ps=1.42 nrd=0.69047619047619  nrs=0.69047619047619 sa=0 sb=0 sd=0 mult=1 m=1
csn_op0_n100_an_s2_r100k_0 sn_op0_n100_an_s2_r100k_0 0 {C_SN}
XMWR_op0_n100_an_s2_r100k_1 sn_op0_n100_an_s2_r100k_1 wwl_des wbl_op0_n100_an_s2_r100k 0 sky130_fd_pr__nfet_01v8 L=0.15 W=0.42 nf=1 ad=0.1218 as=0.1218 pd=1.42 ps=1.42 nrd=0.69047619047619  nrs=0.69047619047619 sa=0 sb=0 sd=0 mult=1 m=1
XMRD_op0_n100_an_s2_r100k_1 rbl_op0_n100_an_s2_r100k sn_op0_n100_an_s2_r100k_1 rwl_des 0 sky130_fd_pr__nfet_01v8 L=0.15 W=0.42 nf=1 ad=0.1218 as=0.1218 pd=1.42 ps=1.42 nrd=0.69047619047619  nrs=0.69047619047619 sa=0 sb=0 sd=0 mult=1 m=1
csn_op0_n100_an_s2_r100k_1 sn_op0_n100_an_s2_r100k_1 0 {C_SN}
XMWR_op0_n100_an_s2_r100k_2 sn_op0_n100_an_s2_r100k_2 wwl_des wbl_op0_n100_an_s2_r100k 0 sky130_fd_pr__nfet_01v8 L=0.15 W=0.42 nf=1 ad=0.1218 as=0.1218 pd=1.42 ps=1.42 nrd=0.69047619047619  nrs=0.69047619047619 sa=0 sb=0 sd=0 mult=1 m=1
XMRD_op0_n100_an_s2_r100k_2 rbl_op0_n100_an_s2_r100k sn_op0_n100_an_s2_r100k_2 rwl_des 0 sky130_fd_pr__nfet_01v8 L=0.15 W=0.42 nf=1 ad=0.1218 as=0.1218 pd=1.42 ps=1.42 nrd=0.69047619047619  nrs=0.69047619047619 sa=0 sb=0 sd=0 mult=1 m=1
csn_op0_n100_an_s2_r100k_2 sn_op0_n100_an_s2_r100k_2 0 {C_SN}
XMWR_op0_n100_an_s2_r100k_3 sn_op0_n100_an_s2_r100k_3 wwl_des wbl_op0_n100_an_s2_r100k 0 sky130_fd_pr__nfet_01v8 L=0.15 W=0.42 nf=1 ad=0.1218 as=0.1218 pd=1.42 ps=1.42 nrd=0.69047619047619  nrs=0.69047619047619 sa=0 sb=0 sd=0 mult=1 m=1
XMRD_op0_n100_an_s2_r100k_3 rbl_op0_n100_an_s2_r100k sn_op0_n100_an_s2_r100k_3 rwl_des 0 sky130_fd_pr__nfet_01v8 L=0.15 W=0.42 nf=1 ad=0.1218 as=0.1218 pd=1.42 ps=1.42 nrd=0.69047619047619  nrs=0.69047619047619 sa=0 sb=0 sd=0 mult=1 m=1
csn_op0_n100_an_s2_r100k_3 sn_op0_n100_an_s2_r100k_3 0 {C_SN}
XMN1_op0_n100_an_s2_r100k rbl_op0_n100_an_s2_r100k ref_op0_n100_an_s2_r100k vn_op0_n100_an_s2_r100k 0 sky130_fd_pr__nfet_01v8 L=0.15 W=1 nf=1 ad=0.29 as=0.29 pd=2.58 ps=2.58 mult=1 m=1
XMN2_op0_n100_an_s2_r100k ref_op0_n100_an_s2_r100k rbl_op0_n100_an_s2_r100k vn_op0_n100_an_s2_r100k 0 sky130_fd_pr__nfet_01v8 L=0.15 W=1 nf=1 ad=0.29 as=0.29 pd=2.58 ps=2.58 mult=1 m=1
XMP1_op0_n100_an_s2_r100k rbl_op0_n100_an_s2_r100k ref_op0_n100_an_s2_r100k vp_op0_n100_an_s2_r100k vdd sky130_fd_pr__pfet_01v8 L=0.15 W=2 nf=1 ad=0.58 as=0.58 pd=4.58 ps=4.58 mult=1 m=1
XMP2_op0_n100_an_s2_r100k ref_op0_n100_an_s2_r100k rbl_op0_n100_an_s2_r100k vp_op0_n100_an_s2_r100k vdd sky130_fd_pr__pfet_01v8 L=0.15 W=2 nf=1 ad=0.58 as=0.58 pd=4.58 ps=4.58 mult=1 m=1
XMNF_op0_n100_an_s2_r100k vn_op0_n100_an_s2_r100k en_op0_n100_an_s2_r100k 0 0 sky130_fd_pr__nfet_01v8 L=0.15 W=2 nf=1 ad=0.58 as=0.58 pd=4.58 ps=4.58 mult=1 m=1
XMPH_op0_n100_an_s2_r100k vp_op0_n100_an_s2_r100k enb_op0_n100_an_s2_r100k vdd vdd sky130_fd_pr__pfet_01v8 L=0.15 W=4 nf=1 ad=1.16 as=1.16 pd=8.58 ps=8.58 mult=1 m=1
bd_op0_n100_an_s2_r100k d_op0_n100_an_s2_r100k 0 v=v(rbl_op0_n100_an_s2_r100k)-v(ref_op0_n100_an_s2_r100k)

* ---- instance 100: op0_0000_an_s2_r100k (variant an_s2_r100k; probe dec 14.9 ns, release 37 ns, meas 39 ns) ----
vctl_op0_0000_an_s2_r100k ctl_op0_0000_an_s2_r100k 0 pwl(0.0000e+00 {VDD} 2.0000e-09 {VDD} 2.1000e-09 0)
* RWL driver model (EXPERIMENTAL): slew 2 ns, series R 100000 ohm; cell pin = rwls_op0_0000_an_s2_r100k
vrs_op0_0000_an_s2_r100k rwlsrc_op0_0000_an_s2_r100k 0 pwl(0.0000e+00 {VDD} 4.0000e-09 {VDD} 6.0000e-09 0 3.7000e-08 0 3.9000e-08 {VDD})
rdrv_op0_0000_an_s2_r100k rwlsrc_op0_0000_an_s2_r100k rwls_op0_0000_an_s2_r100k 100000
ven_op0_0000_an_s2_r100k en_op0_0000_an_s2_r100k 0 pwl(0.0000e+00 0 1.4000e-08 0 1.4100e-08 {VDD} 3.7000e-08 {VDD} 3.7100e-08 0)
venb_op0_0000_an_s2_r100k enb_op0_0000_an_s2_r100k 0 pwl(0.0000e+00 {VDD} 1.4000e-08 {VDD} 1.4100e-08 0 3.7000e-08 0 3.7100e-08 {VDD})
vww_op0_0000_an_s2_r100k wwl_op0_0000_an_s2_r100k 0 pwl(0.0000e+00 0 1.5000e-08 0 1.5100e-08 {VDD} 3.5000e-08 {VDD} 3.5100e-08 0)
vwc_op0_0000_an_s2_r100k wbc_op0_0000_an_s2_r100k 0 pwl(0.0000e+00 0 1.5000e-08 0 1.5100e-08 {VDD} 3.7000e-08 {VDD} 3.7100e-08 0)
swb_op0_0000_an_s2_r100k ref_op0_0000_an_s2_r100k wbl_op0_0000_an_s2_r100k wbc_op0_0000_an_s2_r100k 0 swwbl
cwbl_op0_0000_an_s2_r100k wbl_op0_0000_an_s2_r100k 0 {C_WBL}
spa_op0_0000_an_s2_r100k prea rbl_op0_0000_an_s2_r100k ctl_op0_0000_an_s2_r100k 0 swpre
spr_op0_0000_an_s2_r100k pref ref_op0_0000_an_s2_r100k ctl_op0_0000_an_s2_r100k 0 swpre
crbl_op0_0000_an_s2_r100k rbl_op0_0000_an_s2_r100k 0 {C_RBL}
cref_op0_0000_an_s2_r100k ref_op0_0000_an_s2_r100k 0 {C_RBL}   $ ASSUMPTION: ideal matched dummy load
XMWR_op0_0000_an_s2_r100k_0 sn_op0_0000_an_s2_r100k_0 wwl_op0_0000_an_s2_r100k wbl_op0_0000_an_s2_r100k 0 sky130_fd_pr__nfet_01v8 L=0.15 W=0.42 nf=1 ad=0.1218 as=0.1218 pd=1.42 ps=1.42 nrd=0.69047619047619  nrs=0.69047619047619 sa=0 sb=0 sd=0 mult=1 m=1
XMRD_op0_0000_an_s2_r100k_0 rbl_op0_0000_an_s2_r100k sn_op0_0000_an_s2_r100k_0 rwls_op0_0000_an_s2_r100k 0 sky130_fd_pr__nfet_01v8 L=0.15 W=0.42 nf=1 ad=0.1218 as=0.1218 pd=1.42 ps=1.42 nrd=0.69047619047619  nrs=0.69047619047619 sa=0 sb=0 sd=0 mult=1 m=1
csn_op0_0000_an_s2_r100k_0 sn_op0_0000_an_s2_r100k_0 0 {C_SN}
XMWR_op0_0000_an_s2_r100k_1 sn_op0_0000_an_s2_r100k_1 wwl_des wbl_op0_0000_an_s2_r100k 0 sky130_fd_pr__nfet_01v8 L=0.15 W=0.42 nf=1 ad=0.1218 as=0.1218 pd=1.42 ps=1.42 nrd=0.69047619047619  nrs=0.69047619047619 sa=0 sb=0 sd=0 mult=1 m=1
XMRD_op0_0000_an_s2_r100k_1 rbl_op0_0000_an_s2_r100k sn_op0_0000_an_s2_r100k_1 rwl_des 0 sky130_fd_pr__nfet_01v8 L=0.15 W=0.42 nf=1 ad=0.1218 as=0.1218 pd=1.42 ps=1.42 nrd=0.69047619047619  nrs=0.69047619047619 sa=0 sb=0 sd=0 mult=1 m=1
csn_op0_0000_an_s2_r100k_1 sn_op0_0000_an_s2_r100k_1 0 {C_SN}
XMWR_op0_0000_an_s2_r100k_2 sn_op0_0000_an_s2_r100k_2 wwl_des wbl_op0_0000_an_s2_r100k 0 sky130_fd_pr__nfet_01v8 L=0.15 W=0.42 nf=1 ad=0.1218 as=0.1218 pd=1.42 ps=1.42 nrd=0.69047619047619  nrs=0.69047619047619 sa=0 sb=0 sd=0 mult=1 m=1
XMRD_op0_0000_an_s2_r100k_2 rbl_op0_0000_an_s2_r100k sn_op0_0000_an_s2_r100k_2 rwl_des 0 sky130_fd_pr__nfet_01v8 L=0.15 W=0.42 nf=1 ad=0.1218 as=0.1218 pd=1.42 ps=1.42 nrd=0.69047619047619  nrs=0.69047619047619 sa=0 sb=0 sd=0 mult=1 m=1
csn_op0_0000_an_s2_r100k_2 sn_op0_0000_an_s2_r100k_2 0 {C_SN}
XMWR_op0_0000_an_s2_r100k_3 sn_op0_0000_an_s2_r100k_3 wwl_des wbl_op0_0000_an_s2_r100k 0 sky130_fd_pr__nfet_01v8 L=0.15 W=0.42 nf=1 ad=0.1218 as=0.1218 pd=1.42 ps=1.42 nrd=0.69047619047619  nrs=0.69047619047619 sa=0 sb=0 sd=0 mult=1 m=1
XMRD_op0_0000_an_s2_r100k_3 rbl_op0_0000_an_s2_r100k sn_op0_0000_an_s2_r100k_3 rwl_des 0 sky130_fd_pr__nfet_01v8 L=0.15 W=0.42 nf=1 ad=0.1218 as=0.1218 pd=1.42 ps=1.42 nrd=0.69047619047619  nrs=0.69047619047619 sa=0 sb=0 sd=0 mult=1 m=1
csn_op0_0000_an_s2_r100k_3 sn_op0_0000_an_s2_r100k_3 0 {C_SN}
XMN1_op0_0000_an_s2_r100k rbl_op0_0000_an_s2_r100k ref_op0_0000_an_s2_r100k vn_op0_0000_an_s2_r100k 0 sky130_fd_pr__nfet_01v8 L=0.15 W=1 nf=1 ad=0.29 as=0.29 pd=2.58 ps=2.58 mult=1 m=1
XMN2_op0_0000_an_s2_r100k ref_op0_0000_an_s2_r100k rbl_op0_0000_an_s2_r100k vn_op0_0000_an_s2_r100k 0 sky130_fd_pr__nfet_01v8 L=0.15 W=1 nf=1 ad=0.29 as=0.29 pd=2.58 ps=2.58 mult=1 m=1
XMP1_op0_0000_an_s2_r100k rbl_op0_0000_an_s2_r100k ref_op0_0000_an_s2_r100k vp_op0_0000_an_s2_r100k vdd sky130_fd_pr__pfet_01v8 L=0.15 W=2 nf=1 ad=0.58 as=0.58 pd=4.58 ps=4.58 mult=1 m=1
XMP2_op0_0000_an_s2_r100k ref_op0_0000_an_s2_r100k rbl_op0_0000_an_s2_r100k vp_op0_0000_an_s2_r100k vdd sky130_fd_pr__pfet_01v8 L=0.15 W=2 nf=1 ad=0.58 as=0.58 pd=4.58 ps=4.58 mult=1 m=1
XMNF_op0_0000_an_s2_r100k vn_op0_0000_an_s2_r100k en_op0_0000_an_s2_r100k 0 0 sky130_fd_pr__nfet_01v8 L=0.15 W=2 nf=1 ad=0.58 as=0.58 pd=4.58 ps=4.58 mult=1 m=1
XMPH_op0_0000_an_s2_r100k vp_op0_0000_an_s2_r100k enb_op0_0000_an_s2_r100k vdd vdd sky130_fd_pr__pfet_01v8 L=0.15 W=4 nf=1 ad=1.16 as=1.16 pd=8.58 ps=8.58 mult=1 m=1
bd_op0_0000_an_s2_r100k d_op0_0000_an_s2_r100k 0 v=v(rbl_op0_0000_an_s2_r100k)-v(ref_op0_0000_an_s2_r100k)

* ---- instance 101: op1_0900_rh_s0p5_r0 (variant rh_s0p5_r0; probe dec 11.9 ns, release 34 ns, meas 36 ns) ----
vctl_op1_0900_rh_s0p5_r0 ctl_op1_0900_rh_s0p5_r0 0 pwl(0.0000e+00 {VDD} 2.0000e-09 {VDD} 2.1000e-09 0)
* RWL driver model (EXPERIMENTAL): slew 0.5 ns, series R 0 ohm; cell pin = rwls_op1_0900_rh_s0p5_r0
vrs_op1_0900_rh_s0p5_r0 rwls_op1_0900_rh_s0p5_r0 0 pwl(0.0000e+00 {VDD} 2.0000e-09 {VDD} 2.5000e-09 0 1.2000e-08 0 1.2500e-08 {VDD})
ven_op1_0900_rh_s0p5_r0 en_op1_0900_rh_s0p5_r0 0 pwl(0.0000e+00 0 1.1000e-08 0 1.1100e-08 {VDD} 3.4000e-08 {VDD} 3.4100e-08 0)
venb_op1_0900_rh_s0p5_r0 enb_op1_0900_rh_s0p5_r0 0 pwl(0.0000e+00 {VDD} 1.1000e-08 {VDD} 1.1100e-08 0 3.4000e-08 0 3.4100e-08 {VDD})
vww_op1_0900_rh_s0p5_r0 wwl_op1_0900_rh_s0p5_r0 0 pwl(0.0000e+00 0 1.2000e-08 0 1.2100e-08 {VDD} 3.2000e-08 {VDD} 3.2100e-08 0)
vwc_op1_0900_rh_s0p5_r0 wbc_op1_0900_rh_s0p5_r0 0 pwl(0.0000e+00 0 1.2000e-08 0 1.2100e-08 {VDD} 3.4000e-08 {VDD} 3.4100e-08 0)
swb_op1_0900_rh_s0p5_r0 ref_op1_0900_rh_s0p5_r0 wbl_op1_0900_rh_s0p5_r0 wbc_op1_0900_rh_s0p5_r0 0 swwbl
cwbl_op1_0900_rh_s0p5_r0 wbl_op1_0900_rh_s0p5_r0 0 {C_WBL}
spa_op1_0900_rh_s0p5_r0 prea rbl_op1_0900_rh_s0p5_r0 ctl_op1_0900_rh_s0p5_r0 0 swpre
spr_op1_0900_rh_s0p5_r0 pref ref_op1_0900_rh_s0p5_r0 ctl_op1_0900_rh_s0p5_r0 0 swpre
crbl_op1_0900_rh_s0p5_r0 rbl_op1_0900_rh_s0p5_r0 0 {C_RBL}
cref_op1_0900_rh_s0p5_r0 ref_op1_0900_rh_s0p5_r0 0 {C_RBL}   $ ASSUMPTION: ideal matched dummy load
XMWR_op1_0900_rh_s0p5_r0_0 sn_op1_0900_rh_s0p5_r0_0 wwl_op1_0900_rh_s0p5_r0 wbl_op1_0900_rh_s0p5_r0 0 sky130_fd_pr__nfet_01v8 L=0.15 W=0.42 nf=1 ad=0.1218 as=0.1218 pd=1.42 ps=1.42 nrd=0.69047619047619  nrs=0.69047619047619 sa=0 sb=0 sd=0 mult=1 m=1
XMRD_op1_0900_rh_s0p5_r0_0 rbl_op1_0900_rh_s0p5_r0 sn_op1_0900_rh_s0p5_r0_0 rwls_op1_0900_rh_s0p5_r0 0 sky130_fd_pr__nfet_01v8 L=0.15 W=0.42 nf=1 ad=0.1218 as=0.1218 pd=1.42 ps=1.42 nrd=0.69047619047619  nrs=0.69047619047619 sa=0 sb=0 sd=0 mult=1 m=1
csn_op1_0900_rh_s0p5_r0_0 sn_op1_0900_rh_s0p5_r0_0 0 {C_SN}
XMWR_op1_0900_rh_s0p5_r0_1 sn_op1_0900_rh_s0p5_r0_1 wwl_des wbl_op1_0900_rh_s0p5_r0 0 sky130_fd_pr__nfet_01v8 L=0.15 W=0.42 nf=1 ad=0.1218 as=0.1218 pd=1.42 ps=1.42 nrd=0.69047619047619  nrs=0.69047619047619 sa=0 sb=0 sd=0 mult=1 m=1
XMRD_op1_0900_rh_s0p5_r0_1 rbl_op1_0900_rh_s0p5_r0 sn_op1_0900_rh_s0p5_r0_1 rwl_des 0 sky130_fd_pr__nfet_01v8 L=0.15 W=0.42 nf=1 ad=0.1218 as=0.1218 pd=1.42 ps=1.42 nrd=0.69047619047619  nrs=0.69047619047619 sa=0 sb=0 sd=0 mult=1 m=1
csn_op1_0900_rh_s0p5_r0_1 sn_op1_0900_rh_s0p5_r0_1 0 {C_SN}
XMWR_op1_0900_rh_s0p5_r0_2 sn_op1_0900_rh_s0p5_r0_2 wwl_des wbl_op1_0900_rh_s0p5_r0 0 sky130_fd_pr__nfet_01v8 L=0.15 W=0.42 nf=1 ad=0.1218 as=0.1218 pd=1.42 ps=1.42 nrd=0.69047619047619  nrs=0.69047619047619 sa=0 sb=0 sd=0 mult=1 m=1
XMRD_op1_0900_rh_s0p5_r0_2 rbl_op1_0900_rh_s0p5_r0 sn_op1_0900_rh_s0p5_r0_2 rwl_des 0 sky130_fd_pr__nfet_01v8 L=0.15 W=0.42 nf=1 ad=0.1218 as=0.1218 pd=1.42 ps=1.42 nrd=0.69047619047619  nrs=0.69047619047619 sa=0 sb=0 sd=0 mult=1 m=1
csn_op1_0900_rh_s0p5_r0_2 sn_op1_0900_rh_s0p5_r0_2 0 {C_SN}
XMWR_op1_0900_rh_s0p5_r0_3 sn_op1_0900_rh_s0p5_r0_3 wwl_des wbl_op1_0900_rh_s0p5_r0 0 sky130_fd_pr__nfet_01v8 L=0.15 W=0.42 nf=1 ad=0.1218 as=0.1218 pd=1.42 ps=1.42 nrd=0.69047619047619  nrs=0.69047619047619 sa=0 sb=0 sd=0 mult=1 m=1
XMRD_op1_0900_rh_s0p5_r0_3 rbl_op1_0900_rh_s0p5_r0 sn_op1_0900_rh_s0p5_r0_3 rwl_des 0 sky130_fd_pr__nfet_01v8 L=0.15 W=0.42 nf=1 ad=0.1218 as=0.1218 pd=1.42 ps=1.42 nrd=0.69047619047619  nrs=0.69047619047619 sa=0 sb=0 sd=0 mult=1 m=1
csn_op1_0900_rh_s0p5_r0_3 sn_op1_0900_rh_s0p5_r0_3 0 {C_SN}
XMN1_op1_0900_rh_s0p5_r0 rbl_op1_0900_rh_s0p5_r0 ref_op1_0900_rh_s0p5_r0 vn_op1_0900_rh_s0p5_r0 0 sky130_fd_pr__nfet_01v8 L=0.15 W=1 nf=1 ad=0.29 as=0.29 pd=2.58 ps=2.58 mult=1 m=1
XMN2_op1_0900_rh_s0p5_r0 ref_op1_0900_rh_s0p5_r0 rbl_op1_0900_rh_s0p5_r0 vn_op1_0900_rh_s0p5_r0 0 sky130_fd_pr__nfet_01v8 L=0.15 W=1 nf=1 ad=0.29 as=0.29 pd=2.58 ps=2.58 mult=1 m=1
XMP1_op1_0900_rh_s0p5_r0 rbl_op1_0900_rh_s0p5_r0 ref_op1_0900_rh_s0p5_r0 vp_op1_0900_rh_s0p5_r0 vdd sky130_fd_pr__pfet_01v8 L=0.15 W=2 nf=1 ad=0.58 as=0.58 pd=4.58 ps=4.58 mult=1 m=1
XMP2_op1_0900_rh_s0p5_r0 ref_op1_0900_rh_s0p5_r0 rbl_op1_0900_rh_s0p5_r0 vp_op1_0900_rh_s0p5_r0 vdd sky130_fd_pr__pfet_01v8 L=0.15 W=2 nf=1 ad=0.58 as=0.58 pd=4.58 ps=4.58 mult=1 m=1
XMNF_op1_0900_rh_s0p5_r0 vn_op1_0900_rh_s0p5_r0 en_op1_0900_rh_s0p5_r0 0 0 sky130_fd_pr__nfet_01v8 L=0.15 W=2 nf=1 ad=0.58 as=0.58 pd=4.58 ps=4.58 mult=1 m=1
XMPH_op1_0900_rh_s0p5_r0 vp_op1_0900_rh_s0p5_r0 enb_op1_0900_rh_s0p5_r0 vdd vdd sky130_fd_pr__pfet_01v8 L=0.15 W=4 nf=1 ad=1.16 as=1.16 pd=8.58 ps=8.58 mult=1 m=1
bd_op1_0900_rh_s0p5_r0 d_op1_0900_rh_s0p5_r0 0 v=v(rbl_op1_0900_rh_s0p5_r0)-v(ref_op1_0900_rh_s0p5_r0)

* ---- instance 102: op1_1000_rh_s0p5_r0 (variant rh_s0p5_r0; probe dec 11.9 ns, release 34 ns, meas 36 ns) ----
vctl_op1_1000_rh_s0p5_r0 ctl_op1_1000_rh_s0p5_r0 0 pwl(0.0000e+00 {VDD} 2.0000e-09 {VDD} 2.1000e-09 0)
* RWL driver model (EXPERIMENTAL): slew 0.5 ns, series R 0 ohm; cell pin = rwls_op1_1000_rh_s0p5_r0
vrs_op1_1000_rh_s0p5_r0 rwls_op1_1000_rh_s0p5_r0 0 pwl(0.0000e+00 {VDD} 2.0000e-09 {VDD} 2.5000e-09 0 1.2000e-08 0 1.2500e-08 {VDD})
ven_op1_1000_rh_s0p5_r0 en_op1_1000_rh_s0p5_r0 0 pwl(0.0000e+00 0 1.1000e-08 0 1.1100e-08 {VDD} 3.4000e-08 {VDD} 3.4100e-08 0)
venb_op1_1000_rh_s0p5_r0 enb_op1_1000_rh_s0p5_r0 0 pwl(0.0000e+00 {VDD} 1.1000e-08 {VDD} 1.1100e-08 0 3.4000e-08 0 3.4100e-08 {VDD})
vww_op1_1000_rh_s0p5_r0 wwl_op1_1000_rh_s0p5_r0 0 pwl(0.0000e+00 0 1.2000e-08 0 1.2100e-08 {VDD} 3.2000e-08 {VDD} 3.2100e-08 0)
vwc_op1_1000_rh_s0p5_r0 wbc_op1_1000_rh_s0p5_r0 0 pwl(0.0000e+00 0 1.2000e-08 0 1.2100e-08 {VDD} 3.4000e-08 {VDD} 3.4100e-08 0)
swb_op1_1000_rh_s0p5_r0 ref_op1_1000_rh_s0p5_r0 wbl_op1_1000_rh_s0p5_r0 wbc_op1_1000_rh_s0p5_r0 0 swwbl
cwbl_op1_1000_rh_s0p5_r0 wbl_op1_1000_rh_s0p5_r0 0 {C_WBL}
spa_op1_1000_rh_s0p5_r0 prea rbl_op1_1000_rh_s0p5_r0 ctl_op1_1000_rh_s0p5_r0 0 swpre
spr_op1_1000_rh_s0p5_r0 pref ref_op1_1000_rh_s0p5_r0 ctl_op1_1000_rh_s0p5_r0 0 swpre
crbl_op1_1000_rh_s0p5_r0 rbl_op1_1000_rh_s0p5_r0 0 {C_RBL}
cref_op1_1000_rh_s0p5_r0 ref_op1_1000_rh_s0p5_r0 0 {C_RBL}   $ ASSUMPTION: ideal matched dummy load
XMWR_op1_1000_rh_s0p5_r0_0 sn_op1_1000_rh_s0p5_r0_0 wwl_op1_1000_rh_s0p5_r0 wbl_op1_1000_rh_s0p5_r0 0 sky130_fd_pr__nfet_01v8 L=0.15 W=0.42 nf=1 ad=0.1218 as=0.1218 pd=1.42 ps=1.42 nrd=0.69047619047619  nrs=0.69047619047619 sa=0 sb=0 sd=0 mult=1 m=1
XMRD_op1_1000_rh_s0p5_r0_0 rbl_op1_1000_rh_s0p5_r0 sn_op1_1000_rh_s0p5_r0_0 rwls_op1_1000_rh_s0p5_r0 0 sky130_fd_pr__nfet_01v8 L=0.15 W=0.42 nf=1 ad=0.1218 as=0.1218 pd=1.42 ps=1.42 nrd=0.69047619047619  nrs=0.69047619047619 sa=0 sb=0 sd=0 mult=1 m=1
csn_op1_1000_rh_s0p5_r0_0 sn_op1_1000_rh_s0p5_r0_0 0 {C_SN}
XMWR_op1_1000_rh_s0p5_r0_1 sn_op1_1000_rh_s0p5_r0_1 wwl_des wbl_op1_1000_rh_s0p5_r0 0 sky130_fd_pr__nfet_01v8 L=0.15 W=0.42 nf=1 ad=0.1218 as=0.1218 pd=1.42 ps=1.42 nrd=0.69047619047619  nrs=0.69047619047619 sa=0 sb=0 sd=0 mult=1 m=1
XMRD_op1_1000_rh_s0p5_r0_1 rbl_op1_1000_rh_s0p5_r0 sn_op1_1000_rh_s0p5_r0_1 rwl_des 0 sky130_fd_pr__nfet_01v8 L=0.15 W=0.42 nf=1 ad=0.1218 as=0.1218 pd=1.42 ps=1.42 nrd=0.69047619047619  nrs=0.69047619047619 sa=0 sb=0 sd=0 mult=1 m=1
csn_op1_1000_rh_s0p5_r0_1 sn_op1_1000_rh_s0p5_r0_1 0 {C_SN}
XMWR_op1_1000_rh_s0p5_r0_2 sn_op1_1000_rh_s0p5_r0_2 wwl_des wbl_op1_1000_rh_s0p5_r0 0 sky130_fd_pr__nfet_01v8 L=0.15 W=0.42 nf=1 ad=0.1218 as=0.1218 pd=1.42 ps=1.42 nrd=0.69047619047619  nrs=0.69047619047619 sa=0 sb=0 sd=0 mult=1 m=1
XMRD_op1_1000_rh_s0p5_r0_2 rbl_op1_1000_rh_s0p5_r0 sn_op1_1000_rh_s0p5_r0_2 rwl_des 0 sky130_fd_pr__nfet_01v8 L=0.15 W=0.42 nf=1 ad=0.1218 as=0.1218 pd=1.42 ps=1.42 nrd=0.69047619047619  nrs=0.69047619047619 sa=0 sb=0 sd=0 mult=1 m=1
csn_op1_1000_rh_s0p5_r0_2 sn_op1_1000_rh_s0p5_r0_2 0 {C_SN}
XMWR_op1_1000_rh_s0p5_r0_3 sn_op1_1000_rh_s0p5_r0_3 wwl_des wbl_op1_1000_rh_s0p5_r0 0 sky130_fd_pr__nfet_01v8 L=0.15 W=0.42 nf=1 ad=0.1218 as=0.1218 pd=1.42 ps=1.42 nrd=0.69047619047619  nrs=0.69047619047619 sa=0 sb=0 sd=0 mult=1 m=1
XMRD_op1_1000_rh_s0p5_r0_3 rbl_op1_1000_rh_s0p5_r0 sn_op1_1000_rh_s0p5_r0_3 rwl_des 0 sky130_fd_pr__nfet_01v8 L=0.15 W=0.42 nf=1 ad=0.1218 as=0.1218 pd=1.42 ps=1.42 nrd=0.69047619047619  nrs=0.69047619047619 sa=0 sb=0 sd=0 mult=1 m=1
csn_op1_1000_rh_s0p5_r0_3 sn_op1_1000_rh_s0p5_r0_3 0 {C_SN}
XMN1_op1_1000_rh_s0p5_r0 rbl_op1_1000_rh_s0p5_r0 ref_op1_1000_rh_s0p5_r0 vn_op1_1000_rh_s0p5_r0 0 sky130_fd_pr__nfet_01v8 L=0.15 W=1 nf=1 ad=0.29 as=0.29 pd=2.58 ps=2.58 mult=1 m=1
XMN2_op1_1000_rh_s0p5_r0 ref_op1_1000_rh_s0p5_r0 rbl_op1_1000_rh_s0p5_r0 vn_op1_1000_rh_s0p5_r0 0 sky130_fd_pr__nfet_01v8 L=0.15 W=1 nf=1 ad=0.29 as=0.29 pd=2.58 ps=2.58 mult=1 m=1
XMP1_op1_1000_rh_s0p5_r0 rbl_op1_1000_rh_s0p5_r0 ref_op1_1000_rh_s0p5_r0 vp_op1_1000_rh_s0p5_r0 vdd sky130_fd_pr__pfet_01v8 L=0.15 W=2 nf=1 ad=0.58 as=0.58 pd=4.58 ps=4.58 mult=1 m=1
XMP2_op1_1000_rh_s0p5_r0 ref_op1_1000_rh_s0p5_r0 rbl_op1_1000_rh_s0p5_r0 vp_op1_1000_rh_s0p5_r0 vdd sky130_fd_pr__pfet_01v8 L=0.15 W=2 nf=1 ad=0.58 as=0.58 pd=4.58 ps=4.58 mult=1 m=1
XMNF_op1_1000_rh_s0p5_r0 vn_op1_1000_rh_s0p5_r0 en_op1_1000_rh_s0p5_r0 0 0 sky130_fd_pr__nfet_01v8 L=0.15 W=2 nf=1 ad=0.58 as=0.58 pd=4.58 ps=4.58 mult=1 m=1
XMPH_op1_1000_rh_s0p5_r0 vp_op1_1000_rh_s0p5_r0 enb_op1_1000_rh_s0p5_r0 vdd vdd sky130_fd_pr__pfet_01v8 L=0.15 W=4 nf=1 ad=1.16 as=1.16 pd=8.58 ps=8.58 mult=1 m=1
bd_op1_1000_rh_s0p5_r0 d_op1_1000_rh_s0p5_r0 0 v=v(rbl_op1_1000_rh_s0p5_r0)-v(ref_op1_1000_rh_s0p5_r0)

* ---- instance 103: op0_n100_rh_s0p5_r0 (variant rh_s0p5_r0; probe dec 11.9 ns, release 34 ns, meas 36 ns) ----
vctl_op0_n100_rh_s0p5_r0 ctl_op0_n100_rh_s0p5_r0 0 pwl(0.0000e+00 {VDD} 2.0000e-09 {VDD} 2.1000e-09 0)
* RWL driver model (EXPERIMENTAL): slew 0.5 ns, series R 0 ohm; cell pin = rwls_op0_n100_rh_s0p5_r0
vrs_op0_n100_rh_s0p5_r0 rwls_op0_n100_rh_s0p5_r0 0 pwl(0.0000e+00 {VDD} 2.0000e-09 {VDD} 2.5000e-09 0 1.2000e-08 0 1.2500e-08 {VDD})
ven_op0_n100_rh_s0p5_r0 en_op0_n100_rh_s0p5_r0 0 pwl(0.0000e+00 0 1.1000e-08 0 1.1100e-08 {VDD} 3.4000e-08 {VDD} 3.4100e-08 0)
venb_op0_n100_rh_s0p5_r0 enb_op0_n100_rh_s0p5_r0 0 pwl(0.0000e+00 {VDD} 1.1000e-08 {VDD} 1.1100e-08 0 3.4000e-08 0 3.4100e-08 {VDD})
vww_op0_n100_rh_s0p5_r0 wwl_op0_n100_rh_s0p5_r0 0 pwl(0.0000e+00 0 1.2000e-08 0 1.2100e-08 {VDD} 3.2000e-08 {VDD} 3.2100e-08 0)
vwc_op0_n100_rh_s0p5_r0 wbc_op0_n100_rh_s0p5_r0 0 pwl(0.0000e+00 0 1.2000e-08 0 1.2100e-08 {VDD} 3.4000e-08 {VDD} 3.4100e-08 0)
swb_op0_n100_rh_s0p5_r0 ref_op0_n100_rh_s0p5_r0 wbl_op0_n100_rh_s0p5_r0 wbc_op0_n100_rh_s0p5_r0 0 swwbl
cwbl_op0_n100_rh_s0p5_r0 wbl_op0_n100_rh_s0p5_r0 0 {C_WBL}
spa_op0_n100_rh_s0p5_r0 prea rbl_op0_n100_rh_s0p5_r0 ctl_op0_n100_rh_s0p5_r0 0 swpre
spr_op0_n100_rh_s0p5_r0 pref ref_op0_n100_rh_s0p5_r0 ctl_op0_n100_rh_s0p5_r0 0 swpre
crbl_op0_n100_rh_s0p5_r0 rbl_op0_n100_rh_s0p5_r0 0 {C_RBL}
cref_op0_n100_rh_s0p5_r0 ref_op0_n100_rh_s0p5_r0 0 {C_RBL}   $ ASSUMPTION: ideal matched dummy load
XMWR_op0_n100_rh_s0p5_r0_0 sn_op0_n100_rh_s0p5_r0_0 wwl_op0_n100_rh_s0p5_r0 wbl_op0_n100_rh_s0p5_r0 0 sky130_fd_pr__nfet_01v8 L=0.15 W=0.42 nf=1 ad=0.1218 as=0.1218 pd=1.42 ps=1.42 nrd=0.69047619047619  nrs=0.69047619047619 sa=0 sb=0 sd=0 mult=1 m=1
XMRD_op0_n100_rh_s0p5_r0_0 rbl_op0_n100_rh_s0p5_r0 sn_op0_n100_rh_s0p5_r0_0 rwls_op0_n100_rh_s0p5_r0 0 sky130_fd_pr__nfet_01v8 L=0.15 W=0.42 nf=1 ad=0.1218 as=0.1218 pd=1.42 ps=1.42 nrd=0.69047619047619  nrs=0.69047619047619 sa=0 sb=0 sd=0 mult=1 m=1
csn_op0_n100_rh_s0p5_r0_0 sn_op0_n100_rh_s0p5_r0_0 0 {C_SN}
XMWR_op0_n100_rh_s0p5_r0_1 sn_op0_n100_rh_s0p5_r0_1 wwl_des wbl_op0_n100_rh_s0p5_r0 0 sky130_fd_pr__nfet_01v8 L=0.15 W=0.42 nf=1 ad=0.1218 as=0.1218 pd=1.42 ps=1.42 nrd=0.69047619047619  nrs=0.69047619047619 sa=0 sb=0 sd=0 mult=1 m=1
XMRD_op0_n100_rh_s0p5_r0_1 rbl_op0_n100_rh_s0p5_r0 sn_op0_n100_rh_s0p5_r0_1 rwl_des 0 sky130_fd_pr__nfet_01v8 L=0.15 W=0.42 nf=1 ad=0.1218 as=0.1218 pd=1.42 ps=1.42 nrd=0.69047619047619  nrs=0.69047619047619 sa=0 sb=0 sd=0 mult=1 m=1
csn_op0_n100_rh_s0p5_r0_1 sn_op0_n100_rh_s0p5_r0_1 0 {C_SN}
XMWR_op0_n100_rh_s0p5_r0_2 sn_op0_n100_rh_s0p5_r0_2 wwl_des wbl_op0_n100_rh_s0p5_r0 0 sky130_fd_pr__nfet_01v8 L=0.15 W=0.42 nf=1 ad=0.1218 as=0.1218 pd=1.42 ps=1.42 nrd=0.69047619047619  nrs=0.69047619047619 sa=0 sb=0 sd=0 mult=1 m=1
XMRD_op0_n100_rh_s0p5_r0_2 rbl_op0_n100_rh_s0p5_r0 sn_op0_n100_rh_s0p5_r0_2 rwl_des 0 sky130_fd_pr__nfet_01v8 L=0.15 W=0.42 nf=1 ad=0.1218 as=0.1218 pd=1.42 ps=1.42 nrd=0.69047619047619  nrs=0.69047619047619 sa=0 sb=0 sd=0 mult=1 m=1
csn_op0_n100_rh_s0p5_r0_2 sn_op0_n100_rh_s0p5_r0_2 0 {C_SN}
XMWR_op0_n100_rh_s0p5_r0_3 sn_op0_n100_rh_s0p5_r0_3 wwl_des wbl_op0_n100_rh_s0p5_r0 0 sky130_fd_pr__nfet_01v8 L=0.15 W=0.42 nf=1 ad=0.1218 as=0.1218 pd=1.42 ps=1.42 nrd=0.69047619047619  nrs=0.69047619047619 sa=0 sb=0 sd=0 mult=1 m=1
XMRD_op0_n100_rh_s0p5_r0_3 rbl_op0_n100_rh_s0p5_r0 sn_op0_n100_rh_s0p5_r0_3 rwl_des 0 sky130_fd_pr__nfet_01v8 L=0.15 W=0.42 nf=1 ad=0.1218 as=0.1218 pd=1.42 ps=1.42 nrd=0.69047619047619  nrs=0.69047619047619 sa=0 sb=0 sd=0 mult=1 m=1
csn_op0_n100_rh_s0p5_r0_3 sn_op0_n100_rh_s0p5_r0_3 0 {C_SN}
XMN1_op0_n100_rh_s0p5_r0 rbl_op0_n100_rh_s0p5_r0 ref_op0_n100_rh_s0p5_r0 vn_op0_n100_rh_s0p5_r0 0 sky130_fd_pr__nfet_01v8 L=0.15 W=1 nf=1 ad=0.29 as=0.29 pd=2.58 ps=2.58 mult=1 m=1
XMN2_op0_n100_rh_s0p5_r0 ref_op0_n100_rh_s0p5_r0 rbl_op0_n100_rh_s0p5_r0 vn_op0_n100_rh_s0p5_r0 0 sky130_fd_pr__nfet_01v8 L=0.15 W=1 nf=1 ad=0.29 as=0.29 pd=2.58 ps=2.58 mult=1 m=1
XMP1_op0_n100_rh_s0p5_r0 rbl_op0_n100_rh_s0p5_r0 ref_op0_n100_rh_s0p5_r0 vp_op0_n100_rh_s0p5_r0 vdd sky130_fd_pr__pfet_01v8 L=0.15 W=2 nf=1 ad=0.58 as=0.58 pd=4.58 ps=4.58 mult=1 m=1
XMP2_op0_n100_rh_s0p5_r0 ref_op0_n100_rh_s0p5_r0 rbl_op0_n100_rh_s0p5_r0 vp_op0_n100_rh_s0p5_r0 vdd sky130_fd_pr__pfet_01v8 L=0.15 W=2 nf=1 ad=0.58 as=0.58 pd=4.58 ps=4.58 mult=1 m=1
XMNF_op0_n100_rh_s0p5_r0 vn_op0_n100_rh_s0p5_r0 en_op0_n100_rh_s0p5_r0 0 0 sky130_fd_pr__nfet_01v8 L=0.15 W=2 nf=1 ad=0.58 as=0.58 pd=4.58 ps=4.58 mult=1 m=1
XMPH_op0_n100_rh_s0p5_r0 vp_op0_n100_rh_s0p5_r0 enb_op0_n100_rh_s0p5_r0 vdd vdd sky130_fd_pr__pfet_01v8 L=0.15 W=4 nf=1 ad=1.16 as=1.16 pd=8.58 ps=8.58 mult=1 m=1
bd_op0_n100_rh_s0p5_r0 d_op0_n100_rh_s0p5_r0 0 v=v(rbl_op0_n100_rh_s0p5_r0)-v(ref_op0_n100_rh_s0p5_r0)

* ---- instance 104: op0_0000_rh_s0p5_r0 (variant rh_s0p5_r0; probe dec 11.9 ns, release 34 ns, meas 36 ns) ----
vctl_op0_0000_rh_s0p5_r0 ctl_op0_0000_rh_s0p5_r0 0 pwl(0.0000e+00 {VDD} 2.0000e-09 {VDD} 2.1000e-09 0)
* RWL driver model (EXPERIMENTAL): slew 0.5 ns, series R 0 ohm; cell pin = rwls_op0_0000_rh_s0p5_r0
vrs_op0_0000_rh_s0p5_r0 rwls_op0_0000_rh_s0p5_r0 0 pwl(0.0000e+00 {VDD} 2.0000e-09 {VDD} 2.5000e-09 0 1.2000e-08 0 1.2500e-08 {VDD})
ven_op0_0000_rh_s0p5_r0 en_op0_0000_rh_s0p5_r0 0 pwl(0.0000e+00 0 1.1000e-08 0 1.1100e-08 {VDD} 3.4000e-08 {VDD} 3.4100e-08 0)
venb_op0_0000_rh_s0p5_r0 enb_op0_0000_rh_s0p5_r0 0 pwl(0.0000e+00 {VDD} 1.1000e-08 {VDD} 1.1100e-08 0 3.4000e-08 0 3.4100e-08 {VDD})
vww_op0_0000_rh_s0p5_r0 wwl_op0_0000_rh_s0p5_r0 0 pwl(0.0000e+00 0 1.2000e-08 0 1.2100e-08 {VDD} 3.2000e-08 {VDD} 3.2100e-08 0)
vwc_op0_0000_rh_s0p5_r0 wbc_op0_0000_rh_s0p5_r0 0 pwl(0.0000e+00 0 1.2000e-08 0 1.2100e-08 {VDD} 3.4000e-08 {VDD} 3.4100e-08 0)
swb_op0_0000_rh_s0p5_r0 ref_op0_0000_rh_s0p5_r0 wbl_op0_0000_rh_s0p5_r0 wbc_op0_0000_rh_s0p5_r0 0 swwbl
cwbl_op0_0000_rh_s0p5_r0 wbl_op0_0000_rh_s0p5_r0 0 {C_WBL}
spa_op0_0000_rh_s0p5_r0 prea rbl_op0_0000_rh_s0p5_r0 ctl_op0_0000_rh_s0p5_r0 0 swpre
spr_op0_0000_rh_s0p5_r0 pref ref_op0_0000_rh_s0p5_r0 ctl_op0_0000_rh_s0p5_r0 0 swpre
crbl_op0_0000_rh_s0p5_r0 rbl_op0_0000_rh_s0p5_r0 0 {C_RBL}
cref_op0_0000_rh_s0p5_r0 ref_op0_0000_rh_s0p5_r0 0 {C_RBL}   $ ASSUMPTION: ideal matched dummy load
XMWR_op0_0000_rh_s0p5_r0_0 sn_op0_0000_rh_s0p5_r0_0 wwl_op0_0000_rh_s0p5_r0 wbl_op0_0000_rh_s0p5_r0 0 sky130_fd_pr__nfet_01v8 L=0.15 W=0.42 nf=1 ad=0.1218 as=0.1218 pd=1.42 ps=1.42 nrd=0.69047619047619  nrs=0.69047619047619 sa=0 sb=0 sd=0 mult=1 m=1
XMRD_op0_0000_rh_s0p5_r0_0 rbl_op0_0000_rh_s0p5_r0 sn_op0_0000_rh_s0p5_r0_0 rwls_op0_0000_rh_s0p5_r0 0 sky130_fd_pr__nfet_01v8 L=0.15 W=0.42 nf=1 ad=0.1218 as=0.1218 pd=1.42 ps=1.42 nrd=0.69047619047619  nrs=0.69047619047619 sa=0 sb=0 sd=0 mult=1 m=1
csn_op0_0000_rh_s0p5_r0_0 sn_op0_0000_rh_s0p5_r0_0 0 {C_SN}
XMWR_op0_0000_rh_s0p5_r0_1 sn_op0_0000_rh_s0p5_r0_1 wwl_des wbl_op0_0000_rh_s0p5_r0 0 sky130_fd_pr__nfet_01v8 L=0.15 W=0.42 nf=1 ad=0.1218 as=0.1218 pd=1.42 ps=1.42 nrd=0.69047619047619  nrs=0.69047619047619 sa=0 sb=0 sd=0 mult=1 m=1
XMRD_op0_0000_rh_s0p5_r0_1 rbl_op0_0000_rh_s0p5_r0 sn_op0_0000_rh_s0p5_r0_1 rwl_des 0 sky130_fd_pr__nfet_01v8 L=0.15 W=0.42 nf=1 ad=0.1218 as=0.1218 pd=1.42 ps=1.42 nrd=0.69047619047619  nrs=0.69047619047619 sa=0 sb=0 sd=0 mult=1 m=1
csn_op0_0000_rh_s0p5_r0_1 sn_op0_0000_rh_s0p5_r0_1 0 {C_SN}
XMWR_op0_0000_rh_s0p5_r0_2 sn_op0_0000_rh_s0p5_r0_2 wwl_des wbl_op0_0000_rh_s0p5_r0 0 sky130_fd_pr__nfet_01v8 L=0.15 W=0.42 nf=1 ad=0.1218 as=0.1218 pd=1.42 ps=1.42 nrd=0.69047619047619  nrs=0.69047619047619 sa=0 sb=0 sd=0 mult=1 m=1
XMRD_op0_0000_rh_s0p5_r0_2 rbl_op0_0000_rh_s0p5_r0 sn_op0_0000_rh_s0p5_r0_2 rwl_des 0 sky130_fd_pr__nfet_01v8 L=0.15 W=0.42 nf=1 ad=0.1218 as=0.1218 pd=1.42 ps=1.42 nrd=0.69047619047619  nrs=0.69047619047619 sa=0 sb=0 sd=0 mult=1 m=1
csn_op0_0000_rh_s0p5_r0_2 sn_op0_0000_rh_s0p5_r0_2 0 {C_SN}
XMWR_op0_0000_rh_s0p5_r0_3 sn_op0_0000_rh_s0p5_r0_3 wwl_des wbl_op0_0000_rh_s0p5_r0 0 sky130_fd_pr__nfet_01v8 L=0.15 W=0.42 nf=1 ad=0.1218 as=0.1218 pd=1.42 ps=1.42 nrd=0.69047619047619  nrs=0.69047619047619 sa=0 sb=0 sd=0 mult=1 m=1
XMRD_op0_0000_rh_s0p5_r0_3 rbl_op0_0000_rh_s0p5_r0 sn_op0_0000_rh_s0p5_r0_3 rwl_des 0 sky130_fd_pr__nfet_01v8 L=0.15 W=0.42 nf=1 ad=0.1218 as=0.1218 pd=1.42 ps=1.42 nrd=0.69047619047619  nrs=0.69047619047619 sa=0 sb=0 sd=0 mult=1 m=1
csn_op0_0000_rh_s0p5_r0_3 sn_op0_0000_rh_s0p5_r0_3 0 {C_SN}
XMN1_op0_0000_rh_s0p5_r0 rbl_op0_0000_rh_s0p5_r0 ref_op0_0000_rh_s0p5_r0 vn_op0_0000_rh_s0p5_r0 0 sky130_fd_pr__nfet_01v8 L=0.15 W=1 nf=1 ad=0.29 as=0.29 pd=2.58 ps=2.58 mult=1 m=1
XMN2_op0_0000_rh_s0p5_r0 ref_op0_0000_rh_s0p5_r0 rbl_op0_0000_rh_s0p5_r0 vn_op0_0000_rh_s0p5_r0 0 sky130_fd_pr__nfet_01v8 L=0.15 W=1 nf=1 ad=0.29 as=0.29 pd=2.58 ps=2.58 mult=1 m=1
XMP1_op0_0000_rh_s0p5_r0 rbl_op0_0000_rh_s0p5_r0 ref_op0_0000_rh_s0p5_r0 vp_op0_0000_rh_s0p5_r0 vdd sky130_fd_pr__pfet_01v8 L=0.15 W=2 nf=1 ad=0.58 as=0.58 pd=4.58 ps=4.58 mult=1 m=1
XMP2_op0_0000_rh_s0p5_r0 ref_op0_0000_rh_s0p5_r0 rbl_op0_0000_rh_s0p5_r0 vp_op0_0000_rh_s0p5_r0 vdd sky130_fd_pr__pfet_01v8 L=0.15 W=2 nf=1 ad=0.58 as=0.58 pd=4.58 ps=4.58 mult=1 m=1
XMNF_op0_0000_rh_s0p5_r0 vn_op0_0000_rh_s0p5_r0 en_op0_0000_rh_s0p5_r0 0 0 sky130_fd_pr__nfet_01v8 L=0.15 W=2 nf=1 ad=0.58 as=0.58 pd=4.58 ps=4.58 mult=1 m=1
XMPH_op0_0000_rh_s0p5_r0 vp_op0_0000_rh_s0p5_r0 enb_op0_0000_rh_s0p5_r0 vdd vdd sky130_fd_pr__pfet_01v8 L=0.15 W=4 nf=1 ad=1.16 as=1.16 pd=8.58 ps=8.58 mult=1 m=1
bd_op0_0000_rh_s0p5_r0 d_op0_0000_rh_s0p5_r0 0 v=v(rbl_op0_0000_rh_s0p5_r0)-v(ref_op0_0000_rh_s0p5_r0)

* ---- instance 105: op1_0900_rh_s1_r0 (variant rh_s1_r0; probe dec 11.9 ns, release 34 ns, meas 36 ns) ----
vctl_op1_0900_rh_s1_r0 ctl_op1_0900_rh_s1_r0 0 pwl(0.0000e+00 {VDD} 2.0000e-09 {VDD} 2.1000e-09 0)
* RWL driver model (EXPERIMENTAL): slew 1 ns, series R 0 ohm; cell pin = rwls_op1_0900_rh_s1_r0
vrs_op1_0900_rh_s1_r0 rwls_op1_0900_rh_s1_r0 0 pwl(0.0000e+00 {VDD} 2.0000e-09 {VDD} 3.0000e-09 0 1.2000e-08 0 1.3000e-08 {VDD})
ven_op1_0900_rh_s1_r0 en_op1_0900_rh_s1_r0 0 pwl(0.0000e+00 0 1.1000e-08 0 1.1100e-08 {VDD} 3.4000e-08 {VDD} 3.4100e-08 0)
venb_op1_0900_rh_s1_r0 enb_op1_0900_rh_s1_r0 0 pwl(0.0000e+00 {VDD} 1.1000e-08 {VDD} 1.1100e-08 0 3.4000e-08 0 3.4100e-08 {VDD})
vww_op1_0900_rh_s1_r0 wwl_op1_0900_rh_s1_r0 0 pwl(0.0000e+00 0 1.2000e-08 0 1.2100e-08 {VDD} 3.2000e-08 {VDD} 3.2100e-08 0)
vwc_op1_0900_rh_s1_r0 wbc_op1_0900_rh_s1_r0 0 pwl(0.0000e+00 0 1.2000e-08 0 1.2100e-08 {VDD} 3.4000e-08 {VDD} 3.4100e-08 0)
swb_op1_0900_rh_s1_r0 ref_op1_0900_rh_s1_r0 wbl_op1_0900_rh_s1_r0 wbc_op1_0900_rh_s1_r0 0 swwbl
cwbl_op1_0900_rh_s1_r0 wbl_op1_0900_rh_s1_r0 0 {C_WBL}
spa_op1_0900_rh_s1_r0 prea rbl_op1_0900_rh_s1_r0 ctl_op1_0900_rh_s1_r0 0 swpre
spr_op1_0900_rh_s1_r0 pref ref_op1_0900_rh_s1_r0 ctl_op1_0900_rh_s1_r0 0 swpre
crbl_op1_0900_rh_s1_r0 rbl_op1_0900_rh_s1_r0 0 {C_RBL}
cref_op1_0900_rh_s1_r0 ref_op1_0900_rh_s1_r0 0 {C_RBL}   $ ASSUMPTION: ideal matched dummy load
XMWR_op1_0900_rh_s1_r0_0 sn_op1_0900_rh_s1_r0_0 wwl_op1_0900_rh_s1_r0 wbl_op1_0900_rh_s1_r0 0 sky130_fd_pr__nfet_01v8 L=0.15 W=0.42 nf=1 ad=0.1218 as=0.1218 pd=1.42 ps=1.42 nrd=0.69047619047619  nrs=0.69047619047619 sa=0 sb=0 sd=0 mult=1 m=1
XMRD_op1_0900_rh_s1_r0_0 rbl_op1_0900_rh_s1_r0 sn_op1_0900_rh_s1_r0_0 rwls_op1_0900_rh_s1_r0 0 sky130_fd_pr__nfet_01v8 L=0.15 W=0.42 nf=1 ad=0.1218 as=0.1218 pd=1.42 ps=1.42 nrd=0.69047619047619  nrs=0.69047619047619 sa=0 sb=0 sd=0 mult=1 m=1
csn_op1_0900_rh_s1_r0_0 sn_op1_0900_rh_s1_r0_0 0 {C_SN}
XMWR_op1_0900_rh_s1_r0_1 sn_op1_0900_rh_s1_r0_1 wwl_des wbl_op1_0900_rh_s1_r0 0 sky130_fd_pr__nfet_01v8 L=0.15 W=0.42 nf=1 ad=0.1218 as=0.1218 pd=1.42 ps=1.42 nrd=0.69047619047619  nrs=0.69047619047619 sa=0 sb=0 sd=0 mult=1 m=1
XMRD_op1_0900_rh_s1_r0_1 rbl_op1_0900_rh_s1_r0 sn_op1_0900_rh_s1_r0_1 rwl_des 0 sky130_fd_pr__nfet_01v8 L=0.15 W=0.42 nf=1 ad=0.1218 as=0.1218 pd=1.42 ps=1.42 nrd=0.69047619047619  nrs=0.69047619047619 sa=0 sb=0 sd=0 mult=1 m=1
csn_op1_0900_rh_s1_r0_1 sn_op1_0900_rh_s1_r0_1 0 {C_SN}
XMWR_op1_0900_rh_s1_r0_2 sn_op1_0900_rh_s1_r0_2 wwl_des wbl_op1_0900_rh_s1_r0 0 sky130_fd_pr__nfet_01v8 L=0.15 W=0.42 nf=1 ad=0.1218 as=0.1218 pd=1.42 ps=1.42 nrd=0.69047619047619  nrs=0.69047619047619 sa=0 sb=0 sd=0 mult=1 m=1
XMRD_op1_0900_rh_s1_r0_2 rbl_op1_0900_rh_s1_r0 sn_op1_0900_rh_s1_r0_2 rwl_des 0 sky130_fd_pr__nfet_01v8 L=0.15 W=0.42 nf=1 ad=0.1218 as=0.1218 pd=1.42 ps=1.42 nrd=0.69047619047619  nrs=0.69047619047619 sa=0 sb=0 sd=0 mult=1 m=1
csn_op1_0900_rh_s1_r0_2 sn_op1_0900_rh_s1_r0_2 0 {C_SN}
XMWR_op1_0900_rh_s1_r0_3 sn_op1_0900_rh_s1_r0_3 wwl_des wbl_op1_0900_rh_s1_r0 0 sky130_fd_pr__nfet_01v8 L=0.15 W=0.42 nf=1 ad=0.1218 as=0.1218 pd=1.42 ps=1.42 nrd=0.69047619047619  nrs=0.69047619047619 sa=0 sb=0 sd=0 mult=1 m=1
XMRD_op1_0900_rh_s1_r0_3 rbl_op1_0900_rh_s1_r0 sn_op1_0900_rh_s1_r0_3 rwl_des 0 sky130_fd_pr__nfet_01v8 L=0.15 W=0.42 nf=1 ad=0.1218 as=0.1218 pd=1.42 ps=1.42 nrd=0.69047619047619  nrs=0.69047619047619 sa=0 sb=0 sd=0 mult=1 m=1
csn_op1_0900_rh_s1_r0_3 sn_op1_0900_rh_s1_r0_3 0 {C_SN}
XMN1_op1_0900_rh_s1_r0 rbl_op1_0900_rh_s1_r0 ref_op1_0900_rh_s1_r0 vn_op1_0900_rh_s1_r0 0 sky130_fd_pr__nfet_01v8 L=0.15 W=1 nf=1 ad=0.29 as=0.29 pd=2.58 ps=2.58 mult=1 m=1
XMN2_op1_0900_rh_s1_r0 ref_op1_0900_rh_s1_r0 rbl_op1_0900_rh_s1_r0 vn_op1_0900_rh_s1_r0 0 sky130_fd_pr__nfet_01v8 L=0.15 W=1 nf=1 ad=0.29 as=0.29 pd=2.58 ps=2.58 mult=1 m=1
XMP1_op1_0900_rh_s1_r0 rbl_op1_0900_rh_s1_r0 ref_op1_0900_rh_s1_r0 vp_op1_0900_rh_s1_r0 vdd sky130_fd_pr__pfet_01v8 L=0.15 W=2 nf=1 ad=0.58 as=0.58 pd=4.58 ps=4.58 mult=1 m=1
XMP2_op1_0900_rh_s1_r0 ref_op1_0900_rh_s1_r0 rbl_op1_0900_rh_s1_r0 vp_op1_0900_rh_s1_r0 vdd sky130_fd_pr__pfet_01v8 L=0.15 W=2 nf=1 ad=0.58 as=0.58 pd=4.58 ps=4.58 mult=1 m=1
XMNF_op1_0900_rh_s1_r0 vn_op1_0900_rh_s1_r0 en_op1_0900_rh_s1_r0 0 0 sky130_fd_pr__nfet_01v8 L=0.15 W=2 nf=1 ad=0.58 as=0.58 pd=4.58 ps=4.58 mult=1 m=1
XMPH_op1_0900_rh_s1_r0 vp_op1_0900_rh_s1_r0 enb_op1_0900_rh_s1_r0 vdd vdd sky130_fd_pr__pfet_01v8 L=0.15 W=4 nf=1 ad=1.16 as=1.16 pd=8.58 ps=8.58 mult=1 m=1
bd_op1_0900_rh_s1_r0 d_op1_0900_rh_s1_r0 0 v=v(rbl_op1_0900_rh_s1_r0)-v(ref_op1_0900_rh_s1_r0)

* ---- instance 106: op1_1000_rh_s1_r0 (variant rh_s1_r0; probe dec 11.9 ns, release 34 ns, meas 36 ns) ----
vctl_op1_1000_rh_s1_r0 ctl_op1_1000_rh_s1_r0 0 pwl(0.0000e+00 {VDD} 2.0000e-09 {VDD} 2.1000e-09 0)
* RWL driver model (EXPERIMENTAL): slew 1 ns, series R 0 ohm; cell pin = rwls_op1_1000_rh_s1_r0
vrs_op1_1000_rh_s1_r0 rwls_op1_1000_rh_s1_r0 0 pwl(0.0000e+00 {VDD} 2.0000e-09 {VDD} 3.0000e-09 0 1.2000e-08 0 1.3000e-08 {VDD})
ven_op1_1000_rh_s1_r0 en_op1_1000_rh_s1_r0 0 pwl(0.0000e+00 0 1.1000e-08 0 1.1100e-08 {VDD} 3.4000e-08 {VDD} 3.4100e-08 0)
venb_op1_1000_rh_s1_r0 enb_op1_1000_rh_s1_r0 0 pwl(0.0000e+00 {VDD} 1.1000e-08 {VDD} 1.1100e-08 0 3.4000e-08 0 3.4100e-08 {VDD})
vww_op1_1000_rh_s1_r0 wwl_op1_1000_rh_s1_r0 0 pwl(0.0000e+00 0 1.2000e-08 0 1.2100e-08 {VDD} 3.2000e-08 {VDD} 3.2100e-08 0)
vwc_op1_1000_rh_s1_r0 wbc_op1_1000_rh_s1_r0 0 pwl(0.0000e+00 0 1.2000e-08 0 1.2100e-08 {VDD} 3.4000e-08 {VDD} 3.4100e-08 0)
swb_op1_1000_rh_s1_r0 ref_op1_1000_rh_s1_r0 wbl_op1_1000_rh_s1_r0 wbc_op1_1000_rh_s1_r0 0 swwbl
cwbl_op1_1000_rh_s1_r0 wbl_op1_1000_rh_s1_r0 0 {C_WBL}
spa_op1_1000_rh_s1_r0 prea rbl_op1_1000_rh_s1_r0 ctl_op1_1000_rh_s1_r0 0 swpre
spr_op1_1000_rh_s1_r0 pref ref_op1_1000_rh_s1_r0 ctl_op1_1000_rh_s1_r0 0 swpre
crbl_op1_1000_rh_s1_r0 rbl_op1_1000_rh_s1_r0 0 {C_RBL}
cref_op1_1000_rh_s1_r0 ref_op1_1000_rh_s1_r0 0 {C_RBL}   $ ASSUMPTION: ideal matched dummy load
XMWR_op1_1000_rh_s1_r0_0 sn_op1_1000_rh_s1_r0_0 wwl_op1_1000_rh_s1_r0 wbl_op1_1000_rh_s1_r0 0 sky130_fd_pr__nfet_01v8 L=0.15 W=0.42 nf=1 ad=0.1218 as=0.1218 pd=1.42 ps=1.42 nrd=0.69047619047619  nrs=0.69047619047619 sa=0 sb=0 sd=0 mult=1 m=1
XMRD_op1_1000_rh_s1_r0_0 rbl_op1_1000_rh_s1_r0 sn_op1_1000_rh_s1_r0_0 rwls_op1_1000_rh_s1_r0 0 sky130_fd_pr__nfet_01v8 L=0.15 W=0.42 nf=1 ad=0.1218 as=0.1218 pd=1.42 ps=1.42 nrd=0.69047619047619  nrs=0.69047619047619 sa=0 sb=0 sd=0 mult=1 m=1
csn_op1_1000_rh_s1_r0_0 sn_op1_1000_rh_s1_r0_0 0 {C_SN}
XMWR_op1_1000_rh_s1_r0_1 sn_op1_1000_rh_s1_r0_1 wwl_des wbl_op1_1000_rh_s1_r0 0 sky130_fd_pr__nfet_01v8 L=0.15 W=0.42 nf=1 ad=0.1218 as=0.1218 pd=1.42 ps=1.42 nrd=0.69047619047619  nrs=0.69047619047619 sa=0 sb=0 sd=0 mult=1 m=1
XMRD_op1_1000_rh_s1_r0_1 rbl_op1_1000_rh_s1_r0 sn_op1_1000_rh_s1_r0_1 rwl_des 0 sky130_fd_pr__nfet_01v8 L=0.15 W=0.42 nf=1 ad=0.1218 as=0.1218 pd=1.42 ps=1.42 nrd=0.69047619047619  nrs=0.69047619047619 sa=0 sb=0 sd=0 mult=1 m=1
csn_op1_1000_rh_s1_r0_1 sn_op1_1000_rh_s1_r0_1 0 {C_SN}
XMWR_op1_1000_rh_s1_r0_2 sn_op1_1000_rh_s1_r0_2 wwl_des wbl_op1_1000_rh_s1_r0 0 sky130_fd_pr__nfet_01v8 L=0.15 W=0.42 nf=1 ad=0.1218 as=0.1218 pd=1.42 ps=1.42 nrd=0.69047619047619  nrs=0.69047619047619 sa=0 sb=0 sd=0 mult=1 m=1
XMRD_op1_1000_rh_s1_r0_2 rbl_op1_1000_rh_s1_r0 sn_op1_1000_rh_s1_r0_2 rwl_des 0 sky130_fd_pr__nfet_01v8 L=0.15 W=0.42 nf=1 ad=0.1218 as=0.1218 pd=1.42 ps=1.42 nrd=0.69047619047619  nrs=0.69047619047619 sa=0 sb=0 sd=0 mult=1 m=1
csn_op1_1000_rh_s1_r0_2 sn_op1_1000_rh_s1_r0_2 0 {C_SN}
XMWR_op1_1000_rh_s1_r0_3 sn_op1_1000_rh_s1_r0_3 wwl_des wbl_op1_1000_rh_s1_r0 0 sky130_fd_pr__nfet_01v8 L=0.15 W=0.42 nf=1 ad=0.1218 as=0.1218 pd=1.42 ps=1.42 nrd=0.69047619047619  nrs=0.69047619047619 sa=0 sb=0 sd=0 mult=1 m=1
XMRD_op1_1000_rh_s1_r0_3 rbl_op1_1000_rh_s1_r0 sn_op1_1000_rh_s1_r0_3 rwl_des 0 sky130_fd_pr__nfet_01v8 L=0.15 W=0.42 nf=1 ad=0.1218 as=0.1218 pd=1.42 ps=1.42 nrd=0.69047619047619  nrs=0.69047619047619 sa=0 sb=0 sd=0 mult=1 m=1
csn_op1_1000_rh_s1_r0_3 sn_op1_1000_rh_s1_r0_3 0 {C_SN}
XMN1_op1_1000_rh_s1_r0 rbl_op1_1000_rh_s1_r0 ref_op1_1000_rh_s1_r0 vn_op1_1000_rh_s1_r0 0 sky130_fd_pr__nfet_01v8 L=0.15 W=1 nf=1 ad=0.29 as=0.29 pd=2.58 ps=2.58 mult=1 m=1
XMN2_op1_1000_rh_s1_r0 ref_op1_1000_rh_s1_r0 rbl_op1_1000_rh_s1_r0 vn_op1_1000_rh_s1_r0 0 sky130_fd_pr__nfet_01v8 L=0.15 W=1 nf=1 ad=0.29 as=0.29 pd=2.58 ps=2.58 mult=1 m=1
XMP1_op1_1000_rh_s1_r0 rbl_op1_1000_rh_s1_r0 ref_op1_1000_rh_s1_r0 vp_op1_1000_rh_s1_r0 vdd sky130_fd_pr__pfet_01v8 L=0.15 W=2 nf=1 ad=0.58 as=0.58 pd=4.58 ps=4.58 mult=1 m=1
XMP2_op1_1000_rh_s1_r0 ref_op1_1000_rh_s1_r0 rbl_op1_1000_rh_s1_r0 vp_op1_1000_rh_s1_r0 vdd sky130_fd_pr__pfet_01v8 L=0.15 W=2 nf=1 ad=0.58 as=0.58 pd=4.58 ps=4.58 mult=1 m=1
XMNF_op1_1000_rh_s1_r0 vn_op1_1000_rh_s1_r0 en_op1_1000_rh_s1_r0 0 0 sky130_fd_pr__nfet_01v8 L=0.15 W=2 nf=1 ad=0.58 as=0.58 pd=4.58 ps=4.58 mult=1 m=1
XMPH_op1_1000_rh_s1_r0 vp_op1_1000_rh_s1_r0 enb_op1_1000_rh_s1_r0 vdd vdd sky130_fd_pr__pfet_01v8 L=0.15 W=4 nf=1 ad=1.16 as=1.16 pd=8.58 ps=8.58 mult=1 m=1
bd_op1_1000_rh_s1_r0 d_op1_1000_rh_s1_r0 0 v=v(rbl_op1_1000_rh_s1_r0)-v(ref_op1_1000_rh_s1_r0)

* ---- instance 107: op0_n100_rh_s1_r0 (variant rh_s1_r0; probe dec 11.9 ns, release 34 ns, meas 36 ns) ----
vctl_op0_n100_rh_s1_r0 ctl_op0_n100_rh_s1_r0 0 pwl(0.0000e+00 {VDD} 2.0000e-09 {VDD} 2.1000e-09 0)
* RWL driver model (EXPERIMENTAL): slew 1 ns, series R 0 ohm; cell pin = rwls_op0_n100_rh_s1_r0
vrs_op0_n100_rh_s1_r0 rwls_op0_n100_rh_s1_r0 0 pwl(0.0000e+00 {VDD} 2.0000e-09 {VDD} 3.0000e-09 0 1.2000e-08 0 1.3000e-08 {VDD})
ven_op0_n100_rh_s1_r0 en_op0_n100_rh_s1_r0 0 pwl(0.0000e+00 0 1.1000e-08 0 1.1100e-08 {VDD} 3.4000e-08 {VDD} 3.4100e-08 0)
venb_op0_n100_rh_s1_r0 enb_op0_n100_rh_s1_r0 0 pwl(0.0000e+00 {VDD} 1.1000e-08 {VDD} 1.1100e-08 0 3.4000e-08 0 3.4100e-08 {VDD})
vww_op0_n100_rh_s1_r0 wwl_op0_n100_rh_s1_r0 0 pwl(0.0000e+00 0 1.2000e-08 0 1.2100e-08 {VDD} 3.2000e-08 {VDD} 3.2100e-08 0)
vwc_op0_n100_rh_s1_r0 wbc_op0_n100_rh_s1_r0 0 pwl(0.0000e+00 0 1.2000e-08 0 1.2100e-08 {VDD} 3.4000e-08 {VDD} 3.4100e-08 0)
swb_op0_n100_rh_s1_r0 ref_op0_n100_rh_s1_r0 wbl_op0_n100_rh_s1_r0 wbc_op0_n100_rh_s1_r0 0 swwbl
cwbl_op0_n100_rh_s1_r0 wbl_op0_n100_rh_s1_r0 0 {C_WBL}
spa_op0_n100_rh_s1_r0 prea rbl_op0_n100_rh_s1_r0 ctl_op0_n100_rh_s1_r0 0 swpre
spr_op0_n100_rh_s1_r0 pref ref_op0_n100_rh_s1_r0 ctl_op0_n100_rh_s1_r0 0 swpre
crbl_op0_n100_rh_s1_r0 rbl_op0_n100_rh_s1_r0 0 {C_RBL}
cref_op0_n100_rh_s1_r0 ref_op0_n100_rh_s1_r0 0 {C_RBL}   $ ASSUMPTION: ideal matched dummy load
XMWR_op0_n100_rh_s1_r0_0 sn_op0_n100_rh_s1_r0_0 wwl_op0_n100_rh_s1_r0 wbl_op0_n100_rh_s1_r0 0 sky130_fd_pr__nfet_01v8 L=0.15 W=0.42 nf=1 ad=0.1218 as=0.1218 pd=1.42 ps=1.42 nrd=0.69047619047619  nrs=0.69047619047619 sa=0 sb=0 sd=0 mult=1 m=1
XMRD_op0_n100_rh_s1_r0_0 rbl_op0_n100_rh_s1_r0 sn_op0_n100_rh_s1_r0_0 rwls_op0_n100_rh_s1_r0 0 sky130_fd_pr__nfet_01v8 L=0.15 W=0.42 nf=1 ad=0.1218 as=0.1218 pd=1.42 ps=1.42 nrd=0.69047619047619  nrs=0.69047619047619 sa=0 sb=0 sd=0 mult=1 m=1
csn_op0_n100_rh_s1_r0_0 sn_op0_n100_rh_s1_r0_0 0 {C_SN}
XMWR_op0_n100_rh_s1_r0_1 sn_op0_n100_rh_s1_r0_1 wwl_des wbl_op0_n100_rh_s1_r0 0 sky130_fd_pr__nfet_01v8 L=0.15 W=0.42 nf=1 ad=0.1218 as=0.1218 pd=1.42 ps=1.42 nrd=0.69047619047619  nrs=0.69047619047619 sa=0 sb=0 sd=0 mult=1 m=1
XMRD_op0_n100_rh_s1_r0_1 rbl_op0_n100_rh_s1_r0 sn_op0_n100_rh_s1_r0_1 rwl_des 0 sky130_fd_pr__nfet_01v8 L=0.15 W=0.42 nf=1 ad=0.1218 as=0.1218 pd=1.42 ps=1.42 nrd=0.69047619047619  nrs=0.69047619047619 sa=0 sb=0 sd=0 mult=1 m=1
csn_op0_n100_rh_s1_r0_1 sn_op0_n100_rh_s1_r0_1 0 {C_SN}
XMWR_op0_n100_rh_s1_r0_2 sn_op0_n100_rh_s1_r0_2 wwl_des wbl_op0_n100_rh_s1_r0 0 sky130_fd_pr__nfet_01v8 L=0.15 W=0.42 nf=1 ad=0.1218 as=0.1218 pd=1.42 ps=1.42 nrd=0.69047619047619  nrs=0.69047619047619 sa=0 sb=0 sd=0 mult=1 m=1
XMRD_op0_n100_rh_s1_r0_2 rbl_op0_n100_rh_s1_r0 sn_op0_n100_rh_s1_r0_2 rwl_des 0 sky130_fd_pr__nfet_01v8 L=0.15 W=0.42 nf=1 ad=0.1218 as=0.1218 pd=1.42 ps=1.42 nrd=0.69047619047619  nrs=0.69047619047619 sa=0 sb=0 sd=0 mult=1 m=1
csn_op0_n100_rh_s1_r0_2 sn_op0_n100_rh_s1_r0_2 0 {C_SN}
XMWR_op0_n100_rh_s1_r0_3 sn_op0_n100_rh_s1_r0_3 wwl_des wbl_op0_n100_rh_s1_r0 0 sky130_fd_pr__nfet_01v8 L=0.15 W=0.42 nf=1 ad=0.1218 as=0.1218 pd=1.42 ps=1.42 nrd=0.69047619047619  nrs=0.69047619047619 sa=0 sb=0 sd=0 mult=1 m=1
XMRD_op0_n100_rh_s1_r0_3 rbl_op0_n100_rh_s1_r0 sn_op0_n100_rh_s1_r0_3 rwl_des 0 sky130_fd_pr__nfet_01v8 L=0.15 W=0.42 nf=1 ad=0.1218 as=0.1218 pd=1.42 ps=1.42 nrd=0.69047619047619  nrs=0.69047619047619 sa=0 sb=0 sd=0 mult=1 m=1
csn_op0_n100_rh_s1_r0_3 sn_op0_n100_rh_s1_r0_3 0 {C_SN}
XMN1_op0_n100_rh_s1_r0 rbl_op0_n100_rh_s1_r0 ref_op0_n100_rh_s1_r0 vn_op0_n100_rh_s1_r0 0 sky130_fd_pr__nfet_01v8 L=0.15 W=1 nf=1 ad=0.29 as=0.29 pd=2.58 ps=2.58 mult=1 m=1
XMN2_op0_n100_rh_s1_r0 ref_op0_n100_rh_s1_r0 rbl_op0_n100_rh_s1_r0 vn_op0_n100_rh_s1_r0 0 sky130_fd_pr__nfet_01v8 L=0.15 W=1 nf=1 ad=0.29 as=0.29 pd=2.58 ps=2.58 mult=1 m=1
XMP1_op0_n100_rh_s1_r0 rbl_op0_n100_rh_s1_r0 ref_op0_n100_rh_s1_r0 vp_op0_n100_rh_s1_r0 vdd sky130_fd_pr__pfet_01v8 L=0.15 W=2 nf=1 ad=0.58 as=0.58 pd=4.58 ps=4.58 mult=1 m=1
XMP2_op0_n100_rh_s1_r0 ref_op0_n100_rh_s1_r0 rbl_op0_n100_rh_s1_r0 vp_op0_n100_rh_s1_r0 vdd sky130_fd_pr__pfet_01v8 L=0.15 W=2 nf=1 ad=0.58 as=0.58 pd=4.58 ps=4.58 mult=1 m=1
XMNF_op0_n100_rh_s1_r0 vn_op0_n100_rh_s1_r0 en_op0_n100_rh_s1_r0 0 0 sky130_fd_pr__nfet_01v8 L=0.15 W=2 nf=1 ad=0.58 as=0.58 pd=4.58 ps=4.58 mult=1 m=1
XMPH_op0_n100_rh_s1_r0 vp_op0_n100_rh_s1_r0 enb_op0_n100_rh_s1_r0 vdd vdd sky130_fd_pr__pfet_01v8 L=0.15 W=4 nf=1 ad=1.16 as=1.16 pd=8.58 ps=8.58 mult=1 m=1
bd_op0_n100_rh_s1_r0 d_op0_n100_rh_s1_r0 0 v=v(rbl_op0_n100_rh_s1_r0)-v(ref_op0_n100_rh_s1_r0)

* ---- instance 108: op0_0000_rh_s1_r0 (variant rh_s1_r0; probe dec 11.9 ns, release 34 ns, meas 36 ns) ----
vctl_op0_0000_rh_s1_r0 ctl_op0_0000_rh_s1_r0 0 pwl(0.0000e+00 {VDD} 2.0000e-09 {VDD} 2.1000e-09 0)
* RWL driver model (EXPERIMENTAL): slew 1 ns, series R 0 ohm; cell pin = rwls_op0_0000_rh_s1_r0
vrs_op0_0000_rh_s1_r0 rwls_op0_0000_rh_s1_r0 0 pwl(0.0000e+00 {VDD} 2.0000e-09 {VDD} 3.0000e-09 0 1.2000e-08 0 1.3000e-08 {VDD})
ven_op0_0000_rh_s1_r0 en_op0_0000_rh_s1_r0 0 pwl(0.0000e+00 0 1.1000e-08 0 1.1100e-08 {VDD} 3.4000e-08 {VDD} 3.4100e-08 0)
venb_op0_0000_rh_s1_r0 enb_op0_0000_rh_s1_r0 0 pwl(0.0000e+00 {VDD} 1.1000e-08 {VDD} 1.1100e-08 0 3.4000e-08 0 3.4100e-08 {VDD})
vww_op0_0000_rh_s1_r0 wwl_op0_0000_rh_s1_r0 0 pwl(0.0000e+00 0 1.2000e-08 0 1.2100e-08 {VDD} 3.2000e-08 {VDD} 3.2100e-08 0)
vwc_op0_0000_rh_s1_r0 wbc_op0_0000_rh_s1_r0 0 pwl(0.0000e+00 0 1.2000e-08 0 1.2100e-08 {VDD} 3.4000e-08 {VDD} 3.4100e-08 0)
swb_op0_0000_rh_s1_r0 ref_op0_0000_rh_s1_r0 wbl_op0_0000_rh_s1_r0 wbc_op0_0000_rh_s1_r0 0 swwbl
cwbl_op0_0000_rh_s1_r0 wbl_op0_0000_rh_s1_r0 0 {C_WBL}
spa_op0_0000_rh_s1_r0 prea rbl_op0_0000_rh_s1_r0 ctl_op0_0000_rh_s1_r0 0 swpre
spr_op0_0000_rh_s1_r0 pref ref_op0_0000_rh_s1_r0 ctl_op0_0000_rh_s1_r0 0 swpre
crbl_op0_0000_rh_s1_r0 rbl_op0_0000_rh_s1_r0 0 {C_RBL}
cref_op0_0000_rh_s1_r0 ref_op0_0000_rh_s1_r0 0 {C_RBL}   $ ASSUMPTION: ideal matched dummy load
XMWR_op0_0000_rh_s1_r0_0 sn_op0_0000_rh_s1_r0_0 wwl_op0_0000_rh_s1_r0 wbl_op0_0000_rh_s1_r0 0 sky130_fd_pr__nfet_01v8 L=0.15 W=0.42 nf=1 ad=0.1218 as=0.1218 pd=1.42 ps=1.42 nrd=0.69047619047619  nrs=0.69047619047619 sa=0 sb=0 sd=0 mult=1 m=1
XMRD_op0_0000_rh_s1_r0_0 rbl_op0_0000_rh_s1_r0 sn_op0_0000_rh_s1_r0_0 rwls_op0_0000_rh_s1_r0 0 sky130_fd_pr__nfet_01v8 L=0.15 W=0.42 nf=1 ad=0.1218 as=0.1218 pd=1.42 ps=1.42 nrd=0.69047619047619  nrs=0.69047619047619 sa=0 sb=0 sd=0 mult=1 m=1
csn_op0_0000_rh_s1_r0_0 sn_op0_0000_rh_s1_r0_0 0 {C_SN}
XMWR_op0_0000_rh_s1_r0_1 sn_op0_0000_rh_s1_r0_1 wwl_des wbl_op0_0000_rh_s1_r0 0 sky130_fd_pr__nfet_01v8 L=0.15 W=0.42 nf=1 ad=0.1218 as=0.1218 pd=1.42 ps=1.42 nrd=0.69047619047619  nrs=0.69047619047619 sa=0 sb=0 sd=0 mult=1 m=1
XMRD_op0_0000_rh_s1_r0_1 rbl_op0_0000_rh_s1_r0 sn_op0_0000_rh_s1_r0_1 rwl_des 0 sky130_fd_pr__nfet_01v8 L=0.15 W=0.42 nf=1 ad=0.1218 as=0.1218 pd=1.42 ps=1.42 nrd=0.69047619047619  nrs=0.69047619047619 sa=0 sb=0 sd=0 mult=1 m=1
csn_op0_0000_rh_s1_r0_1 sn_op0_0000_rh_s1_r0_1 0 {C_SN}
XMWR_op0_0000_rh_s1_r0_2 sn_op0_0000_rh_s1_r0_2 wwl_des wbl_op0_0000_rh_s1_r0 0 sky130_fd_pr__nfet_01v8 L=0.15 W=0.42 nf=1 ad=0.1218 as=0.1218 pd=1.42 ps=1.42 nrd=0.69047619047619  nrs=0.69047619047619 sa=0 sb=0 sd=0 mult=1 m=1
XMRD_op0_0000_rh_s1_r0_2 rbl_op0_0000_rh_s1_r0 sn_op0_0000_rh_s1_r0_2 rwl_des 0 sky130_fd_pr__nfet_01v8 L=0.15 W=0.42 nf=1 ad=0.1218 as=0.1218 pd=1.42 ps=1.42 nrd=0.69047619047619  nrs=0.69047619047619 sa=0 sb=0 sd=0 mult=1 m=1
csn_op0_0000_rh_s1_r0_2 sn_op0_0000_rh_s1_r0_2 0 {C_SN}
XMWR_op0_0000_rh_s1_r0_3 sn_op0_0000_rh_s1_r0_3 wwl_des wbl_op0_0000_rh_s1_r0 0 sky130_fd_pr__nfet_01v8 L=0.15 W=0.42 nf=1 ad=0.1218 as=0.1218 pd=1.42 ps=1.42 nrd=0.69047619047619  nrs=0.69047619047619 sa=0 sb=0 sd=0 mult=1 m=1
XMRD_op0_0000_rh_s1_r0_3 rbl_op0_0000_rh_s1_r0 sn_op0_0000_rh_s1_r0_3 rwl_des 0 sky130_fd_pr__nfet_01v8 L=0.15 W=0.42 nf=1 ad=0.1218 as=0.1218 pd=1.42 ps=1.42 nrd=0.69047619047619  nrs=0.69047619047619 sa=0 sb=0 sd=0 mult=1 m=1
csn_op0_0000_rh_s1_r0_3 sn_op0_0000_rh_s1_r0_3 0 {C_SN}
XMN1_op0_0000_rh_s1_r0 rbl_op0_0000_rh_s1_r0 ref_op0_0000_rh_s1_r0 vn_op0_0000_rh_s1_r0 0 sky130_fd_pr__nfet_01v8 L=0.15 W=1 nf=1 ad=0.29 as=0.29 pd=2.58 ps=2.58 mult=1 m=1
XMN2_op0_0000_rh_s1_r0 ref_op0_0000_rh_s1_r0 rbl_op0_0000_rh_s1_r0 vn_op0_0000_rh_s1_r0 0 sky130_fd_pr__nfet_01v8 L=0.15 W=1 nf=1 ad=0.29 as=0.29 pd=2.58 ps=2.58 mult=1 m=1
XMP1_op0_0000_rh_s1_r0 rbl_op0_0000_rh_s1_r0 ref_op0_0000_rh_s1_r0 vp_op0_0000_rh_s1_r0 vdd sky130_fd_pr__pfet_01v8 L=0.15 W=2 nf=1 ad=0.58 as=0.58 pd=4.58 ps=4.58 mult=1 m=1
XMP2_op0_0000_rh_s1_r0 ref_op0_0000_rh_s1_r0 rbl_op0_0000_rh_s1_r0 vp_op0_0000_rh_s1_r0 vdd sky130_fd_pr__pfet_01v8 L=0.15 W=2 nf=1 ad=0.58 as=0.58 pd=4.58 ps=4.58 mult=1 m=1
XMNF_op0_0000_rh_s1_r0 vn_op0_0000_rh_s1_r0 en_op0_0000_rh_s1_r0 0 0 sky130_fd_pr__nfet_01v8 L=0.15 W=2 nf=1 ad=0.58 as=0.58 pd=4.58 ps=4.58 mult=1 m=1
XMPH_op0_0000_rh_s1_r0 vp_op0_0000_rh_s1_r0 enb_op0_0000_rh_s1_r0 vdd vdd sky130_fd_pr__pfet_01v8 L=0.15 W=4 nf=1 ad=1.16 as=1.16 pd=8.58 ps=8.58 mult=1 m=1
bd_op0_0000_rh_s1_r0 d_op0_0000_rh_s1_r0 0 v=v(rbl_op0_0000_rh_s1_r0)-v(ref_op0_0000_rh_s1_r0)

* ---- instance 109: op1_0900_rh_s2_r0 (variant rh_s2_r0; probe dec 11.9 ns, release 34 ns, meas 36 ns) ----
vctl_op1_0900_rh_s2_r0 ctl_op1_0900_rh_s2_r0 0 pwl(0.0000e+00 {VDD} 2.0000e-09 {VDD} 2.1000e-09 0)
* RWL driver model (EXPERIMENTAL): slew 2 ns, series R 0 ohm; cell pin = rwls_op1_0900_rh_s2_r0
vrs_op1_0900_rh_s2_r0 rwls_op1_0900_rh_s2_r0 0 pwl(0.0000e+00 {VDD} 2.0000e-09 {VDD} 4.0000e-09 0 1.2000e-08 0 1.4000e-08 {VDD})
ven_op1_0900_rh_s2_r0 en_op1_0900_rh_s2_r0 0 pwl(0.0000e+00 0 1.1000e-08 0 1.1100e-08 {VDD} 3.4000e-08 {VDD} 3.4100e-08 0)
venb_op1_0900_rh_s2_r0 enb_op1_0900_rh_s2_r0 0 pwl(0.0000e+00 {VDD} 1.1000e-08 {VDD} 1.1100e-08 0 3.4000e-08 0 3.4100e-08 {VDD})
vww_op1_0900_rh_s2_r0 wwl_op1_0900_rh_s2_r0 0 pwl(0.0000e+00 0 1.2000e-08 0 1.2100e-08 {VDD} 3.2000e-08 {VDD} 3.2100e-08 0)
vwc_op1_0900_rh_s2_r0 wbc_op1_0900_rh_s2_r0 0 pwl(0.0000e+00 0 1.2000e-08 0 1.2100e-08 {VDD} 3.4000e-08 {VDD} 3.4100e-08 0)
swb_op1_0900_rh_s2_r0 ref_op1_0900_rh_s2_r0 wbl_op1_0900_rh_s2_r0 wbc_op1_0900_rh_s2_r0 0 swwbl
cwbl_op1_0900_rh_s2_r0 wbl_op1_0900_rh_s2_r0 0 {C_WBL}
spa_op1_0900_rh_s2_r0 prea rbl_op1_0900_rh_s2_r0 ctl_op1_0900_rh_s2_r0 0 swpre
spr_op1_0900_rh_s2_r0 pref ref_op1_0900_rh_s2_r0 ctl_op1_0900_rh_s2_r0 0 swpre
crbl_op1_0900_rh_s2_r0 rbl_op1_0900_rh_s2_r0 0 {C_RBL}
cref_op1_0900_rh_s2_r0 ref_op1_0900_rh_s2_r0 0 {C_RBL}   $ ASSUMPTION: ideal matched dummy load
XMWR_op1_0900_rh_s2_r0_0 sn_op1_0900_rh_s2_r0_0 wwl_op1_0900_rh_s2_r0 wbl_op1_0900_rh_s2_r0 0 sky130_fd_pr__nfet_01v8 L=0.15 W=0.42 nf=1 ad=0.1218 as=0.1218 pd=1.42 ps=1.42 nrd=0.69047619047619  nrs=0.69047619047619 sa=0 sb=0 sd=0 mult=1 m=1
XMRD_op1_0900_rh_s2_r0_0 rbl_op1_0900_rh_s2_r0 sn_op1_0900_rh_s2_r0_0 rwls_op1_0900_rh_s2_r0 0 sky130_fd_pr__nfet_01v8 L=0.15 W=0.42 nf=1 ad=0.1218 as=0.1218 pd=1.42 ps=1.42 nrd=0.69047619047619  nrs=0.69047619047619 sa=0 sb=0 sd=0 mult=1 m=1
csn_op1_0900_rh_s2_r0_0 sn_op1_0900_rh_s2_r0_0 0 {C_SN}
XMWR_op1_0900_rh_s2_r0_1 sn_op1_0900_rh_s2_r0_1 wwl_des wbl_op1_0900_rh_s2_r0 0 sky130_fd_pr__nfet_01v8 L=0.15 W=0.42 nf=1 ad=0.1218 as=0.1218 pd=1.42 ps=1.42 nrd=0.69047619047619  nrs=0.69047619047619 sa=0 sb=0 sd=0 mult=1 m=1
XMRD_op1_0900_rh_s2_r0_1 rbl_op1_0900_rh_s2_r0 sn_op1_0900_rh_s2_r0_1 rwl_des 0 sky130_fd_pr__nfet_01v8 L=0.15 W=0.42 nf=1 ad=0.1218 as=0.1218 pd=1.42 ps=1.42 nrd=0.69047619047619  nrs=0.69047619047619 sa=0 sb=0 sd=0 mult=1 m=1
csn_op1_0900_rh_s2_r0_1 sn_op1_0900_rh_s2_r0_1 0 {C_SN}
XMWR_op1_0900_rh_s2_r0_2 sn_op1_0900_rh_s2_r0_2 wwl_des wbl_op1_0900_rh_s2_r0 0 sky130_fd_pr__nfet_01v8 L=0.15 W=0.42 nf=1 ad=0.1218 as=0.1218 pd=1.42 ps=1.42 nrd=0.69047619047619  nrs=0.69047619047619 sa=0 sb=0 sd=0 mult=1 m=1
XMRD_op1_0900_rh_s2_r0_2 rbl_op1_0900_rh_s2_r0 sn_op1_0900_rh_s2_r0_2 rwl_des 0 sky130_fd_pr__nfet_01v8 L=0.15 W=0.42 nf=1 ad=0.1218 as=0.1218 pd=1.42 ps=1.42 nrd=0.69047619047619  nrs=0.69047619047619 sa=0 sb=0 sd=0 mult=1 m=1
csn_op1_0900_rh_s2_r0_2 sn_op1_0900_rh_s2_r0_2 0 {C_SN}
XMWR_op1_0900_rh_s2_r0_3 sn_op1_0900_rh_s2_r0_3 wwl_des wbl_op1_0900_rh_s2_r0 0 sky130_fd_pr__nfet_01v8 L=0.15 W=0.42 nf=1 ad=0.1218 as=0.1218 pd=1.42 ps=1.42 nrd=0.69047619047619  nrs=0.69047619047619 sa=0 sb=0 sd=0 mult=1 m=1
XMRD_op1_0900_rh_s2_r0_3 rbl_op1_0900_rh_s2_r0 sn_op1_0900_rh_s2_r0_3 rwl_des 0 sky130_fd_pr__nfet_01v8 L=0.15 W=0.42 nf=1 ad=0.1218 as=0.1218 pd=1.42 ps=1.42 nrd=0.69047619047619  nrs=0.69047619047619 sa=0 sb=0 sd=0 mult=1 m=1
csn_op1_0900_rh_s2_r0_3 sn_op1_0900_rh_s2_r0_3 0 {C_SN}
XMN1_op1_0900_rh_s2_r0 rbl_op1_0900_rh_s2_r0 ref_op1_0900_rh_s2_r0 vn_op1_0900_rh_s2_r0 0 sky130_fd_pr__nfet_01v8 L=0.15 W=1 nf=1 ad=0.29 as=0.29 pd=2.58 ps=2.58 mult=1 m=1
XMN2_op1_0900_rh_s2_r0 ref_op1_0900_rh_s2_r0 rbl_op1_0900_rh_s2_r0 vn_op1_0900_rh_s2_r0 0 sky130_fd_pr__nfet_01v8 L=0.15 W=1 nf=1 ad=0.29 as=0.29 pd=2.58 ps=2.58 mult=1 m=1
XMP1_op1_0900_rh_s2_r0 rbl_op1_0900_rh_s2_r0 ref_op1_0900_rh_s2_r0 vp_op1_0900_rh_s2_r0 vdd sky130_fd_pr__pfet_01v8 L=0.15 W=2 nf=1 ad=0.58 as=0.58 pd=4.58 ps=4.58 mult=1 m=1
XMP2_op1_0900_rh_s2_r0 ref_op1_0900_rh_s2_r0 rbl_op1_0900_rh_s2_r0 vp_op1_0900_rh_s2_r0 vdd sky130_fd_pr__pfet_01v8 L=0.15 W=2 nf=1 ad=0.58 as=0.58 pd=4.58 ps=4.58 mult=1 m=1
XMNF_op1_0900_rh_s2_r0 vn_op1_0900_rh_s2_r0 en_op1_0900_rh_s2_r0 0 0 sky130_fd_pr__nfet_01v8 L=0.15 W=2 nf=1 ad=0.58 as=0.58 pd=4.58 ps=4.58 mult=1 m=1
XMPH_op1_0900_rh_s2_r0 vp_op1_0900_rh_s2_r0 enb_op1_0900_rh_s2_r0 vdd vdd sky130_fd_pr__pfet_01v8 L=0.15 W=4 nf=1 ad=1.16 as=1.16 pd=8.58 ps=8.58 mult=1 m=1
bd_op1_0900_rh_s2_r0 d_op1_0900_rh_s2_r0 0 v=v(rbl_op1_0900_rh_s2_r0)-v(ref_op1_0900_rh_s2_r0)

* ---- instance 110: op1_1000_rh_s2_r0 (variant rh_s2_r0; probe dec 11.9 ns, release 34 ns, meas 36 ns) ----
vctl_op1_1000_rh_s2_r0 ctl_op1_1000_rh_s2_r0 0 pwl(0.0000e+00 {VDD} 2.0000e-09 {VDD} 2.1000e-09 0)
* RWL driver model (EXPERIMENTAL): slew 2 ns, series R 0 ohm; cell pin = rwls_op1_1000_rh_s2_r0
vrs_op1_1000_rh_s2_r0 rwls_op1_1000_rh_s2_r0 0 pwl(0.0000e+00 {VDD} 2.0000e-09 {VDD} 4.0000e-09 0 1.2000e-08 0 1.4000e-08 {VDD})
ven_op1_1000_rh_s2_r0 en_op1_1000_rh_s2_r0 0 pwl(0.0000e+00 0 1.1000e-08 0 1.1100e-08 {VDD} 3.4000e-08 {VDD} 3.4100e-08 0)
venb_op1_1000_rh_s2_r0 enb_op1_1000_rh_s2_r0 0 pwl(0.0000e+00 {VDD} 1.1000e-08 {VDD} 1.1100e-08 0 3.4000e-08 0 3.4100e-08 {VDD})
vww_op1_1000_rh_s2_r0 wwl_op1_1000_rh_s2_r0 0 pwl(0.0000e+00 0 1.2000e-08 0 1.2100e-08 {VDD} 3.2000e-08 {VDD} 3.2100e-08 0)
vwc_op1_1000_rh_s2_r0 wbc_op1_1000_rh_s2_r0 0 pwl(0.0000e+00 0 1.2000e-08 0 1.2100e-08 {VDD} 3.4000e-08 {VDD} 3.4100e-08 0)
swb_op1_1000_rh_s2_r0 ref_op1_1000_rh_s2_r0 wbl_op1_1000_rh_s2_r0 wbc_op1_1000_rh_s2_r0 0 swwbl
cwbl_op1_1000_rh_s2_r0 wbl_op1_1000_rh_s2_r0 0 {C_WBL}
spa_op1_1000_rh_s2_r0 prea rbl_op1_1000_rh_s2_r0 ctl_op1_1000_rh_s2_r0 0 swpre
spr_op1_1000_rh_s2_r0 pref ref_op1_1000_rh_s2_r0 ctl_op1_1000_rh_s2_r0 0 swpre
crbl_op1_1000_rh_s2_r0 rbl_op1_1000_rh_s2_r0 0 {C_RBL}
cref_op1_1000_rh_s2_r0 ref_op1_1000_rh_s2_r0 0 {C_RBL}   $ ASSUMPTION: ideal matched dummy load
XMWR_op1_1000_rh_s2_r0_0 sn_op1_1000_rh_s2_r0_0 wwl_op1_1000_rh_s2_r0 wbl_op1_1000_rh_s2_r0 0 sky130_fd_pr__nfet_01v8 L=0.15 W=0.42 nf=1 ad=0.1218 as=0.1218 pd=1.42 ps=1.42 nrd=0.69047619047619  nrs=0.69047619047619 sa=0 sb=0 sd=0 mult=1 m=1
XMRD_op1_1000_rh_s2_r0_0 rbl_op1_1000_rh_s2_r0 sn_op1_1000_rh_s2_r0_0 rwls_op1_1000_rh_s2_r0 0 sky130_fd_pr__nfet_01v8 L=0.15 W=0.42 nf=1 ad=0.1218 as=0.1218 pd=1.42 ps=1.42 nrd=0.69047619047619  nrs=0.69047619047619 sa=0 sb=0 sd=0 mult=1 m=1
csn_op1_1000_rh_s2_r0_0 sn_op1_1000_rh_s2_r0_0 0 {C_SN}
XMWR_op1_1000_rh_s2_r0_1 sn_op1_1000_rh_s2_r0_1 wwl_des wbl_op1_1000_rh_s2_r0 0 sky130_fd_pr__nfet_01v8 L=0.15 W=0.42 nf=1 ad=0.1218 as=0.1218 pd=1.42 ps=1.42 nrd=0.69047619047619  nrs=0.69047619047619 sa=0 sb=0 sd=0 mult=1 m=1
XMRD_op1_1000_rh_s2_r0_1 rbl_op1_1000_rh_s2_r0 sn_op1_1000_rh_s2_r0_1 rwl_des 0 sky130_fd_pr__nfet_01v8 L=0.15 W=0.42 nf=1 ad=0.1218 as=0.1218 pd=1.42 ps=1.42 nrd=0.69047619047619  nrs=0.69047619047619 sa=0 sb=0 sd=0 mult=1 m=1
csn_op1_1000_rh_s2_r0_1 sn_op1_1000_rh_s2_r0_1 0 {C_SN}
XMWR_op1_1000_rh_s2_r0_2 sn_op1_1000_rh_s2_r0_2 wwl_des wbl_op1_1000_rh_s2_r0 0 sky130_fd_pr__nfet_01v8 L=0.15 W=0.42 nf=1 ad=0.1218 as=0.1218 pd=1.42 ps=1.42 nrd=0.69047619047619  nrs=0.69047619047619 sa=0 sb=0 sd=0 mult=1 m=1
XMRD_op1_1000_rh_s2_r0_2 rbl_op1_1000_rh_s2_r0 sn_op1_1000_rh_s2_r0_2 rwl_des 0 sky130_fd_pr__nfet_01v8 L=0.15 W=0.42 nf=1 ad=0.1218 as=0.1218 pd=1.42 ps=1.42 nrd=0.69047619047619  nrs=0.69047619047619 sa=0 sb=0 sd=0 mult=1 m=1
csn_op1_1000_rh_s2_r0_2 sn_op1_1000_rh_s2_r0_2 0 {C_SN}
XMWR_op1_1000_rh_s2_r0_3 sn_op1_1000_rh_s2_r0_3 wwl_des wbl_op1_1000_rh_s2_r0 0 sky130_fd_pr__nfet_01v8 L=0.15 W=0.42 nf=1 ad=0.1218 as=0.1218 pd=1.42 ps=1.42 nrd=0.69047619047619  nrs=0.69047619047619 sa=0 sb=0 sd=0 mult=1 m=1
XMRD_op1_1000_rh_s2_r0_3 rbl_op1_1000_rh_s2_r0 sn_op1_1000_rh_s2_r0_3 rwl_des 0 sky130_fd_pr__nfet_01v8 L=0.15 W=0.42 nf=1 ad=0.1218 as=0.1218 pd=1.42 ps=1.42 nrd=0.69047619047619  nrs=0.69047619047619 sa=0 sb=0 sd=0 mult=1 m=1
csn_op1_1000_rh_s2_r0_3 sn_op1_1000_rh_s2_r0_3 0 {C_SN}
XMN1_op1_1000_rh_s2_r0 rbl_op1_1000_rh_s2_r0 ref_op1_1000_rh_s2_r0 vn_op1_1000_rh_s2_r0 0 sky130_fd_pr__nfet_01v8 L=0.15 W=1 nf=1 ad=0.29 as=0.29 pd=2.58 ps=2.58 mult=1 m=1
XMN2_op1_1000_rh_s2_r0 ref_op1_1000_rh_s2_r0 rbl_op1_1000_rh_s2_r0 vn_op1_1000_rh_s2_r0 0 sky130_fd_pr__nfet_01v8 L=0.15 W=1 nf=1 ad=0.29 as=0.29 pd=2.58 ps=2.58 mult=1 m=1
XMP1_op1_1000_rh_s2_r0 rbl_op1_1000_rh_s2_r0 ref_op1_1000_rh_s2_r0 vp_op1_1000_rh_s2_r0 vdd sky130_fd_pr__pfet_01v8 L=0.15 W=2 nf=1 ad=0.58 as=0.58 pd=4.58 ps=4.58 mult=1 m=1
XMP2_op1_1000_rh_s2_r0 ref_op1_1000_rh_s2_r0 rbl_op1_1000_rh_s2_r0 vp_op1_1000_rh_s2_r0 vdd sky130_fd_pr__pfet_01v8 L=0.15 W=2 nf=1 ad=0.58 as=0.58 pd=4.58 ps=4.58 mult=1 m=1
XMNF_op1_1000_rh_s2_r0 vn_op1_1000_rh_s2_r0 en_op1_1000_rh_s2_r0 0 0 sky130_fd_pr__nfet_01v8 L=0.15 W=2 nf=1 ad=0.58 as=0.58 pd=4.58 ps=4.58 mult=1 m=1
XMPH_op1_1000_rh_s2_r0 vp_op1_1000_rh_s2_r0 enb_op1_1000_rh_s2_r0 vdd vdd sky130_fd_pr__pfet_01v8 L=0.15 W=4 nf=1 ad=1.16 as=1.16 pd=8.58 ps=8.58 mult=1 m=1
bd_op1_1000_rh_s2_r0 d_op1_1000_rh_s2_r0 0 v=v(rbl_op1_1000_rh_s2_r0)-v(ref_op1_1000_rh_s2_r0)

* ---- instance 111: op0_n100_rh_s2_r0 (variant rh_s2_r0; probe dec 11.9 ns, release 34 ns, meas 36 ns) ----
vctl_op0_n100_rh_s2_r0 ctl_op0_n100_rh_s2_r0 0 pwl(0.0000e+00 {VDD} 2.0000e-09 {VDD} 2.1000e-09 0)
* RWL driver model (EXPERIMENTAL): slew 2 ns, series R 0 ohm; cell pin = rwls_op0_n100_rh_s2_r0
vrs_op0_n100_rh_s2_r0 rwls_op0_n100_rh_s2_r0 0 pwl(0.0000e+00 {VDD} 2.0000e-09 {VDD} 4.0000e-09 0 1.2000e-08 0 1.4000e-08 {VDD})
ven_op0_n100_rh_s2_r0 en_op0_n100_rh_s2_r0 0 pwl(0.0000e+00 0 1.1000e-08 0 1.1100e-08 {VDD} 3.4000e-08 {VDD} 3.4100e-08 0)
venb_op0_n100_rh_s2_r0 enb_op0_n100_rh_s2_r0 0 pwl(0.0000e+00 {VDD} 1.1000e-08 {VDD} 1.1100e-08 0 3.4000e-08 0 3.4100e-08 {VDD})
vww_op0_n100_rh_s2_r0 wwl_op0_n100_rh_s2_r0 0 pwl(0.0000e+00 0 1.2000e-08 0 1.2100e-08 {VDD} 3.2000e-08 {VDD} 3.2100e-08 0)
vwc_op0_n100_rh_s2_r0 wbc_op0_n100_rh_s2_r0 0 pwl(0.0000e+00 0 1.2000e-08 0 1.2100e-08 {VDD} 3.4000e-08 {VDD} 3.4100e-08 0)
swb_op0_n100_rh_s2_r0 ref_op0_n100_rh_s2_r0 wbl_op0_n100_rh_s2_r0 wbc_op0_n100_rh_s2_r0 0 swwbl
cwbl_op0_n100_rh_s2_r0 wbl_op0_n100_rh_s2_r0 0 {C_WBL}
spa_op0_n100_rh_s2_r0 prea rbl_op0_n100_rh_s2_r0 ctl_op0_n100_rh_s2_r0 0 swpre
spr_op0_n100_rh_s2_r0 pref ref_op0_n100_rh_s2_r0 ctl_op0_n100_rh_s2_r0 0 swpre
crbl_op0_n100_rh_s2_r0 rbl_op0_n100_rh_s2_r0 0 {C_RBL}
cref_op0_n100_rh_s2_r0 ref_op0_n100_rh_s2_r0 0 {C_RBL}   $ ASSUMPTION: ideal matched dummy load
XMWR_op0_n100_rh_s2_r0_0 sn_op0_n100_rh_s2_r0_0 wwl_op0_n100_rh_s2_r0 wbl_op0_n100_rh_s2_r0 0 sky130_fd_pr__nfet_01v8 L=0.15 W=0.42 nf=1 ad=0.1218 as=0.1218 pd=1.42 ps=1.42 nrd=0.69047619047619  nrs=0.69047619047619 sa=0 sb=0 sd=0 mult=1 m=1
XMRD_op0_n100_rh_s2_r0_0 rbl_op0_n100_rh_s2_r0 sn_op0_n100_rh_s2_r0_0 rwls_op0_n100_rh_s2_r0 0 sky130_fd_pr__nfet_01v8 L=0.15 W=0.42 nf=1 ad=0.1218 as=0.1218 pd=1.42 ps=1.42 nrd=0.69047619047619  nrs=0.69047619047619 sa=0 sb=0 sd=0 mult=1 m=1
csn_op0_n100_rh_s2_r0_0 sn_op0_n100_rh_s2_r0_0 0 {C_SN}
XMWR_op0_n100_rh_s2_r0_1 sn_op0_n100_rh_s2_r0_1 wwl_des wbl_op0_n100_rh_s2_r0 0 sky130_fd_pr__nfet_01v8 L=0.15 W=0.42 nf=1 ad=0.1218 as=0.1218 pd=1.42 ps=1.42 nrd=0.69047619047619  nrs=0.69047619047619 sa=0 sb=0 sd=0 mult=1 m=1
XMRD_op0_n100_rh_s2_r0_1 rbl_op0_n100_rh_s2_r0 sn_op0_n100_rh_s2_r0_1 rwl_des 0 sky130_fd_pr__nfet_01v8 L=0.15 W=0.42 nf=1 ad=0.1218 as=0.1218 pd=1.42 ps=1.42 nrd=0.69047619047619  nrs=0.69047619047619 sa=0 sb=0 sd=0 mult=1 m=1
csn_op0_n100_rh_s2_r0_1 sn_op0_n100_rh_s2_r0_1 0 {C_SN}
XMWR_op0_n100_rh_s2_r0_2 sn_op0_n100_rh_s2_r0_2 wwl_des wbl_op0_n100_rh_s2_r0 0 sky130_fd_pr__nfet_01v8 L=0.15 W=0.42 nf=1 ad=0.1218 as=0.1218 pd=1.42 ps=1.42 nrd=0.69047619047619  nrs=0.69047619047619 sa=0 sb=0 sd=0 mult=1 m=1
XMRD_op0_n100_rh_s2_r0_2 rbl_op0_n100_rh_s2_r0 sn_op0_n100_rh_s2_r0_2 rwl_des 0 sky130_fd_pr__nfet_01v8 L=0.15 W=0.42 nf=1 ad=0.1218 as=0.1218 pd=1.42 ps=1.42 nrd=0.69047619047619  nrs=0.69047619047619 sa=0 sb=0 sd=0 mult=1 m=1
csn_op0_n100_rh_s2_r0_2 sn_op0_n100_rh_s2_r0_2 0 {C_SN}
XMWR_op0_n100_rh_s2_r0_3 sn_op0_n100_rh_s2_r0_3 wwl_des wbl_op0_n100_rh_s2_r0 0 sky130_fd_pr__nfet_01v8 L=0.15 W=0.42 nf=1 ad=0.1218 as=0.1218 pd=1.42 ps=1.42 nrd=0.69047619047619  nrs=0.69047619047619 sa=0 sb=0 sd=0 mult=1 m=1
XMRD_op0_n100_rh_s2_r0_3 rbl_op0_n100_rh_s2_r0 sn_op0_n100_rh_s2_r0_3 rwl_des 0 sky130_fd_pr__nfet_01v8 L=0.15 W=0.42 nf=1 ad=0.1218 as=0.1218 pd=1.42 ps=1.42 nrd=0.69047619047619  nrs=0.69047619047619 sa=0 sb=0 sd=0 mult=1 m=1
csn_op0_n100_rh_s2_r0_3 sn_op0_n100_rh_s2_r0_3 0 {C_SN}
XMN1_op0_n100_rh_s2_r0 rbl_op0_n100_rh_s2_r0 ref_op0_n100_rh_s2_r0 vn_op0_n100_rh_s2_r0 0 sky130_fd_pr__nfet_01v8 L=0.15 W=1 nf=1 ad=0.29 as=0.29 pd=2.58 ps=2.58 mult=1 m=1
XMN2_op0_n100_rh_s2_r0 ref_op0_n100_rh_s2_r0 rbl_op0_n100_rh_s2_r0 vn_op0_n100_rh_s2_r0 0 sky130_fd_pr__nfet_01v8 L=0.15 W=1 nf=1 ad=0.29 as=0.29 pd=2.58 ps=2.58 mult=1 m=1
XMP1_op0_n100_rh_s2_r0 rbl_op0_n100_rh_s2_r0 ref_op0_n100_rh_s2_r0 vp_op0_n100_rh_s2_r0 vdd sky130_fd_pr__pfet_01v8 L=0.15 W=2 nf=1 ad=0.58 as=0.58 pd=4.58 ps=4.58 mult=1 m=1
XMP2_op0_n100_rh_s2_r0 ref_op0_n100_rh_s2_r0 rbl_op0_n100_rh_s2_r0 vp_op0_n100_rh_s2_r0 vdd sky130_fd_pr__pfet_01v8 L=0.15 W=2 nf=1 ad=0.58 as=0.58 pd=4.58 ps=4.58 mult=1 m=1
XMNF_op0_n100_rh_s2_r0 vn_op0_n100_rh_s2_r0 en_op0_n100_rh_s2_r0 0 0 sky130_fd_pr__nfet_01v8 L=0.15 W=2 nf=1 ad=0.58 as=0.58 pd=4.58 ps=4.58 mult=1 m=1
XMPH_op0_n100_rh_s2_r0 vp_op0_n100_rh_s2_r0 enb_op0_n100_rh_s2_r0 vdd vdd sky130_fd_pr__pfet_01v8 L=0.15 W=4 nf=1 ad=1.16 as=1.16 pd=8.58 ps=8.58 mult=1 m=1
bd_op0_n100_rh_s2_r0 d_op0_n100_rh_s2_r0 0 v=v(rbl_op0_n100_rh_s2_r0)-v(ref_op0_n100_rh_s2_r0)

* ---- instance 112: op0_0000_rh_s2_r0 (variant rh_s2_r0; probe dec 11.9 ns, release 34 ns, meas 36 ns) ----
vctl_op0_0000_rh_s2_r0 ctl_op0_0000_rh_s2_r0 0 pwl(0.0000e+00 {VDD} 2.0000e-09 {VDD} 2.1000e-09 0)
* RWL driver model (EXPERIMENTAL): slew 2 ns, series R 0 ohm; cell pin = rwls_op0_0000_rh_s2_r0
vrs_op0_0000_rh_s2_r0 rwls_op0_0000_rh_s2_r0 0 pwl(0.0000e+00 {VDD} 2.0000e-09 {VDD} 4.0000e-09 0 1.2000e-08 0 1.4000e-08 {VDD})
ven_op0_0000_rh_s2_r0 en_op0_0000_rh_s2_r0 0 pwl(0.0000e+00 0 1.1000e-08 0 1.1100e-08 {VDD} 3.4000e-08 {VDD} 3.4100e-08 0)
venb_op0_0000_rh_s2_r0 enb_op0_0000_rh_s2_r0 0 pwl(0.0000e+00 {VDD} 1.1000e-08 {VDD} 1.1100e-08 0 3.4000e-08 0 3.4100e-08 {VDD})
vww_op0_0000_rh_s2_r0 wwl_op0_0000_rh_s2_r0 0 pwl(0.0000e+00 0 1.2000e-08 0 1.2100e-08 {VDD} 3.2000e-08 {VDD} 3.2100e-08 0)
vwc_op0_0000_rh_s2_r0 wbc_op0_0000_rh_s2_r0 0 pwl(0.0000e+00 0 1.2000e-08 0 1.2100e-08 {VDD} 3.4000e-08 {VDD} 3.4100e-08 0)
swb_op0_0000_rh_s2_r0 ref_op0_0000_rh_s2_r0 wbl_op0_0000_rh_s2_r0 wbc_op0_0000_rh_s2_r0 0 swwbl
cwbl_op0_0000_rh_s2_r0 wbl_op0_0000_rh_s2_r0 0 {C_WBL}
spa_op0_0000_rh_s2_r0 prea rbl_op0_0000_rh_s2_r0 ctl_op0_0000_rh_s2_r0 0 swpre
spr_op0_0000_rh_s2_r0 pref ref_op0_0000_rh_s2_r0 ctl_op0_0000_rh_s2_r0 0 swpre
crbl_op0_0000_rh_s2_r0 rbl_op0_0000_rh_s2_r0 0 {C_RBL}
cref_op0_0000_rh_s2_r0 ref_op0_0000_rh_s2_r0 0 {C_RBL}   $ ASSUMPTION: ideal matched dummy load
XMWR_op0_0000_rh_s2_r0_0 sn_op0_0000_rh_s2_r0_0 wwl_op0_0000_rh_s2_r0 wbl_op0_0000_rh_s2_r0 0 sky130_fd_pr__nfet_01v8 L=0.15 W=0.42 nf=1 ad=0.1218 as=0.1218 pd=1.42 ps=1.42 nrd=0.69047619047619  nrs=0.69047619047619 sa=0 sb=0 sd=0 mult=1 m=1
XMRD_op0_0000_rh_s2_r0_0 rbl_op0_0000_rh_s2_r0 sn_op0_0000_rh_s2_r0_0 rwls_op0_0000_rh_s2_r0 0 sky130_fd_pr__nfet_01v8 L=0.15 W=0.42 nf=1 ad=0.1218 as=0.1218 pd=1.42 ps=1.42 nrd=0.69047619047619  nrs=0.69047619047619 sa=0 sb=0 sd=0 mult=1 m=1
csn_op0_0000_rh_s2_r0_0 sn_op0_0000_rh_s2_r0_0 0 {C_SN}
XMWR_op0_0000_rh_s2_r0_1 sn_op0_0000_rh_s2_r0_1 wwl_des wbl_op0_0000_rh_s2_r0 0 sky130_fd_pr__nfet_01v8 L=0.15 W=0.42 nf=1 ad=0.1218 as=0.1218 pd=1.42 ps=1.42 nrd=0.69047619047619  nrs=0.69047619047619 sa=0 sb=0 sd=0 mult=1 m=1
XMRD_op0_0000_rh_s2_r0_1 rbl_op0_0000_rh_s2_r0 sn_op0_0000_rh_s2_r0_1 rwl_des 0 sky130_fd_pr__nfet_01v8 L=0.15 W=0.42 nf=1 ad=0.1218 as=0.1218 pd=1.42 ps=1.42 nrd=0.69047619047619  nrs=0.69047619047619 sa=0 sb=0 sd=0 mult=1 m=1
csn_op0_0000_rh_s2_r0_1 sn_op0_0000_rh_s2_r0_1 0 {C_SN}
XMWR_op0_0000_rh_s2_r0_2 sn_op0_0000_rh_s2_r0_2 wwl_des wbl_op0_0000_rh_s2_r0 0 sky130_fd_pr__nfet_01v8 L=0.15 W=0.42 nf=1 ad=0.1218 as=0.1218 pd=1.42 ps=1.42 nrd=0.69047619047619  nrs=0.69047619047619 sa=0 sb=0 sd=0 mult=1 m=1
XMRD_op0_0000_rh_s2_r0_2 rbl_op0_0000_rh_s2_r0 sn_op0_0000_rh_s2_r0_2 rwl_des 0 sky130_fd_pr__nfet_01v8 L=0.15 W=0.42 nf=1 ad=0.1218 as=0.1218 pd=1.42 ps=1.42 nrd=0.69047619047619  nrs=0.69047619047619 sa=0 sb=0 sd=0 mult=1 m=1
csn_op0_0000_rh_s2_r0_2 sn_op0_0000_rh_s2_r0_2 0 {C_SN}
XMWR_op0_0000_rh_s2_r0_3 sn_op0_0000_rh_s2_r0_3 wwl_des wbl_op0_0000_rh_s2_r0 0 sky130_fd_pr__nfet_01v8 L=0.15 W=0.42 nf=1 ad=0.1218 as=0.1218 pd=1.42 ps=1.42 nrd=0.69047619047619  nrs=0.69047619047619 sa=0 sb=0 sd=0 mult=1 m=1
XMRD_op0_0000_rh_s2_r0_3 rbl_op0_0000_rh_s2_r0 sn_op0_0000_rh_s2_r0_3 rwl_des 0 sky130_fd_pr__nfet_01v8 L=0.15 W=0.42 nf=1 ad=0.1218 as=0.1218 pd=1.42 ps=1.42 nrd=0.69047619047619  nrs=0.69047619047619 sa=0 sb=0 sd=0 mult=1 m=1
csn_op0_0000_rh_s2_r0_3 sn_op0_0000_rh_s2_r0_3 0 {C_SN}
XMN1_op0_0000_rh_s2_r0 rbl_op0_0000_rh_s2_r0 ref_op0_0000_rh_s2_r0 vn_op0_0000_rh_s2_r0 0 sky130_fd_pr__nfet_01v8 L=0.15 W=1 nf=1 ad=0.29 as=0.29 pd=2.58 ps=2.58 mult=1 m=1
XMN2_op0_0000_rh_s2_r0 ref_op0_0000_rh_s2_r0 rbl_op0_0000_rh_s2_r0 vn_op0_0000_rh_s2_r0 0 sky130_fd_pr__nfet_01v8 L=0.15 W=1 nf=1 ad=0.29 as=0.29 pd=2.58 ps=2.58 mult=1 m=1
XMP1_op0_0000_rh_s2_r0 rbl_op0_0000_rh_s2_r0 ref_op0_0000_rh_s2_r0 vp_op0_0000_rh_s2_r0 vdd sky130_fd_pr__pfet_01v8 L=0.15 W=2 nf=1 ad=0.58 as=0.58 pd=4.58 ps=4.58 mult=1 m=1
XMP2_op0_0000_rh_s2_r0 ref_op0_0000_rh_s2_r0 rbl_op0_0000_rh_s2_r0 vp_op0_0000_rh_s2_r0 vdd sky130_fd_pr__pfet_01v8 L=0.15 W=2 nf=1 ad=0.58 as=0.58 pd=4.58 ps=4.58 mult=1 m=1
XMNF_op0_0000_rh_s2_r0 vn_op0_0000_rh_s2_r0 en_op0_0000_rh_s2_r0 0 0 sky130_fd_pr__nfet_01v8 L=0.15 W=2 nf=1 ad=0.58 as=0.58 pd=4.58 ps=4.58 mult=1 m=1
XMPH_op0_0000_rh_s2_r0 vp_op0_0000_rh_s2_r0 enb_op0_0000_rh_s2_r0 vdd vdd sky130_fd_pr__pfet_01v8 L=0.15 W=4 nf=1 ad=1.16 as=1.16 pd=8.58 ps=8.58 mult=1 m=1
bd_op0_0000_rh_s2_r0 d_op0_0000_rh_s2_r0 0 v=v(rbl_op0_0000_rh_s2_r0)-v(ref_op0_0000_rh_s2_r0)

* ---- instance 113: op1_0900_rh_s5_r0 (variant rh_s5_r0; probe dec 11.9 ns, release 34 ns, meas 36 ns) ----
vctl_op1_0900_rh_s5_r0 ctl_op1_0900_rh_s5_r0 0 pwl(0.0000e+00 {VDD} 2.0000e-09 {VDD} 2.1000e-09 0)
* RWL driver model (EXPERIMENTAL): slew 5 ns, series R 0 ohm; cell pin = rwls_op1_0900_rh_s5_r0
vrs_op1_0900_rh_s5_r0 rwls_op1_0900_rh_s5_r0 0 pwl(0.0000e+00 {VDD} 2.0000e-09 {VDD} 7.0000e-09 0 1.2000e-08 0 1.7000e-08 {VDD})
ven_op1_0900_rh_s5_r0 en_op1_0900_rh_s5_r0 0 pwl(0.0000e+00 0 1.1000e-08 0 1.1100e-08 {VDD} 3.4000e-08 {VDD} 3.4100e-08 0)
venb_op1_0900_rh_s5_r0 enb_op1_0900_rh_s5_r0 0 pwl(0.0000e+00 {VDD} 1.1000e-08 {VDD} 1.1100e-08 0 3.4000e-08 0 3.4100e-08 {VDD})
vww_op1_0900_rh_s5_r0 wwl_op1_0900_rh_s5_r0 0 pwl(0.0000e+00 0 1.2000e-08 0 1.2100e-08 {VDD} 3.2000e-08 {VDD} 3.2100e-08 0)
vwc_op1_0900_rh_s5_r0 wbc_op1_0900_rh_s5_r0 0 pwl(0.0000e+00 0 1.2000e-08 0 1.2100e-08 {VDD} 3.4000e-08 {VDD} 3.4100e-08 0)
swb_op1_0900_rh_s5_r0 ref_op1_0900_rh_s5_r0 wbl_op1_0900_rh_s5_r0 wbc_op1_0900_rh_s5_r0 0 swwbl
cwbl_op1_0900_rh_s5_r0 wbl_op1_0900_rh_s5_r0 0 {C_WBL}
spa_op1_0900_rh_s5_r0 prea rbl_op1_0900_rh_s5_r0 ctl_op1_0900_rh_s5_r0 0 swpre
spr_op1_0900_rh_s5_r0 pref ref_op1_0900_rh_s5_r0 ctl_op1_0900_rh_s5_r0 0 swpre
crbl_op1_0900_rh_s5_r0 rbl_op1_0900_rh_s5_r0 0 {C_RBL}
cref_op1_0900_rh_s5_r0 ref_op1_0900_rh_s5_r0 0 {C_RBL}   $ ASSUMPTION: ideal matched dummy load
XMWR_op1_0900_rh_s5_r0_0 sn_op1_0900_rh_s5_r0_0 wwl_op1_0900_rh_s5_r0 wbl_op1_0900_rh_s5_r0 0 sky130_fd_pr__nfet_01v8 L=0.15 W=0.42 nf=1 ad=0.1218 as=0.1218 pd=1.42 ps=1.42 nrd=0.69047619047619  nrs=0.69047619047619 sa=0 sb=0 sd=0 mult=1 m=1
XMRD_op1_0900_rh_s5_r0_0 rbl_op1_0900_rh_s5_r0 sn_op1_0900_rh_s5_r0_0 rwls_op1_0900_rh_s5_r0 0 sky130_fd_pr__nfet_01v8 L=0.15 W=0.42 nf=1 ad=0.1218 as=0.1218 pd=1.42 ps=1.42 nrd=0.69047619047619  nrs=0.69047619047619 sa=0 sb=0 sd=0 mult=1 m=1
csn_op1_0900_rh_s5_r0_0 sn_op1_0900_rh_s5_r0_0 0 {C_SN}
XMWR_op1_0900_rh_s5_r0_1 sn_op1_0900_rh_s5_r0_1 wwl_des wbl_op1_0900_rh_s5_r0 0 sky130_fd_pr__nfet_01v8 L=0.15 W=0.42 nf=1 ad=0.1218 as=0.1218 pd=1.42 ps=1.42 nrd=0.69047619047619  nrs=0.69047619047619 sa=0 sb=0 sd=0 mult=1 m=1
XMRD_op1_0900_rh_s5_r0_1 rbl_op1_0900_rh_s5_r0 sn_op1_0900_rh_s5_r0_1 rwl_des 0 sky130_fd_pr__nfet_01v8 L=0.15 W=0.42 nf=1 ad=0.1218 as=0.1218 pd=1.42 ps=1.42 nrd=0.69047619047619  nrs=0.69047619047619 sa=0 sb=0 sd=0 mult=1 m=1
csn_op1_0900_rh_s5_r0_1 sn_op1_0900_rh_s5_r0_1 0 {C_SN}
XMWR_op1_0900_rh_s5_r0_2 sn_op1_0900_rh_s5_r0_2 wwl_des wbl_op1_0900_rh_s5_r0 0 sky130_fd_pr__nfet_01v8 L=0.15 W=0.42 nf=1 ad=0.1218 as=0.1218 pd=1.42 ps=1.42 nrd=0.69047619047619  nrs=0.69047619047619 sa=0 sb=0 sd=0 mult=1 m=1
XMRD_op1_0900_rh_s5_r0_2 rbl_op1_0900_rh_s5_r0 sn_op1_0900_rh_s5_r0_2 rwl_des 0 sky130_fd_pr__nfet_01v8 L=0.15 W=0.42 nf=1 ad=0.1218 as=0.1218 pd=1.42 ps=1.42 nrd=0.69047619047619  nrs=0.69047619047619 sa=0 sb=0 sd=0 mult=1 m=1
csn_op1_0900_rh_s5_r0_2 sn_op1_0900_rh_s5_r0_2 0 {C_SN}
XMWR_op1_0900_rh_s5_r0_3 sn_op1_0900_rh_s5_r0_3 wwl_des wbl_op1_0900_rh_s5_r0 0 sky130_fd_pr__nfet_01v8 L=0.15 W=0.42 nf=1 ad=0.1218 as=0.1218 pd=1.42 ps=1.42 nrd=0.69047619047619  nrs=0.69047619047619 sa=0 sb=0 sd=0 mult=1 m=1
XMRD_op1_0900_rh_s5_r0_3 rbl_op1_0900_rh_s5_r0 sn_op1_0900_rh_s5_r0_3 rwl_des 0 sky130_fd_pr__nfet_01v8 L=0.15 W=0.42 nf=1 ad=0.1218 as=0.1218 pd=1.42 ps=1.42 nrd=0.69047619047619  nrs=0.69047619047619 sa=0 sb=0 sd=0 mult=1 m=1
csn_op1_0900_rh_s5_r0_3 sn_op1_0900_rh_s5_r0_3 0 {C_SN}
XMN1_op1_0900_rh_s5_r0 rbl_op1_0900_rh_s5_r0 ref_op1_0900_rh_s5_r0 vn_op1_0900_rh_s5_r0 0 sky130_fd_pr__nfet_01v8 L=0.15 W=1 nf=1 ad=0.29 as=0.29 pd=2.58 ps=2.58 mult=1 m=1
XMN2_op1_0900_rh_s5_r0 ref_op1_0900_rh_s5_r0 rbl_op1_0900_rh_s5_r0 vn_op1_0900_rh_s5_r0 0 sky130_fd_pr__nfet_01v8 L=0.15 W=1 nf=1 ad=0.29 as=0.29 pd=2.58 ps=2.58 mult=1 m=1
XMP1_op1_0900_rh_s5_r0 rbl_op1_0900_rh_s5_r0 ref_op1_0900_rh_s5_r0 vp_op1_0900_rh_s5_r0 vdd sky130_fd_pr__pfet_01v8 L=0.15 W=2 nf=1 ad=0.58 as=0.58 pd=4.58 ps=4.58 mult=1 m=1
XMP2_op1_0900_rh_s5_r0 ref_op1_0900_rh_s5_r0 rbl_op1_0900_rh_s5_r0 vp_op1_0900_rh_s5_r0 vdd sky130_fd_pr__pfet_01v8 L=0.15 W=2 nf=1 ad=0.58 as=0.58 pd=4.58 ps=4.58 mult=1 m=1
XMNF_op1_0900_rh_s5_r0 vn_op1_0900_rh_s5_r0 en_op1_0900_rh_s5_r0 0 0 sky130_fd_pr__nfet_01v8 L=0.15 W=2 nf=1 ad=0.58 as=0.58 pd=4.58 ps=4.58 mult=1 m=1
XMPH_op1_0900_rh_s5_r0 vp_op1_0900_rh_s5_r0 enb_op1_0900_rh_s5_r0 vdd vdd sky130_fd_pr__pfet_01v8 L=0.15 W=4 nf=1 ad=1.16 as=1.16 pd=8.58 ps=8.58 mult=1 m=1
bd_op1_0900_rh_s5_r0 d_op1_0900_rh_s5_r0 0 v=v(rbl_op1_0900_rh_s5_r0)-v(ref_op1_0900_rh_s5_r0)

* ---- instance 114: op1_1000_rh_s5_r0 (variant rh_s5_r0; probe dec 11.9 ns, release 34 ns, meas 36 ns) ----
vctl_op1_1000_rh_s5_r0 ctl_op1_1000_rh_s5_r0 0 pwl(0.0000e+00 {VDD} 2.0000e-09 {VDD} 2.1000e-09 0)
* RWL driver model (EXPERIMENTAL): slew 5 ns, series R 0 ohm; cell pin = rwls_op1_1000_rh_s5_r0
vrs_op1_1000_rh_s5_r0 rwls_op1_1000_rh_s5_r0 0 pwl(0.0000e+00 {VDD} 2.0000e-09 {VDD} 7.0000e-09 0 1.2000e-08 0 1.7000e-08 {VDD})
ven_op1_1000_rh_s5_r0 en_op1_1000_rh_s5_r0 0 pwl(0.0000e+00 0 1.1000e-08 0 1.1100e-08 {VDD} 3.4000e-08 {VDD} 3.4100e-08 0)
venb_op1_1000_rh_s5_r0 enb_op1_1000_rh_s5_r0 0 pwl(0.0000e+00 {VDD} 1.1000e-08 {VDD} 1.1100e-08 0 3.4000e-08 0 3.4100e-08 {VDD})
vww_op1_1000_rh_s5_r0 wwl_op1_1000_rh_s5_r0 0 pwl(0.0000e+00 0 1.2000e-08 0 1.2100e-08 {VDD} 3.2000e-08 {VDD} 3.2100e-08 0)
vwc_op1_1000_rh_s5_r0 wbc_op1_1000_rh_s5_r0 0 pwl(0.0000e+00 0 1.2000e-08 0 1.2100e-08 {VDD} 3.4000e-08 {VDD} 3.4100e-08 0)
swb_op1_1000_rh_s5_r0 ref_op1_1000_rh_s5_r0 wbl_op1_1000_rh_s5_r0 wbc_op1_1000_rh_s5_r0 0 swwbl
cwbl_op1_1000_rh_s5_r0 wbl_op1_1000_rh_s5_r0 0 {C_WBL}
spa_op1_1000_rh_s5_r0 prea rbl_op1_1000_rh_s5_r0 ctl_op1_1000_rh_s5_r0 0 swpre
spr_op1_1000_rh_s5_r0 pref ref_op1_1000_rh_s5_r0 ctl_op1_1000_rh_s5_r0 0 swpre
crbl_op1_1000_rh_s5_r0 rbl_op1_1000_rh_s5_r0 0 {C_RBL}
cref_op1_1000_rh_s5_r0 ref_op1_1000_rh_s5_r0 0 {C_RBL}   $ ASSUMPTION: ideal matched dummy load
XMWR_op1_1000_rh_s5_r0_0 sn_op1_1000_rh_s5_r0_0 wwl_op1_1000_rh_s5_r0 wbl_op1_1000_rh_s5_r0 0 sky130_fd_pr__nfet_01v8 L=0.15 W=0.42 nf=1 ad=0.1218 as=0.1218 pd=1.42 ps=1.42 nrd=0.69047619047619  nrs=0.69047619047619 sa=0 sb=0 sd=0 mult=1 m=1
XMRD_op1_1000_rh_s5_r0_0 rbl_op1_1000_rh_s5_r0 sn_op1_1000_rh_s5_r0_0 rwls_op1_1000_rh_s5_r0 0 sky130_fd_pr__nfet_01v8 L=0.15 W=0.42 nf=1 ad=0.1218 as=0.1218 pd=1.42 ps=1.42 nrd=0.69047619047619  nrs=0.69047619047619 sa=0 sb=0 sd=0 mult=1 m=1
csn_op1_1000_rh_s5_r0_0 sn_op1_1000_rh_s5_r0_0 0 {C_SN}
XMWR_op1_1000_rh_s5_r0_1 sn_op1_1000_rh_s5_r0_1 wwl_des wbl_op1_1000_rh_s5_r0 0 sky130_fd_pr__nfet_01v8 L=0.15 W=0.42 nf=1 ad=0.1218 as=0.1218 pd=1.42 ps=1.42 nrd=0.69047619047619  nrs=0.69047619047619 sa=0 sb=0 sd=0 mult=1 m=1
XMRD_op1_1000_rh_s5_r0_1 rbl_op1_1000_rh_s5_r0 sn_op1_1000_rh_s5_r0_1 rwl_des 0 sky130_fd_pr__nfet_01v8 L=0.15 W=0.42 nf=1 ad=0.1218 as=0.1218 pd=1.42 ps=1.42 nrd=0.69047619047619  nrs=0.69047619047619 sa=0 sb=0 sd=0 mult=1 m=1
csn_op1_1000_rh_s5_r0_1 sn_op1_1000_rh_s5_r0_1 0 {C_SN}
XMWR_op1_1000_rh_s5_r0_2 sn_op1_1000_rh_s5_r0_2 wwl_des wbl_op1_1000_rh_s5_r0 0 sky130_fd_pr__nfet_01v8 L=0.15 W=0.42 nf=1 ad=0.1218 as=0.1218 pd=1.42 ps=1.42 nrd=0.69047619047619  nrs=0.69047619047619 sa=0 sb=0 sd=0 mult=1 m=1
XMRD_op1_1000_rh_s5_r0_2 rbl_op1_1000_rh_s5_r0 sn_op1_1000_rh_s5_r0_2 rwl_des 0 sky130_fd_pr__nfet_01v8 L=0.15 W=0.42 nf=1 ad=0.1218 as=0.1218 pd=1.42 ps=1.42 nrd=0.69047619047619  nrs=0.69047619047619 sa=0 sb=0 sd=0 mult=1 m=1
csn_op1_1000_rh_s5_r0_2 sn_op1_1000_rh_s5_r0_2 0 {C_SN}
XMWR_op1_1000_rh_s5_r0_3 sn_op1_1000_rh_s5_r0_3 wwl_des wbl_op1_1000_rh_s5_r0 0 sky130_fd_pr__nfet_01v8 L=0.15 W=0.42 nf=1 ad=0.1218 as=0.1218 pd=1.42 ps=1.42 nrd=0.69047619047619  nrs=0.69047619047619 sa=0 sb=0 sd=0 mult=1 m=1
XMRD_op1_1000_rh_s5_r0_3 rbl_op1_1000_rh_s5_r0 sn_op1_1000_rh_s5_r0_3 rwl_des 0 sky130_fd_pr__nfet_01v8 L=0.15 W=0.42 nf=1 ad=0.1218 as=0.1218 pd=1.42 ps=1.42 nrd=0.69047619047619  nrs=0.69047619047619 sa=0 sb=0 sd=0 mult=1 m=1
csn_op1_1000_rh_s5_r0_3 sn_op1_1000_rh_s5_r0_3 0 {C_SN}
XMN1_op1_1000_rh_s5_r0 rbl_op1_1000_rh_s5_r0 ref_op1_1000_rh_s5_r0 vn_op1_1000_rh_s5_r0 0 sky130_fd_pr__nfet_01v8 L=0.15 W=1 nf=1 ad=0.29 as=0.29 pd=2.58 ps=2.58 mult=1 m=1
XMN2_op1_1000_rh_s5_r0 ref_op1_1000_rh_s5_r0 rbl_op1_1000_rh_s5_r0 vn_op1_1000_rh_s5_r0 0 sky130_fd_pr__nfet_01v8 L=0.15 W=1 nf=1 ad=0.29 as=0.29 pd=2.58 ps=2.58 mult=1 m=1
XMP1_op1_1000_rh_s5_r0 rbl_op1_1000_rh_s5_r0 ref_op1_1000_rh_s5_r0 vp_op1_1000_rh_s5_r0 vdd sky130_fd_pr__pfet_01v8 L=0.15 W=2 nf=1 ad=0.58 as=0.58 pd=4.58 ps=4.58 mult=1 m=1
XMP2_op1_1000_rh_s5_r0 ref_op1_1000_rh_s5_r0 rbl_op1_1000_rh_s5_r0 vp_op1_1000_rh_s5_r0 vdd sky130_fd_pr__pfet_01v8 L=0.15 W=2 nf=1 ad=0.58 as=0.58 pd=4.58 ps=4.58 mult=1 m=1
XMNF_op1_1000_rh_s5_r0 vn_op1_1000_rh_s5_r0 en_op1_1000_rh_s5_r0 0 0 sky130_fd_pr__nfet_01v8 L=0.15 W=2 nf=1 ad=0.58 as=0.58 pd=4.58 ps=4.58 mult=1 m=1
XMPH_op1_1000_rh_s5_r0 vp_op1_1000_rh_s5_r0 enb_op1_1000_rh_s5_r0 vdd vdd sky130_fd_pr__pfet_01v8 L=0.15 W=4 nf=1 ad=1.16 as=1.16 pd=8.58 ps=8.58 mult=1 m=1
bd_op1_1000_rh_s5_r0 d_op1_1000_rh_s5_r0 0 v=v(rbl_op1_1000_rh_s5_r0)-v(ref_op1_1000_rh_s5_r0)

* ---- instance 115: op0_n100_rh_s5_r0 (variant rh_s5_r0; probe dec 11.9 ns, release 34 ns, meas 36 ns) ----
vctl_op0_n100_rh_s5_r0 ctl_op0_n100_rh_s5_r0 0 pwl(0.0000e+00 {VDD} 2.0000e-09 {VDD} 2.1000e-09 0)
* RWL driver model (EXPERIMENTAL): slew 5 ns, series R 0 ohm; cell pin = rwls_op0_n100_rh_s5_r0
vrs_op0_n100_rh_s5_r0 rwls_op0_n100_rh_s5_r0 0 pwl(0.0000e+00 {VDD} 2.0000e-09 {VDD} 7.0000e-09 0 1.2000e-08 0 1.7000e-08 {VDD})
ven_op0_n100_rh_s5_r0 en_op0_n100_rh_s5_r0 0 pwl(0.0000e+00 0 1.1000e-08 0 1.1100e-08 {VDD} 3.4000e-08 {VDD} 3.4100e-08 0)
venb_op0_n100_rh_s5_r0 enb_op0_n100_rh_s5_r0 0 pwl(0.0000e+00 {VDD} 1.1000e-08 {VDD} 1.1100e-08 0 3.4000e-08 0 3.4100e-08 {VDD})
vww_op0_n100_rh_s5_r0 wwl_op0_n100_rh_s5_r0 0 pwl(0.0000e+00 0 1.2000e-08 0 1.2100e-08 {VDD} 3.2000e-08 {VDD} 3.2100e-08 0)
vwc_op0_n100_rh_s5_r0 wbc_op0_n100_rh_s5_r0 0 pwl(0.0000e+00 0 1.2000e-08 0 1.2100e-08 {VDD} 3.4000e-08 {VDD} 3.4100e-08 0)
swb_op0_n100_rh_s5_r0 ref_op0_n100_rh_s5_r0 wbl_op0_n100_rh_s5_r0 wbc_op0_n100_rh_s5_r0 0 swwbl
cwbl_op0_n100_rh_s5_r0 wbl_op0_n100_rh_s5_r0 0 {C_WBL}
spa_op0_n100_rh_s5_r0 prea rbl_op0_n100_rh_s5_r0 ctl_op0_n100_rh_s5_r0 0 swpre
spr_op0_n100_rh_s5_r0 pref ref_op0_n100_rh_s5_r0 ctl_op0_n100_rh_s5_r0 0 swpre
crbl_op0_n100_rh_s5_r0 rbl_op0_n100_rh_s5_r0 0 {C_RBL}
cref_op0_n100_rh_s5_r0 ref_op0_n100_rh_s5_r0 0 {C_RBL}   $ ASSUMPTION: ideal matched dummy load
XMWR_op0_n100_rh_s5_r0_0 sn_op0_n100_rh_s5_r0_0 wwl_op0_n100_rh_s5_r0 wbl_op0_n100_rh_s5_r0 0 sky130_fd_pr__nfet_01v8 L=0.15 W=0.42 nf=1 ad=0.1218 as=0.1218 pd=1.42 ps=1.42 nrd=0.69047619047619  nrs=0.69047619047619 sa=0 sb=0 sd=0 mult=1 m=1
XMRD_op0_n100_rh_s5_r0_0 rbl_op0_n100_rh_s5_r0 sn_op0_n100_rh_s5_r0_0 rwls_op0_n100_rh_s5_r0 0 sky130_fd_pr__nfet_01v8 L=0.15 W=0.42 nf=1 ad=0.1218 as=0.1218 pd=1.42 ps=1.42 nrd=0.69047619047619  nrs=0.69047619047619 sa=0 sb=0 sd=0 mult=1 m=1
csn_op0_n100_rh_s5_r0_0 sn_op0_n100_rh_s5_r0_0 0 {C_SN}
XMWR_op0_n100_rh_s5_r0_1 sn_op0_n100_rh_s5_r0_1 wwl_des wbl_op0_n100_rh_s5_r0 0 sky130_fd_pr__nfet_01v8 L=0.15 W=0.42 nf=1 ad=0.1218 as=0.1218 pd=1.42 ps=1.42 nrd=0.69047619047619  nrs=0.69047619047619 sa=0 sb=0 sd=0 mult=1 m=1
XMRD_op0_n100_rh_s5_r0_1 rbl_op0_n100_rh_s5_r0 sn_op0_n100_rh_s5_r0_1 rwl_des 0 sky130_fd_pr__nfet_01v8 L=0.15 W=0.42 nf=1 ad=0.1218 as=0.1218 pd=1.42 ps=1.42 nrd=0.69047619047619  nrs=0.69047619047619 sa=0 sb=0 sd=0 mult=1 m=1
csn_op0_n100_rh_s5_r0_1 sn_op0_n100_rh_s5_r0_1 0 {C_SN}
XMWR_op0_n100_rh_s5_r0_2 sn_op0_n100_rh_s5_r0_2 wwl_des wbl_op0_n100_rh_s5_r0 0 sky130_fd_pr__nfet_01v8 L=0.15 W=0.42 nf=1 ad=0.1218 as=0.1218 pd=1.42 ps=1.42 nrd=0.69047619047619  nrs=0.69047619047619 sa=0 sb=0 sd=0 mult=1 m=1
XMRD_op0_n100_rh_s5_r0_2 rbl_op0_n100_rh_s5_r0 sn_op0_n100_rh_s5_r0_2 rwl_des 0 sky130_fd_pr__nfet_01v8 L=0.15 W=0.42 nf=1 ad=0.1218 as=0.1218 pd=1.42 ps=1.42 nrd=0.69047619047619  nrs=0.69047619047619 sa=0 sb=0 sd=0 mult=1 m=1
csn_op0_n100_rh_s5_r0_2 sn_op0_n100_rh_s5_r0_2 0 {C_SN}
XMWR_op0_n100_rh_s5_r0_3 sn_op0_n100_rh_s5_r0_3 wwl_des wbl_op0_n100_rh_s5_r0 0 sky130_fd_pr__nfet_01v8 L=0.15 W=0.42 nf=1 ad=0.1218 as=0.1218 pd=1.42 ps=1.42 nrd=0.69047619047619  nrs=0.69047619047619 sa=0 sb=0 sd=0 mult=1 m=1
XMRD_op0_n100_rh_s5_r0_3 rbl_op0_n100_rh_s5_r0 sn_op0_n100_rh_s5_r0_3 rwl_des 0 sky130_fd_pr__nfet_01v8 L=0.15 W=0.42 nf=1 ad=0.1218 as=0.1218 pd=1.42 ps=1.42 nrd=0.69047619047619  nrs=0.69047619047619 sa=0 sb=0 sd=0 mult=1 m=1
csn_op0_n100_rh_s5_r0_3 sn_op0_n100_rh_s5_r0_3 0 {C_SN}
XMN1_op0_n100_rh_s5_r0 rbl_op0_n100_rh_s5_r0 ref_op0_n100_rh_s5_r0 vn_op0_n100_rh_s5_r0 0 sky130_fd_pr__nfet_01v8 L=0.15 W=1 nf=1 ad=0.29 as=0.29 pd=2.58 ps=2.58 mult=1 m=1
XMN2_op0_n100_rh_s5_r0 ref_op0_n100_rh_s5_r0 rbl_op0_n100_rh_s5_r0 vn_op0_n100_rh_s5_r0 0 sky130_fd_pr__nfet_01v8 L=0.15 W=1 nf=1 ad=0.29 as=0.29 pd=2.58 ps=2.58 mult=1 m=1
XMP1_op0_n100_rh_s5_r0 rbl_op0_n100_rh_s5_r0 ref_op0_n100_rh_s5_r0 vp_op0_n100_rh_s5_r0 vdd sky130_fd_pr__pfet_01v8 L=0.15 W=2 nf=1 ad=0.58 as=0.58 pd=4.58 ps=4.58 mult=1 m=1
XMP2_op0_n100_rh_s5_r0 ref_op0_n100_rh_s5_r0 rbl_op0_n100_rh_s5_r0 vp_op0_n100_rh_s5_r0 vdd sky130_fd_pr__pfet_01v8 L=0.15 W=2 nf=1 ad=0.58 as=0.58 pd=4.58 ps=4.58 mult=1 m=1
XMNF_op0_n100_rh_s5_r0 vn_op0_n100_rh_s5_r0 en_op0_n100_rh_s5_r0 0 0 sky130_fd_pr__nfet_01v8 L=0.15 W=2 nf=1 ad=0.58 as=0.58 pd=4.58 ps=4.58 mult=1 m=1
XMPH_op0_n100_rh_s5_r0 vp_op0_n100_rh_s5_r0 enb_op0_n100_rh_s5_r0 vdd vdd sky130_fd_pr__pfet_01v8 L=0.15 W=4 nf=1 ad=1.16 as=1.16 pd=8.58 ps=8.58 mult=1 m=1
bd_op0_n100_rh_s5_r0 d_op0_n100_rh_s5_r0 0 v=v(rbl_op0_n100_rh_s5_r0)-v(ref_op0_n100_rh_s5_r0)

* ---- instance 116: op0_0000_rh_s5_r0 (variant rh_s5_r0; probe dec 11.9 ns, release 34 ns, meas 36 ns) ----
vctl_op0_0000_rh_s5_r0 ctl_op0_0000_rh_s5_r0 0 pwl(0.0000e+00 {VDD} 2.0000e-09 {VDD} 2.1000e-09 0)
* RWL driver model (EXPERIMENTAL): slew 5 ns, series R 0 ohm; cell pin = rwls_op0_0000_rh_s5_r0
vrs_op0_0000_rh_s5_r0 rwls_op0_0000_rh_s5_r0 0 pwl(0.0000e+00 {VDD} 2.0000e-09 {VDD} 7.0000e-09 0 1.2000e-08 0 1.7000e-08 {VDD})
ven_op0_0000_rh_s5_r0 en_op0_0000_rh_s5_r0 0 pwl(0.0000e+00 0 1.1000e-08 0 1.1100e-08 {VDD} 3.4000e-08 {VDD} 3.4100e-08 0)
venb_op0_0000_rh_s5_r0 enb_op0_0000_rh_s5_r0 0 pwl(0.0000e+00 {VDD} 1.1000e-08 {VDD} 1.1100e-08 0 3.4000e-08 0 3.4100e-08 {VDD})
vww_op0_0000_rh_s5_r0 wwl_op0_0000_rh_s5_r0 0 pwl(0.0000e+00 0 1.2000e-08 0 1.2100e-08 {VDD} 3.2000e-08 {VDD} 3.2100e-08 0)
vwc_op0_0000_rh_s5_r0 wbc_op0_0000_rh_s5_r0 0 pwl(0.0000e+00 0 1.2000e-08 0 1.2100e-08 {VDD} 3.4000e-08 {VDD} 3.4100e-08 0)
swb_op0_0000_rh_s5_r0 ref_op0_0000_rh_s5_r0 wbl_op0_0000_rh_s5_r0 wbc_op0_0000_rh_s5_r0 0 swwbl
cwbl_op0_0000_rh_s5_r0 wbl_op0_0000_rh_s5_r0 0 {C_WBL}
spa_op0_0000_rh_s5_r0 prea rbl_op0_0000_rh_s5_r0 ctl_op0_0000_rh_s5_r0 0 swpre
spr_op0_0000_rh_s5_r0 pref ref_op0_0000_rh_s5_r0 ctl_op0_0000_rh_s5_r0 0 swpre
crbl_op0_0000_rh_s5_r0 rbl_op0_0000_rh_s5_r0 0 {C_RBL}
cref_op0_0000_rh_s5_r0 ref_op0_0000_rh_s5_r0 0 {C_RBL}   $ ASSUMPTION: ideal matched dummy load
XMWR_op0_0000_rh_s5_r0_0 sn_op0_0000_rh_s5_r0_0 wwl_op0_0000_rh_s5_r0 wbl_op0_0000_rh_s5_r0 0 sky130_fd_pr__nfet_01v8 L=0.15 W=0.42 nf=1 ad=0.1218 as=0.1218 pd=1.42 ps=1.42 nrd=0.69047619047619  nrs=0.69047619047619 sa=0 sb=0 sd=0 mult=1 m=1
XMRD_op0_0000_rh_s5_r0_0 rbl_op0_0000_rh_s5_r0 sn_op0_0000_rh_s5_r0_0 rwls_op0_0000_rh_s5_r0 0 sky130_fd_pr__nfet_01v8 L=0.15 W=0.42 nf=1 ad=0.1218 as=0.1218 pd=1.42 ps=1.42 nrd=0.69047619047619  nrs=0.69047619047619 sa=0 sb=0 sd=0 mult=1 m=1
csn_op0_0000_rh_s5_r0_0 sn_op0_0000_rh_s5_r0_0 0 {C_SN}
XMWR_op0_0000_rh_s5_r0_1 sn_op0_0000_rh_s5_r0_1 wwl_des wbl_op0_0000_rh_s5_r0 0 sky130_fd_pr__nfet_01v8 L=0.15 W=0.42 nf=1 ad=0.1218 as=0.1218 pd=1.42 ps=1.42 nrd=0.69047619047619  nrs=0.69047619047619 sa=0 sb=0 sd=0 mult=1 m=1
XMRD_op0_0000_rh_s5_r0_1 rbl_op0_0000_rh_s5_r0 sn_op0_0000_rh_s5_r0_1 rwl_des 0 sky130_fd_pr__nfet_01v8 L=0.15 W=0.42 nf=1 ad=0.1218 as=0.1218 pd=1.42 ps=1.42 nrd=0.69047619047619  nrs=0.69047619047619 sa=0 sb=0 sd=0 mult=1 m=1
csn_op0_0000_rh_s5_r0_1 sn_op0_0000_rh_s5_r0_1 0 {C_SN}
XMWR_op0_0000_rh_s5_r0_2 sn_op0_0000_rh_s5_r0_2 wwl_des wbl_op0_0000_rh_s5_r0 0 sky130_fd_pr__nfet_01v8 L=0.15 W=0.42 nf=1 ad=0.1218 as=0.1218 pd=1.42 ps=1.42 nrd=0.69047619047619  nrs=0.69047619047619 sa=0 sb=0 sd=0 mult=1 m=1
XMRD_op0_0000_rh_s5_r0_2 rbl_op0_0000_rh_s5_r0 sn_op0_0000_rh_s5_r0_2 rwl_des 0 sky130_fd_pr__nfet_01v8 L=0.15 W=0.42 nf=1 ad=0.1218 as=0.1218 pd=1.42 ps=1.42 nrd=0.69047619047619  nrs=0.69047619047619 sa=0 sb=0 sd=0 mult=1 m=1
csn_op0_0000_rh_s5_r0_2 sn_op0_0000_rh_s5_r0_2 0 {C_SN}
XMWR_op0_0000_rh_s5_r0_3 sn_op0_0000_rh_s5_r0_3 wwl_des wbl_op0_0000_rh_s5_r0 0 sky130_fd_pr__nfet_01v8 L=0.15 W=0.42 nf=1 ad=0.1218 as=0.1218 pd=1.42 ps=1.42 nrd=0.69047619047619  nrs=0.69047619047619 sa=0 sb=0 sd=0 mult=1 m=1
XMRD_op0_0000_rh_s5_r0_3 rbl_op0_0000_rh_s5_r0 sn_op0_0000_rh_s5_r0_3 rwl_des 0 sky130_fd_pr__nfet_01v8 L=0.15 W=0.42 nf=1 ad=0.1218 as=0.1218 pd=1.42 ps=1.42 nrd=0.69047619047619  nrs=0.69047619047619 sa=0 sb=0 sd=0 mult=1 m=1
csn_op0_0000_rh_s5_r0_3 sn_op0_0000_rh_s5_r0_3 0 {C_SN}
XMN1_op0_0000_rh_s5_r0 rbl_op0_0000_rh_s5_r0 ref_op0_0000_rh_s5_r0 vn_op0_0000_rh_s5_r0 0 sky130_fd_pr__nfet_01v8 L=0.15 W=1 nf=1 ad=0.29 as=0.29 pd=2.58 ps=2.58 mult=1 m=1
XMN2_op0_0000_rh_s5_r0 ref_op0_0000_rh_s5_r0 rbl_op0_0000_rh_s5_r0 vn_op0_0000_rh_s5_r0 0 sky130_fd_pr__nfet_01v8 L=0.15 W=1 nf=1 ad=0.29 as=0.29 pd=2.58 ps=2.58 mult=1 m=1
XMP1_op0_0000_rh_s5_r0 rbl_op0_0000_rh_s5_r0 ref_op0_0000_rh_s5_r0 vp_op0_0000_rh_s5_r0 vdd sky130_fd_pr__pfet_01v8 L=0.15 W=2 nf=1 ad=0.58 as=0.58 pd=4.58 ps=4.58 mult=1 m=1
XMP2_op0_0000_rh_s5_r0 ref_op0_0000_rh_s5_r0 rbl_op0_0000_rh_s5_r0 vp_op0_0000_rh_s5_r0 vdd sky130_fd_pr__pfet_01v8 L=0.15 W=2 nf=1 ad=0.58 as=0.58 pd=4.58 ps=4.58 mult=1 m=1
XMNF_op0_0000_rh_s5_r0 vn_op0_0000_rh_s5_r0 en_op0_0000_rh_s5_r0 0 0 sky130_fd_pr__nfet_01v8 L=0.15 W=2 nf=1 ad=0.58 as=0.58 pd=4.58 ps=4.58 mult=1 m=1
XMPH_op0_0000_rh_s5_r0 vp_op0_0000_rh_s5_r0 enb_op0_0000_rh_s5_r0 vdd vdd sky130_fd_pr__pfet_01v8 L=0.15 W=4 nf=1 ad=1.16 as=1.16 pd=8.58 ps=8.58 mult=1 m=1
bd_op0_0000_rh_s5_r0 d_op0_0000_rh_s5_r0 0 v=v(rbl_op0_0000_rh_s5_r0)-v(ref_op0_0000_rh_s5_r0)

* ---- instance 117: op1_0900_rh_s0p1_r1k (variant rh_s0p1_r1k; probe dec 11.9 ns, release 34 ns, meas 36 ns) ----
vctl_op1_0900_rh_s0p1_r1k ctl_op1_0900_rh_s0p1_r1k 0 pwl(0.0000e+00 {VDD} 2.0000e-09 {VDD} 2.1000e-09 0)
* RWL driver model (EXPERIMENTAL): slew 0.1 ns, series R 1000 ohm; cell pin = rwls_op1_0900_rh_s0p1_r1k
vrs_op1_0900_rh_s0p1_r1k rwlsrc_op1_0900_rh_s0p1_r1k 0 pwl(0.0000e+00 {VDD} 2.0000e-09 {VDD} 2.1000e-09 0 1.2000e-08 0 1.2100e-08 {VDD})
rdrv_op1_0900_rh_s0p1_r1k rwlsrc_op1_0900_rh_s0p1_r1k rwls_op1_0900_rh_s0p1_r1k 1000
ven_op1_0900_rh_s0p1_r1k en_op1_0900_rh_s0p1_r1k 0 pwl(0.0000e+00 0 1.1000e-08 0 1.1100e-08 {VDD} 3.4000e-08 {VDD} 3.4100e-08 0)
venb_op1_0900_rh_s0p1_r1k enb_op1_0900_rh_s0p1_r1k 0 pwl(0.0000e+00 {VDD} 1.1000e-08 {VDD} 1.1100e-08 0 3.4000e-08 0 3.4100e-08 {VDD})
vww_op1_0900_rh_s0p1_r1k wwl_op1_0900_rh_s0p1_r1k 0 pwl(0.0000e+00 0 1.2000e-08 0 1.2100e-08 {VDD} 3.2000e-08 {VDD} 3.2100e-08 0)
vwc_op1_0900_rh_s0p1_r1k wbc_op1_0900_rh_s0p1_r1k 0 pwl(0.0000e+00 0 1.2000e-08 0 1.2100e-08 {VDD} 3.4000e-08 {VDD} 3.4100e-08 0)
swb_op1_0900_rh_s0p1_r1k ref_op1_0900_rh_s0p1_r1k wbl_op1_0900_rh_s0p1_r1k wbc_op1_0900_rh_s0p1_r1k 0 swwbl
cwbl_op1_0900_rh_s0p1_r1k wbl_op1_0900_rh_s0p1_r1k 0 {C_WBL}
spa_op1_0900_rh_s0p1_r1k prea rbl_op1_0900_rh_s0p1_r1k ctl_op1_0900_rh_s0p1_r1k 0 swpre
spr_op1_0900_rh_s0p1_r1k pref ref_op1_0900_rh_s0p1_r1k ctl_op1_0900_rh_s0p1_r1k 0 swpre
crbl_op1_0900_rh_s0p1_r1k rbl_op1_0900_rh_s0p1_r1k 0 {C_RBL}
cref_op1_0900_rh_s0p1_r1k ref_op1_0900_rh_s0p1_r1k 0 {C_RBL}   $ ASSUMPTION: ideal matched dummy load
XMWR_op1_0900_rh_s0p1_r1k_0 sn_op1_0900_rh_s0p1_r1k_0 wwl_op1_0900_rh_s0p1_r1k wbl_op1_0900_rh_s0p1_r1k 0 sky130_fd_pr__nfet_01v8 L=0.15 W=0.42 nf=1 ad=0.1218 as=0.1218 pd=1.42 ps=1.42 nrd=0.69047619047619  nrs=0.69047619047619 sa=0 sb=0 sd=0 mult=1 m=1
XMRD_op1_0900_rh_s0p1_r1k_0 rbl_op1_0900_rh_s0p1_r1k sn_op1_0900_rh_s0p1_r1k_0 rwls_op1_0900_rh_s0p1_r1k 0 sky130_fd_pr__nfet_01v8 L=0.15 W=0.42 nf=1 ad=0.1218 as=0.1218 pd=1.42 ps=1.42 nrd=0.69047619047619  nrs=0.69047619047619 sa=0 sb=0 sd=0 mult=1 m=1
csn_op1_0900_rh_s0p1_r1k_0 sn_op1_0900_rh_s0p1_r1k_0 0 {C_SN}
XMWR_op1_0900_rh_s0p1_r1k_1 sn_op1_0900_rh_s0p1_r1k_1 wwl_des wbl_op1_0900_rh_s0p1_r1k 0 sky130_fd_pr__nfet_01v8 L=0.15 W=0.42 nf=1 ad=0.1218 as=0.1218 pd=1.42 ps=1.42 nrd=0.69047619047619  nrs=0.69047619047619 sa=0 sb=0 sd=0 mult=1 m=1
XMRD_op1_0900_rh_s0p1_r1k_1 rbl_op1_0900_rh_s0p1_r1k sn_op1_0900_rh_s0p1_r1k_1 rwl_des 0 sky130_fd_pr__nfet_01v8 L=0.15 W=0.42 nf=1 ad=0.1218 as=0.1218 pd=1.42 ps=1.42 nrd=0.69047619047619  nrs=0.69047619047619 sa=0 sb=0 sd=0 mult=1 m=1
csn_op1_0900_rh_s0p1_r1k_1 sn_op1_0900_rh_s0p1_r1k_1 0 {C_SN}
XMWR_op1_0900_rh_s0p1_r1k_2 sn_op1_0900_rh_s0p1_r1k_2 wwl_des wbl_op1_0900_rh_s0p1_r1k 0 sky130_fd_pr__nfet_01v8 L=0.15 W=0.42 nf=1 ad=0.1218 as=0.1218 pd=1.42 ps=1.42 nrd=0.69047619047619  nrs=0.69047619047619 sa=0 sb=0 sd=0 mult=1 m=1
XMRD_op1_0900_rh_s0p1_r1k_2 rbl_op1_0900_rh_s0p1_r1k sn_op1_0900_rh_s0p1_r1k_2 rwl_des 0 sky130_fd_pr__nfet_01v8 L=0.15 W=0.42 nf=1 ad=0.1218 as=0.1218 pd=1.42 ps=1.42 nrd=0.69047619047619  nrs=0.69047619047619 sa=0 sb=0 sd=0 mult=1 m=1
csn_op1_0900_rh_s0p1_r1k_2 sn_op1_0900_rh_s0p1_r1k_2 0 {C_SN}
XMWR_op1_0900_rh_s0p1_r1k_3 sn_op1_0900_rh_s0p1_r1k_3 wwl_des wbl_op1_0900_rh_s0p1_r1k 0 sky130_fd_pr__nfet_01v8 L=0.15 W=0.42 nf=1 ad=0.1218 as=0.1218 pd=1.42 ps=1.42 nrd=0.69047619047619  nrs=0.69047619047619 sa=0 sb=0 sd=0 mult=1 m=1
XMRD_op1_0900_rh_s0p1_r1k_3 rbl_op1_0900_rh_s0p1_r1k sn_op1_0900_rh_s0p1_r1k_3 rwl_des 0 sky130_fd_pr__nfet_01v8 L=0.15 W=0.42 nf=1 ad=0.1218 as=0.1218 pd=1.42 ps=1.42 nrd=0.69047619047619  nrs=0.69047619047619 sa=0 sb=0 sd=0 mult=1 m=1
csn_op1_0900_rh_s0p1_r1k_3 sn_op1_0900_rh_s0p1_r1k_3 0 {C_SN}
XMN1_op1_0900_rh_s0p1_r1k rbl_op1_0900_rh_s0p1_r1k ref_op1_0900_rh_s0p1_r1k vn_op1_0900_rh_s0p1_r1k 0 sky130_fd_pr__nfet_01v8 L=0.15 W=1 nf=1 ad=0.29 as=0.29 pd=2.58 ps=2.58 mult=1 m=1
XMN2_op1_0900_rh_s0p1_r1k ref_op1_0900_rh_s0p1_r1k rbl_op1_0900_rh_s0p1_r1k vn_op1_0900_rh_s0p1_r1k 0 sky130_fd_pr__nfet_01v8 L=0.15 W=1 nf=1 ad=0.29 as=0.29 pd=2.58 ps=2.58 mult=1 m=1
XMP1_op1_0900_rh_s0p1_r1k rbl_op1_0900_rh_s0p1_r1k ref_op1_0900_rh_s0p1_r1k vp_op1_0900_rh_s0p1_r1k vdd sky130_fd_pr__pfet_01v8 L=0.15 W=2 nf=1 ad=0.58 as=0.58 pd=4.58 ps=4.58 mult=1 m=1
XMP2_op1_0900_rh_s0p1_r1k ref_op1_0900_rh_s0p1_r1k rbl_op1_0900_rh_s0p1_r1k vp_op1_0900_rh_s0p1_r1k vdd sky130_fd_pr__pfet_01v8 L=0.15 W=2 nf=1 ad=0.58 as=0.58 pd=4.58 ps=4.58 mult=1 m=1
XMNF_op1_0900_rh_s0p1_r1k vn_op1_0900_rh_s0p1_r1k en_op1_0900_rh_s0p1_r1k 0 0 sky130_fd_pr__nfet_01v8 L=0.15 W=2 nf=1 ad=0.58 as=0.58 pd=4.58 ps=4.58 mult=1 m=1
XMPH_op1_0900_rh_s0p1_r1k vp_op1_0900_rh_s0p1_r1k enb_op1_0900_rh_s0p1_r1k vdd vdd sky130_fd_pr__pfet_01v8 L=0.15 W=4 nf=1 ad=1.16 as=1.16 pd=8.58 ps=8.58 mult=1 m=1
bd_op1_0900_rh_s0p1_r1k d_op1_0900_rh_s0p1_r1k 0 v=v(rbl_op1_0900_rh_s0p1_r1k)-v(ref_op1_0900_rh_s0p1_r1k)

* ---- instance 118: op1_1000_rh_s0p1_r1k (variant rh_s0p1_r1k; probe dec 11.9 ns, release 34 ns, meas 36 ns) ----
vctl_op1_1000_rh_s0p1_r1k ctl_op1_1000_rh_s0p1_r1k 0 pwl(0.0000e+00 {VDD} 2.0000e-09 {VDD} 2.1000e-09 0)
* RWL driver model (EXPERIMENTAL): slew 0.1 ns, series R 1000 ohm; cell pin = rwls_op1_1000_rh_s0p1_r1k
vrs_op1_1000_rh_s0p1_r1k rwlsrc_op1_1000_rh_s0p1_r1k 0 pwl(0.0000e+00 {VDD} 2.0000e-09 {VDD} 2.1000e-09 0 1.2000e-08 0 1.2100e-08 {VDD})
rdrv_op1_1000_rh_s0p1_r1k rwlsrc_op1_1000_rh_s0p1_r1k rwls_op1_1000_rh_s0p1_r1k 1000
ven_op1_1000_rh_s0p1_r1k en_op1_1000_rh_s0p1_r1k 0 pwl(0.0000e+00 0 1.1000e-08 0 1.1100e-08 {VDD} 3.4000e-08 {VDD} 3.4100e-08 0)
venb_op1_1000_rh_s0p1_r1k enb_op1_1000_rh_s0p1_r1k 0 pwl(0.0000e+00 {VDD} 1.1000e-08 {VDD} 1.1100e-08 0 3.4000e-08 0 3.4100e-08 {VDD})
vww_op1_1000_rh_s0p1_r1k wwl_op1_1000_rh_s0p1_r1k 0 pwl(0.0000e+00 0 1.2000e-08 0 1.2100e-08 {VDD} 3.2000e-08 {VDD} 3.2100e-08 0)
vwc_op1_1000_rh_s0p1_r1k wbc_op1_1000_rh_s0p1_r1k 0 pwl(0.0000e+00 0 1.2000e-08 0 1.2100e-08 {VDD} 3.4000e-08 {VDD} 3.4100e-08 0)
swb_op1_1000_rh_s0p1_r1k ref_op1_1000_rh_s0p1_r1k wbl_op1_1000_rh_s0p1_r1k wbc_op1_1000_rh_s0p1_r1k 0 swwbl
cwbl_op1_1000_rh_s0p1_r1k wbl_op1_1000_rh_s0p1_r1k 0 {C_WBL}
spa_op1_1000_rh_s0p1_r1k prea rbl_op1_1000_rh_s0p1_r1k ctl_op1_1000_rh_s0p1_r1k 0 swpre
spr_op1_1000_rh_s0p1_r1k pref ref_op1_1000_rh_s0p1_r1k ctl_op1_1000_rh_s0p1_r1k 0 swpre
crbl_op1_1000_rh_s0p1_r1k rbl_op1_1000_rh_s0p1_r1k 0 {C_RBL}
cref_op1_1000_rh_s0p1_r1k ref_op1_1000_rh_s0p1_r1k 0 {C_RBL}   $ ASSUMPTION: ideal matched dummy load
XMWR_op1_1000_rh_s0p1_r1k_0 sn_op1_1000_rh_s0p1_r1k_0 wwl_op1_1000_rh_s0p1_r1k wbl_op1_1000_rh_s0p1_r1k 0 sky130_fd_pr__nfet_01v8 L=0.15 W=0.42 nf=1 ad=0.1218 as=0.1218 pd=1.42 ps=1.42 nrd=0.69047619047619  nrs=0.69047619047619 sa=0 sb=0 sd=0 mult=1 m=1
XMRD_op1_1000_rh_s0p1_r1k_0 rbl_op1_1000_rh_s0p1_r1k sn_op1_1000_rh_s0p1_r1k_0 rwls_op1_1000_rh_s0p1_r1k 0 sky130_fd_pr__nfet_01v8 L=0.15 W=0.42 nf=1 ad=0.1218 as=0.1218 pd=1.42 ps=1.42 nrd=0.69047619047619  nrs=0.69047619047619 sa=0 sb=0 sd=0 mult=1 m=1
csn_op1_1000_rh_s0p1_r1k_0 sn_op1_1000_rh_s0p1_r1k_0 0 {C_SN}
XMWR_op1_1000_rh_s0p1_r1k_1 sn_op1_1000_rh_s0p1_r1k_1 wwl_des wbl_op1_1000_rh_s0p1_r1k 0 sky130_fd_pr__nfet_01v8 L=0.15 W=0.42 nf=1 ad=0.1218 as=0.1218 pd=1.42 ps=1.42 nrd=0.69047619047619  nrs=0.69047619047619 sa=0 sb=0 sd=0 mult=1 m=1
XMRD_op1_1000_rh_s0p1_r1k_1 rbl_op1_1000_rh_s0p1_r1k sn_op1_1000_rh_s0p1_r1k_1 rwl_des 0 sky130_fd_pr__nfet_01v8 L=0.15 W=0.42 nf=1 ad=0.1218 as=0.1218 pd=1.42 ps=1.42 nrd=0.69047619047619  nrs=0.69047619047619 sa=0 sb=0 sd=0 mult=1 m=1
csn_op1_1000_rh_s0p1_r1k_1 sn_op1_1000_rh_s0p1_r1k_1 0 {C_SN}
XMWR_op1_1000_rh_s0p1_r1k_2 sn_op1_1000_rh_s0p1_r1k_2 wwl_des wbl_op1_1000_rh_s0p1_r1k 0 sky130_fd_pr__nfet_01v8 L=0.15 W=0.42 nf=1 ad=0.1218 as=0.1218 pd=1.42 ps=1.42 nrd=0.69047619047619  nrs=0.69047619047619 sa=0 sb=0 sd=0 mult=1 m=1
XMRD_op1_1000_rh_s0p1_r1k_2 rbl_op1_1000_rh_s0p1_r1k sn_op1_1000_rh_s0p1_r1k_2 rwl_des 0 sky130_fd_pr__nfet_01v8 L=0.15 W=0.42 nf=1 ad=0.1218 as=0.1218 pd=1.42 ps=1.42 nrd=0.69047619047619  nrs=0.69047619047619 sa=0 sb=0 sd=0 mult=1 m=1
csn_op1_1000_rh_s0p1_r1k_2 sn_op1_1000_rh_s0p1_r1k_2 0 {C_SN}
XMWR_op1_1000_rh_s0p1_r1k_3 sn_op1_1000_rh_s0p1_r1k_3 wwl_des wbl_op1_1000_rh_s0p1_r1k 0 sky130_fd_pr__nfet_01v8 L=0.15 W=0.42 nf=1 ad=0.1218 as=0.1218 pd=1.42 ps=1.42 nrd=0.69047619047619  nrs=0.69047619047619 sa=0 sb=0 sd=0 mult=1 m=1
XMRD_op1_1000_rh_s0p1_r1k_3 rbl_op1_1000_rh_s0p1_r1k sn_op1_1000_rh_s0p1_r1k_3 rwl_des 0 sky130_fd_pr__nfet_01v8 L=0.15 W=0.42 nf=1 ad=0.1218 as=0.1218 pd=1.42 ps=1.42 nrd=0.69047619047619  nrs=0.69047619047619 sa=0 sb=0 sd=0 mult=1 m=1
csn_op1_1000_rh_s0p1_r1k_3 sn_op1_1000_rh_s0p1_r1k_3 0 {C_SN}
XMN1_op1_1000_rh_s0p1_r1k rbl_op1_1000_rh_s0p1_r1k ref_op1_1000_rh_s0p1_r1k vn_op1_1000_rh_s0p1_r1k 0 sky130_fd_pr__nfet_01v8 L=0.15 W=1 nf=1 ad=0.29 as=0.29 pd=2.58 ps=2.58 mult=1 m=1
XMN2_op1_1000_rh_s0p1_r1k ref_op1_1000_rh_s0p1_r1k rbl_op1_1000_rh_s0p1_r1k vn_op1_1000_rh_s0p1_r1k 0 sky130_fd_pr__nfet_01v8 L=0.15 W=1 nf=1 ad=0.29 as=0.29 pd=2.58 ps=2.58 mult=1 m=1
XMP1_op1_1000_rh_s0p1_r1k rbl_op1_1000_rh_s0p1_r1k ref_op1_1000_rh_s0p1_r1k vp_op1_1000_rh_s0p1_r1k vdd sky130_fd_pr__pfet_01v8 L=0.15 W=2 nf=1 ad=0.58 as=0.58 pd=4.58 ps=4.58 mult=1 m=1
XMP2_op1_1000_rh_s0p1_r1k ref_op1_1000_rh_s0p1_r1k rbl_op1_1000_rh_s0p1_r1k vp_op1_1000_rh_s0p1_r1k vdd sky130_fd_pr__pfet_01v8 L=0.15 W=2 nf=1 ad=0.58 as=0.58 pd=4.58 ps=4.58 mult=1 m=1
XMNF_op1_1000_rh_s0p1_r1k vn_op1_1000_rh_s0p1_r1k en_op1_1000_rh_s0p1_r1k 0 0 sky130_fd_pr__nfet_01v8 L=0.15 W=2 nf=1 ad=0.58 as=0.58 pd=4.58 ps=4.58 mult=1 m=1
XMPH_op1_1000_rh_s0p1_r1k vp_op1_1000_rh_s0p1_r1k enb_op1_1000_rh_s0p1_r1k vdd vdd sky130_fd_pr__pfet_01v8 L=0.15 W=4 nf=1 ad=1.16 as=1.16 pd=8.58 ps=8.58 mult=1 m=1
bd_op1_1000_rh_s0p1_r1k d_op1_1000_rh_s0p1_r1k 0 v=v(rbl_op1_1000_rh_s0p1_r1k)-v(ref_op1_1000_rh_s0p1_r1k)

* ---- instance 119: op0_n100_rh_s0p1_r1k (variant rh_s0p1_r1k; probe dec 11.9 ns, release 34 ns, meas 36 ns) ----
vctl_op0_n100_rh_s0p1_r1k ctl_op0_n100_rh_s0p1_r1k 0 pwl(0.0000e+00 {VDD} 2.0000e-09 {VDD} 2.1000e-09 0)
* RWL driver model (EXPERIMENTAL): slew 0.1 ns, series R 1000 ohm; cell pin = rwls_op0_n100_rh_s0p1_r1k
vrs_op0_n100_rh_s0p1_r1k rwlsrc_op0_n100_rh_s0p1_r1k 0 pwl(0.0000e+00 {VDD} 2.0000e-09 {VDD} 2.1000e-09 0 1.2000e-08 0 1.2100e-08 {VDD})
rdrv_op0_n100_rh_s0p1_r1k rwlsrc_op0_n100_rh_s0p1_r1k rwls_op0_n100_rh_s0p1_r1k 1000
ven_op0_n100_rh_s0p1_r1k en_op0_n100_rh_s0p1_r1k 0 pwl(0.0000e+00 0 1.1000e-08 0 1.1100e-08 {VDD} 3.4000e-08 {VDD} 3.4100e-08 0)
venb_op0_n100_rh_s0p1_r1k enb_op0_n100_rh_s0p1_r1k 0 pwl(0.0000e+00 {VDD} 1.1000e-08 {VDD} 1.1100e-08 0 3.4000e-08 0 3.4100e-08 {VDD})
vww_op0_n100_rh_s0p1_r1k wwl_op0_n100_rh_s0p1_r1k 0 pwl(0.0000e+00 0 1.2000e-08 0 1.2100e-08 {VDD} 3.2000e-08 {VDD} 3.2100e-08 0)
vwc_op0_n100_rh_s0p1_r1k wbc_op0_n100_rh_s0p1_r1k 0 pwl(0.0000e+00 0 1.2000e-08 0 1.2100e-08 {VDD} 3.4000e-08 {VDD} 3.4100e-08 0)
swb_op0_n100_rh_s0p1_r1k ref_op0_n100_rh_s0p1_r1k wbl_op0_n100_rh_s0p1_r1k wbc_op0_n100_rh_s0p1_r1k 0 swwbl
cwbl_op0_n100_rh_s0p1_r1k wbl_op0_n100_rh_s0p1_r1k 0 {C_WBL}
spa_op0_n100_rh_s0p1_r1k prea rbl_op0_n100_rh_s0p1_r1k ctl_op0_n100_rh_s0p1_r1k 0 swpre
spr_op0_n100_rh_s0p1_r1k pref ref_op0_n100_rh_s0p1_r1k ctl_op0_n100_rh_s0p1_r1k 0 swpre
crbl_op0_n100_rh_s0p1_r1k rbl_op0_n100_rh_s0p1_r1k 0 {C_RBL}
cref_op0_n100_rh_s0p1_r1k ref_op0_n100_rh_s0p1_r1k 0 {C_RBL}   $ ASSUMPTION: ideal matched dummy load
XMWR_op0_n100_rh_s0p1_r1k_0 sn_op0_n100_rh_s0p1_r1k_0 wwl_op0_n100_rh_s0p1_r1k wbl_op0_n100_rh_s0p1_r1k 0 sky130_fd_pr__nfet_01v8 L=0.15 W=0.42 nf=1 ad=0.1218 as=0.1218 pd=1.42 ps=1.42 nrd=0.69047619047619  nrs=0.69047619047619 sa=0 sb=0 sd=0 mult=1 m=1
XMRD_op0_n100_rh_s0p1_r1k_0 rbl_op0_n100_rh_s0p1_r1k sn_op0_n100_rh_s0p1_r1k_0 rwls_op0_n100_rh_s0p1_r1k 0 sky130_fd_pr__nfet_01v8 L=0.15 W=0.42 nf=1 ad=0.1218 as=0.1218 pd=1.42 ps=1.42 nrd=0.69047619047619  nrs=0.69047619047619 sa=0 sb=0 sd=0 mult=1 m=1
csn_op0_n100_rh_s0p1_r1k_0 sn_op0_n100_rh_s0p1_r1k_0 0 {C_SN}
XMWR_op0_n100_rh_s0p1_r1k_1 sn_op0_n100_rh_s0p1_r1k_1 wwl_des wbl_op0_n100_rh_s0p1_r1k 0 sky130_fd_pr__nfet_01v8 L=0.15 W=0.42 nf=1 ad=0.1218 as=0.1218 pd=1.42 ps=1.42 nrd=0.69047619047619  nrs=0.69047619047619 sa=0 sb=0 sd=0 mult=1 m=1
XMRD_op0_n100_rh_s0p1_r1k_1 rbl_op0_n100_rh_s0p1_r1k sn_op0_n100_rh_s0p1_r1k_1 rwl_des 0 sky130_fd_pr__nfet_01v8 L=0.15 W=0.42 nf=1 ad=0.1218 as=0.1218 pd=1.42 ps=1.42 nrd=0.69047619047619  nrs=0.69047619047619 sa=0 sb=0 sd=0 mult=1 m=1
csn_op0_n100_rh_s0p1_r1k_1 sn_op0_n100_rh_s0p1_r1k_1 0 {C_SN}
XMWR_op0_n100_rh_s0p1_r1k_2 sn_op0_n100_rh_s0p1_r1k_2 wwl_des wbl_op0_n100_rh_s0p1_r1k 0 sky130_fd_pr__nfet_01v8 L=0.15 W=0.42 nf=1 ad=0.1218 as=0.1218 pd=1.42 ps=1.42 nrd=0.69047619047619  nrs=0.69047619047619 sa=0 sb=0 sd=0 mult=1 m=1
XMRD_op0_n100_rh_s0p1_r1k_2 rbl_op0_n100_rh_s0p1_r1k sn_op0_n100_rh_s0p1_r1k_2 rwl_des 0 sky130_fd_pr__nfet_01v8 L=0.15 W=0.42 nf=1 ad=0.1218 as=0.1218 pd=1.42 ps=1.42 nrd=0.69047619047619  nrs=0.69047619047619 sa=0 sb=0 sd=0 mult=1 m=1
csn_op0_n100_rh_s0p1_r1k_2 sn_op0_n100_rh_s0p1_r1k_2 0 {C_SN}
XMWR_op0_n100_rh_s0p1_r1k_3 sn_op0_n100_rh_s0p1_r1k_3 wwl_des wbl_op0_n100_rh_s0p1_r1k 0 sky130_fd_pr__nfet_01v8 L=0.15 W=0.42 nf=1 ad=0.1218 as=0.1218 pd=1.42 ps=1.42 nrd=0.69047619047619  nrs=0.69047619047619 sa=0 sb=0 sd=0 mult=1 m=1
XMRD_op0_n100_rh_s0p1_r1k_3 rbl_op0_n100_rh_s0p1_r1k sn_op0_n100_rh_s0p1_r1k_3 rwl_des 0 sky130_fd_pr__nfet_01v8 L=0.15 W=0.42 nf=1 ad=0.1218 as=0.1218 pd=1.42 ps=1.42 nrd=0.69047619047619  nrs=0.69047619047619 sa=0 sb=0 sd=0 mult=1 m=1
csn_op0_n100_rh_s0p1_r1k_3 sn_op0_n100_rh_s0p1_r1k_3 0 {C_SN}
XMN1_op0_n100_rh_s0p1_r1k rbl_op0_n100_rh_s0p1_r1k ref_op0_n100_rh_s0p1_r1k vn_op0_n100_rh_s0p1_r1k 0 sky130_fd_pr__nfet_01v8 L=0.15 W=1 nf=1 ad=0.29 as=0.29 pd=2.58 ps=2.58 mult=1 m=1
XMN2_op0_n100_rh_s0p1_r1k ref_op0_n100_rh_s0p1_r1k rbl_op0_n100_rh_s0p1_r1k vn_op0_n100_rh_s0p1_r1k 0 sky130_fd_pr__nfet_01v8 L=0.15 W=1 nf=1 ad=0.29 as=0.29 pd=2.58 ps=2.58 mult=1 m=1
XMP1_op0_n100_rh_s0p1_r1k rbl_op0_n100_rh_s0p1_r1k ref_op0_n100_rh_s0p1_r1k vp_op0_n100_rh_s0p1_r1k vdd sky130_fd_pr__pfet_01v8 L=0.15 W=2 nf=1 ad=0.58 as=0.58 pd=4.58 ps=4.58 mult=1 m=1
XMP2_op0_n100_rh_s0p1_r1k ref_op0_n100_rh_s0p1_r1k rbl_op0_n100_rh_s0p1_r1k vp_op0_n100_rh_s0p1_r1k vdd sky130_fd_pr__pfet_01v8 L=0.15 W=2 nf=1 ad=0.58 as=0.58 pd=4.58 ps=4.58 mult=1 m=1
XMNF_op0_n100_rh_s0p1_r1k vn_op0_n100_rh_s0p1_r1k en_op0_n100_rh_s0p1_r1k 0 0 sky130_fd_pr__nfet_01v8 L=0.15 W=2 nf=1 ad=0.58 as=0.58 pd=4.58 ps=4.58 mult=1 m=1
XMPH_op0_n100_rh_s0p1_r1k vp_op0_n100_rh_s0p1_r1k enb_op0_n100_rh_s0p1_r1k vdd vdd sky130_fd_pr__pfet_01v8 L=0.15 W=4 nf=1 ad=1.16 as=1.16 pd=8.58 ps=8.58 mult=1 m=1
bd_op0_n100_rh_s0p1_r1k d_op0_n100_rh_s0p1_r1k 0 v=v(rbl_op0_n100_rh_s0p1_r1k)-v(ref_op0_n100_rh_s0p1_r1k)

* ---- instance 120: op0_0000_rh_s0p1_r1k (variant rh_s0p1_r1k; probe dec 11.9 ns, release 34 ns, meas 36 ns) ----
vctl_op0_0000_rh_s0p1_r1k ctl_op0_0000_rh_s0p1_r1k 0 pwl(0.0000e+00 {VDD} 2.0000e-09 {VDD} 2.1000e-09 0)
* RWL driver model (EXPERIMENTAL): slew 0.1 ns, series R 1000 ohm; cell pin = rwls_op0_0000_rh_s0p1_r1k
vrs_op0_0000_rh_s0p1_r1k rwlsrc_op0_0000_rh_s0p1_r1k 0 pwl(0.0000e+00 {VDD} 2.0000e-09 {VDD} 2.1000e-09 0 1.2000e-08 0 1.2100e-08 {VDD})
rdrv_op0_0000_rh_s0p1_r1k rwlsrc_op0_0000_rh_s0p1_r1k rwls_op0_0000_rh_s0p1_r1k 1000
ven_op0_0000_rh_s0p1_r1k en_op0_0000_rh_s0p1_r1k 0 pwl(0.0000e+00 0 1.1000e-08 0 1.1100e-08 {VDD} 3.4000e-08 {VDD} 3.4100e-08 0)
venb_op0_0000_rh_s0p1_r1k enb_op0_0000_rh_s0p1_r1k 0 pwl(0.0000e+00 {VDD} 1.1000e-08 {VDD} 1.1100e-08 0 3.4000e-08 0 3.4100e-08 {VDD})
vww_op0_0000_rh_s0p1_r1k wwl_op0_0000_rh_s0p1_r1k 0 pwl(0.0000e+00 0 1.2000e-08 0 1.2100e-08 {VDD} 3.2000e-08 {VDD} 3.2100e-08 0)
vwc_op0_0000_rh_s0p1_r1k wbc_op0_0000_rh_s0p1_r1k 0 pwl(0.0000e+00 0 1.2000e-08 0 1.2100e-08 {VDD} 3.4000e-08 {VDD} 3.4100e-08 0)
swb_op0_0000_rh_s0p1_r1k ref_op0_0000_rh_s0p1_r1k wbl_op0_0000_rh_s0p1_r1k wbc_op0_0000_rh_s0p1_r1k 0 swwbl
cwbl_op0_0000_rh_s0p1_r1k wbl_op0_0000_rh_s0p1_r1k 0 {C_WBL}
spa_op0_0000_rh_s0p1_r1k prea rbl_op0_0000_rh_s0p1_r1k ctl_op0_0000_rh_s0p1_r1k 0 swpre
spr_op0_0000_rh_s0p1_r1k pref ref_op0_0000_rh_s0p1_r1k ctl_op0_0000_rh_s0p1_r1k 0 swpre
crbl_op0_0000_rh_s0p1_r1k rbl_op0_0000_rh_s0p1_r1k 0 {C_RBL}
cref_op0_0000_rh_s0p1_r1k ref_op0_0000_rh_s0p1_r1k 0 {C_RBL}   $ ASSUMPTION: ideal matched dummy load
XMWR_op0_0000_rh_s0p1_r1k_0 sn_op0_0000_rh_s0p1_r1k_0 wwl_op0_0000_rh_s0p1_r1k wbl_op0_0000_rh_s0p1_r1k 0 sky130_fd_pr__nfet_01v8 L=0.15 W=0.42 nf=1 ad=0.1218 as=0.1218 pd=1.42 ps=1.42 nrd=0.69047619047619  nrs=0.69047619047619 sa=0 sb=0 sd=0 mult=1 m=1
XMRD_op0_0000_rh_s0p1_r1k_0 rbl_op0_0000_rh_s0p1_r1k sn_op0_0000_rh_s0p1_r1k_0 rwls_op0_0000_rh_s0p1_r1k 0 sky130_fd_pr__nfet_01v8 L=0.15 W=0.42 nf=1 ad=0.1218 as=0.1218 pd=1.42 ps=1.42 nrd=0.69047619047619  nrs=0.69047619047619 sa=0 sb=0 sd=0 mult=1 m=1
csn_op0_0000_rh_s0p1_r1k_0 sn_op0_0000_rh_s0p1_r1k_0 0 {C_SN}
XMWR_op0_0000_rh_s0p1_r1k_1 sn_op0_0000_rh_s0p1_r1k_1 wwl_des wbl_op0_0000_rh_s0p1_r1k 0 sky130_fd_pr__nfet_01v8 L=0.15 W=0.42 nf=1 ad=0.1218 as=0.1218 pd=1.42 ps=1.42 nrd=0.69047619047619  nrs=0.69047619047619 sa=0 sb=0 sd=0 mult=1 m=1
XMRD_op0_0000_rh_s0p1_r1k_1 rbl_op0_0000_rh_s0p1_r1k sn_op0_0000_rh_s0p1_r1k_1 rwl_des 0 sky130_fd_pr__nfet_01v8 L=0.15 W=0.42 nf=1 ad=0.1218 as=0.1218 pd=1.42 ps=1.42 nrd=0.69047619047619  nrs=0.69047619047619 sa=0 sb=0 sd=0 mult=1 m=1
csn_op0_0000_rh_s0p1_r1k_1 sn_op0_0000_rh_s0p1_r1k_1 0 {C_SN}
XMWR_op0_0000_rh_s0p1_r1k_2 sn_op0_0000_rh_s0p1_r1k_2 wwl_des wbl_op0_0000_rh_s0p1_r1k 0 sky130_fd_pr__nfet_01v8 L=0.15 W=0.42 nf=1 ad=0.1218 as=0.1218 pd=1.42 ps=1.42 nrd=0.69047619047619  nrs=0.69047619047619 sa=0 sb=0 sd=0 mult=1 m=1
XMRD_op0_0000_rh_s0p1_r1k_2 rbl_op0_0000_rh_s0p1_r1k sn_op0_0000_rh_s0p1_r1k_2 rwl_des 0 sky130_fd_pr__nfet_01v8 L=0.15 W=0.42 nf=1 ad=0.1218 as=0.1218 pd=1.42 ps=1.42 nrd=0.69047619047619  nrs=0.69047619047619 sa=0 sb=0 sd=0 mult=1 m=1
csn_op0_0000_rh_s0p1_r1k_2 sn_op0_0000_rh_s0p1_r1k_2 0 {C_SN}
XMWR_op0_0000_rh_s0p1_r1k_3 sn_op0_0000_rh_s0p1_r1k_3 wwl_des wbl_op0_0000_rh_s0p1_r1k 0 sky130_fd_pr__nfet_01v8 L=0.15 W=0.42 nf=1 ad=0.1218 as=0.1218 pd=1.42 ps=1.42 nrd=0.69047619047619  nrs=0.69047619047619 sa=0 sb=0 sd=0 mult=1 m=1
XMRD_op0_0000_rh_s0p1_r1k_3 rbl_op0_0000_rh_s0p1_r1k sn_op0_0000_rh_s0p1_r1k_3 rwl_des 0 sky130_fd_pr__nfet_01v8 L=0.15 W=0.42 nf=1 ad=0.1218 as=0.1218 pd=1.42 ps=1.42 nrd=0.69047619047619  nrs=0.69047619047619 sa=0 sb=0 sd=0 mult=1 m=1
csn_op0_0000_rh_s0p1_r1k_3 sn_op0_0000_rh_s0p1_r1k_3 0 {C_SN}
XMN1_op0_0000_rh_s0p1_r1k rbl_op0_0000_rh_s0p1_r1k ref_op0_0000_rh_s0p1_r1k vn_op0_0000_rh_s0p1_r1k 0 sky130_fd_pr__nfet_01v8 L=0.15 W=1 nf=1 ad=0.29 as=0.29 pd=2.58 ps=2.58 mult=1 m=1
XMN2_op0_0000_rh_s0p1_r1k ref_op0_0000_rh_s0p1_r1k rbl_op0_0000_rh_s0p1_r1k vn_op0_0000_rh_s0p1_r1k 0 sky130_fd_pr__nfet_01v8 L=0.15 W=1 nf=1 ad=0.29 as=0.29 pd=2.58 ps=2.58 mult=1 m=1
XMP1_op0_0000_rh_s0p1_r1k rbl_op0_0000_rh_s0p1_r1k ref_op0_0000_rh_s0p1_r1k vp_op0_0000_rh_s0p1_r1k vdd sky130_fd_pr__pfet_01v8 L=0.15 W=2 nf=1 ad=0.58 as=0.58 pd=4.58 ps=4.58 mult=1 m=1
XMP2_op0_0000_rh_s0p1_r1k ref_op0_0000_rh_s0p1_r1k rbl_op0_0000_rh_s0p1_r1k vp_op0_0000_rh_s0p1_r1k vdd sky130_fd_pr__pfet_01v8 L=0.15 W=2 nf=1 ad=0.58 as=0.58 pd=4.58 ps=4.58 mult=1 m=1
XMNF_op0_0000_rh_s0p1_r1k vn_op0_0000_rh_s0p1_r1k en_op0_0000_rh_s0p1_r1k 0 0 sky130_fd_pr__nfet_01v8 L=0.15 W=2 nf=1 ad=0.58 as=0.58 pd=4.58 ps=4.58 mult=1 m=1
XMPH_op0_0000_rh_s0p1_r1k vp_op0_0000_rh_s0p1_r1k enb_op0_0000_rh_s0p1_r1k vdd vdd sky130_fd_pr__pfet_01v8 L=0.15 W=4 nf=1 ad=1.16 as=1.16 pd=8.58 ps=8.58 mult=1 m=1
bd_op0_0000_rh_s0p1_r1k d_op0_0000_rh_s0p1_r1k 0 v=v(rbl_op0_0000_rh_s0p1_r1k)-v(ref_op0_0000_rh_s0p1_r1k)

* ---- instance 121: op1_0900_rh_s0p1_r3k (variant rh_s0p1_r3k; probe dec 11.9 ns, release 34 ns, meas 36 ns) ----
vctl_op1_0900_rh_s0p1_r3k ctl_op1_0900_rh_s0p1_r3k 0 pwl(0.0000e+00 {VDD} 2.0000e-09 {VDD} 2.1000e-09 0)
* RWL driver model (EXPERIMENTAL): slew 0.1 ns, series R 3000 ohm; cell pin = rwls_op1_0900_rh_s0p1_r3k
vrs_op1_0900_rh_s0p1_r3k rwlsrc_op1_0900_rh_s0p1_r3k 0 pwl(0.0000e+00 {VDD} 2.0000e-09 {VDD} 2.1000e-09 0 1.2000e-08 0 1.2100e-08 {VDD})
rdrv_op1_0900_rh_s0p1_r3k rwlsrc_op1_0900_rh_s0p1_r3k rwls_op1_0900_rh_s0p1_r3k 3000
ven_op1_0900_rh_s0p1_r3k en_op1_0900_rh_s0p1_r3k 0 pwl(0.0000e+00 0 1.1000e-08 0 1.1100e-08 {VDD} 3.4000e-08 {VDD} 3.4100e-08 0)
venb_op1_0900_rh_s0p1_r3k enb_op1_0900_rh_s0p1_r3k 0 pwl(0.0000e+00 {VDD} 1.1000e-08 {VDD} 1.1100e-08 0 3.4000e-08 0 3.4100e-08 {VDD})
vww_op1_0900_rh_s0p1_r3k wwl_op1_0900_rh_s0p1_r3k 0 pwl(0.0000e+00 0 1.2000e-08 0 1.2100e-08 {VDD} 3.2000e-08 {VDD} 3.2100e-08 0)
vwc_op1_0900_rh_s0p1_r3k wbc_op1_0900_rh_s0p1_r3k 0 pwl(0.0000e+00 0 1.2000e-08 0 1.2100e-08 {VDD} 3.4000e-08 {VDD} 3.4100e-08 0)
swb_op1_0900_rh_s0p1_r3k ref_op1_0900_rh_s0p1_r3k wbl_op1_0900_rh_s0p1_r3k wbc_op1_0900_rh_s0p1_r3k 0 swwbl
cwbl_op1_0900_rh_s0p1_r3k wbl_op1_0900_rh_s0p1_r3k 0 {C_WBL}
spa_op1_0900_rh_s0p1_r3k prea rbl_op1_0900_rh_s0p1_r3k ctl_op1_0900_rh_s0p1_r3k 0 swpre
spr_op1_0900_rh_s0p1_r3k pref ref_op1_0900_rh_s0p1_r3k ctl_op1_0900_rh_s0p1_r3k 0 swpre
crbl_op1_0900_rh_s0p1_r3k rbl_op1_0900_rh_s0p1_r3k 0 {C_RBL}
cref_op1_0900_rh_s0p1_r3k ref_op1_0900_rh_s0p1_r3k 0 {C_RBL}   $ ASSUMPTION: ideal matched dummy load
XMWR_op1_0900_rh_s0p1_r3k_0 sn_op1_0900_rh_s0p1_r3k_0 wwl_op1_0900_rh_s0p1_r3k wbl_op1_0900_rh_s0p1_r3k 0 sky130_fd_pr__nfet_01v8 L=0.15 W=0.42 nf=1 ad=0.1218 as=0.1218 pd=1.42 ps=1.42 nrd=0.69047619047619  nrs=0.69047619047619 sa=0 sb=0 sd=0 mult=1 m=1
XMRD_op1_0900_rh_s0p1_r3k_0 rbl_op1_0900_rh_s0p1_r3k sn_op1_0900_rh_s0p1_r3k_0 rwls_op1_0900_rh_s0p1_r3k 0 sky130_fd_pr__nfet_01v8 L=0.15 W=0.42 nf=1 ad=0.1218 as=0.1218 pd=1.42 ps=1.42 nrd=0.69047619047619  nrs=0.69047619047619 sa=0 sb=0 sd=0 mult=1 m=1
csn_op1_0900_rh_s0p1_r3k_0 sn_op1_0900_rh_s0p1_r3k_0 0 {C_SN}
XMWR_op1_0900_rh_s0p1_r3k_1 sn_op1_0900_rh_s0p1_r3k_1 wwl_des wbl_op1_0900_rh_s0p1_r3k 0 sky130_fd_pr__nfet_01v8 L=0.15 W=0.42 nf=1 ad=0.1218 as=0.1218 pd=1.42 ps=1.42 nrd=0.69047619047619  nrs=0.69047619047619 sa=0 sb=0 sd=0 mult=1 m=1
XMRD_op1_0900_rh_s0p1_r3k_1 rbl_op1_0900_rh_s0p1_r3k sn_op1_0900_rh_s0p1_r3k_1 rwl_des 0 sky130_fd_pr__nfet_01v8 L=0.15 W=0.42 nf=1 ad=0.1218 as=0.1218 pd=1.42 ps=1.42 nrd=0.69047619047619  nrs=0.69047619047619 sa=0 sb=0 sd=0 mult=1 m=1
csn_op1_0900_rh_s0p1_r3k_1 sn_op1_0900_rh_s0p1_r3k_1 0 {C_SN}
XMWR_op1_0900_rh_s0p1_r3k_2 sn_op1_0900_rh_s0p1_r3k_2 wwl_des wbl_op1_0900_rh_s0p1_r3k 0 sky130_fd_pr__nfet_01v8 L=0.15 W=0.42 nf=1 ad=0.1218 as=0.1218 pd=1.42 ps=1.42 nrd=0.69047619047619  nrs=0.69047619047619 sa=0 sb=0 sd=0 mult=1 m=1
XMRD_op1_0900_rh_s0p1_r3k_2 rbl_op1_0900_rh_s0p1_r3k sn_op1_0900_rh_s0p1_r3k_2 rwl_des 0 sky130_fd_pr__nfet_01v8 L=0.15 W=0.42 nf=1 ad=0.1218 as=0.1218 pd=1.42 ps=1.42 nrd=0.69047619047619  nrs=0.69047619047619 sa=0 sb=0 sd=0 mult=1 m=1
csn_op1_0900_rh_s0p1_r3k_2 sn_op1_0900_rh_s0p1_r3k_2 0 {C_SN}
XMWR_op1_0900_rh_s0p1_r3k_3 sn_op1_0900_rh_s0p1_r3k_3 wwl_des wbl_op1_0900_rh_s0p1_r3k 0 sky130_fd_pr__nfet_01v8 L=0.15 W=0.42 nf=1 ad=0.1218 as=0.1218 pd=1.42 ps=1.42 nrd=0.69047619047619  nrs=0.69047619047619 sa=0 sb=0 sd=0 mult=1 m=1
XMRD_op1_0900_rh_s0p1_r3k_3 rbl_op1_0900_rh_s0p1_r3k sn_op1_0900_rh_s0p1_r3k_3 rwl_des 0 sky130_fd_pr__nfet_01v8 L=0.15 W=0.42 nf=1 ad=0.1218 as=0.1218 pd=1.42 ps=1.42 nrd=0.69047619047619  nrs=0.69047619047619 sa=0 sb=0 sd=0 mult=1 m=1
csn_op1_0900_rh_s0p1_r3k_3 sn_op1_0900_rh_s0p1_r3k_3 0 {C_SN}
XMN1_op1_0900_rh_s0p1_r3k rbl_op1_0900_rh_s0p1_r3k ref_op1_0900_rh_s0p1_r3k vn_op1_0900_rh_s0p1_r3k 0 sky130_fd_pr__nfet_01v8 L=0.15 W=1 nf=1 ad=0.29 as=0.29 pd=2.58 ps=2.58 mult=1 m=1
XMN2_op1_0900_rh_s0p1_r3k ref_op1_0900_rh_s0p1_r3k rbl_op1_0900_rh_s0p1_r3k vn_op1_0900_rh_s0p1_r3k 0 sky130_fd_pr__nfet_01v8 L=0.15 W=1 nf=1 ad=0.29 as=0.29 pd=2.58 ps=2.58 mult=1 m=1
XMP1_op1_0900_rh_s0p1_r3k rbl_op1_0900_rh_s0p1_r3k ref_op1_0900_rh_s0p1_r3k vp_op1_0900_rh_s0p1_r3k vdd sky130_fd_pr__pfet_01v8 L=0.15 W=2 nf=1 ad=0.58 as=0.58 pd=4.58 ps=4.58 mult=1 m=1
XMP2_op1_0900_rh_s0p1_r3k ref_op1_0900_rh_s0p1_r3k rbl_op1_0900_rh_s0p1_r3k vp_op1_0900_rh_s0p1_r3k vdd sky130_fd_pr__pfet_01v8 L=0.15 W=2 nf=1 ad=0.58 as=0.58 pd=4.58 ps=4.58 mult=1 m=1
XMNF_op1_0900_rh_s0p1_r3k vn_op1_0900_rh_s0p1_r3k en_op1_0900_rh_s0p1_r3k 0 0 sky130_fd_pr__nfet_01v8 L=0.15 W=2 nf=1 ad=0.58 as=0.58 pd=4.58 ps=4.58 mult=1 m=1
XMPH_op1_0900_rh_s0p1_r3k vp_op1_0900_rh_s0p1_r3k enb_op1_0900_rh_s0p1_r3k vdd vdd sky130_fd_pr__pfet_01v8 L=0.15 W=4 nf=1 ad=1.16 as=1.16 pd=8.58 ps=8.58 mult=1 m=1
bd_op1_0900_rh_s0p1_r3k d_op1_0900_rh_s0p1_r3k 0 v=v(rbl_op1_0900_rh_s0p1_r3k)-v(ref_op1_0900_rh_s0p1_r3k)

* ---- instance 122: op1_1000_rh_s0p1_r3k (variant rh_s0p1_r3k; probe dec 11.9 ns, release 34 ns, meas 36 ns) ----
vctl_op1_1000_rh_s0p1_r3k ctl_op1_1000_rh_s0p1_r3k 0 pwl(0.0000e+00 {VDD} 2.0000e-09 {VDD} 2.1000e-09 0)
* RWL driver model (EXPERIMENTAL): slew 0.1 ns, series R 3000 ohm; cell pin = rwls_op1_1000_rh_s0p1_r3k
vrs_op1_1000_rh_s0p1_r3k rwlsrc_op1_1000_rh_s0p1_r3k 0 pwl(0.0000e+00 {VDD} 2.0000e-09 {VDD} 2.1000e-09 0 1.2000e-08 0 1.2100e-08 {VDD})
rdrv_op1_1000_rh_s0p1_r3k rwlsrc_op1_1000_rh_s0p1_r3k rwls_op1_1000_rh_s0p1_r3k 3000
ven_op1_1000_rh_s0p1_r3k en_op1_1000_rh_s0p1_r3k 0 pwl(0.0000e+00 0 1.1000e-08 0 1.1100e-08 {VDD} 3.4000e-08 {VDD} 3.4100e-08 0)
venb_op1_1000_rh_s0p1_r3k enb_op1_1000_rh_s0p1_r3k 0 pwl(0.0000e+00 {VDD} 1.1000e-08 {VDD} 1.1100e-08 0 3.4000e-08 0 3.4100e-08 {VDD})
vww_op1_1000_rh_s0p1_r3k wwl_op1_1000_rh_s0p1_r3k 0 pwl(0.0000e+00 0 1.2000e-08 0 1.2100e-08 {VDD} 3.2000e-08 {VDD} 3.2100e-08 0)
vwc_op1_1000_rh_s0p1_r3k wbc_op1_1000_rh_s0p1_r3k 0 pwl(0.0000e+00 0 1.2000e-08 0 1.2100e-08 {VDD} 3.4000e-08 {VDD} 3.4100e-08 0)
swb_op1_1000_rh_s0p1_r3k ref_op1_1000_rh_s0p1_r3k wbl_op1_1000_rh_s0p1_r3k wbc_op1_1000_rh_s0p1_r3k 0 swwbl
cwbl_op1_1000_rh_s0p1_r3k wbl_op1_1000_rh_s0p1_r3k 0 {C_WBL}
spa_op1_1000_rh_s0p1_r3k prea rbl_op1_1000_rh_s0p1_r3k ctl_op1_1000_rh_s0p1_r3k 0 swpre
spr_op1_1000_rh_s0p1_r3k pref ref_op1_1000_rh_s0p1_r3k ctl_op1_1000_rh_s0p1_r3k 0 swpre
crbl_op1_1000_rh_s0p1_r3k rbl_op1_1000_rh_s0p1_r3k 0 {C_RBL}
cref_op1_1000_rh_s0p1_r3k ref_op1_1000_rh_s0p1_r3k 0 {C_RBL}   $ ASSUMPTION: ideal matched dummy load
XMWR_op1_1000_rh_s0p1_r3k_0 sn_op1_1000_rh_s0p1_r3k_0 wwl_op1_1000_rh_s0p1_r3k wbl_op1_1000_rh_s0p1_r3k 0 sky130_fd_pr__nfet_01v8 L=0.15 W=0.42 nf=1 ad=0.1218 as=0.1218 pd=1.42 ps=1.42 nrd=0.69047619047619  nrs=0.69047619047619 sa=0 sb=0 sd=0 mult=1 m=1
XMRD_op1_1000_rh_s0p1_r3k_0 rbl_op1_1000_rh_s0p1_r3k sn_op1_1000_rh_s0p1_r3k_0 rwls_op1_1000_rh_s0p1_r3k 0 sky130_fd_pr__nfet_01v8 L=0.15 W=0.42 nf=1 ad=0.1218 as=0.1218 pd=1.42 ps=1.42 nrd=0.69047619047619  nrs=0.69047619047619 sa=0 sb=0 sd=0 mult=1 m=1
csn_op1_1000_rh_s0p1_r3k_0 sn_op1_1000_rh_s0p1_r3k_0 0 {C_SN}
XMWR_op1_1000_rh_s0p1_r3k_1 sn_op1_1000_rh_s0p1_r3k_1 wwl_des wbl_op1_1000_rh_s0p1_r3k 0 sky130_fd_pr__nfet_01v8 L=0.15 W=0.42 nf=1 ad=0.1218 as=0.1218 pd=1.42 ps=1.42 nrd=0.69047619047619  nrs=0.69047619047619 sa=0 sb=0 sd=0 mult=1 m=1
XMRD_op1_1000_rh_s0p1_r3k_1 rbl_op1_1000_rh_s0p1_r3k sn_op1_1000_rh_s0p1_r3k_1 rwl_des 0 sky130_fd_pr__nfet_01v8 L=0.15 W=0.42 nf=1 ad=0.1218 as=0.1218 pd=1.42 ps=1.42 nrd=0.69047619047619  nrs=0.69047619047619 sa=0 sb=0 sd=0 mult=1 m=1
csn_op1_1000_rh_s0p1_r3k_1 sn_op1_1000_rh_s0p1_r3k_1 0 {C_SN}
XMWR_op1_1000_rh_s0p1_r3k_2 sn_op1_1000_rh_s0p1_r3k_2 wwl_des wbl_op1_1000_rh_s0p1_r3k 0 sky130_fd_pr__nfet_01v8 L=0.15 W=0.42 nf=1 ad=0.1218 as=0.1218 pd=1.42 ps=1.42 nrd=0.69047619047619  nrs=0.69047619047619 sa=0 sb=0 sd=0 mult=1 m=1
XMRD_op1_1000_rh_s0p1_r3k_2 rbl_op1_1000_rh_s0p1_r3k sn_op1_1000_rh_s0p1_r3k_2 rwl_des 0 sky130_fd_pr__nfet_01v8 L=0.15 W=0.42 nf=1 ad=0.1218 as=0.1218 pd=1.42 ps=1.42 nrd=0.69047619047619  nrs=0.69047619047619 sa=0 sb=0 sd=0 mult=1 m=1
csn_op1_1000_rh_s0p1_r3k_2 sn_op1_1000_rh_s0p1_r3k_2 0 {C_SN}
XMWR_op1_1000_rh_s0p1_r3k_3 sn_op1_1000_rh_s0p1_r3k_3 wwl_des wbl_op1_1000_rh_s0p1_r3k 0 sky130_fd_pr__nfet_01v8 L=0.15 W=0.42 nf=1 ad=0.1218 as=0.1218 pd=1.42 ps=1.42 nrd=0.69047619047619  nrs=0.69047619047619 sa=0 sb=0 sd=0 mult=1 m=1
XMRD_op1_1000_rh_s0p1_r3k_3 rbl_op1_1000_rh_s0p1_r3k sn_op1_1000_rh_s0p1_r3k_3 rwl_des 0 sky130_fd_pr__nfet_01v8 L=0.15 W=0.42 nf=1 ad=0.1218 as=0.1218 pd=1.42 ps=1.42 nrd=0.69047619047619  nrs=0.69047619047619 sa=0 sb=0 sd=0 mult=1 m=1
csn_op1_1000_rh_s0p1_r3k_3 sn_op1_1000_rh_s0p1_r3k_3 0 {C_SN}
XMN1_op1_1000_rh_s0p1_r3k rbl_op1_1000_rh_s0p1_r3k ref_op1_1000_rh_s0p1_r3k vn_op1_1000_rh_s0p1_r3k 0 sky130_fd_pr__nfet_01v8 L=0.15 W=1 nf=1 ad=0.29 as=0.29 pd=2.58 ps=2.58 mult=1 m=1
XMN2_op1_1000_rh_s0p1_r3k ref_op1_1000_rh_s0p1_r3k rbl_op1_1000_rh_s0p1_r3k vn_op1_1000_rh_s0p1_r3k 0 sky130_fd_pr__nfet_01v8 L=0.15 W=1 nf=1 ad=0.29 as=0.29 pd=2.58 ps=2.58 mult=1 m=1
XMP1_op1_1000_rh_s0p1_r3k rbl_op1_1000_rh_s0p1_r3k ref_op1_1000_rh_s0p1_r3k vp_op1_1000_rh_s0p1_r3k vdd sky130_fd_pr__pfet_01v8 L=0.15 W=2 nf=1 ad=0.58 as=0.58 pd=4.58 ps=4.58 mult=1 m=1
XMP2_op1_1000_rh_s0p1_r3k ref_op1_1000_rh_s0p1_r3k rbl_op1_1000_rh_s0p1_r3k vp_op1_1000_rh_s0p1_r3k vdd sky130_fd_pr__pfet_01v8 L=0.15 W=2 nf=1 ad=0.58 as=0.58 pd=4.58 ps=4.58 mult=1 m=1
XMNF_op1_1000_rh_s0p1_r3k vn_op1_1000_rh_s0p1_r3k en_op1_1000_rh_s0p1_r3k 0 0 sky130_fd_pr__nfet_01v8 L=0.15 W=2 nf=1 ad=0.58 as=0.58 pd=4.58 ps=4.58 mult=1 m=1
XMPH_op1_1000_rh_s0p1_r3k vp_op1_1000_rh_s0p1_r3k enb_op1_1000_rh_s0p1_r3k vdd vdd sky130_fd_pr__pfet_01v8 L=0.15 W=4 nf=1 ad=1.16 as=1.16 pd=8.58 ps=8.58 mult=1 m=1
bd_op1_1000_rh_s0p1_r3k d_op1_1000_rh_s0p1_r3k 0 v=v(rbl_op1_1000_rh_s0p1_r3k)-v(ref_op1_1000_rh_s0p1_r3k)

* ---- instance 123: op0_n100_rh_s0p1_r3k (variant rh_s0p1_r3k; probe dec 11.9 ns, release 34 ns, meas 36 ns) ----
vctl_op0_n100_rh_s0p1_r3k ctl_op0_n100_rh_s0p1_r3k 0 pwl(0.0000e+00 {VDD} 2.0000e-09 {VDD} 2.1000e-09 0)
* RWL driver model (EXPERIMENTAL): slew 0.1 ns, series R 3000 ohm; cell pin = rwls_op0_n100_rh_s0p1_r3k
vrs_op0_n100_rh_s0p1_r3k rwlsrc_op0_n100_rh_s0p1_r3k 0 pwl(0.0000e+00 {VDD} 2.0000e-09 {VDD} 2.1000e-09 0 1.2000e-08 0 1.2100e-08 {VDD})
rdrv_op0_n100_rh_s0p1_r3k rwlsrc_op0_n100_rh_s0p1_r3k rwls_op0_n100_rh_s0p1_r3k 3000
ven_op0_n100_rh_s0p1_r3k en_op0_n100_rh_s0p1_r3k 0 pwl(0.0000e+00 0 1.1000e-08 0 1.1100e-08 {VDD} 3.4000e-08 {VDD} 3.4100e-08 0)
venb_op0_n100_rh_s0p1_r3k enb_op0_n100_rh_s0p1_r3k 0 pwl(0.0000e+00 {VDD} 1.1000e-08 {VDD} 1.1100e-08 0 3.4000e-08 0 3.4100e-08 {VDD})
vww_op0_n100_rh_s0p1_r3k wwl_op0_n100_rh_s0p1_r3k 0 pwl(0.0000e+00 0 1.2000e-08 0 1.2100e-08 {VDD} 3.2000e-08 {VDD} 3.2100e-08 0)
vwc_op0_n100_rh_s0p1_r3k wbc_op0_n100_rh_s0p1_r3k 0 pwl(0.0000e+00 0 1.2000e-08 0 1.2100e-08 {VDD} 3.4000e-08 {VDD} 3.4100e-08 0)
swb_op0_n100_rh_s0p1_r3k ref_op0_n100_rh_s0p1_r3k wbl_op0_n100_rh_s0p1_r3k wbc_op0_n100_rh_s0p1_r3k 0 swwbl
cwbl_op0_n100_rh_s0p1_r3k wbl_op0_n100_rh_s0p1_r3k 0 {C_WBL}
spa_op0_n100_rh_s0p1_r3k prea rbl_op0_n100_rh_s0p1_r3k ctl_op0_n100_rh_s0p1_r3k 0 swpre
spr_op0_n100_rh_s0p1_r3k pref ref_op0_n100_rh_s0p1_r3k ctl_op0_n100_rh_s0p1_r3k 0 swpre
crbl_op0_n100_rh_s0p1_r3k rbl_op0_n100_rh_s0p1_r3k 0 {C_RBL}
cref_op0_n100_rh_s0p1_r3k ref_op0_n100_rh_s0p1_r3k 0 {C_RBL}   $ ASSUMPTION: ideal matched dummy load
XMWR_op0_n100_rh_s0p1_r3k_0 sn_op0_n100_rh_s0p1_r3k_0 wwl_op0_n100_rh_s0p1_r3k wbl_op0_n100_rh_s0p1_r3k 0 sky130_fd_pr__nfet_01v8 L=0.15 W=0.42 nf=1 ad=0.1218 as=0.1218 pd=1.42 ps=1.42 nrd=0.69047619047619  nrs=0.69047619047619 sa=0 sb=0 sd=0 mult=1 m=1
XMRD_op0_n100_rh_s0p1_r3k_0 rbl_op0_n100_rh_s0p1_r3k sn_op0_n100_rh_s0p1_r3k_0 rwls_op0_n100_rh_s0p1_r3k 0 sky130_fd_pr__nfet_01v8 L=0.15 W=0.42 nf=1 ad=0.1218 as=0.1218 pd=1.42 ps=1.42 nrd=0.69047619047619  nrs=0.69047619047619 sa=0 sb=0 sd=0 mult=1 m=1
csn_op0_n100_rh_s0p1_r3k_0 sn_op0_n100_rh_s0p1_r3k_0 0 {C_SN}
XMWR_op0_n100_rh_s0p1_r3k_1 sn_op0_n100_rh_s0p1_r3k_1 wwl_des wbl_op0_n100_rh_s0p1_r3k 0 sky130_fd_pr__nfet_01v8 L=0.15 W=0.42 nf=1 ad=0.1218 as=0.1218 pd=1.42 ps=1.42 nrd=0.69047619047619  nrs=0.69047619047619 sa=0 sb=0 sd=0 mult=1 m=1
XMRD_op0_n100_rh_s0p1_r3k_1 rbl_op0_n100_rh_s0p1_r3k sn_op0_n100_rh_s0p1_r3k_1 rwl_des 0 sky130_fd_pr__nfet_01v8 L=0.15 W=0.42 nf=1 ad=0.1218 as=0.1218 pd=1.42 ps=1.42 nrd=0.69047619047619  nrs=0.69047619047619 sa=0 sb=0 sd=0 mult=1 m=1
csn_op0_n100_rh_s0p1_r3k_1 sn_op0_n100_rh_s0p1_r3k_1 0 {C_SN}
XMWR_op0_n100_rh_s0p1_r3k_2 sn_op0_n100_rh_s0p1_r3k_2 wwl_des wbl_op0_n100_rh_s0p1_r3k 0 sky130_fd_pr__nfet_01v8 L=0.15 W=0.42 nf=1 ad=0.1218 as=0.1218 pd=1.42 ps=1.42 nrd=0.69047619047619  nrs=0.69047619047619 sa=0 sb=0 sd=0 mult=1 m=1
XMRD_op0_n100_rh_s0p1_r3k_2 rbl_op0_n100_rh_s0p1_r3k sn_op0_n100_rh_s0p1_r3k_2 rwl_des 0 sky130_fd_pr__nfet_01v8 L=0.15 W=0.42 nf=1 ad=0.1218 as=0.1218 pd=1.42 ps=1.42 nrd=0.69047619047619  nrs=0.69047619047619 sa=0 sb=0 sd=0 mult=1 m=1
csn_op0_n100_rh_s0p1_r3k_2 sn_op0_n100_rh_s0p1_r3k_2 0 {C_SN}
XMWR_op0_n100_rh_s0p1_r3k_3 sn_op0_n100_rh_s0p1_r3k_3 wwl_des wbl_op0_n100_rh_s0p1_r3k 0 sky130_fd_pr__nfet_01v8 L=0.15 W=0.42 nf=1 ad=0.1218 as=0.1218 pd=1.42 ps=1.42 nrd=0.69047619047619  nrs=0.69047619047619 sa=0 sb=0 sd=0 mult=1 m=1
XMRD_op0_n100_rh_s0p1_r3k_3 rbl_op0_n100_rh_s0p1_r3k sn_op0_n100_rh_s0p1_r3k_3 rwl_des 0 sky130_fd_pr__nfet_01v8 L=0.15 W=0.42 nf=1 ad=0.1218 as=0.1218 pd=1.42 ps=1.42 nrd=0.69047619047619  nrs=0.69047619047619 sa=0 sb=0 sd=0 mult=1 m=1
csn_op0_n100_rh_s0p1_r3k_3 sn_op0_n100_rh_s0p1_r3k_3 0 {C_SN}
XMN1_op0_n100_rh_s0p1_r3k rbl_op0_n100_rh_s0p1_r3k ref_op0_n100_rh_s0p1_r3k vn_op0_n100_rh_s0p1_r3k 0 sky130_fd_pr__nfet_01v8 L=0.15 W=1 nf=1 ad=0.29 as=0.29 pd=2.58 ps=2.58 mult=1 m=1
XMN2_op0_n100_rh_s0p1_r3k ref_op0_n100_rh_s0p1_r3k rbl_op0_n100_rh_s0p1_r3k vn_op0_n100_rh_s0p1_r3k 0 sky130_fd_pr__nfet_01v8 L=0.15 W=1 nf=1 ad=0.29 as=0.29 pd=2.58 ps=2.58 mult=1 m=1
XMP1_op0_n100_rh_s0p1_r3k rbl_op0_n100_rh_s0p1_r3k ref_op0_n100_rh_s0p1_r3k vp_op0_n100_rh_s0p1_r3k vdd sky130_fd_pr__pfet_01v8 L=0.15 W=2 nf=1 ad=0.58 as=0.58 pd=4.58 ps=4.58 mult=1 m=1
XMP2_op0_n100_rh_s0p1_r3k ref_op0_n100_rh_s0p1_r3k rbl_op0_n100_rh_s0p1_r3k vp_op0_n100_rh_s0p1_r3k vdd sky130_fd_pr__pfet_01v8 L=0.15 W=2 nf=1 ad=0.58 as=0.58 pd=4.58 ps=4.58 mult=1 m=1
XMNF_op0_n100_rh_s0p1_r3k vn_op0_n100_rh_s0p1_r3k en_op0_n100_rh_s0p1_r3k 0 0 sky130_fd_pr__nfet_01v8 L=0.15 W=2 nf=1 ad=0.58 as=0.58 pd=4.58 ps=4.58 mult=1 m=1
XMPH_op0_n100_rh_s0p1_r3k vp_op0_n100_rh_s0p1_r3k enb_op0_n100_rh_s0p1_r3k vdd vdd sky130_fd_pr__pfet_01v8 L=0.15 W=4 nf=1 ad=1.16 as=1.16 pd=8.58 ps=8.58 mult=1 m=1
bd_op0_n100_rh_s0p1_r3k d_op0_n100_rh_s0p1_r3k 0 v=v(rbl_op0_n100_rh_s0p1_r3k)-v(ref_op0_n100_rh_s0p1_r3k)

* ---- instance 124: op0_0000_rh_s0p1_r3k (variant rh_s0p1_r3k; probe dec 11.9 ns, release 34 ns, meas 36 ns) ----
vctl_op0_0000_rh_s0p1_r3k ctl_op0_0000_rh_s0p1_r3k 0 pwl(0.0000e+00 {VDD} 2.0000e-09 {VDD} 2.1000e-09 0)
* RWL driver model (EXPERIMENTAL): slew 0.1 ns, series R 3000 ohm; cell pin = rwls_op0_0000_rh_s0p1_r3k
vrs_op0_0000_rh_s0p1_r3k rwlsrc_op0_0000_rh_s0p1_r3k 0 pwl(0.0000e+00 {VDD} 2.0000e-09 {VDD} 2.1000e-09 0 1.2000e-08 0 1.2100e-08 {VDD})
rdrv_op0_0000_rh_s0p1_r3k rwlsrc_op0_0000_rh_s0p1_r3k rwls_op0_0000_rh_s0p1_r3k 3000
ven_op0_0000_rh_s0p1_r3k en_op0_0000_rh_s0p1_r3k 0 pwl(0.0000e+00 0 1.1000e-08 0 1.1100e-08 {VDD} 3.4000e-08 {VDD} 3.4100e-08 0)
venb_op0_0000_rh_s0p1_r3k enb_op0_0000_rh_s0p1_r3k 0 pwl(0.0000e+00 {VDD} 1.1000e-08 {VDD} 1.1100e-08 0 3.4000e-08 0 3.4100e-08 {VDD})
vww_op0_0000_rh_s0p1_r3k wwl_op0_0000_rh_s0p1_r3k 0 pwl(0.0000e+00 0 1.2000e-08 0 1.2100e-08 {VDD} 3.2000e-08 {VDD} 3.2100e-08 0)
vwc_op0_0000_rh_s0p1_r3k wbc_op0_0000_rh_s0p1_r3k 0 pwl(0.0000e+00 0 1.2000e-08 0 1.2100e-08 {VDD} 3.4000e-08 {VDD} 3.4100e-08 0)
swb_op0_0000_rh_s0p1_r3k ref_op0_0000_rh_s0p1_r3k wbl_op0_0000_rh_s0p1_r3k wbc_op0_0000_rh_s0p1_r3k 0 swwbl
cwbl_op0_0000_rh_s0p1_r3k wbl_op0_0000_rh_s0p1_r3k 0 {C_WBL}
spa_op0_0000_rh_s0p1_r3k prea rbl_op0_0000_rh_s0p1_r3k ctl_op0_0000_rh_s0p1_r3k 0 swpre
spr_op0_0000_rh_s0p1_r3k pref ref_op0_0000_rh_s0p1_r3k ctl_op0_0000_rh_s0p1_r3k 0 swpre
crbl_op0_0000_rh_s0p1_r3k rbl_op0_0000_rh_s0p1_r3k 0 {C_RBL}
cref_op0_0000_rh_s0p1_r3k ref_op0_0000_rh_s0p1_r3k 0 {C_RBL}   $ ASSUMPTION: ideal matched dummy load
XMWR_op0_0000_rh_s0p1_r3k_0 sn_op0_0000_rh_s0p1_r3k_0 wwl_op0_0000_rh_s0p1_r3k wbl_op0_0000_rh_s0p1_r3k 0 sky130_fd_pr__nfet_01v8 L=0.15 W=0.42 nf=1 ad=0.1218 as=0.1218 pd=1.42 ps=1.42 nrd=0.69047619047619  nrs=0.69047619047619 sa=0 sb=0 sd=0 mult=1 m=1
XMRD_op0_0000_rh_s0p1_r3k_0 rbl_op0_0000_rh_s0p1_r3k sn_op0_0000_rh_s0p1_r3k_0 rwls_op0_0000_rh_s0p1_r3k 0 sky130_fd_pr__nfet_01v8 L=0.15 W=0.42 nf=1 ad=0.1218 as=0.1218 pd=1.42 ps=1.42 nrd=0.69047619047619  nrs=0.69047619047619 sa=0 sb=0 sd=0 mult=1 m=1
csn_op0_0000_rh_s0p1_r3k_0 sn_op0_0000_rh_s0p1_r3k_0 0 {C_SN}
XMWR_op0_0000_rh_s0p1_r3k_1 sn_op0_0000_rh_s0p1_r3k_1 wwl_des wbl_op0_0000_rh_s0p1_r3k 0 sky130_fd_pr__nfet_01v8 L=0.15 W=0.42 nf=1 ad=0.1218 as=0.1218 pd=1.42 ps=1.42 nrd=0.69047619047619  nrs=0.69047619047619 sa=0 sb=0 sd=0 mult=1 m=1
XMRD_op0_0000_rh_s0p1_r3k_1 rbl_op0_0000_rh_s0p1_r3k sn_op0_0000_rh_s0p1_r3k_1 rwl_des 0 sky130_fd_pr__nfet_01v8 L=0.15 W=0.42 nf=1 ad=0.1218 as=0.1218 pd=1.42 ps=1.42 nrd=0.69047619047619  nrs=0.69047619047619 sa=0 sb=0 sd=0 mult=1 m=1
csn_op0_0000_rh_s0p1_r3k_1 sn_op0_0000_rh_s0p1_r3k_1 0 {C_SN}
XMWR_op0_0000_rh_s0p1_r3k_2 sn_op0_0000_rh_s0p1_r3k_2 wwl_des wbl_op0_0000_rh_s0p1_r3k 0 sky130_fd_pr__nfet_01v8 L=0.15 W=0.42 nf=1 ad=0.1218 as=0.1218 pd=1.42 ps=1.42 nrd=0.69047619047619  nrs=0.69047619047619 sa=0 sb=0 sd=0 mult=1 m=1
XMRD_op0_0000_rh_s0p1_r3k_2 rbl_op0_0000_rh_s0p1_r3k sn_op0_0000_rh_s0p1_r3k_2 rwl_des 0 sky130_fd_pr__nfet_01v8 L=0.15 W=0.42 nf=1 ad=0.1218 as=0.1218 pd=1.42 ps=1.42 nrd=0.69047619047619  nrs=0.69047619047619 sa=0 sb=0 sd=0 mult=1 m=1
csn_op0_0000_rh_s0p1_r3k_2 sn_op0_0000_rh_s0p1_r3k_2 0 {C_SN}
XMWR_op0_0000_rh_s0p1_r3k_3 sn_op0_0000_rh_s0p1_r3k_3 wwl_des wbl_op0_0000_rh_s0p1_r3k 0 sky130_fd_pr__nfet_01v8 L=0.15 W=0.42 nf=1 ad=0.1218 as=0.1218 pd=1.42 ps=1.42 nrd=0.69047619047619  nrs=0.69047619047619 sa=0 sb=0 sd=0 mult=1 m=1
XMRD_op0_0000_rh_s0p1_r3k_3 rbl_op0_0000_rh_s0p1_r3k sn_op0_0000_rh_s0p1_r3k_3 rwl_des 0 sky130_fd_pr__nfet_01v8 L=0.15 W=0.42 nf=1 ad=0.1218 as=0.1218 pd=1.42 ps=1.42 nrd=0.69047619047619  nrs=0.69047619047619 sa=0 sb=0 sd=0 mult=1 m=1
csn_op0_0000_rh_s0p1_r3k_3 sn_op0_0000_rh_s0p1_r3k_3 0 {C_SN}
XMN1_op0_0000_rh_s0p1_r3k rbl_op0_0000_rh_s0p1_r3k ref_op0_0000_rh_s0p1_r3k vn_op0_0000_rh_s0p1_r3k 0 sky130_fd_pr__nfet_01v8 L=0.15 W=1 nf=1 ad=0.29 as=0.29 pd=2.58 ps=2.58 mult=1 m=1
XMN2_op0_0000_rh_s0p1_r3k ref_op0_0000_rh_s0p1_r3k rbl_op0_0000_rh_s0p1_r3k vn_op0_0000_rh_s0p1_r3k 0 sky130_fd_pr__nfet_01v8 L=0.15 W=1 nf=1 ad=0.29 as=0.29 pd=2.58 ps=2.58 mult=1 m=1
XMP1_op0_0000_rh_s0p1_r3k rbl_op0_0000_rh_s0p1_r3k ref_op0_0000_rh_s0p1_r3k vp_op0_0000_rh_s0p1_r3k vdd sky130_fd_pr__pfet_01v8 L=0.15 W=2 nf=1 ad=0.58 as=0.58 pd=4.58 ps=4.58 mult=1 m=1
XMP2_op0_0000_rh_s0p1_r3k ref_op0_0000_rh_s0p1_r3k rbl_op0_0000_rh_s0p1_r3k vp_op0_0000_rh_s0p1_r3k vdd sky130_fd_pr__pfet_01v8 L=0.15 W=2 nf=1 ad=0.58 as=0.58 pd=4.58 ps=4.58 mult=1 m=1
XMNF_op0_0000_rh_s0p1_r3k vn_op0_0000_rh_s0p1_r3k en_op0_0000_rh_s0p1_r3k 0 0 sky130_fd_pr__nfet_01v8 L=0.15 W=2 nf=1 ad=0.58 as=0.58 pd=4.58 ps=4.58 mult=1 m=1
XMPH_op0_0000_rh_s0p1_r3k vp_op0_0000_rh_s0p1_r3k enb_op0_0000_rh_s0p1_r3k vdd vdd sky130_fd_pr__pfet_01v8 L=0.15 W=4 nf=1 ad=1.16 as=1.16 pd=8.58 ps=8.58 mult=1 m=1
bd_op0_0000_rh_s0p1_r3k d_op0_0000_rh_s0p1_r3k 0 v=v(rbl_op0_0000_rh_s0p1_r3k)-v(ref_op0_0000_rh_s0p1_r3k)

* ---- instance 125: op1_0900_rh_s0p1_r10k (variant rh_s0p1_r10k; probe dec 11.9 ns, release 34 ns, meas 36 ns) ----
vctl_op1_0900_rh_s0p1_r10k ctl_op1_0900_rh_s0p1_r10k 0 pwl(0.0000e+00 {VDD} 2.0000e-09 {VDD} 2.1000e-09 0)
* RWL driver model (EXPERIMENTAL): slew 0.1 ns, series R 10000 ohm; cell pin = rwls_op1_0900_rh_s0p1_r10k
vrs_op1_0900_rh_s0p1_r10k rwlsrc_op1_0900_rh_s0p1_r10k 0 pwl(0.0000e+00 {VDD} 2.0000e-09 {VDD} 2.1000e-09 0 1.2000e-08 0 1.2100e-08 {VDD})
rdrv_op1_0900_rh_s0p1_r10k rwlsrc_op1_0900_rh_s0p1_r10k rwls_op1_0900_rh_s0p1_r10k 10000
ven_op1_0900_rh_s0p1_r10k en_op1_0900_rh_s0p1_r10k 0 pwl(0.0000e+00 0 1.1000e-08 0 1.1100e-08 {VDD} 3.4000e-08 {VDD} 3.4100e-08 0)
venb_op1_0900_rh_s0p1_r10k enb_op1_0900_rh_s0p1_r10k 0 pwl(0.0000e+00 {VDD} 1.1000e-08 {VDD} 1.1100e-08 0 3.4000e-08 0 3.4100e-08 {VDD})
vww_op1_0900_rh_s0p1_r10k wwl_op1_0900_rh_s0p1_r10k 0 pwl(0.0000e+00 0 1.2000e-08 0 1.2100e-08 {VDD} 3.2000e-08 {VDD} 3.2100e-08 0)
vwc_op1_0900_rh_s0p1_r10k wbc_op1_0900_rh_s0p1_r10k 0 pwl(0.0000e+00 0 1.2000e-08 0 1.2100e-08 {VDD} 3.4000e-08 {VDD} 3.4100e-08 0)
swb_op1_0900_rh_s0p1_r10k ref_op1_0900_rh_s0p1_r10k wbl_op1_0900_rh_s0p1_r10k wbc_op1_0900_rh_s0p1_r10k 0 swwbl
cwbl_op1_0900_rh_s0p1_r10k wbl_op1_0900_rh_s0p1_r10k 0 {C_WBL}
spa_op1_0900_rh_s0p1_r10k prea rbl_op1_0900_rh_s0p1_r10k ctl_op1_0900_rh_s0p1_r10k 0 swpre
spr_op1_0900_rh_s0p1_r10k pref ref_op1_0900_rh_s0p1_r10k ctl_op1_0900_rh_s0p1_r10k 0 swpre
crbl_op1_0900_rh_s0p1_r10k rbl_op1_0900_rh_s0p1_r10k 0 {C_RBL}
cref_op1_0900_rh_s0p1_r10k ref_op1_0900_rh_s0p1_r10k 0 {C_RBL}   $ ASSUMPTION: ideal matched dummy load
XMWR_op1_0900_rh_s0p1_r10k_0 sn_op1_0900_rh_s0p1_r10k_0 wwl_op1_0900_rh_s0p1_r10k wbl_op1_0900_rh_s0p1_r10k 0 sky130_fd_pr__nfet_01v8 L=0.15 W=0.42 nf=1 ad=0.1218 as=0.1218 pd=1.42 ps=1.42 nrd=0.69047619047619  nrs=0.69047619047619 sa=0 sb=0 sd=0 mult=1 m=1
XMRD_op1_0900_rh_s0p1_r10k_0 rbl_op1_0900_rh_s0p1_r10k sn_op1_0900_rh_s0p1_r10k_0 rwls_op1_0900_rh_s0p1_r10k 0 sky130_fd_pr__nfet_01v8 L=0.15 W=0.42 nf=1 ad=0.1218 as=0.1218 pd=1.42 ps=1.42 nrd=0.69047619047619  nrs=0.69047619047619 sa=0 sb=0 sd=0 mult=1 m=1
csn_op1_0900_rh_s0p1_r10k_0 sn_op1_0900_rh_s0p1_r10k_0 0 {C_SN}
XMWR_op1_0900_rh_s0p1_r10k_1 sn_op1_0900_rh_s0p1_r10k_1 wwl_des wbl_op1_0900_rh_s0p1_r10k 0 sky130_fd_pr__nfet_01v8 L=0.15 W=0.42 nf=1 ad=0.1218 as=0.1218 pd=1.42 ps=1.42 nrd=0.69047619047619  nrs=0.69047619047619 sa=0 sb=0 sd=0 mult=1 m=1
XMRD_op1_0900_rh_s0p1_r10k_1 rbl_op1_0900_rh_s0p1_r10k sn_op1_0900_rh_s0p1_r10k_1 rwl_des 0 sky130_fd_pr__nfet_01v8 L=0.15 W=0.42 nf=1 ad=0.1218 as=0.1218 pd=1.42 ps=1.42 nrd=0.69047619047619  nrs=0.69047619047619 sa=0 sb=0 sd=0 mult=1 m=1
csn_op1_0900_rh_s0p1_r10k_1 sn_op1_0900_rh_s0p1_r10k_1 0 {C_SN}
XMWR_op1_0900_rh_s0p1_r10k_2 sn_op1_0900_rh_s0p1_r10k_2 wwl_des wbl_op1_0900_rh_s0p1_r10k 0 sky130_fd_pr__nfet_01v8 L=0.15 W=0.42 nf=1 ad=0.1218 as=0.1218 pd=1.42 ps=1.42 nrd=0.69047619047619  nrs=0.69047619047619 sa=0 sb=0 sd=0 mult=1 m=1
XMRD_op1_0900_rh_s0p1_r10k_2 rbl_op1_0900_rh_s0p1_r10k sn_op1_0900_rh_s0p1_r10k_2 rwl_des 0 sky130_fd_pr__nfet_01v8 L=0.15 W=0.42 nf=1 ad=0.1218 as=0.1218 pd=1.42 ps=1.42 nrd=0.69047619047619  nrs=0.69047619047619 sa=0 sb=0 sd=0 mult=1 m=1
csn_op1_0900_rh_s0p1_r10k_2 sn_op1_0900_rh_s0p1_r10k_2 0 {C_SN}
XMWR_op1_0900_rh_s0p1_r10k_3 sn_op1_0900_rh_s0p1_r10k_3 wwl_des wbl_op1_0900_rh_s0p1_r10k 0 sky130_fd_pr__nfet_01v8 L=0.15 W=0.42 nf=1 ad=0.1218 as=0.1218 pd=1.42 ps=1.42 nrd=0.69047619047619  nrs=0.69047619047619 sa=0 sb=0 sd=0 mult=1 m=1
XMRD_op1_0900_rh_s0p1_r10k_3 rbl_op1_0900_rh_s0p1_r10k sn_op1_0900_rh_s0p1_r10k_3 rwl_des 0 sky130_fd_pr__nfet_01v8 L=0.15 W=0.42 nf=1 ad=0.1218 as=0.1218 pd=1.42 ps=1.42 nrd=0.69047619047619  nrs=0.69047619047619 sa=0 sb=0 sd=0 mult=1 m=1
csn_op1_0900_rh_s0p1_r10k_3 sn_op1_0900_rh_s0p1_r10k_3 0 {C_SN}
XMN1_op1_0900_rh_s0p1_r10k rbl_op1_0900_rh_s0p1_r10k ref_op1_0900_rh_s0p1_r10k vn_op1_0900_rh_s0p1_r10k 0 sky130_fd_pr__nfet_01v8 L=0.15 W=1 nf=1 ad=0.29 as=0.29 pd=2.58 ps=2.58 mult=1 m=1
XMN2_op1_0900_rh_s0p1_r10k ref_op1_0900_rh_s0p1_r10k rbl_op1_0900_rh_s0p1_r10k vn_op1_0900_rh_s0p1_r10k 0 sky130_fd_pr__nfet_01v8 L=0.15 W=1 nf=1 ad=0.29 as=0.29 pd=2.58 ps=2.58 mult=1 m=1
XMP1_op1_0900_rh_s0p1_r10k rbl_op1_0900_rh_s0p1_r10k ref_op1_0900_rh_s0p1_r10k vp_op1_0900_rh_s0p1_r10k vdd sky130_fd_pr__pfet_01v8 L=0.15 W=2 nf=1 ad=0.58 as=0.58 pd=4.58 ps=4.58 mult=1 m=1
XMP2_op1_0900_rh_s0p1_r10k ref_op1_0900_rh_s0p1_r10k rbl_op1_0900_rh_s0p1_r10k vp_op1_0900_rh_s0p1_r10k vdd sky130_fd_pr__pfet_01v8 L=0.15 W=2 nf=1 ad=0.58 as=0.58 pd=4.58 ps=4.58 mult=1 m=1
XMNF_op1_0900_rh_s0p1_r10k vn_op1_0900_rh_s0p1_r10k en_op1_0900_rh_s0p1_r10k 0 0 sky130_fd_pr__nfet_01v8 L=0.15 W=2 nf=1 ad=0.58 as=0.58 pd=4.58 ps=4.58 mult=1 m=1
XMPH_op1_0900_rh_s0p1_r10k vp_op1_0900_rh_s0p1_r10k enb_op1_0900_rh_s0p1_r10k vdd vdd sky130_fd_pr__pfet_01v8 L=0.15 W=4 nf=1 ad=1.16 as=1.16 pd=8.58 ps=8.58 mult=1 m=1
bd_op1_0900_rh_s0p1_r10k d_op1_0900_rh_s0p1_r10k 0 v=v(rbl_op1_0900_rh_s0p1_r10k)-v(ref_op1_0900_rh_s0p1_r10k)

* ---- instance 126: op1_1000_rh_s0p1_r10k (variant rh_s0p1_r10k; probe dec 11.9 ns, release 34 ns, meas 36 ns) ----
vctl_op1_1000_rh_s0p1_r10k ctl_op1_1000_rh_s0p1_r10k 0 pwl(0.0000e+00 {VDD} 2.0000e-09 {VDD} 2.1000e-09 0)
* RWL driver model (EXPERIMENTAL): slew 0.1 ns, series R 10000 ohm; cell pin = rwls_op1_1000_rh_s0p1_r10k
vrs_op1_1000_rh_s0p1_r10k rwlsrc_op1_1000_rh_s0p1_r10k 0 pwl(0.0000e+00 {VDD} 2.0000e-09 {VDD} 2.1000e-09 0 1.2000e-08 0 1.2100e-08 {VDD})
rdrv_op1_1000_rh_s0p1_r10k rwlsrc_op1_1000_rh_s0p1_r10k rwls_op1_1000_rh_s0p1_r10k 10000
ven_op1_1000_rh_s0p1_r10k en_op1_1000_rh_s0p1_r10k 0 pwl(0.0000e+00 0 1.1000e-08 0 1.1100e-08 {VDD} 3.4000e-08 {VDD} 3.4100e-08 0)
venb_op1_1000_rh_s0p1_r10k enb_op1_1000_rh_s0p1_r10k 0 pwl(0.0000e+00 {VDD} 1.1000e-08 {VDD} 1.1100e-08 0 3.4000e-08 0 3.4100e-08 {VDD})
vww_op1_1000_rh_s0p1_r10k wwl_op1_1000_rh_s0p1_r10k 0 pwl(0.0000e+00 0 1.2000e-08 0 1.2100e-08 {VDD} 3.2000e-08 {VDD} 3.2100e-08 0)
vwc_op1_1000_rh_s0p1_r10k wbc_op1_1000_rh_s0p1_r10k 0 pwl(0.0000e+00 0 1.2000e-08 0 1.2100e-08 {VDD} 3.4000e-08 {VDD} 3.4100e-08 0)
swb_op1_1000_rh_s0p1_r10k ref_op1_1000_rh_s0p1_r10k wbl_op1_1000_rh_s0p1_r10k wbc_op1_1000_rh_s0p1_r10k 0 swwbl
cwbl_op1_1000_rh_s0p1_r10k wbl_op1_1000_rh_s0p1_r10k 0 {C_WBL}
spa_op1_1000_rh_s0p1_r10k prea rbl_op1_1000_rh_s0p1_r10k ctl_op1_1000_rh_s0p1_r10k 0 swpre
spr_op1_1000_rh_s0p1_r10k pref ref_op1_1000_rh_s0p1_r10k ctl_op1_1000_rh_s0p1_r10k 0 swpre
crbl_op1_1000_rh_s0p1_r10k rbl_op1_1000_rh_s0p1_r10k 0 {C_RBL}
cref_op1_1000_rh_s0p1_r10k ref_op1_1000_rh_s0p1_r10k 0 {C_RBL}   $ ASSUMPTION: ideal matched dummy load
XMWR_op1_1000_rh_s0p1_r10k_0 sn_op1_1000_rh_s0p1_r10k_0 wwl_op1_1000_rh_s0p1_r10k wbl_op1_1000_rh_s0p1_r10k 0 sky130_fd_pr__nfet_01v8 L=0.15 W=0.42 nf=1 ad=0.1218 as=0.1218 pd=1.42 ps=1.42 nrd=0.69047619047619  nrs=0.69047619047619 sa=0 sb=0 sd=0 mult=1 m=1
XMRD_op1_1000_rh_s0p1_r10k_0 rbl_op1_1000_rh_s0p1_r10k sn_op1_1000_rh_s0p1_r10k_0 rwls_op1_1000_rh_s0p1_r10k 0 sky130_fd_pr__nfet_01v8 L=0.15 W=0.42 nf=1 ad=0.1218 as=0.1218 pd=1.42 ps=1.42 nrd=0.69047619047619  nrs=0.69047619047619 sa=0 sb=0 sd=0 mult=1 m=1
csn_op1_1000_rh_s0p1_r10k_0 sn_op1_1000_rh_s0p1_r10k_0 0 {C_SN}
XMWR_op1_1000_rh_s0p1_r10k_1 sn_op1_1000_rh_s0p1_r10k_1 wwl_des wbl_op1_1000_rh_s0p1_r10k 0 sky130_fd_pr__nfet_01v8 L=0.15 W=0.42 nf=1 ad=0.1218 as=0.1218 pd=1.42 ps=1.42 nrd=0.69047619047619  nrs=0.69047619047619 sa=0 sb=0 sd=0 mult=1 m=1
XMRD_op1_1000_rh_s0p1_r10k_1 rbl_op1_1000_rh_s0p1_r10k sn_op1_1000_rh_s0p1_r10k_1 rwl_des 0 sky130_fd_pr__nfet_01v8 L=0.15 W=0.42 nf=1 ad=0.1218 as=0.1218 pd=1.42 ps=1.42 nrd=0.69047619047619  nrs=0.69047619047619 sa=0 sb=0 sd=0 mult=1 m=1
csn_op1_1000_rh_s0p1_r10k_1 sn_op1_1000_rh_s0p1_r10k_1 0 {C_SN}
XMWR_op1_1000_rh_s0p1_r10k_2 sn_op1_1000_rh_s0p1_r10k_2 wwl_des wbl_op1_1000_rh_s0p1_r10k 0 sky130_fd_pr__nfet_01v8 L=0.15 W=0.42 nf=1 ad=0.1218 as=0.1218 pd=1.42 ps=1.42 nrd=0.69047619047619  nrs=0.69047619047619 sa=0 sb=0 sd=0 mult=1 m=1
XMRD_op1_1000_rh_s0p1_r10k_2 rbl_op1_1000_rh_s0p1_r10k sn_op1_1000_rh_s0p1_r10k_2 rwl_des 0 sky130_fd_pr__nfet_01v8 L=0.15 W=0.42 nf=1 ad=0.1218 as=0.1218 pd=1.42 ps=1.42 nrd=0.69047619047619  nrs=0.69047619047619 sa=0 sb=0 sd=0 mult=1 m=1
csn_op1_1000_rh_s0p1_r10k_2 sn_op1_1000_rh_s0p1_r10k_2 0 {C_SN}
XMWR_op1_1000_rh_s0p1_r10k_3 sn_op1_1000_rh_s0p1_r10k_3 wwl_des wbl_op1_1000_rh_s0p1_r10k 0 sky130_fd_pr__nfet_01v8 L=0.15 W=0.42 nf=1 ad=0.1218 as=0.1218 pd=1.42 ps=1.42 nrd=0.69047619047619  nrs=0.69047619047619 sa=0 sb=0 sd=0 mult=1 m=1
XMRD_op1_1000_rh_s0p1_r10k_3 rbl_op1_1000_rh_s0p1_r10k sn_op1_1000_rh_s0p1_r10k_3 rwl_des 0 sky130_fd_pr__nfet_01v8 L=0.15 W=0.42 nf=1 ad=0.1218 as=0.1218 pd=1.42 ps=1.42 nrd=0.69047619047619  nrs=0.69047619047619 sa=0 sb=0 sd=0 mult=1 m=1
csn_op1_1000_rh_s0p1_r10k_3 sn_op1_1000_rh_s0p1_r10k_3 0 {C_SN}
XMN1_op1_1000_rh_s0p1_r10k rbl_op1_1000_rh_s0p1_r10k ref_op1_1000_rh_s0p1_r10k vn_op1_1000_rh_s0p1_r10k 0 sky130_fd_pr__nfet_01v8 L=0.15 W=1 nf=1 ad=0.29 as=0.29 pd=2.58 ps=2.58 mult=1 m=1
XMN2_op1_1000_rh_s0p1_r10k ref_op1_1000_rh_s0p1_r10k rbl_op1_1000_rh_s0p1_r10k vn_op1_1000_rh_s0p1_r10k 0 sky130_fd_pr__nfet_01v8 L=0.15 W=1 nf=1 ad=0.29 as=0.29 pd=2.58 ps=2.58 mult=1 m=1
XMP1_op1_1000_rh_s0p1_r10k rbl_op1_1000_rh_s0p1_r10k ref_op1_1000_rh_s0p1_r10k vp_op1_1000_rh_s0p1_r10k vdd sky130_fd_pr__pfet_01v8 L=0.15 W=2 nf=1 ad=0.58 as=0.58 pd=4.58 ps=4.58 mult=1 m=1
XMP2_op1_1000_rh_s0p1_r10k ref_op1_1000_rh_s0p1_r10k rbl_op1_1000_rh_s0p1_r10k vp_op1_1000_rh_s0p1_r10k vdd sky130_fd_pr__pfet_01v8 L=0.15 W=2 nf=1 ad=0.58 as=0.58 pd=4.58 ps=4.58 mult=1 m=1
XMNF_op1_1000_rh_s0p1_r10k vn_op1_1000_rh_s0p1_r10k en_op1_1000_rh_s0p1_r10k 0 0 sky130_fd_pr__nfet_01v8 L=0.15 W=2 nf=1 ad=0.58 as=0.58 pd=4.58 ps=4.58 mult=1 m=1
XMPH_op1_1000_rh_s0p1_r10k vp_op1_1000_rh_s0p1_r10k enb_op1_1000_rh_s0p1_r10k vdd vdd sky130_fd_pr__pfet_01v8 L=0.15 W=4 nf=1 ad=1.16 as=1.16 pd=8.58 ps=8.58 mult=1 m=1
bd_op1_1000_rh_s0p1_r10k d_op1_1000_rh_s0p1_r10k 0 v=v(rbl_op1_1000_rh_s0p1_r10k)-v(ref_op1_1000_rh_s0p1_r10k)

* ---- instance 127: op0_n100_rh_s0p1_r10k (variant rh_s0p1_r10k; probe dec 11.9 ns, release 34 ns, meas 36 ns) ----
vctl_op0_n100_rh_s0p1_r10k ctl_op0_n100_rh_s0p1_r10k 0 pwl(0.0000e+00 {VDD} 2.0000e-09 {VDD} 2.1000e-09 0)
* RWL driver model (EXPERIMENTAL): slew 0.1 ns, series R 10000 ohm; cell pin = rwls_op0_n100_rh_s0p1_r10k
vrs_op0_n100_rh_s0p1_r10k rwlsrc_op0_n100_rh_s0p1_r10k 0 pwl(0.0000e+00 {VDD} 2.0000e-09 {VDD} 2.1000e-09 0 1.2000e-08 0 1.2100e-08 {VDD})
rdrv_op0_n100_rh_s0p1_r10k rwlsrc_op0_n100_rh_s0p1_r10k rwls_op0_n100_rh_s0p1_r10k 10000
ven_op0_n100_rh_s0p1_r10k en_op0_n100_rh_s0p1_r10k 0 pwl(0.0000e+00 0 1.1000e-08 0 1.1100e-08 {VDD} 3.4000e-08 {VDD} 3.4100e-08 0)
venb_op0_n100_rh_s0p1_r10k enb_op0_n100_rh_s0p1_r10k 0 pwl(0.0000e+00 {VDD} 1.1000e-08 {VDD} 1.1100e-08 0 3.4000e-08 0 3.4100e-08 {VDD})
vww_op0_n100_rh_s0p1_r10k wwl_op0_n100_rh_s0p1_r10k 0 pwl(0.0000e+00 0 1.2000e-08 0 1.2100e-08 {VDD} 3.2000e-08 {VDD} 3.2100e-08 0)
vwc_op0_n100_rh_s0p1_r10k wbc_op0_n100_rh_s0p1_r10k 0 pwl(0.0000e+00 0 1.2000e-08 0 1.2100e-08 {VDD} 3.4000e-08 {VDD} 3.4100e-08 0)
swb_op0_n100_rh_s0p1_r10k ref_op0_n100_rh_s0p1_r10k wbl_op0_n100_rh_s0p1_r10k wbc_op0_n100_rh_s0p1_r10k 0 swwbl
cwbl_op0_n100_rh_s0p1_r10k wbl_op0_n100_rh_s0p1_r10k 0 {C_WBL}
spa_op0_n100_rh_s0p1_r10k prea rbl_op0_n100_rh_s0p1_r10k ctl_op0_n100_rh_s0p1_r10k 0 swpre
spr_op0_n100_rh_s0p1_r10k pref ref_op0_n100_rh_s0p1_r10k ctl_op0_n100_rh_s0p1_r10k 0 swpre
crbl_op0_n100_rh_s0p1_r10k rbl_op0_n100_rh_s0p1_r10k 0 {C_RBL}
cref_op0_n100_rh_s0p1_r10k ref_op0_n100_rh_s0p1_r10k 0 {C_RBL}   $ ASSUMPTION: ideal matched dummy load
XMWR_op0_n100_rh_s0p1_r10k_0 sn_op0_n100_rh_s0p1_r10k_0 wwl_op0_n100_rh_s0p1_r10k wbl_op0_n100_rh_s0p1_r10k 0 sky130_fd_pr__nfet_01v8 L=0.15 W=0.42 nf=1 ad=0.1218 as=0.1218 pd=1.42 ps=1.42 nrd=0.69047619047619  nrs=0.69047619047619 sa=0 sb=0 sd=0 mult=1 m=1
XMRD_op0_n100_rh_s0p1_r10k_0 rbl_op0_n100_rh_s0p1_r10k sn_op0_n100_rh_s0p1_r10k_0 rwls_op0_n100_rh_s0p1_r10k 0 sky130_fd_pr__nfet_01v8 L=0.15 W=0.42 nf=1 ad=0.1218 as=0.1218 pd=1.42 ps=1.42 nrd=0.69047619047619  nrs=0.69047619047619 sa=0 sb=0 sd=0 mult=1 m=1
csn_op0_n100_rh_s0p1_r10k_0 sn_op0_n100_rh_s0p1_r10k_0 0 {C_SN}
XMWR_op0_n100_rh_s0p1_r10k_1 sn_op0_n100_rh_s0p1_r10k_1 wwl_des wbl_op0_n100_rh_s0p1_r10k 0 sky130_fd_pr__nfet_01v8 L=0.15 W=0.42 nf=1 ad=0.1218 as=0.1218 pd=1.42 ps=1.42 nrd=0.69047619047619  nrs=0.69047619047619 sa=0 sb=0 sd=0 mult=1 m=1
XMRD_op0_n100_rh_s0p1_r10k_1 rbl_op0_n100_rh_s0p1_r10k sn_op0_n100_rh_s0p1_r10k_1 rwl_des 0 sky130_fd_pr__nfet_01v8 L=0.15 W=0.42 nf=1 ad=0.1218 as=0.1218 pd=1.42 ps=1.42 nrd=0.69047619047619  nrs=0.69047619047619 sa=0 sb=0 sd=0 mult=1 m=1
csn_op0_n100_rh_s0p1_r10k_1 sn_op0_n100_rh_s0p1_r10k_1 0 {C_SN}
XMWR_op0_n100_rh_s0p1_r10k_2 sn_op0_n100_rh_s0p1_r10k_2 wwl_des wbl_op0_n100_rh_s0p1_r10k 0 sky130_fd_pr__nfet_01v8 L=0.15 W=0.42 nf=1 ad=0.1218 as=0.1218 pd=1.42 ps=1.42 nrd=0.69047619047619  nrs=0.69047619047619 sa=0 sb=0 sd=0 mult=1 m=1
XMRD_op0_n100_rh_s0p1_r10k_2 rbl_op0_n100_rh_s0p1_r10k sn_op0_n100_rh_s0p1_r10k_2 rwl_des 0 sky130_fd_pr__nfet_01v8 L=0.15 W=0.42 nf=1 ad=0.1218 as=0.1218 pd=1.42 ps=1.42 nrd=0.69047619047619  nrs=0.69047619047619 sa=0 sb=0 sd=0 mult=1 m=1
csn_op0_n100_rh_s0p1_r10k_2 sn_op0_n100_rh_s0p1_r10k_2 0 {C_SN}
XMWR_op0_n100_rh_s0p1_r10k_3 sn_op0_n100_rh_s0p1_r10k_3 wwl_des wbl_op0_n100_rh_s0p1_r10k 0 sky130_fd_pr__nfet_01v8 L=0.15 W=0.42 nf=1 ad=0.1218 as=0.1218 pd=1.42 ps=1.42 nrd=0.69047619047619  nrs=0.69047619047619 sa=0 sb=0 sd=0 mult=1 m=1
XMRD_op0_n100_rh_s0p1_r10k_3 rbl_op0_n100_rh_s0p1_r10k sn_op0_n100_rh_s0p1_r10k_3 rwl_des 0 sky130_fd_pr__nfet_01v8 L=0.15 W=0.42 nf=1 ad=0.1218 as=0.1218 pd=1.42 ps=1.42 nrd=0.69047619047619  nrs=0.69047619047619 sa=0 sb=0 sd=0 mult=1 m=1
csn_op0_n100_rh_s0p1_r10k_3 sn_op0_n100_rh_s0p1_r10k_3 0 {C_SN}
XMN1_op0_n100_rh_s0p1_r10k rbl_op0_n100_rh_s0p1_r10k ref_op0_n100_rh_s0p1_r10k vn_op0_n100_rh_s0p1_r10k 0 sky130_fd_pr__nfet_01v8 L=0.15 W=1 nf=1 ad=0.29 as=0.29 pd=2.58 ps=2.58 mult=1 m=1
XMN2_op0_n100_rh_s0p1_r10k ref_op0_n100_rh_s0p1_r10k rbl_op0_n100_rh_s0p1_r10k vn_op0_n100_rh_s0p1_r10k 0 sky130_fd_pr__nfet_01v8 L=0.15 W=1 nf=1 ad=0.29 as=0.29 pd=2.58 ps=2.58 mult=1 m=1
XMP1_op0_n100_rh_s0p1_r10k rbl_op0_n100_rh_s0p1_r10k ref_op0_n100_rh_s0p1_r10k vp_op0_n100_rh_s0p1_r10k vdd sky130_fd_pr__pfet_01v8 L=0.15 W=2 nf=1 ad=0.58 as=0.58 pd=4.58 ps=4.58 mult=1 m=1
XMP2_op0_n100_rh_s0p1_r10k ref_op0_n100_rh_s0p1_r10k rbl_op0_n100_rh_s0p1_r10k vp_op0_n100_rh_s0p1_r10k vdd sky130_fd_pr__pfet_01v8 L=0.15 W=2 nf=1 ad=0.58 as=0.58 pd=4.58 ps=4.58 mult=1 m=1
XMNF_op0_n100_rh_s0p1_r10k vn_op0_n100_rh_s0p1_r10k en_op0_n100_rh_s0p1_r10k 0 0 sky130_fd_pr__nfet_01v8 L=0.15 W=2 nf=1 ad=0.58 as=0.58 pd=4.58 ps=4.58 mult=1 m=1
XMPH_op0_n100_rh_s0p1_r10k vp_op0_n100_rh_s0p1_r10k enb_op0_n100_rh_s0p1_r10k vdd vdd sky130_fd_pr__pfet_01v8 L=0.15 W=4 nf=1 ad=1.16 as=1.16 pd=8.58 ps=8.58 mult=1 m=1
bd_op0_n100_rh_s0p1_r10k d_op0_n100_rh_s0p1_r10k 0 v=v(rbl_op0_n100_rh_s0p1_r10k)-v(ref_op0_n100_rh_s0p1_r10k)

* ---- instance 128: op0_0000_rh_s0p1_r10k (variant rh_s0p1_r10k; probe dec 11.9 ns, release 34 ns, meas 36 ns) ----
vctl_op0_0000_rh_s0p1_r10k ctl_op0_0000_rh_s0p1_r10k 0 pwl(0.0000e+00 {VDD} 2.0000e-09 {VDD} 2.1000e-09 0)
* RWL driver model (EXPERIMENTAL): slew 0.1 ns, series R 10000 ohm; cell pin = rwls_op0_0000_rh_s0p1_r10k
vrs_op0_0000_rh_s0p1_r10k rwlsrc_op0_0000_rh_s0p1_r10k 0 pwl(0.0000e+00 {VDD} 2.0000e-09 {VDD} 2.1000e-09 0 1.2000e-08 0 1.2100e-08 {VDD})
rdrv_op0_0000_rh_s0p1_r10k rwlsrc_op0_0000_rh_s0p1_r10k rwls_op0_0000_rh_s0p1_r10k 10000
ven_op0_0000_rh_s0p1_r10k en_op0_0000_rh_s0p1_r10k 0 pwl(0.0000e+00 0 1.1000e-08 0 1.1100e-08 {VDD} 3.4000e-08 {VDD} 3.4100e-08 0)
venb_op0_0000_rh_s0p1_r10k enb_op0_0000_rh_s0p1_r10k 0 pwl(0.0000e+00 {VDD} 1.1000e-08 {VDD} 1.1100e-08 0 3.4000e-08 0 3.4100e-08 {VDD})
vww_op0_0000_rh_s0p1_r10k wwl_op0_0000_rh_s0p1_r10k 0 pwl(0.0000e+00 0 1.2000e-08 0 1.2100e-08 {VDD} 3.2000e-08 {VDD} 3.2100e-08 0)
vwc_op0_0000_rh_s0p1_r10k wbc_op0_0000_rh_s0p1_r10k 0 pwl(0.0000e+00 0 1.2000e-08 0 1.2100e-08 {VDD} 3.4000e-08 {VDD} 3.4100e-08 0)
swb_op0_0000_rh_s0p1_r10k ref_op0_0000_rh_s0p1_r10k wbl_op0_0000_rh_s0p1_r10k wbc_op0_0000_rh_s0p1_r10k 0 swwbl
cwbl_op0_0000_rh_s0p1_r10k wbl_op0_0000_rh_s0p1_r10k 0 {C_WBL}
spa_op0_0000_rh_s0p1_r10k prea rbl_op0_0000_rh_s0p1_r10k ctl_op0_0000_rh_s0p1_r10k 0 swpre
spr_op0_0000_rh_s0p1_r10k pref ref_op0_0000_rh_s0p1_r10k ctl_op0_0000_rh_s0p1_r10k 0 swpre
crbl_op0_0000_rh_s0p1_r10k rbl_op0_0000_rh_s0p1_r10k 0 {C_RBL}
cref_op0_0000_rh_s0p1_r10k ref_op0_0000_rh_s0p1_r10k 0 {C_RBL}   $ ASSUMPTION: ideal matched dummy load
XMWR_op0_0000_rh_s0p1_r10k_0 sn_op0_0000_rh_s0p1_r10k_0 wwl_op0_0000_rh_s0p1_r10k wbl_op0_0000_rh_s0p1_r10k 0 sky130_fd_pr__nfet_01v8 L=0.15 W=0.42 nf=1 ad=0.1218 as=0.1218 pd=1.42 ps=1.42 nrd=0.69047619047619  nrs=0.69047619047619 sa=0 sb=0 sd=0 mult=1 m=1
XMRD_op0_0000_rh_s0p1_r10k_0 rbl_op0_0000_rh_s0p1_r10k sn_op0_0000_rh_s0p1_r10k_0 rwls_op0_0000_rh_s0p1_r10k 0 sky130_fd_pr__nfet_01v8 L=0.15 W=0.42 nf=1 ad=0.1218 as=0.1218 pd=1.42 ps=1.42 nrd=0.69047619047619  nrs=0.69047619047619 sa=0 sb=0 sd=0 mult=1 m=1
csn_op0_0000_rh_s0p1_r10k_0 sn_op0_0000_rh_s0p1_r10k_0 0 {C_SN}
XMWR_op0_0000_rh_s0p1_r10k_1 sn_op0_0000_rh_s0p1_r10k_1 wwl_des wbl_op0_0000_rh_s0p1_r10k 0 sky130_fd_pr__nfet_01v8 L=0.15 W=0.42 nf=1 ad=0.1218 as=0.1218 pd=1.42 ps=1.42 nrd=0.69047619047619  nrs=0.69047619047619 sa=0 sb=0 sd=0 mult=1 m=1
XMRD_op0_0000_rh_s0p1_r10k_1 rbl_op0_0000_rh_s0p1_r10k sn_op0_0000_rh_s0p1_r10k_1 rwl_des 0 sky130_fd_pr__nfet_01v8 L=0.15 W=0.42 nf=1 ad=0.1218 as=0.1218 pd=1.42 ps=1.42 nrd=0.69047619047619  nrs=0.69047619047619 sa=0 sb=0 sd=0 mult=1 m=1
csn_op0_0000_rh_s0p1_r10k_1 sn_op0_0000_rh_s0p1_r10k_1 0 {C_SN}
XMWR_op0_0000_rh_s0p1_r10k_2 sn_op0_0000_rh_s0p1_r10k_2 wwl_des wbl_op0_0000_rh_s0p1_r10k 0 sky130_fd_pr__nfet_01v8 L=0.15 W=0.42 nf=1 ad=0.1218 as=0.1218 pd=1.42 ps=1.42 nrd=0.69047619047619  nrs=0.69047619047619 sa=0 sb=0 sd=0 mult=1 m=1
XMRD_op0_0000_rh_s0p1_r10k_2 rbl_op0_0000_rh_s0p1_r10k sn_op0_0000_rh_s0p1_r10k_2 rwl_des 0 sky130_fd_pr__nfet_01v8 L=0.15 W=0.42 nf=1 ad=0.1218 as=0.1218 pd=1.42 ps=1.42 nrd=0.69047619047619  nrs=0.69047619047619 sa=0 sb=0 sd=0 mult=1 m=1
csn_op0_0000_rh_s0p1_r10k_2 sn_op0_0000_rh_s0p1_r10k_2 0 {C_SN}
XMWR_op0_0000_rh_s0p1_r10k_3 sn_op0_0000_rh_s0p1_r10k_3 wwl_des wbl_op0_0000_rh_s0p1_r10k 0 sky130_fd_pr__nfet_01v8 L=0.15 W=0.42 nf=1 ad=0.1218 as=0.1218 pd=1.42 ps=1.42 nrd=0.69047619047619  nrs=0.69047619047619 sa=0 sb=0 sd=0 mult=1 m=1
XMRD_op0_0000_rh_s0p1_r10k_3 rbl_op0_0000_rh_s0p1_r10k sn_op0_0000_rh_s0p1_r10k_3 rwl_des 0 sky130_fd_pr__nfet_01v8 L=0.15 W=0.42 nf=1 ad=0.1218 as=0.1218 pd=1.42 ps=1.42 nrd=0.69047619047619  nrs=0.69047619047619 sa=0 sb=0 sd=0 mult=1 m=1
csn_op0_0000_rh_s0p1_r10k_3 sn_op0_0000_rh_s0p1_r10k_3 0 {C_SN}
XMN1_op0_0000_rh_s0p1_r10k rbl_op0_0000_rh_s0p1_r10k ref_op0_0000_rh_s0p1_r10k vn_op0_0000_rh_s0p1_r10k 0 sky130_fd_pr__nfet_01v8 L=0.15 W=1 nf=1 ad=0.29 as=0.29 pd=2.58 ps=2.58 mult=1 m=1
XMN2_op0_0000_rh_s0p1_r10k ref_op0_0000_rh_s0p1_r10k rbl_op0_0000_rh_s0p1_r10k vn_op0_0000_rh_s0p1_r10k 0 sky130_fd_pr__nfet_01v8 L=0.15 W=1 nf=1 ad=0.29 as=0.29 pd=2.58 ps=2.58 mult=1 m=1
XMP1_op0_0000_rh_s0p1_r10k rbl_op0_0000_rh_s0p1_r10k ref_op0_0000_rh_s0p1_r10k vp_op0_0000_rh_s0p1_r10k vdd sky130_fd_pr__pfet_01v8 L=0.15 W=2 nf=1 ad=0.58 as=0.58 pd=4.58 ps=4.58 mult=1 m=1
XMP2_op0_0000_rh_s0p1_r10k ref_op0_0000_rh_s0p1_r10k rbl_op0_0000_rh_s0p1_r10k vp_op0_0000_rh_s0p1_r10k vdd sky130_fd_pr__pfet_01v8 L=0.15 W=2 nf=1 ad=0.58 as=0.58 pd=4.58 ps=4.58 mult=1 m=1
XMNF_op0_0000_rh_s0p1_r10k vn_op0_0000_rh_s0p1_r10k en_op0_0000_rh_s0p1_r10k 0 0 sky130_fd_pr__nfet_01v8 L=0.15 W=2 nf=1 ad=0.58 as=0.58 pd=4.58 ps=4.58 mult=1 m=1
XMPH_op0_0000_rh_s0p1_r10k vp_op0_0000_rh_s0p1_r10k enb_op0_0000_rh_s0p1_r10k vdd vdd sky130_fd_pr__pfet_01v8 L=0.15 W=4 nf=1 ad=1.16 as=1.16 pd=8.58 ps=8.58 mult=1 m=1
bd_op0_0000_rh_s0p1_r10k d_op0_0000_rh_s0p1_r10k 0 v=v(rbl_op0_0000_rh_s0p1_r10k)-v(ref_op0_0000_rh_s0p1_r10k)

* ---- instance 129: op1_0900_rh_s0p1_r30k (variant rh_s0p1_r30k; probe dec 11.9 ns, release 34 ns, meas 36 ns) ----
vctl_op1_0900_rh_s0p1_r30k ctl_op1_0900_rh_s0p1_r30k 0 pwl(0.0000e+00 {VDD} 2.0000e-09 {VDD} 2.1000e-09 0)
* RWL driver model (EXPERIMENTAL): slew 0.1 ns, series R 30000 ohm; cell pin = rwls_op1_0900_rh_s0p1_r30k
vrs_op1_0900_rh_s0p1_r30k rwlsrc_op1_0900_rh_s0p1_r30k 0 pwl(0.0000e+00 {VDD} 2.0000e-09 {VDD} 2.1000e-09 0 1.2000e-08 0 1.2100e-08 {VDD})
rdrv_op1_0900_rh_s0p1_r30k rwlsrc_op1_0900_rh_s0p1_r30k rwls_op1_0900_rh_s0p1_r30k 30000
ven_op1_0900_rh_s0p1_r30k en_op1_0900_rh_s0p1_r30k 0 pwl(0.0000e+00 0 1.1000e-08 0 1.1100e-08 {VDD} 3.4000e-08 {VDD} 3.4100e-08 0)
venb_op1_0900_rh_s0p1_r30k enb_op1_0900_rh_s0p1_r30k 0 pwl(0.0000e+00 {VDD} 1.1000e-08 {VDD} 1.1100e-08 0 3.4000e-08 0 3.4100e-08 {VDD})
vww_op1_0900_rh_s0p1_r30k wwl_op1_0900_rh_s0p1_r30k 0 pwl(0.0000e+00 0 1.2000e-08 0 1.2100e-08 {VDD} 3.2000e-08 {VDD} 3.2100e-08 0)
vwc_op1_0900_rh_s0p1_r30k wbc_op1_0900_rh_s0p1_r30k 0 pwl(0.0000e+00 0 1.2000e-08 0 1.2100e-08 {VDD} 3.4000e-08 {VDD} 3.4100e-08 0)
swb_op1_0900_rh_s0p1_r30k ref_op1_0900_rh_s0p1_r30k wbl_op1_0900_rh_s0p1_r30k wbc_op1_0900_rh_s0p1_r30k 0 swwbl
cwbl_op1_0900_rh_s0p1_r30k wbl_op1_0900_rh_s0p1_r30k 0 {C_WBL}
spa_op1_0900_rh_s0p1_r30k prea rbl_op1_0900_rh_s0p1_r30k ctl_op1_0900_rh_s0p1_r30k 0 swpre
spr_op1_0900_rh_s0p1_r30k pref ref_op1_0900_rh_s0p1_r30k ctl_op1_0900_rh_s0p1_r30k 0 swpre
crbl_op1_0900_rh_s0p1_r30k rbl_op1_0900_rh_s0p1_r30k 0 {C_RBL}
cref_op1_0900_rh_s0p1_r30k ref_op1_0900_rh_s0p1_r30k 0 {C_RBL}   $ ASSUMPTION: ideal matched dummy load
XMWR_op1_0900_rh_s0p1_r30k_0 sn_op1_0900_rh_s0p1_r30k_0 wwl_op1_0900_rh_s0p1_r30k wbl_op1_0900_rh_s0p1_r30k 0 sky130_fd_pr__nfet_01v8 L=0.15 W=0.42 nf=1 ad=0.1218 as=0.1218 pd=1.42 ps=1.42 nrd=0.69047619047619  nrs=0.69047619047619 sa=0 sb=0 sd=0 mult=1 m=1
XMRD_op1_0900_rh_s0p1_r30k_0 rbl_op1_0900_rh_s0p1_r30k sn_op1_0900_rh_s0p1_r30k_0 rwls_op1_0900_rh_s0p1_r30k 0 sky130_fd_pr__nfet_01v8 L=0.15 W=0.42 nf=1 ad=0.1218 as=0.1218 pd=1.42 ps=1.42 nrd=0.69047619047619  nrs=0.69047619047619 sa=0 sb=0 sd=0 mult=1 m=1
csn_op1_0900_rh_s0p1_r30k_0 sn_op1_0900_rh_s0p1_r30k_0 0 {C_SN}
XMWR_op1_0900_rh_s0p1_r30k_1 sn_op1_0900_rh_s0p1_r30k_1 wwl_des wbl_op1_0900_rh_s0p1_r30k 0 sky130_fd_pr__nfet_01v8 L=0.15 W=0.42 nf=1 ad=0.1218 as=0.1218 pd=1.42 ps=1.42 nrd=0.69047619047619  nrs=0.69047619047619 sa=0 sb=0 sd=0 mult=1 m=1
XMRD_op1_0900_rh_s0p1_r30k_1 rbl_op1_0900_rh_s0p1_r30k sn_op1_0900_rh_s0p1_r30k_1 rwl_des 0 sky130_fd_pr__nfet_01v8 L=0.15 W=0.42 nf=1 ad=0.1218 as=0.1218 pd=1.42 ps=1.42 nrd=0.69047619047619  nrs=0.69047619047619 sa=0 sb=0 sd=0 mult=1 m=1
csn_op1_0900_rh_s0p1_r30k_1 sn_op1_0900_rh_s0p1_r30k_1 0 {C_SN}
XMWR_op1_0900_rh_s0p1_r30k_2 sn_op1_0900_rh_s0p1_r30k_2 wwl_des wbl_op1_0900_rh_s0p1_r30k 0 sky130_fd_pr__nfet_01v8 L=0.15 W=0.42 nf=1 ad=0.1218 as=0.1218 pd=1.42 ps=1.42 nrd=0.69047619047619  nrs=0.69047619047619 sa=0 sb=0 sd=0 mult=1 m=1
XMRD_op1_0900_rh_s0p1_r30k_2 rbl_op1_0900_rh_s0p1_r30k sn_op1_0900_rh_s0p1_r30k_2 rwl_des 0 sky130_fd_pr__nfet_01v8 L=0.15 W=0.42 nf=1 ad=0.1218 as=0.1218 pd=1.42 ps=1.42 nrd=0.69047619047619  nrs=0.69047619047619 sa=0 sb=0 sd=0 mult=1 m=1
csn_op1_0900_rh_s0p1_r30k_2 sn_op1_0900_rh_s0p1_r30k_2 0 {C_SN}
XMWR_op1_0900_rh_s0p1_r30k_3 sn_op1_0900_rh_s0p1_r30k_3 wwl_des wbl_op1_0900_rh_s0p1_r30k 0 sky130_fd_pr__nfet_01v8 L=0.15 W=0.42 nf=1 ad=0.1218 as=0.1218 pd=1.42 ps=1.42 nrd=0.69047619047619  nrs=0.69047619047619 sa=0 sb=0 sd=0 mult=1 m=1
XMRD_op1_0900_rh_s0p1_r30k_3 rbl_op1_0900_rh_s0p1_r30k sn_op1_0900_rh_s0p1_r30k_3 rwl_des 0 sky130_fd_pr__nfet_01v8 L=0.15 W=0.42 nf=1 ad=0.1218 as=0.1218 pd=1.42 ps=1.42 nrd=0.69047619047619  nrs=0.69047619047619 sa=0 sb=0 sd=0 mult=1 m=1
csn_op1_0900_rh_s0p1_r30k_3 sn_op1_0900_rh_s0p1_r30k_3 0 {C_SN}
XMN1_op1_0900_rh_s0p1_r30k rbl_op1_0900_rh_s0p1_r30k ref_op1_0900_rh_s0p1_r30k vn_op1_0900_rh_s0p1_r30k 0 sky130_fd_pr__nfet_01v8 L=0.15 W=1 nf=1 ad=0.29 as=0.29 pd=2.58 ps=2.58 mult=1 m=1
XMN2_op1_0900_rh_s0p1_r30k ref_op1_0900_rh_s0p1_r30k rbl_op1_0900_rh_s0p1_r30k vn_op1_0900_rh_s0p1_r30k 0 sky130_fd_pr__nfet_01v8 L=0.15 W=1 nf=1 ad=0.29 as=0.29 pd=2.58 ps=2.58 mult=1 m=1
XMP1_op1_0900_rh_s0p1_r30k rbl_op1_0900_rh_s0p1_r30k ref_op1_0900_rh_s0p1_r30k vp_op1_0900_rh_s0p1_r30k vdd sky130_fd_pr__pfet_01v8 L=0.15 W=2 nf=1 ad=0.58 as=0.58 pd=4.58 ps=4.58 mult=1 m=1
XMP2_op1_0900_rh_s0p1_r30k ref_op1_0900_rh_s0p1_r30k rbl_op1_0900_rh_s0p1_r30k vp_op1_0900_rh_s0p1_r30k vdd sky130_fd_pr__pfet_01v8 L=0.15 W=2 nf=1 ad=0.58 as=0.58 pd=4.58 ps=4.58 mult=1 m=1
XMNF_op1_0900_rh_s0p1_r30k vn_op1_0900_rh_s0p1_r30k en_op1_0900_rh_s0p1_r30k 0 0 sky130_fd_pr__nfet_01v8 L=0.15 W=2 nf=1 ad=0.58 as=0.58 pd=4.58 ps=4.58 mult=1 m=1
XMPH_op1_0900_rh_s0p1_r30k vp_op1_0900_rh_s0p1_r30k enb_op1_0900_rh_s0p1_r30k vdd vdd sky130_fd_pr__pfet_01v8 L=0.15 W=4 nf=1 ad=1.16 as=1.16 pd=8.58 ps=8.58 mult=1 m=1
bd_op1_0900_rh_s0p1_r30k d_op1_0900_rh_s0p1_r30k 0 v=v(rbl_op1_0900_rh_s0p1_r30k)-v(ref_op1_0900_rh_s0p1_r30k)

* ---- instance 130: op1_1000_rh_s0p1_r30k (variant rh_s0p1_r30k; probe dec 11.9 ns, release 34 ns, meas 36 ns) ----
vctl_op1_1000_rh_s0p1_r30k ctl_op1_1000_rh_s0p1_r30k 0 pwl(0.0000e+00 {VDD} 2.0000e-09 {VDD} 2.1000e-09 0)
* RWL driver model (EXPERIMENTAL): slew 0.1 ns, series R 30000 ohm; cell pin = rwls_op1_1000_rh_s0p1_r30k
vrs_op1_1000_rh_s0p1_r30k rwlsrc_op1_1000_rh_s0p1_r30k 0 pwl(0.0000e+00 {VDD} 2.0000e-09 {VDD} 2.1000e-09 0 1.2000e-08 0 1.2100e-08 {VDD})
rdrv_op1_1000_rh_s0p1_r30k rwlsrc_op1_1000_rh_s0p1_r30k rwls_op1_1000_rh_s0p1_r30k 30000
ven_op1_1000_rh_s0p1_r30k en_op1_1000_rh_s0p1_r30k 0 pwl(0.0000e+00 0 1.1000e-08 0 1.1100e-08 {VDD} 3.4000e-08 {VDD} 3.4100e-08 0)
venb_op1_1000_rh_s0p1_r30k enb_op1_1000_rh_s0p1_r30k 0 pwl(0.0000e+00 {VDD} 1.1000e-08 {VDD} 1.1100e-08 0 3.4000e-08 0 3.4100e-08 {VDD})
vww_op1_1000_rh_s0p1_r30k wwl_op1_1000_rh_s0p1_r30k 0 pwl(0.0000e+00 0 1.2000e-08 0 1.2100e-08 {VDD} 3.2000e-08 {VDD} 3.2100e-08 0)
vwc_op1_1000_rh_s0p1_r30k wbc_op1_1000_rh_s0p1_r30k 0 pwl(0.0000e+00 0 1.2000e-08 0 1.2100e-08 {VDD} 3.4000e-08 {VDD} 3.4100e-08 0)
swb_op1_1000_rh_s0p1_r30k ref_op1_1000_rh_s0p1_r30k wbl_op1_1000_rh_s0p1_r30k wbc_op1_1000_rh_s0p1_r30k 0 swwbl
cwbl_op1_1000_rh_s0p1_r30k wbl_op1_1000_rh_s0p1_r30k 0 {C_WBL}
spa_op1_1000_rh_s0p1_r30k prea rbl_op1_1000_rh_s0p1_r30k ctl_op1_1000_rh_s0p1_r30k 0 swpre
spr_op1_1000_rh_s0p1_r30k pref ref_op1_1000_rh_s0p1_r30k ctl_op1_1000_rh_s0p1_r30k 0 swpre
crbl_op1_1000_rh_s0p1_r30k rbl_op1_1000_rh_s0p1_r30k 0 {C_RBL}
cref_op1_1000_rh_s0p1_r30k ref_op1_1000_rh_s0p1_r30k 0 {C_RBL}   $ ASSUMPTION: ideal matched dummy load
XMWR_op1_1000_rh_s0p1_r30k_0 sn_op1_1000_rh_s0p1_r30k_0 wwl_op1_1000_rh_s0p1_r30k wbl_op1_1000_rh_s0p1_r30k 0 sky130_fd_pr__nfet_01v8 L=0.15 W=0.42 nf=1 ad=0.1218 as=0.1218 pd=1.42 ps=1.42 nrd=0.69047619047619  nrs=0.69047619047619 sa=0 sb=0 sd=0 mult=1 m=1
XMRD_op1_1000_rh_s0p1_r30k_0 rbl_op1_1000_rh_s0p1_r30k sn_op1_1000_rh_s0p1_r30k_0 rwls_op1_1000_rh_s0p1_r30k 0 sky130_fd_pr__nfet_01v8 L=0.15 W=0.42 nf=1 ad=0.1218 as=0.1218 pd=1.42 ps=1.42 nrd=0.69047619047619  nrs=0.69047619047619 sa=0 sb=0 sd=0 mult=1 m=1
csn_op1_1000_rh_s0p1_r30k_0 sn_op1_1000_rh_s0p1_r30k_0 0 {C_SN}
XMWR_op1_1000_rh_s0p1_r30k_1 sn_op1_1000_rh_s0p1_r30k_1 wwl_des wbl_op1_1000_rh_s0p1_r30k 0 sky130_fd_pr__nfet_01v8 L=0.15 W=0.42 nf=1 ad=0.1218 as=0.1218 pd=1.42 ps=1.42 nrd=0.69047619047619  nrs=0.69047619047619 sa=0 sb=0 sd=0 mult=1 m=1
XMRD_op1_1000_rh_s0p1_r30k_1 rbl_op1_1000_rh_s0p1_r30k sn_op1_1000_rh_s0p1_r30k_1 rwl_des 0 sky130_fd_pr__nfet_01v8 L=0.15 W=0.42 nf=1 ad=0.1218 as=0.1218 pd=1.42 ps=1.42 nrd=0.69047619047619  nrs=0.69047619047619 sa=0 sb=0 sd=0 mult=1 m=1
csn_op1_1000_rh_s0p1_r30k_1 sn_op1_1000_rh_s0p1_r30k_1 0 {C_SN}
XMWR_op1_1000_rh_s0p1_r30k_2 sn_op1_1000_rh_s0p1_r30k_2 wwl_des wbl_op1_1000_rh_s0p1_r30k 0 sky130_fd_pr__nfet_01v8 L=0.15 W=0.42 nf=1 ad=0.1218 as=0.1218 pd=1.42 ps=1.42 nrd=0.69047619047619  nrs=0.69047619047619 sa=0 sb=0 sd=0 mult=1 m=1
XMRD_op1_1000_rh_s0p1_r30k_2 rbl_op1_1000_rh_s0p1_r30k sn_op1_1000_rh_s0p1_r30k_2 rwl_des 0 sky130_fd_pr__nfet_01v8 L=0.15 W=0.42 nf=1 ad=0.1218 as=0.1218 pd=1.42 ps=1.42 nrd=0.69047619047619  nrs=0.69047619047619 sa=0 sb=0 sd=0 mult=1 m=1
csn_op1_1000_rh_s0p1_r30k_2 sn_op1_1000_rh_s0p1_r30k_2 0 {C_SN}
XMWR_op1_1000_rh_s0p1_r30k_3 sn_op1_1000_rh_s0p1_r30k_3 wwl_des wbl_op1_1000_rh_s0p1_r30k 0 sky130_fd_pr__nfet_01v8 L=0.15 W=0.42 nf=1 ad=0.1218 as=0.1218 pd=1.42 ps=1.42 nrd=0.69047619047619  nrs=0.69047619047619 sa=0 sb=0 sd=0 mult=1 m=1
XMRD_op1_1000_rh_s0p1_r30k_3 rbl_op1_1000_rh_s0p1_r30k sn_op1_1000_rh_s0p1_r30k_3 rwl_des 0 sky130_fd_pr__nfet_01v8 L=0.15 W=0.42 nf=1 ad=0.1218 as=0.1218 pd=1.42 ps=1.42 nrd=0.69047619047619  nrs=0.69047619047619 sa=0 sb=0 sd=0 mult=1 m=1
csn_op1_1000_rh_s0p1_r30k_3 sn_op1_1000_rh_s0p1_r30k_3 0 {C_SN}
XMN1_op1_1000_rh_s0p1_r30k rbl_op1_1000_rh_s0p1_r30k ref_op1_1000_rh_s0p1_r30k vn_op1_1000_rh_s0p1_r30k 0 sky130_fd_pr__nfet_01v8 L=0.15 W=1 nf=1 ad=0.29 as=0.29 pd=2.58 ps=2.58 mult=1 m=1
XMN2_op1_1000_rh_s0p1_r30k ref_op1_1000_rh_s0p1_r30k rbl_op1_1000_rh_s0p1_r30k vn_op1_1000_rh_s0p1_r30k 0 sky130_fd_pr__nfet_01v8 L=0.15 W=1 nf=1 ad=0.29 as=0.29 pd=2.58 ps=2.58 mult=1 m=1
XMP1_op1_1000_rh_s0p1_r30k rbl_op1_1000_rh_s0p1_r30k ref_op1_1000_rh_s0p1_r30k vp_op1_1000_rh_s0p1_r30k vdd sky130_fd_pr__pfet_01v8 L=0.15 W=2 nf=1 ad=0.58 as=0.58 pd=4.58 ps=4.58 mult=1 m=1
XMP2_op1_1000_rh_s0p1_r30k ref_op1_1000_rh_s0p1_r30k rbl_op1_1000_rh_s0p1_r30k vp_op1_1000_rh_s0p1_r30k vdd sky130_fd_pr__pfet_01v8 L=0.15 W=2 nf=1 ad=0.58 as=0.58 pd=4.58 ps=4.58 mult=1 m=1
XMNF_op1_1000_rh_s0p1_r30k vn_op1_1000_rh_s0p1_r30k en_op1_1000_rh_s0p1_r30k 0 0 sky130_fd_pr__nfet_01v8 L=0.15 W=2 nf=1 ad=0.58 as=0.58 pd=4.58 ps=4.58 mult=1 m=1
XMPH_op1_1000_rh_s0p1_r30k vp_op1_1000_rh_s0p1_r30k enb_op1_1000_rh_s0p1_r30k vdd vdd sky130_fd_pr__pfet_01v8 L=0.15 W=4 nf=1 ad=1.16 as=1.16 pd=8.58 ps=8.58 mult=1 m=1
bd_op1_1000_rh_s0p1_r30k d_op1_1000_rh_s0p1_r30k 0 v=v(rbl_op1_1000_rh_s0p1_r30k)-v(ref_op1_1000_rh_s0p1_r30k)

* ---- instance 131: op0_n100_rh_s0p1_r30k (variant rh_s0p1_r30k; probe dec 11.9 ns, release 34 ns, meas 36 ns) ----
vctl_op0_n100_rh_s0p1_r30k ctl_op0_n100_rh_s0p1_r30k 0 pwl(0.0000e+00 {VDD} 2.0000e-09 {VDD} 2.1000e-09 0)
* RWL driver model (EXPERIMENTAL): slew 0.1 ns, series R 30000 ohm; cell pin = rwls_op0_n100_rh_s0p1_r30k
vrs_op0_n100_rh_s0p1_r30k rwlsrc_op0_n100_rh_s0p1_r30k 0 pwl(0.0000e+00 {VDD} 2.0000e-09 {VDD} 2.1000e-09 0 1.2000e-08 0 1.2100e-08 {VDD})
rdrv_op0_n100_rh_s0p1_r30k rwlsrc_op0_n100_rh_s0p1_r30k rwls_op0_n100_rh_s0p1_r30k 30000
ven_op0_n100_rh_s0p1_r30k en_op0_n100_rh_s0p1_r30k 0 pwl(0.0000e+00 0 1.1000e-08 0 1.1100e-08 {VDD} 3.4000e-08 {VDD} 3.4100e-08 0)
venb_op0_n100_rh_s0p1_r30k enb_op0_n100_rh_s0p1_r30k 0 pwl(0.0000e+00 {VDD} 1.1000e-08 {VDD} 1.1100e-08 0 3.4000e-08 0 3.4100e-08 {VDD})
vww_op0_n100_rh_s0p1_r30k wwl_op0_n100_rh_s0p1_r30k 0 pwl(0.0000e+00 0 1.2000e-08 0 1.2100e-08 {VDD} 3.2000e-08 {VDD} 3.2100e-08 0)
vwc_op0_n100_rh_s0p1_r30k wbc_op0_n100_rh_s0p1_r30k 0 pwl(0.0000e+00 0 1.2000e-08 0 1.2100e-08 {VDD} 3.4000e-08 {VDD} 3.4100e-08 0)
swb_op0_n100_rh_s0p1_r30k ref_op0_n100_rh_s0p1_r30k wbl_op0_n100_rh_s0p1_r30k wbc_op0_n100_rh_s0p1_r30k 0 swwbl
cwbl_op0_n100_rh_s0p1_r30k wbl_op0_n100_rh_s0p1_r30k 0 {C_WBL}
spa_op0_n100_rh_s0p1_r30k prea rbl_op0_n100_rh_s0p1_r30k ctl_op0_n100_rh_s0p1_r30k 0 swpre
spr_op0_n100_rh_s0p1_r30k pref ref_op0_n100_rh_s0p1_r30k ctl_op0_n100_rh_s0p1_r30k 0 swpre
crbl_op0_n100_rh_s0p1_r30k rbl_op0_n100_rh_s0p1_r30k 0 {C_RBL}
cref_op0_n100_rh_s0p1_r30k ref_op0_n100_rh_s0p1_r30k 0 {C_RBL}   $ ASSUMPTION: ideal matched dummy load
XMWR_op0_n100_rh_s0p1_r30k_0 sn_op0_n100_rh_s0p1_r30k_0 wwl_op0_n100_rh_s0p1_r30k wbl_op0_n100_rh_s0p1_r30k 0 sky130_fd_pr__nfet_01v8 L=0.15 W=0.42 nf=1 ad=0.1218 as=0.1218 pd=1.42 ps=1.42 nrd=0.69047619047619  nrs=0.69047619047619 sa=0 sb=0 sd=0 mult=1 m=1
XMRD_op0_n100_rh_s0p1_r30k_0 rbl_op0_n100_rh_s0p1_r30k sn_op0_n100_rh_s0p1_r30k_0 rwls_op0_n100_rh_s0p1_r30k 0 sky130_fd_pr__nfet_01v8 L=0.15 W=0.42 nf=1 ad=0.1218 as=0.1218 pd=1.42 ps=1.42 nrd=0.69047619047619  nrs=0.69047619047619 sa=0 sb=0 sd=0 mult=1 m=1
csn_op0_n100_rh_s0p1_r30k_0 sn_op0_n100_rh_s0p1_r30k_0 0 {C_SN}
XMWR_op0_n100_rh_s0p1_r30k_1 sn_op0_n100_rh_s0p1_r30k_1 wwl_des wbl_op0_n100_rh_s0p1_r30k 0 sky130_fd_pr__nfet_01v8 L=0.15 W=0.42 nf=1 ad=0.1218 as=0.1218 pd=1.42 ps=1.42 nrd=0.69047619047619  nrs=0.69047619047619 sa=0 sb=0 sd=0 mult=1 m=1
XMRD_op0_n100_rh_s0p1_r30k_1 rbl_op0_n100_rh_s0p1_r30k sn_op0_n100_rh_s0p1_r30k_1 rwl_des 0 sky130_fd_pr__nfet_01v8 L=0.15 W=0.42 nf=1 ad=0.1218 as=0.1218 pd=1.42 ps=1.42 nrd=0.69047619047619  nrs=0.69047619047619 sa=0 sb=0 sd=0 mult=1 m=1
csn_op0_n100_rh_s0p1_r30k_1 sn_op0_n100_rh_s0p1_r30k_1 0 {C_SN}
XMWR_op0_n100_rh_s0p1_r30k_2 sn_op0_n100_rh_s0p1_r30k_2 wwl_des wbl_op0_n100_rh_s0p1_r30k 0 sky130_fd_pr__nfet_01v8 L=0.15 W=0.42 nf=1 ad=0.1218 as=0.1218 pd=1.42 ps=1.42 nrd=0.69047619047619  nrs=0.69047619047619 sa=0 sb=0 sd=0 mult=1 m=1
XMRD_op0_n100_rh_s0p1_r30k_2 rbl_op0_n100_rh_s0p1_r30k sn_op0_n100_rh_s0p1_r30k_2 rwl_des 0 sky130_fd_pr__nfet_01v8 L=0.15 W=0.42 nf=1 ad=0.1218 as=0.1218 pd=1.42 ps=1.42 nrd=0.69047619047619  nrs=0.69047619047619 sa=0 sb=0 sd=0 mult=1 m=1
csn_op0_n100_rh_s0p1_r30k_2 sn_op0_n100_rh_s0p1_r30k_2 0 {C_SN}
XMWR_op0_n100_rh_s0p1_r30k_3 sn_op0_n100_rh_s0p1_r30k_3 wwl_des wbl_op0_n100_rh_s0p1_r30k 0 sky130_fd_pr__nfet_01v8 L=0.15 W=0.42 nf=1 ad=0.1218 as=0.1218 pd=1.42 ps=1.42 nrd=0.69047619047619  nrs=0.69047619047619 sa=0 sb=0 sd=0 mult=1 m=1
XMRD_op0_n100_rh_s0p1_r30k_3 rbl_op0_n100_rh_s0p1_r30k sn_op0_n100_rh_s0p1_r30k_3 rwl_des 0 sky130_fd_pr__nfet_01v8 L=0.15 W=0.42 nf=1 ad=0.1218 as=0.1218 pd=1.42 ps=1.42 nrd=0.69047619047619  nrs=0.69047619047619 sa=0 sb=0 sd=0 mult=1 m=1
csn_op0_n100_rh_s0p1_r30k_3 sn_op0_n100_rh_s0p1_r30k_3 0 {C_SN}
XMN1_op0_n100_rh_s0p1_r30k rbl_op0_n100_rh_s0p1_r30k ref_op0_n100_rh_s0p1_r30k vn_op0_n100_rh_s0p1_r30k 0 sky130_fd_pr__nfet_01v8 L=0.15 W=1 nf=1 ad=0.29 as=0.29 pd=2.58 ps=2.58 mult=1 m=1
XMN2_op0_n100_rh_s0p1_r30k ref_op0_n100_rh_s0p1_r30k rbl_op0_n100_rh_s0p1_r30k vn_op0_n100_rh_s0p1_r30k 0 sky130_fd_pr__nfet_01v8 L=0.15 W=1 nf=1 ad=0.29 as=0.29 pd=2.58 ps=2.58 mult=1 m=1
XMP1_op0_n100_rh_s0p1_r30k rbl_op0_n100_rh_s0p1_r30k ref_op0_n100_rh_s0p1_r30k vp_op0_n100_rh_s0p1_r30k vdd sky130_fd_pr__pfet_01v8 L=0.15 W=2 nf=1 ad=0.58 as=0.58 pd=4.58 ps=4.58 mult=1 m=1
XMP2_op0_n100_rh_s0p1_r30k ref_op0_n100_rh_s0p1_r30k rbl_op0_n100_rh_s0p1_r30k vp_op0_n100_rh_s0p1_r30k vdd sky130_fd_pr__pfet_01v8 L=0.15 W=2 nf=1 ad=0.58 as=0.58 pd=4.58 ps=4.58 mult=1 m=1
XMNF_op0_n100_rh_s0p1_r30k vn_op0_n100_rh_s0p1_r30k en_op0_n100_rh_s0p1_r30k 0 0 sky130_fd_pr__nfet_01v8 L=0.15 W=2 nf=1 ad=0.58 as=0.58 pd=4.58 ps=4.58 mult=1 m=1
XMPH_op0_n100_rh_s0p1_r30k vp_op0_n100_rh_s0p1_r30k enb_op0_n100_rh_s0p1_r30k vdd vdd sky130_fd_pr__pfet_01v8 L=0.15 W=4 nf=1 ad=1.16 as=1.16 pd=8.58 ps=8.58 mult=1 m=1
bd_op0_n100_rh_s0p1_r30k d_op0_n100_rh_s0p1_r30k 0 v=v(rbl_op0_n100_rh_s0p1_r30k)-v(ref_op0_n100_rh_s0p1_r30k)

* ---- instance 132: op0_0000_rh_s0p1_r30k (variant rh_s0p1_r30k; probe dec 11.9 ns, release 34 ns, meas 36 ns) ----
vctl_op0_0000_rh_s0p1_r30k ctl_op0_0000_rh_s0p1_r30k 0 pwl(0.0000e+00 {VDD} 2.0000e-09 {VDD} 2.1000e-09 0)
* RWL driver model (EXPERIMENTAL): slew 0.1 ns, series R 30000 ohm; cell pin = rwls_op0_0000_rh_s0p1_r30k
vrs_op0_0000_rh_s0p1_r30k rwlsrc_op0_0000_rh_s0p1_r30k 0 pwl(0.0000e+00 {VDD} 2.0000e-09 {VDD} 2.1000e-09 0 1.2000e-08 0 1.2100e-08 {VDD})
rdrv_op0_0000_rh_s0p1_r30k rwlsrc_op0_0000_rh_s0p1_r30k rwls_op0_0000_rh_s0p1_r30k 30000
ven_op0_0000_rh_s0p1_r30k en_op0_0000_rh_s0p1_r30k 0 pwl(0.0000e+00 0 1.1000e-08 0 1.1100e-08 {VDD} 3.4000e-08 {VDD} 3.4100e-08 0)
venb_op0_0000_rh_s0p1_r30k enb_op0_0000_rh_s0p1_r30k 0 pwl(0.0000e+00 {VDD} 1.1000e-08 {VDD} 1.1100e-08 0 3.4000e-08 0 3.4100e-08 {VDD})
vww_op0_0000_rh_s0p1_r30k wwl_op0_0000_rh_s0p1_r30k 0 pwl(0.0000e+00 0 1.2000e-08 0 1.2100e-08 {VDD} 3.2000e-08 {VDD} 3.2100e-08 0)
vwc_op0_0000_rh_s0p1_r30k wbc_op0_0000_rh_s0p1_r30k 0 pwl(0.0000e+00 0 1.2000e-08 0 1.2100e-08 {VDD} 3.4000e-08 {VDD} 3.4100e-08 0)
swb_op0_0000_rh_s0p1_r30k ref_op0_0000_rh_s0p1_r30k wbl_op0_0000_rh_s0p1_r30k wbc_op0_0000_rh_s0p1_r30k 0 swwbl
cwbl_op0_0000_rh_s0p1_r30k wbl_op0_0000_rh_s0p1_r30k 0 {C_WBL}
spa_op0_0000_rh_s0p1_r30k prea rbl_op0_0000_rh_s0p1_r30k ctl_op0_0000_rh_s0p1_r30k 0 swpre
spr_op0_0000_rh_s0p1_r30k pref ref_op0_0000_rh_s0p1_r30k ctl_op0_0000_rh_s0p1_r30k 0 swpre
crbl_op0_0000_rh_s0p1_r30k rbl_op0_0000_rh_s0p1_r30k 0 {C_RBL}
cref_op0_0000_rh_s0p1_r30k ref_op0_0000_rh_s0p1_r30k 0 {C_RBL}   $ ASSUMPTION: ideal matched dummy load
XMWR_op0_0000_rh_s0p1_r30k_0 sn_op0_0000_rh_s0p1_r30k_0 wwl_op0_0000_rh_s0p1_r30k wbl_op0_0000_rh_s0p1_r30k 0 sky130_fd_pr__nfet_01v8 L=0.15 W=0.42 nf=1 ad=0.1218 as=0.1218 pd=1.42 ps=1.42 nrd=0.69047619047619  nrs=0.69047619047619 sa=0 sb=0 sd=0 mult=1 m=1
XMRD_op0_0000_rh_s0p1_r30k_0 rbl_op0_0000_rh_s0p1_r30k sn_op0_0000_rh_s0p1_r30k_0 rwls_op0_0000_rh_s0p1_r30k 0 sky130_fd_pr__nfet_01v8 L=0.15 W=0.42 nf=1 ad=0.1218 as=0.1218 pd=1.42 ps=1.42 nrd=0.69047619047619  nrs=0.69047619047619 sa=0 sb=0 sd=0 mult=1 m=1
csn_op0_0000_rh_s0p1_r30k_0 sn_op0_0000_rh_s0p1_r30k_0 0 {C_SN}
XMWR_op0_0000_rh_s0p1_r30k_1 sn_op0_0000_rh_s0p1_r30k_1 wwl_des wbl_op0_0000_rh_s0p1_r30k 0 sky130_fd_pr__nfet_01v8 L=0.15 W=0.42 nf=1 ad=0.1218 as=0.1218 pd=1.42 ps=1.42 nrd=0.69047619047619  nrs=0.69047619047619 sa=0 sb=0 sd=0 mult=1 m=1
XMRD_op0_0000_rh_s0p1_r30k_1 rbl_op0_0000_rh_s0p1_r30k sn_op0_0000_rh_s0p1_r30k_1 rwl_des 0 sky130_fd_pr__nfet_01v8 L=0.15 W=0.42 nf=1 ad=0.1218 as=0.1218 pd=1.42 ps=1.42 nrd=0.69047619047619  nrs=0.69047619047619 sa=0 sb=0 sd=0 mult=1 m=1
csn_op0_0000_rh_s0p1_r30k_1 sn_op0_0000_rh_s0p1_r30k_1 0 {C_SN}
XMWR_op0_0000_rh_s0p1_r30k_2 sn_op0_0000_rh_s0p1_r30k_2 wwl_des wbl_op0_0000_rh_s0p1_r30k 0 sky130_fd_pr__nfet_01v8 L=0.15 W=0.42 nf=1 ad=0.1218 as=0.1218 pd=1.42 ps=1.42 nrd=0.69047619047619  nrs=0.69047619047619 sa=0 sb=0 sd=0 mult=1 m=1
XMRD_op0_0000_rh_s0p1_r30k_2 rbl_op0_0000_rh_s0p1_r30k sn_op0_0000_rh_s0p1_r30k_2 rwl_des 0 sky130_fd_pr__nfet_01v8 L=0.15 W=0.42 nf=1 ad=0.1218 as=0.1218 pd=1.42 ps=1.42 nrd=0.69047619047619  nrs=0.69047619047619 sa=0 sb=0 sd=0 mult=1 m=1
csn_op0_0000_rh_s0p1_r30k_2 sn_op0_0000_rh_s0p1_r30k_2 0 {C_SN}
XMWR_op0_0000_rh_s0p1_r30k_3 sn_op0_0000_rh_s0p1_r30k_3 wwl_des wbl_op0_0000_rh_s0p1_r30k 0 sky130_fd_pr__nfet_01v8 L=0.15 W=0.42 nf=1 ad=0.1218 as=0.1218 pd=1.42 ps=1.42 nrd=0.69047619047619  nrs=0.69047619047619 sa=0 sb=0 sd=0 mult=1 m=1
XMRD_op0_0000_rh_s0p1_r30k_3 rbl_op0_0000_rh_s0p1_r30k sn_op0_0000_rh_s0p1_r30k_3 rwl_des 0 sky130_fd_pr__nfet_01v8 L=0.15 W=0.42 nf=1 ad=0.1218 as=0.1218 pd=1.42 ps=1.42 nrd=0.69047619047619  nrs=0.69047619047619 sa=0 sb=0 sd=0 mult=1 m=1
csn_op0_0000_rh_s0p1_r30k_3 sn_op0_0000_rh_s0p1_r30k_3 0 {C_SN}
XMN1_op0_0000_rh_s0p1_r30k rbl_op0_0000_rh_s0p1_r30k ref_op0_0000_rh_s0p1_r30k vn_op0_0000_rh_s0p1_r30k 0 sky130_fd_pr__nfet_01v8 L=0.15 W=1 nf=1 ad=0.29 as=0.29 pd=2.58 ps=2.58 mult=1 m=1
XMN2_op0_0000_rh_s0p1_r30k ref_op0_0000_rh_s0p1_r30k rbl_op0_0000_rh_s0p1_r30k vn_op0_0000_rh_s0p1_r30k 0 sky130_fd_pr__nfet_01v8 L=0.15 W=1 nf=1 ad=0.29 as=0.29 pd=2.58 ps=2.58 mult=1 m=1
XMP1_op0_0000_rh_s0p1_r30k rbl_op0_0000_rh_s0p1_r30k ref_op0_0000_rh_s0p1_r30k vp_op0_0000_rh_s0p1_r30k vdd sky130_fd_pr__pfet_01v8 L=0.15 W=2 nf=1 ad=0.58 as=0.58 pd=4.58 ps=4.58 mult=1 m=1
XMP2_op0_0000_rh_s0p1_r30k ref_op0_0000_rh_s0p1_r30k rbl_op0_0000_rh_s0p1_r30k vp_op0_0000_rh_s0p1_r30k vdd sky130_fd_pr__pfet_01v8 L=0.15 W=2 nf=1 ad=0.58 as=0.58 pd=4.58 ps=4.58 mult=1 m=1
XMNF_op0_0000_rh_s0p1_r30k vn_op0_0000_rh_s0p1_r30k en_op0_0000_rh_s0p1_r30k 0 0 sky130_fd_pr__nfet_01v8 L=0.15 W=2 nf=1 ad=0.58 as=0.58 pd=4.58 ps=4.58 mult=1 m=1
XMPH_op0_0000_rh_s0p1_r30k vp_op0_0000_rh_s0p1_r30k enb_op0_0000_rh_s0p1_r30k vdd vdd sky130_fd_pr__pfet_01v8 L=0.15 W=4 nf=1 ad=1.16 as=1.16 pd=8.58 ps=8.58 mult=1 m=1
bd_op0_0000_rh_s0p1_r30k d_op0_0000_rh_s0p1_r30k 0 v=v(rbl_op0_0000_rh_s0p1_r30k)-v(ref_op0_0000_rh_s0p1_r30k)

* ---- instance 133: op1_0900_rh_s0p1_r100k (variant rh_s0p1_r100k; probe dec 11.9 ns, release 34 ns, meas 36 ns) ----
vctl_op1_0900_rh_s0p1_r100k ctl_op1_0900_rh_s0p1_r100k 0 pwl(0.0000e+00 {VDD} 2.0000e-09 {VDD} 2.1000e-09 0)
* RWL driver model (EXPERIMENTAL): slew 0.1 ns, series R 100000 ohm; cell pin = rwls_op1_0900_rh_s0p1_r100k
vrs_op1_0900_rh_s0p1_r100k rwlsrc_op1_0900_rh_s0p1_r100k 0 pwl(0.0000e+00 {VDD} 2.0000e-09 {VDD} 2.1000e-09 0 1.2000e-08 0 1.2100e-08 {VDD})
rdrv_op1_0900_rh_s0p1_r100k rwlsrc_op1_0900_rh_s0p1_r100k rwls_op1_0900_rh_s0p1_r100k 100000
ven_op1_0900_rh_s0p1_r100k en_op1_0900_rh_s0p1_r100k 0 pwl(0.0000e+00 0 1.1000e-08 0 1.1100e-08 {VDD} 3.4000e-08 {VDD} 3.4100e-08 0)
venb_op1_0900_rh_s0p1_r100k enb_op1_0900_rh_s0p1_r100k 0 pwl(0.0000e+00 {VDD} 1.1000e-08 {VDD} 1.1100e-08 0 3.4000e-08 0 3.4100e-08 {VDD})
vww_op1_0900_rh_s0p1_r100k wwl_op1_0900_rh_s0p1_r100k 0 pwl(0.0000e+00 0 1.2000e-08 0 1.2100e-08 {VDD} 3.2000e-08 {VDD} 3.2100e-08 0)
vwc_op1_0900_rh_s0p1_r100k wbc_op1_0900_rh_s0p1_r100k 0 pwl(0.0000e+00 0 1.2000e-08 0 1.2100e-08 {VDD} 3.4000e-08 {VDD} 3.4100e-08 0)
swb_op1_0900_rh_s0p1_r100k ref_op1_0900_rh_s0p1_r100k wbl_op1_0900_rh_s0p1_r100k wbc_op1_0900_rh_s0p1_r100k 0 swwbl
cwbl_op1_0900_rh_s0p1_r100k wbl_op1_0900_rh_s0p1_r100k 0 {C_WBL}
spa_op1_0900_rh_s0p1_r100k prea rbl_op1_0900_rh_s0p1_r100k ctl_op1_0900_rh_s0p1_r100k 0 swpre
spr_op1_0900_rh_s0p1_r100k pref ref_op1_0900_rh_s0p1_r100k ctl_op1_0900_rh_s0p1_r100k 0 swpre
crbl_op1_0900_rh_s0p1_r100k rbl_op1_0900_rh_s0p1_r100k 0 {C_RBL}
cref_op1_0900_rh_s0p1_r100k ref_op1_0900_rh_s0p1_r100k 0 {C_RBL}   $ ASSUMPTION: ideal matched dummy load
XMWR_op1_0900_rh_s0p1_r100k_0 sn_op1_0900_rh_s0p1_r100k_0 wwl_op1_0900_rh_s0p1_r100k wbl_op1_0900_rh_s0p1_r100k 0 sky130_fd_pr__nfet_01v8 L=0.15 W=0.42 nf=1 ad=0.1218 as=0.1218 pd=1.42 ps=1.42 nrd=0.69047619047619  nrs=0.69047619047619 sa=0 sb=0 sd=0 mult=1 m=1
XMRD_op1_0900_rh_s0p1_r100k_0 rbl_op1_0900_rh_s0p1_r100k sn_op1_0900_rh_s0p1_r100k_0 rwls_op1_0900_rh_s0p1_r100k 0 sky130_fd_pr__nfet_01v8 L=0.15 W=0.42 nf=1 ad=0.1218 as=0.1218 pd=1.42 ps=1.42 nrd=0.69047619047619  nrs=0.69047619047619 sa=0 sb=0 sd=0 mult=1 m=1
csn_op1_0900_rh_s0p1_r100k_0 sn_op1_0900_rh_s0p1_r100k_0 0 {C_SN}
XMWR_op1_0900_rh_s0p1_r100k_1 sn_op1_0900_rh_s0p1_r100k_1 wwl_des wbl_op1_0900_rh_s0p1_r100k 0 sky130_fd_pr__nfet_01v8 L=0.15 W=0.42 nf=1 ad=0.1218 as=0.1218 pd=1.42 ps=1.42 nrd=0.69047619047619  nrs=0.69047619047619 sa=0 sb=0 sd=0 mult=1 m=1
XMRD_op1_0900_rh_s0p1_r100k_1 rbl_op1_0900_rh_s0p1_r100k sn_op1_0900_rh_s0p1_r100k_1 rwl_des 0 sky130_fd_pr__nfet_01v8 L=0.15 W=0.42 nf=1 ad=0.1218 as=0.1218 pd=1.42 ps=1.42 nrd=0.69047619047619  nrs=0.69047619047619 sa=0 sb=0 sd=0 mult=1 m=1
csn_op1_0900_rh_s0p1_r100k_1 sn_op1_0900_rh_s0p1_r100k_1 0 {C_SN}
XMWR_op1_0900_rh_s0p1_r100k_2 sn_op1_0900_rh_s0p1_r100k_2 wwl_des wbl_op1_0900_rh_s0p1_r100k 0 sky130_fd_pr__nfet_01v8 L=0.15 W=0.42 nf=1 ad=0.1218 as=0.1218 pd=1.42 ps=1.42 nrd=0.69047619047619  nrs=0.69047619047619 sa=0 sb=0 sd=0 mult=1 m=1
XMRD_op1_0900_rh_s0p1_r100k_2 rbl_op1_0900_rh_s0p1_r100k sn_op1_0900_rh_s0p1_r100k_2 rwl_des 0 sky130_fd_pr__nfet_01v8 L=0.15 W=0.42 nf=1 ad=0.1218 as=0.1218 pd=1.42 ps=1.42 nrd=0.69047619047619  nrs=0.69047619047619 sa=0 sb=0 sd=0 mult=1 m=1
csn_op1_0900_rh_s0p1_r100k_2 sn_op1_0900_rh_s0p1_r100k_2 0 {C_SN}
XMWR_op1_0900_rh_s0p1_r100k_3 sn_op1_0900_rh_s0p1_r100k_3 wwl_des wbl_op1_0900_rh_s0p1_r100k 0 sky130_fd_pr__nfet_01v8 L=0.15 W=0.42 nf=1 ad=0.1218 as=0.1218 pd=1.42 ps=1.42 nrd=0.69047619047619  nrs=0.69047619047619 sa=0 sb=0 sd=0 mult=1 m=1
XMRD_op1_0900_rh_s0p1_r100k_3 rbl_op1_0900_rh_s0p1_r100k sn_op1_0900_rh_s0p1_r100k_3 rwl_des 0 sky130_fd_pr__nfet_01v8 L=0.15 W=0.42 nf=1 ad=0.1218 as=0.1218 pd=1.42 ps=1.42 nrd=0.69047619047619  nrs=0.69047619047619 sa=0 sb=0 sd=0 mult=1 m=1
csn_op1_0900_rh_s0p1_r100k_3 sn_op1_0900_rh_s0p1_r100k_3 0 {C_SN}
XMN1_op1_0900_rh_s0p1_r100k rbl_op1_0900_rh_s0p1_r100k ref_op1_0900_rh_s0p1_r100k vn_op1_0900_rh_s0p1_r100k 0 sky130_fd_pr__nfet_01v8 L=0.15 W=1 nf=1 ad=0.29 as=0.29 pd=2.58 ps=2.58 mult=1 m=1
XMN2_op1_0900_rh_s0p1_r100k ref_op1_0900_rh_s0p1_r100k rbl_op1_0900_rh_s0p1_r100k vn_op1_0900_rh_s0p1_r100k 0 sky130_fd_pr__nfet_01v8 L=0.15 W=1 nf=1 ad=0.29 as=0.29 pd=2.58 ps=2.58 mult=1 m=1
XMP1_op1_0900_rh_s0p1_r100k rbl_op1_0900_rh_s0p1_r100k ref_op1_0900_rh_s0p1_r100k vp_op1_0900_rh_s0p1_r100k vdd sky130_fd_pr__pfet_01v8 L=0.15 W=2 nf=1 ad=0.58 as=0.58 pd=4.58 ps=4.58 mult=1 m=1
XMP2_op1_0900_rh_s0p1_r100k ref_op1_0900_rh_s0p1_r100k rbl_op1_0900_rh_s0p1_r100k vp_op1_0900_rh_s0p1_r100k vdd sky130_fd_pr__pfet_01v8 L=0.15 W=2 nf=1 ad=0.58 as=0.58 pd=4.58 ps=4.58 mult=1 m=1
XMNF_op1_0900_rh_s0p1_r100k vn_op1_0900_rh_s0p1_r100k en_op1_0900_rh_s0p1_r100k 0 0 sky130_fd_pr__nfet_01v8 L=0.15 W=2 nf=1 ad=0.58 as=0.58 pd=4.58 ps=4.58 mult=1 m=1
XMPH_op1_0900_rh_s0p1_r100k vp_op1_0900_rh_s0p1_r100k enb_op1_0900_rh_s0p1_r100k vdd vdd sky130_fd_pr__pfet_01v8 L=0.15 W=4 nf=1 ad=1.16 as=1.16 pd=8.58 ps=8.58 mult=1 m=1
bd_op1_0900_rh_s0p1_r100k d_op1_0900_rh_s0p1_r100k 0 v=v(rbl_op1_0900_rh_s0p1_r100k)-v(ref_op1_0900_rh_s0p1_r100k)

* ---- instance 134: op1_1000_rh_s0p1_r100k (variant rh_s0p1_r100k; probe dec 11.9 ns, release 34 ns, meas 36 ns) ----
vctl_op1_1000_rh_s0p1_r100k ctl_op1_1000_rh_s0p1_r100k 0 pwl(0.0000e+00 {VDD} 2.0000e-09 {VDD} 2.1000e-09 0)
* RWL driver model (EXPERIMENTAL): slew 0.1 ns, series R 100000 ohm; cell pin = rwls_op1_1000_rh_s0p1_r100k
vrs_op1_1000_rh_s0p1_r100k rwlsrc_op1_1000_rh_s0p1_r100k 0 pwl(0.0000e+00 {VDD} 2.0000e-09 {VDD} 2.1000e-09 0 1.2000e-08 0 1.2100e-08 {VDD})
rdrv_op1_1000_rh_s0p1_r100k rwlsrc_op1_1000_rh_s0p1_r100k rwls_op1_1000_rh_s0p1_r100k 100000
ven_op1_1000_rh_s0p1_r100k en_op1_1000_rh_s0p1_r100k 0 pwl(0.0000e+00 0 1.1000e-08 0 1.1100e-08 {VDD} 3.4000e-08 {VDD} 3.4100e-08 0)
venb_op1_1000_rh_s0p1_r100k enb_op1_1000_rh_s0p1_r100k 0 pwl(0.0000e+00 {VDD} 1.1000e-08 {VDD} 1.1100e-08 0 3.4000e-08 0 3.4100e-08 {VDD})
vww_op1_1000_rh_s0p1_r100k wwl_op1_1000_rh_s0p1_r100k 0 pwl(0.0000e+00 0 1.2000e-08 0 1.2100e-08 {VDD} 3.2000e-08 {VDD} 3.2100e-08 0)
vwc_op1_1000_rh_s0p1_r100k wbc_op1_1000_rh_s0p1_r100k 0 pwl(0.0000e+00 0 1.2000e-08 0 1.2100e-08 {VDD} 3.4000e-08 {VDD} 3.4100e-08 0)
swb_op1_1000_rh_s0p1_r100k ref_op1_1000_rh_s0p1_r100k wbl_op1_1000_rh_s0p1_r100k wbc_op1_1000_rh_s0p1_r100k 0 swwbl
cwbl_op1_1000_rh_s0p1_r100k wbl_op1_1000_rh_s0p1_r100k 0 {C_WBL}
spa_op1_1000_rh_s0p1_r100k prea rbl_op1_1000_rh_s0p1_r100k ctl_op1_1000_rh_s0p1_r100k 0 swpre
spr_op1_1000_rh_s0p1_r100k pref ref_op1_1000_rh_s0p1_r100k ctl_op1_1000_rh_s0p1_r100k 0 swpre
crbl_op1_1000_rh_s0p1_r100k rbl_op1_1000_rh_s0p1_r100k 0 {C_RBL}
cref_op1_1000_rh_s0p1_r100k ref_op1_1000_rh_s0p1_r100k 0 {C_RBL}   $ ASSUMPTION: ideal matched dummy load
XMWR_op1_1000_rh_s0p1_r100k_0 sn_op1_1000_rh_s0p1_r100k_0 wwl_op1_1000_rh_s0p1_r100k wbl_op1_1000_rh_s0p1_r100k 0 sky130_fd_pr__nfet_01v8 L=0.15 W=0.42 nf=1 ad=0.1218 as=0.1218 pd=1.42 ps=1.42 nrd=0.69047619047619  nrs=0.69047619047619 sa=0 sb=0 sd=0 mult=1 m=1
XMRD_op1_1000_rh_s0p1_r100k_0 rbl_op1_1000_rh_s0p1_r100k sn_op1_1000_rh_s0p1_r100k_0 rwls_op1_1000_rh_s0p1_r100k 0 sky130_fd_pr__nfet_01v8 L=0.15 W=0.42 nf=1 ad=0.1218 as=0.1218 pd=1.42 ps=1.42 nrd=0.69047619047619  nrs=0.69047619047619 sa=0 sb=0 sd=0 mult=1 m=1
csn_op1_1000_rh_s0p1_r100k_0 sn_op1_1000_rh_s0p1_r100k_0 0 {C_SN}
XMWR_op1_1000_rh_s0p1_r100k_1 sn_op1_1000_rh_s0p1_r100k_1 wwl_des wbl_op1_1000_rh_s0p1_r100k 0 sky130_fd_pr__nfet_01v8 L=0.15 W=0.42 nf=1 ad=0.1218 as=0.1218 pd=1.42 ps=1.42 nrd=0.69047619047619  nrs=0.69047619047619 sa=0 sb=0 sd=0 mult=1 m=1
XMRD_op1_1000_rh_s0p1_r100k_1 rbl_op1_1000_rh_s0p1_r100k sn_op1_1000_rh_s0p1_r100k_1 rwl_des 0 sky130_fd_pr__nfet_01v8 L=0.15 W=0.42 nf=1 ad=0.1218 as=0.1218 pd=1.42 ps=1.42 nrd=0.69047619047619  nrs=0.69047619047619 sa=0 sb=0 sd=0 mult=1 m=1
csn_op1_1000_rh_s0p1_r100k_1 sn_op1_1000_rh_s0p1_r100k_1 0 {C_SN}
XMWR_op1_1000_rh_s0p1_r100k_2 sn_op1_1000_rh_s0p1_r100k_2 wwl_des wbl_op1_1000_rh_s0p1_r100k 0 sky130_fd_pr__nfet_01v8 L=0.15 W=0.42 nf=1 ad=0.1218 as=0.1218 pd=1.42 ps=1.42 nrd=0.69047619047619  nrs=0.69047619047619 sa=0 sb=0 sd=0 mult=1 m=1
XMRD_op1_1000_rh_s0p1_r100k_2 rbl_op1_1000_rh_s0p1_r100k sn_op1_1000_rh_s0p1_r100k_2 rwl_des 0 sky130_fd_pr__nfet_01v8 L=0.15 W=0.42 nf=1 ad=0.1218 as=0.1218 pd=1.42 ps=1.42 nrd=0.69047619047619  nrs=0.69047619047619 sa=0 sb=0 sd=0 mult=1 m=1
csn_op1_1000_rh_s0p1_r100k_2 sn_op1_1000_rh_s0p1_r100k_2 0 {C_SN}
XMWR_op1_1000_rh_s0p1_r100k_3 sn_op1_1000_rh_s0p1_r100k_3 wwl_des wbl_op1_1000_rh_s0p1_r100k 0 sky130_fd_pr__nfet_01v8 L=0.15 W=0.42 nf=1 ad=0.1218 as=0.1218 pd=1.42 ps=1.42 nrd=0.69047619047619  nrs=0.69047619047619 sa=0 sb=0 sd=0 mult=1 m=1
XMRD_op1_1000_rh_s0p1_r100k_3 rbl_op1_1000_rh_s0p1_r100k sn_op1_1000_rh_s0p1_r100k_3 rwl_des 0 sky130_fd_pr__nfet_01v8 L=0.15 W=0.42 nf=1 ad=0.1218 as=0.1218 pd=1.42 ps=1.42 nrd=0.69047619047619  nrs=0.69047619047619 sa=0 sb=0 sd=0 mult=1 m=1
csn_op1_1000_rh_s0p1_r100k_3 sn_op1_1000_rh_s0p1_r100k_3 0 {C_SN}
XMN1_op1_1000_rh_s0p1_r100k rbl_op1_1000_rh_s0p1_r100k ref_op1_1000_rh_s0p1_r100k vn_op1_1000_rh_s0p1_r100k 0 sky130_fd_pr__nfet_01v8 L=0.15 W=1 nf=1 ad=0.29 as=0.29 pd=2.58 ps=2.58 mult=1 m=1
XMN2_op1_1000_rh_s0p1_r100k ref_op1_1000_rh_s0p1_r100k rbl_op1_1000_rh_s0p1_r100k vn_op1_1000_rh_s0p1_r100k 0 sky130_fd_pr__nfet_01v8 L=0.15 W=1 nf=1 ad=0.29 as=0.29 pd=2.58 ps=2.58 mult=1 m=1
XMP1_op1_1000_rh_s0p1_r100k rbl_op1_1000_rh_s0p1_r100k ref_op1_1000_rh_s0p1_r100k vp_op1_1000_rh_s0p1_r100k vdd sky130_fd_pr__pfet_01v8 L=0.15 W=2 nf=1 ad=0.58 as=0.58 pd=4.58 ps=4.58 mult=1 m=1
XMP2_op1_1000_rh_s0p1_r100k ref_op1_1000_rh_s0p1_r100k rbl_op1_1000_rh_s0p1_r100k vp_op1_1000_rh_s0p1_r100k vdd sky130_fd_pr__pfet_01v8 L=0.15 W=2 nf=1 ad=0.58 as=0.58 pd=4.58 ps=4.58 mult=1 m=1
XMNF_op1_1000_rh_s0p1_r100k vn_op1_1000_rh_s0p1_r100k en_op1_1000_rh_s0p1_r100k 0 0 sky130_fd_pr__nfet_01v8 L=0.15 W=2 nf=1 ad=0.58 as=0.58 pd=4.58 ps=4.58 mult=1 m=1
XMPH_op1_1000_rh_s0p1_r100k vp_op1_1000_rh_s0p1_r100k enb_op1_1000_rh_s0p1_r100k vdd vdd sky130_fd_pr__pfet_01v8 L=0.15 W=4 nf=1 ad=1.16 as=1.16 pd=8.58 ps=8.58 mult=1 m=1
bd_op1_1000_rh_s0p1_r100k d_op1_1000_rh_s0p1_r100k 0 v=v(rbl_op1_1000_rh_s0p1_r100k)-v(ref_op1_1000_rh_s0p1_r100k)

* ---- instance 135: op0_n100_rh_s0p1_r100k (variant rh_s0p1_r100k; probe dec 11.9 ns, release 34 ns, meas 36 ns) ----
vctl_op0_n100_rh_s0p1_r100k ctl_op0_n100_rh_s0p1_r100k 0 pwl(0.0000e+00 {VDD} 2.0000e-09 {VDD} 2.1000e-09 0)
* RWL driver model (EXPERIMENTAL): slew 0.1 ns, series R 100000 ohm; cell pin = rwls_op0_n100_rh_s0p1_r100k
vrs_op0_n100_rh_s0p1_r100k rwlsrc_op0_n100_rh_s0p1_r100k 0 pwl(0.0000e+00 {VDD} 2.0000e-09 {VDD} 2.1000e-09 0 1.2000e-08 0 1.2100e-08 {VDD})
rdrv_op0_n100_rh_s0p1_r100k rwlsrc_op0_n100_rh_s0p1_r100k rwls_op0_n100_rh_s0p1_r100k 100000
ven_op0_n100_rh_s0p1_r100k en_op0_n100_rh_s0p1_r100k 0 pwl(0.0000e+00 0 1.1000e-08 0 1.1100e-08 {VDD} 3.4000e-08 {VDD} 3.4100e-08 0)
venb_op0_n100_rh_s0p1_r100k enb_op0_n100_rh_s0p1_r100k 0 pwl(0.0000e+00 {VDD} 1.1000e-08 {VDD} 1.1100e-08 0 3.4000e-08 0 3.4100e-08 {VDD})
vww_op0_n100_rh_s0p1_r100k wwl_op0_n100_rh_s0p1_r100k 0 pwl(0.0000e+00 0 1.2000e-08 0 1.2100e-08 {VDD} 3.2000e-08 {VDD} 3.2100e-08 0)
vwc_op0_n100_rh_s0p1_r100k wbc_op0_n100_rh_s0p1_r100k 0 pwl(0.0000e+00 0 1.2000e-08 0 1.2100e-08 {VDD} 3.4000e-08 {VDD} 3.4100e-08 0)
swb_op0_n100_rh_s0p1_r100k ref_op0_n100_rh_s0p1_r100k wbl_op0_n100_rh_s0p1_r100k wbc_op0_n100_rh_s0p1_r100k 0 swwbl
cwbl_op0_n100_rh_s0p1_r100k wbl_op0_n100_rh_s0p1_r100k 0 {C_WBL}
spa_op0_n100_rh_s0p1_r100k prea rbl_op0_n100_rh_s0p1_r100k ctl_op0_n100_rh_s0p1_r100k 0 swpre
spr_op0_n100_rh_s0p1_r100k pref ref_op0_n100_rh_s0p1_r100k ctl_op0_n100_rh_s0p1_r100k 0 swpre
crbl_op0_n100_rh_s0p1_r100k rbl_op0_n100_rh_s0p1_r100k 0 {C_RBL}
cref_op0_n100_rh_s0p1_r100k ref_op0_n100_rh_s0p1_r100k 0 {C_RBL}   $ ASSUMPTION: ideal matched dummy load
XMWR_op0_n100_rh_s0p1_r100k_0 sn_op0_n100_rh_s0p1_r100k_0 wwl_op0_n100_rh_s0p1_r100k wbl_op0_n100_rh_s0p1_r100k 0 sky130_fd_pr__nfet_01v8 L=0.15 W=0.42 nf=1 ad=0.1218 as=0.1218 pd=1.42 ps=1.42 nrd=0.69047619047619  nrs=0.69047619047619 sa=0 sb=0 sd=0 mult=1 m=1
XMRD_op0_n100_rh_s0p1_r100k_0 rbl_op0_n100_rh_s0p1_r100k sn_op0_n100_rh_s0p1_r100k_0 rwls_op0_n100_rh_s0p1_r100k 0 sky130_fd_pr__nfet_01v8 L=0.15 W=0.42 nf=1 ad=0.1218 as=0.1218 pd=1.42 ps=1.42 nrd=0.69047619047619  nrs=0.69047619047619 sa=0 sb=0 sd=0 mult=1 m=1
csn_op0_n100_rh_s0p1_r100k_0 sn_op0_n100_rh_s0p1_r100k_0 0 {C_SN}
XMWR_op0_n100_rh_s0p1_r100k_1 sn_op0_n100_rh_s0p1_r100k_1 wwl_des wbl_op0_n100_rh_s0p1_r100k 0 sky130_fd_pr__nfet_01v8 L=0.15 W=0.42 nf=1 ad=0.1218 as=0.1218 pd=1.42 ps=1.42 nrd=0.69047619047619  nrs=0.69047619047619 sa=0 sb=0 sd=0 mult=1 m=1
XMRD_op0_n100_rh_s0p1_r100k_1 rbl_op0_n100_rh_s0p1_r100k sn_op0_n100_rh_s0p1_r100k_1 rwl_des 0 sky130_fd_pr__nfet_01v8 L=0.15 W=0.42 nf=1 ad=0.1218 as=0.1218 pd=1.42 ps=1.42 nrd=0.69047619047619  nrs=0.69047619047619 sa=0 sb=0 sd=0 mult=1 m=1
csn_op0_n100_rh_s0p1_r100k_1 sn_op0_n100_rh_s0p1_r100k_1 0 {C_SN}
XMWR_op0_n100_rh_s0p1_r100k_2 sn_op0_n100_rh_s0p1_r100k_2 wwl_des wbl_op0_n100_rh_s0p1_r100k 0 sky130_fd_pr__nfet_01v8 L=0.15 W=0.42 nf=1 ad=0.1218 as=0.1218 pd=1.42 ps=1.42 nrd=0.69047619047619  nrs=0.69047619047619 sa=0 sb=0 sd=0 mult=1 m=1
XMRD_op0_n100_rh_s0p1_r100k_2 rbl_op0_n100_rh_s0p1_r100k sn_op0_n100_rh_s0p1_r100k_2 rwl_des 0 sky130_fd_pr__nfet_01v8 L=0.15 W=0.42 nf=1 ad=0.1218 as=0.1218 pd=1.42 ps=1.42 nrd=0.69047619047619  nrs=0.69047619047619 sa=0 sb=0 sd=0 mult=1 m=1
csn_op0_n100_rh_s0p1_r100k_2 sn_op0_n100_rh_s0p1_r100k_2 0 {C_SN}
XMWR_op0_n100_rh_s0p1_r100k_3 sn_op0_n100_rh_s0p1_r100k_3 wwl_des wbl_op0_n100_rh_s0p1_r100k 0 sky130_fd_pr__nfet_01v8 L=0.15 W=0.42 nf=1 ad=0.1218 as=0.1218 pd=1.42 ps=1.42 nrd=0.69047619047619  nrs=0.69047619047619 sa=0 sb=0 sd=0 mult=1 m=1
XMRD_op0_n100_rh_s0p1_r100k_3 rbl_op0_n100_rh_s0p1_r100k sn_op0_n100_rh_s0p1_r100k_3 rwl_des 0 sky130_fd_pr__nfet_01v8 L=0.15 W=0.42 nf=1 ad=0.1218 as=0.1218 pd=1.42 ps=1.42 nrd=0.69047619047619  nrs=0.69047619047619 sa=0 sb=0 sd=0 mult=1 m=1
csn_op0_n100_rh_s0p1_r100k_3 sn_op0_n100_rh_s0p1_r100k_3 0 {C_SN}
XMN1_op0_n100_rh_s0p1_r100k rbl_op0_n100_rh_s0p1_r100k ref_op0_n100_rh_s0p1_r100k vn_op0_n100_rh_s0p1_r100k 0 sky130_fd_pr__nfet_01v8 L=0.15 W=1 nf=1 ad=0.29 as=0.29 pd=2.58 ps=2.58 mult=1 m=1
XMN2_op0_n100_rh_s0p1_r100k ref_op0_n100_rh_s0p1_r100k rbl_op0_n100_rh_s0p1_r100k vn_op0_n100_rh_s0p1_r100k 0 sky130_fd_pr__nfet_01v8 L=0.15 W=1 nf=1 ad=0.29 as=0.29 pd=2.58 ps=2.58 mult=1 m=1
XMP1_op0_n100_rh_s0p1_r100k rbl_op0_n100_rh_s0p1_r100k ref_op0_n100_rh_s0p1_r100k vp_op0_n100_rh_s0p1_r100k vdd sky130_fd_pr__pfet_01v8 L=0.15 W=2 nf=1 ad=0.58 as=0.58 pd=4.58 ps=4.58 mult=1 m=1
XMP2_op0_n100_rh_s0p1_r100k ref_op0_n100_rh_s0p1_r100k rbl_op0_n100_rh_s0p1_r100k vp_op0_n100_rh_s0p1_r100k vdd sky130_fd_pr__pfet_01v8 L=0.15 W=2 nf=1 ad=0.58 as=0.58 pd=4.58 ps=4.58 mult=1 m=1
XMNF_op0_n100_rh_s0p1_r100k vn_op0_n100_rh_s0p1_r100k en_op0_n100_rh_s0p1_r100k 0 0 sky130_fd_pr__nfet_01v8 L=0.15 W=2 nf=1 ad=0.58 as=0.58 pd=4.58 ps=4.58 mult=1 m=1
XMPH_op0_n100_rh_s0p1_r100k vp_op0_n100_rh_s0p1_r100k enb_op0_n100_rh_s0p1_r100k vdd vdd sky130_fd_pr__pfet_01v8 L=0.15 W=4 nf=1 ad=1.16 as=1.16 pd=8.58 ps=8.58 mult=1 m=1
bd_op0_n100_rh_s0p1_r100k d_op0_n100_rh_s0p1_r100k 0 v=v(rbl_op0_n100_rh_s0p1_r100k)-v(ref_op0_n100_rh_s0p1_r100k)

* ---- instance 136: op0_0000_rh_s0p1_r100k (variant rh_s0p1_r100k; probe dec 11.9 ns, release 34 ns, meas 36 ns) ----
vctl_op0_0000_rh_s0p1_r100k ctl_op0_0000_rh_s0p1_r100k 0 pwl(0.0000e+00 {VDD} 2.0000e-09 {VDD} 2.1000e-09 0)
* RWL driver model (EXPERIMENTAL): slew 0.1 ns, series R 100000 ohm; cell pin = rwls_op0_0000_rh_s0p1_r100k
vrs_op0_0000_rh_s0p1_r100k rwlsrc_op0_0000_rh_s0p1_r100k 0 pwl(0.0000e+00 {VDD} 2.0000e-09 {VDD} 2.1000e-09 0 1.2000e-08 0 1.2100e-08 {VDD})
rdrv_op0_0000_rh_s0p1_r100k rwlsrc_op0_0000_rh_s0p1_r100k rwls_op0_0000_rh_s0p1_r100k 100000
ven_op0_0000_rh_s0p1_r100k en_op0_0000_rh_s0p1_r100k 0 pwl(0.0000e+00 0 1.1000e-08 0 1.1100e-08 {VDD} 3.4000e-08 {VDD} 3.4100e-08 0)
venb_op0_0000_rh_s0p1_r100k enb_op0_0000_rh_s0p1_r100k 0 pwl(0.0000e+00 {VDD} 1.1000e-08 {VDD} 1.1100e-08 0 3.4000e-08 0 3.4100e-08 {VDD})
vww_op0_0000_rh_s0p1_r100k wwl_op0_0000_rh_s0p1_r100k 0 pwl(0.0000e+00 0 1.2000e-08 0 1.2100e-08 {VDD} 3.2000e-08 {VDD} 3.2100e-08 0)
vwc_op0_0000_rh_s0p1_r100k wbc_op0_0000_rh_s0p1_r100k 0 pwl(0.0000e+00 0 1.2000e-08 0 1.2100e-08 {VDD} 3.4000e-08 {VDD} 3.4100e-08 0)
swb_op0_0000_rh_s0p1_r100k ref_op0_0000_rh_s0p1_r100k wbl_op0_0000_rh_s0p1_r100k wbc_op0_0000_rh_s0p1_r100k 0 swwbl
cwbl_op0_0000_rh_s0p1_r100k wbl_op0_0000_rh_s0p1_r100k 0 {C_WBL}
spa_op0_0000_rh_s0p1_r100k prea rbl_op0_0000_rh_s0p1_r100k ctl_op0_0000_rh_s0p1_r100k 0 swpre
spr_op0_0000_rh_s0p1_r100k pref ref_op0_0000_rh_s0p1_r100k ctl_op0_0000_rh_s0p1_r100k 0 swpre
crbl_op0_0000_rh_s0p1_r100k rbl_op0_0000_rh_s0p1_r100k 0 {C_RBL}
cref_op0_0000_rh_s0p1_r100k ref_op0_0000_rh_s0p1_r100k 0 {C_RBL}   $ ASSUMPTION: ideal matched dummy load
XMWR_op0_0000_rh_s0p1_r100k_0 sn_op0_0000_rh_s0p1_r100k_0 wwl_op0_0000_rh_s0p1_r100k wbl_op0_0000_rh_s0p1_r100k 0 sky130_fd_pr__nfet_01v8 L=0.15 W=0.42 nf=1 ad=0.1218 as=0.1218 pd=1.42 ps=1.42 nrd=0.69047619047619  nrs=0.69047619047619 sa=0 sb=0 sd=0 mult=1 m=1
XMRD_op0_0000_rh_s0p1_r100k_0 rbl_op0_0000_rh_s0p1_r100k sn_op0_0000_rh_s0p1_r100k_0 rwls_op0_0000_rh_s0p1_r100k 0 sky130_fd_pr__nfet_01v8 L=0.15 W=0.42 nf=1 ad=0.1218 as=0.1218 pd=1.42 ps=1.42 nrd=0.69047619047619  nrs=0.69047619047619 sa=0 sb=0 sd=0 mult=1 m=1
csn_op0_0000_rh_s0p1_r100k_0 sn_op0_0000_rh_s0p1_r100k_0 0 {C_SN}
XMWR_op0_0000_rh_s0p1_r100k_1 sn_op0_0000_rh_s0p1_r100k_1 wwl_des wbl_op0_0000_rh_s0p1_r100k 0 sky130_fd_pr__nfet_01v8 L=0.15 W=0.42 nf=1 ad=0.1218 as=0.1218 pd=1.42 ps=1.42 nrd=0.69047619047619  nrs=0.69047619047619 sa=0 sb=0 sd=0 mult=1 m=1
XMRD_op0_0000_rh_s0p1_r100k_1 rbl_op0_0000_rh_s0p1_r100k sn_op0_0000_rh_s0p1_r100k_1 rwl_des 0 sky130_fd_pr__nfet_01v8 L=0.15 W=0.42 nf=1 ad=0.1218 as=0.1218 pd=1.42 ps=1.42 nrd=0.69047619047619  nrs=0.69047619047619 sa=0 sb=0 sd=0 mult=1 m=1
csn_op0_0000_rh_s0p1_r100k_1 sn_op0_0000_rh_s0p1_r100k_1 0 {C_SN}
XMWR_op0_0000_rh_s0p1_r100k_2 sn_op0_0000_rh_s0p1_r100k_2 wwl_des wbl_op0_0000_rh_s0p1_r100k 0 sky130_fd_pr__nfet_01v8 L=0.15 W=0.42 nf=1 ad=0.1218 as=0.1218 pd=1.42 ps=1.42 nrd=0.69047619047619  nrs=0.69047619047619 sa=0 sb=0 sd=0 mult=1 m=1
XMRD_op0_0000_rh_s0p1_r100k_2 rbl_op0_0000_rh_s0p1_r100k sn_op0_0000_rh_s0p1_r100k_2 rwl_des 0 sky130_fd_pr__nfet_01v8 L=0.15 W=0.42 nf=1 ad=0.1218 as=0.1218 pd=1.42 ps=1.42 nrd=0.69047619047619  nrs=0.69047619047619 sa=0 sb=0 sd=0 mult=1 m=1
csn_op0_0000_rh_s0p1_r100k_2 sn_op0_0000_rh_s0p1_r100k_2 0 {C_SN}
XMWR_op0_0000_rh_s0p1_r100k_3 sn_op0_0000_rh_s0p1_r100k_3 wwl_des wbl_op0_0000_rh_s0p1_r100k 0 sky130_fd_pr__nfet_01v8 L=0.15 W=0.42 nf=1 ad=0.1218 as=0.1218 pd=1.42 ps=1.42 nrd=0.69047619047619  nrs=0.69047619047619 sa=0 sb=0 sd=0 mult=1 m=1
XMRD_op0_0000_rh_s0p1_r100k_3 rbl_op0_0000_rh_s0p1_r100k sn_op0_0000_rh_s0p1_r100k_3 rwl_des 0 sky130_fd_pr__nfet_01v8 L=0.15 W=0.42 nf=1 ad=0.1218 as=0.1218 pd=1.42 ps=1.42 nrd=0.69047619047619  nrs=0.69047619047619 sa=0 sb=0 sd=0 mult=1 m=1
csn_op0_0000_rh_s0p1_r100k_3 sn_op0_0000_rh_s0p1_r100k_3 0 {C_SN}
XMN1_op0_0000_rh_s0p1_r100k rbl_op0_0000_rh_s0p1_r100k ref_op0_0000_rh_s0p1_r100k vn_op0_0000_rh_s0p1_r100k 0 sky130_fd_pr__nfet_01v8 L=0.15 W=1 nf=1 ad=0.29 as=0.29 pd=2.58 ps=2.58 mult=1 m=1
XMN2_op0_0000_rh_s0p1_r100k ref_op0_0000_rh_s0p1_r100k rbl_op0_0000_rh_s0p1_r100k vn_op0_0000_rh_s0p1_r100k 0 sky130_fd_pr__nfet_01v8 L=0.15 W=1 nf=1 ad=0.29 as=0.29 pd=2.58 ps=2.58 mult=1 m=1
XMP1_op0_0000_rh_s0p1_r100k rbl_op0_0000_rh_s0p1_r100k ref_op0_0000_rh_s0p1_r100k vp_op0_0000_rh_s0p1_r100k vdd sky130_fd_pr__pfet_01v8 L=0.15 W=2 nf=1 ad=0.58 as=0.58 pd=4.58 ps=4.58 mult=1 m=1
XMP2_op0_0000_rh_s0p1_r100k ref_op0_0000_rh_s0p1_r100k rbl_op0_0000_rh_s0p1_r100k vp_op0_0000_rh_s0p1_r100k vdd sky130_fd_pr__pfet_01v8 L=0.15 W=2 nf=1 ad=0.58 as=0.58 pd=4.58 ps=4.58 mult=1 m=1
XMNF_op0_0000_rh_s0p1_r100k vn_op0_0000_rh_s0p1_r100k en_op0_0000_rh_s0p1_r100k 0 0 sky130_fd_pr__nfet_01v8 L=0.15 W=2 nf=1 ad=0.58 as=0.58 pd=4.58 ps=4.58 mult=1 m=1
XMPH_op0_0000_rh_s0p1_r100k vp_op0_0000_rh_s0p1_r100k enb_op0_0000_rh_s0p1_r100k vdd vdd sky130_fd_pr__pfet_01v8 L=0.15 W=4 nf=1 ad=1.16 as=1.16 pd=8.58 ps=8.58 mult=1 m=1
bd_op0_0000_rh_s0p1_r100k d_op0_0000_rh_s0p1_r100k 0 v=v(rbl_op0_0000_rh_s0p1_r100k)-v(ref_op0_0000_rh_s0p1_r100k)

* ---- instance 137: op1_0900_rh_s0p1_r300k (variant rh_s0p1_r300k; probe dec 11.9 ns, release 34 ns, meas 36 ns) ----
vctl_op1_0900_rh_s0p1_r300k ctl_op1_0900_rh_s0p1_r300k 0 pwl(0.0000e+00 {VDD} 2.0000e-09 {VDD} 2.1000e-09 0)
* RWL driver model (EXPERIMENTAL): slew 0.1 ns, series R 300000 ohm; cell pin = rwls_op1_0900_rh_s0p1_r300k
vrs_op1_0900_rh_s0p1_r300k rwlsrc_op1_0900_rh_s0p1_r300k 0 pwl(0.0000e+00 {VDD} 2.0000e-09 {VDD} 2.1000e-09 0 1.2000e-08 0 1.2100e-08 {VDD})
rdrv_op1_0900_rh_s0p1_r300k rwlsrc_op1_0900_rh_s0p1_r300k rwls_op1_0900_rh_s0p1_r300k 300000
ven_op1_0900_rh_s0p1_r300k en_op1_0900_rh_s0p1_r300k 0 pwl(0.0000e+00 0 1.1000e-08 0 1.1100e-08 {VDD} 3.4000e-08 {VDD} 3.4100e-08 0)
venb_op1_0900_rh_s0p1_r300k enb_op1_0900_rh_s0p1_r300k 0 pwl(0.0000e+00 {VDD} 1.1000e-08 {VDD} 1.1100e-08 0 3.4000e-08 0 3.4100e-08 {VDD})
vww_op1_0900_rh_s0p1_r300k wwl_op1_0900_rh_s0p1_r300k 0 pwl(0.0000e+00 0 1.2000e-08 0 1.2100e-08 {VDD} 3.2000e-08 {VDD} 3.2100e-08 0)
vwc_op1_0900_rh_s0p1_r300k wbc_op1_0900_rh_s0p1_r300k 0 pwl(0.0000e+00 0 1.2000e-08 0 1.2100e-08 {VDD} 3.4000e-08 {VDD} 3.4100e-08 0)
swb_op1_0900_rh_s0p1_r300k ref_op1_0900_rh_s0p1_r300k wbl_op1_0900_rh_s0p1_r300k wbc_op1_0900_rh_s0p1_r300k 0 swwbl
cwbl_op1_0900_rh_s0p1_r300k wbl_op1_0900_rh_s0p1_r300k 0 {C_WBL}
spa_op1_0900_rh_s0p1_r300k prea rbl_op1_0900_rh_s0p1_r300k ctl_op1_0900_rh_s0p1_r300k 0 swpre
spr_op1_0900_rh_s0p1_r300k pref ref_op1_0900_rh_s0p1_r300k ctl_op1_0900_rh_s0p1_r300k 0 swpre
crbl_op1_0900_rh_s0p1_r300k rbl_op1_0900_rh_s0p1_r300k 0 {C_RBL}
cref_op1_0900_rh_s0p1_r300k ref_op1_0900_rh_s0p1_r300k 0 {C_RBL}   $ ASSUMPTION: ideal matched dummy load
XMWR_op1_0900_rh_s0p1_r300k_0 sn_op1_0900_rh_s0p1_r300k_0 wwl_op1_0900_rh_s0p1_r300k wbl_op1_0900_rh_s0p1_r300k 0 sky130_fd_pr__nfet_01v8 L=0.15 W=0.42 nf=1 ad=0.1218 as=0.1218 pd=1.42 ps=1.42 nrd=0.69047619047619  nrs=0.69047619047619 sa=0 sb=0 sd=0 mult=1 m=1
XMRD_op1_0900_rh_s0p1_r300k_0 rbl_op1_0900_rh_s0p1_r300k sn_op1_0900_rh_s0p1_r300k_0 rwls_op1_0900_rh_s0p1_r300k 0 sky130_fd_pr__nfet_01v8 L=0.15 W=0.42 nf=1 ad=0.1218 as=0.1218 pd=1.42 ps=1.42 nrd=0.69047619047619  nrs=0.69047619047619 sa=0 sb=0 sd=0 mult=1 m=1
csn_op1_0900_rh_s0p1_r300k_0 sn_op1_0900_rh_s0p1_r300k_0 0 {C_SN}
XMWR_op1_0900_rh_s0p1_r300k_1 sn_op1_0900_rh_s0p1_r300k_1 wwl_des wbl_op1_0900_rh_s0p1_r300k 0 sky130_fd_pr__nfet_01v8 L=0.15 W=0.42 nf=1 ad=0.1218 as=0.1218 pd=1.42 ps=1.42 nrd=0.69047619047619  nrs=0.69047619047619 sa=0 sb=0 sd=0 mult=1 m=1
XMRD_op1_0900_rh_s0p1_r300k_1 rbl_op1_0900_rh_s0p1_r300k sn_op1_0900_rh_s0p1_r300k_1 rwl_des 0 sky130_fd_pr__nfet_01v8 L=0.15 W=0.42 nf=1 ad=0.1218 as=0.1218 pd=1.42 ps=1.42 nrd=0.69047619047619  nrs=0.69047619047619 sa=0 sb=0 sd=0 mult=1 m=1
csn_op1_0900_rh_s0p1_r300k_1 sn_op1_0900_rh_s0p1_r300k_1 0 {C_SN}
XMWR_op1_0900_rh_s0p1_r300k_2 sn_op1_0900_rh_s0p1_r300k_2 wwl_des wbl_op1_0900_rh_s0p1_r300k 0 sky130_fd_pr__nfet_01v8 L=0.15 W=0.42 nf=1 ad=0.1218 as=0.1218 pd=1.42 ps=1.42 nrd=0.69047619047619  nrs=0.69047619047619 sa=0 sb=0 sd=0 mult=1 m=1
XMRD_op1_0900_rh_s0p1_r300k_2 rbl_op1_0900_rh_s0p1_r300k sn_op1_0900_rh_s0p1_r300k_2 rwl_des 0 sky130_fd_pr__nfet_01v8 L=0.15 W=0.42 nf=1 ad=0.1218 as=0.1218 pd=1.42 ps=1.42 nrd=0.69047619047619  nrs=0.69047619047619 sa=0 sb=0 sd=0 mult=1 m=1
csn_op1_0900_rh_s0p1_r300k_2 sn_op1_0900_rh_s0p1_r300k_2 0 {C_SN}
XMWR_op1_0900_rh_s0p1_r300k_3 sn_op1_0900_rh_s0p1_r300k_3 wwl_des wbl_op1_0900_rh_s0p1_r300k 0 sky130_fd_pr__nfet_01v8 L=0.15 W=0.42 nf=1 ad=0.1218 as=0.1218 pd=1.42 ps=1.42 nrd=0.69047619047619  nrs=0.69047619047619 sa=0 sb=0 sd=0 mult=1 m=1
XMRD_op1_0900_rh_s0p1_r300k_3 rbl_op1_0900_rh_s0p1_r300k sn_op1_0900_rh_s0p1_r300k_3 rwl_des 0 sky130_fd_pr__nfet_01v8 L=0.15 W=0.42 nf=1 ad=0.1218 as=0.1218 pd=1.42 ps=1.42 nrd=0.69047619047619  nrs=0.69047619047619 sa=0 sb=0 sd=0 mult=1 m=1
csn_op1_0900_rh_s0p1_r300k_3 sn_op1_0900_rh_s0p1_r300k_3 0 {C_SN}
XMN1_op1_0900_rh_s0p1_r300k rbl_op1_0900_rh_s0p1_r300k ref_op1_0900_rh_s0p1_r300k vn_op1_0900_rh_s0p1_r300k 0 sky130_fd_pr__nfet_01v8 L=0.15 W=1 nf=1 ad=0.29 as=0.29 pd=2.58 ps=2.58 mult=1 m=1
XMN2_op1_0900_rh_s0p1_r300k ref_op1_0900_rh_s0p1_r300k rbl_op1_0900_rh_s0p1_r300k vn_op1_0900_rh_s0p1_r300k 0 sky130_fd_pr__nfet_01v8 L=0.15 W=1 nf=1 ad=0.29 as=0.29 pd=2.58 ps=2.58 mult=1 m=1
XMP1_op1_0900_rh_s0p1_r300k rbl_op1_0900_rh_s0p1_r300k ref_op1_0900_rh_s0p1_r300k vp_op1_0900_rh_s0p1_r300k vdd sky130_fd_pr__pfet_01v8 L=0.15 W=2 nf=1 ad=0.58 as=0.58 pd=4.58 ps=4.58 mult=1 m=1
XMP2_op1_0900_rh_s0p1_r300k ref_op1_0900_rh_s0p1_r300k rbl_op1_0900_rh_s0p1_r300k vp_op1_0900_rh_s0p1_r300k vdd sky130_fd_pr__pfet_01v8 L=0.15 W=2 nf=1 ad=0.58 as=0.58 pd=4.58 ps=4.58 mult=1 m=1
XMNF_op1_0900_rh_s0p1_r300k vn_op1_0900_rh_s0p1_r300k en_op1_0900_rh_s0p1_r300k 0 0 sky130_fd_pr__nfet_01v8 L=0.15 W=2 nf=1 ad=0.58 as=0.58 pd=4.58 ps=4.58 mult=1 m=1
XMPH_op1_0900_rh_s0p1_r300k vp_op1_0900_rh_s0p1_r300k enb_op1_0900_rh_s0p1_r300k vdd vdd sky130_fd_pr__pfet_01v8 L=0.15 W=4 nf=1 ad=1.16 as=1.16 pd=8.58 ps=8.58 mult=1 m=1
bd_op1_0900_rh_s0p1_r300k d_op1_0900_rh_s0p1_r300k 0 v=v(rbl_op1_0900_rh_s0p1_r300k)-v(ref_op1_0900_rh_s0p1_r300k)

* ---- instance 138: op1_1000_rh_s0p1_r300k (variant rh_s0p1_r300k; probe dec 11.9 ns, release 34 ns, meas 36 ns) ----
vctl_op1_1000_rh_s0p1_r300k ctl_op1_1000_rh_s0p1_r300k 0 pwl(0.0000e+00 {VDD} 2.0000e-09 {VDD} 2.1000e-09 0)
* RWL driver model (EXPERIMENTAL): slew 0.1 ns, series R 300000 ohm; cell pin = rwls_op1_1000_rh_s0p1_r300k
vrs_op1_1000_rh_s0p1_r300k rwlsrc_op1_1000_rh_s0p1_r300k 0 pwl(0.0000e+00 {VDD} 2.0000e-09 {VDD} 2.1000e-09 0 1.2000e-08 0 1.2100e-08 {VDD})
rdrv_op1_1000_rh_s0p1_r300k rwlsrc_op1_1000_rh_s0p1_r300k rwls_op1_1000_rh_s0p1_r300k 300000
ven_op1_1000_rh_s0p1_r300k en_op1_1000_rh_s0p1_r300k 0 pwl(0.0000e+00 0 1.1000e-08 0 1.1100e-08 {VDD} 3.4000e-08 {VDD} 3.4100e-08 0)
venb_op1_1000_rh_s0p1_r300k enb_op1_1000_rh_s0p1_r300k 0 pwl(0.0000e+00 {VDD} 1.1000e-08 {VDD} 1.1100e-08 0 3.4000e-08 0 3.4100e-08 {VDD})
vww_op1_1000_rh_s0p1_r300k wwl_op1_1000_rh_s0p1_r300k 0 pwl(0.0000e+00 0 1.2000e-08 0 1.2100e-08 {VDD} 3.2000e-08 {VDD} 3.2100e-08 0)
vwc_op1_1000_rh_s0p1_r300k wbc_op1_1000_rh_s0p1_r300k 0 pwl(0.0000e+00 0 1.2000e-08 0 1.2100e-08 {VDD} 3.4000e-08 {VDD} 3.4100e-08 0)
swb_op1_1000_rh_s0p1_r300k ref_op1_1000_rh_s0p1_r300k wbl_op1_1000_rh_s0p1_r300k wbc_op1_1000_rh_s0p1_r300k 0 swwbl
cwbl_op1_1000_rh_s0p1_r300k wbl_op1_1000_rh_s0p1_r300k 0 {C_WBL}
spa_op1_1000_rh_s0p1_r300k prea rbl_op1_1000_rh_s0p1_r300k ctl_op1_1000_rh_s0p1_r300k 0 swpre
spr_op1_1000_rh_s0p1_r300k pref ref_op1_1000_rh_s0p1_r300k ctl_op1_1000_rh_s0p1_r300k 0 swpre
crbl_op1_1000_rh_s0p1_r300k rbl_op1_1000_rh_s0p1_r300k 0 {C_RBL}
cref_op1_1000_rh_s0p1_r300k ref_op1_1000_rh_s0p1_r300k 0 {C_RBL}   $ ASSUMPTION: ideal matched dummy load
XMWR_op1_1000_rh_s0p1_r300k_0 sn_op1_1000_rh_s0p1_r300k_0 wwl_op1_1000_rh_s0p1_r300k wbl_op1_1000_rh_s0p1_r300k 0 sky130_fd_pr__nfet_01v8 L=0.15 W=0.42 nf=1 ad=0.1218 as=0.1218 pd=1.42 ps=1.42 nrd=0.69047619047619  nrs=0.69047619047619 sa=0 sb=0 sd=0 mult=1 m=1
XMRD_op1_1000_rh_s0p1_r300k_0 rbl_op1_1000_rh_s0p1_r300k sn_op1_1000_rh_s0p1_r300k_0 rwls_op1_1000_rh_s0p1_r300k 0 sky130_fd_pr__nfet_01v8 L=0.15 W=0.42 nf=1 ad=0.1218 as=0.1218 pd=1.42 ps=1.42 nrd=0.69047619047619  nrs=0.69047619047619 sa=0 sb=0 sd=0 mult=1 m=1
csn_op1_1000_rh_s0p1_r300k_0 sn_op1_1000_rh_s0p1_r300k_0 0 {C_SN}
XMWR_op1_1000_rh_s0p1_r300k_1 sn_op1_1000_rh_s0p1_r300k_1 wwl_des wbl_op1_1000_rh_s0p1_r300k 0 sky130_fd_pr__nfet_01v8 L=0.15 W=0.42 nf=1 ad=0.1218 as=0.1218 pd=1.42 ps=1.42 nrd=0.69047619047619  nrs=0.69047619047619 sa=0 sb=0 sd=0 mult=1 m=1
XMRD_op1_1000_rh_s0p1_r300k_1 rbl_op1_1000_rh_s0p1_r300k sn_op1_1000_rh_s0p1_r300k_1 rwl_des 0 sky130_fd_pr__nfet_01v8 L=0.15 W=0.42 nf=1 ad=0.1218 as=0.1218 pd=1.42 ps=1.42 nrd=0.69047619047619  nrs=0.69047619047619 sa=0 sb=0 sd=0 mult=1 m=1
csn_op1_1000_rh_s0p1_r300k_1 sn_op1_1000_rh_s0p1_r300k_1 0 {C_SN}
XMWR_op1_1000_rh_s0p1_r300k_2 sn_op1_1000_rh_s0p1_r300k_2 wwl_des wbl_op1_1000_rh_s0p1_r300k 0 sky130_fd_pr__nfet_01v8 L=0.15 W=0.42 nf=1 ad=0.1218 as=0.1218 pd=1.42 ps=1.42 nrd=0.69047619047619  nrs=0.69047619047619 sa=0 sb=0 sd=0 mult=1 m=1
XMRD_op1_1000_rh_s0p1_r300k_2 rbl_op1_1000_rh_s0p1_r300k sn_op1_1000_rh_s0p1_r300k_2 rwl_des 0 sky130_fd_pr__nfet_01v8 L=0.15 W=0.42 nf=1 ad=0.1218 as=0.1218 pd=1.42 ps=1.42 nrd=0.69047619047619  nrs=0.69047619047619 sa=0 sb=0 sd=0 mult=1 m=1
csn_op1_1000_rh_s0p1_r300k_2 sn_op1_1000_rh_s0p1_r300k_2 0 {C_SN}
XMWR_op1_1000_rh_s0p1_r300k_3 sn_op1_1000_rh_s0p1_r300k_3 wwl_des wbl_op1_1000_rh_s0p1_r300k 0 sky130_fd_pr__nfet_01v8 L=0.15 W=0.42 nf=1 ad=0.1218 as=0.1218 pd=1.42 ps=1.42 nrd=0.69047619047619  nrs=0.69047619047619 sa=0 sb=0 sd=0 mult=1 m=1
XMRD_op1_1000_rh_s0p1_r300k_3 rbl_op1_1000_rh_s0p1_r300k sn_op1_1000_rh_s0p1_r300k_3 rwl_des 0 sky130_fd_pr__nfet_01v8 L=0.15 W=0.42 nf=1 ad=0.1218 as=0.1218 pd=1.42 ps=1.42 nrd=0.69047619047619  nrs=0.69047619047619 sa=0 sb=0 sd=0 mult=1 m=1
csn_op1_1000_rh_s0p1_r300k_3 sn_op1_1000_rh_s0p1_r300k_3 0 {C_SN}
XMN1_op1_1000_rh_s0p1_r300k rbl_op1_1000_rh_s0p1_r300k ref_op1_1000_rh_s0p1_r300k vn_op1_1000_rh_s0p1_r300k 0 sky130_fd_pr__nfet_01v8 L=0.15 W=1 nf=1 ad=0.29 as=0.29 pd=2.58 ps=2.58 mult=1 m=1
XMN2_op1_1000_rh_s0p1_r300k ref_op1_1000_rh_s0p1_r300k rbl_op1_1000_rh_s0p1_r300k vn_op1_1000_rh_s0p1_r300k 0 sky130_fd_pr__nfet_01v8 L=0.15 W=1 nf=1 ad=0.29 as=0.29 pd=2.58 ps=2.58 mult=1 m=1
XMP1_op1_1000_rh_s0p1_r300k rbl_op1_1000_rh_s0p1_r300k ref_op1_1000_rh_s0p1_r300k vp_op1_1000_rh_s0p1_r300k vdd sky130_fd_pr__pfet_01v8 L=0.15 W=2 nf=1 ad=0.58 as=0.58 pd=4.58 ps=4.58 mult=1 m=1
XMP2_op1_1000_rh_s0p1_r300k ref_op1_1000_rh_s0p1_r300k rbl_op1_1000_rh_s0p1_r300k vp_op1_1000_rh_s0p1_r300k vdd sky130_fd_pr__pfet_01v8 L=0.15 W=2 nf=1 ad=0.58 as=0.58 pd=4.58 ps=4.58 mult=1 m=1
XMNF_op1_1000_rh_s0p1_r300k vn_op1_1000_rh_s0p1_r300k en_op1_1000_rh_s0p1_r300k 0 0 sky130_fd_pr__nfet_01v8 L=0.15 W=2 nf=1 ad=0.58 as=0.58 pd=4.58 ps=4.58 mult=1 m=1
XMPH_op1_1000_rh_s0p1_r300k vp_op1_1000_rh_s0p1_r300k enb_op1_1000_rh_s0p1_r300k vdd vdd sky130_fd_pr__pfet_01v8 L=0.15 W=4 nf=1 ad=1.16 as=1.16 pd=8.58 ps=8.58 mult=1 m=1
bd_op1_1000_rh_s0p1_r300k d_op1_1000_rh_s0p1_r300k 0 v=v(rbl_op1_1000_rh_s0p1_r300k)-v(ref_op1_1000_rh_s0p1_r300k)

* ---- instance 139: op0_n100_rh_s0p1_r300k (variant rh_s0p1_r300k; probe dec 11.9 ns, release 34 ns, meas 36 ns) ----
vctl_op0_n100_rh_s0p1_r300k ctl_op0_n100_rh_s0p1_r300k 0 pwl(0.0000e+00 {VDD} 2.0000e-09 {VDD} 2.1000e-09 0)
* RWL driver model (EXPERIMENTAL): slew 0.1 ns, series R 300000 ohm; cell pin = rwls_op0_n100_rh_s0p1_r300k
vrs_op0_n100_rh_s0p1_r300k rwlsrc_op0_n100_rh_s0p1_r300k 0 pwl(0.0000e+00 {VDD} 2.0000e-09 {VDD} 2.1000e-09 0 1.2000e-08 0 1.2100e-08 {VDD})
rdrv_op0_n100_rh_s0p1_r300k rwlsrc_op0_n100_rh_s0p1_r300k rwls_op0_n100_rh_s0p1_r300k 300000
ven_op0_n100_rh_s0p1_r300k en_op0_n100_rh_s0p1_r300k 0 pwl(0.0000e+00 0 1.1000e-08 0 1.1100e-08 {VDD} 3.4000e-08 {VDD} 3.4100e-08 0)
venb_op0_n100_rh_s0p1_r300k enb_op0_n100_rh_s0p1_r300k 0 pwl(0.0000e+00 {VDD} 1.1000e-08 {VDD} 1.1100e-08 0 3.4000e-08 0 3.4100e-08 {VDD})
vww_op0_n100_rh_s0p1_r300k wwl_op0_n100_rh_s0p1_r300k 0 pwl(0.0000e+00 0 1.2000e-08 0 1.2100e-08 {VDD} 3.2000e-08 {VDD} 3.2100e-08 0)
vwc_op0_n100_rh_s0p1_r300k wbc_op0_n100_rh_s0p1_r300k 0 pwl(0.0000e+00 0 1.2000e-08 0 1.2100e-08 {VDD} 3.4000e-08 {VDD} 3.4100e-08 0)
swb_op0_n100_rh_s0p1_r300k ref_op0_n100_rh_s0p1_r300k wbl_op0_n100_rh_s0p1_r300k wbc_op0_n100_rh_s0p1_r300k 0 swwbl
cwbl_op0_n100_rh_s0p1_r300k wbl_op0_n100_rh_s0p1_r300k 0 {C_WBL}
spa_op0_n100_rh_s0p1_r300k prea rbl_op0_n100_rh_s0p1_r300k ctl_op0_n100_rh_s0p1_r300k 0 swpre
spr_op0_n100_rh_s0p1_r300k pref ref_op0_n100_rh_s0p1_r300k ctl_op0_n100_rh_s0p1_r300k 0 swpre
crbl_op0_n100_rh_s0p1_r300k rbl_op0_n100_rh_s0p1_r300k 0 {C_RBL}
cref_op0_n100_rh_s0p1_r300k ref_op0_n100_rh_s0p1_r300k 0 {C_RBL}   $ ASSUMPTION: ideal matched dummy load
XMWR_op0_n100_rh_s0p1_r300k_0 sn_op0_n100_rh_s0p1_r300k_0 wwl_op0_n100_rh_s0p1_r300k wbl_op0_n100_rh_s0p1_r300k 0 sky130_fd_pr__nfet_01v8 L=0.15 W=0.42 nf=1 ad=0.1218 as=0.1218 pd=1.42 ps=1.42 nrd=0.69047619047619  nrs=0.69047619047619 sa=0 sb=0 sd=0 mult=1 m=1
XMRD_op0_n100_rh_s0p1_r300k_0 rbl_op0_n100_rh_s0p1_r300k sn_op0_n100_rh_s0p1_r300k_0 rwls_op0_n100_rh_s0p1_r300k 0 sky130_fd_pr__nfet_01v8 L=0.15 W=0.42 nf=1 ad=0.1218 as=0.1218 pd=1.42 ps=1.42 nrd=0.69047619047619  nrs=0.69047619047619 sa=0 sb=0 sd=0 mult=1 m=1
csn_op0_n100_rh_s0p1_r300k_0 sn_op0_n100_rh_s0p1_r300k_0 0 {C_SN}
XMWR_op0_n100_rh_s0p1_r300k_1 sn_op0_n100_rh_s0p1_r300k_1 wwl_des wbl_op0_n100_rh_s0p1_r300k 0 sky130_fd_pr__nfet_01v8 L=0.15 W=0.42 nf=1 ad=0.1218 as=0.1218 pd=1.42 ps=1.42 nrd=0.69047619047619  nrs=0.69047619047619 sa=0 sb=0 sd=0 mult=1 m=1
XMRD_op0_n100_rh_s0p1_r300k_1 rbl_op0_n100_rh_s0p1_r300k sn_op0_n100_rh_s0p1_r300k_1 rwl_des 0 sky130_fd_pr__nfet_01v8 L=0.15 W=0.42 nf=1 ad=0.1218 as=0.1218 pd=1.42 ps=1.42 nrd=0.69047619047619  nrs=0.69047619047619 sa=0 sb=0 sd=0 mult=1 m=1
csn_op0_n100_rh_s0p1_r300k_1 sn_op0_n100_rh_s0p1_r300k_1 0 {C_SN}
XMWR_op0_n100_rh_s0p1_r300k_2 sn_op0_n100_rh_s0p1_r300k_2 wwl_des wbl_op0_n100_rh_s0p1_r300k 0 sky130_fd_pr__nfet_01v8 L=0.15 W=0.42 nf=1 ad=0.1218 as=0.1218 pd=1.42 ps=1.42 nrd=0.69047619047619  nrs=0.69047619047619 sa=0 sb=0 sd=0 mult=1 m=1
XMRD_op0_n100_rh_s0p1_r300k_2 rbl_op0_n100_rh_s0p1_r300k sn_op0_n100_rh_s0p1_r300k_2 rwl_des 0 sky130_fd_pr__nfet_01v8 L=0.15 W=0.42 nf=1 ad=0.1218 as=0.1218 pd=1.42 ps=1.42 nrd=0.69047619047619  nrs=0.69047619047619 sa=0 sb=0 sd=0 mult=1 m=1
csn_op0_n100_rh_s0p1_r300k_2 sn_op0_n100_rh_s0p1_r300k_2 0 {C_SN}
XMWR_op0_n100_rh_s0p1_r300k_3 sn_op0_n100_rh_s0p1_r300k_3 wwl_des wbl_op0_n100_rh_s0p1_r300k 0 sky130_fd_pr__nfet_01v8 L=0.15 W=0.42 nf=1 ad=0.1218 as=0.1218 pd=1.42 ps=1.42 nrd=0.69047619047619  nrs=0.69047619047619 sa=0 sb=0 sd=0 mult=1 m=1
XMRD_op0_n100_rh_s0p1_r300k_3 rbl_op0_n100_rh_s0p1_r300k sn_op0_n100_rh_s0p1_r300k_3 rwl_des 0 sky130_fd_pr__nfet_01v8 L=0.15 W=0.42 nf=1 ad=0.1218 as=0.1218 pd=1.42 ps=1.42 nrd=0.69047619047619  nrs=0.69047619047619 sa=0 sb=0 sd=0 mult=1 m=1
csn_op0_n100_rh_s0p1_r300k_3 sn_op0_n100_rh_s0p1_r300k_3 0 {C_SN}
XMN1_op0_n100_rh_s0p1_r300k rbl_op0_n100_rh_s0p1_r300k ref_op0_n100_rh_s0p1_r300k vn_op0_n100_rh_s0p1_r300k 0 sky130_fd_pr__nfet_01v8 L=0.15 W=1 nf=1 ad=0.29 as=0.29 pd=2.58 ps=2.58 mult=1 m=1
XMN2_op0_n100_rh_s0p1_r300k ref_op0_n100_rh_s0p1_r300k rbl_op0_n100_rh_s0p1_r300k vn_op0_n100_rh_s0p1_r300k 0 sky130_fd_pr__nfet_01v8 L=0.15 W=1 nf=1 ad=0.29 as=0.29 pd=2.58 ps=2.58 mult=1 m=1
XMP1_op0_n100_rh_s0p1_r300k rbl_op0_n100_rh_s0p1_r300k ref_op0_n100_rh_s0p1_r300k vp_op0_n100_rh_s0p1_r300k vdd sky130_fd_pr__pfet_01v8 L=0.15 W=2 nf=1 ad=0.58 as=0.58 pd=4.58 ps=4.58 mult=1 m=1
XMP2_op0_n100_rh_s0p1_r300k ref_op0_n100_rh_s0p1_r300k rbl_op0_n100_rh_s0p1_r300k vp_op0_n100_rh_s0p1_r300k vdd sky130_fd_pr__pfet_01v8 L=0.15 W=2 nf=1 ad=0.58 as=0.58 pd=4.58 ps=4.58 mult=1 m=1
XMNF_op0_n100_rh_s0p1_r300k vn_op0_n100_rh_s0p1_r300k en_op0_n100_rh_s0p1_r300k 0 0 sky130_fd_pr__nfet_01v8 L=0.15 W=2 nf=1 ad=0.58 as=0.58 pd=4.58 ps=4.58 mult=1 m=1
XMPH_op0_n100_rh_s0p1_r300k vp_op0_n100_rh_s0p1_r300k enb_op0_n100_rh_s0p1_r300k vdd vdd sky130_fd_pr__pfet_01v8 L=0.15 W=4 nf=1 ad=1.16 as=1.16 pd=8.58 ps=8.58 mult=1 m=1
bd_op0_n100_rh_s0p1_r300k d_op0_n100_rh_s0p1_r300k 0 v=v(rbl_op0_n100_rh_s0p1_r300k)-v(ref_op0_n100_rh_s0p1_r300k)

* ---- instance 140: op0_0000_rh_s0p1_r300k (variant rh_s0p1_r300k; probe dec 11.9 ns, release 34 ns, meas 36 ns) ----
vctl_op0_0000_rh_s0p1_r300k ctl_op0_0000_rh_s0p1_r300k 0 pwl(0.0000e+00 {VDD} 2.0000e-09 {VDD} 2.1000e-09 0)
* RWL driver model (EXPERIMENTAL): slew 0.1 ns, series R 300000 ohm; cell pin = rwls_op0_0000_rh_s0p1_r300k
vrs_op0_0000_rh_s0p1_r300k rwlsrc_op0_0000_rh_s0p1_r300k 0 pwl(0.0000e+00 {VDD} 2.0000e-09 {VDD} 2.1000e-09 0 1.2000e-08 0 1.2100e-08 {VDD})
rdrv_op0_0000_rh_s0p1_r300k rwlsrc_op0_0000_rh_s0p1_r300k rwls_op0_0000_rh_s0p1_r300k 300000
ven_op0_0000_rh_s0p1_r300k en_op0_0000_rh_s0p1_r300k 0 pwl(0.0000e+00 0 1.1000e-08 0 1.1100e-08 {VDD} 3.4000e-08 {VDD} 3.4100e-08 0)
venb_op0_0000_rh_s0p1_r300k enb_op0_0000_rh_s0p1_r300k 0 pwl(0.0000e+00 {VDD} 1.1000e-08 {VDD} 1.1100e-08 0 3.4000e-08 0 3.4100e-08 {VDD})
vww_op0_0000_rh_s0p1_r300k wwl_op0_0000_rh_s0p1_r300k 0 pwl(0.0000e+00 0 1.2000e-08 0 1.2100e-08 {VDD} 3.2000e-08 {VDD} 3.2100e-08 0)
vwc_op0_0000_rh_s0p1_r300k wbc_op0_0000_rh_s0p1_r300k 0 pwl(0.0000e+00 0 1.2000e-08 0 1.2100e-08 {VDD} 3.4000e-08 {VDD} 3.4100e-08 0)
swb_op0_0000_rh_s0p1_r300k ref_op0_0000_rh_s0p1_r300k wbl_op0_0000_rh_s0p1_r300k wbc_op0_0000_rh_s0p1_r300k 0 swwbl
cwbl_op0_0000_rh_s0p1_r300k wbl_op0_0000_rh_s0p1_r300k 0 {C_WBL}
spa_op0_0000_rh_s0p1_r300k prea rbl_op0_0000_rh_s0p1_r300k ctl_op0_0000_rh_s0p1_r300k 0 swpre
spr_op0_0000_rh_s0p1_r300k pref ref_op0_0000_rh_s0p1_r300k ctl_op0_0000_rh_s0p1_r300k 0 swpre
crbl_op0_0000_rh_s0p1_r300k rbl_op0_0000_rh_s0p1_r300k 0 {C_RBL}
cref_op0_0000_rh_s0p1_r300k ref_op0_0000_rh_s0p1_r300k 0 {C_RBL}   $ ASSUMPTION: ideal matched dummy load
XMWR_op0_0000_rh_s0p1_r300k_0 sn_op0_0000_rh_s0p1_r300k_0 wwl_op0_0000_rh_s0p1_r300k wbl_op0_0000_rh_s0p1_r300k 0 sky130_fd_pr__nfet_01v8 L=0.15 W=0.42 nf=1 ad=0.1218 as=0.1218 pd=1.42 ps=1.42 nrd=0.69047619047619  nrs=0.69047619047619 sa=0 sb=0 sd=0 mult=1 m=1
XMRD_op0_0000_rh_s0p1_r300k_0 rbl_op0_0000_rh_s0p1_r300k sn_op0_0000_rh_s0p1_r300k_0 rwls_op0_0000_rh_s0p1_r300k 0 sky130_fd_pr__nfet_01v8 L=0.15 W=0.42 nf=1 ad=0.1218 as=0.1218 pd=1.42 ps=1.42 nrd=0.69047619047619  nrs=0.69047619047619 sa=0 sb=0 sd=0 mult=1 m=1
csn_op0_0000_rh_s0p1_r300k_0 sn_op0_0000_rh_s0p1_r300k_0 0 {C_SN}
XMWR_op0_0000_rh_s0p1_r300k_1 sn_op0_0000_rh_s0p1_r300k_1 wwl_des wbl_op0_0000_rh_s0p1_r300k 0 sky130_fd_pr__nfet_01v8 L=0.15 W=0.42 nf=1 ad=0.1218 as=0.1218 pd=1.42 ps=1.42 nrd=0.69047619047619  nrs=0.69047619047619 sa=0 sb=0 sd=0 mult=1 m=1
XMRD_op0_0000_rh_s0p1_r300k_1 rbl_op0_0000_rh_s0p1_r300k sn_op0_0000_rh_s0p1_r300k_1 rwl_des 0 sky130_fd_pr__nfet_01v8 L=0.15 W=0.42 nf=1 ad=0.1218 as=0.1218 pd=1.42 ps=1.42 nrd=0.69047619047619  nrs=0.69047619047619 sa=0 sb=0 sd=0 mult=1 m=1
csn_op0_0000_rh_s0p1_r300k_1 sn_op0_0000_rh_s0p1_r300k_1 0 {C_SN}
XMWR_op0_0000_rh_s0p1_r300k_2 sn_op0_0000_rh_s0p1_r300k_2 wwl_des wbl_op0_0000_rh_s0p1_r300k 0 sky130_fd_pr__nfet_01v8 L=0.15 W=0.42 nf=1 ad=0.1218 as=0.1218 pd=1.42 ps=1.42 nrd=0.69047619047619  nrs=0.69047619047619 sa=0 sb=0 sd=0 mult=1 m=1
XMRD_op0_0000_rh_s0p1_r300k_2 rbl_op0_0000_rh_s0p1_r300k sn_op0_0000_rh_s0p1_r300k_2 rwl_des 0 sky130_fd_pr__nfet_01v8 L=0.15 W=0.42 nf=1 ad=0.1218 as=0.1218 pd=1.42 ps=1.42 nrd=0.69047619047619  nrs=0.69047619047619 sa=0 sb=0 sd=0 mult=1 m=1
csn_op0_0000_rh_s0p1_r300k_2 sn_op0_0000_rh_s0p1_r300k_2 0 {C_SN}
XMWR_op0_0000_rh_s0p1_r300k_3 sn_op0_0000_rh_s0p1_r300k_3 wwl_des wbl_op0_0000_rh_s0p1_r300k 0 sky130_fd_pr__nfet_01v8 L=0.15 W=0.42 nf=1 ad=0.1218 as=0.1218 pd=1.42 ps=1.42 nrd=0.69047619047619  nrs=0.69047619047619 sa=0 sb=0 sd=0 mult=1 m=1
XMRD_op0_0000_rh_s0p1_r300k_3 rbl_op0_0000_rh_s0p1_r300k sn_op0_0000_rh_s0p1_r300k_3 rwl_des 0 sky130_fd_pr__nfet_01v8 L=0.15 W=0.42 nf=1 ad=0.1218 as=0.1218 pd=1.42 ps=1.42 nrd=0.69047619047619  nrs=0.69047619047619 sa=0 sb=0 sd=0 mult=1 m=1
csn_op0_0000_rh_s0p1_r300k_3 sn_op0_0000_rh_s0p1_r300k_3 0 {C_SN}
XMN1_op0_0000_rh_s0p1_r300k rbl_op0_0000_rh_s0p1_r300k ref_op0_0000_rh_s0p1_r300k vn_op0_0000_rh_s0p1_r300k 0 sky130_fd_pr__nfet_01v8 L=0.15 W=1 nf=1 ad=0.29 as=0.29 pd=2.58 ps=2.58 mult=1 m=1
XMN2_op0_0000_rh_s0p1_r300k ref_op0_0000_rh_s0p1_r300k rbl_op0_0000_rh_s0p1_r300k vn_op0_0000_rh_s0p1_r300k 0 sky130_fd_pr__nfet_01v8 L=0.15 W=1 nf=1 ad=0.29 as=0.29 pd=2.58 ps=2.58 mult=1 m=1
XMP1_op0_0000_rh_s0p1_r300k rbl_op0_0000_rh_s0p1_r300k ref_op0_0000_rh_s0p1_r300k vp_op0_0000_rh_s0p1_r300k vdd sky130_fd_pr__pfet_01v8 L=0.15 W=2 nf=1 ad=0.58 as=0.58 pd=4.58 ps=4.58 mult=1 m=1
XMP2_op0_0000_rh_s0p1_r300k ref_op0_0000_rh_s0p1_r300k rbl_op0_0000_rh_s0p1_r300k vp_op0_0000_rh_s0p1_r300k vdd sky130_fd_pr__pfet_01v8 L=0.15 W=2 nf=1 ad=0.58 as=0.58 pd=4.58 ps=4.58 mult=1 m=1
XMNF_op0_0000_rh_s0p1_r300k vn_op0_0000_rh_s0p1_r300k en_op0_0000_rh_s0p1_r300k 0 0 sky130_fd_pr__nfet_01v8 L=0.15 W=2 nf=1 ad=0.58 as=0.58 pd=4.58 ps=4.58 mult=1 m=1
XMPH_op0_0000_rh_s0p1_r300k vp_op0_0000_rh_s0p1_r300k enb_op0_0000_rh_s0p1_r300k vdd vdd sky130_fd_pr__pfet_01v8 L=0.15 W=4 nf=1 ad=1.16 as=1.16 pd=8.58 ps=8.58 mult=1 m=1
bd_op0_0000_rh_s0p1_r300k d_op0_0000_rh_s0p1_r300k 0 v=v(rbl_op0_0000_rh_s0p1_r300k)-v(ref_op0_0000_rh_s0p1_r300k)

* ---- instance 141: op1_0900_rh_s0p1_r1000k (variant rh_s0p1_r1000k; probe dec 11.9 ns, release 34 ns, meas 36 ns) ----
vctl_op1_0900_rh_s0p1_r1000k ctl_op1_0900_rh_s0p1_r1000k 0 pwl(0.0000e+00 {VDD} 2.0000e-09 {VDD} 2.1000e-09 0)
* RWL driver model (EXPERIMENTAL): slew 0.1 ns, series R 1e+06 ohm; cell pin = rwls_op1_0900_rh_s0p1_r1000k
vrs_op1_0900_rh_s0p1_r1000k rwlsrc_op1_0900_rh_s0p1_r1000k 0 pwl(0.0000e+00 {VDD} 2.0000e-09 {VDD} 2.1000e-09 0 1.2000e-08 0 1.2100e-08 {VDD})
rdrv_op1_0900_rh_s0p1_r1000k rwlsrc_op1_0900_rh_s0p1_r1000k rwls_op1_0900_rh_s0p1_r1000k 1e+06
ven_op1_0900_rh_s0p1_r1000k en_op1_0900_rh_s0p1_r1000k 0 pwl(0.0000e+00 0 1.1000e-08 0 1.1100e-08 {VDD} 3.4000e-08 {VDD} 3.4100e-08 0)
venb_op1_0900_rh_s0p1_r1000k enb_op1_0900_rh_s0p1_r1000k 0 pwl(0.0000e+00 {VDD} 1.1000e-08 {VDD} 1.1100e-08 0 3.4000e-08 0 3.4100e-08 {VDD})
vww_op1_0900_rh_s0p1_r1000k wwl_op1_0900_rh_s0p1_r1000k 0 pwl(0.0000e+00 0 1.2000e-08 0 1.2100e-08 {VDD} 3.2000e-08 {VDD} 3.2100e-08 0)
vwc_op1_0900_rh_s0p1_r1000k wbc_op1_0900_rh_s0p1_r1000k 0 pwl(0.0000e+00 0 1.2000e-08 0 1.2100e-08 {VDD} 3.4000e-08 {VDD} 3.4100e-08 0)
swb_op1_0900_rh_s0p1_r1000k ref_op1_0900_rh_s0p1_r1000k wbl_op1_0900_rh_s0p1_r1000k wbc_op1_0900_rh_s0p1_r1000k 0 swwbl
cwbl_op1_0900_rh_s0p1_r1000k wbl_op1_0900_rh_s0p1_r1000k 0 {C_WBL}
spa_op1_0900_rh_s0p1_r1000k prea rbl_op1_0900_rh_s0p1_r1000k ctl_op1_0900_rh_s0p1_r1000k 0 swpre
spr_op1_0900_rh_s0p1_r1000k pref ref_op1_0900_rh_s0p1_r1000k ctl_op1_0900_rh_s0p1_r1000k 0 swpre
crbl_op1_0900_rh_s0p1_r1000k rbl_op1_0900_rh_s0p1_r1000k 0 {C_RBL}
cref_op1_0900_rh_s0p1_r1000k ref_op1_0900_rh_s0p1_r1000k 0 {C_RBL}   $ ASSUMPTION: ideal matched dummy load
XMWR_op1_0900_rh_s0p1_r1000k_0 sn_op1_0900_rh_s0p1_r1000k_0 wwl_op1_0900_rh_s0p1_r1000k wbl_op1_0900_rh_s0p1_r1000k 0 sky130_fd_pr__nfet_01v8 L=0.15 W=0.42 nf=1 ad=0.1218 as=0.1218 pd=1.42 ps=1.42 nrd=0.69047619047619  nrs=0.69047619047619 sa=0 sb=0 sd=0 mult=1 m=1
XMRD_op1_0900_rh_s0p1_r1000k_0 rbl_op1_0900_rh_s0p1_r1000k sn_op1_0900_rh_s0p1_r1000k_0 rwls_op1_0900_rh_s0p1_r1000k 0 sky130_fd_pr__nfet_01v8 L=0.15 W=0.42 nf=1 ad=0.1218 as=0.1218 pd=1.42 ps=1.42 nrd=0.69047619047619  nrs=0.69047619047619 sa=0 sb=0 sd=0 mult=1 m=1
csn_op1_0900_rh_s0p1_r1000k_0 sn_op1_0900_rh_s0p1_r1000k_0 0 {C_SN}
XMWR_op1_0900_rh_s0p1_r1000k_1 sn_op1_0900_rh_s0p1_r1000k_1 wwl_des wbl_op1_0900_rh_s0p1_r1000k 0 sky130_fd_pr__nfet_01v8 L=0.15 W=0.42 nf=1 ad=0.1218 as=0.1218 pd=1.42 ps=1.42 nrd=0.69047619047619  nrs=0.69047619047619 sa=0 sb=0 sd=0 mult=1 m=1
XMRD_op1_0900_rh_s0p1_r1000k_1 rbl_op1_0900_rh_s0p1_r1000k sn_op1_0900_rh_s0p1_r1000k_1 rwl_des 0 sky130_fd_pr__nfet_01v8 L=0.15 W=0.42 nf=1 ad=0.1218 as=0.1218 pd=1.42 ps=1.42 nrd=0.69047619047619  nrs=0.69047619047619 sa=0 sb=0 sd=0 mult=1 m=1
csn_op1_0900_rh_s0p1_r1000k_1 sn_op1_0900_rh_s0p1_r1000k_1 0 {C_SN}
XMWR_op1_0900_rh_s0p1_r1000k_2 sn_op1_0900_rh_s0p1_r1000k_2 wwl_des wbl_op1_0900_rh_s0p1_r1000k 0 sky130_fd_pr__nfet_01v8 L=0.15 W=0.42 nf=1 ad=0.1218 as=0.1218 pd=1.42 ps=1.42 nrd=0.69047619047619  nrs=0.69047619047619 sa=0 sb=0 sd=0 mult=1 m=1
XMRD_op1_0900_rh_s0p1_r1000k_2 rbl_op1_0900_rh_s0p1_r1000k sn_op1_0900_rh_s0p1_r1000k_2 rwl_des 0 sky130_fd_pr__nfet_01v8 L=0.15 W=0.42 nf=1 ad=0.1218 as=0.1218 pd=1.42 ps=1.42 nrd=0.69047619047619  nrs=0.69047619047619 sa=0 sb=0 sd=0 mult=1 m=1
csn_op1_0900_rh_s0p1_r1000k_2 sn_op1_0900_rh_s0p1_r1000k_2 0 {C_SN}
XMWR_op1_0900_rh_s0p1_r1000k_3 sn_op1_0900_rh_s0p1_r1000k_3 wwl_des wbl_op1_0900_rh_s0p1_r1000k 0 sky130_fd_pr__nfet_01v8 L=0.15 W=0.42 nf=1 ad=0.1218 as=0.1218 pd=1.42 ps=1.42 nrd=0.69047619047619  nrs=0.69047619047619 sa=0 sb=0 sd=0 mult=1 m=1
XMRD_op1_0900_rh_s0p1_r1000k_3 rbl_op1_0900_rh_s0p1_r1000k sn_op1_0900_rh_s0p1_r1000k_3 rwl_des 0 sky130_fd_pr__nfet_01v8 L=0.15 W=0.42 nf=1 ad=0.1218 as=0.1218 pd=1.42 ps=1.42 nrd=0.69047619047619  nrs=0.69047619047619 sa=0 sb=0 sd=0 mult=1 m=1
csn_op1_0900_rh_s0p1_r1000k_3 sn_op1_0900_rh_s0p1_r1000k_3 0 {C_SN}
XMN1_op1_0900_rh_s0p1_r1000k rbl_op1_0900_rh_s0p1_r1000k ref_op1_0900_rh_s0p1_r1000k vn_op1_0900_rh_s0p1_r1000k 0 sky130_fd_pr__nfet_01v8 L=0.15 W=1 nf=1 ad=0.29 as=0.29 pd=2.58 ps=2.58 mult=1 m=1
XMN2_op1_0900_rh_s0p1_r1000k ref_op1_0900_rh_s0p1_r1000k rbl_op1_0900_rh_s0p1_r1000k vn_op1_0900_rh_s0p1_r1000k 0 sky130_fd_pr__nfet_01v8 L=0.15 W=1 nf=1 ad=0.29 as=0.29 pd=2.58 ps=2.58 mult=1 m=1
XMP1_op1_0900_rh_s0p1_r1000k rbl_op1_0900_rh_s0p1_r1000k ref_op1_0900_rh_s0p1_r1000k vp_op1_0900_rh_s0p1_r1000k vdd sky130_fd_pr__pfet_01v8 L=0.15 W=2 nf=1 ad=0.58 as=0.58 pd=4.58 ps=4.58 mult=1 m=1
XMP2_op1_0900_rh_s0p1_r1000k ref_op1_0900_rh_s0p1_r1000k rbl_op1_0900_rh_s0p1_r1000k vp_op1_0900_rh_s0p1_r1000k vdd sky130_fd_pr__pfet_01v8 L=0.15 W=2 nf=1 ad=0.58 as=0.58 pd=4.58 ps=4.58 mult=1 m=1
XMNF_op1_0900_rh_s0p1_r1000k vn_op1_0900_rh_s0p1_r1000k en_op1_0900_rh_s0p1_r1000k 0 0 sky130_fd_pr__nfet_01v8 L=0.15 W=2 nf=1 ad=0.58 as=0.58 pd=4.58 ps=4.58 mult=1 m=1
XMPH_op1_0900_rh_s0p1_r1000k vp_op1_0900_rh_s0p1_r1000k enb_op1_0900_rh_s0p1_r1000k vdd vdd sky130_fd_pr__pfet_01v8 L=0.15 W=4 nf=1 ad=1.16 as=1.16 pd=8.58 ps=8.58 mult=1 m=1
bd_op1_0900_rh_s0p1_r1000k d_op1_0900_rh_s0p1_r1000k 0 v=v(rbl_op1_0900_rh_s0p1_r1000k)-v(ref_op1_0900_rh_s0p1_r1000k)

* ---- instance 142: op1_1000_rh_s0p1_r1000k (variant rh_s0p1_r1000k; probe dec 11.9 ns, release 34 ns, meas 36 ns) ----
vctl_op1_1000_rh_s0p1_r1000k ctl_op1_1000_rh_s0p1_r1000k 0 pwl(0.0000e+00 {VDD} 2.0000e-09 {VDD} 2.1000e-09 0)
* RWL driver model (EXPERIMENTAL): slew 0.1 ns, series R 1e+06 ohm; cell pin = rwls_op1_1000_rh_s0p1_r1000k
vrs_op1_1000_rh_s0p1_r1000k rwlsrc_op1_1000_rh_s0p1_r1000k 0 pwl(0.0000e+00 {VDD} 2.0000e-09 {VDD} 2.1000e-09 0 1.2000e-08 0 1.2100e-08 {VDD})
rdrv_op1_1000_rh_s0p1_r1000k rwlsrc_op1_1000_rh_s0p1_r1000k rwls_op1_1000_rh_s0p1_r1000k 1e+06
ven_op1_1000_rh_s0p1_r1000k en_op1_1000_rh_s0p1_r1000k 0 pwl(0.0000e+00 0 1.1000e-08 0 1.1100e-08 {VDD} 3.4000e-08 {VDD} 3.4100e-08 0)
venb_op1_1000_rh_s0p1_r1000k enb_op1_1000_rh_s0p1_r1000k 0 pwl(0.0000e+00 {VDD} 1.1000e-08 {VDD} 1.1100e-08 0 3.4000e-08 0 3.4100e-08 {VDD})
vww_op1_1000_rh_s0p1_r1000k wwl_op1_1000_rh_s0p1_r1000k 0 pwl(0.0000e+00 0 1.2000e-08 0 1.2100e-08 {VDD} 3.2000e-08 {VDD} 3.2100e-08 0)
vwc_op1_1000_rh_s0p1_r1000k wbc_op1_1000_rh_s0p1_r1000k 0 pwl(0.0000e+00 0 1.2000e-08 0 1.2100e-08 {VDD} 3.4000e-08 {VDD} 3.4100e-08 0)
swb_op1_1000_rh_s0p1_r1000k ref_op1_1000_rh_s0p1_r1000k wbl_op1_1000_rh_s0p1_r1000k wbc_op1_1000_rh_s0p1_r1000k 0 swwbl
cwbl_op1_1000_rh_s0p1_r1000k wbl_op1_1000_rh_s0p1_r1000k 0 {C_WBL}
spa_op1_1000_rh_s0p1_r1000k prea rbl_op1_1000_rh_s0p1_r1000k ctl_op1_1000_rh_s0p1_r1000k 0 swpre
spr_op1_1000_rh_s0p1_r1000k pref ref_op1_1000_rh_s0p1_r1000k ctl_op1_1000_rh_s0p1_r1000k 0 swpre
crbl_op1_1000_rh_s0p1_r1000k rbl_op1_1000_rh_s0p1_r1000k 0 {C_RBL}
cref_op1_1000_rh_s0p1_r1000k ref_op1_1000_rh_s0p1_r1000k 0 {C_RBL}   $ ASSUMPTION: ideal matched dummy load
XMWR_op1_1000_rh_s0p1_r1000k_0 sn_op1_1000_rh_s0p1_r1000k_0 wwl_op1_1000_rh_s0p1_r1000k wbl_op1_1000_rh_s0p1_r1000k 0 sky130_fd_pr__nfet_01v8 L=0.15 W=0.42 nf=1 ad=0.1218 as=0.1218 pd=1.42 ps=1.42 nrd=0.69047619047619  nrs=0.69047619047619 sa=0 sb=0 sd=0 mult=1 m=1
XMRD_op1_1000_rh_s0p1_r1000k_0 rbl_op1_1000_rh_s0p1_r1000k sn_op1_1000_rh_s0p1_r1000k_0 rwls_op1_1000_rh_s0p1_r1000k 0 sky130_fd_pr__nfet_01v8 L=0.15 W=0.42 nf=1 ad=0.1218 as=0.1218 pd=1.42 ps=1.42 nrd=0.69047619047619  nrs=0.69047619047619 sa=0 sb=0 sd=0 mult=1 m=1
csn_op1_1000_rh_s0p1_r1000k_0 sn_op1_1000_rh_s0p1_r1000k_0 0 {C_SN}
XMWR_op1_1000_rh_s0p1_r1000k_1 sn_op1_1000_rh_s0p1_r1000k_1 wwl_des wbl_op1_1000_rh_s0p1_r1000k 0 sky130_fd_pr__nfet_01v8 L=0.15 W=0.42 nf=1 ad=0.1218 as=0.1218 pd=1.42 ps=1.42 nrd=0.69047619047619  nrs=0.69047619047619 sa=0 sb=0 sd=0 mult=1 m=1
XMRD_op1_1000_rh_s0p1_r1000k_1 rbl_op1_1000_rh_s0p1_r1000k sn_op1_1000_rh_s0p1_r1000k_1 rwl_des 0 sky130_fd_pr__nfet_01v8 L=0.15 W=0.42 nf=1 ad=0.1218 as=0.1218 pd=1.42 ps=1.42 nrd=0.69047619047619  nrs=0.69047619047619 sa=0 sb=0 sd=0 mult=1 m=1
csn_op1_1000_rh_s0p1_r1000k_1 sn_op1_1000_rh_s0p1_r1000k_1 0 {C_SN}
XMWR_op1_1000_rh_s0p1_r1000k_2 sn_op1_1000_rh_s0p1_r1000k_2 wwl_des wbl_op1_1000_rh_s0p1_r1000k 0 sky130_fd_pr__nfet_01v8 L=0.15 W=0.42 nf=1 ad=0.1218 as=0.1218 pd=1.42 ps=1.42 nrd=0.69047619047619  nrs=0.69047619047619 sa=0 sb=0 sd=0 mult=1 m=1
XMRD_op1_1000_rh_s0p1_r1000k_2 rbl_op1_1000_rh_s0p1_r1000k sn_op1_1000_rh_s0p1_r1000k_2 rwl_des 0 sky130_fd_pr__nfet_01v8 L=0.15 W=0.42 nf=1 ad=0.1218 as=0.1218 pd=1.42 ps=1.42 nrd=0.69047619047619  nrs=0.69047619047619 sa=0 sb=0 sd=0 mult=1 m=1
csn_op1_1000_rh_s0p1_r1000k_2 sn_op1_1000_rh_s0p1_r1000k_2 0 {C_SN}
XMWR_op1_1000_rh_s0p1_r1000k_3 sn_op1_1000_rh_s0p1_r1000k_3 wwl_des wbl_op1_1000_rh_s0p1_r1000k 0 sky130_fd_pr__nfet_01v8 L=0.15 W=0.42 nf=1 ad=0.1218 as=0.1218 pd=1.42 ps=1.42 nrd=0.69047619047619  nrs=0.69047619047619 sa=0 sb=0 sd=0 mult=1 m=1
XMRD_op1_1000_rh_s0p1_r1000k_3 rbl_op1_1000_rh_s0p1_r1000k sn_op1_1000_rh_s0p1_r1000k_3 rwl_des 0 sky130_fd_pr__nfet_01v8 L=0.15 W=0.42 nf=1 ad=0.1218 as=0.1218 pd=1.42 ps=1.42 nrd=0.69047619047619  nrs=0.69047619047619 sa=0 sb=0 sd=0 mult=1 m=1
csn_op1_1000_rh_s0p1_r1000k_3 sn_op1_1000_rh_s0p1_r1000k_3 0 {C_SN}
XMN1_op1_1000_rh_s0p1_r1000k rbl_op1_1000_rh_s0p1_r1000k ref_op1_1000_rh_s0p1_r1000k vn_op1_1000_rh_s0p1_r1000k 0 sky130_fd_pr__nfet_01v8 L=0.15 W=1 nf=1 ad=0.29 as=0.29 pd=2.58 ps=2.58 mult=1 m=1
XMN2_op1_1000_rh_s0p1_r1000k ref_op1_1000_rh_s0p1_r1000k rbl_op1_1000_rh_s0p1_r1000k vn_op1_1000_rh_s0p1_r1000k 0 sky130_fd_pr__nfet_01v8 L=0.15 W=1 nf=1 ad=0.29 as=0.29 pd=2.58 ps=2.58 mult=1 m=1
XMP1_op1_1000_rh_s0p1_r1000k rbl_op1_1000_rh_s0p1_r1000k ref_op1_1000_rh_s0p1_r1000k vp_op1_1000_rh_s0p1_r1000k vdd sky130_fd_pr__pfet_01v8 L=0.15 W=2 nf=1 ad=0.58 as=0.58 pd=4.58 ps=4.58 mult=1 m=1
XMP2_op1_1000_rh_s0p1_r1000k ref_op1_1000_rh_s0p1_r1000k rbl_op1_1000_rh_s0p1_r1000k vp_op1_1000_rh_s0p1_r1000k vdd sky130_fd_pr__pfet_01v8 L=0.15 W=2 nf=1 ad=0.58 as=0.58 pd=4.58 ps=4.58 mult=1 m=1
XMNF_op1_1000_rh_s0p1_r1000k vn_op1_1000_rh_s0p1_r1000k en_op1_1000_rh_s0p1_r1000k 0 0 sky130_fd_pr__nfet_01v8 L=0.15 W=2 nf=1 ad=0.58 as=0.58 pd=4.58 ps=4.58 mult=1 m=1
XMPH_op1_1000_rh_s0p1_r1000k vp_op1_1000_rh_s0p1_r1000k enb_op1_1000_rh_s0p1_r1000k vdd vdd sky130_fd_pr__pfet_01v8 L=0.15 W=4 nf=1 ad=1.16 as=1.16 pd=8.58 ps=8.58 mult=1 m=1
bd_op1_1000_rh_s0p1_r1000k d_op1_1000_rh_s0p1_r1000k 0 v=v(rbl_op1_1000_rh_s0p1_r1000k)-v(ref_op1_1000_rh_s0p1_r1000k)

* ---- instance 143: op0_n100_rh_s0p1_r1000k (variant rh_s0p1_r1000k; probe dec 11.9 ns, release 34 ns, meas 36 ns) ----
vctl_op0_n100_rh_s0p1_r1000k ctl_op0_n100_rh_s0p1_r1000k 0 pwl(0.0000e+00 {VDD} 2.0000e-09 {VDD} 2.1000e-09 0)
* RWL driver model (EXPERIMENTAL): slew 0.1 ns, series R 1e+06 ohm; cell pin = rwls_op0_n100_rh_s0p1_r1000k
vrs_op0_n100_rh_s0p1_r1000k rwlsrc_op0_n100_rh_s0p1_r1000k 0 pwl(0.0000e+00 {VDD} 2.0000e-09 {VDD} 2.1000e-09 0 1.2000e-08 0 1.2100e-08 {VDD})
rdrv_op0_n100_rh_s0p1_r1000k rwlsrc_op0_n100_rh_s0p1_r1000k rwls_op0_n100_rh_s0p1_r1000k 1e+06
ven_op0_n100_rh_s0p1_r1000k en_op0_n100_rh_s0p1_r1000k 0 pwl(0.0000e+00 0 1.1000e-08 0 1.1100e-08 {VDD} 3.4000e-08 {VDD} 3.4100e-08 0)
venb_op0_n100_rh_s0p1_r1000k enb_op0_n100_rh_s0p1_r1000k 0 pwl(0.0000e+00 {VDD} 1.1000e-08 {VDD} 1.1100e-08 0 3.4000e-08 0 3.4100e-08 {VDD})
vww_op0_n100_rh_s0p1_r1000k wwl_op0_n100_rh_s0p1_r1000k 0 pwl(0.0000e+00 0 1.2000e-08 0 1.2100e-08 {VDD} 3.2000e-08 {VDD} 3.2100e-08 0)
vwc_op0_n100_rh_s0p1_r1000k wbc_op0_n100_rh_s0p1_r1000k 0 pwl(0.0000e+00 0 1.2000e-08 0 1.2100e-08 {VDD} 3.4000e-08 {VDD} 3.4100e-08 0)
swb_op0_n100_rh_s0p1_r1000k ref_op0_n100_rh_s0p1_r1000k wbl_op0_n100_rh_s0p1_r1000k wbc_op0_n100_rh_s0p1_r1000k 0 swwbl
cwbl_op0_n100_rh_s0p1_r1000k wbl_op0_n100_rh_s0p1_r1000k 0 {C_WBL}
spa_op0_n100_rh_s0p1_r1000k prea rbl_op0_n100_rh_s0p1_r1000k ctl_op0_n100_rh_s0p1_r1000k 0 swpre
spr_op0_n100_rh_s0p1_r1000k pref ref_op0_n100_rh_s0p1_r1000k ctl_op0_n100_rh_s0p1_r1000k 0 swpre
crbl_op0_n100_rh_s0p1_r1000k rbl_op0_n100_rh_s0p1_r1000k 0 {C_RBL}
cref_op0_n100_rh_s0p1_r1000k ref_op0_n100_rh_s0p1_r1000k 0 {C_RBL}   $ ASSUMPTION: ideal matched dummy load
XMWR_op0_n100_rh_s0p1_r1000k_0 sn_op0_n100_rh_s0p1_r1000k_0 wwl_op0_n100_rh_s0p1_r1000k wbl_op0_n100_rh_s0p1_r1000k 0 sky130_fd_pr__nfet_01v8 L=0.15 W=0.42 nf=1 ad=0.1218 as=0.1218 pd=1.42 ps=1.42 nrd=0.69047619047619  nrs=0.69047619047619 sa=0 sb=0 sd=0 mult=1 m=1
XMRD_op0_n100_rh_s0p1_r1000k_0 rbl_op0_n100_rh_s0p1_r1000k sn_op0_n100_rh_s0p1_r1000k_0 rwls_op0_n100_rh_s0p1_r1000k 0 sky130_fd_pr__nfet_01v8 L=0.15 W=0.42 nf=1 ad=0.1218 as=0.1218 pd=1.42 ps=1.42 nrd=0.69047619047619  nrs=0.69047619047619 sa=0 sb=0 sd=0 mult=1 m=1
csn_op0_n100_rh_s0p1_r1000k_0 sn_op0_n100_rh_s0p1_r1000k_0 0 {C_SN}
XMWR_op0_n100_rh_s0p1_r1000k_1 sn_op0_n100_rh_s0p1_r1000k_1 wwl_des wbl_op0_n100_rh_s0p1_r1000k 0 sky130_fd_pr__nfet_01v8 L=0.15 W=0.42 nf=1 ad=0.1218 as=0.1218 pd=1.42 ps=1.42 nrd=0.69047619047619  nrs=0.69047619047619 sa=0 sb=0 sd=0 mult=1 m=1
XMRD_op0_n100_rh_s0p1_r1000k_1 rbl_op0_n100_rh_s0p1_r1000k sn_op0_n100_rh_s0p1_r1000k_1 rwl_des 0 sky130_fd_pr__nfet_01v8 L=0.15 W=0.42 nf=1 ad=0.1218 as=0.1218 pd=1.42 ps=1.42 nrd=0.69047619047619  nrs=0.69047619047619 sa=0 sb=0 sd=0 mult=1 m=1
csn_op0_n100_rh_s0p1_r1000k_1 sn_op0_n100_rh_s0p1_r1000k_1 0 {C_SN}
XMWR_op0_n100_rh_s0p1_r1000k_2 sn_op0_n100_rh_s0p1_r1000k_2 wwl_des wbl_op0_n100_rh_s0p1_r1000k 0 sky130_fd_pr__nfet_01v8 L=0.15 W=0.42 nf=1 ad=0.1218 as=0.1218 pd=1.42 ps=1.42 nrd=0.69047619047619  nrs=0.69047619047619 sa=0 sb=0 sd=0 mult=1 m=1
XMRD_op0_n100_rh_s0p1_r1000k_2 rbl_op0_n100_rh_s0p1_r1000k sn_op0_n100_rh_s0p1_r1000k_2 rwl_des 0 sky130_fd_pr__nfet_01v8 L=0.15 W=0.42 nf=1 ad=0.1218 as=0.1218 pd=1.42 ps=1.42 nrd=0.69047619047619  nrs=0.69047619047619 sa=0 sb=0 sd=0 mult=1 m=1
csn_op0_n100_rh_s0p1_r1000k_2 sn_op0_n100_rh_s0p1_r1000k_2 0 {C_SN}
XMWR_op0_n100_rh_s0p1_r1000k_3 sn_op0_n100_rh_s0p1_r1000k_3 wwl_des wbl_op0_n100_rh_s0p1_r1000k 0 sky130_fd_pr__nfet_01v8 L=0.15 W=0.42 nf=1 ad=0.1218 as=0.1218 pd=1.42 ps=1.42 nrd=0.69047619047619  nrs=0.69047619047619 sa=0 sb=0 sd=0 mult=1 m=1
XMRD_op0_n100_rh_s0p1_r1000k_3 rbl_op0_n100_rh_s0p1_r1000k sn_op0_n100_rh_s0p1_r1000k_3 rwl_des 0 sky130_fd_pr__nfet_01v8 L=0.15 W=0.42 nf=1 ad=0.1218 as=0.1218 pd=1.42 ps=1.42 nrd=0.69047619047619  nrs=0.69047619047619 sa=0 sb=0 sd=0 mult=1 m=1
csn_op0_n100_rh_s0p1_r1000k_3 sn_op0_n100_rh_s0p1_r1000k_3 0 {C_SN}
XMN1_op0_n100_rh_s0p1_r1000k rbl_op0_n100_rh_s0p1_r1000k ref_op0_n100_rh_s0p1_r1000k vn_op0_n100_rh_s0p1_r1000k 0 sky130_fd_pr__nfet_01v8 L=0.15 W=1 nf=1 ad=0.29 as=0.29 pd=2.58 ps=2.58 mult=1 m=1
XMN2_op0_n100_rh_s0p1_r1000k ref_op0_n100_rh_s0p1_r1000k rbl_op0_n100_rh_s0p1_r1000k vn_op0_n100_rh_s0p1_r1000k 0 sky130_fd_pr__nfet_01v8 L=0.15 W=1 nf=1 ad=0.29 as=0.29 pd=2.58 ps=2.58 mult=1 m=1
XMP1_op0_n100_rh_s0p1_r1000k rbl_op0_n100_rh_s0p1_r1000k ref_op0_n100_rh_s0p1_r1000k vp_op0_n100_rh_s0p1_r1000k vdd sky130_fd_pr__pfet_01v8 L=0.15 W=2 nf=1 ad=0.58 as=0.58 pd=4.58 ps=4.58 mult=1 m=1
XMP2_op0_n100_rh_s0p1_r1000k ref_op0_n100_rh_s0p1_r1000k rbl_op0_n100_rh_s0p1_r1000k vp_op0_n100_rh_s0p1_r1000k vdd sky130_fd_pr__pfet_01v8 L=0.15 W=2 nf=1 ad=0.58 as=0.58 pd=4.58 ps=4.58 mult=1 m=1
XMNF_op0_n100_rh_s0p1_r1000k vn_op0_n100_rh_s0p1_r1000k en_op0_n100_rh_s0p1_r1000k 0 0 sky130_fd_pr__nfet_01v8 L=0.15 W=2 nf=1 ad=0.58 as=0.58 pd=4.58 ps=4.58 mult=1 m=1
XMPH_op0_n100_rh_s0p1_r1000k vp_op0_n100_rh_s0p1_r1000k enb_op0_n100_rh_s0p1_r1000k vdd vdd sky130_fd_pr__pfet_01v8 L=0.15 W=4 nf=1 ad=1.16 as=1.16 pd=8.58 ps=8.58 mult=1 m=1
bd_op0_n100_rh_s0p1_r1000k d_op0_n100_rh_s0p1_r1000k 0 v=v(rbl_op0_n100_rh_s0p1_r1000k)-v(ref_op0_n100_rh_s0p1_r1000k)

* ---- instance 144: op0_0000_rh_s0p1_r1000k (variant rh_s0p1_r1000k; probe dec 11.9 ns, release 34 ns, meas 36 ns) ----
vctl_op0_0000_rh_s0p1_r1000k ctl_op0_0000_rh_s0p1_r1000k 0 pwl(0.0000e+00 {VDD} 2.0000e-09 {VDD} 2.1000e-09 0)
* RWL driver model (EXPERIMENTAL): slew 0.1 ns, series R 1e+06 ohm; cell pin = rwls_op0_0000_rh_s0p1_r1000k
vrs_op0_0000_rh_s0p1_r1000k rwlsrc_op0_0000_rh_s0p1_r1000k 0 pwl(0.0000e+00 {VDD} 2.0000e-09 {VDD} 2.1000e-09 0 1.2000e-08 0 1.2100e-08 {VDD})
rdrv_op0_0000_rh_s0p1_r1000k rwlsrc_op0_0000_rh_s0p1_r1000k rwls_op0_0000_rh_s0p1_r1000k 1e+06
ven_op0_0000_rh_s0p1_r1000k en_op0_0000_rh_s0p1_r1000k 0 pwl(0.0000e+00 0 1.1000e-08 0 1.1100e-08 {VDD} 3.4000e-08 {VDD} 3.4100e-08 0)
venb_op0_0000_rh_s0p1_r1000k enb_op0_0000_rh_s0p1_r1000k 0 pwl(0.0000e+00 {VDD} 1.1000e-08 {VDD} 1.1100e-08 0 3.4000e-08 0 3.4100e-08 {VDD})
vww_op0_0000_rh_s0p1_r1000k wwl_op0_0000_rh_s0p1_r1000k 0 pwl(0.0000e+00 0 1.2000e-08 0 1.2100e-08 {VDD} 3.2000e-08 {VDD} 3.2100e-08 0)
vwc_op0_0000_rh_s0p1_r1000k wbc_op0_0000_rh_s0p1_r1000k 0 pwl(0.0000e+00 0 1.2000e-08 0 1.2100e-08 {VDD} 3.4000e-08 {VDD} 3.4100e-08 0)
swb_op0_0000_rh_s0p1_r1000k ref_op0_0000_rh_s0p1_r1000k wbl_op0_0000_rh_s0p1_r1000k wbc_op0_0000_rh_s0p1_r1000k 0 swwbl
cwbl_op0_0000_rh_s0p1_r1000k wbl_op0_0000_rh_s0p1_r1000k 0 {C_WBL}
spa_op0_0000_rh_s0p1_r1000k prea rbl_op0_0000_rh_s0p1_r1000k ctl_op0_0000_rh_s0p1_r1000k 0 swpre
spr_op0_0000_rh_s0p1_r1000k pref ref_op0_0000_rh_s0p1_r1000k ctl_op0_0000_rh_s0p1_r1000k 0 swpre
crbl_op0_0000_rh_s0p1_r1000k rbl_op0_0000_rh_s0p1_r1000k 0 {C_RBL}
cref_op0_0000_rh_s0p1_r1000k ref_op0_0000_rh_s0p1_r1000k 0 {C_RBL}   $ ASSUMPTION: ideal matched dummy load
XMWR_op0_0000_rh_s0p1_r1000k_0 sn_op0_0000_rh_s0p1_r1000k_0 wwl_op0_0000_rh_s0p1_r1000k wbl_op0_0000_rh_s0p1_r1000k 0 sky130_fd_pr__nfet_01v8 L=0.15 W=0.42 nf=1 ad=0.1218 as=0.1218 pd=1.42 ps=1.42 nrd=0.69047619047619  nrs=0.69047619047619 sa=0 sb=0 sd=0 mult=1 m=1
XMRD_op0_0000_rh_s0p1_r1000k_0 rbl_op0_0000_rh_s0p1_r1000k sn_op0_0000_rh_s0p1_r1000k_0 rwls_op0_0000_rh_s0p1_r1000k 0 sky130_fd_pr__nfet_01v8 L=0.15 W=0.42 nf=1 ad=0.1218 as=0.1218 pd=1.42 ps=1.42 nrd=0.69047619047619  nrs=0.69047619047619 sa=0 sb=0 sd=0 mult=1 m=1
csn_op0_0000_rh_s0p1_r1000k_0 sn_op0_0000_rh_s0p1_r1000k_0 0 {C_SN}
XMWR_op0_0000_rh_s0p1_r1000k_1 sn_op0_0000_rh_s0p1_r1000k_1 wwl_des wbl_op0_0000_rh_s0p1_r1000k 0 sky130_fd_pr__nfet_01v8 L=0.15 W=0.42 nf=1 ad=0.1218 as=0.1218 pd=1.42 ps=1.42 nrd=0.69047619047619  nrs=0.69047619047619 sa=0 sb=0 sd=0 mult=1 m=1
XMRD_op0_0000_rh_s0p1_r1000k_1 rbl_op0_0000_rh_s0p1_r1000k sn_op0_0000_rh_s0p1_r1000k_1 rwl_des 0 sky130_fd_pr__nfet_01v8 L=0.15 W=0.42 nf=1 ad=0.1218 as=0.1218 pd=1.42 ps=1.42 nrd=0.69047619047619  nrs=0.69047619047619 sa=0 sb=0 sd=0 mult=1 m=1
csn_op0_0000_rh_s0p1_r1000k_1 sn_op0_0000_rh_s0p1_r1000k_1 0 {C_SN}
XMWR_op0_0000_rh_s0p1_r1000k_2 sn_op0_0000_rh_s0p1_r1000k_2 wwl_des wbl_op0_0000_rh_s0p1_r1000k 0 sky130_fd_pr__nfet_01v8 L=0.15 W=0.42 nf=1 ad=0.1218 as=0.1218 pd=1.42 ps=1.42 nrd=0.69047619047619  nrs=0.69047619047619 sa=0 sb=0 sd=0 mult=1 m=1
XMRD_op0_0000_rh_s0p1_r1000k_2 rbl_op0_0000_rh_s0p1_r1000k sn_op0_0000_rh_s0p1_r1000k_2 rwl_des 0 sky130_fd_pr__nfet_01v8 L=0.15 W=0.42 nf=1 ad=0.1218 as=0.1218 pd=1.42 ps=1.42 nrd=0.69047619047619  nrs=0.69047619047619 sa=0 sb=0 sd=0 mult=1 m=1
csn_op0_0000_rh_s0p1_r1000k_2 sn_op0_0000_rh_s0p1_r1000k_2 0 {C_SN}
XMWR_op0_0000_rh_s0p1_r1000k_3 sn_op0_0000_rh_s0p1_r1000k_3 wwl_des wbl_op0_0000_rh_s0p1_r1000k 0 sky130_fd_pr__nfet_01v8 L=0.15 W=0.42 nf=1 ad=0.1218 as=0.1218 pd=1.42 ps=1.42 nrd=0.69047619047619  nrs=0.69047619047619 sa=0 sb=0 sd=0 mult=1 m=1
XMRD_op0_0000_rh_s0p1_r1000k_3 rbl_op0_0000_rh_s0p1_r1000k sn_op0_0000_rh_s0p1_r1000k_3 rwl_des 0 sky130_fd_pr__nfet_01v8 L=0.15 W=0.42 nf=1 ad=0.1218 as=0.1218 pd=1.42 ps=1.42 nrd=0.69047619047619  nrs=0.69047619047619 sa=0 sb=0 sd=0 mult=1 m=1
csn_op0_0000_rh_s0p1_r1000k_3 sn_op0_0000_rh_s0p1_r1000k_3 0 {C_SN}
XMN1_op0_0000_rh_s0p1_r1000k rbl_op0_0000_rh_s0p1_r1000k ref_op0_0000_rh_s0p1_r1000k vn_op0_0000_rh_s0p1_r1000k 0 sky130_fd_pr__nfet_01v8 L=0.15 W=1 nf=1 ad=0.29 as=0.29 pd=2.58 ps=2.58 mult=1 m=1
XMN2_op0_0000_rh_s0p1_r1000k ref_op0_0000_rh_s0p1_r1000k rbl_op0_0000_rh_s0p1_r1000k vn_op0_0000_rh_s0p1_r1000k 0 sky130_fd_pr__nfet_01v8 L=0.15 W=1 nf=1 ad=0.29 as=0.29 pd=2.58 ps=2.58 mult=1 m=1
XMP1_op0_0000_rh_s0p1_r1000k rbl_op0_0000_rh_s0p1_r1000k ref_op0_0000_rh_s0p1_r1000k vp_op0_0000_rh_s0p1_r1000k vdd sky130_fd_pr__pfet_01v8 L=0.15 W=2 nf=1 ad=0.58 as=0.58 pd=4.58 ps=4.58 mult=1 m=1
XMP2_op0_0000_rh_s0p1_r1000k ref_op0_0000_rh_s0p1_r1000k rbl_op0_0000_rh_s0p1_r1000k vp_op0_0000_rh_s0p1_r1000k vdd sky130_fd_pr__pfet_01v8 L=0.15 W=2 nf=1 ad=0.58 as=0.58 pd=4.58 ps=4.58 mult=1 m=1
XMNF_op0_0000_rh_s0p1_r1000k vn_op0_0000_rh_s0p1_r1000k en_op0_0000_rh_s0p1_r1000k 0 0 sky130_fd_pr__nfet_01v8 L=0.15 W=2 nf=1 ad=0.58 as=0.58 pd=4.58 ps=4.58 mult=1 m=1
XMPH_op0_0000_rh_s0p1_r1000k vp_op0_0000_rh_s0p1_r1000k enb_op0_0000_rh_s0p1_r1000k vdd vdd sky130_fd_pr__pfet_01v8 L=0.15 W=4 nf=1 ad=1.16 as=1.16 pd=8.58 ps=8.58 mult=1 m=1
bd_op0_0000_rh_s0p1_r1000k d_op0_0000_rh_s0p1_r1000k 0 v=v(rbl_op0_0000_rh_s0p1_r1000k)-v(ref_op0_0000_rh_s0p1_r1000k)

* ---- instance 145: op1_0900_rh_s1_r10k (variant rh_s1_r10k; probe dec 11.9 ns, release 34 ns, meas 36 ns) ----
vctl_op1_0900_rh_s1_r10k ctl_op1_0900_rh_s1_r10k 0 pwl(0.0000e+00 {VDD} 2.0000e-09 {VDD} 2.1000e-09 0)
* RWL driver model (EXPERIMENTAL): slew 1 ns, series R 10000 ohm; cell pin = rwls_op1_0900_rh_s1_r10k
vrs_op1_0900_rh_s1_r10k rwlsrc_op1_0900_rh_s1_r10k 0 pwl(0.0000e+00 {VDD} 2.0000e-09 {VDD} 3.0000e-09 0 1.2000e-08 0 1.3000e-08 {VDD})
rdrv_op1_0900_rh_s1_r10k rwlsrc_op1_0900_rh_s1_r10k rwls_op1_0900_rh_s1_r10k 10000
ven_op1_0900_rh_s1_r10k en_op1_0900_rh_s1_r10k 0 pwl(0.0000e+00 0 1.1000e-08 0 1.1100e-08 {VDD} 3.4000e-08 {VDD} 3.4100e-08 0)
venb_op1_0900_rh_s1_r10k enb_op1_0900_rh_s1_r10k 0 pwl(0.0000e+00 {VDD} 1.1000e-08 {VDD} 1.1100e-08 0 3.4000e-08 0 3.4100e-08 {VDD})
vww_op1_0900_rh_s1_r10k wwl_op1_0900_rh_s1_r10k 0 pwl(0.0000e+00 0 1.2000e-08 0 1.2100e-08 {VDD} 3.2000e-08 {VDD} 3.2100e-08 0)
vwc_op1_0900_rh_s1_r10k wbc_op1_0900_rh_s1_r10k 0 pwl(0.0000e+00 0 1.2000e-08 0 1.2100e-08 {VDD} 3.4000e-08 {VDD} 3.4100e-08 0)
swb_op1_0900_rh_s1_r10k ref_op1_0900_rh_s1_r10k wbl_op1_0900_rh_s1_r10k wbc_op1_0900_rh_s1_r10k 0 swwbl
cwbl_op1_0900_rh_s1_r10k wbl_op1_0900_rh_s1_r10k 0 {C_WBL}
spa_op1_0900_rh_s1_r10k prea rbl_op1_0900_rh_s1_r10k ctl_op1_0900_rh_s1_r10k 0 swpre
spr_op1_0900_rh_s1_r10k pref ref_op1_0900_rh_s1_r10k ctl_op1_0900_rh_s1_r10k 0 swpre
crbl_op1_0900_rh_s1_r10k rbl_op1_0900_rh_s1_r10k 0 {C_RBL}
cref_op1_0900_rh_s1_r10k ref_op1_0900_rh_s1_r10k 0 {C_RBL}   $ ASSUMPTION: ideal matched dummy load
XMWR_op1_0900_rh_s1_r10k_0 sn_op1_0900_rh_s1_r10k_0 wwl_op1_0900_rh_s1_r10k wbl_op1_0900_rh_s1_r10k 0 sky130_fd_pr__nfet_01v8 L=0.15 W=0.42 nf=1 ad=0.1218 as=0.1218 pd=1.42 ps=1.42 nrd=0.69047619047619  nrs=0.69047619047619 sa=0 sb=0 sd=0 mult=1 m=1
XMRD_op1_0900_rh_s1_r10k_0 rbl_op1_0900_rh_s1_r10k sn_op1_0900_rh_s1_r10k_0 rwls_op1_0900_rh_s1_r10k 0 sky130_fd_pr__nfet_01v8 L=0.15 W=0.42 nf=1 ad=0.1218 as=0.1218 pd=1.42 ps=1.42 nrd=0.69047619047619  nrs=0.69047619047619 sa=0 sb=0 sd=0 mult=1 m=1
csn_op1_0900_rh_s1_r10k_0 sn_op1_0900_rh_s1_r10k_0 0 {C_SN}
XMWR_op1_0900_rh_s1_r10k_1 sn_op1_0900_rh_s1_r10k_1 wwl_des wbl_op1_0900_rh_s1_r10k 0 sky130_fd_pr__nfet_01v8 L=0.15 W=0.42 nf=1 ad=0.1218 as=0.1218 pd=1.42 ps=1.42 nrd=0.69047619047619  nrs=0.69047619047619 sa=0 sb=0 sd=0 mult=1 m=1
XMRD_op1_0900_rh_s1_r10k_1 rbl_op1_0900_rh_s1_r10k sn_op1_0900_rh_s1_r10k_1 rwl_des 0 sky130_fd_pr__nfet_01v8 L=0.15 W=0.42 nf=1 ad=0.1218 as=0.1218 pd=1.42 ps=1.42 nrd=0.69047619047619  nrs=0.69047619047619 sa=0 sb=0 sd=0 mult=1 m=1
csn_op1_0900_rh_s1_r10k_1 sn_op1_0900_rh_s1_r10k_1 0 {C_SN}
XMWR_op1_0900_rh_s1_r10k_2 sn_op1_0900_rh_s1_r10k_2 wwl_des wbl_op1_0900_rh_s1_r10k 0 sky130_fd_pr__nfet_01v8 L=0.15 W=0.42 nf=1 ad=0.1218 as=0.1218 pd=1.42 ps=1.42 nrd=0.69047619047619  nrs=0.69047619047619 sa=0 sb=0 sd=0 mult=1 m=1
XMRD_op1_0900_rh_s1_r10k_2 rbl_op1_0900_rh_s1_r10k sn_op1_0900_rh_s1_r10k_2 rwl_des 0 sky130_fd_pr__nfet_01v8 L=0.15 W=0.42 nf=1 ad=0.1218 as=0.1218 pd=1.42 ps=1.42 nrd=0.69047619047619  nrs=0.69047619047619 sa=0 sb=0 sd=0 mult=1 m=1
csn_op1_0900_rh_s1_r10k_2 sn_op1_0900_rh_s1_r10k_2 0 {C_SN}
XMWR_op1_0900_rh_s1_r10k_3 sn_op1_0900_rh_s1_r10k_3 wwl_des wbl_op1_0900_rh_s1_r10k 0 sky130_fd_pr__nfet_01v8 L=0.15 W=0.42 nf=1 ad=0.1218 as=0.1218 pd=1.42 ps=1.42 nrd=0.69047619047619  nrs=0.69047619047619 sa=0 sb=0 sd=0 mult=1 m=1
XMRD_op1_0900_rh_s1_r10k_3 rbl_op1_0900_rh_s1_r10k sn_op1_0900_rh_s1_r10k_3 rwl_des 0 sky130_fd_pr__nfet_01v8 L=0.15 W=0.42 nf=1 ad=0.1218 as=0.1218 pd=1.42 ps=1.42 nrd=0.69047619047619  nrs=0.69047619047619 sa=0 sb=0 sd=0 mult=1 m=1
csn_op1_0900_rh_s1_r10k_3 sn_op1_0900_rh_s1_r10k_3 0 {C_SN}
XMN1_op1_0900_rh_s1_r10k rbl_op1_0900_rh_s1_r10k ref_op1_0900_rh_s1_r10k vn_op1_0900_rh_s1_r10k 0 sky130_fd_pr__nfet_01v8 L=0.15 W=1 nf=1 ad=0.29 as=0.29 pd=2.58 ps=2.58 mult=1 m=1
XMN2_op1_0900_rh_s1_r10k ref_op1_0900_rh_s1_r10k rbl_op1_0900_rh_s1_r10k vn_op1_0900_rh_s1_r10k 0 sky130_fd_pr__nfet_01v8 L=0.15 W=1 nf=1 ad=0.29 as=0.29 pd=2.58 ps=2.58 mult=1 m=1
XMP1_op1_0900_rh_s1_r10k rbl_op1_0900_rh_s1_r10k ref_op1_0900_rh_s1_r10k vp_op1_0900_rh_s1_r10k vdd sky130_fd_pr__pfet_01v8 L=0.15 W=2 nf=1 ad=0.58 as=0.58 pd=4.58 ps=4.58 mult=1 m=1
XMP2_op1_0900_rh_s1_r10k ref_op1_0900_rh_s1_r10k rbl_op1_0900_rh_s1_r10k vp_op1_0900_rh_s1_r10k vdd sky130_fd_pr__pfet_01v8 L=0.15 W=2 nf=1 ad=0.58 as=0.58 pd=4.58 ps=4.58 mult=1 m=1
XMNF_op1_0900_rh_s1_r10k vn_op1_0900_rh_s1_r10k en_op1_0900_rh_s1_r10k 0 0 sky130_fd_pr__nfet_01v8 L=0.15 W=2 nf=1 ad=0.58 as=0.58 pd=4.58 ps=4.58 mult=1 m=1
XMPH_op1_0900_rh_s1_r10k vp_op1_0900_rh_s1_r10k enb_op1_0900_rh_s1_r10k vdd vdd sky130_fd_pr__pfet_01v8 L=0.15 W=4 nf=1 ad=1.16 as=1.16 pd=8.58 ps=8.58 mult=1 m=1
bd_op1_0900_rh_s1_r10k d_op1_0900_rh_s1_r10k 0 v=v(rbl_op1_0900_rh_s1_r10k)-v(ref_op1_0900_rh_s1_r10k)

* ---- instance 146: op1_1000_rh_s1_r10k (variant rh_s1_r10k; probe dec 11.9 ns, release 34 ns, meas 36 ns) ----
vctl_op1_1000_rh_s1_r10k ctl_op1_1000_rh_s1_r10k 0 pwl(0.0000e+00 {VDD} 2.0000e-09 {VDD} 2.1000e-09 0)
* RWL driver model (EXPERIMENTAL): slew 1 ns, series R 10000 ohm; cell pin = rwls_op1_1000_rh_s1_r10k
vrs_op1_1000_rh_s1_r10k rwlsrc_op1_1000_rh_s1_r10k 0 pwl(0.0000e+00 {VDD} 2.0000e-09 {VDD} 3.0000e-09 0 1.2000e-08 0 1.3000e-08 {VDD})
rdrv_op1_1000_rh_s1_r10k rwlsrc_op1_1000_rh_s1_r10k rwls_op1_1000_rh_s1_r10k 10000
ven_op1_1000_rh_s1_r10k en_op1_1000_rh_s1_r10k 0 pwl(0.0000e+00 0 1.1000e-08 0 1.1100e-08 {VDD} 3.4000e-08 {VDD} 3.4100e-08 0)
venb_op1_1000_rh_s1_r10k enb_op1_1000_rh_s1_r10k 0 pwl(0.0000e+00 {VDD} 1.1000e-08 {VDD} 1.1100e-08 0 3.4000e-08 0 3.4100e-08 {VDD})
vww_op1_1000_rh_s1_r10k wwl_op1_1000_rh_s1_r10k 0 pwl(0.0000e+00 0 1.2000e-08 0 1.2100e-08 {VDD} 3.2000e-08 {VDD} 3.2100e-08 0)
vwc_op1_1000_rh_s1_r10k wbc_op1_1000_rh_s1_r10k 0 pwl(0.0000e+00 0 1.2000e-08 0 1.2100e-08 {VDD} 3.4000e-08 {VDD} 3.4100e-08 0)
swb_op1_1000_rh_s1_r10k ref_op1_1000_rh_s1_r10k wbl_op1_1000_rh_s1_r10k wbc_op1_1000_rh_s1_r10k 0 swwbl
cwbl_op1_1000_rh_s1_r10k wbl_op1_1000_rh_s1_r10k 0 {C_WBL}
spa_op1_1000_rh_s1_r10k prea rbl_op1_1000_rh_s1_r10k ctl_op1_1000_rh_s1_r10k 0 swpre
spr_op1_1000_rh_s1_r10k pref ref_op1_1000_rh_s1_r10k ctl_op1_1000_rh_s1_r10k 0 swpre
crbl_op1_1000_rh_s1_r10k rbl_op1_1000_rh_s1_r10k 0 {C_RBL}
cref_op1_1000_rh_s1_r10k ref_op1_1000_rh_s1_r10k 0 {C_RBL}   $ ASSUMPTION: ideal matched dummy load
XMWR_op1_1000_rh_s1_r10k_0 sn_op1_1000_rh_s1_r10k_0 wwl_op1_1000_rh_s1_r10k wbl_op1_1000_rh_s1_r10k 0 sky130_fd_pr__nfet_01v8 L=0.15 W=0.42 nf=1 ad=0.1218 as=0.1218 pd=1.42 ps=1.42 nrd=0.69047619047619  nrs=0.69047619047619 sa=0 sb=0 sd=0 mult=1 m=1
XMRD_op1_1000_rh_s1_r10k_0 rbl_op1_1000_rh_s1_r10k sn_op1_1000_rh_s1_r10k_0 rwls_op1_1000_rh_s1_r10k 0 sky130_fd_pr__nfet_01v8 L=0.15 W=0.42 nf=1 ad=0.1218 as=0.1218 pd=1.42 ps=1.42 nrd=0.69047619047619  nrs=0.69047619047619 sa=0 sb=0 sd=0 mult=1 m=1
csn_op1_1000_rh_s1_r10k_0 sn_op1_1000_rh_s1_r10k_0 0 {C_SN}
XMWR_op1_1000_rh_s1_r10k_1 sn_op1_1000_rh_s1_r10k_1 wwl_des wbl_op1_1000_rh_s1_r10k 0 sky130_fd_pr__nfet_01v8 L=0.15 W=0.42 nf=1 ad=0.1218 as=0.1218 pd=1.42 ps=1.42 nrd=0.69047619047619  nrs=0.69047619047619 sa=0 sb=0 sd=0 mult=1 m=1
XMRD_op1_1000_rh_s1_r10k_1 rbl_op1_1000_rh_s1_r10k sn_op1_1000_rh_s1_r10k_1 rwl_des 0 sky130_fd_pr__nfet_01v8 L=0.15 W=0.42 nf=1 ad=0.1218 as=0.1218 pd=1.42 ps=1.42 nrd=0.69047619047619  nrs=0.69047619047619 sa=0 sb=0 sd=0 mult=1 m=1
csn_op1_1000_rh_s1_r10k_1 sn_op1_1000_rh_s1_r10k_1 0 {C_SN}
XMWR_op1_1000_rh_s1_r10k_2 sn_op1_1000_rh_s1_r10k_2 wwl_des wbl_op1_1000_rh_s1_r10k 0 sky130_fd_pr__nfet_01v8 L=0.15 W=0.42 nf=1 ad=0.1218 as=0.1218 pd=1.42 ps=1.42 nrd=0.69047619047619  nrs=0.69047619047619 sa=0 sb=0 sd=0 mult=1 m=1
XMRD_op1_1000_rh_s1_r10k_2 rbl_op1_1000_rh_s1_r10k sn_op1_1000_rh_s1_r10k_2 rwl_des 0 sky130_fd_pr__nfet_01v8 L=0.15 W=0.42 nf=1 ad=0.1218 as=0.1218 pd=1.42 ps=1.42 nrd=0.69047619047619  nrs=0.69047619047619 sa=0 sb=0 sd=0 mult=1 m=1
csn_op1_1000_rh_s1_r10k_2 sn_op1_1000_rh_s1_r10k_2 0 {C_SN}
XMWR_op1_1000_rh_s1_r10k_3 sn_op1_1000_rh_s1_r10k_3 wwl_des wbl_op1_1000_rh_s1_r10k 0 sky130_fd_pr__nfet_01v8 L=0.15 W=0.42 nf=1 ad=0.1218 as=0.1218 pd=1.42 ps=1.42 nrd=0.69047619047619  nrs=0.69047619047619 sa=0 sb=0 sd=0 mult=1 m=1
XMRD_op1_1000_rh_s1_r10k_3 rbl_op1_1000_rh_s1_r10k sn_op1_1000_rh_s1_r10k_3 rwl_des 0 sky130_fd_pr__nfet_01v8 L=0.15 W=0.42 nf=1 ad=0.1218 as=0.1218 pd=1.42 ps=1.42 nrd=0.69047619047619  nrs=0.69047619047619 sa=0 sb=0 sd=0 mult=1 m=1
csn_op1_1000_rh_s1_r10k_3 sn_op1_1000_rh_s1_r10k_3 0 {C_SN}
XMN1_op1_1000_rh_s1_r10k rbl_op1_1000_rh_s1_r10k ref_op1_1000_rh_s1_r10k vn_op1_1000_rh_s1_r10k 0 sky130_fd_pr__nfet_01v8 L=0.15 W=1 nf=1 ad=0.29 as=0.29 pd=2.58 ps=2.58 mult=1 m=1
XMN2_op1_1000_rh_s1_r10k ref_op1_1000_rh_s1_r10k rbl_op1_1000_rh_s1_r10k vn_op1_1000_rh_s1_r10k 0 sky130_fd_pr__nfet_01v8 L=0.15 W=1 nf=1 ad=0.29 as=0.29 pd=2.58 ps=2.58 mult=1 m=1
XMP1_op1_1000_rh_s1_r10k rbl_op1_1000_rh_s1_r10k ref_op1_1000_rh_s1_r10k vp_op1_1000_rh_s1_r10k vdd sky130_fd_pr__pfet_01v8 L=0.15 W=2 nf=1 ad=0.58 as=0.58 pd=4.58 ps=4.58 mult=1 m=1
XMP2_op1_1000_rh_s1_r10k ref_op1_1000_rh_s1_r10k rbl_op1_1000_rh_s1_r10k vp_op1_1000_rh_s1_r10k vdd sky130_fd_pr__pfet_01v8 L=0.15 W=2 nf=1 ad=0.58 as=0.58 pd=4.58 ps=4.58 mult=1 m=1
XMNF_op1_1000_rh_s1_r10k vn_op1_1000_rh_s1_r10k en_op1_1000_rh_s1_r10k 0 0 sky130_fd_pr__nfet_01v8 L=0.15 W=2 nf=1 ad=0.58 as=0.58 pd=4.58 ps=4.58 mult=1 m=1
XMPH_op1_1000_rh_s1_r10k vp_op1_1000_rh_s1_r10k enb_op1_1000_rh_s1_r10k vdd vdd sky130_fd_pr__pfet_01v8 L=0.15 W=4 nf=1 ad=1.16 as=1.16 pd=8.58 ps=8.58 mult=1 m=1
bd_op1_1000_rh_s1_r10k d_op1_1000_rh_s1_r10k 0 v=v(rbl_op1_1000_rh_s1_r10k)-v(ref_op1_1000_rh_s1_r10k)

* ---- instance 147: op0_n100_rh_s1_r10k (variant rh_s1_r10k; probe dec 11.9 ns, release 34 ns, meas 36 ns) ----
vctl_op0_n100_rh_s1_r10k ctl_op0_n100_rh_s1_r10k 0 pwl(0.0000e+00 {VDD} 2.0000e-09 {VDD} 2.1000e-09 0)
* RWL driver model (EXPERIMENTAL): slew 1 ns, series R 10000 ohm; cell pin = rwls_op0_n100_rh_s1_r10k
vrs_op0_n100_rh_s1_r10k rwlsrc_op0_n100_rh_s1_r10k 0 pwl(0.0000e+00 {VDD} 2.0000e-09 {VDD} 3.0000e-09 0 1.2000e-08 0 1.3000e-08 {VDD})
rdrv_op0_n100_rh_s1_r10k rwlsrc_op0_n100_rh_s1_r10k rwls_op0_n100_rh_s1_r10k 10000
ven_op0_n100_rh_s1_r10k en_op0_n100_rh_s1_r10k 0 pwl(0.0000e+00 0 1.1000e-08 0 1.1100e-08 {VDD} 3.4000e-08 {VDD} 3.4100e-08 0)
venb_op0_n100_rh_s1_r10k enb_op0_n100_rh_s1_r10k 0 pwl(0.0000e+00 {VDD} 1.1000e-08 {VDD} 1.1100e-08 0 3.4000e-08 0 3.4100e-08 {VDD})
vww_op0_n100_rh_s1_r10k wwl_op0_n100_rh_s1_r10k 0 pwl(0.0000e+00 0 1.2000e-08 0 1.2100e-08 {VDD} 3.2000e-08 {VDD} 3.2100e-08 0)
vwc_op0_n100_rh_s1_r10k wbc_op0_n100_rh_s1_r10k 0 pwl(0.0000e+00 0 1.2000e-08 0 1.2100e-08 {VDD} 3.4000e-08 {VDD} 3.4100e-08 0)
swb_op0_n100_rh_s1_r10k ref_op0_n100_rh_s1_r10k wbl_op0_n100_rh_s1_r10k wbc_op0_n100_rh_s1_r10k 0 swwbl
cwbl_op0_n100_rh_s1_r10k wbl_op0_n100_rh_s1_r10k 0 {C_WBL}
spa_op0_n100_rh_s1_r10k prea rbl_op0_n100_rh_s1_r10k ctl_op0_n100_rh_s1_r10k 0 swpre
spr_op0_n100_rh_s1_r10k pref ref_op0_n100_rh_s1_r10k ctl_op0_n100_rh_s1_r10k 0 swpre
crbl_op0_n100_rh_s1_r10k rbl_op0_n100_rh_s1_r10k 0 {C_RBL}
cref_op0_n100_rh_s1_r10k ref_op0_n100_rh_s1_r10k 0 {C_RBL}   $ ASSUMPTION: ideal matched dummy load
XMWR_op0_n100_rh_s1_r10k_0 sn_op0_n100_rh_s1_r10k_0 wwl_op0_n100_rh_s1_r10k wbl_op0_n100_rh_s1_r10k 0 sky130_fd_pr__nfet_01v8 L=0.15 W=0.42 nf=1 ad=0.1218 as=0.1218 pd=1.42 ps=1.42 nrd=0.69047619047619  nrs=0.69047619047619 sa=0 sb=0 sd=0 mult=1 m=1
XMRD_op0_n100_rh_s1_r10k_0 rbl_op0_n100_rh_s1_r10k sn_op0_n100_rh_s1_r10k_0 rwls_op0_n100_rh_s1_r10k 0 sky130_fd_pr__nfet_01v8 L=0.15 W=0.42 nf=1 ad=0.1218 as=0.1218 pd=1.42 ps=1.42 nrd=0.69047619047619  nrs=0.69047619047619 sa=0 sb=0 sd=0 mult=1 m=1
csn_op0_n100_rh_s1_r10k_0 sn_op0_n100_rh_s1_r10k_0 0 {C_SN}
XMWR_op0_n100_rh_s1_r10k_1 sn_op0_n100_rh_s1_r10k_1 wwl_des wbl_op0_n100_rh_s1_r10k 0 sky130_fd_pr__nfet_01v8 L=0.15 W=0.42 nf=1 ad=0.1218 as=0.1218 pd=1.42 ps=1.42 nrd=0.69047619047619  nrs=0.69047619047619 sa=0 sb=0 sd=0 mult=1 m=1
XMRD_op0_n100_rh_s1_r10k_1 rbl_op0_n100_rh_s1_r10k sn_op0_n100_rh_s1_r10k_1 rwl_des 0 sky130_fd_pr__nfet_01v8 L=0.15 W=0.42 nf=1 ad=0.1218 as=0.1218 pd=1.42 ps=1.42 nrd=0.69047619047619  nrs=0.69047619047619 sa=0 sb=0 sd=0 mult=1 m=1
csn_op0_n100_rh_s1_r10k_1 sn_op0_n100_rh_s1_r10k_1 0 {C_SN}
XMWR_op0_n100_rh_s1_r10k_2 sn_op0_n100_rh_s1_r10k_2 wwl_des wbl_op0_n100_rh_s1_r10k 0 sky130_fd_pr__nfet_01v8 L=0.15 W=0.42 nf=1 ad=0.1218 as=0.1218 pd=1.42 ps=1.42 nrd=0.69047619047619  nrs=0.69047619047619 sa=0 sb=0 sd=0 mult=1 m=1
XMRD_op0_n100_rh_s1_r10k_2 rbl_op0_n100_rh_s1_r10k sn_op0_n100_rh_s1_r10k_2 rwl_des 0 sky130_fd_pr__nfet_01v8 L=0.15 W=0.42 nf=1 ad=0.1218 as=0.1218 pd=1.42 ps=1.42 nrd=0.69047619047619  nrs=0.69047619047619 sa=0 sb=0 sd=0 mult=1 m=1
csn_op0_n100_rh_s1_r10k_2 sn_op0_n100_rh_s1_r10k_2 0 {C_SN}
XMWR_op0_n100_rh_s1_r10k_3 sn_op0_n100_rh_s1_r10k_3 wwl_des wbl_op0_n100_rh_s1_r10k 0 sky130_fd_pr__nfet_01v8 L=0.15 W=0.42 nf=1 ad=0.1218 as=0.1218 pd=1.42 ps=1.42 nrd=0.69047619047619  nrs=0.69047619047619 sa=0 sb=0 sd=0 mult=1 m=1
XMRD_op0_n100_rh_s1_r10k_3 rbl_op0_n100_rh_s1_r10k sn_op0_n100_rh_s1_r10k_3 rwl_des 0 sky130_fd_pr__nfet_01v8 L=0.15 W=0.42 nf=1 ad=0.1218 as=0.1218 pd=1.42 ps=1.42 nrd=0.69047619047619  nrs=0.69047619047619 sa=0 sb=0 sd=0 mult=1 m=1
csn_op0_n100_rh_s1_r10k_3 sn_op0_n100_rh_s1_r10k_3 0 {C_SN}
XMN1_op0_n100_rh_s1_r10k rbl_op0_n100_rh_s1_r10k ref_op0_n100_rh_s1_r10k vn_op0_n100_rh_s1_r10k 0 sky130_fd_pr__nfet_01v8 L=0.15 W=1 nf=1 ad=0.29 as=0.29 pd=2.58 ps=2.58 mult=1 m=1
XMN2_op0_n100_rh_s1_r10k ref_op0_n100_rh_s1_r10k rbl_op0_n100_rh_s1_r10k vn_op0_n100_rh_s1_r10k 0 sky130_fd_pr__nfet_01v8 L=0.15 W=1 nf=1 ad=0.29 as=0.29 pd=2.58 ps=2.58 mult=1 m=1
XMP1_op0_n100_rh_s1_r10k rbl_op0_n100_rh_s1_r10k ref_op0_n100_rh_s1_r10k vp_op0_n100_rh_s1_r10k vdd sky130_fd_pr__pfet_01v8 L=0.15 W=2 nf=1 ad=0.58 as=0.58 pd=4.58 ps=4.58 mult=1 m=1
XMP2_op0_n100_rh_s1_r10k ref_op0_n100_rh_s1_r10k rbl_op0_n100_rh_s1_r10k vp_op0_n100_rh_s1_r10k vdd sky130_fd_pr__pfet_01v8 L=0.15 W=2 nf=1 ad=0.58 as=0.58 pd=4.58 ps=4.58 mult=1 m=1
XMNF_op0_n100_rh_s1_r10k vn_op0_n100_rh_s1_r10k en_op0_n100_rh_s1_r10k 0 0 sky130_fd_pr__nfet_01v8 L=0.15 W=2 nf=1 ad=0.58 as=0.58 pd=4.58 ps=4.58 mult=1 m=1
XMPH_op0_n100_rh_s1_r10k vp_op0_n100_rh_s1_r10k enb_op0_n100_rh_s1_r10k vdd vdd sky130_fd_pr__pfet_01v8 L=0.15 W=4 nf=1 ad=1.16 as=1.16 pd=8.58 ps=8.58 mult=1 m=1
bd_op0_n100_rh_s1_r10k d_op0_n100_rh_s1_r10k 0 v=v(rbl_op0_n100_rh_s1_r10k)-v(ref_op0_n100_rh_s1_r10k)

* ---- instance 148: op0_0000_rh_s1_r10k (variant rh_s1_r10k; probe dec 11.9 ns, release 34 ns, meas 36 ns) ----
vctl_op0_0000_rh_s1_r10k ctl_op0_0000_rh_s1_r10k 0 pwl(0.0000e+00 {VDD} 2.0000e-09 {VDD} 2.1000e-09 0)
* RWL driver model (EXPERIMENTAL): slew 1 ns, series R 10000 ohm; cell pin = rwls_op0_0000_rh_s1_r10k
vrs_op0_0000_rh_s1_r10k rwlsrc_op0_0000_rh_s1_r10k 0 pwl(0.0000e+00 {VDD} 2.0000e-09 {VDD} 3.0000e-09 0 1.2000e-08 0 1.3000e-08 {VDD})
rdrv_op0_0000_rh_s1_r10k rwlsrc_op0_0000_rh_s1_r10k rwls_op0_0000_rh_s1_r10k 10000
ven_op0_0000_rh_s1_r10k en_op0_0000_rh_s1_r10k 0 pwl(0.0000e+00 0 1.1000e-08 0 1.1100e-08 {VDD} 3.4000e-08 {VDD} 3.4100e-08 0)
venb_op0_0000_rh_s1_r10k enb_op0_0000_rh_s1_r10k 0 pwl(0.0000e+00 {VDD} 1.1000e-08 {VDD} 1.1100e-08 0 3.4000e-08 0 3.4100e-08 {VDD})
vww_op0_0000_rh_s1_r10k wwl_op0_0000_rh_s1_r10k 0 pwl(0.0000e+00 0 1.2000e-08 0 1.2100e-08 {VDD} 3.2000e-08 {VDD} 3.2100e-08 0)
vwc_op0_0000_rh_s1_r10k wbc_op0_0000_rh_s1_r10k 0 pwl(0.0000e+00 0 1.2000e-08 0 1.2100e-08 {VDD} 3.4000e-08 {VDD} 3.4100e-08 0)
swb_op0_0000_rh_s1_r10k ref_op0_0000_rh_s1_r10k wbl_op0_0000_rh_s1_r10k wbc_op0_0000_rh_s1_r10k 0 swwbl
cwbl_op0_0000_rh_s1_r10k wbl_op0_0000_rh_s1_r10k 0 {C_WBL}
spa_op0_0000_rh_s1_r10k prea rbl_op0_0000_rh_s1_r10k ctl_op0_0000_rh_s1_r10k 0 swpre
spr_op0_0000_rh_s1_r10k pref ref_op0_0000_rh_s1_r10k ctl_op0_0000_rh_s1_r10k 0 swpre
crbl_op0_0000_rh_s1_r10k rbl_op0_0000_rh_s1_r10k 0 {C_RBL}
cref_op0_0000_rh_s1_r10k ref_op0_0000_rh_s1_r10k 0 {C_RBL}   $ ASSUMPTION: ideal matched dummy load
XMWR_op0_0000_rh_s1_r10k_0 sn_op0_0000_rh_s1_r10k_0 wwl_op0_0000_rh_s1_r10k wbl_op0_0000_rh_s1_r10k 0 sky130_fd_pr__nfet_01v8 L=0.15 W=0.42 nf=1 ad=0.1218 as=0.1218 pd=1.42 ps=1.42 nrd=0.69047619047619  nrs=0.69047619047619 sa=0 sb=0 sd=0 mult=1 m=1
XMRD_op0_0000_rh_s1_r10k_0 rbl_op0_0000_rh_s1_r10k sn_op0_0000_rh_s1_r10k_0 rwls_op0_0000_rh_s1_r10k 0 sky130_fd_pr__nfet_01v8 L=0.15 W=0.42 nf=1 ad=0.1218 as=0.1218 pd=1.42 ps=1.42 nrd=0.69047619047619  nrs=0.69047619047619 sa=0 sb=0 sd=0 mult=1 m=1
csn_op0_0000_rh_s1_r10k_0 sn_op0_0000_rh_s1_r10k_0 0 {C_SN}
XMWR_op0_0000_rh_s1_r10k_1 sn_op0_0000_rh_s1_r10k_1 wwl_des wbl_op0_0000_rh_s1_r10k 0 sky130_fd_pr__nfet_01v8 L=0.15 W=0.42 nf=1 ad=0.1218 as=0.1218 pd=1.42 ps=1.42 nrd=0.69047619047619  nrs=0.69047619047619 sa=0 sb=0 sd=0 mult=1 m=1
XMRD_op0_0000_rh_s1_r10k_1 rbl_op0_0000_rh_s1_r10k sn_op0_0000_rh_s1_r10k_1 rwl_des 0 sky130_fd_pr__nfet_01v8 L=0.15 W=0.42 nf=1 ad=0.1218 as=0.1218 pd=1.42 ps=1.42 nrd=0.69047619047619  nrs=0.69047619047619 sa=0 sb=0 sd=0 mult=1 m=1
csn_op0_0000_rh_s1_r10k_1 sn_op0_0000_rh_s1_r10k_1 0 {C_SN}
XMWR_op0_0000_rh_s1_r10k_2 sn_op0_0000_rh_s1_r10k_2 wwl_des wbl_op0_0000_rh_s1_r10k 0 sky130_fd_pr__nfet_01v8 L=0.15 W=0.42 nf=1 ad=0.1218 as=0.1218 pd=1.42 ps=1.42 nrd=0.69047619047619  nrs=0.69047619047619 sa=0 sb=0 sd=0 mult=1 m=1
XMRD_op0_0000_rh_s1_r10k_2 rbl_op0_0000_rh_s1_r10k sn_op0_0000_rh_s1_r10k_2 rwl_des 0 sky130_fd_pr__nfet_01v8 L=0.15 W=0.42 nf=1 ad=0.1218 as=0.1218 pd=1.42 ps=1.42 nrd=0.69047619047619  nrs=0.69047619047619 sa=0 sb=0 sd=0 mult=1 m=1
csn_op0_0000_rh_s1_r10k_2 sn_op0_0000_rh_s1_r10k_2 0 {C_SN}
XMWR_op0_0000_rh_s1_r10k_3 sn_op0_0000_rh_s1_r10k_3 wwl_des wbl_op0_0000_rh_s1_r10k 0 sky130_fd_pr__nfet_01v8 L=0.15 W=0.42 nf=1 ad=0.1218 as=0.1218 pd=1.42 ps=1.42 nrd=0.69047619047619  nrs=0.69047619047619 sa=0 sb=0 sd=0 mult=1 m=1
XMRD_op0_0000_rh_s1_r10k_3 rbl_op0_0000_rh_s1_r10k sn_op0_0000_rh_s1_r10k_3 rwl_des 0 sky130_fd_pr__nfet_01v8 L=0.15 W=0.42 nf=1 ad=0.1218 as=0.1218 pd=1.42 ps=1.42 nrd=0.69047619047619  nrs=0.69047619047619 sa=0 sb=0 sd=0 mult=1 m=1
csn_op0_0000_rh_s1_r10k_3 sn_op0_0000_rh_s1_r10k_3 0 {C_SN}
XMN1_op0_0000_rh_s1_r10k rbl_op0_0000_rh_s1_r10k ref_op0_0000_rh_s1_r10k vn_op0_0000_rh_s1_r10k 0 sky130_fd_pr__nfet_01v8 L=0.15 W=1 nf=1 ad=0.29 as=0.29 pd=2.58 ps=2.58 mult=1 m=1
XMN2_op0_0000_rh_s1_r10k ref_op0_0000_rh_s1_r10k rbl_op0_0000_rh_s1_r10k vn_op0_0000_rh_s1_r10k 0 sky130_fd_pr__nfet_01v8 L=0.15 W=1 nf=1 ad=0.29 as=0.29 pd=2.58 ps=2.58 mult=1 m=1
XMP1_op0_0000_rh_s1_r10k rbl_op0_0000_rh_s1_r10k ref_op0_0000_rh_s1_r10k vp_op0_0000_rh_s1_r10k vdd sky130_fd_pr__pfet_01v8 L=0.15 W=2 nf=1 ad=0.58 as=0.58 pd=4.58 ps=4.58 mult=1 m=1
XMP2_op0_0000_rh_s1_r10k ref_op0_0000_rh_s1_r10k rbl_op0_0000_rh_s1_r10k vp_op0_0000_rh_s1_r10k vdd sky130_fd_pr__pfet_01v8 L=0.15 W=2 nf=1 ad=0.58 as=0.58 pd=4.58 ps=4.58 mult=1 m=1
XMNF_op0_0000_rh_s1_r10k vn_op0_0000_rh_s1_r10k en_op0_0000_rh_s1_r10k 0 0 sky130_fd_pr__nfet_01v8 L=0.15 W=2 nf=1 ad=0.58 as=0.58 pd=4.58 ps=4.58 mult=1 m=1
XMPH_op0_0000_rh_s1_r10k vp_op0_0000_rh_s1_r10k enb_op0_0000_rh_s1_r10k vdd vdd sky130_fd_pr__pfet_01v8 L=0.15 W=4 nf=1 ad=1.16 as=1.16 pd=8.58 ps=8.58 mult=1 m=1
bd_op0_0000_rh_s1_r10k d_op0_0000_rh_s1_r10k 0 v=v(rbl_op0_0000_rh_s1_r10k)-v(ref_op0_0000_rh_s1_r10k)

* ---- instance 149: op1_0900_rh_s1_r100k (variant rh_s1_r100k; probe dec 11.9 ns, release 34 ns, meas 36 ns) ----
vctl_op1_0900_rh_s1_r100k ctl_op1_0900_rh_s1_r100k 0 pwl(0.0000e+00 {VDD} 2.0000e-09 {VDD} 2.1000e-09 0)
* RWL driver model (EXPERIMENTAL): slew 1 ns, series R 100000 ohm; cell pin = rwls_op1_0900_rh_s1_r100k
vrs_op1_0900_rh_s1_r100k rwlsrc_op1_0900_rh_s1_r100k 0 pwl(0.0000e+00 {VDD} 2.0000e-09 {VDD} 3.0000e-09 0 1.2000e-08 0 1.3000e-08 {VDD})
rdrv_op1_0900_rh_s1_r100k rwlsrc_op1_0900_rh_s1_r100k rwls_op1_0900_rh_s1_r100k 100000
ven_op1_0900_rh_s1_r100k en_op1_0900_rh_s1_r100k 0 pwl(0.0000e+00 0 1.1000e-08 0 1.1100e-08 {VDD} 3.4000e-08 {VDD} 3.4100e-08 0)
venb_op1_0900_rh_s1_r100k enb_op1_0900_rh_s1_r100k 0 pwl(0.0000e+00 {VDD} 1.1000e-08 {VDD} 1.1100e-08 0 3.4000e-08 0 3.4100e-08 {VDD})
vww_op1_0900_rh_s1_r100k wwl_op1_0900_rh_s1_r100k 0 pwl(0.0000e+00 0 1.2000e-08 0 1.2100e-08 {VDD} 3.2000e-08 {VDD} 3.2100e-08 0)
vwc_op1_0900_rh_s1_r100k wbc_op1_0900_rh_s1_r100k 0 pwl(0.0000e+00 0 1.2000e-08 0 1.2100e-08 {VDD} 3.4000e-08 {VDD} 3.4100e-08 0)
swb_op1_0900_rh_s1_r100k ref_op1_0900_rh_s1_r100k wbl_op1_0900_rh_s1_r100k wbc_op1_0900_rh_s1_r100k 0 swwbl
cwbl_op1_0900_rh_s1_r100k wbl_op1_0900_rh_s1_r100k 0 {C_WBL}
spa_op1_0900_rh_s1_r100k prea rbl_op1_0900_rh_s1_r100k ctl_op1_0900_rh_s1_r100k 0 swpre
spr_op1_0900_rh_s1_r100k pref ref_op1_0900_rh_s1_r100k ctl_op1_0900_rh_s1_r100k 0 swpre
crbl_op1_0900_rh_s1_r100k rbl_op1_0900_rh_s1_r100k 0 {C_RBL}
cref_op1_0900_rh_s1_r100k ref_op1_0900_rh_s1_r100k 0 {C_RBL}   $ ASSUMPTION: ideal matched dummy load
XMWR_op1_0900_rh_s1_r100k_0 sn_op1_0900_rh_s1_r100k_0 wwl_op1_0900_rh_s1_r100k wbl_op1_0900_rh_s1_r100k 0 sky130_fd_pr__nfet_01v8 L=0.15 W=0.42 nf=1 ad=0.1218 as=0.1218 pd=1.42 ps=1.42 nrd=0.69047619047619  nrs=0.69047619047619 sa=0 sb=0 sd=0 mult=1 m=1
XMRD_op1_0900_rh_s1_r100k_0 rbl_op1_0900_rh_s1_r100k sn_op1_0900_rh_s1_r100k_0 rwls_op1_0900_rh_s1_r100k 0 sky130_fd_pr__nfet_01v8 L=0.15 W=0.42 nf=1 ad=0.1218 as=0.1218 pd=1.42 ps=1.42 nrd=0.69047619047619  nrs=0.69047619047619 sa=0 sb=0 sd=0 mult=1 m=1
csn_op1_0900_rh_s1_r100k_0 sn_op1_0900_rh_s1_r100k_0 0 {C_SN}
XMWR_op1_0900_rh_s1_r100k_1 sn_op1_0900_rh_s1_r100k_1 wwl_des wbl_op1_0900_rh_s1_r100k 0 sky130_fd_pr__nfet_01v8 L=0.15 W=0.42 nf=1 ad=0.1218 as=0.1218 pd=1.42 ps=1.42 nrd=0.69047619047619  nrs=0.69047619047619 sa=0 sb=0 sd=0 mult=1 m=1
XMRD_op1_0900_rh_s1_r100k_1 rbl_op1_0900_rh_s1_r100k sn_op1_0900_rh_s1_r100k_1 rwl_des 0 sky130_fd_pr__nfet_01v8 L=0.15 W=0.42 nf=1 ad=0.1218 as=0.1218 pd=1.42 ps=1.42 nrd=0.69047619047619  nrs=0.69047619047619 sa=0 sb=0 sd=0 mult=1 m=1
csn_op1_0900_rh_s1_r100k_1 sn_op1_0900_rh_s1_r100k_1 0 {C_SN}
XMWR_op1_0900_rh_s1_r100k_2 sn_op1_0900_rh_s1_r100k_2 wwl_des wbl_op1_0900_rh_s1_r100k 0 sky130_fd_pr__nfet_01v8 L=0.15 W=0.42 nf=1 ad=0.1218 as=0.1218 pd=1.42 ps=1.42 nrd=0.69047619047619  nrs=0.69047619047619 sa=0 sb=0 sd=0 mult=1 m=1
XMRD_op1_0900_rh_s1_r100k_2 rbl_op1_0900_rh_s1_r100k sn_op1_0900_rh_s1_r100k_2 rwl_des 0 sky130_fd_pr__nfet_01v8 L=0.15 W=0.42 nf=1 ad=0.1218 as=0.1218 pd=1.42 ps=1.42 nrd=0.69047619047619  nrs=0.69047619047619 sa=0 sb=0 sd=0 mult=1 m=1
csn_op1_0900_rh_s1_r100k_2 sn_op1_0900_rh_s1_r100k_2 0 {C_SN}
XMWR_op1_0900_rh_s1_r100k_3 sn_op1_0900_rh_s1_r100k_3 wwl_des wbl_op1_0900_rh_s1_r100k 0 sky130_fd_pr__nfet_01v8 L=0.15 W=0.42 nf=1 ad=0.1218 as=0.1218 pd=1.42 ps=1.42 nrd=0.69047619047619  nrs=0.69047619047619 sa=0 sb=0 sd=0 mult=1 m=1
XMRD_op1_0900_rh_s1_r100k_3 rbl_op1_0900_rh_s1_r100k sn_op1_0900_rh_s1_r100k_3 rwl_des 0 sky130_fd_pr__nfet_01v8 L=0.15 W=0.42 nf=1 ad=0.1218 as=0.1218 pd=1.42 ps=1.42 nrd=0.69047619047619  nrs=0.69047619047619 sa=0 sb=0 sd=0 mult=1 m=1
csn_op1_0900_rh_s1_r100k_3 sn_op1_0900_rh_s1_r100k_3 0 {C_SN}
XMN1_op1_0900_rh_s1_r100k rbl_op1_0900_rh_s1_r100k ref_op1_0900_rh_s1_r100k vn_op1_0900_rh_s1_r100k 0 sky130_fd_pr__nfet_01v8 L=0.15 W=1 nf=1 ad=0.29 as=0.29 pd=2.58 ps=2.58 mult=1 m=1
XMN2_op1_0900_rh_s1_r100k ref_op1_0900_rh_s1_r100k rbl_op1_0900_rh_s1_r100k vn_op1_0900_rh_s1_r100k 0 sky130_fd_pr__nfet_01v8 L=0.15 W=1 nf=1 ad=0.29 as=0.29 pd=2.58 ps=2.58 mult=1 m=1
XMP1_op1_0900_rh_s1_r100k rbl_op1_0900_rh_s1_r100k ref_op1_0900_rh_s1_r100k vp_op1_0900_rh_s1_r100k vdd sky130_fd_pr__pfet_01v8 L=0.15 W=2 nf=1 ad=0.58 as=0.58 pd=4.58 ps=4.58 mult=1 m=1
XMP2_op1_0900_rh_s1_r100k ref_op1_0900_rh_s1_r100k rbl_op1_0900_rh_s1_r100k vp_op1_0900_rh_s1_r100k vdd sky130_fd_pr__pfet_01v8 L=0.15 W=2 nf=1 ad=0.58 as=0.58 pd=4.58 ps=4.58 mult=1 m=1
XMNF_op1_0900_rh_s1_r100k vn_op1_0900_rh_s1_r100k en_op1_0900_rh_s1_r100k 0 0 sky130_fd_pr__nfet_01v8 L=0.15 W=2 nf=1 ad=0.58 as=0.58 pd=4.58 ps=4.58 mult=1 m=1
XMPH_op1_0900_rh_s1_r100k vp_op1_0900_rh_s1_r100k enb_op1_0900_rh_s1_r100k vdd vdd sky130_fd_pr__pfet_01v8 L=0.15 W=4 nf=1 ad=1.16 as=1.16 pd=8.58 ps=8.58 mult=1 m=1
bd_op1_0900_rh_s1_r100k d_op1_0900_rh_s1_r100k 0 v=v(rbl_op1_0900_rh_s1_r100k)-v(ref_op1_0900_rh_s1_r100k)

* ---- instance 150: op1_1000_rh_s1_r100k (variant rh_s1_r100k; probe dec 11.9 ns, release 34 ns, meas 36 ns) ----
vctl_op1_1000_rh_s1_r100k ctl_op1_1000_rh_s1_r100k 0 pwl(0.0000e+00 {VDD} 2.0000e-09 {VDD} 2.1000e-09 0)
* RWL driver model (EXPERIMENTAL): slew 1 ns, series R 100000 ohm; cell pin = rwls_op1_1000_rh_s1_r100k
vrs_op1_1000_rh_s1_r100k rwlsrc_op1_1000_rh_s1_r100k 0 pwl(0.0000e+00 {VDD} 2.0000e-09 {VDD} 3.0000e-09 0 1.2000e-08 0 1.3000e-08 {VDD})
rdrv_op1_1000_rh_s1_r100k rwlsrc_op1_1000_rh_s1_r100k rwls_op1_1000_rh_s1_r100k 100000
ven_op1_1000_rh_s1_r100k en_op1_1000_rh_s1_r100k 0 pwl(0.0000e+00 0 1.1000e-08 0 1.1100e-08 {VDD} 3.4000e-08 {VDD} 3.4100e-08 0)
venb_op1_1000_rh_s1_r100k enb_op1_1000_rh_s1_r100k 0 pwl(0.0000e+00 {VDD} 1.1000e-08 {VDD} 1.1100e-08 0 3.4000e-08 0 3.4100e-08 {VDD})
vww_op1_1000_rh_s1_r100k wwl_op1_1000_rh_s1_r100k 0 pwl(0.0000e+00 0 1.2000e-08 0 1.2100e-08 {VDD} 3.2000e-08 {VDD} 3.2100e-08 0)
vwc_op1_1000_rh_s1_r100k wbc_op1_1000_rh_s1_r100k 0 pwl(0.0000e+00 0 1.2000e-08 0 1.2100e-08 {VDD} 3.4000e-08 {VDD} 3.4100e-08 0)
swb_op1_1000_rh_s1_r100k ref_op1_1000_rh_s1_r100k wbl_op1_1000_rh_s1_r100k wbc_op1_1000_rh_s1_r100k 0 swwbl
cwbl_op1_1000_rh_s1_r100k wbl_op1_1000_rh_s1_r100k 0 {C_WBL}
spa_op1_1000_rh_s1_r100k prea rbl_op1_1000_rh_s1_r100k ctl_op1_1000_rh_s1_r100k 0 swpre
spr_op1_1000_rh_s1_r100k pref ref_op1_1000_rh_s1_r100k ctl_op1_1000_rh_s1_r100k 0 swpre
crbl_op1_1000_rh_s1_r100k rbl_op1_1000_rh_s1_r100k 0 {C_RBL}
cref_op1_1000_rh_s1_r100k ref_op1_1000_rh_s1_r100k 0 {C_RBL}   $ ASSUMPTION: ideal matched dummy load
XMWR_op1_1000_rh_s1_r100k_0 sn_op1_1000_rh_s1_r100k_0 wwl_op1_1000_rh_s1_r100k wbl_op1_1000_rh_s1_r100k 0 sky130_fd_pr__nfet_01v8 L=0.15 W=0.42 nf=1 ad=0.1218 as=0.1218 pd=1.42 ps=1.42 nrd=0.69047619047619  nrs=0.69047619047619 sa=0 sb=0 sd=0 mult=1 m=1
XMRD_op1_1000_rh_s1_r100k_0 rbl_op1_1000_rh_s1_r100k sn_op1_1000_rh_s1_r100k_0 rwls_op1_1000_rh_s1_r100k 0 sky130_fd_pr__nfet_01v8 L=0.15 W=0.42 nf=1 ad=0.1218 as=0.1218 pd=1.42 ps=1.42 nrd=0.69047619047619  nrs=0.69047619047619 sa=0 sb=0 sd=0 mult=1 m=1
csn_op1_1000_rh_s1_r100k_0 sn_op1_1000_rh_s1_r100k_0 0 {C_SN}
XMWR_op1_1000_rh_s1_r100k_1 sn_op1_1000_rh_s1_r100k_1 wwl_des wbl_op1_1000_rh_s1_r100k 0 sky130_fd_pr__nfet_01v8 L=0.15 W=0.42 nf=1 ad=0.1218 as=0.1218 pd=1.42 ps=1.42 nrd=0.69047619047619  nrs=0.69047619047619 sa=0 sb=0 sd=0 mult=1 m=1
XMRD_op1_1000_rh_s1_r100k_1 rbl_op1_1000_rh_s1_r100k sn_op1_1000_rh_s1_r100k_1 rwl_des 0 sky130_fd_pr__nfet_01v8 L=0.15 W=0.42 nf=1 ad=0.1218 as=0.1218 pd=1.42 ps=1.42 nrd=0.69047619047619  nrs=0.69047619047619 sa=0 sb=0 sd=0 mult=1 m=1
csn_op1_1000_rh_s1_r100k_1 sn_op1_1000_rh_s1_r100k_1 0 {C_SN}
XMWR_op1_1000_rh_s1_r100k_2 sn_op1_1000_rh_s1_r100k_2 wwl_des wbl_op1_1000_rh_s1_r100k 0 sky130_fd_pr__nfet_01v8 L=0.15 W=0.42 nf=1 ad=0.1218 as=0.1218 pd=1.42 ps=1.42 nrd=0.69047619047619  nrs=0.69047619047619 sa=0 sb=0 sd=0 mult=1 m=1
XMRD_op1_1000_rh_s1_r100k_2 rbl_op1_1000_rh_s1_r100k sn_op1_1000_rh_s1_r100k_2 rwl_des 0 sky130_fd_pr__nfet_01v8 L=0.15 W=0.42 nf=1 ad=0.1218 as=0.1218 pd=1.42 ps=1.42 nrd=0.69047619047619  nrs=0.69047619047619 sa=0 sb=0 sd=0 mult=1 m=1
csn_op1_1000_rh_s1_r100k_2 sn_op1_1000_rh_s1_r100k_2 0 {C_SN}
XMWR_op1_1000_rh_s1_r100k_3 sn_op1_1000_rh_s1_r100k_3 wwl_des wbl_op1_1000_rh_s1_r100k 0 sky130_fd_pr__nfet_01v8 L=0.15 W=0.42 nf=1 ad=0.1218 as=0.1218 pd=1.42 ps=1.42 nrd=0.69047619047619  nrs=0.69047619047619 sa=0 sb=0 sd=0 mult=1 m=1
XMRD_op1_1000_rh_s1_r100k_3 rbl_op1_1000_rh_s1_r100k sn_op1_1000_rh_s1_r100k_3 rwl_des 0 sky130_fd_pr__nfet_01v8 L=0.15 W=0.42 nf=1 ad=0.1218 as=0.1218 pd=1.42 ps=1.42 nrd=0.69047619047619  nrs=0.69047619047619 sa=0 sb=0 sd=0 mult=1 m=1
csn_op1_1000_rh_s1_r100k_3 sn_op1_1000_rh_s1_r100k_3 0 {C_SN}
XMN1_op1_1000_rh_s1_r100k rbl_op1_1000_rh_s1_r100k ref_op1_1000_rh_s1_r100k vn_op1_1000_rh_s1_r100k 0 sky130_fd_pr__nfet_01v8 L=0.15 W=1 nf=1 ad=0.29 as=0.29 pd=2.58 ps=2.58 mult=1 m=1
XMN2_op1_1000_rh_s1_r100k ref_op1_1000_rh_s1_r100k rbl_op1_1000_rh_s1_r100k vn_op1_1000_rh_s1_r100k 0 sky130_fd_pr__nfet_01v8 L=0.15 W=1 nf=1 ad=0.29 as=0.29 pd=2.58 ps=2.58 mult=1 m=1
XMP1_op1_1000_rh_s1_r100k rbl_op1_1000_rh_s1_r100k ref_op1_1000_rh_s1_r100k vp_op1_1000_rh_s1_r100k vdd sky130_fd_pr__pfet_01v8 L=0.15 W=2 nf=1 ad=0.58 as=0.58 pd=4.58 ps=4.58 mult=1 m=1
XMP2_op1_1000_rh_s1_r100k ref_op1_1000_rh_s1_r100k rbl_op1_1000_rh_s1_r100k vp_op1_1000_rh_s1_r100k vdd sky130_fd_pr__pfet_01v8 L=0.15 W=2 nf=1 ad=0.58 as=0.58 pd=4.58 ps=4.58 mult=1 m=1
XMNF_op1_1000_rh_s1_r100k vn_op1_1000_rh_s1_r100k en_op1_1000_rh_s1_r100k 0 0 sky130_fd_pr__nfet_01v8 L=0.15 W=2 nf=1 ad=0.58 as=0.58 pd=4.58 ps=4.58 mult=1 m=1
XMPH_op1_1000_rh_s1_r100k vp_op1_1000_rh_s1_r100k enb_op1_1000_rh_s1_r100k vdd vdd sky130_fd_pr__pfet_01v8 L=0.15 W=4 nf=1 ad=1.16 as=1.16 pd=8.58 ps=8.58 mult=1 m=1
bd_op1_1000_rh_s1_r100k d_op1_1000_rh_s1_r100k 0 v=v(rbl_op1_1000_rh_s1_r100k)-v(ref_op1_1000_rh_s1_r100k)

* ---- instance 151: op0_n100_rh_s1_r100k (variant rh_s1_r100k; probe dec 11.9 ns, release 34 ns, meas 36 ns) ----
vctl_op0_n100_rh_s1_r100k ctl_op0_n100_rh_s1_r100k 0 pwl(0.0000e+00 {VDD} 2.0000e-09 {VDD} 2.1000e-09 0)
* RWL driver model (EXPERIMENTAL): slew 1 ns, series R 100000 ohm; cell pin = rwls_op0_n100_rh_s1_r100k
vrs_op0_n100_rh_s1_r100k rwlsrc_op0_n100_rh_s1_r100k 0 pwl(0.0000e+00 {VDD} 2.0000e-09 {VDD} 3.0000e-09 0 1.2000e-08 0 1.3000e-08 {VDD})
rdrv_op0_n100_rh_s1_r100k rwlsrc_op0_n100_rh_s1_r100k rwls_op0_n100_rh_s1_r100k 100000
ven_op0_n100_rh_s1_r100k en_op0_n100_rh_s1_r100k 0 pwl(0.0000e+00 0 1.1000e-08 0 1.1100e-08 {VDD} 3.4000e-08 {VDD} 3.4100e-08 0)
venb_op0_n100_rh_s1_r100k enb_op0_n100_rh_s1_r100k 0 pwl(0.0000e+00 {VDD} 1.1000e-08 {VDD} 1.1100e-08 0 3.4000e-08 0 3.4100e-08 {VDD})
vww_op0_n100_rh_s1_r100k wwl_op0_n100_rh_s1_r100k 0 pwl(0.0000e+00 0 1.2000e-08 0 1.2100e-08 {VDD} 3.2000e-08 {VDD} 3.2100e-08 0)
vwc_op0_n100_rh_s1_r100k wbc_op0_n100_rh_s1_r100k 0 pwl(0.0000e+00 0 1.2000e-08 0 1.2100e-08 {VDD} 3.4000e-08 {VDD} 3.4100e-08 0)
swb_op0_n100_rh_s1_r100k ref_op0_n100_rh_s1_r100k wbl_op0_n100_rh_s1_r100k wbc_op0_n100_rh_s1_r100k 0 swwbl
cwbl_op0_n100_rh_s1_r100k wbl_op0_n100_rh_s1_r100k 0 {C_WBL}
spa_op0_n100_rh_s1_r100k prea rbl_op0_n100_rh_s1_r100k ctl_op0_n100_rh_s1_r100k 0 swpre
spr_op0_n100_rh_s1_r100k pref ref_op0_n100_rh_s1_r100k ctl_op0_n100_rh_s1_r100k 0 swpre
crbl_op0_n100_rh_s1_r100k rbl_op0_n100_rh_s1_r100k 0 {C_RBL}
cref_op0_n100_rh_s1_r100k ref_op0_n100_rh_s1_r100k 0 {C_RBL}   $ ASSUMPTION: ideal matched dummy load
XMWR_op0_n100_rh_s1_r100k_0 sn_op0_n100_rh_s1_r100k_0 wwl_op0_n100_rh_s1_r100k wbl_op0_n100_rh_s1_r100k 0 sky130_fd_pr__nfet_01v8 L=0.15 W=0.42 nf=1 ad=0.1218 as=0.1218 pd=1.42 ps=1.42 nrd=0.69047619047619  nrs=0.69047619047619 sa=0 sb=0 sd=0 mult=1 m=1
XMRD_op0_n100_rh_s1_r100k_0 rbl_op0_n100_rh_s1_r100k sn_op0_n100_rh_s1_r100k_0 rwls_op0_n100_rh_s1_r100k 0 sky130_fd_pr__nfet_01v8 L=0.15 W=0.42 nf=1 ad=0.1218 as=0.1218 pd=1.42 ps=1.42 nrd=0.69047619047619  nrs=0.69047619047619 sa=0 sb=0 sd=0 mult=1 m=1
csn_op0_n100_rh_s1_r100k_0 sn_op0_n100_rh_s1_r100k_0 0 {C_SN}
XMWR_op0_n100_rh_s1_r100k_1 sn_op0_n100_rh_s1_r100k_1 wwl_des wbl_op0_n100_rh_s1_r100k 0 sky130_fd_pr__nfet_01v8 L=0.15 W=0.42 nf=1 ad=0.1218 as=0.1218 pd=1.42 ps=1.42 nrd=0.69047619047619  nrs=0.69047619047619 sa=0 sb=0 sd=0 mult=1 m=1
XMRD_op0_n100_rh_s1_r100k_1 rbl_op0_n100_rh_s1_r100k sn_op0_n100_rh_s1_r100k_1 rwl_des 0 sky130_fd_pr__nfet_01v8 L=0.15 W=0.42 nf=1 ad=0.1218 as=0.1218 pd=1.42 ps=1.42 nrd=0.69047619047619  nrs=0.69047619047619 sa=0 sb=0 sd=0 mult=1 m=1
csn_op0_n100_rh_s1_r100k_1 sn_op0_n100_rh_s1_r100k_1 0 {C_SN}
XMWR_op0_n100_rh_s1_r100k_2 sn_op0_n100_rh_s1_r100k_2 wwl_des wbl_op0_n100_rh_s1_r100k 0 sky130_fd_pr__nfet_01v8 L=0.15 W=0.42 nf=1 ad=0.1218 as=0.1218 pd=1.42 ps=1.42 nrd=0.69047619047619  nrs=0.69047619047619 sa=0 sb=0 sd=0 mult=1 m=1
XMRD_op0_n100_rh_s1_r100k_2 rbl_op0_n100_rh_s1_r100k sn_op0_n100_rh_s1_r100k_2 rwl_des 0 sky130_fd_pr__nfet_01v8 L=0.15 W=0.42 nf=1 ad=0.1218 as=0.1218 pd=1.42 ps=1.42 nrd=0.69047619047619  nrs=0.69047619047619 sa=0 sb=0 sd=0 mult=1 m=1
csn_op0_n100_rh_s1_r100k_2 sn_op0_n100_rh_s1_r100k_2 0 {C_SN}
XMWR_op0_n100_rh_s1_r100k_3 sn_op0_n100_rh_s1_r100k_3 wwl_des wbl_op0_n100_rh_s1_r100k 0 sky130_fd_pr__nfet_01v8 L=0.15 W=0.42 nf=1 ad=0.1218 as=0.1218 pd=1.42 ps=1.42 nrd=0.69047619047619  nrs=0.69047619047619 sa=0 sb=0 sd=0 mult=1 m=1
XMRD_op0_n100_rh_s1_r100k_3 rbl_op0_n100_rh_s1_r100k sn_op0_n100_rh_s1_r100k_3 rwl_des 0 sky130_fd_pr__nfet_01v8 L=0.15 W=0.42 nf=1 ad=0.1218 as=0.1218 pd=1.42 ps=1.42 nrd=0.69047619047619  nrs=0.69047619047619 sa=0 sb=0 sd=0 mult=1 m=1
csn_op0_n100_rh_s1_r100k_3 sn_op0_n100_rh_s1_r100k_3 0 {C_SN}
XMN1_op0_n100_rh_s1_r100k rbl_op0_n100_rh_s1_r100k ref_op0_n100_rh_s1_r100k vn_op0_n100_rh_s1_r100k 0 sky130_fd_pr__nfet_01v8 L=0.15 W=1 nf=1 ad=0.29 as=0.29 pd=2.58 ps=2.58 mult=1 m=1
XMN2_op0_n100_rh_s1_r100k ref_op0_n100_rh_s1_r100k rbl_op0_n100_rh_s1_r100k vn_op0_n100_rh_s1_r100k 0 sky130_fd_pr__nfet_01v8 L=0.15 W=1 nf=1 ad=0.29 as=0.29 pd=2.58 ps=2.58 mult=1 m=1
XMP1_op0_n100_rh_s1_r100k rbl_op0_n100_rh_s1_r100k ref_op0_n100_rh_s1_r100k vp_op0_n100_rh_s1_r100k vdd sky130_fd_pr__pfet_01v8 L=0.15 W=2 nf=1 ad=0.58 as=0.58 pd=4.58 ps=4.58 mult=1 m=1
XMP2_op0_n100_rh_s1_r100k ref_op0_n100_rh_s1_r100k rbl_op0_n100_rh_s1_r100k vp_op0_n100_rh_s1_r100k vdd sky130_fd_pr__pfet_01v8 L=0.15 W=2 nf=1 ad=0.58 as=0.58 pd=4.58 ps=4.58 mult=1 m=1
XMNF_op0_n100_rh_s1_r100k vn_op0_n100_rh_s1_r100k en_op0_n100_rh_s1_r100k 0 0 sky130_fd_pr__nfet_01v8 L=0.15 W=2 nf=1 ad=0.58 as=0.58 pd=4.58 ps=4.58 mult=1 m=1
XMPH_op0_n100_rh_s1_r100k vp_op0_n100_rh_s1_r100k enb_op0_n100_rh_s1_r100k vdd vdd sky130_fd_pr__pfet_01v8 L=0.15 W=4 nf=1 ad=1.16 as=1.16 pd=8.58 ps=8.58 mult=1 m=1
bd_op0_n100_rh_s1_r100k d_op0_n100_rh_s1_r100k 0 v=v(rbl_op0_n100_rh_s1_r100k)-v(ref_op0_n100_rh_s1_r100k)

* ---- instance 152: op0_0000_rh_s1_r100k (variant rh_s1_r100k; probe dec 11.9 ns, release 34 ns, meas 36 ns) ----
vctl_op0_0000_rh_s1_r100k ctl_op0_0000_rh_s1_r100k 0 pwl(0.0000e+00 {VDD} 2.0000e-09 {VDD} 2.1000e-09 0)
* RWL driver model (EXPERIMENTAL): slew 1 ns, series R 100000 ohm; cell pin = rwls_op0_0000_rh_s1_r100k
vrs_op0_0000_rh_s1_r100k rwlsrc_op0_0000_rh_s1_r100k 0 pwl(0.0000e+00 {VDD} 2.0000e-09 {VDD} 3.0000e-09 0 1.2000e-08 0 1.3000e-08 {VDD})
rdrv_op0_0000_rh_s1_r100k rwlsrc_op0_0000_rh_s1_r100k rwls_op0_0000_rh_s1_r100k 100000
ven_op0_0000_rh_s1_r100k en_op0_0000_rh_s1_r100k 0 pwl(0.0000e+00 0 1.1000e-08 0 1.1100e-08 {VDD} 3.4000e-08 {VDD} 3.4100e-08 0)
venb_op0_0000_rh_s1_r100k enb_op0_0000_rh_s1_r100k 0 pwl(0.0000e+00 {VDD} 1.1000e-08 {VDD} 1.1100e-08 0 3.4000e-08 0 3.4100e-08 {VDD})
vww_op0_0000_rh_s1_r100k wwl_op0_0000_rh_s1_r100k 0 pwl(0.0000e+00 0 1.2000e-08 0 1.2100e-08 {VDD} 3.2000e-08 {VDD} 3.2100e-08 0)
vwc_op0_0000_rh_s1_r100k wbc_op0_0000_rh_s1_r100k 0 pwl(0.0000e+00 0 1.2000e-08 0 1.2100e-08 {VDD} 3.4000e-08 {VDD} 3.4100e-08 0)
swb_op0_0000_rh_s1_r100k ref_op0_0000_rh_s1_r100k wbl_op0_0000_rh_s1_r100k wbc_op0_0000_rh_s1_r100k 0 swwbl
cwbl_op0_0000_rh_s1_r100k wbl_op0_0000_rh_s1_r100k 0 {C_WBL}
spa_op0_0000_rh_s1_r100k prea rbl_op0_0000_rh_s1_r100k ctl_op0_0000_rh_s1_r100k 0 swpre
spr_op0_0000_rh_s1_r100k pref ref_op0_0000_rh_s1_r100k ctl_op0_0000_rh_s1_r100k 0 swpre
crbl_op0_0000_rh_s1_r100k rbl_op0_0000_rh_s1_r100k 0 {C_RBL}
cref_op0_0000_rh_s1_r100k ref_op0_0000_rh_s1_r100k 0 {C_RBL}   $ ASSUMPTION: ideal matched dummy load
XMWR_op0_0000_rh_s1_r100k_0 sn_op0_0000_rh_s1_r100k_0 wwl_op0_0000_rh_s1_r100k wbl_op0_0000_rh_s1_r100k 0 sky130_fd_pr__nfet_01v8 L=0.15 W=0.42 nf=1 ad=0.1218 as=0.1218 pd=1.42 ps=1.42 nrd=0.69047619047619  nrs=0.69047619047619 sa=0 sb=0 sd=0 mult=1 m=1
XMRD_op0_0000_rh_s1_r100k_0 rbl_op0_0000_rh_s1_r100k sn_op0_0000_rh_s1_r100k_0 rwls_op0_0000_rh_s1_r100k 0 sky130_fd_pr__nfet_01v8 L=0.15 W=0.42 nf=1 ad=0.1218 as=0.1218 pd=1.42 ps=1.42 nrd=0.69047619047619  nrs=0.69047619047619 sa=0 sb=0 sd=0 mult=1 m=1
csn_op0_0000_rh_s1_r100k_0 sn_op0_0000_rh_s1_r100k_0 0 {C_SN}
XMWR_op0_0000_rh_s1_r100k_1 sn_op0_0000_rh_s1_r100k_1 wwl_des wbl_op0_0000_rh_s1_r100k 0 sky130_fd_pr__nfet_01v8 L=0.15 W=0.42 nf=1 ad=0.1218 as=0.1218 pd=1.42 ps=1.42 nrd=0.69047619047619  nrs=0.69047619047619 sa=0 sb=0 sd=0 mult=1 m=1
XMRD_op0_0000_rh_s1_r100k_1 rbl_op0_0000_rh_s1_r100k sn_op0_0000_rh_s1_r100k_1 rwl_des 0 sky130_fd_pr__nfet_01v8 L=0.15 W=0.42 nf=1 ad=0.1218 as=0.1218 pd=1.42 ps=1.42 nrd=0.69047619047619  nrs=0.69047619047619 sa=0 sb=0 sd=0 mult=1 m=1
csn_op0_0000_rh_s1_r100k_1 sn_op0_0000_rh_s1_r100k_1 0 {C_SN}
XMWR_op0_0000_rh_s1_r100k_2 sn_op0_0000_rh_s1_r100k_2 wwl_des wbl_op0_0000_rh_s1_r100k 0 sky130_fd_pr__nfet_01v8 L=0.15 W=0.42 nf=1 ad=0.1218 as=0.1218 pd=1.42 ps=1.42 nrd=0.69047619047619  nrs=0.69047619047619 sa=0 sb=0 sd=0 mult=1 m=1
XMRD_op0_0000_rh_s1_r100k_2 rbl_op0_0000_rh_s1_r100k sn_op0_0000_rh_s1_r100k_2 rwl_des 0 sky130_fd_pr__nfet_01v8 L=0.15 W=0.42 nf=1 ad=0.1218 as=0.1218 pd=1.42 ps=1.42 nrd=0.69047619047619  nrs=0.69047619047619 sa=0 sb=0 sd=0 mult=1 m=1
csn_op0_0000_rh_s1_r100k_2 sn_op0_0000_rh_s1_r100k_2 0 {C_SN}
XMWR_op0_0000_rh_s1_r100k_3 sn_op0_0000_rh_s1_r100k_3 wwl_des wbl_op0_0000_rh_s1_r100k 0 sky130_fd_pr__nfet_01v8 L=0.15 W=0.42 nf=1 ad=0.1218 as=0.1218 pd=1.42 ps=1.42 nrd=0.69047619047619  nrs=0.69047619047619 sa=0 sb=0 sd=0 mult=1 m=1
XMRD_op0_0000_rh_s1_r100k_3 rbl_op0_0000_rh_s1_r100k sn_op0_0000_rh_s1_r100k_3 rwl_des 0 sky130_fd_pr__nfet_01v8 L=0.15 W=0.42 nf=1 ad=0.1218 as=0.1218 pd=1.42 ps=1.42 nrd=0.69047619047619  nrs=0.69047619047619 sa=0 sb=0 sd=0 mult=1 m=1
csn_op0_0000_rh_s1_r100k_3 sn_op0_0000_rh_s1_r100k_3 0 {C_SN}
XMN1_op0_0000_rh_s1_r100k rbl_op0_0000_rh_s1_r100k ref_op0_0000_rh_s1_r100k vn_op0_0000_rh_s1_r100k 0 sky130_fd_pr__nfet_01v8 L=0.15 W=1 nf=1 ad=0.29 as=0.29 pd=2.58 ps=2.58 mult=1 m=1
XMN2_op0_0000_rh_s1_r100k ref_op0_0000_rh_s1_r100k rbl_op0_0000_rh_s1_r100k vn_op0_0000_rh_s1_r100k 0 sky130_fd_pr__nfet_01v8 L=0.15 W=1 nf=1 ad=0.29 as=0.29 pd=2.58 ps=2.58 mult=1 m=1
XMP1_op0_0000_rh_s1_r100k rbl_op0_0000_rh_s1_r100k ref_op0_0000_rh_s1_r100k vp_op0_0000_rh_s1_r100k vdd sky130_fd_pr__pfet_01v8 L=0.15 W=2 nf=1 ad=0.58 as=0.58 pd=4.58 ps=4.58 mult=1 m=1
XMP2_op0_0000_rh_s1_r100k ref_op0_0000_rh_s1_r100k rbl_op0_0000_rh_s1_r100k vp_op0_0000_rh_s1_r100k vdd sky130_fd_pr__pfet_01v8 L=0.15 W=2 nf=1 ad=0.58 as=0.58 pd=4.58 ps=4.58 mult=1 m=1
XMNF_op0_0000_rh_s1_r100k vn_op0_0000_rh_s1_r100k en_op0_0000_rh_s1_r100k 0 0 sky130_fd_pr__nfet_01v8 L=0.15 W=2 nf=1 ad=0.58 as=0.58 pd=4.58 ps=4.58 mult=1 m=1
XMPH_op0_0000_rh_s1_r100k vp_op0_0000_rh_s1_r100k enb_op0_0000_rh_s1_r100k vdd vdd sky130_fd_pr__pfet_01v8 L=0.15 W=4 nf=1 ad=1.16 as=1.16 pd=8.58 ps=8.58 mult=1 m=1
bd_op0_0000_rh_s1_r100k d_op0_0000_rh_s1_r100k 0 v=v(rbl_op0_0000_rh_s1_r100k)-v(ref_op0_0000_rh_s1_r100k)

* ---- instance 153: op1_0900_rh_s2_r10k (variant rh_s2_r10k; probe dec 11.9 ns, release 34 ns, meas 36 ns) ----
vctl_op1_0900_rh_s2_r10k ctl_op1_0900_rh_s2_r10k 0 pwl(0.0000e+00 {VDD} 2.0000e-09 {VDD} 2.1000e-09 0)
* RWL driver model (EXPERIMENTAL): slew 2 ns, series R 10000 ohm; cell pin = rwls_op1_0900_rh_s2_r10k
vrs_op1_0900_rh_s2_r10k rwlsrc_op1_0900_rh_s2_r10k 0 pwl(0.0000e+00 {VDD} 2.0000e-09 {VDD} 4.0000e-09 0 1.2000e-08 0 1.4000e-08 {VDD})
rdrv_op1_0900_rh_s2_r10k rwlsrc_op1_0900_rh_s2_r10k rwls_op1_0900_rh_s2_r10k 10000
ven_op1_0900_rh_s2_r10k en_op1_0900_rh_s2_r10k 0 pwl(0.0000e+00 0 1.1000e-08 0 1.1100e-08 {VDD} 3.4000e-08 {VDD} 3.4100e-08 0)
venb_op1_0900_rh_s2_r10k enb_op1_0900_rh_s2_r10k 0 pwl(0.0000e+00 {VDD} 1.1000e-08 {VDD} 1.1100e-08 0 3.4000e-08 0 3.4100e-08 {VDD})
vww_op1_0900_rh_s2_r10k wwl_op1_0900_rh_s2_r10k 0 pwl(0.0000e+00 0 1.2000e-08 0 1.2100e-08 {VDD} 3.2000e-08 {VDD} 3.2100e-08 0)
vwc_op1_0900_rh_s2_r10k wbc_op1_0900_rh_s2_r10k 0 pwl(0.0000e+00 0 1.2000e-08 0 1.2100e-08 {VDD} 3.4000e-08 {VDD} 3.4100e-08 0)
swb_op1_0900_rh_s2_r10k ref_op1_0900_rh_s2_r10k wbl_op1_0900_rh_s2_r10k wbc_op1_0900_rh_s2_r10k 0 swwbl
cwbl_op1_0900_rh_s2_r10k wbl_op1_0900_rh_s2_r10k 0 {C_WBL}
spa_op1_0900_rh_s2_r10k prea rbl_op1_0900_rh_s2_r10k ctl_op1_0900_rh_s2_r10k 0 swpre
spr_op1_0900_rh_s2_r10k pref ref_op1_0900_rh_s2_r10k ctl_op1_0900_rh_s2_r10k 0 swpre
crbl_op1_0900_rh_s2_r10k rbl_op1_0900_rh_s2_r10k 0 {C_RBL}
cref_op1_0900_rh_s2_r10k ref_op1_0900_rh_s2_r10k 0 {C_RBL}   $ ASSUMPTION: ideal matched dummy load
XMWR_op1_0900_rh_s2_r10k_0 sn_op1_0900_rh_s2_r10k_0 wwl_op1_0900_rh_s2_r10k wbl_op1_0900_rh_s2_r10k 0 sky130_fd_pr__nfet_01v8 L=0.15 W=0.42 nf=1 ad=0.1218 as=0.1218 pd=1.42 ps=1.42 nrd=0.69047619047619  nrs=0.69047619047619 sa=0 sb=0 sd=0 mult=1 m=1
XMRD_op1_0900_rh_s2_r10k_0 rbl_op1_0900_rh_s2_r10k sn_op1_0900_rh_s2_r10k_0 rwls_op1_0900_rh_s2_r10k 0 sky130_fd_pr__nfet_01v8 L=0.15 W=0.42 nf=1 ad=0.1218 as=0.1218 pd=1.42 ps=1.42 nrd=0.69047619047619  nrs=0.69047619047619 sa=0 sb=0 sd=0 mult=1 m=1
csn_op1_0900_rh_s2_r10k_0 sn_op1_0900_rh_s2_r10k_0 0 {C_SN}
XMWR_op1_0900_rh_s2_r10k_1 sn_op1_0900_rh_s2_r10k_1 wwl_des wbl_op1_0900_rh_s2_r10k 0 sky130_fd_pr__nfet_01v8 L=0.15 W=0.42 nf=1 ad=0.1218 as=0.1218 pd=1.42 ps=1.42 nrd=0.69047619047619  nrs=0.69047619047619 sa=0 sb=0 sd=0 mult=1 m=1
XMRD_op1_0900_rh_s2_r10k_1 rbl_op1_0900_rh_s2_r10k sn_op1_0900_rh_s2_r10k_1 rwl_des 0 sky130_fd_pr__nfet_01v8 L=0.15 W=0.42 nf=1 ad=0.1218 as=0.1218 pd=1.42 ps=1.42 nrd=0.69047619047619  nrs=0.69047619047619 sa=0 sb=0 sd=0 mult=1 m=1
csn_op1_0900_rh_s2_r10k_1 sn_op1_0900_rh_s2_r10k_1 0 {C_SN}
XMWR_op1_0900_rh_s2_r10k_2 sn_op1_0900_rh_s2_r10k_2 wwl_des wbl_op1_0900_rh_s2_r10k 0 sky130_fd_pr__nfet_01v8 L=0.15 W=0.42 nf=1 ad=0.1218 as=0.1218 pd=1.42 ps=1.42 nrd=0.69047619047619  nrs=0.69047619047619 sa=0 sb=0 sd=0 mult=1 m=1
XMRD_op1_0900_rh_s2_r10k_2 rbl_op1_0900_rh_s2_r10k sn_op1_0900_rh_s2_r10k_2 rwl_des 0 sky130_fd_pr__nfet_01v8 L=0.15 W=0.42 nf=1 ad=0.1218 as=0.1218 pd=1.42 ps=1.42 nrd=0.69047619047619  nrs=0.69047619047619 sa=0 sb=0 sd=0 mult=1 m=1
csn_op1_0900_rh_s2_r10k_2 sn_op1_0900_rh_s2_r10k_2 0 {C_SN}
XMWR_op1_0900_rh_s2_r10k_3 sn_op1_0900_rh_s2_r10k_3 wwl_des wbl_op1_0900_rh_s2_r10k 0 sky130_fd_pr__nfet_01v8 L=0.15 W=0.42 nf=1 ad=0.1218 as=0.1218 pd=1.42 ps=1.42 nrd=0.69047619047619  nrs=0.69047619047619 sa=0 sb=0 sd=0 mult=1 m=1
XMRD_op1_0900_rh_s2_r10k_3 rbl_op1_0900_rh_s2_r10k sn_op1_0900_rh_s2_r10k_3 rwl_des 0 sky130_fd_pr__nfet_01v8 L=0.15 W=0.42 nf=1 ad=0.1218 as=0.1218 pd=1.42 ps=1.42 nrd=0.69047619047619  nrs=0.69047619047619 sa=0 sb=0 sd=0 mult=1 m=1
csn_op1_0900_rh_s2_r10k_3 sn_op1_0900_rh_s2_r10k_3 0 {C_SN}
XMN1_op1_0900_rh_s2_r10k rbl_op1_0900_rh_s2_r10k ref_op1_0900_rh_s2_r10k vn_op1_0900_rh_s2_r10k 0 sky130_fd_pr__nfet_01v8 L=0.15 W=1 nf=1 ad=0.29 as=0.29 pd=2.58 ps=2.58 mult=1 m=1
XMN2_op1_0900_rh_s2_r10k ref_op1_0900_rh_s2_r10k rbl_op1_0900_rh_s2_r10k vn_op1_0900_rh_s2_r10k 0 sky130_fd_pr__nfet_01v8 L=0.15 W=1 nf=1 ad=0.29 as=0.29 pd=2.58 ps=2.58 mult=1 m=1
XMP1_op1_0900_rh_s2_r10k rbl_op1_0900_rh_s2_r10k ref_op1_0900_rh_s2_r10k vp_op1_0900_rh_s2_r10k vdd sky130_fd_pr__pfet_01v8 L=0.15 W=2 nf=1 ad=0.58 as=0.58 pd=4.58 ps=4.58 mult=1 m=1
XMP2_op1_0900_rh_s2_r10k ref_op1_0900_rh_s2_r10k rbl_op1_0900_rh_s2_r10k vp_op1_0900_rh_s2_r10k vdd sky130_fd_pr__pfet_01v8 L=0.15 W=2 nf=1 ad=0.58 as=0.58 pd=4.58 ps=4.58 mult=1 m=1
XMNF_op1_0900_rh_s2_r10k vn_op1_0900_rh_s2_r10k en_op1_0900_rh_s2_r10k 0 0 sky130_fd_pr__nfet_01v8 L=0.15 W=2 nf=1 ad=0.58 as=0.58 pd=4.58 ps=4.58 mult=1 m=1
XMPH_op1_0900_rh_s2_r10k vp_op1_0900_rh_s2_r10k enb_op1_0900_rh_s2_r10k vdd vdd sky130_fd_pr__pfet_01v8 L=0.15 W=4 nf=1 ad=1.16 as=1.16 pd=8.58 ps=8.58 mult=1 m=1
bd_op1_0900_rh_s2_r10k d_op1_0900_rh_s2_r10k 0 v=v(rbl_op1_0900_rh_s2_r10k)-v(ref_op1_0900_rh_s2_r10k)

* ---- instance 154: op1_1000_rh_s2_r10k (variant rh_s2_r10k; probe dec 11.9 ns, release 34 ns, meas 36 ns) ----
vctl_op1_1000_rh_s2_r10k ctl_op1_1000_rh_s2_r10k 0 pwl(0.0000e+00 {VDD} 2.0000e-09 {VDD} 2.1000e-09 0)
* RWL driver model (EXPERIMENTAL): slew 2 ns, series R 10000 ohm; cell pin = rwls_op1_1000_rh_s2_r10k
vrs_op1_1000_rh_s2_r10k rwlsrc_op1_1000_rh_s2_r10k 0 pwl(0.0000e+00 {VDD} 2.0000e-09 {VDD} 4.0000e-09 0 1.2000e-08 0 1.4000e-08 {VDD})
rdrv_op1_1000_rh_s2_r10k rwlsrc_op1_1000_rh_s2_r10k rwls_op1_1000_rh_s2_r10k 10000
ven_op1_1000_rh_s2_r10k en_op1_1000_rh_s2_r10k 0 pwl(0.0000e+00 0 1.1000e-08 0 1.1100e-08 {VDD} 3.4000e-08 {VDD} 3.4100e-08 0)
venb_op1_1000_rh_s2_r10k enb_op1_1000_rh_s2_r10k 0 pwl(0.0000e+00 {VDD} 1.1000e-08 {VDD} 1.1100e-08 0 3.4000e-08 0 3.4100e-08 {VDD})
vww_op1_1000_rh_s2_r10k wwl_op1_1000_rh_s2_r10k 0 pwl(0.0000e+00 0 1.2000e-08 0 1.2100e-08 {VDD} 3.2000e-08 {VDD} 3.2100e-08 0)
vwc_op1_1000_rh_s2_r10k wbc_op1_1000_rh_s2_r10k 0 pwl(0.0000e+00 0 1.2000e-08 0 1.2100e-08 {VDD} 3.4000e-08 {VDD} 3.4100e-08 0)
swb_op1_1000_rh_s2_r10k ref_op1_1000_rh_s2_r10k wbl_op1_1000_rh_s2_r10k wbc_op1_1000_rh_s2_r10k 0 swwbl
cwbl_op1_1000_rh_s2_r10k wbl_op1_1000_rh_s2_r10k 0 {C_WBL}
spa_op1_1000_rh_s2_r10k prea rbl_op1_1000_rh_s2_r10k ctl_op1_1000_rh_s2_r10k 0 swpre
spr_op1_1000_rh_s2_r10k pref ref_op1_1000_rh_s2_r10k ctl_op1_1000_rh_s2_r10k 0 swpre
crbl_op1_1000_rh_s2_r10k rbl_op1_1000_rh_s2_r10k 0 {C_RBL}
cref_op1_1000_rh_s2_r10k ref_op1_1000_rh_s2_r10k 0 {C_RBL}   $ ASSUMPTION: ideal matched dummy load
XMWR_op1_1000_rh_s2_r10k_0 sn_op1_1000_rh_s2_r10k_0 wwl_op1_1000_rh_s2_r10k wbl_op1_1000_rh_s2_r10k 0 sky130_fd_pr__nfet_01v8 L=0.15 W=0.42 nf=1 ad=0.1218 as=0.1218 pd=1.42 ps=1.42 nrd=0.69047619047619  nrs=0.69047619047619 sa=0 sb=0 sd=0 mult=1 m=1
XMRD_op1_1000_rh_s2_r10k_0 rbl_op1_1000_rh_s2_r10k sn_op1_1000_rh_s2_r10k_0 rwls_op1_1000_rh_s2_r10k 0 sky130_fd_pr__nfet_01v8 L=0.15 W=0.42 nf=1 ad=0.1218 as=0.1218 pd=1.42 ps=1.42 nrd=0.69047619047619  nrs=0.69047619047619 sa=0 sb=0 sd=0 mult=1 m=1
csn_op1_1000_rh_s2_r10k_0 sn_op1_1000_rh_s2_r10k_0 0 {C_SN}
XMWR_op1_1000_rh_s2_r10k_1 sn_op1_1000_rh_s2_r10k_1 wwl_des wbl_op1_1000_rh_s2_r10k 0 sky130_fd_pr__nfet_01v8 L=0.15 W=0.42 nf=1 ad=0.1218 as=0.1218 pd=1.42 ps=1.42 nrd=0.69047619047619  nrs=0.69047619047619 sa=0 sb=0 sd=0 mult=1 m=1
XMRD_op1_1000_rh_s2_r10k_1 rbl_op1_1000_rh_s2_r10k sn_op1_1000_rh_s2_r10k_1 rwl_des 0 sky130_fd_pr__nfet_01v8 L=0.15 W=0.42 nf=1 ad=0.1218 as=0.1218 pd=1.42 ps=1.42 nrd=0.69047619047619  nrs=0.69047619047619 sa=0 sb=0 sd=0 mult=1 m=1
csn_op1_1000_rh_s2_r10k_1 sn_op1_1000_rh_s2_r10k_1 0 {C_SN}
XMWR_op1_1000_rh_s2_r10k_2 sn_op1_1000_rh_s2_r10k_2 wwl_des wbl_op1_1000_rh_s2_r10k 0 sky130_fd_pr__nfet_01v8 L=0.15 W=0.42 nf=1 ad=0.1218 as=0.1218 pd=1.42 ps=1.42 nrd=0.69047619047619  nrs=0.69047619047619 sa=0 sb=0 sd=0 mult=1 m=1
XMRD_op1_1000_rh_s2_r10k_2 rbl_op1_1000_rh_s2_r10k sn_op1_1000_rh_s2_r10k_2 rwl_des 0 sky130_fd_pr__nfet_01v8 L=0.15 W=0.42 nf=1 ad=0.1218 as=0.1218 pd=1.42 ps=1.42 nrd=0.69047619047619  nrs=0.69047619047619 sa=0 sb=0 sd=0 mult=1 m=1
csn_op1_1000_rh_s2_r10k_2 sn_op1_1000_rh_s2_r10k_2 0 {C_SN}
XMWR_op1_1000_rh_s2_r10k_3 sn_op1_1000_rh_s2_r10k_3 wwl_des wbl_op1_1000_rh_s2_r10k 0 sky130_fd_pr__nfet_01v8 L=0.15 W=0.42 nf=1 ad=0.1218 as=0.1218 pd=1.42 ps=1.42 nrd=0.69047619047619  nrs=0.69047619047619 sa=0 sb=0 sd=0 mult=1 m=1
XMRD_op1_1000_rh_s2_r10k_3 rbl_op1_1000_rh_s2_r10k sn_op1_1000_rh_s2_r10k_3 rwl_des 0 sky130_fd_pr__nfet_01v8 L=0.15 W=0.42 nf=1 ad=0.1218 as=0.1218 pd=1.42 ps=1.42 nrd=0.69047619047619  nrs=0.69047619047619 sa=0 sb=0 sd=0 mult=1 m=1
csn_op1_1000_rh_s2_r10k_3 sn_op1_1000_rh_s2_r10k_3 0 {C_SN}
XMN1_op1_1000_rh_s2_r10k rbl_op1_1000_rh_s2_r10k ref_op1_1000_rh_s2_r10k vn_op1_1000_rh_s2_r10k 0 sky130_fd_pr__nfet_01v8 L=0.15 W=1 nf=1 ad=0.29 as=0.29 pd=2.58 ps=2.58 mult=1 m=1
XMN2_op1_1000_rh_s2_r10k ref_op1_1000_rh_s2_r10k rbl_op1_1000_rh_s2_r10k vn_op1_1000_rh_s2_r10k 0 sky130_fd_pr__nfet_01v8 L=0.15 W=1 nf=1 ad=0.29 as=0.29 pd=2.58 ps=2.58 mult=1 m=1
XMP1_op1_1000_rh_s2_r10k rbl_op1_1000_rh_s2_r10k ref_op1_1000_rh_s2_r10k vp_op1_1000_rh_s2_r10k vdd sky130_fd_pr__pfet_01v8 L=0.15 W=2 nf=1 ad=0.58 as=0.58 pd=4.58 ps=4.58 mult=1 m=1
XMP2_op1_1000_rh_s2_r10k ref_op1_1000_rh_s2_r10k rbl_op1_1000_rh_s2_r10k vp_op1_1000_rh_s2_r10k vdd sky130_fd_pr__pfet_01v8 L=0.15 W=2 nf=1 ad=0.58 as=0.58 pd=4.58 ps=4.58 mult=1 m=1
XMNF_op1_1000_rh_s2_r10k vn_op1_1000_rh_s2_r10k en_op1_1000_rh_s2_r10k 0 0 sky130_fd_pr__nfet_01v8 L=0.15 W=2 nf=1 ad=0.58 as=0.58 pd=4.58 ps=4.58 mult=1 m=1
XMPH_op1_1000_rh_s2_r10k vp_op1_1000_rh_s2_r10k enb_op1_1000_rh_s2_r10k vdd vdd sky130_fd_pr__pfet_01v8 L=0.15 W=4 nf=1 ad=1.16 as=1.16 pd=8.58 ps=8.58 mult=1 m=1
bd_op1_1000_rh_s2_r10k d_op1_1000_rh_s2_r10k 0 v=v(rbl_op1_1000_rh_s2_r10k)-v(ref_op1_1000_rh_s2_r10k)

* ---- instance 155: op0_n100_rh_s2_r10k (variant rh_s2_r10k; probe dec 11.9 ns, release 34 ns, meas 36 ns) ----
vctl_op0_n100_rh_s2_r10k ctl_op0_n100_rh_s2_r10k 0 pwl(0.0000e+00 {VDD} 2.0000e-09 {VDD} 2.1000e-09 0)
* RWL driver model (EXPERIMENTAL): slew 2 ns, series R 10000 ohm; cell pin = rwls_op0_n100_rh_s2_r10k
vrs_op0_n100_rh_s2_r10k rwlsrc_op0_n100_rh_s2_r10k 0 pwl(0.0000e+00 {VDD} 2.0000e-09 {VDD} 4.0000e-09 0 1.2000e-08 0 1.4000e-08 {VDD})
rdrv_op0_n100_rh_s2_r10k rwlsrc_op0_n100_rh_s2_r10k rwls_op0_n100_rh_s2_r10k 10000
ven_op0_n100_rh_s2_r10k en_op0_n100_rh_s2_r10k 0 pwl(0.0000e+00 0 1.1000e-08 0 1.1100e-08 {VDD} 3.4000e-08 {VDD} 3.4100e-08 0)
venb_op0_n100_rh_s2_r10k enb_op0_n100_rh_s2_r10k 0 pwl(0.0000e+00 {VDD} 1.1000e-08 {VDD} 1.1100e-08 0 3.4000e-08 0 3.4100e-08 {VDD})
vww_op0_n100_rh_s2_r10k wwl_op0_n100_rh_s2_r10k 0 pwl(0.0000e+00 0 1.2000e-08 0 1.2100e-08 {VDD} 3.2000e-08 {VDD} 3.2100e-08 0)
vwc_op0_n100_rh_s2_r10k wbc_op0_n100_rh_s2_r10k 0 pwl(0.0000e+00 0 1.2000e-08 0 1.2100e-08 {VDD} 3.4000e-08 {VDD} 3.4100e-08 0)
swb_op0_n100_rh_s2_r10k ref_op0_n100_rh_s2_r10k wbl_op0_n100_rh_s2_r10k wbc_op0_n100_rh_s2_r10k 0 swwbl
cwbl_op0_n100_rh_s2_r10k wbl_op0_n100_rh_s2_r10k 0 {C_WBL}
spa_op0_n100_rh_s2_r10k prea rbl_op0_n100_rh_s2_r10k ctl_op0_n100_rh_s2_r10k 0 swpre
spr_op0_n100_rh_s2_r10k pref ref_op0_n100_rh_s2_r10k ctl_op0_n100_rh_s2_r10k 0 swpre
crbl_op0_n100_rh_s2_r10k rbl_op0_n100_rh_s2_r10k 0 {C_RBL}
cref_op0_n100_rh_s2_r10k ref_op0_n100_rh_s2_r10k 0 {C_RBL}   $ ASSUMPTION: ideal matched dummy load
XMWR_op0_n100_rh_s2_r10k_0 sn_op0_n100_rh_s2_r10k_0 wwl_op0_n100_rh_s2_r10k wbl_op0_n100_rh_s2_r10k 0 sky130_fd_pr__nfet_01v8 L=0.15 W=0.42 nf=1 ad=0.1218 as=0.1218 pd=1.42 ps=1.42 nrd=0.69047619047619  nrs=0.69047619047619 sa=0 sb=0 sd=0 mult=1 m=1
XMRD_op0_n100_rh_s2_r10k_0 rbl_op0_n100_rh_s2_r10k sn_op0_n100_rh_s2_r10k_0 rwls_op0_n100_rh_s2_r10k 0 sky130_fd_pr__nfet_01v8 L=0.15 W=0.42 nf=1 ad=0.1218 as=0.1218 pd=1.42 ps=1.42 nrd=0.69047619047619  nrs=0.69047619047619 sa=0 sb=0 sd=0 mult=1 m=1
csn_op0_n100_rh_s2_r10k_0 sn_op0_n100_rh_s2_r10k_0 0 {C_SN}
XMWR_op0_n100_rh_s2_r10k_1 sn_op0_n100_rh_s2_r10k_1 wwl_des wbl_op0_n100_rh_s2_r10k 0 sky130_fd_pr__nfet_01v8 L=0.15 W=0.42 nf=1 ad=0.1218 as=0.1218 pd=1.42 ps=1.42 nrd=0.69047619047619  nrs=0.69047619047619 sa=0 sb=0 sd=0 mult=1 m=1
XMRD_op0_n100_rh_s2_r10k_1 rbl_op0_n100_rh_s2_r10k sn_op0_n100_rh_s2_r10k_1 rwl_des 0 sky130_fd_pr__nfet_01v8 L=0.15 W=0.42 nf=1 ad=0.1218 as=0.1218 pd=1.42 ps=1.42 nrd=0.69047619047619  nrs=0.69047619047619 sa=0 sb=0 sd=0 mult=1 m=1
csn_op0_n100_rh_s2_r10k_1 sn_op0_n100_rh_s2_r10k_1 0 {C_SN}
XMWR_op0_n100_rh_s2_r10k_2 sn_op0_n100_rh_s2_r10k_2 wwl_des wbl_op0_n100_rh_s2_r10k 0 sky130_fd_pr__nfet_01v8 L=0.15 W=0.42 nf=1 ad=0.1218 as=0.1218 pd=1.42 ps=1.42 nrd=0.69047619047619  nrs=0.69047619047619 sa=0 sb=0 sd=0 mult=1 m=1
XMRD_op0_n100_rh_s2_r10k_2 rbl_op0_n100_rh_s2_r10k sn_op0_n100_rh_s2_r10k_2 rwl_des 0 sky130_fd_pr__nfet_01v8 L=0.15 W=0.42 nf=1 ad=0.1218 as=0.1218 pd=1.42 ps=1.42 nrd=0.69047619047619  nrs=0.69047619047619 sa=0 sb=0 sd=0 mult=1 m=1
csn_op0_n100_rh_s2_r10k_2 sn_op0_n100_rh_s2_r10k_2 0 {C_SN}
XMWR_op0_n100_rh_s2_r10k_3 sn_op0_n100_rh_s2_r10k_3 wwl_des wbl_op0_n100_rh_s2_r10k 0 sky130_fd_pr__nfet_01v8 L=0.15 W=0.42 nf=1 ad=0.1218 as=0.1218 pd=1.42 ps=1.42 nrd=0.69047619047619  nrs=0.69047619047619 sa=0 sb=0 sd=0 mult=1 m=1
XMRD_op0_n100_rh_s2_r10k_3 rbl_op0_n100_rh_s2_r10k sn_op0_n100_rh_s2_r10k_3 rwl_des 0 sky130_fd_pr__nfet_01v8 L=0.15 W=0.42 nf=1 ad=0.1218 as=0.1218 pd=1.42 ps=1.42 nrd=0.69047619047619  nrs=0.69047619047619 sa=0 sb=0 sd=0 mult=1 m=1
csn_op0_n100_rh_s2_r10k_3 sn_op0_n100_rh_s2_r10k_3 0 {C_SN}
XMN1_op0_n100_rh_s2_r10k rbl_op0_n100_rh_s2_r10k ref_op0_n100_rh_s2_r10k vn_op0_n100_rh_s2_r10k 0 sky130_fd_pr__nfet_01v8 L=0.15 W=1 nf=1 ad=0.29 as=0.29 pd=2.58 ps=2.58 mult=1 m=1
XMN2_op0_n100_rh_s2_r10k ref_op0_n100_rh_s2_r10k rbl_op0_n100_rh_s2_r10k vn_op0_n100_rh_s2_r10k 0 sky130_fd_pr__nfet_01v8 L=0.15 W=1 nf=1 ad=0.29 as=0.29 pd=2.58 ps=2.58 mult=1 m=1
XMP1_op0_n100_rh_s2_r10k rbl_op0_n100_rh_s2_r10k ref_op0_n100_rh_s2_r10k vp_op0_n100_rh_s2_r10k vdd sky130_fd_pr__pfet_01v8 L=0.15 W=2 nf=1 ad=0.58 as=0.58 pd=4.58 ps=4.58 mult=1 m=1
XMP2_op0_n100_rh_s2_r10k ref_op0_n100_rh_s2_r10k rbl_op0_n100_rh_s2_r10k vp_op0_n100_rh_s2_r10k vdd sky130_fd_pr__pfet_01v8 L=0.15 W=2 nf=1 ad=0.58 as=0.58 pd=4.58 ps=4.58 mult=1 m=1
XMNF_op0_n100_rh_s2_r10k vn_op0_n100_rh_s2_r10k en_op0_n100_rh_s2_r10k 0 0 sky130_fd_pr__nfet_01v8 L=0.15 W=2 nf=1 ad=0.58 as=0.58 pd=4.58 ps=4.58 mult=1 m=1
XMPH_op0_n100_rh_s2_r10k vp_op0_n100_rh_s2_r10k enb_op0_n100_rh_s2_r10k vdd vdd sky130_fd_pr__pfet_01v8 L=0.15 W=4 nf=1 ad=1.16 as=1.16 pd=8.58 ps=8.58 mult=1 m=1
bd_op0_n100_rh_s2_r10k d_op0_n100_rh_s2_r10k 0 v=v(rbl_op0_n100_rh_s2_r10k)-v(ref_op0_n100_rh_s2_r10k)

* ---- instance 156: op0_0000_rh_s2_r10k (variant rh_s2_r10k; probe dec 11.9 ns, release 34 ns, meas 36 ns) ----
vctl_op0_0000_rh_s2_r10k ctl_op0_0000_rh_s2_r10k 0 pwl(0.0000e+00 {VDD} 2.0000e-09 {VDD} 2.1000e-09 0)
* RWL driver model (EXPERIMENTAL): slew 2 ns, series R 10000 ohm; cell pin = rwls_op0_0000_rh_s2_r10k
vrs_op0_0000_rh_s2_r10k rwlsrc_op0_0000_rh_s2_r10k 0 pwl(0.0000e+00 {VDD} 2.0000e-09 {VDD} 4.0000e-09 0 1.2000e-08 0 1.4000e-08 {VDD})
rdrv_op0_0000_rh_s2_r10k rwlsrc_op0_0000_rh_s2_r10k rwls_op0_0000_rh_s2_r10k 10000
ven_op0_0000_rh_s2_r10k en_op0_0000_rh_s2_r10k 0 pwl(0.0000e+00 0 1.1000e-08 0 1.1100e-08 {VDD} 3.4000e-08 {VDD} 3.4100e-08 0)
venb_op0_0000_rh_s2_r10k enb_op0_0000_rh_s2_r10k 0 pwl(0.0000e+00 {VDD} 1.1000e-08 {VDD} 1.1100e-08 0 3.4000e-08 0 3.4100e-08 {VDD})
vww_op0_0000_rh_s2_r10k wwl_op0_0000_rh_s2_r10k 0 pwl(0.0000e+00 0 1.2000e-08 0 1.2100e-08 {VDD} 3.2000e-08 {VDD} 3.2100e-08 0)
vwc_op0_0000_rh_s2_r10k wbc_op0_0000_rh_s2_r10k 0 pwl(0.0000e+00 0 1.2000e-08 0 1.2100e-08 {VDD} 3.4000e-08 {VDD} 3.4100e-08 0)
swb_op0_0000_rh_s2_r10k ref_op0_0000_rh_s2_r10k wbl_op0_0000_rh_s2_r10k wbc_op0_0000_rh_s2_r10k 0 swwbl
cwbl_op0_0000_rh_s2_r10k wbl_op0_0000_rh_s2_r10k 0 {C_WBL}
spa_op0_0000_rh_s2_r10k prea rbl_op0_0000_rh_s2_r10k ctl_op0_0000_rh_s2_r10k 0 swpre
spr_op0_0000_rh_s2_r10k pref ref_op0_0000_rh_s2_r10k ctl_op0_0000_rh_s2_r10k 0 swpre
crbl_op0_0000_rh_s2_r10k rbl_op0_0000_rh_s2_r10k 0 {C_RBL}
cref_op0_0000_rh_s2_r10k ref_op0_0000_rh_s2_r10k 0 {C_RBL}   $ ASSUMPTION: ideal matched dummy load
XMWR_op0_0000_rh_s2_r10k_0 sn_op0_0000_rh_s2_r10k_0 wwl_op0_0000_rh_s2_r10k wbl_op0_0000_rh_s2_r10k 0 sky130_fd_pr__nfet_01v8 L=0.15 W=0.42 nf=1 ad=0.1218 as=0.1218 pd=1.42 ps=1.42 nrd=0.69047619047619  nrs=0.69047619047619 sa=0 sb=0 sd=0 mult=1 m=1
XMRD_op0_0000_rh_s2_r10k_0 rbl_op0_0000_rh_s2_r10k sn_op0_0000_rh_s2_r10k_0 rwls_op0_0000_rh_s2_r10k 0 sky130_fd_pr__nfet_01v8 L=0.15 W=0.42 nf=1 ad=0.1218 as=0.1218 pd=1.42 ps=1.42 nrd=0.69047619047619  nrs=0.69047619047619 sa=0 sb=0 sd=0 mult=1 m=1
csn_op0_0000_rh_s2_r10k_0 sn_op0_0000_rh_s2_r10k_0 0 {C_SN}
XMWR_op0_0000_rh_s2_r10k_1 sn_op0_0000_rh_s2_r10k_1 wwl_des wbl_op0_0000_rh_s2_r10k 0 sky130_fd_pr__nfet_01v8 L=0.15 W=0.42 nf=1 ad=0.1218 as=0.1218 pd=1.42 ps=1.42 nrd=0.69047619047619  nrs=0.69047619047619 sa=0 sb=0 sd=0 mult=1 m=1
XMRD_op0_0000_rh_s2_r10k_1 rbl_op0_0000_rh_s2_r10k sn_op0_0000_rh_s2_r10k_1 rwl_des 0 sky130_fd_pr__nfet_01v8 L=0.15 W=0.42 nf=1 ad=0.1218 as=0.1218 pd=1.42 ps=1.42 nrd=0.69047619047619  nrs=0.69047619047619 sa=0 sb=0 sd=0 mult=1 m=1
csn_op0_0000_rh_s2_r10k_1 sn_op0_0000_rh_s2_r10k_1 0 {C_SN}
XMWR_op0_0000_rh_s2_r10k_2 sn_op0_0000_rh_s2_r10k_2 wwl_des wbl_op0_0000_rh_s2_r10k 0 sky130_fd_pr__nfet_01v8 L=0.15 W=0.42 nf=1 ad=0.1218 as=0.1218 pd=1.42 ps=1.42 nrd=0.69047619047619  nrs=0.69047619047619 sa=0 sb=0 sd=0 mult=1 m=1
XMRD_op0_0000_rh_s2_r10k_2 rbl_op0_0000_rh_s2_r10k sn_op0_0000_rh_s2_r10k_2 rwl_des 0 sky130_fd_pr__nfet_01v8 L=0.15 W=0.42 nf=1 ad=0.1218 as=0.1218 pd=1.42 ps=1.42 nrd=0.69047619047619  nrs=0.69047619047619 sa=0 sb=0 sd=0 mult=1 m=1
csn_op0_0000_rh_s2_r10k_2 sn_op0_0000_rh_s2_r10k_2 0 {C_SN}
XMWR_op0_0000_rh_s2_r10k_3 sn_op0_0000_rh_s2_r10k_3 wwl_des wbl_op0_0000_rh_s2_r10k 0 sky130_fd_pr__nfet_01v8 L=0.15 W=0.42 nf=1 ad=0.1218 as=0.1218 pd=1.42 ps=1.42 nrd=0.69047619047619  nrs=0.69047619047619 sa=0 sb=0 sd=0 mult=1 m=1
XMRD_op0_0000_rh_s2_r10k_3 rbl_op0_0000_rh_s2_r10k sn_op0_0000_rh_s2_r10k_3 rwl_des 0 sky130_fd_pr__nfet_01v8 L=0.15 W=0.42 nf=1 ad=0.1218 as=0.1218 pd=1.42 ps=1.42 nrd=0.69047619047619  nrs=0.69047619047619 sa=0 sb=0 sd=0 mult=1 m=1
csn_op0_0000_rh_s2_r10k_3 sn_op0_0000_rh_s2_r10k_3 0 {C_SN}
XMN1_op0_0000_rh_s2_r10k rbl_op0_0000_rh_s2_r10k ref_op0_0000_rh_s2_r10k vn_op0_0000_rh_s2_r10k 0 sky130_fd_pr__nfet_01v8 L=0.15 W=1 nf=1 ad=0.29 as=0.29 pd=2.58 ps=2.58 mult=1 m=1
XMN2_op0_0000_rh_s2_r10k ref_op0_0000_rh_s2_r10k rbl_op0_0000_rh_s2_r10k vn_op0_0000_rh_s2_r10k 0 sky130_fd_pr__nfet_01v8 L=0.15 W=1 nf=1 ad=0.29 as=0.29 pd=2.58 ps=2.58 mult=1 m=1
XMP1_op0_0000_rh_s2_r10k rbl_op0_0000_rh_s2_r10k ref_op0_0000_rh_s2_r10k vp_op0_0000_rh_s2_r10k vdd sky130_fd_pr__pfet_01v8 L=0.15 W=2 nf=1 ad=0.58 as=0.58 pd=4.58 ps=4.58 mult=1 m=1
XMP2_op0_0000_rh_s2_r10k ref_op0_0000_rh_s2_r10k rbl_op0_0000_rh_s2_r10k vp_op0_0000_rh_s2_r10k vdd sky130_fd_pr__pfet_01v8 L=0.15 W=2 nf=1 ad=0.58 as=0.58 pd=4.58 ps=4.58 mult=1 m=1
XMNF_op0_0000_rh_s2_r10k vn_op0_0000_rh_s2_r10k en_op0_0000_rh_s2_r10k 0 0 sky130_fd_pr__nfet_01v8 L=0.15 W=2 nf=1 ad=0.58 as=0.58 pd=4.58 ps=4.58 mult=1 m=1
XMPH_op0_0000_rh_s2_r10k vp_op0_0000_rh_s2_r10k enb_op0_0000_rh_s2_r10k vdd vdd sky130_fd_pr__pfet_01v8 L=0.15 W=4 nf=1 ad=1.16 as=1.16 pd=8.58 ps=8.58 mult=1 m=1
bd_op0_0000_rh_s2_r10k d_op0_0000_rh_s2_r10k 0 v=v(rbl_op0_0000_rh_s2_r10k)-v(ref_op0_0000_rh_s2_r10k)

* ---- instance 157: op1_0900_rh_s2_r100k (variant rh_s2_r100k; probe dec 11.9 ns, release 34 ns, meas 36 ns) ----
vctl_op1_0900_rh_s2_r100k ctl_op1_0900_rh_s2_r100k 0 pwl(0.0000e+00 {VDD} 2.0000e-09 {VDD} 2.1000e-09 0)
* RWL driver model (EXPERIMENTAL): slew 2 ns, series R 100000 ohm; cell pin = rwls_op1_0900_rh_s2_r100k
vrs_op1_0900_rh_s2_r100k rwlsrc_op1_0900_rh_s2_r100k 0 pwl(0.0000e+00 {VDD} 2.0000e-09 {VDD} 4.0000e-09 0 1.2000e-08 0 1.4000e-08 {VDD})
rdrv_op1_0900_rh_s2_r100k rwlsrc_op1_0900_rh_s2_r100k rwls_op1_0900_rh_s2_r100k 100000
ven_op1_0900_rh_s2_r100k en_op1_0900_rh_s2_r100k 0 pwl(0.0000e+00 0 1.1000e-08 0 1.1100e-08 {VDD} 3.4000e-08 {VDD} 3.4100e-08 0)
venb_op1_0900_rh_s2_r100k enb_op1_0900_rh_s2_r100k 0 pwl(0.0000e+00 {VDD} 1.1000e-08 {VDD} 1.1100e-08 0 3.4000e-08 0 3.4100e-08 {VDD})
vww_op1_0900_rh_s2_r100k wwl_op1_0900_rh_s2_r100k 0 pwl(0.0000e+00 0 1.2000e-08 0 1.2100e-08 {VDD} 3.2000e-08 {VDD} 3.2100e-08 0)
vwc_op1_0900_rh_s2_r100k wbc_op1_0900_rh_s2_r100k 0 pwl(0.0000e+00 0 1.2000e-08 0 1.2100e-08 {VDD} 3.4000e-08 {VDD} 3.4100e-08 0)
swb_op1_0900_rh_s2_r100k ref_op1_0900_rh_s2_r100k wbl_op1_0900_rh_s2_r100k wbc_op1_0900_rh_s2_r100k 0 swwbl
cwbl_op1_0900_rh_s2_r100k wbl_op1_0900_rh_s2_r100k 0 {C_WBL}
spa_op1_0900_rh_s2_r100k prea rbl_op1_0900_rh_s2_r100k ctl_op1_0900_rh_s2_r100k 0 swpre
spr_op1_0900_rh_s2_r100k pref ref_op1_0900_rh_s2_r100k ctl_op1_0900_rh_s2_r100k 0 swpre
crbl_op1_0900_rh_s2_r100k rbl_op1_0900_rh_s2_r100k 0 {C_RBL}
cref_op1_0900_rh_s2_r100k ref_op1_0900_rh_s2_r100k 0 {C_RBL}   $ ASSUMPTION: ideal matched dummy load
XMWR_op1_0900_rh_s2_r100k_0 sn_op1_0900_rh_s2_r100k_0 wwl_op1_0900_rh_s2_r100k wbl_op1_0900_rh_s2_r100k 0 sky130_fd_pr__nfet_01v8 L=0.15 W=0.42 nf=1 ad=0.1218 as=0.1218 pd=1.42 ps=1.42 nrd=0.69047619047619  nrs=0.69047619047619 sa=0 sb=0 sd=0 mult=1 m=1
XMRD_op1_0900_rh_s2_r100k_0 rbl_op1_0900_rh_s2_r100k sn_op1_0900_rh_s2_r100k_0 rwls_op1_0900_rh_s2_r100k 0 sky130_fd_pr__nfet_01v8 L=0.15 W=0.42 nf=1 ad=0.1218 as=0.1218 pd=1.42 ps=1.42 nrd=0.69047619047619  nrs=0.69047619047619 sa=0 sb=0 sd=0 mult=1 m=1
csn_op1_0900_rh_s2_r100k_0 sn_op1_0900_rh_s2_r100k_0 0 {C_SN}
XMWR_op1_0900_rh_s2_r100k_1 sn_op1_0900_rh_s2_r100k_1 wwl_des wbl_op1_0900_rh_s2_r100k 0 sky130_fd_pr__nfet_01v8 L=0.15 W=0.42 nf=1 ad=0.1218 as=0.1218 pd=1.42 ps=1.42 nrd=0.69047619047619  nrs=0.69047619047619 sa=0 sb=0 sd=0 mult=1 m=1
XMRD_op1_0900_rh_s2_r100k_1 rbl_op1_0900_rh_s2_r100k sn_op1_0900_rh_s2_r100k_1 rwl_des 0 sky130_fd_pr__nfet_01v8 L=0.15 W=0.42 nf=1 ad=0.1218 as=0.1218 pd=1.42 ps=1.42 nrd=0.69047619047619  nrs=0.69047619047619 sa=0 sb=0 sd=0 mult=1 m=1
csn_op1_0900_rh_s2_r100k_1 sn_op1_0900_rh_s2_r100k_1 0 {C_SN}
XMWR_op1_0900_rh_s2_r100k_2 sn_op1_0900_rh_s2_r100k_2 wwl_des wbl_op1_0900_rh_s2_r100k 0 sky130_fd_pr__nfet_01v8 L=0.15 W=0.42 nf=1 ad=0.1218 as=0.1218 pd=1.42 ps=1.42 nrd=0.69047619047619  nrs=0.69047619047619 sa=0 sb=0 sd=0 mult=1 m=1
XMRD_op1_0900_rh_s2_r100k_2 rbl_op1_0900_rh_s2_r100k sn_op1_0900_rh_s2_r100k_2 rwl_des 0 sky130_fd_pr__nfet_01v8 L=0.15 W=0.42 nf=1 ad=0.1218 as=0.1218 pd=1.42 ps=1.42 nrd=0.69047619047619  nrs=0.69047619047619 sa=0 sb=0 sd=0 mult=1 m=1
csn_op1_0900_rh_s2_r100k_2 sn_op1_0900_rh_s2_r100k_2 0 {C_SN}
XMWR_op1_0900_rh_s2_r100k_3 sn_op1_0900_rh_s2_r100k_3 wwl_des wbl_op1_0900_rh_s2_r100k 0 sky130_fd_pr__nfet_01v8 L=0.15 W=0.42 nf=1 ad=0.1218 as=0.1218 pd=1.42 ps=1.42 nrd=0.69047619047619  nrs=0.69047619047619 sa=0 sb=0 sd=0 mult=1 m=1
XMRD_op1_0900_rh_s2_r100k_3 rbl_op1_0900_rh_s2_r100k sn_op1_0900_rh_s2_r100k_3 rwl_des 0 sky130_fd_pr__nfet_01v8 L=0.15 W=0.42 nf=1 ad=0.1218 as=0.1218 pd=1.42 ps=1.42 nrd=0.69047619047619  nrs=0.69047619047619 sa=0 sb=0 sd=0 mult=1 m=1
csn_op1_0900_rh_s2_r100k_3 sn_op1_0900_rh_s2_r100k_3 0 {C_SN}
XMN1_op1_0900_rh_s2_r100k rbl_op1_0900_rh_s2_r100k ref_op1_0900_rh_s2_r100k vn_op1_0900_rh_s2_r100k 0 sky130_fd_pr__nfet_01v8 L=0.15 W=1 nf=1 ad=0.29 as=0.29 pd=2.58 ps=2.58 mult=1 m=1
XMN2_op1_0900_rh_s2_r100k ref_op1_0900_rh_s2_r100k rbl_op1_0900_rh_s2_r100k vn_op1_0900_rh_s2_r100k 0 sky130_fd_pr__nfet_01v8 L=0.15 W=1 nf=1 ad=0.29 as=0.29 pd=2.58 ps=2.58 mult=1 m=1
XMP1_op1_0900_rh_s2_r100k rbl_op1_0900_rh_s2_r100k ref_op1_0900_rh_s2_r100k vp_op1_0900_rh_s2_r100k vdd sky130_fd_pr__pfet_01v8 L=0.15 W=2 nf=1 ad=0.58 as=0.58 pd=4.58 ps=4.58 mult=1 m=1
XMP2_op1_0900_rh_s2_r100k ref_op1_0900_rh_s2_r100k rbl_op1_0900_rh_s2_r100k vp_op1_0900_rh_s2_r100k vdd sky130_fd_pr__pfet_01v8 L=0.15 W=2 nf=1 ad=0.58 as=0.58 pd=4.58 ps=4.58 mult=1 m=1
XMNF_op1_0900_rh_s2_r100k vn_op1_0900_rh_s2_r100k en_op1_0900_rh_s2_r100k 0 0 sky130_fd_pr__nfet_01v8 L=0.15 W=2 nf=1 ad=0.58 as=0.58 pd=4.58 ps=4.58 mult=1 m=1
XMPH_op1_0900_rh_s2_r100k vp_op1_0900_rh_s2_r100k enb_op1_0900_rh_s2_r100k vdd vdd sky130_fd_pr__pfet_01v8 L=0.15 W=4 nf=1 ad=1.16 as=1.16 pd=8.58 ps=8.58 mult=1 m=1
bd_op1_0900_rh_s2_r100k d_op1_0900_rh_s2_r100k 0 v=v(rbl_op1_0900_rh_s2_r100k)-v(ref_op1_0900_rh_s2_r100k)

* ---- instance 158: op1_1000_rh_s2_r100k (variant rh_s2_r100k; probe dec 11.9 ns, release 34 ns, meas 36 ns) ----
vctl_op1_1000_rh_s2_r100k ctl_op1_1000_rh_s2_r100k 0 pwl(0.0000e+00 {VDD} 2.0000e-09 {VDD} 2.1000e-09 0)
* RWL driver model (EXPERIMENTAL): slew 2 ns, series R 100000 ohm; cell pin = rwls_op1_1000_rh_s2_r100k
vrs_op1_1000_rh_s2_r100k rwlsrc_op1_1000_rh_s2_r100k 0 pwl(0.0000e+00 {VDD} 2.0000e-09 {VDD} 4.0000e-09 0 1.2000e-08 0 1.4000e-08 {VDD})
rdrv_op1_1000_rh_s2_r100k rwlsrc_op1_1000_rh_s2_r100k rwls_op1_1000_rh_s2_r100k 100000
ven_op1_1000_rh_s2_r100k en_op1_1000_rh_s2_r100k 0 pwl(0.0000e+00 0 1.1000e-08 0 1.1100e-08 {VDD} 3.4000e-08 {VDD} 3.4100e-08 0)
venb_op1_1000_rh_s2_r100k enb_op1_1000_rh_s2_r100k 0 pwl(0.0000e+00 {VDD} 1.1000e-08 {VDD} 1.1100e-08 0 3.4000e-08 0 3.4100e-08 {VDD})
vww_op1_1000_rh_s2_r100k wwl_op1_1000_rh_s2_r100k 0 pwl(0.0000e+00 0 1.2000e-08 0 1.2100e-08 {VDD} 3.2000e-08 {VDD} 3.2100e-08 0)
vwc_op1_1000_rh_s2_r100k wbc_op1_1000_rh_s2_r100k 0 pwl(0.0000e+00 0 1.2000e-08 0 1.2100e-08 {VDD} 3.4000e-08 {VDD} 3.4100e-08 0)
swb_op1_1000_rh_s2_r100k ref_op1_1000_rh_s2_r100k wbl_op1_1000_rh_s2_r100k wbc_op1_1000_rh_s2_r100k 0 swwbl
cwbl_op1_1000_rh_s2_r100k wbl_op1_1000_rh_s2_r100k 0 {C_WBL}
spa_op1_1000_rh_s2_r100k prea rbl_op1_1000_rh_s2_r100k ctl_op1_1000_rh_s2_r100k 0 swpre
spr_op1_1000_rh_s2_r100k pref ref_op1_1000_rh_s2_r100k ctl_op1_1000_rh_s2_r100k 0 swpre
crbl_op1_1000_rh_s2_r100k rbl_op1_1000_rh_s2_r100k 0 {C_RBL}
cref_op1_1000_rh_s2_r100k ref_op1_1000_rh_s2_r100k 0 {C_RBL}   $ ASSUMPTION: ideal matched dummy load
XMWR_op1_1000_rh_s2_r100k_0 sn_op1_1000_rh_s2_r100k_0 wwl_op1_1000_rh_s2_r100k wbl_op1_1000_rh_s2_r100k 0 sky130_fd_pr__nfet_01v8 L=0.15 W=0.42 nf=1 ad=0.1218 as=0.1218 pd=1.42 ps=1.42 nrd=0.69047619047619  nrs=0.69047619047619 sa=0 sb=0 sd=0 mult=1 m=1
XMRD_op1_1000_rh_s2_r100k_0 rbl_op1_1000_rh_s2_r100k sn_op1_1000_rh_s2_r100k_0 rwls_op1_1000_rh_s2_r100k 0 sky130_fd_pr__nfet_01v8 L=0.15 W=0.42 nf=1 ad=0.1218 as=0.1218 pd=1.42 ps=1.42 nrd=0.69047619047619  nrs=0.69047619047619 sa=0 sb=0 sd=0 mult=1 m=1
csn_op1_1000_rh_s2_r100k_0 sn_op1_1000_rh_s2_r100k_0 0 {C_SN}
XMWR_op1_1000_rh_s2_r100k_1 sn_op1_1000_rh_s2_r100k_1 wwl_des wbl_op1_1000_rh_s2_r100k 0 sky130_fd_pr__nfet_01v8 L=0.15 W=0.42 nf=1 ad=0.1218 as=0.1218 pd=1.42 ps=1.42 nrd=0.69047619047619  nrs=0.69047619047619 sa=0 sb=0 sd=0 mult=1 m=1
XMRD_op1_1000_rh_s2_r100k_1 rbl_op1_1000_rh_s2_r100k sn_op1_1000_rh_s2_r100k_1 rwl_des 0 sky130_fd_pr__nfet_01v8 L=0.15 W=0.42 nf=1 ad=0.1218 as=0.1218 pd=1.42 ps=1.42 nrd=0.69047619047619  nrs=0.69047619047619 sa=0 sb=0 sd=0 mult=1 m=1
csn_op1_1000_rh_s2_r100k_1 sn_op1_1000_rh_s2_r100k_1 0 {C_SN}
XMWR_op1_1000_rh_s2_r100k_2 sn_op1_1000_rh_s2_r100k_2 wwl_des wbl_op1_1000_rh_s2_r100k 0 sky130_fd_pr__nfet_01v8 L=0.15 W=0.42 nf=1 ad=0.1218 as=0.1218 pd=1.42 ps=1.42 nrd=0.69047619047619  nrs=0.69047619047619 sa=0 sb=0 sd=0 mult=1 m=1
XMRD_op1_1000_rh_s2_r100k_2 rbl_op1_1000_rh_s2_r100k sn_op1_1000_rh_s2_r100k_2 rwl_des 0 sky130_fd_pr__nfet_01v8 L=0.15 W=0.42 nf=1 ad=0.1218 as=0.1218 pd=1.42 ps=1.42 nrd=0.69047619047619  nrs=0.69047619047619 sa=0 sb=0 sd=0 mult=1 m=1
csn_op1_1000_rh_s2_r100k_2 sn_op1_1000_rh_s2_r100k_2 0 {C_SN}
XMWR_op1_1000_rh_s2_r100k_3 sn_op1_1000_rh_s2_r100k_3 wwl_des wbl_op1_1000_rh_s2_r100k 0 sky130_fd_pr__nfet_01v8 L=0.15 W=0.42 nf=1 ad=0.1218 as=0.1218 pd=1.42 ps=1.42 nrd=0.69047619047619  nrs=0.69047619047619 sa=0 sb=0 sd=0 mult=1 m=1
XMRD_op1_1000_rh_s2_r100k_3 rbl_op1_1000_rh_s2_r100k sn_op1_1000_rh_s2_r100k_3 rwl_des 0 sky130_fd_pr__nfet_01v8 L=0.15 W=0.42 nf=1 ad=0.1218 as=0.1218 pd=1.42 ps=1.42 nrd=0.69047619047619  nrs=0.69047619047619 sa=0 sb=0 sd=0 mult=1 m=1
csn_op1_1000_rh_s2_r100k_3 sn_op1_1000_rh_s2_r100k_3 0 {C_SN}
XMN1_op1_1000_rh_s2_r100k rbl_op1_1000_rh_s2_r100k ref_op1_1000_rh_s2_r100k vn_op1_1000_rh_s2_r100k 0 sky130_fd_pr__nfet_01v8 L=0.15 W=1 nf=1 ad=0.29 as=0.29 pd=2.58 ps=2.58 mult=1 m=1
XMN2_op1_1000_rh_s2_r100k ref_op1_1000_rh_s2_r100k rbl_op1_1000_rh_s2_r100k vn_op1_1000_rh_s2_r100k 0 sky130_fd_pr__nfet_01v8 L=0.15 W=1 nf=1 ad=0.29 as=0.29 pd=2.58 ps=2.58 mult=1 m=1
XMP1_op1_1000_rh_s2_r100k rbl_op1_1000_rh_s2_r100k ref_op1_1000_rh_s2_r100k vp_op1_1000_rh_s2_r100k vdd sky130_fd_pr__pfet_01v8 L=0.15 W=2 nf=1 ad=0.58 as=0.58 pd=4.58 ps=4.58 mult=1 m=1
XMP2_op1_1000_rh_s2_r100k ref_op1_1000_rh_s2_r100k rbl_op1_1000_rh_s2_r100k vp_op1_1000_rh_s2_r100k vdd sky130_fd_pr__pfet_01v8 L=0.15 W=2 nf=1 ad=0.58 as=0.58 pd=4.58 ps=4.58 mult=1 m=1
XMNF_op1_1000_rh_s2_r100k vn_op1_1000_rh_s2_r100k en_op1_1000_rh_s2_r100k 0 0 sky130_fd_pr__nfet_01v8 L=0.15 W=2 nf=1 ad=0.58 as=0.58 pd=4.58 ps=4.58 mult=1 m=1
XMPH_op1_1000_rh_s2_r100k vp_op1_1000_rh_s2_r100k enb_op1_1000_rh_s2_r100k vdd vdd sky130_fd_pr__pfet_01v8 L=0.15 W=4 nf=1 ad=1.16 as=1.16 pd=8.58 ps=8.58 mult=1 m=1
bd_op1_1000_rh_s2_r100k d_op1_1000_rh_s2_r100k 0 v=v(rbl_op1_1000_rh_s2_r100k)-v(ref_op1_1000_rh_s2_r100k)

* ---- instance 159: op0_n100_rh_s2_r100k (variant rh_s2_r100k; probe dec 11.9 ns, release 34 ns, meas 36 ns) ----
vctl_op0_n100_rh_s2_r100k ctl_op0_n100_rh_s2_r100k 0 pwl(0.0000e+00 {VDD} 2.0000e-09 {VDD} 2.1000e-09 0)
* RWL driver model (EXPERIMENTAL): slew 2 ns, series R 100000 ohm; cell pin = rwls_op0_n100_rh_s2_r100k
vrs_op0_n100_rh_s2_r100k rwlsrc_op0_n100_rh_s2_r100k 0 pwl(0.0000e+00 {VDD} 2.0000e-09 {VDD} 4.0000e-09 0 1.2000e-08 0 1.4000e-08 {VDD})
rdrv_op0_n100_rh_s2_r100k rwlsrc_op0_n100_rh_s2_r100k rwls_op0_n100_rh_s2_r100k 100000
ven_op0_n100_rh_s2_r100k en_op0_n100_rh_s2_r100k 0 pwl(0.0000e+00 0 1.1000e-08 0 1.1100e-08 {VDD} 3.4000e-08 {VDD} 3.4100e-08 0)
venb_op0_n100_rh_s2_r100k enb_op0_n100_rh_s2_r100k 0 pwl(0.0000e+00 {VDD} 1.1000e-08 {VDD} 1.1100e-08 0 3.4000e-08 0 3.4100e-08 {VDD})
vww_op0_n100_rh_s2_r100k wwl_op0_n100_rh_s2_r100k 0 pwl(0.0000e+00 0 1.2000e-08 0 1.2100e-08 {VDD} 3.2000e-08 {VDD} 3.2100e-08 0)
vwc_op0_n100_rh_s2_r100k wbc_op0_n100_rh_s2_r100k 0 pwl(0.0000e+00 0 1.2000e-08 0 1.2100e-08 {VDD} 3.4000e-08 {VDD} 3.4100e-08 0)
swb_op0_n100_rh_s2_r100k ref_op0_n100_rh_s2_r100k wbl_op0_n100_rh_s2_r100k wbc_op0_n100_rh_s2_r100k 0 swwbl
cwbl_op0_n100_rh_s2_r100k wbl_op0_n100_rh_s2_r100k 0 {C_WBL}
spa_op0_n100_rh_s2_r100k prea rbl_op0_n100_rh_s2_r100k ctl_op0_n100_rh_s2_r100k 0 swpre
spr_op0_n100_rh_s2_r100k pref ref_op0_n100_rh_s2_r100k ctl_op0_n100_rh_s2_r100k 0 swpre
crbl_op0_n100_rh_s2_r100k rbl_op0_n100_rh_s2_r100k 0 {C_RBL}
cref_op0_n100_rh_s2_r100k ref_op0_n100_rh_s2_r100k 0 {C_RBL}   $ ASSUMPTION: ideal matched dummy load
XMWR_op0_n100_rh_s2_r100k_0 sn_op0_n100_rh_s2_r100k_0 wwl_op0_n100_rh_s2_r100k wbl_op0_n100_rh_s2_r100k 0 sky130_fd_pr__nfet_01v8 L=0.15 W=0.42 nf=1 ad=0.1218 as=0.1218 pd=1.42 ps=1.42 nrd=0.69047619047619  nrs=0.69047619047619 sa=0 sb=0 sd=0 mult=1 m=1
XMRD_op0_n100_rh_s2_r100k_0 rbl_op0_n100_rh_s2_r100k sn_op0_n100_rh_s2_r100k_0 rwls_op0_n100_rh_s2_r100k 0 sky130_fd_pr__nfet_01v8 L=0.15 W=0.42 nf=1 ad=0.1218 as=0.1218 pd=1.42 ps=1.42 nrd=0.69047619047619  nrs=0.69047619047619 sa=0 sb=0 sd=0 mult=1 m=1
csn_op0_n100_rh_s2_r100k_0 sn_op0_n100_rh_s2_r100k_0 0 {C_SN}
XMWR_op0_n100_rh_s2_r100k_1 sn_op0_n100_rh_s2_r100k_1 wwl_des wbl_op0_n100_rh_s2_r100k 0 sky130_fd_pr__nfet_01v8 L=0.15 W=0.42 nf=1 ad=0.1218 as=0.1218 pd=1.42 ps=1.42 nrd=0.69047619047619  nrs=0.69047619047619 sa=0 sb=0 sd=0 mult=1 m=1
XMRD_op0_n100_rh_s2_r100k_1 rbl_op0_n100_rh_s2_r100k sn_op0_n100_rh_s2_r100k_1 rwl_des 0 sky130_fd_pr__nfet_01v8 L=0.15 W=0.42 nf=1 ad=0.1218 as=0.1218 pd=1.42 ps=1.42 nrd=0.69047619047619  nrs=0.69047619047619 sa=0 sb=0 sd=0 mult=1 m=1
csn_op0_n100_rh_s2_r100k_1 sn_op0_n100_rh_s2_r100k_1 0 {C_SN}
XMWR_op0_n100_rh_s2_r100k_2 sn_op0_n100_rh_s2_r100k_2 wwl_des wbl_op0_n100_rh_s2_r100k 0 sky130_fd_pr__nfet_01v8 L=0.15 W=0.42 nf=1 ad=0.1218 as=0.1218 pd=1.42 ps=1.42 nrd=0.69047619047619  nrs=0.69047619047619 sa=0 sb=0 sd=0 mult=1 m=1
XMRD_op0_n100_rh_s2_r100k_2 rbl_op0_n100_rh_s2_r100k sn_op0_n100_rh_s2_r100k_2 rwl_des 0 sky130_fd_pr__nfet_01v8 L=0.15 W=0.42 nf=1 ad=0.1218 as=0.1218 pd=1.42 ps=1.42 nrd=0.69047619047619  nrs=0.69047619047619 sa=0 sb=0 sd=0 mult=1 m=1
csn_op0_n100_rh_s2_r100k_2 sn_op0_n100_rh_s2_r100k_2 0 {C_SN}
XMWR_op0_n100_rh_s2_r100k_3 sn_op0_n100_rh_s2_r100k_3 wwl_des wbl_op0_n100_rh_s2_r100k 0 sky130_fd_pr__nfet_01v8 L=0.15 W=0.42 nf=1 ad=0.1218 as=0.1218 pd=1.42 ps=1.42 nrd=0.69047619047619  nrs=0.69047619047619 sa=0 sb=0 sd=0 mult=1 m=1
XMRD_op0_n100_rh_s2_r100k_3 rbl_op0_n100_rh_s2_r100k sn_op0_n100_rh_s2_r100k_3 rwl_des 0 sky130_fd_pr__nfet_01v8 L=0.15 W=0.42 nf=1 ad=0.1218 as=0.1218 pd=1.42 ps=1.42 nrd=0.69047619047619  nrs=0.69047619047619 sa=0 sb=0 sd=0 mult=1 m=1
csn_op0_n100_rh_s2_r100k_3 sn_op0_n100_rh_s2_r100k_3 0 {C_SN}
XMN1_op0_n100_rh_s2_r100k rbl_op0_n100_rh_s2_r100k ref_op0_n100_rh_s2_r100k vn_op0_n100_rh_s2_r100k 0 sky130_fd_pr__nfet_01v8 L=0.15 W=1 nf=1 ad=0.29 as=0.29 pd=2.58 ps=2.58 mult=1 m=1
XMN2_op0_n100_rh_s2_r100k ref_op0_n100_rh_s2_r100k rbl_op0_n100_rh_s2_r100k vn_op0_n100_rh_s2_r100k 0 sky130_fd_pr__nfet_01v8 L=0.15 W=1 nf=1 ad=0.29 as=0.29 pd=2.58 ps=2.58 mult=1 m=1
XMP1_op0_n100_rh_s2_r100k rbl_op0_n100_rh_s2_r100k ref_op0_n100_rh_s2_r100k vp_op0_n100_rh_s2_r100k vdd sky130_fd_pr__pfet_01v8 L=0.15 W=2 nf=1 ad=0.58 as=0.58 pd=4.58 ps=4.58 mult=1 m=1
XMP2_op0_n100_rh_s2_r100k ref_op0_n100_rh_s2_r100k rbl_op0_n100_rh_s2_r100k vp_op0_n100_rh_s2_r100k vdd sky130_fd_pr__pfet_01v8 L=0.15 W=2 nf=1 ad=0.58 as=0.58 pd=4.58 ps=4.58 mult=1 m=1
XMNF_op0_n100_rh_s2_r100k vn_op0_n100_rh_s2_r100k en_op0_n100_rh_s2_r100k 0 0 sky130_fd_pr__nfet_01v8 L=0.15 W=2 nf=1 ad=0.58 as=0.58 pd=4.58 ps=4.58 mult=1 m=1
XMPH_op0_n100_rh_s2_r100k vp_op0_n100_rh_s2_r100k enb_op0_n100_rh_s2_r100k vdd vdd sky130_fd_pr__pfet_01v8 L=0.15 W=4 nf=1 ad=1.16 as=1.16 pd=8.58 ps=8.58 mult=1 m=1
bd_op0_n100_rh_s2_r100k d_op0_n100_rh_s2_r100k 0 v=v(rbl_op0_n100_rh_s2_r100k)-v(ref_op0_n100_rh_s2_r100k)

* ---- instance 160: op0_0000_rh_s2_r100k (variant rh_s2_r100k; probe dec 11.9 ns, release 34 ns, meas 36 ns) ----
vctl_op0_0000_rh_s2_r100k ctl_op0_0000_rh_s2_r100k 0 pwl(0.0000e+00 {VDD} 2.0000e-09 {VDD} 2.1000e-09 0)
* RWL driver model (EXPERIMENTAL): slew 2 ns, series R 100000 ohm; cell pin = rwls_op0_0000_rh_s2_r100k
vrs_op0_0000_rh_s2_r100k rwlsrc_op0_0000_rh_s2_r100k 0 pwl(0.0000e+00 {VDD} 2.0000e-09 {VDD} 4.0000e-09 0 1.2000e-08 0 1.4000e-08 {VDD})
rdrv_op0_0000_rh_s2_r100k rwlsrc_op0_0000_rh_s2_r100k rwls_op0_0000_rh_s2_r100k 100000
ven_op0_0000_rh_s2_r100k en_op0_0000_rh_s2_r100k 0 pwl(0.0000e+00 0 1.1000e-08 0 1.1100e-08 {VDD} 3.4000e-08 {VDD} 3.4100e-08 0)
venb_op0_0000_rh_s2_r100k enb_op0_0000_rh_s2_r100k 0 pwl(0.0000e+00 {VDD} 1.1000e-08 {VDD} 1.1100e-08 0 3.4000e-08 0 3.4100e-08 {VDD})
vww_op0_0000_rh_s2_r100k wwl_op0_0000_rh_s2_r100k 0 pwl(0.0000e+00 0 1.2000e-08 0 1.2100e-08 {VDD} 3.2000e-08 {VDD} 3.2100e-08 0)
vwc_op0_0000_rh_s2_r100k wbc_op0_0000_rh_s2_r100k 0 pwl(0.0000e+00 0 1.2000e-08 0 1.2100e-08 {VDD} 3.4000e-08 {VDD} 3.4100e-08 0)
swb_op0_0000_rh_s2_r100k ref_op0_0000_rh_s2_r100k wbl_op0_0000_rh_s2_r100k wbc_op0_0000_rh_s2_r100k 0 swwbl
cwbl_op0_0000_rh_s2_r100k wbl_op0_0000_rh_s2_r100k 0 {C_WBL}
spa_op0_0000_rh_s2_r100k prea rbl_op0_0000_rh_s2_r100k ctl_op0_0000_rh_s2_r100k 0 swpre
spr_op0_0000_rh_s2_r100k pref ref_op0_0000_rh_s2_r100k ctl_op0_0000_rh_s2_r100k 0 swpre
crbl_op0_0000_rh_s2_r100k rbl_op0_0000_rh_s2_r100k 0 {C_RBL}
cref_op0_0000_rh_s2_r100k ref_op0_0000_rh_s2_r100k 0 {C_RBL}   $ ASSUMPTION: ideal matched dummy load
XMWR_op0_0000_rh_s2_r100k_0 sn_op0_0000_rh_s2_r100k_0 wwl_op0_0000_rh_s2_r100k wbl_op0_0000_rh_s2_r100k 0 sky130_fd_pr__nfet_01v8 L=0.15 W=0.42 nf=1 ad=0.1218 as=0.1218 pd=1.42 ps=1.42 nrd=0.69047619047619  nrs=0.69047619047619 sa=0 sb=0 sd=0 mult=1 m=1
XMRD_op0_0000_rh_s2_r100k_0 rbl_op0_0000_rh_s2_r100k sn_op0_0000_rh_s2_r100k_0 rwls_op0_0000_rh_s2_r100k 0 sky130_fd_pr__nfet_01v8 L=0.15 W=0.42 nf=1 ad=0.1218 as=0.1218 pd=1.42 ps=1.42 nrd=0.69047619047619  nrs=0.69047619047619 sa=0 sb=0 sd=0 mult=1 m=1
csn_op0_0000_rh_s2_r100k_0 sn_op0_0000_rh_s2_r100k_0 0 {C_SN}
XMWR_op0_0000_rh_s2_r100k_1 sn_op0_0000_rh_s2_r100k_1 wwl_des wbl_op0_0000_rh_s2_r100k 0 sky130_fd_pr__nfet_01v8 L=0.15 W=0.42 nf=1 ad=0.1218 as=0.1218 pd=1.42 ps=1.42 nrd=0.69047619047619  nrs=0.69047619047619 sa=0 sb=0 sd=0 mult=1 m=1
XMRD_op0_0000_rh_s2_r100k_1 rbl_op0_0000_rh_s2_r100k sn_op0_0000_rh_s2_r100k_1 rwl_des 0 sky130_fd_pr__nfet_01v8 L=0.15 W=0.42 nf=1 ad=0.1218 as=0.1218 pd=1.42 ps=1.42 nrd=0.69047619047619  nrs=0.69047619047619 sa=0 sb=0 sd=0 mult=1 m=1
csn_op0_0000_rh_s2_r100k_1 sn_op0_0000_rh_s2_r100k_1 0 {C_SN}
XMWR_op0_0000_rh_s2_r100k_2 sn_op0_0000_rh_s2_r100k_2 wwl_des wbl_op0_0000_rh_s2_r100k 0 sky130_fd_pr__nfet_01v8 L=0.15 W=0.42 nf=1 ad=0.1218 as=0.1218 pd=1.42 ps=1.42 nrd=0.69047619047619  nrs=0.69047619047619 sa=0 sb=0 sd=0 mult=1 m=1
XMRD_op0_0000_rh_s2_r100k_2 rbl_op0_0000_rh_s2_r100k sn_op0_0000_rh_s2_r100k_2 rwl_des 0 sky130_fd_pr__nfet_01v8 L=0.15 W=0.42 nf=1 ad=0.1218 as=0.1218 pd=1.42 ps=1.42 nrd=0.69047619047619  nrs=0.69047619047619 sa=0 sb=0 sd=0 mult=1 m=1
csn_op0_0000_rh_s2_r100k_2 sn_op0_0000_rh_s2_r100k_2 0 {C_SN}
XMWR_op0_0000_rh_s2_r100k_3 sn_op0_0000_rh_s2_r100k_3 wwl_des wbl_op0_0000_rh_s2_r100k 0 sky130_fd_pr__nfet_01v8 L=0.15 W=0.42 nf=1 ad=0.1218 as=0.1218 pd=1.42 ps=1.42 nrd=0.69047619047619  nrs=0.69047619047619 sa=0 sb=0 sd=0 mult=1 m=1
XMRD_op0_0000_rh_s2_r100k_3 rbl_op0_0000_rh_s2_r100k sn_op0_0000_rh_s2_r100k_3 rwl_des 0 sky130_fd_pr__nfet_01v8 L=0.15 W=0.42 nf=1 ad=0.1218 as=0.1218 pd=1.42 ps=1.42 nrd=0.69047619047619  nrs=0.69047619047619 sa=0 sb=0 sd=0 mult=1 m=1
csn_op0_0000_rh_s2_r100k_3 sn_op0_0000_rh_s2_r100k_3 0 {C_SN}
XMN1_op0_0000_rh_s2_r100k rbl_op0_0000_rh_s2_r100k ref_op0_0000_rh_s2_r100k vn_op0_0000_rh_s2_r100k 0 sky130_fd_pr__nfet_01v8 L=0.15 W=1 nf=1 ad=0.29 as=0.29 pd=2.58 ps=2.58 mult=1 m=1
XMN2_op0_0000_rh_s2_r100k ref_op0_0000_rh_s2_r100k rbl_op0_0000_rh_s2_r100k vn_op0_0000_rh_s2_r100k 0 sky130_fd_pr__nfet_01v8 L=0.15 W=1 nf=1 ad=0.29 as=0.29 pd=2.58 ps=2.58 mult=1 m=1
XMP1_op0_0000_rh_s2_r100k rbl_op0_0000_rh_s2_r100k ref_op0_0000_rh_s2_r100k vp_op0_0000_rh_s2_r100k vdd sky130_fd_pr__pfet_01v8 L=0.15 W=2 nf=1 ad=0.58 as=0.58 pd=4.58 ps=4.58 mult=1 m=1
XMP2_op0_0000_rh_s2_r100k ref_op0_0000_rh_s2_r100k rbl_op0_0000_rh_s2_r100k vp_op0_0000_rh_s2_r100k vdd sky130_fd_pr__pfet_01v8 L=0.15 W=2 nf=1 ad=0.58 as=0.58 pd=4.58 ps=4.58 mult=1 m=1
XMNF_op0_0000_rh_s2_r100k vn_op0_0000_rh_s2_r100k en_op0_0000_rh_s2_r100k 0 0 sky130_fd_pr__nfet_01v8 L=0.15 W=2 nf=1 ad=0.58 as=0.58 pd=4.58 ps=4.58 mult=1 m=1
XMPH_op0_0000_rh_s2_r100k vp_op0_0000_rh_s2_r100k enb_op0_0000_rh_s2_r100k vdd vdd sky130_fd_pr__pfet_01v8 L=0.15 W=4 nf=1 ad=1.16 as=1.16 pd=8.58 ps=8.58 mult=1 m=1
bd_op0_0000_rh_s2_r100k d_op0_0000_rh_s2_r100k 0 v=v(rbl_op0_0000_rh_s2_r100k)-v(ref_op0_0000_rh_s2_r100k)

* ---- instance 161: op1_0900_rl_s0p5_r0 (variant rl_s0p5_r0; probe dec 11.9 ns, release 34 ns, meas 36 ns) ----
vctl_op1_0900_rl_s0p5_r0 ctl_op1_0900_rl_s0p5_r0 0 pwl(0.0000e+00 {VDD} 2.0000e-09 {VDD} 2.1000e-09 0)
* RWL driver model (EXPERIMENTAL): slew 0.5 ns, series R 0 ohm; cell pin = rwls_op1_0900_rl_s0p5_r0
vrs_op1_0900_rl_s0p5_r0 rwls_op1_0900_rl_s0p5_r0 0 pwl(0.0000e+00 {VDD} 2.0000e-09 {VDD} 2.5000e-09 0 3.4000e-08 0 3.4500e-08 {VDD})
ven_op1_0900_rl_s0p5_r0 en_op1_0900_rl_s0p5_r0 0 pwl(0.0000e+00 0 1.1000e-08 0 1.1100e-08 {VDD} 3.4000e-08 {VDD} 3.4100e-08 0)
venb_op1_0900_rl_s0p5_r0 enb_op1_0900_rl_s0p5_r0 0 pwl(0.0000e+00 {VDD} 1.1000e-08 {VDD} 1.1100e-08 0 3.4000e-08 0 3.4100e-08 {VDD})
vww_op1_0900_rl_s0p5_r0 wwl_op1_0900_rl_s0p5_r0 0 pwl(0.0000e+00 0 1.2000e-08 0 1.2100e-08 {VDD} 3.2000e-08 {VDD} 3.2100e-08 0)
vwc_op1_0900_rl_s0p5_r0 wbc_op1_0900_rl_s0p5_r0 0 pwl(0.0000e+00 0 1.2000e-08 0 1.2100e-08 {VDD} 3.4000e-08 {VDD} 3.4100e-08 0)
swb_op1_0900_rl_s0p5_r0 ref_op1_0900_rl_s0p5_r0 wbl_op1_0900_rl_s0p5_r0 wbc_op1_0900_rl_s0p5_r0 0 swwbl
cwbl_op1_0900_rl_s0p5_r0 wbl_op1_0900_rl_s0p5_r0 0 {C_WBL}
spa_op1_0900_rl_s0p5_r0 prea rbl_op1_0900_rl_s0p5_r0 ctl_op1_0900_rl_s0p5_r0 0 swpre
spr_op1_0900_rl_s0p5_r0 pref ref_op1_0900_rl_s0p5_r0 ctl_op1_0900_rl_s0p5_r0 0 swpre
crbl_op1_0900_rl_s0p5_r0 rbl_op1_0900_rl_s0p5_r0 0 {C_RBL}
cref_op1_0900_rl_s0p5_r0 ref_op1_0900_rl_s0p5_r0 0 {C_RBL}   $ ASSUMPTION: ideal matched dummy load
XMWR_op1_0900_rl_s0p5_r0_0 sn_op1_0900_rl_s0p5_r0_0 wwl_op1_0900_rl_s0p5_r0 wbl_op1_0900_rl_s0p5_r0 0 sky130_fd_pr__nfet_01v8 L=0.15 W=0.42 nf=1 ad=0.1218 as=0.1218 pd=1.42 ps=1.42 nrd=0.69047619047619  nrs=0.69047619047619 sa=0 sb=0 sd=0 mult=1 m=1
XMRD_op1_0900_rl_s0p5_r0_0 rbl_op1_0900_rl_s0p5_r0 sn_op1_0900_rl_s0p5_r0_0 rwls_op1_0900_rl_s0p5_r0 0 sky130_fd_pr__nfet_01v8 L=0.15 W=0.42 nf=1 ad=0.1218 as=0.1218 pd=1.42 ps=1.42 nrd=0.69047619047619  nrs=0.69047619047619 sa=0 sb=0 sd=0 mult=1 m=1
csn_op1_0900_rl_s0p5_r0_0 sn_op1_0900_rl_s0p5_r0_0 0 {C_SN}
XMWR_op1_0900_rl_s0p5_r0_1 sn_op1_0900_rl_s0p5_r0_1 wwl_des wbl_op1_0900_rl_s0p5_r0 0 sky130_fd_pr__nfet_01v8 L=0.15 W=0.42 nf=1 ad=0.1218 as=0.1218 pd=1.42 ps=1.42 nrd=0.69047619047619  nrs=0.69047619047619 sa=0 sb=0 sd=0 mult=1 m=1
XMRD_op1_0900_rl_s0p5_r0_1 rbl_op1_0900_rl_s0p5_r0 sn_op1_0900_rl_s0p5_r0_1 rwl_des 0 sky130_fd_pr__nfet_01v8 L=0.15 W=0.42 nf=1 ad=0.1218 as=0.1218 pd=1.42 ps=1.42 nrd=0.69047619047619  nrs=0.69047619047619 sa=0 sb=0 sd=0 mult=1 m=1
csn_op1_0900_rl_s0p5_r0_1 sn_op1_0900_rl_s0p5_r0_1 0 {C_SN}
XMWR_op1_0900_rl_s0p5_r0_2 sn_op1_0900_rl_s0p5_r0_2 wwl_des wbl_op1_0900_rl_s0p5_r0 0 sky130_fd_pr__nfet_01v8 L=0.15 W=0.42 nf=1 ad=0.1218 as=0.1218 pd=1.42 ps=1.42 nrd=0.69047619047619  nrs=0.69047619047619 sa=0 sb=0 sd=0 mult=1 m=1
XMRD_op1_0900_rl_s0p5_r0_2 rbl_op1_0900_rl_s0p5_r0 sn_op1_0900_rl_s0p5_r0_2 rwl_des 0 sky130_fd_pr__nfet_01v8 L=0.15 W=0.42 nf=1 ad=0.1218 as=0.1218 pd=1.42 ps=1.42 nrd=0.69047619047619  nrs=0.69047619047619 sa=0 sb=0 sd=0 mult=1 m=1
csn_op1_0900_rl_s0p5_r0_2 sn_op1_0900_rl_s0p5_r0_2 0 {C_SN}
XMWR_op1_0900_rl_s0p5_r0_3 sn_op1_0900_rl_s0p5_r0_3 wwl_des wbl_op1_0900_rl_s0p5_r0 0 sky130_fd_pr__nfet_01v8 L=0.15 W=0.42 nf=1 ad=0.1218 as=0.1218 pd=1.42 ps=1.42 nrd=0.69047619047619  nrs=0.69047619047619 sa=0 sb=0 sd=0 mult=1 m=1
XMRD_op1_0900_rl_s0p5_r0_3 rbl_op1_0900_rl_s0p5_r0 sn_op1_0900_rl_s0p5_r0_3 rwl_des 0 sky130_fd_pr__nfet_01v8 L=0.15 W=0.42 nf=1 ad=0.1218 as=0.1218 pd=1.42 ps=1.42 nrd=0.69047619047619  nrs=0.69047619047619 sa=0 sb=0 sd=0 mult=1 m=1
csn_op1_0900_rl_s0p5_r0_3 sn_op1_0900_rl_s0p5_r0_3 0 {C_SN}
XMN1_op1_0900_rl_s0p5_r0 rbl_op1_0900_rl_s0p5_r0 ref_op1_0900_rl_s0p5_r0 vn_op1_0900_rl_s0p5_r0 0 sky130_fd_pr__nfet_01v8 L=0.15 W=1 nf=1 ad=0.29 as=0.29 pd=2.58 ps=2.58 mult=1 m=1
XMN2_op1_0900_rl_s0p5_r0 ref_op1_0900_rl_s0p5_r0 rbl_op1_0900_rl_s0p5_r0 vn_op1_0900_rl_s0p5_r0 0 sky130_fd_pr__nfet_01v8 L=0.15 W=1 nf=1 ad=0.29 as=0.29 pd=2.58 ps=2.58 mult=1 m=1
XMP1_op1_0900_rl_s0p5_r0 rbl_op1_0900_rl_s0p5_r0 ref_op1_0900_rl_s0p5_r0 vp_op1_0900_rl_s0p5_r0 vdd sky130_fd_pr__pfet_01v8 L=0.15 W=2 nf=1 ad=0.58 as=0.58 pd=4.58 ps=4.58 mult=1 m=1
XMP2_op1_0900_rl_s0p5_r0 ref_op1_0900_rl_s0p5_r0 rbl_op1_0900_rl_s0p5_r0 vp_op1_0900_rl_s0p5_r0 vdd sky130_fd_pr__pfet_01v8 L=0.15 W=2 nf=1 ad=0.58 as=0.58 pd=4.58 ps=4.58 mult=1 m=1
XMNF_op1_0900_rl_s0p5_r0 vn_op1_0900_rl_s0p5_r0 en_op1_0900_rl_s0p5_r0 0 0 sky130_fd_pr__nfet_01v8 L=0.15 W=2 nf=1 ad=0.58 as=0.58 pd=4.58 ps=4.58 mult=1 m=1
XMPH_op1_0900_rl_s0p5_r0 vp_op1_0900_rl_s0p5_r0 enb_op1_0900_rl_s0p5_r0 vdd vdd sky130_fd_pr__pfet_01v8 L=0.15 W=4 nf=1 ad=1.16 as=1.16 pd=8.58 ps=8.58 mult=1 m=1
bd_op1_0900_rl_s0p5_r0 d_op1_0900_rl_s0p5_r0 0 v=v(rbl_op1_0900_rl_s0p5_r0)-v(ref_op1_0900_rl_s0p5_r0)

* ---- instance 162: op1_1000_rl_s0p5_r0 (variant rl_s0p5_r0; probe dec 11.9 ns, release 34 ns, meas 36 ns) ----
vctl_op1_1000_rl_s0p5_r0 ctl_op1_1000_rl_s0p5_r0 0 pwl(0.0000e+00 {VDD} 2.0000e-09 {VDD} 2.1000e-09 0)
* RWL driver model (EXPERIMENTAL): slew 0.5 ns, series R 0 ohm; cell pin = rwls_op1_1000_rl_s0p5_r0
vrs_op1_1000_rl_s0p5_r0 rwls_op1_1000_rl_s0p5_r0 0 pwl(0.0000e+00 {VDD} 2.0000e-09 {VDD} 2.5000e-09 0 3.4000e-08 0 3.4500e-08 {VDD})
ven_op1_1000_rl_s0p5_r0 en_op1_1000_rl_s0p5_r0 0 pwl(0.0000e+00 0 1.1000e-08 0 1.1100e-08 {VDD} 3.4000e-08 {VDD} 3.4100e-08 0)
venb_op1_1000_rl_s0p5_r0 enb_op1_1000_rl_s0p5_r0 0 pwl(0.0000e+00 {VDD} 1.1000e-08 {VDD} 1.1100e-08 0 3.4000e-08 0 3.4100e-08 {VDD})
vww_op1_1000_rl_s0p5_r0 wwl_op1_1000_rl_s0p5_r0 0 pwl(0.0000e+00 0 1.2000e-08 0 1.2100e-08 {VDD} 3.2000e-08 {VDD} 3.2100e-08 0)
vwc_op1_1000_rl_s0p5_r0 wbc_op1_1000_rl_s0p5_r0 0 pwl(0.0000e+00 0 1.2000e-08 0 1.2100e-08 {VDD} 3.4000e-08 {VDD} 3.4100e-08 0)
swb_op1_1000_rl_s0p5_r0 ref_op1_1000_rl_s0p5_r0 wbl_op1_1000_rl_s0p5_r0 wbc_op1_1000_rl_s0p5_r0 0 swwbl
cwbl_op1_1000_rl_s0p5_r0 wbl_op1_1000_rl_s0p5_r0 0 {C_WBL}
spa_op1_1000_rl_s0p5_r0 prea rbl_op1_1000_rl_s0p5_r0 ctl_op1_1000_rl_s0p5_r0 0 swpre
spr_op1_1000_rl_s0p5_r0 pref ref_op1_1000_rl_s0p5_r0 ctl_op1_1000_rl_s0p5_r0 0 swpre
crbl_op1_1000_rl_s0p5_r0 rbl_op1_1000_rl_s0p5_r0 0 {C_RBL}
cref_op1_1000_rl_s0p5_r0 ref_op1_1000_rl_s0p5_r0 0 {C_RBL}   $ ASSUMPTION: ideal matched dummy load
XMWR_op1_1000_rl_s0p5_r0_0 sn_op1_1000_rl_s0p5_r0_0 wwl_op1_1000_rl_s0p5_r0 wbl_op1_1000_rl_s0p5_r0 0 sky130_fd_pr__nfet_01v8 L=0.15 W=0.42 nf=1 ad=0.1218 as=0.1218 pd=1.42 ps=1.42 nrd=0.69047619047619  nrs=0.69047619047619 sa=0 sb=0 sd=0 mult=1 m=1
XMRD_op1_1000_rl_s0p5_r0_0 rbl_op1_1000_rl_s0p5_r0 sn_op1_1000_rl_s0p5_r0_0 rwls_op1_1000_rl_s0p5_r0 0 sky130_fd_pr__nfet_01v8 L=0.15 W=0.42 nf=1 ad=0.1218 as=0.1218 pd=1.42 ps=1.42 nrd=0.69047619047619  nrs=0.69047619047619 sa=0 sb=0 sd=0 mult=1 m=1
csn_op1_1000_rl_s0p5_r0_0 sn_op1_1000_rl_s0p5_r0_0 0 {C_SN}
XMWR_op1_1000_rl_s0p5_r0_1 sn_op1_1000_rl_s0p5_r0_1 wwl_des wbl_op1_1000_rl_s0p5_r0 0 sky130_fd_pr__nfet_01v8 L=0.15 W=0.42 nf=1 ad=0.1218 as=0.1218 pd=1.42 ps=1.42 nrd=0.69047619047619  nrs=0.69047619047619 sa=0 sb=0 sd=0 mult=1 m=1
XMRD_op1_1000_rl_s0p5_r0_1 rbl_op1_1000_rl_s0p5_r0 sn_op1_1000_rl_s0p5_r0_1 rwl_des 0 sky130_fd_pr__nfet_01v8 L=0.15 W=0.42 nf=1 ad=0.1218 as=0.1218 pd=1.42 ps=1.42 nrd=0.69047619047619  nrs=0.69047619047619 sa=0 sb=0 sd=0 mult=1 m=1
csn_op1_1000_rl_s0p5_r0_1 sn_op1_1000_rl_s0p5_r0_1 0 {C_SN}
XMWR_op1_1000_rl_s0p5_r0_2 sn_op1_1000_rl_s0p5_r0_2 wwl_des wbl_op1_1000_rl_s0p5_r0 0 sky130_fd_pr__nfet_01v8 L=0.15 W=0.42 nf=1 ad=0.1218 as=0.1218 pd=1.42 ps=1.42 nrd=0.69047619047619  nrs=0.69047619047619 sa=0 sb=0 sd=0 mult=1 m=1
XMRD_op1_1000_rl_s0p5_r0_2 rbl_op1_1000_rl_s0p5_r0 sn_op1_1000_rl_s0p5_r0_2 rwl_des 0 sky130_fd_pr__nfet_01v8 L=0.15 W=0.42 nf=1 ad=0.1218 as=0.1218 pd=1.42 ps=1.42 nrd=0.69047619047619  nrs=0.69047619047619 sa=0 sb=0 sd=0 mult=1 m=1
csn_op1_1000_rl_s0p5_r0_2 sn_op1_1000_rl_s0p5_r0_2 0 {C_SN}
XMWR_op1_1000_rl_s0p5_r0_3 sn_op1_1000_rl_s0p5_r0_3 wwl_des wbl_op1_1000_rl_s0p5_r0 0 sky130_fd_pr__nfet_01v8 L=0.15 W=0.42 nf=1 ad=0.1218 as=0.1218 pd=1.42 ps=1.42 nrd=0.69047619047619  nrs=0.69047619047619 sa=0 sb=0 sd=0 mult=1 m=1
XMRD_op1_1000_rl_s0p5_r0_3 rbl_op1_1000_rl_s0p5_r0 sn_op1_1000_rl_s0p5_r0_3 rwl_des 0 sky130_fd_pr__nfet_01v8 L=0.15 W=0.42 nf=1 ad=0.1218 as=0.1218 pd=1.42 ps=1.42 nrd=0.69047619047619  nrs=0.69047619047619 sa=0 sb=0 sd=0 mult=1 m=1
csn_op1_1000_rl_s0p5_r0_3 sn_op1_1000_rl_s0p5_r0_3 0 {C_SN}
XMN1_op1_1000_rl_s0p5_r0 rbl_op1_1000_rl_s0p5_r0 ref_op1_1000_rl_s0p5_r0 vn_op1_1000_rl_s0p5_r0 0 sky130_fd_pr__nfet_01v8 L=0.15 W=1 nf=1 ad=0.29 as=0.29 pd=2.58 ps=2.58 mult=1 m=1
XMN2_op1_1000_rl_s0p5_r0 ref_op1_1000_rl_s0p5_r0 rbl_op1_1000_rl_s0p5_r0 vn_op1_1000_rl_s0p5_r0 0 sky130_fd_pr__nfet_01v8 L=0.15 W=1 nf=1 ad=0.29 as=0.29 pd=2.58 ps=2.58 mult=1 m=1
XMP1_op1_1000_rl_s0p5_r0 rbl_op1_1000_rl_s0p5_r0 ref_op1_1000_rl_s0p5_r0 vp_op1_1000_rl_s0p5_r0 vdd sky130_fd_pr__pfet_01v8 L=0.15 W=2 nf=1 ad=0.58 as=0.58 pd=4.58 ps=4.58 mult=1 m=1
XMP2_op1_1000_rl_s0p5_r0 ref_op1_1000_rl_s0p5_r0 rbl_op1_1000_rl_s0p5_r0 vp_op1_1000_rl_s0p5_r0 vdd sky130_fd_pr__pfet_01v8 L=0.15 W=2 nf=1 ad=0.58 as=0.58 pd=4.58 ps=4.58 mult=1 m=1
XMNF_op1_1000_rl_s0p5_r0 vn_op1_1000_rl_s0p5_r0 en_op1_1000_rl_s0p5_r0 0 0 sky130_fd_pr__nfet_01v8 L=0.15 W=2 nf=1 ad=0.58 as=0.58 pd=4.58 ps=4.58 mult=1 m=1
XMPH_op1_1000_rl_s0p5_r0 vp_op1_1000_rl_s0p5_r0 enb_op1_1000_rl_s0p5_r0 vdd vdd sky130_fd_pr__pfet_01v8 L=0.15 W=4 nf=1 ad=1.16 as=1.16 pd=8.58 ps=8.58 mult=1 m=1
bd_op1_1000_rl_s0p5_r0 d_op1_1000_rl_s0p5_r0 0 v=v(rbl_op1_1000_rl_s0p5_r0)-v(ref_op1_1000_rl_s0p5_r0)

* ---- instance 163: op0_n100_rl_s0p5_r0 (variant rl_s0p5_r0; probe dec 11.9 ns, release 34 ns, meas 36 ns) ----
vctl_op0_n100_rl_s0p5_r0 ctl_op0_n100_rl_s0p5_r0 0 pwl(0.0000e+00 {VDD} 2.0000e-09 {VDD} 2.1000e-09 0)
* RWL driver model (EXPERIMENTAL): slew 0.5 ns, series R 0 ohm; cell pin = rwls_op0_n100_rl_s0p5_r0
vrs_op0_n100_rl_s0p5_r0 rwls_op0_n100_rl_s0p5_r0 0 pwl(0.0000e+00 {VDD} 2.0000e-09 {VDD} 2.5000e-09 0 3.4000e-08 0 3.4500e-08 {VDD})
ven_op0_n100_rl_s0p5_r0 en_op0_n100_rl_s0p5_r0 0 pwl(0.0000e+00 0 1.1000e-08 0 1.1100e-08 {VDD} 3.4000e-08 {VDD} 3.4100e-08 0)
venb_op0_n100_rl_s0p5_r0 enb_op0_n100_rl_s0p5_r0 0 pwl(0.0000e+00 {VDD} 1.1000e-08 {VDD} 1.1100e-08 0 3.4000e-08 0 3.4100e-08 {VDD})
vww_op0_n100_rl_s0p5_r0 wwl_op0_n100_rl_s0p5_r0 0 pwl(0.0000e+00 0 1.2000e-08 0 1.2100e-08 {VDD} 3.2000e-08 {VDD} 3.2100e-08 0)
vwc_op0_n100_rl_s0p5_r0 wbc_op0_n100_rl_s0p5_r0 0 pwl(0.0000e+00 0 1.2000e-08 0 1.2100e-08 {VDD} 3.4000e-08 {VDD} 3.4100e-08 0)
swb_op0_n100_rl_s0p5_r0 ref_op0_n100_rl_s0p5_r0 wbl_op0_n100_rl_s0p5_r0 wbc_op0_n100_rl_s0p5_r0 0 swwbl
cwbl_op0_n100_rl_s0p5_r0 wbl_op0_n100_rl_s0p5_r0 0 {C_WBL}
spa_op0_n100_rl_s0p5_r0 prea rbl_op0_n100_rl_s0p5_r0 ctl_op0_n100_rl_s0p5_r0 0 swpre
spr_op0_n100_rl_s0p5_r0 pref ref_op0_n100_rl_s0p5_r0 ctl_op0_n100_rl_s0p5_r0 0 swpre
crbl_op0_n100_rl_s0p5_r0 rbl_op0_n100_rl_s0p5_r0 0 {C_RBL}
cref_op0_n100_rl_s0p5_r0 ref_op0_n100_rl_s0p5_r0 0 {C_RBL}   $ ASSUMPTION: ideal matched dummy load
XMWR_op0_n100_rl_s0p5_r0_0 sn_op0_n100_rl_s0p5_r0_0 wwl_op0_n100_rl_s0p5_r0 wbl_op0_n100_rl_s0p5_r0 0 sky130_fd_pr__nfet_01v8 L=0.15 W=0.42 nf=1 ad=0.1218 as=0.1218 pd=1.42 ps=1.42 nrd=0.69047619047619  nrs=0.69047619047619 sa=0 sb=0 sd=0 mult=1 m=1
XMRD_op0_n100_rl_s0p5_r0_0 rbl_op0_n100_rl_s0p5_r0 sn_op0_n100_rl_s0p5_r0_0 rwls_op0_n100_rl_s0p5_r0 0 sky130_fd_pr__nfet_01v8 L=0.15 W=0.42 nf=1 ad=0.1218 as=0.1218 pd=1.42 ps=1.42 nrd=0.69047619047619  nrs=0.69047619047619 sa=0 sb=0 sd=0 mult=1 m=1
csn_op0_n100_rl_s0p5_r0_0 sn_op0_n100_rl_s0p5_r0_0 0 {C_SN}
XMWR_op0_n100_rl_s0p5_r0_1 sn_op0_n100_rl_s0p5_r0_1 wwl_des wbl_op0_n100_rl_s0p5_r0 0 sky130_fd_pr__nfet_01v8 L=0.15 W=0.42 nf=1 ad=0.1218 as=0.1218 pd=1.42 ps=1.42 nrd=0.69047619047619  nrs=0.69047619047619 sa=0 sb=0 sd=0 mult=1 m=1
XMRD_op0_n100_rl_s0p5_r0_1 rbl_op0_n100_rl_s0p5_r0 sn_op0_n100_rl_s0p5_r0_1 rwl_des 0 sky130_fd_pr__nfet_01v8 L=0.15 W=0.42 nf=1 ad=0.1218 as=0.1218 pd=1.42 ps=1.42 nrd=0.69047619047619  nrs=0.69047619047619 sa=0 sb=0 sd=0 mult=1 m=1
csn_op0_n100_rl_s0p5_r0_1 sn_op0_n100_rl_s0p5_r0_1 0 {C_SN}
XMWR_op0_n100_rl_s0p5_r0_2 sn_op0_n100_rl_s0p5_r0_2 wwl_des wbl_op0_n100_rl_s0p5_r0 0 sky130_fd_pr__nfet_01v8 L=0.15 W=0.42 nf=1 ad=0.1218 as=0.1218 pd=1.42 ps=1.42 nrd=0.69047619047619  nrs=0.69047619047619 sa=0 sb=0 sd=0 mult=1 m=1
XMRD_op0_n100_rl_s0p5_r0_2 rbl_op0_n100_rl_s0p5_r0 sn_op0_n100_rl_s0p5_r0_2 rwl_des 0 sky130_fd_pr__nfet_01v8 L=0.15 W=0.42 nf=1 ad=0.1218 as=0.1218 pd=1.42 ps=1.42 nrd=0.69047619047619  nrs=0.69047619047619 sa=0 sb=0 sd=0 mult=1 m=1
csn_op0_n100_rl_s0p5_r0_2 sn_op0_n100_rl_s0p5_r0_2 0 {C_SN}
XMWR_op0_n100_rl_s0p5_r0_3 sn_op0_n100_rl_s0p5_r0_3 wwl_des wbl_op0_n100_rl_s0p5_r0 0 sky130_fd_pr__nfet_01v8 L=0.15 W=0.42 nf=1 ad=0.1218 as=0.1218 pd=1.42 ps=1.42 nrd=0.69047619047619  nrs=0.69047619047619 sa=0 sb=0 sd=0 mult=1 m=1
XMRD_op0_n100_rl_s0p5_r0_3 rbl_op0_n100_rl_s0p5_r0 sn_op0_n100_rl_s0p5_r0_3 rwl_des 0 sky130_fd_pr__nfet_01v8 L=0.15 W=0.42 nf=1 ad=0.1218 as=0.1218 pd=1.42 ps=1.42 nrd=0.69047619047619  nrs=0.69047619047619 sa=0 sb=0 sd=0 mult=1 m=1
csn_op0_n100_rl_s0p5_r0_3 sn_op0_n100_rl_s0p5_r0_3 0 {C_SN}
XMN1_op0_n100_rl_s0p5_r0 rbl_op0_n100_rl_s0p5_r0 ref_op0_n100_rl_s0p5_r0 vn_op0_n100_rl_s0p5_r0 0 sky130_fd_pr__nfet_01v8 L=0.15 W=1 nf=1 ad=0.29 as=0.29 pd=2.58 ps=2.58 mult=1 m=1
XMN2_op0_n100_rl_s0p5_r0 ref_op0_n100_rl_s0p5_r0 rbl_op0_n100_rl_s0p5_r0 vn_op0_n100_rl_s0p5_r0 0 sky130_fd_pr__nfet_01v8 L=0.15 W=1 nf=1 ad=0.29 as=0.29 pd=2.58 ps=2.58 mult=1 m=1
XMP1_op0_n100_rl_s0p5_r0 rbl_op0_n100_rl_s0p5_r0 ref_op0_n100_rl_s0p5_r0 vp_op0_n100_rl_s0p5_r0 vdd sky130_fd_pr__pfet_01v8 L=0.15 W=2 nf=1 ad=0.58 as=0.58 pd=4.58 ps=4.58 mult=1 m=1
XMP2_op0_n100_rl_s0p5_r0 ref_op0_n100_rl_s0p5_r0 rbl_op0_n100_rl_s0p5_r0 vp_op0_n100_rl_s0p5_r0 vdd sky130_fd_pr__pfet_01v8 L=0.15 W=2 nf=1 ad=0.58 as=0.58 pd=4.58 ps=4.58 mult=1 m=1
XMNF_op0_n100_rl_s0p5_r0 vn_op0_n100_rl_s0p5_r0 en_op0_n100_rl_s0p5_r0 0 0 sky130_fd_pr__nfet_01v8 L=0.15 W=2 nf=1 ad=0.58 as=0.58 pd=4.58 ps=4.58 mult=1 m=1
XMPH_op0_n100_rl_s0p5_r0 vp_op0_n100_rl_s0p5_r0 enb_op0_n100_rl_s0p5_r0 vdd vdd sky130_fd_pr__pfet_01v8 L=0.15 W=4 nf=1 ad=1.16 as=1.16 pd=8.58 ps=8.58 mult=1 m=1
bd_op0_n100_rl_s0p5_r0 d_op0_n100_rl_s0p5_r0 0 v=v(rbl_op0_n100_rl_s0p5_r0)-v(ref_op0_n100_rl_s0p5_r0)

* ---- instance 164: op0_0000_rl_s0p5_r0 (variant rl_s0p5_r0; probe dec 11.9 ns, release 34 ns, meas 36 ns) ----
vctl_op0_0000_rl_s0p5_r0 ctl_op0_0000_rl_s0p5_r0 0 pwl(0.0000e+00 {VDD} 2.0000e-09 {VDD} 2.1000e-09 0)
* RWL driver model (EXPERIMENTAL): slew 0.5 ns, series R 0 ohm; cell pin = rwls_op0_0000_rl_s0p5_r0
vrs_op0_0000_rl_s0p5_r0 rwls_op0_0000_rl_s0p5_r0 0 pwl(0.0000e+00 {VDD} 2.0000e-09 {VDD} 2.5000e-09 0 3.4000e-08 0 3.4500e-08 {VDD})
ven_op0_0000_rl_s0p5_r0 en_op0_0000_rl_s0p5_r0 0 pwl(0.0000e+00 0 1.1000e-08 0 1.1100e-08 {VDD} 3.4000e-08 {VDD} 3.4100e-08 0)
venb_op0_0000_rl_s0p5_r0 enb_op0_0000_rl_s0p5_r0 0 pwl(0.0000e+00 {VDD} 1.1000e-08 {VDD} 1.1100e-08 0 3.4000e-08 0 3.4100e-08 {VDD})
vww_op0_0000_rl_s0p5_r0 wwl_op0_0000_rl_s0p5_r0 0 pwl(0.0000e+00 0 1.2000e-08 0 1.2100e-08 {VDD} 3.2000e-08 {VDD} 3.2100e-08 0)
vwc_op0_0000_rl_s0p5_r0 wbc_op0_0000_rl_s0p5_r0 0 pwl(0.0000e+00 0 1.2000e-08 0 1.2100e-08 {VDD} 3.4000e-08 {VDD} 3.4100e-08 0)
swb_op0_0000_rl_s0p5_r0 ref_op0_0000_rl_s0p5_r0 wbl_op0_0000_rl_s0p5_r0 wbc_op0_0000_rl_s0p5_r0 0 swwbl
cwbl_op0_0000_rl_s0p5_r0 wbl_op0_0000_rl_s0p5_r0 0 {C_WBL}
spa_op0_0000_rl_s0p5_r0 prea rbl_op0_0000_rl_s0p5_r0 ctl_op0_0000_rl_s0p5_r0 0 swpre
spr_op0_0000_rl_s0p5_r0 pref ref_op0_0000_rl_s0p5_r0 ctl_op0_0000_rl_s0p5_r0 0 swpre
crbl_op0_0000_rl_s0p5_r0 rbl_op0_0000_rl_s0p5_r0 0 {C_RBL}
cref_op0_0000_rl_s0p5_r0 ref_op0_0000_rl_s0p5_r0 0 {C_RBL}   $ ASSUMPTION: ideal matched dummy load
XMWR_op0_0000_rl_s0p5_r0_0 sn_op0_0000_rl_s0p5_r0_0 wwl_op0_0000_rl_s0p5_r0 wbl_op0_0000_rl_s0p5_r0 0 sky130_fd_pr__nfet_01v8 L=0.15 W=0.42 nf=1 ad=0.1218 as=0.1218 pd=1.42 ps=1.42 nrd=0.69047619047619  nrs=0.69047619047619 sa=0 sb=0 sd=0 mult=1 m=1
XMRD_op0_0000_rl_s0p5_r0_0 rbl_op0_0000_rl_s0p5_r0 sn_op0_0000_rl_s0p5_r0_0 rwls_op0_0000_rl_s0p5_r0 0 sky130_fd_pr__nfet_01v8 L=0.15 W=0.42 nf=1 ad=0.1218 as=0.1218 pd=1.42 ps=1.42 nrd=0.69047619047619  nrs=0.69047619047619 sa=0 sb=0 sd=0 mult=1 m=1
csn_op0_0000_rl_s0p5_r0_0 sn_op0_0000_rl_s0p5_r0_0 0 {C_SN}
XMWR_op0_0000_rl_s0p5_r0_1 sn_op0_0000_rl_s0p5_r0_1 wwl_des wbl_op0_0000_rl_s0p5_r0 0 sky130_fd_pr__nfet_01v8 L=0.15 W=0.42 nf=1 ad=0.1218 as=0.1218 pd=1.42 ps=1.42 nrd=0.69047619047619  nrs=0.69047619047619 sa=0 sb=0 sd=0 mult=1 m=1
XMRD_op0_0000_rl_s0p5_r0_1 rbl_op0_0000_rl_s0p5_r0 sn_op0_0000_rl_s0p5_r0_1 rwl_des 0 sky130_fd_pr__nfet_01v8 L=0.15 W=0.42 nf=1 ad=0.1218 as=0.1218 pd=1.42 ps=1.42 nrd=0.69047619047619  nrs=0.69047619047619 sa=0 sb=0 sd=0 mult=1 m=1
csn_op0_0000_rl_s0p5_r0_1 sn_op0_0000_rl_s0p5_r0_1 0 {C_SN}
XMWR_op0_0000_rl_s0p5_r0_2 sn_op0_0000_rl_s0p5_r0_2 wwl_des wbl_op0_0000_rl_s0p5_r0 0 sky130_fd_pr__nfet_01v8 L=0.15 W=0.42 nf=1 ad=0.1218 as=0.1218 pd=1.42 ps=1.42 nrd=0.69047619047619  nrs=0.69047619047619 sa=0 sb=0 sd=0 mult=1 m=1
XMRD_op0_0000_rl_s0p5_r0_2 rbl_op0_0000_rl_s0p5_r0 sn_op0_0000_rl_s0p5_r0_2 rwl_des 0 sky130_fd_pr__nfet_01v8 L=0.15 W=0.42 nf=1 ad=0.1218 as=0.1218 pd=1.42 ps=1.42 nrd=0.69047619047619  nrs=0.69047619047619 sa=0 sb=0 sd=0 mult=1 m=1
csn_op0_0000_rl_s0p5_r0_2 sn_op0_0000_rl_s0p5_r0_2 0 {C_SN}
XMWR_op0_0000_rl_s0p5_r0_3 sn_op0_0000_rl_s0p5_r0_3 wwl_des wbl_op0_0000_rl_s0p5_r0 0 sky130_fd_pr__nfet_01v8 L=0.15 W=0.42 nf=1 ad=0.1218 as=0.1218 pd=1.42 ps=1.42 nrd=0.69047619047619  nrs=0.69047619047619 sa=0 sb=0 sd=0 mult=1 m=1
XMRD_op0_0000_rl_s0p5_r0_3 rbl_op0_0000_rl_s0p5_r0 sn_op0_0000_rl_s0p5_r0_3 rwl_des 0 sky130_fd_pr__nfet_01v8 L=0.15 W=0.42 nf=1 ad=0.1218 as=0.1218 pd=1.42 ps=1.42 nrd=0.69047619047619  nrs=0.69047619047619 sa=0 sb=0 sd=0 mult=1 m=1
csn_op0_0000_rl_s0p5_r0_3 sn_op0_0000_rl_s0p5_r0_3 0 {C_SN}
XMN1_op0_0000_rl_s0p5_r0 rbl_op0_0000_rl_s0p5_r0 ref_op0_0000_rl_s0p5_r0 vn_op0_0000_rl_s0p5_r0 0 sky130_fd_pr__nfet_01v8 L=0.15 W=1 nf=1 ad=0.29 as=0.29 pd=2.58 ps=2.58 mult=1 m=1
XMN2_op0_0000_rl_s0p5_r0 ref_op0_0000_rl_s0p5_r0 rbl_op0_0000_rl_s0p5_r0 vn_op0_0000_rl_s0p5_r0 0 sky130_fd_pr__nfet_01v8 L=0.15 W=1 nf=1 ad=0.29 as=0.29 pd=2.58 ps=2.58 mult=1 m=1
XMP1_op0_0000_rl_s0p5_r0 rbl_op0_0000_rl_s0p5_r0 ref_op0_0000_rl_s0p5_r0 vp_op0_0000_rl_s0p5_r0 vdd sky130_fd_pr__pfet_01v8 L=0.15 W=2 nf=1 ad=0.58 as=0.58 pd=4.58 ps=4.58 mult=1 m=1
XMP2_op0_0000_rl_s0p5_r0 ref_op0_0000_rl_s0p5_r0 rbl_op0_0000_rl_s0p5_r0 vp_op0_0000_rl_s0p5_r0 vdd sky130_fd_pr__pfet_01v8 L=0.15 W=2 nf=1 ad=0.58 as=0.58 pd=4.58 ps=4.58 mult=1 m=1
XMNF_op0_0000_rl_s0p5_r0 vn_op0_0000_rl_s0p5_r0 en_op0_0000_rl_s0p5_r0 0 0 sky130_fd_pr__nfet_01v8 L=0.15 W=2 nf=1 ad=0.58 as=0.58 pd=4.58 ps=4.58 mult=1 m=1
XMPH_op0_0000_rl_s0p5_r0 vp_op0_0000_rl_s0p5_r0 enb_op0_0000_rl_s0p5_r0 vdd vdd sky130_fd_pr__pfet_01v8 L=0.15 W=4 nf=1 ad=1.16 as=1.16 pd=8.58 ps=8.58 mult=1 m=1
bd_op0_0000_rl_s0p5_r0 d_op0_0000_rl_s0p5_r0 0 v=v(rbl_op0_0000_rl_s0p5_r0)-v(ref_op0_0000_rl_s0p5_r0)

* ---- instance 165: op1_0900_rl_s1_r0 (variant rl_s1_r0; probe dec 11.9 ns, release 34 ns, meas 36 ns) ----
vctl_op1_0900_rl_s1_r0 ctl_op1_0900_rl_s1_r0 0 pwl(0.0000e+00 {VDD} 2.0000e-09 {VDD} 2.1000e-09 0)
* RWL driver model (EXPERIMENTAL): slew 1 ns, series R 0 ohm; cell pin = rwls_op1_0900_rl_s1_r0
vrs_op1_0900_rl_s1_r0 rwls_op1_0900_rl_s1_r0 0 pwl(0.0000e+00 {VDD} 2.0000e-09 {VDD} 3.0000e-09 0 3.4000e-08 0 3.5000e-08 {VDD})
ven_op1_0900_rl_s1_r0 en_op1_0900_rl_s1_r0 0 pwl(0.0000e+00 0 1.1000e-08 0 1.1100e-08 {VDD} 3.4000e-08 {VDD} 3.4100e-08 0)
venb_op1_0900_rl_s1_r0 enb_op1_0900_rl_s1_r0 0 pwl(0.0000e+00 {VDD} 1.1000e-08 {VDD} 1.1100e-08 0 3.4000e-08 0 3.4100e-08 {VDD})
vww_op1_0900_rl_s1_r0 wwl_op1_0900_rl_s1_r0 0 pwl(0.0000e+00 0 1.2000e-08 0 1.2100e-08 {VDD} 3.2000e-08 {VDD} 3.2100e-08 0)
vwc_op1_0900_rl_s1_r0 wbc_op1_0900_rl_s1_r0 0 pwl(0.0000e+00 0 1.2000e-08 0 1.2100e-08 {VDD} 3.4000e-08 {VDD} 3.4100e-08 0)
swb_op1_0900_rl_s1_r0 ref_op1_0900_rl_s1_r0 wbl_op1_0900_rl_s1_r0 wbc_op1_0900_rl_s1_r0 0 swwbl
cwbl_op1_0900_rl_s1_r0 wbl_op1_0900_rl_s1_r0 0 {C_WBL}
spa_op1_0900_rl_s1_r0 prea rbl_op1_0900_rl_s1_r0 ctl_op1_0900_rl_s1_r0 0 swpre
spr_op1_0900_rl_s1_r0 pref ref_op1_0900_rl_s1_r0 ctl_op1_0900_rl_s1_r0 0 swpre
crbl_op1_0900_rl_s1_r0 rbl_op1_0900_rl_s1_r0 0 {C_RBL}
cref_op1_0900_rl_s1_r0 ref_op1_0900_rl_s1_r0 0 {C_RBL}   $ ASSUMPTION: ideal matched dummy load
XMWR_op1_0900_rl_s1_r0_0 sn_op1_0900_rl_s1_r0_0 wwl_op1_0900_rl_s1_r0 wbl_op1_0900_rl_s1_r0 0 sky130_fd_pr__nfet_01v8 L=0.15 W=0.42 nf=1 ad=0.1218 as=0.1218 pd=1.42 ps=1.42 nrd=0.69047619047619  nrs=0.69047619047619 sa=0 sb=0 sd=0 mult=1 m=1
XMRD_op1_0900_rl_s1_r0_0 rbl_op1_0900_rl_s1_r0 sn_op1_0900_rl_s1_r0_0 rwls_op1_0900_rl_s1_r0 0 sky130_fd_pr__nfet_01v8 L=0.15 W=0.42 nf=1 ad=0.1218 as=0.1218 pd=1.42 ps=1.42 nrd=0.69047619047619  nrs=0.69047619047619 sa=0 sb=0 sd=0 mult=1 m=1
csn_op1_0900_rl_s1_r0_0 sn_op1_0900_rl_s1_r0_0 0 {C_SN}
XMWR_op1_0900_rl_s1_r0_1 sn_op1_0900_rl_s1_r0_1 wwl_des wbl_op1_0900_rl_s1_r0 0 sky130_fd_pr__nfet_01v8 L=0.15 W=0.42 nf=1 ad=0.1218 as=0.1218 pd=1.42 ps=1.42 nrd=0.69047619047619  nrs=0.69047619047619 sa=0 sb=0 sd=0 mult=1 m=1
XMRD_op1_0900_rl_s1_r0_1 rbl_op1_0900_rl_s1_r0 sn_op1_0900_rl_s1_r0_1 rwl_des 0 sky130_fd_pr__nfet_01v8 L=0.15 W=0.42 nf=1 ad=0.1218 as=0.1218 pd=1.42 ps=1.42 nrd=0.69047619047619  nrs=0.69047619047619 sa=0 sb=0 sd=0 mult=1 m=1
csn_op1_0900_rl_s1_r0_1 sn_op1_0900_rl_s1_r0_1 0 {C_SN}
XMWR_op1_0900_rl_s1_r0_2 sn_op1_0900_rl_s1_r0_2 wwl_des wbl_op1_0900_rl_s1_r0 0 sky130_fd_pr__nfet_01v8 L=0.15 W=0.42 nf=1 ad=0.1218 as=0.1218 pd=1.42 ps=1.42 nrd=0.69047619047619  nrs=0.69047619047619 sa=0 sb=0 sd=0 mult=1 m=1
XMRD_op1_0900_rl_s1_r0_2 rbl_op1_0900_rl_s1_r0 sn_op1_0900_rl_s1_r0_2 rwl_des 0 sky130_fd_pr__nfet_01v8 L=0.15 W=0.42 nf=1 ad=0.1218 as=0.1218 pd=1.42 ps=1.42 nrd=0.69047619047619  nrs=0.69047619047619 sa=0 sb=0 sd=0 mult=1 m=1
csn_op1_0900_rl_s1_r0_2 sn_op1_0900_rl_s1_r0_2 0 {C_SN}
XMWR_op1_0900_rl_s1_r0_3 sn_op1_0900_rl_s1_r0_3 wwl_des wbl_op1_0900_rl_s1_r0 0 sky130_fd_pr__nfet_01v8 L=0.15 W=0.42 nf=1 ad=0.1218 as=0.1218 pd=1.42 ps=1.42 nrd=0.69047619047619  nrs=0.69047619047619 sa=0 sb=0 sd=0 mult=1 m=1
XMRD_op1_0900_rl_s1_r0_3 rbl_op1_0900_rl_s1_r0 sn_op1_0900_rl_s1_r0_3 rwl_des 0 sky130_fd_pr__nfet_01v8 L=0.15 W=0.42 nf=1 ad=0.1218 as=0.1218 pd=1.42 ps=1.42 nrd=0.69047619047619  nrs=0.69047619047619 sa=0 sb=0 sd=0 mult=1 m=1
csn_op1_0900_rl_s1_r0_3 sn_op1_0900_rl_s1_r0_3 0 {C_SN}
XMN1_op1_0900_rl_s1_r0 rbl_op1_0900_rl_s1_r0 ref_op1_0900_rl_s1_r0 vn_op1_0900_rl_s1_r0 0 sky130_fd_pr__nfet_01v8 L=0.15 W=1 nf=1 ad=0.29 as=0.29 pd=2.58 ps=2.58 mult=1 m=1
XMN2_op1_0900_rl_s1_r0 ref_op1_0900_rl_s1_r0 rbl_op1_0900_rl_s1_r0 vn_op1_0900_rl_s1_r0 0 sky130_fd_pr__nfet_01v8 L=0.15 W=1 nf=1 ad=0.29 as=0.29 pd=2.58 ps=2.58 mult=1 m=1
XMP1_op1_0900_rl_s1_r0 rbl_op1_0900_rl_s1_r0 ref_op1_0900_rl_s1_r0 vp_op1_0900_rl_s1_r0 vdd sky130_fd_pr__pfet_01v8 L=0.15 W=2 nf=1 ad=0.58 as=0.58 pd=4.58 ps=4.58 mult=1 m=1
XMP2_op1_0900_rl_s1_r0 ref_op1_0900_rl_s1_r0 rbl_op1_0900_rl_s1_r0 vp_op1_0900_rl_s1_r0 vdd sky130_fd_pr__pfet_01v8 L=0.15 W=2 nf=1 ad=0.58 as=0.58 pd=4.58 ps=4.58 mult=1 m=1
XMNF_op1_0900_rl_s1_r0 vn_op1_0900_rl_s1_r0 en_op1_0900_rl_s1_r0 0 0 sky130_fd_pr__nfet_01v8 L=0.15 W=2 nf=1 ad=0.58 as=0.58 pd=4.58 ps=4.58 mult=1 m=1
XMPH_op1_0900_rl_s1_r0 vp_op1_0900_rl_s1_r0 enb_op1_0900_rl_s1_r0 vdd vdd sky130_fd_pr__pfet_01v8 L=0.15 W=4 nf=1 ad=1.16 as=1.16 pd=8.58 ps=8.58 mult=1 m=1
bd_op1_0900_rl_s1_r0 d_op1_0900_rl_s1_r0 0 v=v(rbl_op1_0900_rl_s1_r0)-v(ref_op1_0900_rl_s1_r0)

* ---- instance 166: op1_1000_rl_s1_r0 (variant rl_s1_r0; probe dec 11.9 ns, release 34 ns, meas 36 ns) ----
vctl_op1_1000_rl_s1_r0 ctl_op1_1000_rl_s1_r0 0 pwl(0.0000e+00 {VDD} 2.0000e-09 {VDD} 2.1000e-09 0)
* RWL driver model (EXPERIMENTAL): slew 1 ns, series R 0 ohm; cell pin = rwls_op1_1000_rl_s1_r0
vrs_op1_1000_rl_s1_r0 rwls_op1_1000_rl_s1_r0 0 pwl(0.0000e+00 {VDD} 2.0000e-09 {VDD} 3.0000e-09 0 3.4000e-08 0 3.5000e-08 {VDD})
ven_op1_1000_rl_s1_r0 en_op1_1000_rl_s1_r0 0 pwl(0.0000e+00 0 1.1000e-08 0 1.1100e-08 {VDD} 3.4000e-08 {VDD} 3.4100e-08 0)
venb_op1_1000_rl_s1_r0 enb_op1_1000_rl_s1_r0 0 pwl(0.0000e+00 {VDD} 1.1000e-08 {VDD} 1.1100e-08 0 3.4000e-08 0 3.4100e-08 {VDD})
vww_op1_1000_rl_s1_r0 wwl_op1_1000_rl_s1_r0 0 pwl(0.0000e+00 0 1.2000e-08 0 1.2100e-08 {VDD} 3.2000e-08 {VDD} 3.2100e-08 0)
vwc_op1_1000_rl_s1_r0 wbc_op1_1000_rl_s1_r0 0 pwl(0.0000e+00 0 1.2000e-08 0 1.2100e-08 {VDD} 3.4000e-08 {VDD} 3.4100e-08 0)
swb_op1_1000_rl_s1_r0 ref_op1_1000_rl_s1_r0 wbl_op1_1000_rl_s1_r0 wbc_op1_1000_rl_s1_r0 0 swwbl
cwbl_op1_1000_rl_s1_r0 wbl_op1_1000_rl_s1_r0 0 {C_WBL}
spa_op1_1000_rl_s1_r0 prea rbl_op1_1000_rl_s1_r0 ctl_op1_1000_rl_s1_r0 0 swpre
spr_op1_1000_rl_s1_r0 pref ref_op1_1000_rl_s1_r0 ctl_op1_1000_rl_s1_r0 0 swpre
crbl_op1_1000_rl_s1_r0 rbl_op1_1000_rl_s1_r0 0 {C_RBL}
cref_op1_1000_rl_s1_r0 ref_op1_1000_rl_s1_r0 0 {C_RBL}   $ ASSUMPTION: ideal matched dummy load
XMWR_op1_1000_rl_s1_r0_0 sn_op1_1000_rl_s1_r0_0 wwl_op1_1000_rl_s1_r0 wbl_op1_1000_rl_s1_r0 0 sky130_fd_pr__nfet_01v8 L=0.15 W=0.42 nf=1 ad=0.1218 as=0.1218 pd=1.42 ps=1.42 nrd=0.69047619047619  nrs=0.69047619047619 sa=0 sb=0 sd=0 mult=1 m=1
XMRD_op1_1000_rl_s1_r0_0 rbl_op1_1000_rl_s1_r0 sn_op1_1000_rl_s1_r0_0 rwls_op1_1000_rl_s1_r0 0 sky130_fd_pr__nfet_01v8 L=0.15 W=0.42 nf=1 ad=0.1218 as=0.1218 pd=1.42 ps=1.42 nrd=0.69047619047619  nrs=0.69047619047619 sa=0 sb=0 sd=0 mult=1 m=1
csn_op1_1000_rl_s1_r0_0 sn_op1_1000_rl_s1_r0_0 0 {C_SN}
XMWR_op1_1000_rl_s1_r0_1 sn_op1_1000_rl_s1_r0_1 wwl_des wbl_op1_1000_rl_s1_r0 0 sky130_fd_pr__nfet_01v8 L=0.15 W=0.42 nf=1 ad=0.1218 as=0.1218 pd=1.42 ps=1.42 nrd=0.69047619047619  nrs=0.69047619047619 sa=0 sb=0 sd=0 mult=1 m=1
XMRD_op1_1000_rl_s1_r0_1 rbl_op1_1000_rl_s1_r0 sn_op1_1000_rl_s1_r0_1 rwl_des 0 sky130_fd_pr__nfet_01v8 L=0.15 W=0.42 nf=1 ad=0.1218 as=0.1218 pd=1.42 ps=1.42 nrd=0.69047619047619  nrs=0.69047619047619 sa=0 sb=0 sd=0 mult=1 m=1
csn_op1_1000_rl_s1_r0_1 sn_op1_1000_rl_s1_r0_1 0 {C_SN}
XMWR_op1_1000_rl_s1_r0_2 sn_op1_1000_rl_s1_r0_2 wwl_des wbl_op1_1000_rl_s1_r0 0 sky130_fd_pr__nfet_01v8 L=0.15 W=0.42 nf=1 ad=0.1218 as=0.1218 pd=1.42 ps=1.42 nrd=0.69047619047619  nrs=0.69047619047619 sa=0 sb=0 sd=0 mult=1 m=1
XMRD_op1_1000_rl_s1_r0_2 rbl_op1_1000_rl_s1_r0 sn_op1_1000_rl_s1_r0_2 rwl_des 0 sky130_fd_pr__nfet_01v8 L=0.15 W=0.42 nf=1 ad=0.1218 as=0.1218 pd=1.42 ps=1.42 nrd=0.69047619047619  nrs=0.69047619047619 sa=0 sb=0 sd=0 mult=1 m=1
csn_op1_1000_rl_s1_r0_2 sn_op1_1000_rl_s1_r0_2 0 {C_SN}
XMWR_op1_1000_rl_s1_r0_3 sn_op1_1000_rl_s1_r0_3 wwl_des wbl_op1_1000_rl_s1_r0 0 sky130_fd_pr__nfet_01v8 L=0.15 W=0.42 nf=1 ad=0.1218 as=0.1218 pd=1.42 ps=1.42 nrd=0.69047619047619  nrs=0.69047619047619 sa=0 sb=0 sd=0 mult=1 m=1
XMRD_op1_1000_rl_s1_r0_3 rbl_op1_1000_rl_s1_r0 sn_op1_1000_rl_s1_r0_3 rwl_des 0 sky130_fd_pr__nfet_01v8 L=0.15 W=0.42 nf=1 ad=0.1218 as=0.1218 pd=1.42 ps=1.42 nrd=0.69047619047619  nrs=0.69047619047619 sa=0 sb=0 sd=0 mult=1 m=1
csn_op1_1000_rl_s1_r0_3 sn_op1_1000_rl_s1_r0_3 0 {C_SN}
XMN1_op1_1000_rl_s1_r0 rbl_op1_1000_rl_s1_r0 ref_op1_1000_rl_s1_r0 vn_op1_1000_rl_s1_r0 0 sky130_fd_pr__nfet_01v8 L=0.15 W=1 nf=1 ad=0.29 as=0.29 pd=2.58 ps=2.58 mult=1 m=1
XMN2_op1_1000_rl_s1_r0 ref_op1_1000_rl_s1_r0 rbl_op1_1000_rl_s1_r0 vn_op1_1000_rl_s1_r0 0 sky130_fd_pr__nfet_01v8 L=0.15 W=1 nf=1 ad=0.29 as=0.29 pd=2.58 ps=2.58 mult=1 m=1
XMP1_op1_1000_rl_s1_r0 rbl_op1_1000_rl_s1_r0 ref_op1_1000_rl_s1_r0 vp_op1_1000_rl_s1_r0 vdd sky130_fd_pr__pfet_01v8 L=0.15 W=2 nf=1 ad=0.58 as=0.58 pd=4.58 ps=4.58 mult=1 m=1
XMP2_op1_1000_rl_s1_r0 ref_op1_1000_rl_s1_r0 rbl_op1_1000_rl_s1_r0 vp_op1_1000_rl_s1_r0 vdd sky130_fd_pr__pfet_01v8 L=0.15 W=2 nf=1 ad=0.58 as=0.58 pd=4.58 ps=4.58 mult=1 m=1
XMNF_op1_1000_rl_s1_r0 vn_op1_1000_rl_s1_r0 en_op1_1000_rl_s1_r0 0 0 sky130_fd_pr__nfet_01v8 L=0.15 W=2 nf=1 ad=0.58 as=0.58 pd=4.58 ps=4.58 mult=1 m=1
XMPH_op1_1000_rl_s1_r0 vp_op1_1000_rl_s1_r0 enb_op1_1000_rl_s1_r0 vdd vdd sky130_fd_pr__pfet_01v8 L=0.15 W=4 nf=1 ad=1.16 as=1.16 pd=8.58 ps=8.58 mult=1 m=1
bd_op1_1000_rl_s1_r0 d_op1_1000_rl_s1_r0 0 v=v(rbl_op1_1000_rl_s1_r0)-v(ref_op1_1000_rl_s1_r0)

* ---- instance 167: op0_n100_rl_s1_r0 (variant rl_s1_r0; probe dec 11.9 ns, release 34 ns, meas 36 ns) ----
vctl_op0_n100_rl_s1_r0 ctl_op0_n100_rl_s1_r0 0 pwl(0.0000e+00 {VDD} 2.0000e-09 {VDD} 2.1000e-09 0)
* RWL driver model (EXPERIMENTAL): slew 1 ns, series R 0 ohm; cell pin = rwls_op0_n100_rl_s1_r0
vrs_op0_n100_rl_s1_r0 rwls_op0_n100_rl_s1_r0 0 pwl(0.0000e+00 {VDD} 2.0000e-09 {VDD} 3.0000e-09 0 3.4000e-08 0 3.5000e-08 {VDD})
ven_op0_n100_rl_s1_r0 en_op0_n100_rl_s1_r0 0 pwl(0.0000e+00 0 1.1000e-08 0 1.1100e-08 {VDD} 3.4000e-08 {VDD} 3.4100e-08 0)
venb_op0_n100_rl_s1_r0 enb_op0_n100_rl_s1_r0 0 pwl(0.0000e+00 {VDD} 1.1000e-08 {VDD} 1.1100e-08 0 3.4000e-08 0 3.4100e-08 {VDD})
vww_op0_n100_rl_s1_r0 wwl_op0_n100_rl_s1_r0 0 pwl(0.0000e+00 0 1.2000e-08 0 1.2100e-08 {VDD} 3.2000e-08 {VDD} 3.2100e-08 0)
vwc_op0_n100_rl_s1_r0 wbc_op0_n100_rl_s1_r0 0 pwl(0.0000e+00 0 1.2000e-08 0 1.2100e-08 {VDD} 3.4000e-08 {VDD} 3.4100e-08 0)
swb_op0_n100_rl_s1_r0 ref_op0_n100_rl_s1_r0 wbl_op0_n100_rl_s1_r0 wbc_op0_n100_rl_s1_r0 0 swwbl
cwbl_op0_n100_rl_s1_r0 wbl_op0_n100_rl_s1_r0 0 {C_WBL}
spa_op0_n100_rl_s1_r0 prea rbl_op0_n100_rl_s1_r0 ctl_op0_n100_rl_s1_r0 0 swpre
spr_op0_n100_rl_s1_r0 pref ref_op0_n100_rl_s1_r0 ctl_op0_n100_rl_s1_r0 0 swpre
crbl_op0_n100_rl_s1_r0 rbl_op0_n100_rl_s1_r0 0 {C_RBL}
cref_op0_n100_rl_s1_r0 ref_op0_n100_rl_s1_r0 0 {C_RBL}   $ ASSUMPTION: ideal matched dummy load
XMWR_op0_n100_rl_s1_r0_0 sn_op0_n100_rl_s1_r0_0 wwl_op0_n100_rl_s1_r0 wbl_op0_n100_rl_s1_r0 0 sky130_fd_pr__nfet_01v8 L=0.15 W=0.42 nf=1 ad=0.1218 as=0.1218 pd=1.42 ps=1.42 nrd=0.69047619047619  nrs=0.69047619047619 sa=0 sb=0 sd=0 mult=1 m=1
XMRD_op0_n100_rl_s1_r0_0 rbl_op0_n100_rl_s1_r0 sn_op0_n100_rl_s1_r0_0 rwls_op0_n100_rl_s1_r0 0 sky130_fd_pr__nfet_01v8 L=0.15 W=0.42 nf=1 ad=0.1218 as=0.1218 pd=1.42 ps=1.42 nrd=0.69047619047619  nrs=0.69047619047619 sa=0 sb=0 sd=0 mult=1 m=1
csn_op0_n100_rl_s1_r0_0 sn_op0_n100_rl_s1_r0_0 0 {C_SN}
XMWR_op0_n100_rl_s1_r0_1 sn_op0_n100_rl_s1_r0_1 wwl_des wbl_op0_n100_rl_s1_r0 0 sky130_fd_pr__nfet_01v8 L=0.15 W=0.42 nf=1 ad=0.1218 as=0.1218 pd=1.42 ps=1.42 nrd=0.69047619047619  nrs=0.69047619047619 sa=0 sb=0 sd=0 mult=1 m=1
XMRD_op0_n100_rl_s1_r0_1 rbl_op0_n100_rl_s1_r0 sn_op0_n100_rl_s1_r0_1 rwl_des 0 sky130_fd_pr__nfet_01v8 L=0.15 W=0.42 nf=1 ad=0.1218 as=0.1218 pd=1.42 ps=1.42 nrd=0.69047619047619  nrs=0.69047619047619 sa=0 sb=0 sd=0 mult=1 m=1
csn_op0_n100_rl_s1_r0_1 sn_op0_n100_rl_s1_r0_1 0 {C_SN}
XMWR_op0_n100_rl_s1_r0_2 sn_op0_n100_rl_s1_r0_2 wwl_des wbl_op0_n100_rl_s1_r0 0 sky130_fd_pr__nfet_01v8 L=0.15 W=0.42 nf=1 ad=0.1218 as=0.1218 pd=1.42 ps=1.42 nrd=0.69047619047619  nrs=0.69047619047619 sa=0 sb=0 sd=0 mult=1 m=1
XMRD_op0_n100_rl_s1_r0_2 rbl_op0_n100_rl_s1_r0 sn_op0_n100_rl_s1_r0_2 rwl_des 0 sky130_fd_pr__nfet_01v8 L=0.15 W=0.42 nf=1 ad=0.1218 as=0.1218 pd=1.42 ps=1.42 nrd=0.69047619047619  nrs=0.69047619047619 sa=0 sb=0 sd=0 mult=1 m=1
csn_op0_n100_rl_s1_r0_2 sn_op0_n100_rl_s1_r0_2 0 {C_SN}
XMWR_op0_n100_rl_s1_r0_3 sn_op0_n100_rl_s1_r0_3 wwl_des wbl_op0_n100_rl_s1_r0 0 sky130_fd_pr__nfet_01v8 L=0.15 W=0.42 nf=1 ad=0.1218 as=0.1218 pd=1.42 ps=1.42 nrd=0.69047619047619  nrs=0.69047619047619 sa=0 sb=0 sd=0 mult=1 m=1
XMRD_op0_n100_rl_s1_r0_3 rbl_op0_n100_rl_s1_r0 sn_op0_n100_rl_s1_r0_3 rwl_des 0 sky130_fd_pr__nfet_01v8 L=0.15 W=0.42 nf=1 ad=0.1218 as=0.1218 pd=1.42 ps=1.42 nrd=0.69047619047619  nrs=0.69047619047619 sa=0 sb=0 sd=0 mult=1 m=1
csn_op0_n100_rl_s1_r0_3 sn_op0_n100_rl_s1_r0_3 0 {C_SN}
XMN1_op0_n100_rl_s1_r0 rbl_op0_n100_rl_s1_r0 ref_op0_n100_rl_s1_r0 vn_op0_n100_rl_s1_r0 0 sky130_fd_pr__nfet_01v8 L=0.15 W=1 nf=1 ad=0.29 as=0.29 pd=2.58 ps=2.58 mult=1 m=1
XMN2_op0_n100_rl_s1_r0 ref_op0_n100_rl_s1_r0 rbl_op0_n100_rl_s1_r0 vn_op0_n100_rl_s1_r0 0 sky130_fd_pr__nfet_01v8 L=0.15 W=1 nf=1 ad=0.29 as=0.29 pd=2.58 ps=2.58 mult=1 m=1
XMP1_op0_n100_rl_s1_r0 rbl_op0_n100_rl_s1_r0 ref_op0_n100_rl_s1_r0 vp_op0_n100_rl_s1_r0 vdd sky130_fd_pr__pfet_01v8 L=0.15 W=2 nf=1 ad=0.58 as=0.58 pd=4.58 ps=4.58 mult=1 m=1
XMP2_op0_n100_rl_s1_r0 ref_op0_n100_rl_s1_r0 rbl_op0_n100_rl_s1_r0 vp_op0_n100_rl_s1_r0 vdd sky130_fd_pr__pfet_01v8 L=0.15 W=2 nf=1 ad=0.58 as=0.58 pd=4.58 ps=4.58 mult=1 m=1
XMNF_op0_n100_rl_s1_r0 vn_op0_n100_rl_s1_r0 en_op0_n100_rl_s1_r0 0 0 sky130_fd_pr__nfet_01v8 L=0.15 W=2 nf=1 ad=0.58 as=0.58 pd=4.58 ps=4.58 mult=1 m=1
XMPH_op0_n100_rl_s1_r0 vp_op0_n100_rl_s1_r0 enb_op0_n100_rl_s1_r0 vdd vdd sky130_fd_pr__pfet_01v8 L=0.15 W=4 nf=1 ad=1.16 as=1.16 pd=8.58 ps=8.58 mult=1 m=1
bd_op0_n100_rl_s1_r0 d_op0_n100_rl_s1_r0 0 v=v(rbl_op0_n100_rl_s1_r0)-v(ref_op0_n100_rl_s1_r0)

* ---- instance 168: op0_0000_rl_s1_r0 (variant rl_s1_r0; probe dec 11.9 ns, release 34 ns, meas 36 ns) ----
vctl_op0_0000_rl_s1_r0 ctl_op0_0000_rl_s1_r0 0 pwl(0.0000e+00 {VDD} 2.0000e-09 {VDD} 2.1000e-09 0)
* RWL driver model (EXPERIMENTAL): slew 1 ns, series R 0 ohm; cell pin = rwls_op0_0000_rl_s1_r0
vrs_op0_0000_rl_s1_r0 rwls_op0_0000_rl_s1_r0 0 pwl(0.0000e+00 {VDD} 2.0000e-09 {VDD} 3.0000e-09 0 3.4000e-08 0 3.5000e-08 {VDD})
ven_op0_0000_rl_s1_r0 en_op0_0000_rl_s1_r0 0 pwl(0.0000e+00 0 1.1000e-08 0 1.1100e-08 {VDD} 3.4000e-08 {VDD} 3.4100e-08 0)
venb_op0_0000_rl_s1_r0 enb_op0_0000_rl_s1_r0 0 pwl(0.0000e+00 {VDD} 1.1000e-08 {VDD} 1.1100e-08 0 3.4000e-08 0 3.4100e-08 {VDD})
vww_op0_0000_rl_s1_r0 wwl_op0_0000_rl_s1_r0 0 pwl(0.0000e+00 0 1.2000e-08 0 1.2100e-08 {VDD} 3.2000e-08 {VDD} 3.2100e-08 0)
vwc_op0_0000_rl_s1_r0 wbc_op0_0000_rl_s1_r0 0 pwl(0.0000e+00 0 1.2000e-08 0 1.2100e-08 {VDD} 3.4000e-08 {VDD} 3.4100e-08 0)
swb_op0_0000_rl_s1_r0 ref_op0_0000_rl_s1_r0 wbl_op0_0000_rl_s1_r0 wbc_op0_0000_rl_s1_r0 0 swwbl
cwbl_op0_0000_rl_s1_r0 wbl_op0_0000_rl_s1_r0 0 {C_WBL}
spa_op0_0000_rl_s1_r0 prea rbl_op0_0000_rl_s1_r0 ctl_op0_0000_rl_s1_r0 0 swpre
spr_op0_0000_rl_s1_r0 pref ref_op0_0000_rl_s1_r0 ctl_op0_0000_rl_s1_r0 0 swpre
crbl_op0_0000_rl_s1_r0 rbl_op0_0000_rl_s1_r0 0 {C_RBL}
cref_op0_0000_rl_s1_r0 ref_op0_0000_rl_s1_r0 0 {C_RBL}   $ ASSUMPTION: ideal matched dummy load
XMWR_op0_0000_rl_s1_r0_0 sn_op0_0000_rl_s1_r0_0 wwl_op0_0000_rl_s1_r0 wbl_op0_0000_rl_s1_r0 0 sky130_fd_pr__nfet_01v8 L=0.15 W=0.42 nf=1 ad=0.1218 as=0.1218 pd=1.42 ps=1.42 nrd=0.69047619047619  nrs=0.69047619047619 sa=0 sb=0 sd=0 mult=1 m=1
XMRD_op0_0000_rl_s1_r0_0 rbl_op0_0000_rl_s1_r0 sn_op0_0000_rl_s1_r0_0 rwls_op0_0000_rl_s1_r0 0 sky130_fd_pr__nfet_01v8 L=0.15 W=0.42 nf=1 ad=0.1218 as=0.1218 pd=1.42 ps=1.42 nrd=0.69047619047619  nrs=0.69047619047619 sa=0 sb=0 sd=0 mult=1 m=1
csn_op0_0000_rl_s1_r0_0 sn_op0_0000_rl_s1_r0_0 0 {C_SN}
XMWR_op0_0000_rl_s1_r0_1 sn_op0_0000_rl_s1_r0_1 wwl_des wbl_op0_0000_rl_s1_r0 0 sky130_fd_pr__nfet_01v8 L=0.15 W=0.42 nf=1 ad=0.1218 as=0.1218 pd=1.42 ps=1.42 nrd=0.69047619047619  nrs=0.69047619047619 sa=0 sb=0 sd=0 mult=1 m=1
XMRD_op0_0000_rl_s1_r0_1 rbl_op0_0000_rl_s1_r0 sn_op0_0000_rl_s1_r0_1 rwl_des 0 sky130_fd_pr__nfet_01v8 L=0.15 W=0.42 nf=1 ad=0.1218 as=0.1218 pd=1.42 ps=1.42 nrd=0.69047619047619  nrs=0.69047619047619 sa=0 sb=0 sd=0 mult=1 m=1
csn_op0_0000_rl_s1_r0_1 sn_op0_0000_rl_s1_r0_1 0 {C_SN}
XMWR_op0_0000_rl_s1_r0_2 sn_op0_0000_rl_s1_r0_2 wwl_des wbl_op0_0000_rl_s1_r0 0 sky130_fd_pr__nfet_01v8 L=0.15 W=0.42 nf=1 ad=0.1218 as=0.1218 pd=1.42 ps=1.42 nrd=0.69047619047619  nrs=0.69047619047619 sa=0 sb=0 sd=0 mult=1 m=1
XMRD_op0_0000_rl_s1_r0_2 rbl_op0_0000_rl_s1_r0 sn_op0_0000_rl_s1_r0_2 rwl_des 0 sky130_fd_pr__nfet_01v8 L=0.15 W=0.42 nf=1 ad=0.1218 as=0.1218 pd=1.42 ps=1.42 nrd=0.69047619047619  nrs=0.69047619047619 sa=0 sb=0 sd=0 mult=1 m=1
csn_op0_0000_rl_s1_r0_2 sn_op0_0000_rl_s1_r0_2 0 {C_SN}
XMWR_op0_0000_rl_s1_r0_3 sn_op0_0000_rl_s1_r0_3 wwl_des wbl_op0_0000_rl_s1_r0 0 sky130_fd_pr__nfet_01v8 L=0.15 W=0.42 nf=1 ad=0.1218 as=0.1218 pd=1.42 ps=1.42 nrd=0.69047619047619  nrs=0.69047619047619 sa=0 sb=0 sd=0 mult=1 m=1
XMRD_op0_0000_rl_s1_r0_3 rbl_op0_0000_rl_s1_r0 sn_op0_0000_rl_s1_r0_3 rwl_des 0 sky130_fd_pr__nfet_01v8 L=0.15 W=0.42 nf=1 ad=0.1218 as=0.1218 pd=1.42 ps=1.42 nrd=0.69047619047619  nrs=0.69047619047619 sa=0 sb=0 sd=0 mult=1 m=1
csn_op0_0000_rl_s1_r0_3 sn_op0_0000_rl_s1_r0_3 0 {C_SN}
XMN1_op0_0000_rl_s1_r0 rbl_op0_0000_rl_s1_r0 ref_op0_0000_rl_s1_r0 vn_op0_0000_rl_s1_r0 0 sky130_fd_pr__nfet_01v8 L=0.15 W=1 nf=1 ad=0.29 as=0.29 pd=2.58 ps=2.58 mult=1 m=1
XMN2_op0_0000_rl_s1_r0 ref_op0_0000_rl_s1_r0 rbl_op0_0000_rl_s1_r0 vn_op0_0000_rl_s1_r0 0 sky130_fd_pr__nfet_01v8 L=0.15 W=1 nf=1 ad=0.29 as=0.29 pd=2.58 ps=2.58 mult=1 m=1
XMP1_op0_0000_rl_s1_r0 rbl_op0_0000_rl_s1_r0 ref_op0_0000_rl_s1_r0 vp_op0_0000_rl_s1_r0 vdd sky130_fd_pr__pfet_01v8 L=0.15 W=2 nf=1 ad=0.58 as=0.58 pd=4.58 ps=4.58 mult=1 m=1
XMP2_op0_0000_rl_s1_r0 ref_op0_0000_rl_s1_r0 rbl_op0_0000_rl_s1_r0 vp_op0_0000_rl_s1_r0 vdd sky130_fd_pr__pfet_01v8 L=0.15 W=2 nf=1 ad=0.58 as=0.58 pd=4.58 ps=4.58 mult=1 m=1
XMNF_op0_0000_rl_s1_r0 vn_op0_0000_rl_s1_r0 en_op0_0000_rl_s1_r0 0 0 sky130_fd_pr__nfet_01v8 L=0.15 W=2 nf=1 ad=0.58 as=0.58 pd=4.58 ps=4.58 mult=1 m=1
XMPH_op0_0000_rl_s1_r0 vp_op0_0000_rl_s1_r0 enb_op0_0000_rl_s1_r0 vdd vdd sky130_fd_pr__pfet_01v8 L=0.15 W=4 nf=1 ad=1.16 as=1.16 pd=8.58 ps=8.58 mult=1 m=1
bd_op0_0000_rl_s1_r0 d_op0_0000_rl_s1_r0 0 v=v(rbl_op0_0000_rl_s1_r0)-v(ref_op0_0000_rl_s1_r0)

* ---- instance 169: op1_0900_rl_s2_r0 (variant rl_s2_r0; probe dec 11.9 ns, release 34 ns, meas 36 ns) ----
vctl_op1_0900_rl_s2_r0 ctl_op1_0900_rl_s2_r0 0 pwl(0.0000e+00 {VDD} 2.0000e-09 {VDD} 2.1000e-09 0)
* RWL driver model (EXPERIMENTAL): slew 2 ns, series R 0 ohm; cell pin = rwls_op1_0900_rl_s2_r0
vrs_op1_0900_rl_s2_r0 rwls_op1_0900_rl_s2_r0 0 pwl(0.0000e+00 {VDD} 2.0000e-09 {VDD} 4.0000e-09 0 3.4000e-08 0 3.6000e-08 {VDD})
ven_op1_0900_rl_s2_r0 en_op1_0900_rl_s2_r0 0 pwl(0.0000e+00 0 1.1000e-08 0 1.1100e-08 {VDD} 3.4000e-08 {VDD} 3.4100e-08 0)
venb_op1_0900_rl_s2_r0 enb_op1_0900_rl_s2_r0 0 pwl(0.0000e+00 {VDD} 1.1000e-08 {VDD} 1.1100e-08 0 3.4000e-08 0 3.4100e-08 {VDD})
vww_op1_0900_rl_s2_r0 wwl_op1_0900_rl_s2_r0 0 pwl(0.0000e+00 0 1.2000e-08 0 1.2100e-08 {VDD} 3.2000e-08 {VDD} 3.2100e-08 0)
vwc_op1_0900_rl_s2_r0 wbc_op1_0900_rl_s2_r0 0 pwl(0.0000e+00 0 1.2000e-08 0 1.2100e-08 {VDD} 3.4000e-08 {VDD} 3.4100e-08 0)
swb_op1_0900_rl_s2_r0 ref_op1_0900_rl_s2_r0 wbl_op1_0900_rl_s2_r0 wbc_op1_0900_rl_s2_r0 0 swwbl
cwbl_op1_0900_rl_s2_r0 wbl_op1_0900_rl_s2_r0 0 {C_WBL}
spa_op1_0900_rl_s2_r0 prea rbl_op1_0900_rl_s2_r0 ctl_op1_0900_rl_s2_r0 0 swpre
spr_op1_0900_rl_s2_r0 pref ref_op1_0900_rl_s2_r0 ctl_op1_0900_rl_s2_r0 0 swpre
crbl_op1_0900_rl_s2_r0 rbl_op1_0900_rl_s2_r0 0 {C_RBL}
cref_op1_0900_rl_s2_r0 ref_op1_0900_rl_s2_r0 0 {C_RBL}   $ ASSUMPTION: ideal matched dummy load
XMWR_op1_0900_rl_s2_r0_0 sn_op1_0900_rl_s2_r0_0 wwl_op1_0900_rl_s2_r0 wbl_op1_0900_rl_s2_r0 0 sky130_fd_pr__nfet_01v8 L=0.15 W=0.42 nf=1 ad=0.1218 as=0.1218 pd=1.42 ps=1.42 nrd=0.69047619047619  nrs=0.69047619047619 sa=0 sb=0 sd=0 mult=1 m=1
XMRD_op1_0900_rl_s2_r0_0 rbl_op1_0900_rl_s2_r0 sn_op1_0900_rl_s2_r0_0 rwls_op1_0900_rl_s2_r0 0 sky130_fd_pr__nfet_01v8 L=0.15 W=0.42 nf=1 ad=0.1218 as=0.1218 pd=1.42 ps=1.42 nrd=0.69047619047619  nrs=0.69047619047619 sa=0 sb=0 sd=0 mult=1 m=1
csn_op1_0900_rl_s2_r0_0 sn_op1_0900_rl_s2_r0_0 0 {C_SN}
XMWR_op1_0900_rl_s2_r0_1 sn_op1_0900_rl_s2_r0_1 wwl_des wbl_op1_0900_rl_s2_r0 0 sky130_fd_pr__nfet_01v8 L=0.15 W=0.42 nf=1 ad=0.1218 as=0.1218 pd=1.42 ps=1.42 nrd=0.69047619047619  nrs=0.69047619047619 sa=0 sb=0 sd=0 mult=1 m=1
XMRD_op1_0900_rl_s2_r0_1 rbl_op1_0900_rl_s2_r0 sn_op1_0900_rl_s2_r0_1 rwl_des 0 sky130_fd_pr__nfet_01v8 L=0.15 W=0.42 nf=1 ad=0.1218 as=0.1218 pd=1.42 ps=1.42 nrd=0.69047619047619  nrs=0.69047619047619 sa=0 sb=0 sd=0 mult=1 m=1
csn_op1_0900_rl_s2_r0_1 sn_op1_0900_rl_s2_r0_1 0 {C_SN}
XMWR_op1_0900_rl_s2_r0_2 sn_op1_0900_rl_s2_r0_2 wwl_des wbl_op1_0900_rl_s2_r0 0 sky130_fd_pr__nfet_01v8 L=0.15 W=0.42 nf=1 ad=0.1218 as=0.1218 pd=1.42 ps=1.42 nrd=0.69047619047619  nrs=0.69047619047619 sa=0 sb=0 sd=0 mult=1 m=1
XMRD_op1_0900_rl_s2_r0_2 rbl_op1_0900_rl_s2_r0 sn_op1_0900_rl_s2_r0_2 rwl_des 0 sky130_fd_pr__nfet_01v8 L=0.15 W=0.42 nf=1 ad=0.1218 as=0.1218 pd=1.42 ps=1.42 nrd=0.69047619047619  nrs=0.69047619047619 sa=0 sb=0 sd=0 mult=1 m=1
csn_op1_0900_rl_s2_r0_2 sn_op1_0900_rl_s2_r0_2 0 {C_SN}
XMWR_op1_0900_rl_s2_r0_3 sn_op1_0900_rl_s2_r0_3 wwl_des wbl_op1_0900_rl_s2_r0 0 sky130_fd_pr__nfet_01v8 L=0.15 W=0.42 nf=1 ad=0.1218 as=0.1218 pd=1.42 ps=1.42 nrd=0.69047619047619  nrs=0.69047619047619 sa=0 sb=0 sd=0 mult=1 m=1
XMRD_op1_0900_rl_s2_r0_3 rbl_op1_0900_rl_s2_r0 sn_op1_0900_rl_s2_r0_3 rwl_des 0 sky130_fd_pr__nfet_01v8 L=0.15 W=0.42 nf=1 ad=0.1218 as=0.1218 pd=1.42 ps=1.42 nrd=0.69047619047619  nrs=0.69047619047619 sa=0 sb=0 sd=0 mult=1 m=1
csn_op1_0900_rl_s2_r0_3 sn_op1_0900_rl_s2_r0_3 0 {C_SN}
XMN1_op1_0900_rl_s2_r0 rbl_op1_0900_rl_s2_r0 ref_op1_0900_rl_s2_r0 vn_op1_0900_rl_s2_r0 0 sky130_fd_pr__nfet_01v8 L=0.15 W=1 nf=1 ad=0.29 as=0.29 pd=2.58 ps=2.58 mult=1 m=1
XMN2_op1_0900_rl_s2_r0 ref_op1_0900_rl_s2_r0 rbl_op1_0900_rl_s2_r0 vn_op1_0900_rl_s2_r0 0 sky130_fd_pr__nfet_01v8 L=0.15 W=1 nf=1 ad=0.29 as=0.29 pd=2.58 ps=2.58 mult=1 m=1
XMP1_op1_0900_rl_s2_r0 rbl_op1_0900_rl_s2_r0 ref_op1_0900_rl_s2_r0 vp_op1_0900_rl_s2_r0 vdd sky130_fd_pr__pfet_01v8 L=0.15 W=2 nf=1 ad=0.58 as=0.58 pd=4.58 ps=4.58 mult=1 m=1
XMP2_op1_0900_rl_s2_r0 ref_op1_0900_rl_s2_r0 rbl_op1_0900_rl_s2_r0 vp_op1_0900_rl_s2_r0 vdd sky130_fd_pr__pfet_01v8 L=0.15 W=2 nf=1 ad=0.58 as=0.58 pd=4.58 ps=4.58 mult=1 m=1
XMNF_op1_0900_rl_s2_r0 vn_op1_0900_rl_s2_r0 en_op1_0900_rl_s2_r0 0 0 sky130_fd_pr__nfet_01v8 L=0.15 W=2 nf=1 ad=0.58 as=0.58 pd=4.58 ps=4.58 mult=1 m=1
XMPH_op1_0900_rl_s2_r0 vp_op1_0900_rl_s2_r0 enb_op1_0900_rl_s2_r0 vdd vdd sky130_fd_pr__pfet_01v8 L=0.15 W=4 nf=1 ad=1.16 as=1.16 pd=8.58 ps=8.58 mult=1 m=1
bd_op1_0900_rl_s2_r0 d_op1_0900_rl_s2_r0 0 v=v(rbl_op1_0900_rl_s2_r0)-v(ref_op1_0900_rl_s2_r0)

* ---- instance 170: op1_1000_rl_s2_r0 (variant rl_s2_r0; probe dec 11.9 ns, release 34 ns, meas 36 ns) ----
vctl_op1_1000_rl_s2_r0 ctl_op1_1000_rl_s2_r0 0 pwl(0.0000e+00 {VDD} 2.0000e-09 {VDD} 2.1000e-09 0)
* RWL driver model (EXPERIMENTAL): slew 2 ns, series R 0 ohm; cell pin = rwls_op1_1000_rl_s2_r0
vrs_op1_1000_rl_s2_r0 rwls_op1_1000_rl_s2_r0 0 pwl(0.0000e+00 {VDD} 2.0000e-09 {VDD} 4.0000e-09 0 3.4000e-08 0 3.6000e-08 {VDD})
ven_op1_1000_rl_s2_r0 en_op1_1000_rl_s2_r0 0 pwl(0.0000e+00 0 1.1000e-08 0 1.1100e-08 {VDD} 3.4000e-08 {VDD} 3.4100e-08 0)
venb_op1_1000_rl_s2_r0 enb_op1_1000_rl_s2_r0 0 pwl(0.0000e+00 {VDD} 1.1000e-08 {VDD} 1.1100e-08 0 3.4000e-08 0 3.4100e-08 {VDD})
vww_op1_1000_rl_s2_r0 wwl_op1_1000_rl_s2_r0 0 pwl(0.0000e+00 0 1.2000e-08 0 1.2100e-08 {VDD} 3.2000e-08 {VDD} 3.2100e-08 0)
vwc_op1_1000_rl_s2_r0 wbc_op1_1000_rl_s2_r0 0 pwl(0.0000e+00 0 1.2000e-08 0 1.2100e-08 {VDD} 3.4000e-08 {VDD} 3.4100e-08 0)
swb_op1_1000_rl_s2_r0 ref_op1_1000_rl_s2_r0 wbl_op1_1000_rl_s2_r0 wbc_op1_1000_rl_s2_r0 0 swwbl
cwbl_op1_1000_rl_s2_r0 wbl_op1_1000_rl_s2_r0 0 {C_WBL}
spa_op1_1000_rl_s2_r0 prea rbl_op1_1000_rl_s2_r0 ctl_op1_1000_rl_s2_r0 0 swpre
spr_op1_1000_rl_s2_r0 pref ref_op1_1000_rl_s2_r0 ctl_op1_1000_rl_s2_r0 0 swpre
crbl_op1_1000_rl_s2_r0 rbl_op1_1000_rl_s2_r0 0 {C_RBL}
cref_op1_1000_rl_s2_r0 ref_op1_1000_rl_s2_r0 0 {C_RBL}   $ ASSUMPTION: ideal matched dummy load
XMWR_op1_1000_rl_s2_r0_0 sn_op1_1000_rl_s2_r0_0 wwl_op1_1000_rl_s2_r0 wbl_op1_1000_rl_s2_r0 0 sky130_fd_pr__nfet_01v8 L=0.15 W=0.42 nf=1 ad=0.1218 as=0.1218 pd=1.42 ps=1.42 nrd=0.69047619047619  nrs=0.69047619047619 sa=0 sb=0 sd=0 mult=1 m=1
XMRD_op1_1000_rl_s2_r0_0 rbl_op1_1000_rl_s2_r0 sn_op1_1000_rl_s2_r0_0 rwls_op1_1000_rl_s2_r0 0 sky130_fd_pr__nfet_01v8 L=0.15 W=0.42 nf=1 ad=0.1218 as=0.1218 pd=1.42 ps=1.42 nrd=0.69047619047619  nrs=0.69047619047619 sa=0 sb=0 sd=0 mult=1 m=1
csn_op1_1000_rl_s2_r0_0 sn_op1_1000_rl_s2_r0_0 0 {C_SN}
XMWR_op1_1000_rl_s2_r0_1 sn_op1_1000_rl_s2_r0_1 wwl_des wbl_op1_1000_rl_s2_r0 0 sky130_fd_pr__nfet_01v8 L=0.15 W=0.42 nf=1 ad=0.1218 as=0.1218 pd=1.42 ps=1.42 nrd=0.69047619047619  nrs=0.69047619047619 sa=0 sb=0 sd=0 mult=1 m=1
XMRD_op1_1000_rl_s2_r0_1 rbl_op1_1000_rl_s2_r0 sn_op1_1000_rl_s2_r0_1 rwl_des 0 sky130_fd_pr__nfet_01v8 L=0.15 W=0.42 nf=1 ad=0.1218 as=0.1218 pd=1.42 ps=1.42 nrd=0.69047619047619  nrs=0.69047619047619 sa=0 sb=0 sd=0 mult=1 m=1
csn_op1_1000_rl_s2_r0_1 sn_op1_1000_rl_s2_r0_1 0 {C_SN}
XMWR_op1_1000_rl_s2_r0_2 sn_op1_1000_rl_s2_r0_2 wwl_des wbl_op1_1000_rl_s2_r0 0 sky130_fd_pr__nfet_01v8 L=0.15 W=0.42 nf=1 ad=0.1218 as=0.1218 pd=1.42 ps=1.42 nrd=0.69047619047619  nrs=0.69047619047619 sa=0 sb=0 sd=0 mult=1 m=1
XMRD_op1_1000_rl_s2_r0_2 rbl_op1_1000_rl_s2_r0 sn_op1_1000_rl_s2_r0_2 rwl_des 0 sky130_fd_pr__nfet_01v8 L=0.15 W=0.42 nf=1 ad=0.1218 as=0.1218 pd=1.42 ps=1.42 nrd=0.69047619047619  nrs=0.69047619047619 sa=0 sb=0 sd=0 mult=1 m=1
csn_op1_1000_rl_s2_r0_2 sn_op1_1000_rl_s2_r0_2 0 {C_SN}
XMWR_op1_1000_rl_s2_r0_3 sn_op1_1000_rl_s2_r0_3 wwl_des wbl_op1_1000_rl_s2_r0 0 sky130_fd_pr__nfet_01v8 L=0.15 W=0.42 nf=1 ad=0.1218 as=0.1218 pd=1.42 ps=1.42 nrd=0.69047619047619  nrs=0.69047619047619 sa=0 sb=0 sd=0 mult=1 m=1
XMRD_op1_1000_rl_s2_r0_3 rbl_op1_1000_rl_s2_r0 sn_op1_1000_rl_s2_r0_3 rwl_des 0 sky130_fd_pr__nfet_01v8 L=0.15 W=0.42 nf=1 ad=0.1218 as=0.1218 pd=1.42 ps=1.42 nrd=0.69047619047619  nrs=0.69047619047619 sa=0 sb=0 sd=0 mult=1 m=1
csn_op1_1000_rl_s2_r0_3 sn_op1_1000_rl_s2_r0_3 0 {C_SN}
XMN1_op1_1000_rl_s2_r0 rbl_op1_1000_rl_s2_r0 ref_op1_1000_rl_s2_r0 vn_op1_1000_rl_s2_r0 0 sky130_fd_pr__nfet_01v8 L=0.15 W=1 nf=1 ad=0.29 as=0.29 pd=2.58 ps=2.58 mult=1 m=1
XMN2_op1_1000_rl_s2_r0 ref_op1_1000_rl_s2_r0 rbl_op1_1000_rl_s2_r0 vn_op1_1000_rl_s2_r0 0 sky130_fd_pr__nfet_01v8 L=0.15 W=1 nf=1 ad=0.29 as=0.29 pd=2.58 ps=2.58 mult=1 m=1
XMP1_op1_1000_rl_s2_r0 rbl_op1_1000_rl_s2_r0 ref_op1_1000_rl_s2_r0 vp_op1_1000_rl_s2_r0 vdd sky130_fd_pr__pfet_01v8 L=0.15 W=2 nf=1 ad=0.58 as=0.58 pd=4.58 ps=4.58 mult=1 m=1
XMP2_op1_1000_rl_s2_r0 ref_op1_1000_rl_s2_r0 rbl_op1_1000_rl_s2_r0 vp_op1_1000_rl_s2_r0 vdd sky130_fd_pr__pfet_01v8 L=0.15 W=2 nf=1 ad=0.58 as=0.58 pd=4.58 ps=4.58 mult=1 m=1
XMNF_op1_1000_rl_s2_r0 vn_op1_1000_rl_s2_r0 en_op1_1000_rl_s2_r0 0 0 sky130_fd_pr__nfet_01v8 L=0.15 W=2 nf=1 ad=0.58 as=0.58 pd=4.58 ps=4.58 mult=1 m=1
XMPH_op1_1000_rl_s2_r0 vp_op1_1000_rl_s2_r0 enb_op1_1000_rl_s2_r0 vdd vdd sky130_fd_pr__pfet_01v8 L=0.15 W=4 nf=1 ad=1.16 as=1.16 pd=8.58 ps=8.58 mult=1 m=1
bd_op1_1000_rl_s2_r0 d_op1_1000_rl_s2_r0 0 v=v(rbl_op1_1000_rl_s2_r0)-v(ref_op1_1000_rl_s2_r0)

* ---- instance 171: op0_n100_rl_s2_r0 (variant rl_s2_r0; probe dec 11.9 ns, release 34 ns, meas 36 ns) ----
vctl_op0_n100_rl_s2_r0 ctl_op0_n100_rl_s2_r0 0 pwl(0.0000e+00 {VDD} 2.0000e-09 {VDD} 2.1000e-09 0)
* RWL driver model (EXPERIMENTAL): slew 2 ns, series R 0 ohm; cell pin = rwls_op0_n100_rl_s2_r0
vrs_op0_n100_rl_s2_r0 rwls_op0_n100_rl_s2_r0 0 pwl(0.0000e+00 {VDD} 2.0000e-09 {VDD} 4.0000e-09 0 3.4000e-08 0 3.6000e-08 {VDD})
ven_op0_n100_rl_s2_r0 en_op0_n100_rl_s2_r0 0 pwl(0.0000e+00 0 1.1000e-08 0 1.1100e-08 {VDD} 3.4000e-08 {VDD} 3.4100e-08 0)
venb_op0_n100_rl_s2_r0 enb_op0_n100_rl_s2_r0 0 pwl(0.0000e+00 {VDD} 1.1000e-08 {VDD} 1.1100e-08 0 3.4000e-08 0 3.4100e-08 {VDD})
vww_op0_n100_rl_s2_r0 wwl_op0_n100_rl_s2_r0 0 pwl(0.0000e+00 0 1.2000e-08 0 1.2100e-08 {VDD} 3.2000e-08 {VDD} 3.2100e-08 0)
vwc_op0_n100_rl_s2_r0 wbc_op0_n100_rl_s2_r0 0 pwl(0.0000e+00 0 1.2000e-08 0 1.2100e-08 {VDD} 3.4000e-08 {VDD} 3.4100e-08 0)
swb_op0_n100_rl_s2_r0 ref_op0_n100_rl_s2_r0 wbl_op0_n100_rl_s2_r0 wbc_op0_n100_rl_s2_r0 0 swwbl
cwbl_op0_n100_rl_s2_r0 wbl_op0_n100_rl_s2_r0 0 {C_WBL}
spa_op0_n100_rl_s2_r0 prea rbl_op0_n100_rl_s2_r0 ctl_op0_n100_rl_s2_r0 0 swpre
spr_op0_n100_rl_s2_r0 pref ref_op0_n100_rl_s2_r0 ctl_op0_n100_rl_s2_r0 0 swpre
crbl_op0_n100_rl_s2_r0 rbl_op0_n100_rl_s2_r0 0 {C_RBL}
cref_op0_n100_rl_s2_r0 ref_op0_n100_rl_s2_r0 0 {C_RBL}   $ ASSUMPTION: ideal matched dummy load
XMWR_op0_n100_rl_s2_r0_0 sn_op0_n100_rl_s2_r0_0 wwl_op0_n100_rl_s2_r0 wbl_op0_n100_rl_s2_r0 0 sky130_fd_pr__nfet_01v8 L=0.15 W=0.42 nf=1 ad=0.1218 as=0.1218 pd=1.42 ps=1.42 nrd=0.69047619047619  nrs=0.69047619047619 sa=0 sb=0 sd=0 mult=1 m=1
XMRD_op0_n100_rl_s2_r0_0 rbl_op0_n100_rl_s2_r0 sn_op0_n100_rl_s2_r0_0 rwls_op0_n100_rl_s2_r0 0 sky130_fd_pr__nfet_01v8 L=0.15 W=0.42 nf=1 ad=0.1218 as=0.1218 pd=1.42 ps=1.42 nrd=0.69047619047619  nrs=0.69047619047619 sa=0 sb=0 sd=0 mult=1 m=1
csn_op0_n100_rl_s2_r0_0 sn_op0_n100_rl_s2_r0_0 0 {C_SN}
XMWR_op0_n100_rl_s2_r0_1 sn_op0_n100_rl_s2_r0_1 wwl_des wbl_op0_n100_rl_s2_r0 0 sky130_fd_pr__nfet_01v8 L=0.15 W=0.42 nf=1 ad=0.1218 as=0.1218 pd=1.42 ps=1.42 nrd=0.69047619047619  nrs=0.69047619047619 sa=0 sb=0 sd=0 mult=1 m=1
XMRD_op0_n100_rl_s2_r0_1 rbl_op0_n100_rl_s2_r0 sn_op0_n100_rl_s2_r0_1 rwl_des 0 sky130_fd_pr__nfet_01v8 L=0.15 W=0.42 nf=1 ad=0.1218 as=0.1218 pd=1.42 ps=1.42 nrd=0.69047619047619  nrs=0.69047619047619 sa=0 sb=0 sd=0 mult=1 m=1
csn_op0_n100_rl_s2_r0_1 sn_op0_n100_rl_s2_r0_1 0 {C_SN}
XMWR_op0_n100_rl_s2_r0_2 sn_op0_n100_rl_s2_r0_2 wwl_des wbl_op0_n100_rl_s2_r0 0 sky130_fd_pr__nfet_01v8 L=0.15 W=0.42 nf=1 ad=0.1218 as=0.1218 pd=1.42 ps=1.42 nrd=0.69047619047619  nrs=0.69047619047619 sa=0 sb=0 sd=0 mult=1 m=1
XMRD_op0_n100_rl_s2_r0_2 rbl_op0_n100_rl_s2_r0 sn_op0_n100_rl_s2_r0_2 rwl_des 0 sky130_fd_pr__nfet_01v8 L=0.15 W=0.42 nf=1 ad=0.1218 as=0.1218 pd=1.42 ps=1.42 nrd=0.69047619047619  nrs=0.69047619047619 sa=0 sb=0 sd=0 mult=1 m=1
csn_op0_n100_rl_s2_r0_2 sn_op0_n100_rl_s2_r0_2 0 {C_SN}
XMWR_op0_n100_rl_s2_r0_3 sn_op0_n100_rl_s2_r0_3 wwl_des wbl_op0_n100_rl_s2_r0 0 sky130_fd_pr__nfet_01v8 L=0.15 W=0.42 nf=1 ad=0.1218 as=0.1218 pd=1.42 ps=1.42 nrd=0.69047619047619  nrs=0.69047619047619 sa=0 sb=0 sd=0 mult=1 m=1
XMRD_op0_n100_rl_s2_r0_3 rbl_op0_n100_rl_s2_r0 sn_op0_n100_rl_s2_r0_3 rwl_des 0 sky130_fd_pr__nfet_01v8 L=0.15 W=0.42 nf=1 ad=0.1218 as=0.1218 pd=1.42 ps=1.42 nrd=0.69047619047619  nrs=0.69047619047619 sa=0 sb=0 sd=0 mult=1 m=1
csn_op0_n100_rl_s2_r0_3 sn_op0_n100_rl_s2_r0_3 0 {C_SN}
XMN1_op0_n100_rl_s2_r0 rbl_op0_n100_rl_s2_r0 ref_op0_n100_rl_s2_r0 vn_op0_n100_rl_s2_r0 0 sky130_fd_pr__nfet_01v8 L=0.15 W=1 nf=1 ad=0.29 as=0.29 pd=2.58 ps=2.58 mult=1 m=1
XMN2_op0_n100_rl_s2_r0 ref_op0_n100_rl_s2_r0 rbl_op0_n100_rl_s2_r0 vn_op0_n100_rl_s2_r0 0 sky130_fd_pr__nfet_01v8 L=0.15 W=1 nf=1 ad=0.29 as=0.29 pd=2.58 ps=2.58 mult=1 m=1
XMP1_op0_n100_rl_s2_r0 rbl_op0_n100_rl_s2_r0 ref_op0_n100_rl_s2_r0 vp_op0_n100_rl_s2_r0 vdd sky130_fd_pr__pfet_01v8 L=0.15 W=2 nf=1 ad=0.58 as=0.58 pd=4.58 ps=4.58 mult=1 m=1
XMP2_op0_n100_rl_s2_r0 ref_op0_n100_rl_s2_r0 rbl_op0_n100_rl_s2_r0 vp_op0_n100_rl_s2_r0 vdd sky130_fd_pr__pfet_01v8 L=0.15 W=2 nf=1 ad=0.58 as=0.58 pd=4.58 ps=4.58 mult=1 m=1
XMNF_op0_n100_rl_s2_r0 vn_op0_n100_rl_s2_r0 en_op0_n100_rl_s2_r0 0 0 sky130_fd_pr__nfet_01v8 L=0.15 W=2 nf=1 ad=0.58 as=0.58 pd=4.58 ps=4.58 mult=1 m=1
XMPH_op0_n100_rl_s2_r0 vp_op0_n100_rl_s2_r0 enb_op0_n100_rl_s2_r0 vdd vdd sky130_fd_pr__pfet_01v8 L=0.15 W=4 nf=1 ad=1.16 as=1.16 pd=8.58 ps=8.58 mult=1 m=1
bd_op0_n100_rl_s2_r0 d_op0_n100_rl_s2_r0 0 v=v(rbl_op0_n100_rl_s2_r0)-v(ref_op0_n100_rl_s2_r0)

* ---- instance 172: op0_0000_rl_s2_r0 (variant rl_s2_r0; probe dec 11.9 ns, release 34 ns, meas 36 ns) ----
vctl_op0_0000_rl_s2_r0 ctl_op0_0000_rl_s2_r0 0 pwl(0.0000e+00 {VDD} 2.0000e-09 {VDD} 2.1000e-09 0)
* RWL driver model (EXPERIMENTAL): slew 2 ns, series R 0 ohm; cell pin = rwls_op0_0000_rl_s2_r0
vrs_op0_0000_rl_s2_r0 rwls_op0_0000_rl_s2_r0 0 pwl(0.0000e+00 {VDD} 2.0000e-09 {VDD} 4.0000e-09 0 3.4000e-08 0 3.6000e-08 {VDD})
ven_op0_0000_rl_s2_r0 en_op0_0000_rl_s2_r0 0 pwl(0.0000e+00 0 1.1000e-08 0 1.1100e-08 {VDD} 3.4000e-08 {VDD} 3.4100e-08 0)
venb_op0_0000_rl_s2_r0 enb_op0_0000_rl_s2_r0 0 pwl(0.0000e+00 {VDD} 1.1000e-08 {VDD} 1.1100e-08 0 3.4000e-08 0 3.4100e-08 {VDD})
vww_op0_0000_rl_s2_r0 wwl_op0_0000_rl_s2_r0 0 pwl(0.0000e+00 0 1.2000e-08 0 1.2100e-08 {VDD} 3.2000e-08 {VDD} 3.2100e-08 0)
vwc_op0_0000_rl_s2_r0 wbc_op0_0000_rl_s2_r0 0 pwl(0.0000e+00 0 1.2000e-08 0 1.2100e-08 {VDD} 3.4000e-08 {VDD} 3.4100e-08 0)
swb_op0_0000_rl_s2_r0 ref_op0_0000_rl_s2_r0 wbl_op0_0000_rl_s2_r0 wbc_op0_0000_rl_s2_r0 0 swwbl
cwbl_op0_0000_rl_s2_r0 wbl_op0_0000_rl_s2_r0 0 {C_WBL}
spa_op0_0000_rl_s2_r0 prea rbl_op0_0000_rl_s2_r0 ctl_op0_0000_rl_s2_r0 0 swpre
spr_op0_0000_rl_s2_r0 pref ref_op0_0000_rl_s2_r0 ctl_op0_0000_rl_s2_r0 0 swpre
crbl_op0_0000_rl_s2_r0 rbl_op0_0000_rl_s2_r0 0 {C_RBL}
cref_op0_0000_rl_s2_r0 ref_op0_0000_rl_s2_r0 0 {C_RBL}   $ ASSUMPTION: ideal matched dummy load
XMWR_op0_0000_rl_s2_r0_0 sn_op0_0000_rl_s2_r0_0 wwl_op0_0000_rl_s2_r0 wbl_op0_0000_rl_s2_r0 0 sky130_fd_pr__nfet_01v8 L=0.15 W=0.42 nf=1 ad=0.1218 as=0.1218 pd=1.42 ps=1.42 nrd=0.69047619047619  nrs=0.69047619047619 sa=0 sb=0 sd=0 mult=1 m=1
XMRD_op0_0000_rl_s2_r0_0 rbl_op0_0000_rl_s2_r0 sn_op0_0000_rl_s2_r0_0 rwls_op0_0000_rl_s2_r0 0 sky130_fd_pr__nfet_01v8 L=0.15 W=0.42 nf=1 ad=0.1218 as=0.1218 pd=1.42 ps=1.42 nrd=0.69047619047619  nrs=0.69047619047619 sa=0 sb=0 sd=0 mult=1 m=1
csn_op0_0000_rl_s2_r0_0 sn_op0_0000_rl_s2_r0_0 0 {C_SN}
XMWR_op0_0000_rl_s2_r0_1 sn_op0_0000_rl_s2_r0_1 wwl_des wbl_op0_0000_rl_s2_r0 0 sky130_fd_pr__nfet_01v8 L=0.15 W=0.42 nf=1 ad=0.1218 as=0.1218 pd=1.42 ps=1.42 nrd=0.69047619047619  nrs=0.69047619047619 sa=0 sb=0 sd=0 mult=1 m=1
XMRD_op0_0000_rl_s2_r0_1 rbl_op0_0000_rl_s2_r0 sn_op0_0000_rl_s2_r0_1 rwl_des 0 sky130_fd_pr__nfet_01v8 L=0.15 W=0.42 nf=1 ad=0.1218 as=0.1218 pd=1.42 ps=1.42 nrd=0.69047619047619  nrs=0.69047619047619 sa=0 sb=0 sd=0 mult=1 m=1
csn_op0_0000_rl_s2_r0_1 sn_op0_0000_rl_s2_r0_1 0 {C_SN}
XMWR_op0_0000_rl_s2_r0_2 sn_op0_0000_rl_s2_r0_2 wwl_des wbl_op0_0000_rl_s2_r0 0 sky130_fd_pr__nfet_01v8 L=0.15 W=0.42 nf=1 ad=0.1218 as=0.1218 pd=1.42 ps=1.42 nrd=0.69047619047619  nrs=0.69047619047619 sa=0 sb=0 sd=0 mult=1 m=1
XMRD_op0_0000_rl_s2_r0_2 rbl_op0_0000_rl_s2_r0 sn_op0_0000_rl_s2_r0_2 rwl_des 0 sky130_fd_pr__nfet_01v8 L=0.15 W=0.42 nf=1 ad=0.1218 as=0.1218 pd=1.42 ps=1.42 nrd=0.69047619047619  nrs=0.69047619047619 sa=0 sb=0 sd=0 mult=1 m=1
csn_op0_0000_rl_s2_r0_2 sn_op0_0000_rl_s2_r0_2 0 {C_SN}
XMWR_op0_0000_rl_s2_r0_3 sn_op0_0000_rl_s2_r0_3 wwl_des wbl_op0_0000_rl_s2_r0 0 sky130_fd_pr__nfet_01v8 L=0.15 W=0.42 nf=1 ad=0.1218 as=0.1218 pd=1.42 ps=1.42 nrd=0.69047619047619  nrs=0.69047619047619 sa=0 sb=0 sd=0 mult=1 m=1
XMRD_op0_0000_rl_s2_r0_3 rbl_op0_0000_rl_s2_r0 sn_op0_0000_rl_s2_r0_3 rwl_des 0 sky130_fd_pr__nfet_01v8 L=0.15 W=0.42 nf=1 ad=0.1218 as=0.1218 pd=1.42 ps=1.42 nrd=0.69047619047619  nrs=0.69047619047619 sa=0 sb=0 sd=0 mult=1 m=1
csn_op0_0000_rl_s2_r0_3 sn_op0_0000_rl_s2_r0_3 0 {C_SN}
XMN1_op0_0000_rl_s2_r0 rbl_op0_0000_rl_s2_r0 ref_op0_0000_rl_s2_r0 vn_op0_0000_rl_s2_r0 0 sky130_fd_pr__nfet_01v8 L=0.15 W=1 nf=1 ad=0.29 as=0.29 pd=2.58 ps=2.58 mult=1 m=1
XMN2_op0_0000_rl_s2_r0 ref_op0_0000_rl_s2_r0 rbl_op0_0000_rl_s2_r0 vn_op0_0000_rl_s2_r0 0 sky130_fd_pr__nfet_01v8 L=0.15 W=1 nf=1 ad=0.29 as=0.29 pd=2.58 ps=2.58 mult=1 m=1
XMP1_op0_0000_rl_s2_r0 rbl_op0_0000_rl_s2_r0 ref_op0_0000_rl_s2_r0 vp_op0_0000_rl_s2_r0 vdd sky130_fd_pr__pfet_01v8 L=0.15 W=2 nf=1 ad=0.58 as=0.58 pd=4.58 ps=4.58 mult=1 m=1
XMP2_op0_0000_rl_s2_r0 ref_op0_0000_rl_s2_r0 rbl_op0_0000_rl_s2_r0 vp_op0_0000_rl_s2_r0 vdd sky130_fd_pr__pfet_01v8 L=0.15 W=2 nf=1 ad=0.58 as=0.58 pd=4.58 ps=4.58 mult=1 m=1
XMNF_op0_0000_rl_s2_r0 vn_op0_0000_rl_s2_r0 en_op0_0000_rl_s2_r0 0 0 sky130_fd_pr__nfet_01v8 L=0.15 W=2 nf=1 ad=0.58 as=0.58 pd=4.58 ps=4.58 mult=1 m=1
XMPH_op0_0000_rl_s2_r0 vp_op0_0000_rl_s2_r0 enb_op0_0000_rl_s2_r0 vdd vdd sky130_fd_pr__pfet_01v8 L=0.15 W=4 nf=1 ad=1.16 as=1.16 pd=8.58 ps=8.58 mult=1 m=1
bd_op0_0000_rl_s2_r0 d_op0_0000_rl_s2_r0 0 v=v(rbl_op0_0000_rl_s2_r0)-v(ref_op0_0000_rl_s2_r0)

* ---- instance 173: op1_0900_rl_s5_r0 (variant rl_s5_r0; probe dec 11.9 ns, release 34 ns, meas 36 ns) ----
vctl_op1_0900_rl_s5_r0 ctl_op1_0900_rl_s5_r0 0 pwl(0.0000e+00 {VDD} 2.0000e-09 {VDD} 2.1000e-09 0)
* RWL driver model (EXPERIMENTAL): slew 5 ns, series R 0 ohm; cell pin = rwls_op1_0900_rl_s5_r0
vrs_op1_0900_rl_s5_r0 rwls_op1_0900_rl_s5_r0 0 pwl(0.0000e+00 {VDD} 2.0000e-09 {VDD} 7.0000e-09 0 3.4000e-08 0 3.9000e-08 {VDD})
ven_op1_0900_rl_s5_r0 en_op1_0900_rl_s5_r0 0 pwl(0.0000e+00 0 1.1000e-08 0 1.1100e-08 {VDD} 3.4000e-08 {VDD} 3.4100e-08 0)
venb_op1_0900_rl_s5_r0 enb_op1_0900_rl_s5_r0 0 pwl(0.0000e+00 {VDD} 1.1000e-08 {VDD} 1.1100e-08 0 3.4000e-08 0 3.4100e-08 {VDD})
vww_op1_0900_rl_s5_r0 wwl_op1_0900_rl_s5_r0 0 pwl(0.0000e+00 0 1.2000e-08 0 1.2100e-08 {VDD} 3.2000e-08 {VDD} 3.2100e-08 0)
vwc_op1_0900_rl_s5_r0 wbc_op1_0900_rl_s5_r0 0 pwl(0.0000e+00 0 1.2000e-08 0 1.2100e-08 {VDD} 3.4000e-08 {VDD} 3.4100e-08 0)
swb_op1_0900_rl_s5_r0 ref_op1_0900_rl_s5_r0 wbl_op1_0900_rl_s5_r0 wbc_op1_0900_rl_s5_r0 0 swwbl
cwbl_op1_0900_rl_s5_r0 wbl_op1_0900_rl_s5_r0 0 {C_WBL}
spa_op1_0900_rl_s5_r0 prea rbl_op1_0900_rl_s5_r0 ctl_op1_0900_rl_s5_r0 0 swpre
spr_op1_0900_rl_s5_r0 pref ref_op1_0900_rl_s5_r0 ctl_op1_0900_rl_s5_r0 0 swpre
crbl_op1_0900_rl_s5_r0 rbl_op1_0900_rl_s5_r0 0 {C_RBL}
cref_op1_0900_rl_s5_r0 ref_op1_0900_rl_s5_r0 0 {C_RBL}   $ ASSUMPTION: ideal matched dummy load
XMWR_op1_0900_rl_s5_r0_0 sn_op1_0900_rl_s5_r0_0 wwl_op1_0900_rl_s5_r0 wbl_op1_0900_rl_s5_r0 0 sky130_fd_pr__nfet_01v8 L=0.15 W=0.42 nf=1 ad=0.1218 as=0.1218 pd=1.42 ps=1.42 nrd=0.69047619047619  nrs=0.69047619047619 sa=0 sb=0 sd=0 mult=1 m=1
XMRD_op1_0900_rl_s5_r0_0 rbl_op1_0900_rl_s5_r0 sn_op1_0900_rl_s5_r0_0 rwls_op1_0900_rl_s5_r0 0 sky130_fd_pr__nfet_01v8 L=0.15 W=0.42 nf=1 ad=0.1218 as=0.1218 pd=1.42 ps=1.42 nrd=0.69047619047619  nrs=0.69047619047619 sa=0 sb=0 sd=0 mult=1 m=1
csn_op1_0900_rl_s5_r0_0 sn_op1_0900_rl_s5_r0_0 0 {C_SN}
XMWR_op1_0900_rl_s5_r0_1 sn_op1_0900_rl_s5_r0_1 wwl_des wbl_op1_0900_rl_s5_r0 0 sky130_fd_pr__nfet_01v8 L=0.15 W=0.42 nf=1 ad=0.1218 as=0.1218 pd=1.42 ps=1.42 nrd=0.69047619047619  nrs=0.69047619047619 sa=0 sb=0 sd=0 mult=1 m=1
XMRD_op1_0900_rl_s5_r0_1 rbl_op1_0900_rl_s5_r0 sn_op1_0900_rl_s5_r0_1 rwl_des 0 sky130_fd_pr__nfet_01v8 L=0.15 W=0.42 nf=1 ad=0.1218 as=0.1218 pd=1.42 ps=1.42 nrd=0.69047619047619  nrs=0.69047619047619 sa=0 sb=0 sd=0 mult=1 m=1
csn_op1_0900_rl_s5_r0_1 sn_op1_0900_rl_s5_r0_1 0 {C_SN}
XMWR_op1_0900_rl_s5_r0_2 sn_op1_0900_rl_s5_r0_2 wwl_des wbl_op1_0900_rl_s5_r0 0 sky130_fd_pr__nfet_01v8 L=0.15 W=0.42 nf=1 ad=0.1218 as=0.1218 pd=1.42 ps=1.42 nrd=0.69047619047619  nrs=0.69047619047619 sa=0 sb=0 sd=0 mult=1 m=1
XMRD_op1_0900_rl_s5_r0_2 rbl_op1_0900_rl_s5_r0 sn_op1_0900_rl_s5_r0_2 rwl_des 0 sky130_fd_pr__nfet_01v8 L=0.15 W=0.42 nf=1 ad=0.1218 as=0.1218 pd=1.42 ps=1.42 nrd=0.69047619047619  nrs=0.69047619047619 sa=0 sb=0 sd=0 mult=1 m=1
csn_op1_0900_rl_s5_r0_2 sn_op1_0900_rl_s5_r0_2 0 {C_SN}
XMWR_op1_0900_rl_s5_r0_3 sn_op1_0900_rl_s5_r0_3 wwl_des wbl_op1_0900_rl_s5_r0 0 sky130_fd_pr__nfet_01v8 L=0.15 W=0.42 nf=1 ad=0.1218 as=0.1218 pd=1.42 ps=1.42 nrd=0.69047619047619  nrs=0.69047619047619 sa=0 sb=0 sd=0 mult=1 m=1
XMRD_op1_0900_rl_s5_r0_3 rbl_op1_0900_rl_s5_r0 sn_op1_0900_rl_s5_r0_3 rwl_des 0 sky130_fd_pr__nfet_01v8 L=0.15 W=0.42 nf=1 ad=0.1218 as=0.1218 pd=1.42 ps=1.42 nrd=0.69047619047619  nrs=0.69047619047619 sa=0 sb=0 sd=0 mult=1 m=1
csn_op1_0900_rl_s5_r0_3 sn_op1_0900_rl_s5_r0_3 0 {C_SN}
XMN1_op1_0900_rl_s5_r0 rbl_op1_0900_rl_s5_r0 ref_op1_0900_rl_s5_r0 vn_op1_0900_rl_s5_r0 0 sky130_fd_pr__nfet_01v8 L=0.15 W=1 nf=1 ad=0.29 as=0.29 pd=2.58 ps=2.58 mult=1 m=1
XMN2_op1_0900_rl_s5_r0 ref_op1_0900_rl_s5_r0 rbl_op1_0900_rl_s5_r0 vn_op1_0900_rl_s5_r0 0 sky130_fd_pr__nfet_01v8 L=0.15 W=1 nf=1 ad=0.29 as=0.29 pd=2.58 ps=2.58 mult=1 m=1
XMP1_op1_0900_rl_s5_r0 rbl_op1_0900_rl_s5_r0 ref_op1_0900_rl_s5_r0 vp_op1_0900_rl_s5_r0 vdd sky130_fd_pr__pfet_01v8 L=0.15 W=2 nf=1 ad=0.58 as=0.58 pd=4.58 ps=4.58 mult=1 m=1
XMP2_op1_0900_rl_s5_r0 ref_op1_0900_rl_s5_r0 rbl_op1_0900_rl_s5_r0 vp_op1_0900_rl_s5_r0 vdd sky130_fd_pr__pfet_01v8 L=0.15 W=2 nf=1 ad=0.58 as=0.58 pd=4.58 ps=4.58 mult=1 m=1
XMNF_op1_0900_rl_s5_r0 vn_op1_0900_rl_s5_r0 en_op1_0900_rl_s5_r0 0 0 sky130_fd_pr__nfet_01v8 L=0.15 W=2 nf=1 ad=0.58 as=0.58 pd=4.58 ps=4.58 mult=1 m=1
XMPH_op1_0900_rl_s5_r0 vp_op1_0900_rl_s5_r0 enb_op1_0900_rl_s5_r0 vdd vdd sky130_fd_pr__pfet_01v8 L=0.15 W=4 nf=1 ad=1.16 as=1.16 pd=8.58 ps=8.58 mult=1 m=1
bd_op1_0900_rl_s5_r0 d_op1_0900_rl_s5_r0 0 v=v(rbl_op1_0900_rl_s5_r0)-v(ref_op1_0900_rl_s5_r0)

* ---- instance 174: op1_1000_rl_s5_r0 (variant rl_s5_r0; probe dec 11.9 ns, release 34 ns, meas 36 ns) ----
vctl_op1_1000_rl_s5_r0 ctl_op1_1000_rl_s5_r0 0 pwl(0.0000e+00 {VDD} 2.0000e-09 {VDD} 2.1000e-09 0)
* RWL driver model (EXPERIMENTAL): slew 5 ns, series R 0 ohm; cell pin = rwls_op1_1000_rl_s5_r0
vrs_op1_1000_rl_s5_r0 rwls_op1_1000_rl_s5_r0 0 pwl(0.0000e+00 {VDD} 2.0000e-09 {VDD} 7.0000e-09 0 3.4000e-08 0 3.9000e-08 {VDD})
ven_op1_1000_rl_s5_r0 en_op1_1000_rl_s5_r0 0 pwl(0.0000e+00 0 1.1000e-08 0 1.1100e-08 {VDD} 3.4000e-08 {VDD} 3.4100e-08 0)
venb_op1_1000_rl_s5_r0 enb_op1_1000_rl_s5_r0 0 pwl(0.0000e+00 {VDD} 1.1000e-08 {VDD} 1.1100e-08 0 3.4000e-08 0 3.4100e-08 {VDD})
vww_op1_1000_rl_s5_r0 wwl_op1_1000_rl_s5_r0 0 pwl(0.0000e+00 0 1.2000e-08 0 1.2100e-08 {VDD} 3.2000e-08 {VDD} 3.2100e-08 0)
vwc_op1_1000_rl_s5_r0 wbc_op1_1000_rl_s5_r0 0 pwl(0.0000e+00 0 1.2000e-08 0 1.2100e-08 {VDD} 3.4000e-08 {VDD} 3.4100e-08 0)
swb_op1_1000_rl_s5_r0 ref_op1_1000_rl_s5_r0 wbl_op1_1000_rl_s5_r0 wbc_op1_1000_rl_s5_r0 0 swwbl
cwbl_op1_1000_rl_s5_r0 wbl_op1_1000_rl_s5_r0 0 {C_WBL}
spa_op1_1000_rl_s5_r0 prea rbl_op1_1000_rl_s5_r0 ctl_op1_1000_rl_s5_r0 0 swpre
spr_op1_1000_rl_s5_r0 pref ref_op1_1000_rl_s5_r0 ctl_op1_1000_rl_s5_r0 0 swpre
crbl_op1_1000_rl_s5_r0 rbl_op1_1000_rl_s5_r0 0 {C_RBL}
cref_op1_1000_rl_s5_r0 ref_op1_1000_rl_s5_r0 0 {C_RBL}   $ ASSUMPTION: ideal matched dummy load
XMWR_op1_1000_rl_s5_r0_0 sn_op1_1000_rl_s5_r0_0 wwl_op1_1000_rl_s5_r0 wbl_op1_1000_rl_s5_r0 0 sky130_fd_pr__nfet_01v8 L=0.15 W=0.42 nf=1 ad=0.1218 as=0.1218 pd=1.42 ps=1.42 nrd=0.69047619047619  nrs=0.69047619047619 sa=0 sb=0 sd=0 mult=1 m=1
XMRD_op1_1000_rl_s5_r0_0 rbl_op1_1000_rl_s5_r0 sn_op1_1000_rl_s5_r0_0 rwls_op1_1000_rl_s5_r0 0 sky130_fd_pr__nfet_01v8 L=0.15 W=0.42 nf=1 ad=0.1218 as=0.1218 pd=1.42 ps=1.42 nrd=0.69047619047619  nrs=0.69047619047619 sa=0 sb=0 sd=0 mult=1 m=1
csn_op1_1000_rl_s5_r0_0 sn_op1_1000_rl_s5_r0_0 0 {C_SN}
XMWR_op1_1000_rl_s5_r0_1 sn_op1_1000_rl_s5_r0_1 wwl_des wbl_op1_1000_rl_s5_r0 0 sky130_fd_pr__nfet_01v8 L=0.15 W=0.42 nf=1 ad=0.1218 as=0.1218 pd=1.42 ps=1.42 nrd=0.69047619047619  nrs=0.69047619047619 sa=0 sb=0 sd=0 mult=1 m=1
XMRD_op1_1000_rl_s5_r0_1 rbl_op1_1000_rl_s5_r0 sn_op1_1000_rl_s5_r0_1 rwl_des 0 sky130_fd_pr__nfet_01v8 L=0.15 W=0.42 nf=1 ad=0.1218 as=0.1218 pd=1.42 ps=1.42 nrd=0.69047619047619  nrs=0.69047619047619 sa=0 sb=0 sd=0 mult=1 m=1
csn_op1_1000_rl_s5_r0_1 sn_op1_1000_rl_s5_r0_1 0 {C_SN}
XMWR_op1_1000_rl_s5_r0_2 sn_op1_1000_rl_s5_r0_2 wwl_des wbl_op1_1000_rl_s5_r0 0 sky130_fd_pr__nfet_01v8 L=0.15 W=0.42 nf=1 ad=0.1218 as=0.1218 pd=1.42 ps=1.42 nrd=0.69047619047619  nrs=0.69047619047619 sa=0 sb=0 sd=0 mult=1 m=1
XMRD_op1_1000_rl_s5_r0_2 rbl_op1_1000_rl_s5_r0 sn_op1_1000_rl_s5_r0_2 rwl_des 0 sky130_fd_pr__nfet_01v8 L=0.15 W=0.42 nf=1 ad=0.1218 as=0.1218 pd=1.42 ps=1.42 nrd=0.69047619047619  nrs=0.69047619047619 sa=0 sb=0 sd=0 mult=1 m=1
csn_op1_1000_rl_s5_r0_2 sn_op1_1000_rl_s5_r0_2 0 {C_SN}
XMWR_op1_1000_rl_s5_r0_3 sn_op1_1000_rl_s5_r0_3 wwl_des wbl_op1_1000_rl_s5_r0 0 sky130_fd_pr__nfet_01v8 L=0.15 W=0.42 nf=1 ad=0.1218 as=0.1218 pd=1.42 ps=1.42 nrd=0.69047619047619  nrs=0.69047619047619 sa=0 sb=0 sd=0 mult=1 m=1
XMRD_op1_1000_rl_s5_r0_3 rbl_op1_1000_rl_s5_r0 sn_op1_1000_rl_s5_r0_3 rwl_des 0 sky130_fd_pr__nfet_01v8 L=0.15 W=0.42 nf=1 ad=0.1218 as=0.1218 pd=1.42 ps=1.42 nrd=0.69047619047619  nrs=0.69047619047619 sa=0 sb=0 sd=0 mult=1 m=1
csn_op1_1000_rl_s5_r0_3 sn_op1_1000_rl_s5_r0_3 0 {C_SN}
XMN1_op1_1000_rl_s5_r0 rbl_op1_1000_rl_s5_r0 ref_op1_1000_rl_s5_r0 vn_op1_1000_rl_s5_r0 0 sky130_fd_pr__nfet_01v8 L=0.15 W=1 nf=1 ad=0.29 as=0.29 pd=2.58 ps=2.58 mult=1 m=1
XMN2_op1_1000_rl_s5_r0 ref_op1_1000_rl_s5_r0 rbl_op1_1000_rl_s5_r0 vn_op1_1000_rl_s5_r0 0 sky130_fd_pr__nfet_01v8 L=0.15 W=1 nf=1 ad=0.29 as=0.29 pd=2.58 ps=2.58 mult=1 m=1
XMP1_op1_1000_rl_s5_r0 rbl_op1_1000_rl_s5_r0 ref_op1_1000_rl_s5_r0 vp_op1_1000_rl_s5_r0 vdd sky130_fd_pr__pfet_01v8 L=0.15 W=2 nf=1 ad=0.58 as=0.58 pd=4.58 ps=4.58 mult=1 m=1
XMP2_op1_1000_rl_s5_r0 ref_op1_1000_rl_s5_r0 rbl_op1_1000_rl_s5_r0 vp_op1_1000_rl_s5_r0 vdd sky130_fd_pr__pfet_01v8 L=0.15 W=2 nf=1 ad=0.58 as=0.58 pd=4.58 ps=4.58 mult=1 m=1
XMNF_op1_1000_rl_s5_r0 vn_op1_1000_rl_s5_r0 en_op1_1000_rl_s5_r0 0 0 sky130_fd_pr__nfet_01v8 L=0.15 W=2 nf=1 ad=0.58 as=0.58 pd=4.58 ps=4.58 mult=1 m=1
XMPH_op1_1000_rl_s5_r0 vp_op1_1000_rl_s5_r0 enb_op1_1000_rl_s5_r0 vdd vdd sky130_fd_pr__pfet_01v8 L=0.15 W=4 nf=1 ad=1.16 as=1.16 pd=8.58 ps=8.58 mult=1 m=1
bd_op1_1000_rl_s5_r0 d_op1_1000_rl_s5_r0 0 v=v(rbl_op1_1000_rl_s5_r0)-v(ref_op1_1000_rl_s5_r0)

* ---- instance 175: op0_n100_rl_s5_r0 (variant rl_s5_r0; probe dec 11.9 ns, release 34 ns, meas 36 ns) ----
vctl_op0_n100_rl_s5_r0 ctl_op0_n100_rl_s5_r0 0 pwl(0.0000e+00 {VDD} 2.0000e-09 {VDD} 2.1000e-09 0)
* RWL driver model (EXPERIMENTAL): slew 5 ns, series R 0 ohm; cell pin = rwls_op0_n100_rl_s5_r0
vrs_op0_n100_rl_s5_r0 rwls_op0_n100_rl_s5_r0 0 pwl(0.0000e+00 {VDD} 2.0000e-09 {VDD} 7.0000e-09 0 3.4000e-08 0 3.9000e-08 {VDD})
ven_op0_n100_rl_s5_r0 en_op0_n100_rl_s5_r0 0 pwl(0.0000e+00 0 1.1000e-08 0 1.1100e-08 {VDD} 3.4000e-08 {VDD} 3.4100e-08 0)
venb_op0_n100_rl_s5_r0 enb_op0_n100_rl_s5_r0 0 pwl(0.0000e+00 {VDD} 1.1000e-08 {VDD} 1.1100e-08 0 3.4000e-08 0 3.4100e-08 {VDD})
vww_op0_n100_rl_s5_r0 wwl_op0_n100_rl_s5_r0 0 pwl(0.0000e+00 0 1.2000e-08 0 1.2100e-08 {VDD} 3.2000e-08 {VDD} 3.2100e-08 0)
vwc_op0_n100_rl_s5_r0 wbc_op0_n100_rl_s5_r0 0 pwl(0.0000e+00 0 1.2000e-08 0 1.2100e-08 {VDD} 3.4000e-08 {VDD} 3.4100e-08 0)
swb_op0_n100_rl_s5_r0 ref_op0_n100_rl_s5_r0 wbl_op0_n100_rl_s5_r0 wbc_op0_n100_rl_s5_r0 0 swwbl
cwbl_op0_n100_rl_s5_r0 wbl_op0_n100_rl_s5_r0 0 {C_WBL}
spa_op0_n100_rl_s5_r0 prea rbl_op0_n100_rl_s5_r0 ctl_op0_n100_rl_s5_r0 0 swpre
spr_op0_n100_rl_s5_r0 pref ref_op0_n100_rl_s5_r0 ctl_op0_n100_rl_s5_r0 0 swpre
crbl_op0_n100_rl_s5_r0 rbl_op0_n100_rl_s5_r0 0 {C_RBL}
cref_op0_n100_rl_s5_r0 ref_op0_n100_rl_s5_r0 0 {C_RBL}   $ ASSUMPTION: ideal matched dummy load
XMWR_op0_n100_rl_s5_r0_0 sn_op0_n100_rl_s5_r0_0 wwl_op0_n100_rl_s5_r0 wbl_op0_n100_rl_s5_r0 0 sky130_fd_pr__nfet_01v8 L=0.15 W=0.42 nf=1 ad=0.1218 as=0.1218 pd=1.42 ps=1.42 nrd=0.69047619047619  nrs=0.69047619047619 sa=0 sb=0 sd=0 mult=1 m=1
XMRD_op0_n100_rl_s5_r0_0 rbl_op0_n100_rl_s5_r0 sn_op0_n100_rl_s5_r0_0 rwls_op0_n100_rl_s5_r0 0 sky130_fd_pr__nfet_01v8 L=0.15 W=0.42 nf=1 ad=0.1218 as=0.1218 pd=1.42 ps=1.42 nrd=0.69047619047619  nrs=0.69047619047619 sa=0 sb=0 sd=0 mult=1 m=1
csn_op0_n100_rl_s5_r0_0 sn_op0_n100_rl_s5_r0_0 0 {C_SN}
XMWR_op0_n100_rl_s5_r0_1 sn_op0_n100_rl_s5_r0_1 wwl_des wbl_op0_n100_rl_s5_r0 0 sky130_fd_pr__nfet_01v8 L=0.15 W=0.42 nf=1 ad=0.1218 as=0.1218 pd=1.42 ps=1.42 nrd=0.69047619047619  nrs=0.69047619047619 sa=0 sb=0 sd=0 mult=1 m=1
XMRD_op0_n100_rl_s5_r0_1 rbl_op0_n100_rl_s5_r0 sn_op0_n100_rl_s5_r0_1 rwl_des 0 sky130_fd_pr__nfet_01v8 L=0.15 W=0.42 nf=1 ad=0.1218 as=0.1218 pd=1.42 ps=1.42 nrd=0.69047619047619  nrs=0.69047619047619 sa=0 sb=0 sd=0 mult=1 m=1
csn_op0_n100_rl_s5_r0_1 sn_op0_n100_rl_s5_r0_1 0 {C_SN}
XMWR_op0_n100_rl_s5_r0_2 sn_op0_n100_rl_s5_r0_2 wwl_des wbl_op0_n100_rl_s5_r0 0 sky130_fd_pr__nfet_01v8 L=0.15 W=0.42 nf=1 ad=0.1218 as=0.1218 pd=1.42 ps=1.42 nrd=0.69047619047619  nrs=0.69047619047619 sa=0 sb=0 sd=0 mult=1 m=1
XMRD_op0_n100_rl_s5_r0_2 rbl_op0_n100_rl_s5_r0 sn_op0_n100_rl_s5_r0_2 rwl_des 0 sky130_fd_pr__nfet_01v8 L=0.15 W=0.42 nf=1 ad=0.1218 as=0.1218 pd=1.42 ps=1.42 nrd=0.69047619047619  nrs=0.69047619047619 sa=0 sb=0 sd=0 mult=1 m=1
csn_op0_n100_rl_s5_r0_2 sn_op0_n100_rl_s5_r0_2 0 {C_SN}
XMWR_op0_n100_rl_s5_r0_3 sn_op0_n100_rl_s5_r0_3 wwl_des wbl_op0_n100_rl_s5_r0 0 sky130_fd_pr__nfet_01v8 L=0.15 W=0.42 nf=1 ad=0.1218 as=0.1218 pd=1.42 ps=1.42 nrd=0.69047619047619  nrs=0.69047619047619 sa=0 sb=0 sd=0 mult=1 m=1
XMRD_op0_n100_rl_s5_r0_3 rbl_op0_n100_rl_s5_r0 sn_op0_n100_rl_s5_r0_3 rwl_des 0 sky130_fd_pr__nfet_01v8 L=0.15 W=0.42 nf=1 ad=0.1218 as=0.1218 pd=1.42 ps=1.42 nrd=0.69047619047619  nrs=0.69047619047619 sa=0 sb=0 sd=0 mult=1 m=1
csn_op0_n100_rl_s5_r0_3 sn_op0_n100_rl_s5_r0_3 0 {C_SN}
XMN1_op0_n100_rl_s5_r0 rbl_op0_n100_rl_s5_r0 ref_op0_n100_rl_s5_r0 vn_op0_n100_rl_s5_r0 0 sky130_fd_pr__nfet_01v8 L=0.15 W=1 nf=1 ad=0.29 as=0.29 pd=2.58 ps=2.58 mult=1 m=1
XMN2_op0_n100_rl_s5_r0 ref_op0_n100_rl_s5_r0 rbl_op0_n100_rl_s5_r0 vn_op0_n100_rl_s5_r0 0 sky130_fd_pr__nfet_01v8 L=0.15 W=1 nf=1 ad=0.29 as=0.29 pd=2.58 ps=2.58 mult=1 m=1
XMP1_op0_n100_rl_s5_r0 rbl_op0_n100_rl_s5_r0 ref_op0_n100_rl_s5_r0 vp_op0_n100_rl_s5_r0 vdd sky130_fd_pr__pfet_01v8 L=0.15 W=2 nf=1 ad=0.58 as=0.58 pd=4.58 ps=4.58 mult=1 m=1
XMP2_op0_n100_rl_s5_r0 ref_op0_n100_rl_s5_r0 rbl_op0_n100_rl_s5_r0 vp_op0_n100_rl_s5_r0 vdd sky130_fd_pr__pfet_01v8 L=0.15 W=2 nf=1 ad=0.58 as=0.58 pd=4.58 ps=4.58 mult=1 m=1
XMNF_op0_n100_rl_s5_r0 vn_op0_n100_rl_s5_r0 en_op0_n100_rl_s5_r0 0 0 sky130_fd_pr__nfet_01v8 L=0.15 W=2 nf=1 ad=0.58 as=0.58 pd=4.58 ps=4.58 mult=1 m=1
XMPH_op0_n100_rl_s5_r0 vp_op0_n100_rl_s5_r0 enb_op0_n100_rl_s5_r0 vdd vdd sky130_fd_pr__pfet_01v8 L=0.15 W=4 nf=1 ad=1.16 as=1.16 pd=8.58 ps=8.58 mult=1 m=1
bd_op0_n100_rl_s5_r0 d_op0_n100_rl_s5_r0 0 v=v(rbl_op0_n100_rl_s5_r0)-v(ref_op0_n100_rl_s5_r0)

* ---- instance 176: op0_0000_rl_s5_r0 (variant rl_s5_r0; probe dec 11.9 ns, release 34 ns, meas 36 ns) ----
vctl_op0_0000_rl_s5_r0 ctl_op0_0000_rl_s5_r0 0 pwl(0.0000e+00 {VDD} 2.0000e-09 {VDD} 2.1000e-09 0)
* RWL driver model (EXPERIMENTAL): slew 5 ns, series R 0 ohm; cell pin = rwls_op0_0000_rl_s5_r0
vrs_op0_0000_rl_s5_r0 rwls_op0_0000_rl_s5_r0 0 pwl(0.0000e+00 {VDD} 2.0000e-09 {VDD} 7.0000e-09 0 3.4000e-08 0 3.9000e-08 {VDD})
ven_op0_0000_rl_s5_r0 en_op0_0000_rl_s5_r0 0 pwl(0.0000e+00 0 1.1000e-08 0 1.1100e-08 {VDD} 3.4000e-08 {VDD} 3.4100e-08 0)
venb_op0_0000_rl_s5_r0 enb_op0_0000_rl_s5_r0 0 pwl(0.0000e+00 {VDD} 1.1000e-08 {VDD} 1.1100e-08 0 3.4000e-08 0 3.4100e-08 {VDD})
vww_op0_0000_rl_s5_r0 wwl_op0_0000_rl_s5_r0 0 pwl(0.0000e+00 0 1.2000e-08 0 1.2100e-08 {VDD} 3.2000e-08 {VDD} 3.2100e-08 0)
vwc_op0_0000_rl_s5_r0 wbc_op0_0000_rl_s5_r0 0 pwl(0.0000e+00 0 1.2000e-08 0 1.2100e-08 {VDD} 3.4000e-08 {VDD} 3.4100e-08 0)
swb_op0_0000_rl_s5_r0 ref_op0_0000_rl_s5_r0 wbl_op0_0000_rl_s5_r0 wbc_op0_0000_rl_s5_r0 0 swwbl
cwbl_op0_0000_rl_s5_r0 wbl_op0_0000_rl_s5_r0 0 {C_WBL}
spa_op0_0000_rl_s5_r0 prea rbl_op0_0000_rl_s5_r0 ctl_op0_0000_rl_s5_r0 0 swpre
spr_op0_0000_rl_s5_r0 pref ref_op0_0000_rl_s5_r0 ctl_op0_0000_rl_s5_r0 0 swpre
crbl_op0_0000_rl_s5_r0 rbl_op0_0000_rl_s5_r0 0 {C_RBL}
cref_op0_0000_rl_s5_r0 ref_op0_0000_rl_s5_r0 0 {C_RBL}   $ ASSUMPTION: ideal matched dummy load
XMWR_op0_0000_rl_s5_r0_0 sn_op0_0000_rl_s5_r0_0 wwl_op0_0000_rl_s5_r0 wbl_op0_0000_rl_s5_r0 0 sky130_fd_pr__nfet_01v8 L=0.15 W=0.42 nf=1 ad=0.1218 as=0.1218 pd=1.42 ps=1.42 nrd=0.69047619047619  nrs=0.69047619047619 sa=0 sb=0 sd=0 mult=1 m=1
XMRD_op0_0000_rl_s5_r0_0 rbl_op0_0000_rl_s5_r0 sn_op0_0000_rl_s5_r0_0 rwls_op0_0000_rl_s5_r0 0 sky130_fd_pr__nfet_01v8 L=0.15 W=0.42 nf=1 ad=0.1218 as=0.1218 pd=1.42 ps=1.42 nrd=0.69047619047619  nrs=0.69047619047619 sa=0 sb=0 sd=0 mult=1 m=1
csn_op0_0000_rl_s5_r0_0 sn_op0_0000_rl_s5_r0_0 0 {C_SN}
XMWR_op0_0000_rl_s5_r0_1 sn_op0_0000_rl_s5_r0_1 wwl_des wbl_op0_0000_rl_s5_r0 0 sky130_fd_pr__nfet_01v8 L=0.15 W=0.42 nf=1 ad=0.1218 as=0.1218 pd=1.42 ps=1.42 nrd=0.69047619047619  nrs=0.69047619047619 sa=0 sb=0 sd=0 mult=1 m=1
XMRD_op0_0000_rl_s5_r0_1 rbl_op0_0000_rl_s5_r0 sn_op0_0000_rl_s5_r0_1 rwl_des 0 sky130_fd_pr__nfet_01v8 L=0.15 W=0.42 nf=1 ad=0.1218 as=0.1218 pd=1.42 ps=1.42 nrd=0.69047619047619  nrs=0.69047619047619 sa=0 sb=0 sd=0 mult=1 m=1
csn_op0_0000_rl_s5_r0_1 sn_op0_0000_rl_s5_r0_1 0 {C_SN}
XMWR_op0_0000_rl_s5_r0_2 sn_op0_0000_rl_s5_r0_2 wwl_des wbl_op0_0000_rl_s5_r0 0 sky130_fd_pr__nfet_01v8 L=0.15 W=0.42 nf=1 ad=0.1218 as=0.1218 pd=1.42 ps=1.42 nrd=0.69047619047619  nrs=0.69047619047619 sa=0 sb=0 sd=0 mult=1 m=1
XMRD_op0_0000_rl_s5_r0_2 rbl_op0_0000_rl_s5_r0 sn_op0_0000_rl_s5_r0_2 rwl_des 0 sky130_fd_pr__nfet_01v8 L=0.15 W=0.42 nf=1 ad=0.1218 as=0.1218 pd=1.42 ps=1.42 nrd=0.69047619047619  nrs=0.69047619047619 sa=0 sb=0 sd=0 mult=1 m=1
csn_op0_0000_rl_s5_r0_2 sn_op0_0000_rl_s5_r0_2 0 {C_SN}
XMWR_op0_0000_rl_s5_r0_3 sn_op0_0000_rl_s5_r0_3 wwl_des wbl_op0_0000_rl_s5_r0 0 sky130_fd_pr__nfet_01v8 L=0.15 W=0.42 nf=1 ad=0.1218 as=0.1218 pd=1.42 ps=1.42 nrd=0.69047619047619  nrs=0.69047619047619 sa=0 sb=0 sd=0 mult=1 m=1
XMRD_op0_0000_rl_s5_r0_3 rbl_op0_0000_rl_s5_r0 sn_op0_0000_rl_s5_r0_3 rwl_des 0 sky130_fd_pr__nfet_01v8 L=0.15 W=0.42 nf=1 ad=0.1218 as=0.1218 pd=1.42 ps=1.42 nrd=0.69047619047619  nrs=0.69047619047619 sa=0 sb=0 sd=0 mult=1 m=1
csn_op0_0000_rl_s5_r0_3 sn_op0_0000_rl_s5_r0_3 0 {C_SN}
XMN1_op0_0000_rl_s5_r0 rbl_op0_0000_rl_s5_r0 ref_op0_0000_rl_s5_r0 vn_op0_0000_rl_s5_r0 0 sky130_fd_pr__nfet_01v8 L=0.15 W=1 nf=1 ad=0.29 as=0.29 pd=2.58 ps=2.58 mult=1 m=1
XMN2_op0_0000_rl_s5_r0 ref_op0_0000_rl_s5_r0 rbl_op0_0000_rl_s5_r0 vn_op0_0000_rl_s5_r0 0 sky130_fd_pr__nfet_01v8 L=0.15 W=1 nf=1 ad=0.29 as=0.29 pd=2.58 ps=2.58 mult=1 m=1
XMP1_op0_0000_rl_s5_r0 rbl_op0_0000_rl_s5_r0 ref_op0_0000_rl_s5_r0 vp_op0_0000_rl_s5_r0 vdd sky130_fd_pr__pfet_01v8 L=0.15 W=2 nf=1 ad=0.58 as=0.58 pd=4.58 ps=4.58 mult=1 m=1
XMP2_op0_0000_rl_s5_r0 ref_op0_0000_rl_s5_r0 rbl_op0_0000_rl_s5_r0 vp_op0_0000_rl_s5_r0 vdd sky130_fd_pr__pfet_01v8 L=0.15 W=2 nf=1 ad=0.58 as=0.58 pd=4.58 ps=4.58 mult=1 m=1
XMNF_op0_0000_rl_s5_r0 vn_op0_0000_rl_s5_r0 en_op0_0000_rl_s5_r0 0 0 sky130_fd_pr__nfet_01v8 L=0.15 W=2 nf=1 ad=0.58 as=0.58 pd=4.58 ps=4.58 mult=1 m=1
XMPH_op0_0000_rl_s5_r0 vp_op0_0000_rl_s5_r0 enb_op0_0000_rl_s5_r0 vdd vdd sky130_fd_pr__pfet_01v8 L=0.15 W=4 nf=1 ad=1.16 as=1.16 pd=8.58 ps=8.58 mult=1 m=1
bd_op0_0000_rl_s5_r0 d_op0_0000_rl_s5_r0 0 v=v(rbl_op0_0000_rl_s5_r0)-v(ref_op0_0000_rl_s5_r0)

* ---- instance 177: op1_0900_rl_s0p1_r1k (variant rl_s0p1_r1k; probe dec 11.9 ns, release 34 ns, meas 36 ns) ----
vctl_op1_0900_rl_s0p1_r1k ctl_op1_0900_rl_s0p1_r1k 0 pwl(0.0000e+00 {VDD} 2.0000e-09 {VDD} 2.1000e-09 0)
* RWL driver model (EXPERIMENTAL): slew 0.1 ns, series R 1000 ohm; cell pin = rwls_op1_0900_rl_s0p1_r1k
vrs_op1_0900_rl_s0p1_r1k rwlsrc_op1_0900_rl_s0p1_r1k 0 pwl(0.0000e+00 {VDD} 2.0000e-09 {VDD} 2.1000e-09 0 3.4000e-08 0 3.4100e-08 {VDD})
rdrv_op1_0900_rl_s0p1_r1k rwlsrc_op1_0900_rl_s0p1_r1k rwls_op1_0900_rl_s0p1_r1k 1000
ven_op1_0900_rl_s0p1_r1k en_op1_0900_rl_s0p1_r1k 0 pwl(0.0000e+00 0 1.1000e-08 0 1.1100e-08 {VDD} 3.4000e-08 {VDD} 3.4100e-08 0)
venb_op1_0900_rl_s0p1_r1k enb_op1_0900_rl_s0p1_r1k 0 pwl(0.0000e+00 {VDD} 1.1000e-08 {VDD} 1.1100e-08 0 3.4000e-08 0 3.4100e-08 {VDD})
vww_op1_0900_rl_s0p1_r1k wwl_op1_0900_rl_s0p1_r1k 0 pwl(0.0000e+00 0 1.2000e-08 0 1.2100e-08 {VDD} 3.2000e-08 {VDD} 3.2100e-08 0)
vwc_op1_0900_rl_s0p1_r1k wbc_op1_0900_rl_s0p1_r1k 0 pwl(0.0000e+00 0 1.2000e-08 0 1.2100e-08 {VDD} 3.4000e-08 {VDD} 3.4100e-08 0)
swb_op1_0900_rl_s0p1_r1k ref_op1_0900_rl_s0p1_r1k wbl_op1_0900_rl_s0p1_r1k wbc_op1_0900_rl_s0p1_r1k 0 swwbl
cwbl_op1_0900_rl_s0p1_r1k wbl_op1_0900_rl_s0p1_r1k 0 {C_WBL}
spa_op1_0900_rl_s0p1_r1k prea rbl_op1_0900_rl_s0p1_r1k ctl_op1_0900_rl_s0p1_r1k 0 swpre
spr_op1_0900_rl_s0p1_r1k pref ref_op1_0900_rl_s0p1_r1k ctl_op1_0900_rl_s0p1_r1k 0 swpre
crbl_op1_0900_rl_s0p1_r1k rbl_op1_0900_rl_s0p1_r1k 0 {C_RBL}
cref_op1_0900_rl_s0p1_r1k ref_op1_0900_rl_s0p1_r1k 0 {C_RBL}   $ ASSUMPTION: ideal matched dummy load
XMWR_op1_0900_rl_s0p1_r1k_0 sn_op1_0900_rl_s0p1_r1k_0 wwl_op1_0900_rl_s0p1_r1k wbl_op1_0900_rl_s0p1_r1k 0 sky130_fd_pr__nfet_01v8 L=0.15 W=0.42 nf=1 ad=0.1218 as=0.1218 pd=1.42 ps=1.42 nrd=0.69047619047619  nrs=0.69047619047619 sa=0 sb=0 sd=0 mult=1 m=1
XMRD_op1_0900_rl_s0p1_r1k_0 rbl_op1_0900_rl_s0p1_r1k sn_op1_0900_rl_s0p1_r1k_0 rwls_op1_0900_rl_s0p1_r1k 0 sky130_fd_pr__nfet_01v8 L=0.15 W=0.42 nf=1 ad=0.1218 as=0.1218 pd=1.42 ps=1.42 nrd=0.69047619047619  nrs=0.69047619047619 sa=0 sb=0 sd=0 mult=1 m=1
csn_op1_0900_rl_s0p1_r1k_0 sn_op1_0900_rl_s0p1_r1k_0 0 {C_SN}
XMWR_op1_0900_rl_s0p1_r1k_1 sn_op1_0900_rl_s0p1_r1k_1 wwl_des wbl_op1_0900_rl_s0p1_r1k 0 sky130_fd_pr__nfet_01v8 L=0.15 W=0.42 nf=1 ad=0.1218 as=0.1218 pd=1.42 ps=1.42 nrd=0.69047619047619  nrs=0.69047619047619 sa=0 sb=0 sd=0 mult=1 m=1
XMRD_op1_0900_rl_s0p1_r1k_1 rbl_op1_0900_rl_s0p1_r1k sn_op1_0900_rl_s0p1_r1k_1 rwl_des 0 sky130_fd_pr__nfet_01v8 L=0.15 W=0.42 nf=1 ad=0.1218 as=0.1218 pd=1.42 ps=1.42 nrd=0.69047619047619  nrs=0.69047619047619 sa=0 sb=0 sd=0 mult=1 m=1
csn_op1_0900_rl_s0p1_r1k_1 sn_op1_0900_rl_s0p1_r1k_1 0 {C_SN}
XMWR_op1_0900_rl_s0p1_r1k_2 sn_op1_0900_rl_s0p1_r1k_2 wwl_des wbl_op1_0900_rl_s0p1_r1k 0 sky130_fd_pr__nfet_01v8 L=0.15 W=0.42 nf=1 ad=0.1218 as=0.1218 pd=1.42 ps=1.42 nrd=0.69047619047619  nrs=0.69047619047619 sa=0 sb=0 sd=0 mult=1 m=1
XMRD_op1_0900_rl_s0p1_r1k_2 rbl_op1_0900_rl_s0p1_r1k sn_op1_0900_rl_s0p1_r1k_2 rwl_des 0 sky130_fd_pr__nfet_01v8 L=0.15 W=0.42 nf=1 ad=0.1218 as=0.1218 pd=1.42 ps=1.42 nrd=0.69047619047619  nrs=0.69047619047619 sa=0 sb=0 sd=0 mult=1 m=1
csn_op1_0900_rl_s0p1_r1k_2 sn_op1_0900_rl_s0p1_r1k_2 0 {C_SN}
XMWR_op1_0900_rl_s0p1_r1k_3 sn_op1_0900_rl_s0p1_r1k_3 wwl_des wbl_op1_0900_rl_s0p1_r1k 0 sky130_fd_pr__nfet_01v8 L=0.15 W=0.42 nf=1 ad=0.1218 as=0.1218 pd=1.42 ps=1.42 nrd=0.69047619047619  nrs=0.69047619047619 sa=0 sb=0 sd=0 mult=1 m=1
XMRD_op1_0900_rl_s0p1_r1k_3 rbl_op1_0900_rl_s0p1_r1k sn_op1_0900_rl_s0p1_r1k_3 rwl_des 0 sky130_fd_pr__nfet_01v8 L=0.15 W=0.42 nf=1 ad=0.1218 as=0.1218 pd=1.42 ps=1.42 nrd=0.69047619047619  nrs=0.69047619047619 sa=0 sb=0 sd=0 mult=1 m=1
csn_op1_0900_rl_s0p1_r1k_3 sn_op1_0900_rl_s0p1_r1k_3 0 {C_SN}
XMN1_op1_0900_rl_s0p1_r1k rbl_op1_0900_rl_s0p1_r1k ref_op1_0900_rl_s0p1_r1k vn_op1_0900_rl_s0p1_r1k 0 sky130_fd_pr__nfet_01v8 L=0.15 W=1 nf=1 ad=0.29 as=0.29 pd=2.58 ps=2.58 mult=1 m=1
XMN2_op1_0900_rl_s0p1_r1k ref_op1_0900_rl_s0p1_r1k rbl_op1_0900_rl_s0p1_r1k vn_op1_0900_rl_s0p1_r1k 0 sky130_fd_pr__nfet_01v8 L=0.15 W=1 nf=1 ad=0.29 as=0.29 pd=2.58 ps=2.58 mult=1 m=1
XMP1_op1_0900_rl_s0p1_r1k rbl_op1_0900_rl_s0p1_r1k ref_op1_0900_rl_s0p1_r1k vp_op1_0900_rl_s0p1_r1k vdd sky130_fd_pr__pfet_01v8 L=0.15 W=2 nf=1 ad=0.58 as=0.58 pd=4.58 ps=4.58 mult=1 m=1
XMP2_op1_0900_rl_s0p1_r1k ref_op1_0900_rl_s0p1_r1k rbl_op1_0900_rl_s0p1_r1k vp_op1_0900_rl_s0p1_r1k vdd sky130_fd_pr__pfet_01v8 L=0.15 W=2 nf=1 ad=0.58 as=0.58 pd=4.58 ps=4.58 mult=1 m=1
XMNF_op1_0900_rl_s0p1_r1k vn_op1_0900_rl_s0p1_r1k en_op1_0900_rl_s0p1_r1k 0 0 sky130_fd_pr__nfet_01v8 L=0.15 W=2 nf=1 ad=0.58 as=0.58 pd=4.58 ps=4.58 mult=1 m=1
XMPH_op1_0900_rl_s0p1_r1k vp_op1_0900_rl_s0p1_r1k enb_op1_0900_rl_s0p1_r1k vdd vdd sky130_fd_pr__pfet_01v8 L=0.15 W=4 nf=1 ad=1.16 as=1.16 pd=8.58 ps=8.58 mult=1 m=1
bd_op1_0900_rl_s0p1_r1k d_op1_0900_rl_s0p1_r1k 0 v=v(rbl_op1_0900_rl_s0p1_r1k)-v(ref_op1_0900_rl_s0p1_r1k)

* ---- instance 178: op1_1000_rl_s0p1_r1k (variant rl_s0p1_r1k; probe dec 11.9 ns, release 34 ns, meas 36 ns) ----
vctl_op1_1000_rl_s0p1_r1k ctl_op1_1000_rl_s0p1_r1k 0 pwl(0.0000e+00 {VDD} 2.0000e-09 {VDD} 2.1000e-09 0)
* RWL driver model (EXPERIMENTAL): slew 0.1 ns, series R 1000 ohm; cell pin = rwls_op1_1000_rl_s0p1_r1k
vrs_op1_1000_rl_s0p1_r1k rwlsrc_op1_1000_rl_s0p1_r1k 0 pwl(0.0000e+00 {VDD} 2.0000e-09 {VDD} 2.1000e-09 0 3.4000e-08 0 3.4100e-08 {VDD})
rdrv_op1_1000_rl_s0p1_r1k rwlsrc_op1_1000_rl_s0p1_r1k rwls_op1_1000_rl_s0p1_r1k 1000
ven_op1_1000_rl_s0p1_r1k en_op1_1000_rl_s0p1_r1k 0 pwl(0.0000e+00 0 1.1000e-08 0 1.1100e-08 {VDD} 3.4000e-08 {VDD} 3.4100e-08 0)
venb_op1_1000_rl_s0p1_r1k enb_op1_1000_rl_s0p1_r1k 0 pwl(0.0000e+00 {VDD} 1.1000e-08 {VDD} 1.1100e-08 0 3.4000e-08 0 3.4100e-08 {VDD})
vww_op1_1000_rl_s0p1_r1k wwl_op1_1000_rl_s0p1_r1k 0 pwl(0.0000e+00 0 1.2000e-08 0 1.2100e-08 {VDD} 3.2000e-08 {VDD} 3.2100e-08 0)
vwc_op1_1000_rl_s0p1_r1k wbc_op1_1000_rl_s0p1_r1k 0 pwl(0.0000e+00 0 1.2000e-08 0 1.2100e-08 {VDD} 3.4000e-08 {VDD} 3.4100e-08 0)
swb_op1_1000_rl_s0p1_r1k ref_op1_1000_rl_s0p1_r1k wbl_op1_1000_rl_s0p1_r1k wbc_op1_1000_rl_s0p1_r1k 0 swwbl
cwbl_op1_1000_rl_s0p1_r1k wbl_op1_1000_rl_s0p1_r1k 0 {C_WBL}
spa_op1_1000_rl_s0p1_r1k prea rbl_op1_1000_rl_s0p1_r1k ctl_op1_1000_rl_s0p1_r1k 0 swpre
spr_op1_1000_rl_s0p1_r1k pref ref_op1_1000_rl_s0p1_r1k ctl_op1_1000_rl_s0p1_r1k 0 swpre
crbl_op1_1000_rl_s0p1_r1k rbl_op1_1000_rl_s0p1_r1k 0 {C_RBL}
cref_op1_1000_rl_s0p1_r1k ref_op1_1000_rl_s0p1_r1k 0 {C_RBL}   $ ASSUMPTION: ideal matched dummy load
XMWR_op1_1000_rl_s0p1_r1k_0 sn_op1_1000_rl_s0p1_r1k_0 wwl_op1_1000_rl_s0p1_r1k wbl_op1_1000_rl_s0p1_r1k 0 sky130_fd_pr__nfet_01v8 L=0.15 W=0.42 nf=1 ad=0.1218 as=0.1218 pd=1.42 ps=1.42 nrd=0.69047619047619  nrs=0.69047619047619 sa=0 sb=0 sd=0 mult=1 m=1
XMRD_op1_1000_rl_s0p1_r1k_0 rbl_op1_1000_rl_s0p1_r1k sn_op1_1000_rl_s0p1_r1k_0 rwls_op1_1000_rl_s0p1_r1k 0 sky130_fd_pr__nfet_01v8 L=0.15 W=0.42 nf=1 ad=0.1218 as=0.1218 pd=1.42 ps=1.42 nrd=0.69047619047619  nrs=0.69047619047619 sa=0 sb=0 sd=0 mult=1 m=1
csn_op1_1000_rl_s0p1_r1k_0 sn_op1_1000_rl_s0p1_r1k_0 0 {C_SN}
XMWR_op1_1000_rl_s0p1_r1k_1 sn_op1_1000_rl_s0p1_r1k_1 wwl_des wbl_op1_1000_rl_s0p1_r1k 0 sky130_fd_pr__nfet_01v8 L=0.15 W=0.42 nf=1 ad=0.1218 as=0.1218 pd=1.42 ps=1.42 nrd=0.69047619047619  nrs=0.69047619047619 sa=0 sb=0 sd=0 mult=1 m=1
XMRD_op1_1000_rl_s0p1_r1k_1 rbl_op1_1000_rl_s0p1_r1k sn_op1_1000_rl_s0p1_r1k_1 rwl_des 0 sky130_fd_pr__nfet_01v8 L=0.15 W=0.42 nf=1 ad=0.1218 as=0.1218 pd=1.42 ps=1.42 nrd=0.69047619047619  nrs=0.69047619047619 sa=0 sb=0 sd=0 mult=1 m=1
csn_op1_1000_rl_s0p1_r1k_1 sn_op1_1000_rl_s0p1_r1k_1 0 {C_SN}
XMWR_op1_1000_rl_s0p1_r1k_2 sn_op1_1000_rl_s0p1_r1k_2 wwl_des wbl_op1_1000_rl_s0p1_r1k 0 sky130_fd_pr__nfet_01v8 L=0.15 W=0.42 nf=1 ad=0.1218 as=0.1218 pd=1.42 ps=1.42 nrd=0.69047619047619  nrs=0.69047619047619 sa=0 sb=0 sd=0 mult=1 m=1
XMRD_op1_1000_rl_s0p1_r1k_2 rbl_op1_1000_rl_s0p1_r1k sn_op1_1000_rl_s0p1_r1k_2 rwl_des 0 sky130_fd_pr__nfet_01v8 L=0.15 W=0.42 nf=1 ad=0.1218 as=0.1218 pd=1.42 ps=1.42 nrd=0.69047619047619  nrs=0.69047619047619 sa=0 sb=0 sd=0 mult=1 m=1
csn_op1_1000_rl_s0p1_r1k_2 sn_op1_1000_rl_s0p1_r1k_2 0 {C_SN}
XMWR_op1_1000_rl_s0p1_r1k_3 sn_op1_1000_rl_s0p1_r1k_3 wwl_des wbl_op1_1000_rl_s0p1_r1k 0 sky130_fd_pr__nfet_01v8 L=0.15 W=0.42 nf=1 ad=0.1218 as=0.1218 pd=1.42 ps=1.42 nrd=0.69047619047619  nrs=0.69047619047619 sa=0 sb=0 sd=0 mult=1 m=1
XMRD_op1_1000_rl_s0p1_r1k_3 rbl_op1_1000_rl_s0p1_r1k sn_op1_1000_rl_s0p1_r1k_3 rwl_des 0 sky130_fd_pr__nfet_01v8 L=0.15 W=0.42 nf=1 ad=0.1218 as=0.1218 pd=1.42 ps=1.42 nrd=0.69047619047619  nrs=0.69047619047619 sa=0 sb=0 sd=0 mult=1 m=1
csn_op1_1000_rl_s0p1_r1k_3 sn_op1_1000_rl_s0p1_r1k_3 0 {C_SN}
XMN1_op1_1000_rl_s0p1_r1k rbl_op1_1000_rl_s0p1_r1k ref_op1_1000_rl_s0p1_r1k vn_op1_1000_rl_s0p1_r1k 0 sky130_fd_pr__nfet_01v8 L=0.15 W=1 nf=1 ad=0.29 as=0.29 pd=2.58 ps=2.58 mult=1 m=1
XMN2_op1_1000_rl_s0p1_r1k ref_op1_1000_rl_s0p1_r1k rbl_op1_1000_rl_s0p1_r1k vn_op1_1000_rl_s0p1_r1k 0 sky130_fd_pr__nfet_01v8 L=0.15 W=1 nf=1 ad=0.29 as=0.29 pd=2.58 ps=2.58 mult=1 m=1
XMP1_op1_1000_rl_s0p1_r1k rbl_op1_1000_rl_s0p1_r1k ref_op1_1000_rl_s0p1_r1k vp_op1_1000_rl_s0p1_r1k vdd sky130_fd_pr__pfet_01v8 L=0.15 W=2 nf=1 ad=0.58 as=0.58 pd=4.58 ps=4.58 mult=1 m=1
XMP2_op1_1000_rl_s0p1_r1k ref_op1_1000_rl_s0p1_r1k rbl_op1_1000_rl_s0p1_r1k vp_op1_1000_rl_s0p1_r1k vdd sky130_fd_pr__pfet_01v8 L=0.15 W=2 nf=1 ad=0.58 as=0.58 pd=4.58 ps=4.58 mult=1 m=1
XMNF_op1_1000_rl_s0p1_r1k vn_op1_1000_rl_s0p1_r1k en_op1_1000_rl_s0p1_r1k 0 0 sky130_fd_pr__nfet_01v8 L=0.15 W=2 nf=1 ad=0.58 as=0.58 pd=4.58 ps=4.58 mult=1 m=1
XMPH_op1_1000_rl_s0p1_r1k vp_op1_1000_rl_s0p1_r1k enb_op1_1000_rl_s0p1_r1k vdd vdd sky130_fd_pr__pfet_01v8 L=0.15 W=4 nf=1 ad=1.16 as=1.16 pd=8.58 ps=8.58 mult=1 m=1
bd_op1_1000_rl_s0p1_r1k d_op1_1000_rl_s0p1_r1k 0 v=v(rbl_op1_1000_rl_s0p1_r1k)-v(ref_op1_1000_rl_s0p1_r1k)

* ---- instance 179: op0_n100_rl_s0p1_r1k (variant rl_s0p1_r1k; probe dec 11.9 ns, release 34 ns, meas 36 ns) ----
vctl_op0_n100_rl_s0p1_r1k ctl_op0_n100_rl_s0p1_r1k 0 pwl(0.0000e+00 {VDD} 2.0000e-09 {VDD} 2.1000e-09 0)
* RWL driver model (EXPERIMENTAL): slew 0.1 ns, series R 1000 ohm; cell pin = rwls_op0_n100_rl_s0p1_r1k
vrs_op0_n100_rl_s0p1_r1k rwlsrc_op0_n100_rl_s0p1_r1k 0 pwl(0.0000e+00 {VDD} 2.0000e-09 {VDD} 2.1000e-09 0 3.4000e-08 0 3.4100e-08 {VDD})
rdrv_op0_n100_rl_s0p1_r1k rwlsrc_op0_n100_rl_s0p1_r1k rwls_op0_n100_rl_s0p1_r1k 1000
ven_op0_n100_rl_s0p1_r1k en_op0_n100_rl_s0p1_r1k 0 pwl(0.0000e+00 0 1.1000e-08 0 1.1100e-08 {VDD} 3.4000e-08 {VDD} 3.4100e-08 0)
venb_op0_n100_rl_s0p1_r1k enb_op0_n100_rl_s0p1_r1k 0 pwl(0.0000e+00 {VDD} 1.1000e-08 {VDD} 1.1100e-08 0 3.4000e-08 0 3.4100e-08 {VDD})
vww_op0_n100_rl_s0p1_r1k wwl_op0_n100_rl_s0p1_r1k 0 pwl(0.0000e+00 0 1.2000e-08 0 1.2100e-08 {VDD} 3.2000e-08 {VDD} 3.2100e-08 0)
vwc_op0_n100_rl_s0p1_r1k wbc_op0_n100_rl_s0p1_r1k 0 pwl(0.0000e+00 0 1.2000e-08 0 1.2100e-08 {VDD} 3.4000e-08 {VDD} 3.4100e-08 0)
swb_op0_n100_rl_s0p1_r1k ref_op0_n100_rl_s0p1_r1k wbl_op0_n100_rl_s0p1_r1k wbc_op0_n100_rl_s0p1_r1k 0 swwbl
cwbl_op0_n100_rl_s0p1_r1k wbl_op0_n100_rl_s0p1_r1k 0 {C_WBL}
spa_op0_n100_rl_s0p1_r1k prea rbl_op0_n100_rl_s0p1_r1k ctl_op0_n100_rl_s0p1_r1k 0 swpre
spr_op0_n100_rl_s0p1_r1k pref ref_op0_n100_rl_s0p1_r1k ctl_op0_n100_rl_s0p1_r1k 0 swpre
crbl_op0_n100_rl_s0p1_r1k rbl_op0_n100_rl_s0p1_r1k 0 {C_RBL}
cref_op0_n100_rl_s0p1_r1k ref_op0_n100_rl_s0p1_r1k 0 {C_RBL}   $ ASSUMPTION: ideal matched dummy load
XMWR_op0_n100_rl_s0p1_r1k_0 sn_op0_n100_rl_s0p1_r1k_0 wwl_op0_n100_rl_s0p1_r1k wbl_op0_n100_rl_s0p1_r1k 0 sky130_fd_pr__nfet_01v8 L=0.15 W=0.42 nf=1 ad=0.1218 as=0.1218 pd=1.42 ps=1.42 nrd=0.69047619047619  nrs=0.69047619047619 sa=0 sb=0 sd=0 mult=1 m=1
XMRD_op0_n100_rl_s0p1_r1k_0 rbl_op0_n100_rl_s0p1_r1k sn_op0_n100_rl_s0p1_r1k_0 rwls_op0_n100_rl_s0p1_r1k 0 sky130_fd_pr__nfet_01v8 L=0.15 W=0.42 nf=1 ad=0.1218 as=0.1218 pd=1.42 ps=1.42 nrd=0.69047619047619  nrs=0.69047619047619 sa=0 sb=0 sd=0 mult=1 m=1
csn_op0_n100_rl_s0p1_r1k_0 sn_op0_n100_rl_s0p1_r1k_0 0 {C_SN}
XMWR_op0_n100_rl_s0p1_r1k_1 sn_op0_n100_rl_s0p1_r1k_1 wwl_des wbl_op0_n100_rl_s0p1_r1k 0 sky130_fd_pr__nfet_01v8 L=0.15 W=0.42 nf=1 ad=0.1218 as=0.1218 pd=1.42 ps=1.42 nrd=0.69047619047619  nrs=0.69047619047619 sa=0 sb=0 sd=0 mult=1 m=1
XMRD_op0_n100_rl_s0p1_r1k_1 rbl_op0_n100_rl_s0p1_r1k sn_op0_n100_rl_s0p1_r1k_1 rwl_des 0 sky130_fd_pr__nfet_01v8 L=0.15 W=0.42 nf=1 ad=0.1218 as=0.1218 pd=1.42 ps=1.42 nrd=0.69047619047619  nrs=0.69047619047619 sa=0 sb=0 sd=0 mult=1 m=1
csn_op0_n100_rl_s0p1_r1k_1 sn_op0_n100_rl_s0p1_r1k_1 0 {C_SN}
XMWR_op0_n100_rl_s0p1_r1k_2 sn_op0_n100_rl_s0p1_r1k_2 wwl_des wbl_op0_n100_rl_s0p1_r1k 0 sky130_fd_pr__nfet_01v8 L=0.15 W=0.42 nf=1 ad=0.1218 as=0.1218 pd=1.42 ps=1.42 nrd=0.69047619047619  nrs=0.69047619047619 sa=0 sb=0 sd=0 mult=1 m=1
XMRD_op0_n100_rl_s0p1_r1k_2 rbl_op0_n100_rl_s0p1_r1k sn_op0_n100_rl_s0p1_r1k_2 rwl_des 0 sky130_fd_pr__nfet_01v8 L=0.15 W=0.42 nf=1 ad=0.1218 as=0.1218 pd=1.42 ps=1.42 nrd=0.69047619047619  nrs=0.69047619047619 sa=0 sb=0 sd=0 mult=1 m=1
csn_op0_n100_rl_s0p1_r1k_2 sn_op0_n100_rl_s0p1_r1k_2 0 {C_SN}
XMWR_op0_n100_rl_s0p1_r1k_3 sn_op0_n100_rl_s0p1_r1k_3 wwl_des wbl_op0_n100_rl_s0p1_r1k 0 sky130_fd_pr__nfet_01v8 L=0.15 W=0.42 nf=1 ad=0.1218 as=0.1218 pd=1.42 ps=1.42 nrd=0.69047619047619  nrs=0.69047619047619 sa=0 sb=0 sd=0 mult=1 m=1
XMRD_op0_n100_rl_s0p1_r1k_3 rbl_op0_n100_rl_s0p1_r1k sn_op0_n100_rl_s0p1_r1k_3 rwl_des 0 sky130_fd_pr__nfet_01v8 L=0.15 W=0.42 nf=1 ad=0.1218 as=0.1218 pd=1.42 ps=1.42 nrd=0.69047619047619  nrs=0.69047619047619 sa=0 sb=0 sd=0 mult=1 m=1
csn_op0_n100_rl_s0p1_r1k_3 sn_op0_n100_rl_s0p1_r1k_3 0 {C_SN}
XMN1_op0_n100_rl_s0p1_r1k rbl_op0_n100_rl_s0p1_r1k ref_op0_n100_rl_s0p1_r1k vn_op0_n100_rl_s0p1_r1k 0 sky130_fd_pr__nfet_01v8 L=0.15 W=1 nf=1 ad=0.29 as=0.29 pd=2.58 ps=2.58 mult=1 m=1
XMN2_op0_n100_rl_s0p1_r1k ref_op0_n100_rl_s0p1_r1k rbl_op0_n100_rl_s0p1_r1k vn_op0_n100_rl_s0p1_r1k 0 sky130_fd_pr__nfet_01v8 L=0.15 W=1 nf=1 ad=0.29 as=0.29 pd=2.58 ps=2.58 mult=1 m=1
XMP1_op0_n100_rl_s0p1_r1k rbl_op0_n100_rl_s0p1_r1k ref_op0_n100_rl_s0p1_r1k vp_op0_n100_rl_s0p1_r1k vdd sky130_fd_pr__pfet_01v8 L=0.15 W=2 nf=1 ad=0.58 as=0.58 pd=4.58 ps=4.58 mult=1 m=1
XMP2_op0_n100_rl_s0p1_r1k ref_op0_n100_rl_s0p1_r1k rbl_op0_n100_rl_s0p1_r1k vp_op0_n100_rl_s0p1_r1k vdd sky130_fd_pr__pfet_01v8 L=0.15 W=2 nf=1 ad=0.58 as=0.58 pd=4.58 ps=4.58 mult=1 m=1
XMNF_op0_n100_rl_s0p1_r1k vn_op0_n100_rl_s0p1_r1k en_op0_n100_rl_s0p1_r1k 0 0 sky130_fd_pr__nfet_01v8 L=0.15 W=2 nf=1 ad=0.58 as=0.58 pd=4.58 ps=4.58 mult=1 m=1
XMPH_op0_n100_rl_s0p1_r1k vp_op0_n100_rl_s0p1_r1k enb_op0_n100_rl_s0p1_r1k vdd vdd sky130_fd_pr__pfet_01v8 L=0.15 W=4 nf=1 ad=1.16 as=1.16 pd=8.58 ps=8.58 mult=1 m=1
bd_op0_n100_rl_s0p1_r1k d_op0_n100_rl_s0p1_r1k 0 v=v(rbl_op0_n100_rl_s0p1_r1k)-v(ref_op0_n100_rl_s0p1_r1k)

* ---- instance 180: op0_0000_rl_s0p1_r1k (variant rl_s0p1_r1k; probe dec 11.9 ns, release 34 ns, meas 36 ns) ----
vctl_op0_0000_rl_s0p1_r1k ctl_op0_0000_rl_s0p1_r1k 0 pwl(0.0000e+00 {VDD} 2.0000e-09 {VDD} 2.1000e-09 0)
* RWL driver model (EXPERIMENTAL): slew 0.1 ns, series R 1000 ohm; cell pin = rwls_op0_0000_rl_s0p1_r1k
vrs_op0_0000_rl_s0p1_r1k rwlsrc_op0_0000_rl_s0p1_r1k 0 pwl(0.0000e+00 {VDD} 2.0000e-09 {VDD} 2.1000e-09 0 3.4000e-08 0 3.4100e-08 {VDD})
rdrv_op0_0000_rl_s0p1_r1k rwlsrc_op0_0000_rl_s0p1_r1k rwls_op0_0000_rl_s0p1_r1k 1000
ven_op0_0000_rl_s0p1_r1k en_op0_0000_rl_s0p1_r1k 0 pwl(0.0000e+00 0 1.1000e-08 0 1.1100e-08 {VDD} 3.4000e-08 {VDD} 3.4100e-08 0)
venb_op0_0000_rl_s0p1_r1k enb_op0_0000_rl_s0p1_r1k 0 pwl(0.0000e+00 {VDD} 1.1000e-08 {VDD} 1.1100e-08 0 3.4000e-08 0 3.4100e-08 {VDD})
vww_op0_0000_rl_s0p1_r1k wwl_op0_0000_rl_s0p1_r1k 0 pwl(0.0000e+00 0 1.2000e-08 0 1.2100e-08 {VDD} 3.2000e-08 {VDD} 3.2100e-08 0)
vwc_op0_0000_rl_s0p1_r1k wbc_op0_0000_rl_s0p1_r1k 0 pwl(0.0000e+00 0 1.2000e-08 0 1.2100e-08 {VDD} 3.4000e-08 {VDD} 3.4100e-08 0)
swb_op0_0000_rl_s0p1_r1k ref_op0_0000_rl_s0p1_r1k wbl_op0_0000_rl_s0p1_r1k wbc_op0_0000_rl_s0p1_r1k 0 swwbl
cwbl_op0_0000_rl_s0p1_r1k wbl_op0_0000_rl_s0p1_r1k 0 {C_WBL}
spa_op0_0000_rl_s0p1_r1k prea rbl_op0_0000_rl_s0p1_r1k ctl_op0_0000_rl_s0p1_r1k 0 swpre
spr_op0_0000_rl_s0p1_r1k pref ref_op0_0000_rl_s0p1_r1k ctl_op0_0000_rl_s0p1_r1k 0 swpre
crbl_op0_0000_rl_s0p1_r1k rbl_op0_0000_rl_s0p1_r1k 0 {C_RBL}
cref_op0_0000_rl_s0p1_r1k ref_op0_0000_rl_s0p1_r1k 0 {C_RBL}   $ ASSUMPTION: ideal matched dummy load
XMWR_op0_0000_rl_s0p1_r1k_0 sn_op0_0000_rl_s0p1_r1k_0 wwl_op0_0000_rl_s0p1_r1k wbl_op0_0000_rl_s0p1_r1k 0 sky130_fd_pr__nfet_01v8 L=0.15 W=0.42 nf=1 ad=0.1218 as=0.1218 pd=1.42 ps=1.42 nrd=0.69047619047619  nrs=0.69047619047619 sa=0 sb=0 sd=0 mult=1 m=1
XMRD_op0_0000_rl_s0p1_r1k_0 rbl_op0_0000_rl_s0p1_r1k sn_op0_0000_rl_s0p1_r1k_0 rwls_op0_0000_rl_s0p1_r1k 0 sky130_fd_pr__nfet_01v8 L=0.15 W=0.42 nf=1 ad=0.1218 as=0.1218 pd=1.42 ps=1.42 nrd=0.69047619047619  nrs=0.69047619047619 sa=0 sb=0 sd=0 mult=1 m=1
csn_op0_0000_rl_s0p1_r1k_0 sn_op0_0000_rl_s0p1_r1k_0 0 {C_SN}
XMWR_op0_0000_rl_s0p1_r1k_1 sn_op0_0000_rl_s0p1_r1k_1 wwl_des wbl_op0_0000_rl_s0p1_r1k 0 sky130_fd_pr__nfet_01v8 L=0.15 W=0.42 nf=1 ad=0.1218 as=0.1218 pd=1.42 ps=1.42 nrd=0.69047619047619  nrs=0.69047619047619 sa=0 sb=0 sd=0 mult=1 m=1
XMRD_op0_0000_rl_s0p1_r1k_1 rbl_op0_0000_rl_s0p1_r1k sn_op0_0000_rl_s0p1_r1k_1 rwl_des 0 sky130_fd_pr__nfet_01v8 L=0.15 W=0.42 nf=1 ad=0.1218 as=0.1218 pd=1.42 ps=1.42 nrd=0.69047619047619  nrs=0.69047619047619 sa=0 sb=0 sd=0 mult=1 m=1
csn_op0_0000_rl_s0p1_r1k_1 sn_op0_0000_rl_s0p1_r1k_1 0 {C_SN}
XMWR_op0_0000_rl_s0p1_r1k_2 sn_op0_0000_rl_s0p1_r1k_2 wwl_des wbl_op0_0000_rl_s0p1_r1k 0 sky130_fd_pr__nfet_01v8 L=0.15 W=0.42 nf=1 ad=0.1218 as=0.1218 pd=1.42 ps=1.42 nrd=0.69047619047619  nrs=0.69047619047619 sa=0 sb=0 sd=0 mult=1 m=1
XMRD_op0_0000_rl_s0p1_r1k_2 rbl_op0_0000_rl_s0p1_r1k sn_op0_0000_rl_s0p1_r1k_2 rwl_des 0 sky130_fd_pr__nfet_01v8 L=0.15 W=0.42 nf=1 ad=0.1218 as=0.1218 pd=1.42 ps=1.42 nrd=0.69047619047619  nrs=0.69047619047619 sa=0 sb=0 sd=0 mult=1 m=1
csn_op0_0000_rl_s0p1_r1k_2 sn_op0_0000_rl_s0p1_r1k_2 0 {C_SN}
XMWR_op0_0000_rl_s0p1_r1k_3 sn_op0_0000_rl_s0p1_r1k_3 wwl_des wbl_op0_0000_rl_s0p1_r1k 0 sky130_fd_pr__nfet_01v8 L=0.15 W=0.42 nf=1 ad=0.1218 as=0.1218 pd=1.42 ps=1.42 nrd=0.69047619047619  nrs=0.69047619047619 sa=0 sb=0 sd=0 mult=1 m=1
XMRD_op0_0000_rl_s0p1_r1k_3 rbl_op0_0000_rl_s0p1_r1k sn_op0_0000_rl_s0p1_r1k_3 rwl_des 0 sky130_fd_pr__nfet_01v8 L=0.15 W=0.42 nf=1 ad=0.1218 as=0.1218 pd=1.42 ps=1.42 nrd=0.69047619047619  nrs=0.69047619047619 sa=0 sb=0 sd=0 mult=1 m=1
csn_op0_0000_rl_s0p1_r1k_3 sn_op0_0000_rl_s0p1_r1k_3 0 {C_SN}
XMN1_op0_0000_rl_s0p1_r1k rbl_op0_0000_rl_s0p1_r1k ref_op0_0000_rl_s0p1_r1k vn_op0_0000_rl_s0p1_r1k 0 sky130_fd_pr__nfet_01v8 L=0.15 W=1 nf=1 ad=0.29 as=0.29 pd=2.58 ps=2.58 mult=1 m=1
XMN2_op0_0000_rl_s0p1_r1k ref_op0_0000_rl_s0p1_r1k rbl_op0_0000_rl_s0p1_r1k vn_op0_0000_rl_s0p1_r1k 0 sky130_fd_pr__nfet_01v8 L=0.15 W=1 nf=1 ad=0.29 as=0.29 pd=2.58 ps=2.58 mult=1 m=1
XMP1_op0_0000_rl_s0p1_r1k rbl_op0_0000_rl_s0p1_r1k ref_op0_0000_rl_s0p1_r1k vp_op0_0000_rl_s0p1_r1k vdd sky130_fd_pr__pfet_01v8 L=0.15 W=2 nf=1 ad=0.58 as=0.58 pd=4.58 ps=4.58 mult=1 m=1
XMP2_op0_0000_rl_s0p1_r1k ref_op0_0000_rl_s0p1_r1k rbl_op0_0000_rl_s0p1_r1k vp_op0_0000_rl_s0p1_r1k vdd sky130_fd_pr__pfet_01v8 L=0.15 W=2 nf=1 ad=0.58 as=0.58 pd=4.58 ps=4.58 mult=1 m=1
XMNF_op0_0000_rl_s0p1_r1k vn_op0_0000_rl_s0p1_r1k en_op0_0000_rl_s0p1_r1k 0 0 sky130_fd_pr__nfet_01v8 L=0.15 W=2 nf=1 ad=0.58 as=0.58 pd=4.58 ps=4.58 mult=1 m=1
XMPH_op0_0000_rl_s0p1_r1k vp_op0_0000_rl_s0p1_r1k enb_op0_0000_rl_s0p1_r1k vdd vdd sky130_fd_pr__pfet_01v8 L=0.15 W=4 nf=1 ad=1.16 as=1.16 pd=8.58 ps=8.58 mult=1 m=1
bd_op0_0000_rl_s0p1_r1k d_op0_0000_rl_s0p1_r1k 0 v=v(rbl_op0_0000_rl_s0p1_r1k)-v(ref_op0_0000_rl_s0p1_r1k)

* ---- instance 181: op1_0900_rl_s0p1_r3k (variant rl_s0p1_r3k; probe dec 11.9 ns, release 34 ns, meas 36 ns) ----
vctl_op1_0900_rl_s0p1_r3k ctl_op1_0900_rl_s0p1_r3k 0 pwl(0.0000e+00 {VDD} 2.0000e-09 {VDD} 2.1000e-09 0)
* RWL driver model (EXPERIMENTAL): slew 0.1 ns, series R 3000 ohm; cell pin = rwls_op1_0900_rl_s0p1_r3k
vrs_op1_0900_rl_s0p1_r3k rwlsrc_op1_0900_rl_s0p1_r3k 0 pwl(0.0000e+00 {VDD} 2.0000e-09 {VDD} 2.1000e-09 0 3.4000e-08 0 3.4100e-08 {VDD})
rdrv_op1_0900_rl_s0p1_r3k rwlsrc_op1_0900_rl_s0p1_r3k rwls_op1_0900_rl_s0p1_r3k 3000
ven_op1_0900_rl_s0p1_r3k en_op1_0900_rl_s0p1_r3k 0 pwl(0.0000e+00 0 1.1000e-08 0 1.1100e-08 {VDD} 3.4000e-08 {VDD} 3.4100e-08 0)
venb_op1_0900_rl_s0p1_r3k enb_op1_0900_rl_s0p1_r3k 0 pwl(0.0000e+00 {VDD} 1.1000e-08 {VDD} 1.1100e-08 0 3.4000e-08 0 3.4100e-08 {VDD})
vww_op1_0900_rl_s0p1_r3k wwl_op1_0900_rl_s0p1_r3k 0 pwl(0.0000e+00 0 1.2000e-08 0 1.2100e-08 {VDD} 3.2000e-08 {VDD} 3.2100e-08 0)
vwc_op1_0900_rl_s0p1_r3k wbc_op1_0900_rl_s0p1_r3k 0 pwl(0.0000e+00 0 1.2000e-08 0 1.2100e-08 {VDD} 3.4000e-08 {VDD} 3.4100e-08 0)
swb_op1_0900_rl_s0p1_r3k ref_op1_0900_rl_s0p1_r3k wbl_op1_0900_rl_s0p1_r3k wbc_op1_0900_rl_s0p1_r3k 0 swwbl
cwbl_op1_0900_rl_s0p1_r3k wbl_op1_0900_rl_s0p1_r3k 0 {C_WBL}
spa_op1_0900_rl_s0p1_r3k prea rbl_op1_0900_rl_s0p1_r3k ctl_op1_0900_rl_s0p1_r3k 0 swpre
spr_op1_0900_rl_s0p1_r3k pref ref_op1_0900_rl_s0p1_r3k ctl_op1_0900_rl_s0p1_r3k 0 swpre
crbl_op1_0900_rl_s0p1_r3k rbl_op1_0900_rl_s0p1_r3k 0 {C_RBL}
cref_op1_0900_rl_s0p1_r3k ref_op1_0900_rl_s0p1_r3k 0 {C_RBL}   $ ASSUMPTION: ideal matched dummy load
XMWR_op1_0900_rl_s0p1_r3k_0 sn_op1_0900_rl_s0p1_r3k_0 wwl_op1_0900_rl_s0p1_r3k wbl_op1_0900_rl_s0p1_r3k 0 sky130_fd_pr__nfet_01v8 L=0.15 W=0.42 nf=1 ad=0.1218 as=0.1218 pd=1.42 ps=1.42 nrd=0.69047619047619  nrs=0.69047619047619 sa=0 sb=0 sd=0 mult=1 m=1
XMRD_op1_0900_rl_s0p1_r3k_0 rbl_op1_0900_rl_s0p1_r3k sn_op1_0900_rl_s0p1_r3k_0 rwls_op1_0900_rl_s0p1_r3k 0 sky130_fd_pr__nfet_01v8 L=0.15 W=0.42 nf=1 ad=0.1218 as=0.1218 pd=1.42 ps=1.42 nrd=0.69047619047619  nrs=0.69047619047619 sa=0 sb=0 sd=0 mult=1 m=1
csn_op1_0900_rl_s0p1_r3k_0 sn_op1_0900_rl_s0p1_r3k_0 0 {C_SN}
XMWR_op1_0900_rl_s0p1_r3k_1 sn_op1_0900_rl_s0p1_r3k_1 wwl_des wbl_op1_0900_rl_s0p1_r3k 0 sky130_fd_pr__nfet_01v8 L=0.15 W=0.42 nf=1 ad=0.1218 as=0.1218 pd=1.42 ps=1.42 nrd=0.69047619047619  nrs=0.69047619047619 sa=0 sb=0 sd=0 mult=1 m=1
XMRD_op1_0900_rl_s0p1_r3k_1 rbl_op1_0900_rl_s0p1_r3k sn_op1_0900_rl_s0p1_r3k_1 rwl_des 0 sky130_fd_pr__nfet_01v8 L=0.15 W=0.42 nf=1 ad=0.1218 as=0.1218 pd=1.42 ps=1.42 nrd=0.69047619047619  nrs=0.69047619047619 sa=0 sb=0 sd=0 mult=1 m=1
csn_op1_0900_rl_s0p1_r3k_1 sn_op1_0900_rl_s0p1_r3k_1 0 {C_SN}
XMWR_op1_0900_rl_s0p1_r3k_2 sn_op1_0900_rl_s0p1_r3k_2 wwl_des wbl_op1_0900_rl_s0p1_r3k 0 sky130_fd_pr__nfet_01v8 L=0.15 W=0.42 nf=1 ad=0.1218 as=0.1218 pd=1.42 ps=1.42 nrd=0.69047619047619  nrs=0.69047619047619 sa=0 sb=0 sd=0 mult=1 m=1
XMRD_op1_0900_rl_s0p1_r3k_2 rbl_op1_0900_rl_s0p1_r3k sn_op1_0900_rl_s0p1_r3k_2 rwl_des 0 sky130_fd_pr__nfet_01v8 L=0.15 W=0.42 nf=1 ad=0.1218 as=0.1218 pd=1.42 ps=1.42 nrd=0.69047619047619  nrs=0.69047619047619 sa=0 sb=0 sd=0 mult=1 m=1
csn_op1_0900_rl_s0p1_r3k_2 sn_op1_0900_rl_s0p1_r3k_2 0 {C_SN}
XMWR_op1_0900_rl_s0p1_r3k_3 sn_op1_0900_rl_s0p1_r3k_3 wwl_des wbl_op1_0900_rl_s0p1_r3k 0 sky130_fd_pr__nfet_01v8 L=0.15 W=0.42 nf=1 ad=0.1218 as=0.1218 pd=1.42 ps=1.42 nrd=0.69047619047619  nrs=0.69047619047619 sa=0 sb=0 sd=0 mult=1 m=1
XMRD_op1_0900_rl_s0p1_r3k_3 rbl_op1_0900_rl_s0p1_r3k sn_op1_0900_rl_s0p1_r3k_3 rwl_des 0 sky130_fd_pr__nfet_01v8 L=0.15 W=0.42 nf=1 ad=0.1218 as=0.1218 pd=1.42 ps=1.42 nrd=0.69047619047619  nrs=0.69047619047619 sa=0 sb=0 sd=0 mult=1 m=1
csn_op1_0900_rl_s0p1_r3k_3 sn_op1_0900_rl_s0p1_r3k_3 0 {C_SN}
XMN1_op1_0900_rl_s0p1_r3k rbl_op1_0900_rl_s0p1_r3k ref_op1_0900_rl_s0p1_r3k vn_op1_0900_rl_s0p1_r3k 0 sky130_fd_pr__nfet_01v8 L=0.15 W=1 nf=1 ad=0.29 as=0.29 pd=2.58 ps=2.58 mult=1 m=1
XMN2_op1_0900_rl_s0p1_r3k ref_op1_0900_rl_s0p1_r3k rbl_op1_0900_rl_s0p1_r3k vn_op1_0900_rl_s0p1_r3k 0 sky130_fd_pr__nfet_01v8 L=0.15 W=1 nf=1 ad=0.29 as=0.29 pd=2.58 ps=2.58 mult=1 m=1
XMP1_op1_0900_rl_s0p1_r3k rbl_op1_0900_rl_s0p1_r3k ref_op1_0900_rl_s0p1_r3k vp_op1_0900_rl_s0p1_r3k vdd sky130_fd_pr__pfet_01v8 L=0.15 W=2 nf=1 ad=0.58 as=0.58 pd=4.58 ps=4.58 mult=1 m=1
XMP2_op1_0900_rl_s0p1_r3k ref_op1_0900_rl_s0p1_r3k rbl_op1_0900_rl_s0p1_r3k vp_op1_0900_rl_s0p1_r3k vdd sky130_fd_pr__pfet_01v8 L=0.15 W=2 nf=1 ad=0.58 as=0.58 pd=4.58 ps=4.58 mult=1 m=1
XMNF_op1_0900_rl_s0p1_r3k vn_op1_0900_rl_s0p1_r3k en_op1_0900_rl_s0p1_r3k 0 0 sky130_fd_pr__nfet_01v8 L=0.15 W=2 nf=1 ad=0.58 as=0.58 pd=4.58 ps=4.58 mult=1 m=1
XMPH_op1_0900_rl_s0p1_r3k vp_op1_0900_rl_s0p1_r3k enb_op1_0900_rl_s0p1_r3k vdd vdd sky130_fd_pr__pfet_01v8 L=0.15 W=4 nf=1 ad=1.16 as=1.16 pd=8.58 ps=8.58 mult=1 m=1
bd_op1_0900_rl_s0p1_r3k d_op1_0900_rl_s0p1_r3k 0 v=v(rbl_op1_0900_rl_s0p1_r3k)-v(ref_op1_0900_rl_s0p1_r3k)

* ---- instance 182: op1_1000_rl_s0p1_r3k (variant rl_s0p1_r3k; probe dec 11.9 ns, release 34 ns, meas 36 ns) ----
vctl_op1_1000_rl_s0p1_r3k ctl_op1_1000_rl_s0p1_r3k 0 pwl(0.0000e+00 {VDD} 2.0000e-09 {VDD} 2.1000e-09 0)
* RWL driver model (EXPERIMENTAL): slew 0.1 ns, series R 3000 ohm; cell pin = rwls_op1_1000_rl_s0p1_r3k
vrs_op1_1000_rl_s0p1_r3k rwlsrc_op1_1000_rl_s0p1_r3k 0 pwl(0.0000e+00 {VDD} 2.0000e-09 {VDD} 2.1000e-09 0 3.4000e-08 0 3.4100e-08 {VDD})
rdrv_op1_1000_rl_s0p1_r3k rwlsrc_op1_1000_rl_s0p1_r3k rwls_op1_1000_rl_s0p1_r3k 3000
ven_op1_1000_rl_s0p1_r3k en_op1_1000_rl_s0p1_r3k 0 pwl(0.0000e+00 0 1.1000e-08 0 1.1100e-08 {VDD} 3.4000e-08 {VDD} 3.4100e-08 0)
venb_op1_1000_rl_s0p1_r3k enb_op1_1000_rl_s0p1_r3k 0 pwl(0.0000e+00 {VDD} 1.1000e-08 {VDD} 1.1100e-08 0 3.4000e-08 0 3.4100e-08 {VDD})
vww_op1_1000_rl_s0p1_r3k wwl_op1_1000_rl_s0p1_r3k 0 pwl(0.0000e+00 0 1.2000e-08 0 1.2100e-08 {VDD} 3.2000e-08 {VDD} 3.2100e-08 0)
vwc_op1_1000_rl_s0p1_r3k wbc_op1_1000_rl_s0p1_r3k 0 pwl(0.0000e+00 0 1.2000e-08 0 1.2100e-08 {VDD} 3.4000e-08 {VDD} 3.4100e-08 0)
swb_op1_1000_rl_s0p1_r3k ref_op1_1000_rl_s0p1_r3k wbl_op1_1000_rl_s0p1_r3k wbc_op1_1000_rl_s0p1_r3k 0 swwbl
cwbl_op1_1000_rl_s0p1_r3k wbl_op1_1000_rl_s0p1_r3k 0 {C_WBL}
spa_op1_1000_rl_s0p1_r3k prea rbl_op1_1000_rl_s0p1_r3k ctl_op1_1000_rl_s0p1_r3k 0 swpre
spr_op1_1000_rl_s0p1_r3k pref ref_op1_1000_rl_s0p1_r3k ctl_op1_1000_rl_s0p1_r3k 0 swpre
crbl_op1_1000_rl_s0p1_r3k rbl_op1_1000_rl_s0p1_r3k 0 {C_RBL}
cref_op1_1000_rl_s0p1_r3k ref_op1_1000_rl_s0p1_r3k 0 {C_RBL}   $ ASSUMPTION: ideal matched dummy load
XMWR_op1_1000_rl_s0p1_r3k_0 sn_op1_1000_rl_s0p1_r3k_0 wwl_op1_1000_rl_s0p1_r3k wbl_op1_1000_rl_s0p1_r3k 0 sky130_fd_pr__nfet_01v8 L=0.15 W=0.42 nf=1 ad=0.1218 as=0.1218 pd=1.42 ps=1.42 nrd=0.69047619047619  nrs=0.69047619047619 sa=0 sb=0 sd=0 mult=1 m=1
XMRD_op1_1000_rl_s0p1_r3k_0 rbl_op1_1000_rl_s0p1_r3k sn_op1_1000_rl_s0p1_r3k_0 rwls_op1_1000_rl_s0p1_r3k 0 sky130_fd_pr__nfet_01v8 L=0.15 W=0.42 nf=1 ad=0.1218 as=0.1218 pd=1.42 ps=1.42 nrd=0.69047619047619  nrs=0.69047619047619 sa=0 sb=0 sd=0 mult=1 m=1
csn_op1_1000_rl_s0p1_r3k_0 sn_op1_1000_rl_s0p1_r3k_0 0 {C_SN}
XMWR_op1_1000_rl_s0p1_r3k_1 sn_op1_1000_rl_s0p1_r3k_1 wwl_des wbl_op1_1000_rl_s0p1_r3k 0 sky130_fd_pr__nfet_01v8 L=0.15 W=0.42 nf=1 ad=0.1218 as=0.1218 pd=1.42 ps=1.42 nrd=0.69047619047619  nrs=0.69047619047619 sa=0 sb=0 sd=0 mult=1 m=1
XMRD_op1_1000_rl_s0p1_r3k_1 rbl_op1_1000_rl_s0p1_r3k sn_op1_1000_rl_s0p1_r3k_1 rwl_des 0 sky130_fd_pr__nfet_01v8 L=0.15 W=0.42 nf=1 ad=0.1218 as=0.1218 pd=1.42 ps=1.42 nrd=0.69047619047619  nrs=0.69047619047619 sa=0 sb=0 sd=0 mult=1 m=1
csn_op1_1000_rl_s0p1_r3k_1 sn_op1_1000_rl_s0p1_r3k_1 0 {C_SN}
XMWR_op1_1000_rl_s0p1_r3k_2 sn_op1_1000_rl_s0p1_r3k_2 wwl_des wbl_op1_1000_rl_s0p1_r3k 0 sky130_fd_pr__nfet_01v8 L=0.15 W=0.42 nf=1 ad=0.1218 as=0.1218 pd=1.42 ps=1.42 nrd=0.69047619047619  nrs=0.69047619047619 sa=0 sb=0 sd=0 mult=1 m=1
XMRD_op1_1000_rl_s0p1_r3k_2 rbl_op1_1000_rl_s0p1_r3k sn_op1_1000_rl_s0p1_r3k_2 rwl_des 0 sky130_fd_pr__nfet_01v8 L=0.15 W=0.42 nf=1 ad=0.1218 as=0.1218 pd=1.42 ps=1.42 nrd=0.69047619047619  nrs=0.69047619047619 sa=0 sb=0 sd=0 mult=1 m=1
csn_op1_1000_rl_s0p1_r3k_2 sn_op1_1000_rl_s0p1_r3k_2 0 {C_SN}
XMWR_op1_1000_rl_s0p1_r3k_3 sn_op1_1000_rl_s0p1_r3k_3 wwl_des wbl_op1_1000_rl_s0p1_r3k 0 sky130_fd_pr__nfet_01v8 L=0.15 W=0.42 nf=1 ad=0.1218 as=0.1218 pd=1.42 ps=1.42 nrd=0.69047619047619  nrs=0.69047619047619 sa=0 sb=0 sd=0 mult=1 m=1
XMRD_op1_1000_rl_s0p1_r3k_3 rbl_op1_1000_rl_s0p1_r3k sn_op1_1000_rl_s0p1_r3k_3 rwl_des 0 sky130_fd_pr__nfet_01v8 L=0.15 W=0.42 nf=1 ad=0.1218 as=0.1218 pd=1.42 ps=1.42 nrd=0.69047619047619  nrs=0.69047619047619 sa=0 sb=0 sd=0 mult=1 m=1
csn_op1_1000_rl_s0p1_r3k_3 sn_op1_1000_rl_s0p1_r3k_3 0 {C_SN}
XMN1_op1_1000_rl_s0p1_r3k rbl_op1_1000_rl_s0p1_r3k ref_op1_1000_rl_s0p1_r3k vn_op1_1000_rl_s0p1_r3k 0 sky130_fd_pr__nfet_01v8 L=0.15 W=1 nf=1 ad=0.29 as=0.29 pd=2.58 ps=2.58 mult=1 m=1
XMN2_op1_1000_rl_s0p1_r3k ref_op1_1000_rl_s0p1_r3k rbl_op1_1000_rl_s0p1_r3k vn_op1_1000_rl_s0p1_r3k 0 sky130_fd_pr__nfet_01v8 L=0.15 W=1 nf=1 ad=0.29 as=0.29 pd=2.58 ps=2.58 mult=1 m=1
XMP1_op1_1000_rl_s0p1_r3k rbl_op1_1000_rl_s0p1_r3k ref_op1_1000_rl_s0p1_r3k vp_op1_1000_rl_s0p1_r3k vdd sky130_fd_pr__pfet_01v8 L=0.15 W=2 nf=1 ad=0.58 as=0.58 pd=4.58 ps=4.58 mult=1 m=1
XMP2_op1_1000_rl_s0p1_r3k ref_op1_1000_rl_s0p1_r3k rbl_op1_1000_rl_s0p1_r3k vp_op1_1000_rl_s0p1_r3k vdd sky130_fd_pr__pfet_01v8 L=0.15 W=2 nf=1 ad=0.58 as=0.58 pd=4.58 ps=4.58 mult=1 m=1
XMNF_op1_1000_rl_s0p1_r3k vn_op1_1000_rl_s0p1_r3k en_op1_1000_rl_s0p1_r3k 0 0 sky130_fd_pr__nfet_01v8 L=0.15 W=2 nf=1 ad=0.58 as=0.58 pd=4.58 ps=4.58 mult=1 m=1
XMPH_op1_1000_rl_s0p1_r3k vp_op1_1000_rl_s0p1_r3k enb_op1_1000_rl_s0p1_r3k vdd vdd sky130_fd_pr__pfet_01v8 L=0.15 W=4 nf=1 ad=1.16 as=1.16 pd=8.58 ps=8.58 mult=1 m=1
bd_op1_1000_rl_s0p1_r3k d_op1_1000_rl_s0p1_r3k 0 v=v(rbl_op1_1000_rl_s0p1_r3k)-v(ref_op1_1000_rl_s0p1_r3k)

* ---- instance 183: op0_n100_rl_s0p1_r3k (variant rl_s0p1_r3k; probe dec 11.9 ns, release 34 ns, meas 36 ns) ----
vctl_op0_n100_rl_s0p1_r3k ctl_op0_n100_rl_s0p1_r3k 0 pwl(0.0000e+00 {VDD} 2.0000e-09 {VDD} 2.1000e-09 0)
* RWL driver model (EXPERIMENTAL): slew 0.1 ns, series R 3000 ohm; cell pin = rwls_op0_n100_rl_s0p1_r3k
vrs_op0_n100_rl_s0p1_r3k rwlsrc_op0_n100_rl_s0p1_r3k 0 pwl(0.0000e+00 {VDD} 2.0000e-09 {VDD} 2.1000e-09 0 3.4000e-08 0 3.4100e-08 {VDD})
rdrv_op0_n100_rl_s0p1_r3k rwlsrc_op0_n100_rl_s0p1_r3k rwls_op0_n100_rl_s0p1_r3k 3000
ven_op0_n100_rl_s0p1_r3k en_op0_n100_rl_s0p1_r3k 0 pwl(0.0000e+00 0 1.1000e-08 0 1.1100e-08 {VDD} 3.4000e-08 {VDD} 3.4100e-08 0)
venb_op0_n100_rl_s0p1_r3k enb_op0_n100_rl_s0p1_r3k 0 pwl(0.0000e+00 {VDD} 1.1000e-08 {VDD} 1.1100e-08 0 3.4000e-08 0 3.4100e-08 {VDD})
vww_op0_n100_rl_s0p1_r3k wwl_op0_n100_rl_s0p1_r3k 0 pwl(0.0000e+00 0 1.2000e-08 0 1.2100e-08 {VDD} 3.2000e-08 {VDD} 3.2100e-08 0)
vwc_op0_n100_rl_s0p1_r3k wbc_op0_n100_rl_s0p1_r3k 0 pwl(0.0000e+00 0 1.2000e-08 0 1.2100e-08 {VDD} 3.4000e-08 {VDD} 3.4100e-08 0)
swb_op0_n100_rl_s0p1_r3k ref_op0_n100_rl_s0p1_r3k wbl_op0_n100_rl_s0p1_r3k wbc_op0_n100_rl_s0p1_r3k 0 swwbl
cwbl_op0_n100_rl_s0p1_r3k wbl_op0_n100_rl_s0p1_r3k 0 {C_WBL}
spa_op0_n100_rl_s0p1_r3k prea rbl_op0_n100_rl_s0p1_r3k ctl_op0_n100_rl_s0p1_r3k 0 swpre
spr_op0_n100_rl_s0p1_r3k pref ref_op0_n100_rl_s0p1_r3k ctl_op0_n100_rl_s0p1_r3k 0 swpre
crbl_op0_n100_rl_s0p1_r3k rbl_op0_n100_rl_s0p1_r3k 0 {C_RBL}
cref_op0_n100_rl_s0p1_r3k ref_op0_n100_rl_s0p1_r3k 0 {C_RBL}   $ ASSUMPTION: ideal matched dummy load
XMWR_op0_n100_rl_s0p1_r3k_0 sn_op0_n100_rl_s0p1_r3k_0 wwl_op0_n100_rl_s0p1_r3k wbl_op0_n100_rl_s0p1_r3k 0 sky130_fd_pr__nfet_01v8 L=0.15 W=0.42 nf=1 ad=0.1218 as=0.1218 pd=1.42 ps=1.42 nrd=0.69047619047619  nrs=0.69047619047619 sa=0 sb=0 sd=0 mult=1 m=1
XMRD_op0_n100_rl_s0p1_r3k_0 rbl_op0_n100_rl_s0p1_r3k sn_op0_n100_rl_s0p1_r3k_0 rwls_op0_n100_rl_s0p1_r3k 0 sky130_fd_pr__nfet_01v8 L=0.15 W=0.42 nf=1 ad=0.1218 as=0.1218 pd=1.42 ps=1.42 nrd=0.69047619047619  nrs=0.69047619047619 sa=0 sb=0 sd=0 mult=1 m=1
csn_op0_n100_rl_s0p1_r3k_0 sn_op0_n100_rl_s0p1_r3k_0 0 {C_SN}
XMWR_op0_n100_rl_s0p1_r3k_1 sn_op0_n100_rl_s0p1_r3k_1 wwl_des wbl_op0_n100_rl_s0p1_r3k 0 sky130_fd_pr__nfet_01v8 L=0.15 W=0.42 nf=1 ad=0.1218 as=0.1218 pd=1.42 ps=1.42 nrd=0.69047619047619  nrs=0.69047619047619 sa=0 sb=0 sd=0 mult=1 m=1
XMRD_op0_n100_rl_s0p1_r3k_1 rbl_op0_n100_rl_s0p1_r3k sn_op0_n100_rl_s0p1_r3k_1 rwl_des 0 sky130_fd_pr__nfet_01v8 L=0.15 W=0.42 nf=1 ad=0.1218 as=0.1218 pd=1.42 ps=1.42 nrd=0.69047619047619  nrs=0.69047619047619 sa=0 sb=0 sd=0 mult=1 m=1
csn_op0_n100_rl_s0p1_r3k_1 sn_op0_n100_rl_s0p1_r3k_1 0 {C_SN}
XMWR_op0_n100_rl_s0p1_r3k_2 sn_op0_n100_rl_s0p1_r3k_2 wwl_des wbl_op0_n100_rl_s0p1_r3k 0 sky130_fd_pr__nfet_01v8 L=0.15 W=0.42 nf=1 ad=0.1218 as=0.1218 pd=1.42 ps=1.42 nrd=0.69047619047619  nrs=0.69047619047619 sa=0 sb=0 sd=0 mult=1 m=1
XMRD_op0_n100_rl_s0p1_r3k_2 rbl_op0_n100_rl_s0p1_r3k sn_op0_n100_rl_s0p1_r3k_2 rwl_des 0 sky130_fd_pr__nfet_01v8 L=0.15 W=0.42 nf=1 ad=0.1218 as=0.1218 pd=1.42 ps=1.42 nrd=0.69047619047619  nrs=0.69047619047619 sa=0 sb=0 sd=0 mult=1 m=1
csn_op0_n100_rl_s0p1_r3k_2 sn_op0_n100_rl_s0p1_r3k_2 0 {C_SN}
XMWR_op0_n100_rl_s0p1_r3k_3 sn_op0_n100_rl_s0p1_r3k_3 wwl_des wbl_op0_n100_rl_s0p1_r3k 0 sky130_fd_pr__nfet_01v8 L=0.15 W=0.42 nf=1 ad=0.1218 as=0.1218 pd=1.42 ps=1.42 nrd=0.69047619047619  nrs=0.69047619047619 sa=0 sb=0 sd=0 mult=1 m=1
XMRD_op0_n100_rl_s0p1_r3k_3 rbl_op0_n100_rl_s0p1_r3k sn_op0_n100_rl_s0p1_r3k_3 rwl_des 0 sky130_fd_pr__nfet_01v8 L=0.15 W=0.42 nf=1 ad=0.1218 as=0.1218 pd=1.42 ps=1.42 nrd=0.69047619047619  nrs=0.69047619047619 sa=0 sb=0 sd=0 mult=1 m=1
csn_op0_n100_rl_s0p1_r3k_3 sn_op0_n100_rl_s0p1_r3k_3 0 {C_SN}
XMN1_op0_n100_rl_s0p1_r3k rbl_op0_n100_rl_s0p1_r3k ref_op0_n100_rl_s0p1_r3k vn_op0_n100_rl_s0p1_r3k 0 sky130_fd_pr__nfet_01v8 L=0.15 W=1 nf=1 ad=0.29 as=0.29 pd=2.58 ps=2.58 mult=1 m=1
XMN2_op0_n100_rl_s0p1_r3k ref_op0_n100_rl_s0p1_r3k rbl_op0_n100_rl_s0p1_r3k vn_op0_n100_rl_s0p1_r3k 0 sky130_fd_pr__nfet_01v8 L=0.15 W=1 nf=1 ad=0.29 as=0.29 pd=2.58 ps=2.58 mult=1 m=1
XMP1_op0_n100_rl_s0p1_r3k rbl_op0_n100_rl_s0p1_r3k ref_op0_n100_rl_s0p1_r3k vp_op0_n100_rl_s0p1_r3k vdd sky130_fd_pr__pfet_01v8 L=0.15 W=2 nf=1 ad=0.58 as=0.58 pd=4.58 ps=4.58 mult=1 m=1
XMP2_op0_n100_rl_s0p1_r3k ref_op0_n100_rl_s0p1_r3k rbl_op0_n100_rl_s0p1_r3k vp_op0_n100_rl_s0p1_r3k vdd sky130_fd_pr__pfet_01v8 L=0.15 W=2 nf=1 ad=0.58 as=0.58 pd=4.58 ps=4.58 mult=1 m=1
XMNF_op0_n100_rl_s0p1_r3k vn_op0_n100_rl_s0p1_r3k en_op0_n100_rl_s0p1_r3k 0 0 sky130_fd_pr__nfet_01v8 L=0.15 W=2 nf=1 ad=0.58 as=0.58 pd=4.58 ps=4.58 mult=1 m=1
XMPH_op0_n100_rl_s0p1_r3k vp_op0_n100_rl_s0p1_r3k enb_op0_n100_rl_s0p1_r3k vdd vdd sky130_fd_pr__pfet_01v8 L=0.15 W=4 nf=1 ad=1.16 as=1.16 pd=8.58 ps=8.58 mult=1 m=1
bd_op0_n100_rl_s0p1_r3k d_op0_n100_rl_s0p1_r3k 0 v=v(rbl_op0_n100_rl_s0p1_r3k)-v(ref_op0_n100_rl_s0p1_r3k)

* ---- instance 184: op0_0000_rl_s0p1_r3k (variant rl_s0p1_r3k; probe dec 11.9 ns, release 34 ns, meas 36 ns) ----
vctl_op0_0000_rl_s0p1_r3k ctl_op0_0000_rl_s0p1_r3k 0 pwl(0.0000e+00 {VDD} 2.0000e-09 {VDD} 2.1000e-09 0)
* RWL driver model (EXPERIMENTAL): slew 0.1 ns, series R 3000 ohm; cell pin = rwls_op0_0000_rl_s0p1_r3k
vrs_op0_0000_rl_s0p1_r3k rwlsrc_op0_0000_rl_s0p1_r3k 0 pwl(0.0000e+00 {VDD} 2.0000e-09 {VDD} 2.1000e-09 0 3.4000e-08 0 3.4100e-08 {VDD})
rdrv_op0_0000_rl_s0p1_r3k rwlsrc_op0_0000_rl_s0p1_r3k rwls_op0_0000_rl_s0p1_r3k 3000
ven_op0_0000_rl_s0p1_r3k en_op0_0000_rl_s0p1_r3k 0 pwl(0.0000e+00 0 1.1000e-08 0 1.1100e-08 {VDD} 3.4000e-08 {VDD} 3.4100e-08 0)
venb_op0_0000_rl_s0p1_r3k enb_op0_0000_rl_s0p1_r3k 0 pwl(0.0000e+00 {VDD} 1.1000e-08 {VDD} 1.1100e-08 0 3.4000e-08 0 3.4100e-08 {VDD})
vww_op0_0000_rl_s0p1_r3k wwl_op0_0000_rl_s0p1_r3k 0 pwl(0.0000e+00 0 1.2000e-08 0 1.2100e-08 {VDD} 3.2000e-08 {VDD} 3.2100e-08 0)
vwc_op0_0000_rl_s0p1_r3k wbc_op0_0000_rl_s0p1_r3k 0 pwl(0.0000e+00 0 1.2000e-08 0 1.2100e-08 {VDD} 3.4000e-08 {VDD} 3.4100e-08 0)
swb_op0_0000_rl_s0p1_r3k ref_op0_0000_rl_s0p1_r3k wbl_op0_0000_rl_s0p1_r3k wbc_op0_0000_rl_s0p1_r3k 0 swwbl
cwbl_op0_0000_rl_s0p1_r3k wbl_op0_0000_rl_s0p1_r3k 0 {C_WBL}
spa_op0_0000_rl_s0p1_r3k prea rbl_op0_0000_rl_s0p1_r3k ctl_op0_0000_rl_s0p1_r3k 0 swpre
spr_op0_0000_rl_s0p1_r3k pref ref_op0_0000_rl_s0p1_r3k ctl_op0_0000_rl_s0p1_r3k 0 swpre
crbl_op0_0000_rl_s0p1_r3k rbl_op0_0000_rl_s0p1_r3k 0 {C_RBL}
cref_op0_0000_rl_s0p1_r3k ref_op0_0000_rl_s0p1_r3k 0 {C_RBL}   $ ASSUMPTION: ideal matched dummy load
XMWR_op0_0000_rl_s0p1_r3k_0 sn_op0_0000_rl_s0p1_r3k_0 wwl_op0_0000_rl_s0p1_r3k wbl_op0_0000_rl_s0p1_r3k 0 sky130_fd_pr__nfet_01v8 L=0.15 W=0.42 nf=1 ad=0.1218 as=0.1218 pd=1.42 ps=1.42 nrd=0.69047619047619  nrs=0.69047619047619 sa=0 sb=0 sd=0 mult=1 m=1
XMRD_op0_0000_rl_s0p1_r3k_0 rbl_op0_0000_rl_s0p1_r3k sn_op0_0000_rl_s0p1_r3k_0 rwls_op0_0000_rl_s0p1_r3k 0 sky130_fd_pr__nfet_01v8 L=0.15 W=0.42 nf=1 ad=0.1218 as=0.1218 pd=1.42 ps=1.42 nrd=0.69047619047619  nrs=0.69047619047619 sa=0 sb=0 sd=0 mult=1 m=1
csn_op0_0000_rl_s0p1_r3k_0 sn_op0_0000_rl_s0p1_r3k_0 0 {C_SN}
XMWR_op0_0000_rl_s0p1_r3k_1 sn_op0_0000_rl_s0p1_r3k_1 wwl_des wbl_op0_0000_rl_s0p1_r3k 0 sky130_fd_pr__nfet_01v8 L=0.15 W=0.42 nf=1 ad=0.1218 as=0.1218 pd=1.42 ps=1.42 nrd=0.69047619047619  nrs=0.69047619047619 sa=0 sb=0 sd=0 mult=1 m=1
XMRD_op0_0000_rl_s0p1_r3k_1 rbl_op0_0000_rl_s0p1_r3k sn_op0_0000_rl_s0p1_r3k_1 rwl_des 0 sky130_fd_pr__nfet_01v8 L=0.15 W=0.42 nf=1 ad=0.1218 as=0.1218 pd=1.42 ps=1.42 nrd=0.69047619047619  nrs=0.69047619047619 sa=0 sb=0 sd=0 mult=1 m=1
csn_op0_0000_rl_s0p1_r3k_1 sn_op0_0000_rl_s0p1_r3k_1 0 {C_SN}
XMWR_op0_0000_rl_s0p1_r3k_2 sn_op0_0000_rl_s0p1_r3k_2 wwl_des wbl_op0_0000_rl_s0p1_r3k 0 sky130_fd_pr__nfet_01v8 L=0.15 W=0.42 nf=1 ad=0.1218 as=0.1218 pd=1.42 ps=1.42 nrd=0.69047619047619  nrs=0.69047619047619 sa=0 sb=0 sd=0 mult=1 m=1
XMRD_op0_0000_rl_s0p1_r3k_2 rbl_op0_0000_rl_s0p1_r3k sn_op0_0000_rl_s0p1_r3k_2 rwl_des 0 sky130_fd_pr__nfet_01v8 L=0.15 W=0.42 nf=1 ad=0.1218 as=0.1218 pd=1.42 ps=1.42 nrd=0.69047619047619  nrs=0.69047619047619 sa=0 sb=0 sd=0 mult=1 m=1
csn_op0_0000_rl_s0p1_r3k_2 sn_op0_0000_rl_s0p1_r3k_2 0 {C_SN}
XMWR_op0_0000_rl_s0p1_r3k_3 sn_op0_0000_rl_s0p1_r3k_3 wwl_des wbl_op0_0000_rl_s0p1_r3k 0 sky130_fd_pr__nfet_01v8 L=0.15 W=0.42 nf=1 ad=0.1218 as=0.1218 pd=1.42 ps=1.42 nrd=0.69047619047619  nrs=0.69047619047619 sa=0 sb=0 sd=0 mult=1 m=1
XMRD_op0_0000_rl_s0p1_r3k_3 rbl_op0_0000_rl_s0p1_r3k sn_op0_0000_rl_s0p1_r3k_3 rwl_des 0 sky130_fd_pr__nfet_01v8 L=0.15 W=0.42 nf=1 ad=0.1218 as=0.1218 pd=1.42 ps=1.42 nrd=0.69047619047619  nrs=0.69047619047619 sa=0 sb=0 sd=0 mult=1 m=1
csn_op0_0000_rl_s0p1_r3k_3 sn_op0_0000_rl_s0p1_r3k_3 0 {C_SN}
XMN1_op0_0000_rl_s0p1_r3k rbl_op0_0000_rl_s0p1_r3k ref_op0_0000_rl_s0p1_r3k vn_op0_0000_rl_s0p1_r3k 0 sky130_fd_pr__nfet_01v8 L=0.15 W=1 nf=1 ad=0.29 as=0.29 pd=2.58 ps=2.58 mult=1 m=1
XMN2_op0_0000_rl_s0p1_r3k ref_op0_0000_rl_s0p1_r3k rbl_op0_0000_rl_s0p1_r3k vn_op0_0000_rl_s0p1_r3k 0 sky130_fd_pr__nfet_01v8 L=0.15 W=1 nf=1 ad=0.29 as=0.29 pd=2.58 ps=2.58 mult=1 m=1
XMP1_op0_0000_rl_s0p1_r3k rbl_op0_0000_rl_s0p1_r3k ref_op0_0000_rl_s0p1_r3k vp_op0_0000_rl_s0p1_r3k vdd sky130_fd_pr__pfet_01v8 L=0.15 W=2 nf=1 ad=0.58 as=0.58 pd=4.58 ps=4.58 mult=1 m=1
XMP2_op0_0000_rl_s0p1_r3k ref_op0_0000_rl_s0p1_r3k rbl_op0_0000_rl_s0p1_r3k vp_op0_0000_rl_s0p1_r3k vdd sky130_fd_pr__pfet_01v8 L=0.15 W=2 nf=1 ad=0.58 as=0.58 pd=4.58 ps=4.58 mult=1 m=1
XMNF_op0_0000_rl_s0p1_r3k vn_op0_0000_rl_s0p1_r3k en_op0_0000_rl_s0p1_r3k 0 0 sky130_fd_pr__nfet_01v8 L=0.15 W=2 nf=1 ad=0.58 as=0.58 pd=4.58 ps=4.58 mult=1 m=1
XMPH_op0_0000_rl_s0p1_r3k vp_op0_0000_rl_s0p1_r3k enb_op0_0000_rl_s0p1_r3k vdd vdd sky130_fd_pr__pfet_01v8 L=0.15 W=4 nf=1 ad=1.16 as=1.16 pd=8.58 ps=8.58 mult=1 m=1
bd_op0_0000_rl_s0p1_r3k d_op0_0000_rl_s0p1_r3k 0 v=v(rbl_op0_0000_rl_s0p1_r3k)-v(ref_op0_0000_rl_s0p1_r3k)

* ---- instance 185: op1_0900_rl_s0p1_r10k (variant rl_s0p1_r10k; probe dec 11.9 ns, release 34 ns, meas 36 ns) ----
vctl_op1_0900_rl_s0p1_r10k ctl_op1_0900_rl_s0p1_r10k 0 pwl(0.0000e+00 {VDD} 2.0000e-09 {VDD} 2.1000e-09 0)
* RWL driver model (EXPERIMENTAL): slew 0.1 ns, series R 10000 ohm; cell pin = rwls_op1_0900_rl_s0p1_r10k
vrs_op1_0900_rl_s0p1_r10k rwlsrc_op1_0900_rl_s0p1_r10k 0 pwl(0.0000e+00 {VDD} 2.0000e-09 {VDD} 2.1000e-09 0 3.4000e-08 0 3.4100e-08 {VDD})
rdrv_op1_0900_rl_s0p1_r10k rwlsrc_op1_0900_rl_s0p1_r10k rwls_op1_0900_rl_s0p1_r10k 10000
ven_op1_0900_rl_s0p1_r10k en_op1_0900_rl_s0p1_r10k 0 pwl(0.0000e+00 0 1.1000e-08 0 1.1100e-08 {VDD} 3.4000e-08 {VDD} 3.4100e-08 0)
venb_op1_0900_rl_s0p1_r10k enb_op1_0900_rl_s0p1_r10k 0 pwl(0.0000e+00 {VDD} 1.1000e-08 {VDD} 1.1100e-08 0 3.4000e-08 0 3.4100e-08 {VDD})
vww_op1_0900_rl_s0p1_r10k wwl_op1_0900_rl_s0p1_r10k 0 pwl(0.0000e+00 0 1.2000e-08 0 1.2100e-08 {VDD} 3.2000e-08 {VDD} 3.2100e-08 0)
vwc_op1_0900_rl_s0p1_r10k wbc_op1_0900_rl_s0p1_r10k 0 pwl(0.0000e+00 0 1.2000e-08 0 1.2100e-08 {VDD} 3.4000e-08 {VDD} 3.4100e-08 0)
swb_op1_0900_rl_s0p1_r10k ref_op1_0900_rl_s0p1_r10k wbl_op1_0900_rl_s0p1_r10k wbc_op1_0900_rl_s0p1_r10k 0 swwbl
cwbl_op1_0900_rl_s0p1_r10k wbl_op1_0900_rl_s0p1_r10k 0 {C_WBL}
spa_op1_0900_rl_s0p1_r10k prea rbl_op1_0900_rl_s0p1_r10k ctl_op1_0900_rl_s0p1_r10k 0 swpre
spr_op1_0900_rl_s0p1_r10k pref ref_op1_0900_rl_s0p1_r10k ctl_op1_0900_rl_s0p1_r10k 0 swpre
crbl_op1_0900_rl_s0p1_r10k rbl_op1_0900_rl_s0p1_r10k 0 {C_RBL}
cref_op1_0900_rl_s0p1_r10k ref_op1_0900_rl_s0p1_r10k 0 {C_RBL}   $ ASSUMPTION: ideal matched dummy load
XMWR_op1_0900_rl_s0p1_r10k_0 sn_op1_0900_rl_s0p1_r10k_0 wwl_op1_0900_rl_s0p1_r10k wbl_op1_0900_rl_s0p1_r10k 0 sky130_fd_pr__nfet_01v8 L=0.15 W=0.42 nf=1 ad=0.1218 as=0.1218 pd=1.42 ps=1.42 nrd=0.69047619047619  nrs=0.69047619047619 sa=0 sb=0 sd=0 mult=1 m=1
XMRD_op1_0900_rl_s0p1_r10k_0 rbl_op1_0900_rl_s0p1_r10k sn_op1_0900_rl_s0p1_r10k_0 rwls_op1_0900_rl_s0p1_r10k 0 sky130_fd_pr__nfet_01v8 L=0.15 W=0.42 nf=1 ad=0.1218 as=0.1218 pd=1.42 ps=1.42 nrd=0.69047619047619  nrs=0.69047619047619 sa=0 sb=0 sd=0 mult=1 m=1
csn_op1_0900_rl_s0p1_r10k_0 sn_op1_0900_rl_s0p1_r10k_0 0 {C_SN}
XMWR_op1_0900_rl_s0p1_r10k_1 sn_op1_0900_rl_s0p1_r10k_1 wwl_des wbl_op1_0900_rl_s0p1_r10k 0 sky130_fd_pr__nfet_01v8 L=0.15 W=0.42 nf=1 ad=0.1218 as=0.1218 pd=1.42 ps=1.42 nrd=0.69047619047619  nrs=0.69047619047619 sa=0 sb=0 sd=0 mult=1 m=1
XMRD_op1_0900_rl_s0p1_r10k_1 rbl_op1_0900_rl_s0p1_r10k sn_op1_0900_rl_s0p1_r10k_1 rwl_des 0 sky130_fd_pr__nfet_01v8 L=0.15 W=0.42 nf=1 ad=0.1218 as=0.1218 pd=1.42 ps=1.42 nrd=0.69047619047619  nrs=0.69047619047619 sa=0 sb=0 sd=0 mult=1 m=1
csn_op1_0900_rl_s0p1_r10k_1 sn_op1_0900_rl_s0p1_r10k_1 0 {C_SN}
XMWR_op1_0900_rl_s0p1_r10k_2 sn_op1_0900_rl_s0p1_r10k_2 wwl_des wbl_op1_0900_rl_s0p1_r10k 0 sky130_fd_pr__nfet_01v8 L=0.15 W=0.42 nf=1 ad=0.1218 as=0.1218 pd=1.42 ps=1.42 nrd=0.69047619047619  nrs=0.69047619047619 sa=0 sb=0 sd=0 mult=1 m=1
XMRD_op1_0900_rl_s0p1_r10k_2 rbl_op1_0900_rl_s0p1_r10k sn_op1_0900_rl_s0p1_r10k_2 rwl_des 0 sky130_fd_pr__nfet_01v8 L=0.15 W=0.42 nf=1 ad=0.1218 as=0.1218 pd=1.42 ps=1.42 nrd=0.69047619047619  nrs=0.69047619047619 sa=0 sb=0 sd=0 mult=1 m=1
csn_op1_0900_rl_s0p1_r10k_2 sn_op1_0900_rl_s0p1_r10k_2 0 {C_SN}
XMWR_op1_0900_rl_s0p1_r10k_3 sn_op1_0900_rl_s0p1_r10k_3 wwl_des wbl_op1_0900_rl_s0p1_r10k 0 sky130_fd_pr__nfet_01v8 L=0.15 W=0.42 nf=1 ad=0.1218 as=0.1218 pd=1.42 ps=1.42 nrd=0.69047619047619  nrs=0.69047619047619 sa=0 sb=0 sd=0 mult=1 m=1
XMRD_op1_0900_rl_s0p1_r10k_3 rbl_op1_0900_rl_s0p1_r10k sn_op1_0900_rl_s0p1_r10k_3 rwl_des 0 sky130_fd_pr__nfet_01v8 L=0.15 W=0.42 nf=1 ad=0.1218 as=0.1218 pd=1.42 ps=1.42 nrd=0.69047619047619  nrs=0.69047619047619 sa=0 sb=0 sd=0 mult=1 m=1
csn_op1_0900_rl_s0p1_r10k_3 sn_op1_0900_rl_s0p1_r10k_3 0 {C_SN}
XMN1_op1_0900_rl_s0p1_r10k rbl_op1_0900_rl_s0p1_r10k ref_op1_0900_rl_s0p1_r10k vn_op1_0900_rl_s0p1_r10k 0 sky130_fd_pr__nfet_01v8 L=0.15 W=1 nf=1 ad=0.29 as=0.29 pd=2.58 ps=2.58 mult=1 m=1
XMN2_op1_0900_rl_s0p1_r10k ref_op1_0900_rl_s0p1_r10k rbl_op1_0900_rl_s0p1_r10k vn_op1_0900_rl_s0p1_r10k 0 sky130_fd_pr__nfet_01v8 L=0.15 W=1 nf=1 ad=0.29 as=0.29 pd=2.58 ps=2.58 mult=1 m=1
XMP1_op1_0900_rl_s0p1_r10k rbl_op1_0900_rl_s0p1_r10k ref_op1_0900_rl_s0p1_r10k vp_op1_0900_rl_s0p1_r10k vdd sky130_fd_pr__pfet_01v8 L=0.15 W=2 nf=1 ad=0.58 as=0.58 pd=4.58 ps=4.58 mult=1 m=1
XMP2_op1_0900_rl_s0p1_r10k ref_op1_0900_rl_s0p1_r10k rbl_op1_0900_rl_s0p1_r10k vp_op1_0900_rl_s0p1_r10k vdd sky130_fd_pr__pfet_01v8 L=0.15 W=2 nf=1 ad=0.58 as=0.58 pd=4.58 ps=4.58 mult=1 m=1
XMNF_op1_0900_rl_s0p1_r10k vn_op1_0900_rl_s0p1_r10k en_op1_0900_rl_s0p1_r10k 0 0 sky130_fd_pr__nfet_01v8 L=0.15 W=2 nf=1 ad=0.58 as=0.58 pd=4.58 ps=4.58 mult=1 m=1
XMPH_op1_0900_rl_s0p1_r10k vp_op1_0900_rl_s0p1_r10k enb_op1_0900_rl_s0p1_r10k vdd vdd sky130_fd_pr__pfet_01v8 L=0.15 W=4 nf=1 ad=1.16 as=1.16 pd=8.58 ps=8.58 mult=1 m=1
bd_op1_0900_rl_s0p1_r10k d_op1_0900_rl_s0p1_r10k 0 v=v(rbl_op1_0900_rl_s0p1_r10k)-v(ref_op1_0900_rl_s0p1_r10k)

* ---- instance 186: op1_1000_rl_s0p1_r10k (variant rl_s0p1_r10k; probe dec 11.9 ns, release 34 ns, meas 36 ns) ----
vctl_op1_1000_rl_s0p1_r10k ctl_op1_1000_rl_s0p1_r10k 0 pwl(0.0000e+00 {VDD} 2.0000e-09 {VDD} 2.1000e-09 0)
* RWL driver model (EXPERIMENTAL): slew 0.1 ns, series R 10000 ohm; cell pin = rwls_op1_1000_rl_s0p1_r10k
vrs_op1_1000_rl_s0p1_r10k rwlsrc_op1_1000_rl_s0p1_r10k 0 pwl(0.0000e+00 {VDD} 2.0000e-09 {VDD} 2.1000e-09 0 3.4000e-08 0 3.4100e-08 {VDD})
rdrv_op1_1000_rl_s0p1_r10k rwlsrc_op1_1000_rl_s0p1_r10k rwls_op1_1000_rl_s0p1_r10k 10000
ven_op1_1000_rl_s0p1_r10k en_op1_1000_rl_s0p1_r10k 0 pwl(0.0000e+00 0 1.1000e-08 0 1.1100e-08 {VDD} 3.4000e-08 {VDD} 3.4100e-08 0)
venb_op1_1000_rl_s0p1_r10k enb_op1_1000_rl_s0p1_r10k 0 pwl(0.0000e+00 {VDD} 1.1000e-08 {VDD} 1.1100e-08 0 3.4000e-08 0 3.4100e-08 {VDD})
vww_op1_1000_rl_s0p1_r10k wwl_op1_1000_rl_s0p1_r10k 0 pwl(0.0000e+00 0 1.2000e-08 0 1.2100e-08 {VDD} 3.2000e-08 {VDD} 3.2100e-08 0)
vwc_op1_1000_rl_s0p1_r10k wbc_op1_1000_rl_s0p1_r10k 0 pwl(0.0000e+00 0 1.2000e-08 0 1.2100e-08 {VDD} 3.4000e-08 {VDD} 3.4100e-08 0)
swb_op1_1000_rl_s0p1_r10k ref_op1_1000_rl_s0p1_r10k wbl_op1_1000_rl_s0p1_r10k wbc_op1_1000_rl_s0p1_r10k 0 swwbl
cwbl_op1_1000_rl_s0p1_r10k wbl_op1_1000_rl_s0p1_r10k 0 {C_WBL}
spa_op1_1000_rl_s0p1_r10k prea rbl_op1_1000_rl_s0p1_r10k ctl_op1_1000_rl_s0p1_r10k 0 swpre
spr_op1_1000_rl_s0p1_r10k pref ref_op1_1000_rl_s0p1_r10k ctl_op1_1000_rl_s0p1_r10k 0 swpre
crbl_op1_1000_rl_s0p1_r10k rbl_op1_1000_rl_s0p1_r10k 0 {C_RBL}
cref_op1_1000_rl_s0p1_r10k ref_op1_1000_rl_s0p1_r10k 0 {C_RBL}   $ ASSUMPTION: ideal matched dummy load
XMWR_op1_1000_rl_s0p1_r10k_0 sn_op1_1000_rl_s0p1_r10k_0 wwl_op1_1000_rl_s0p1_r10k wbl_op1_1000_rl_s0p1_r10k 0 sky130_fd_pr__nfet_01v8 L=0.15 W=0.42 nf=1 ad=0.1218 as=0.1218 pd=1.42 ps=1.42 nrd=0.69047619047619  nrs=0.69047619047619 sa=0 sb=0 sd=0 mult=1 m=1
XMRD_op1_1000_rl_s0p1_r10k_0 rbl_op1_1000_rl_s0p1_r10k sn_op1_1000_rl_s0p1_r10k_0 rwls_op1_1000_rl_s0p1_r10k 0 sky130_fd_pr__nfet_01v8 L=0.15 W=0.42 nf=1 ad=0.1218 as=0.1218 pd=1.42 ps=1.42 nrd=0.69047619047619  nrs=0.69047619047619 sa=0 sb=0 sd=0 mult=1 m=1
csn_op1_1000_rl_s0p1_r10k_0 sn_op1_1000_rl_s0p1_r10k_0 0 {C_SN}
XMWR_op1_1000_rl_s0p1_r10k_1 sn_op1_1000_rl_s0p1_r10k_1 wwl_des wbl_op1_1000_rl_s0p1_r10k 0 sky130_fd_pr__nfet_01v8 L=0.15 W=0.42 nf=1 ad=0.1218 as=0.1218 pd=1.42 ps=1.42 nrd=0.69047619047619  nrs=0.69047619047619 sa=0 sb=0 sd=0 mult=1 m=1
XMRD_op1_1000_rl_s0p1_r10k_1 rbl_op1_1000_rl_s0p1_r10k sn_op1_1000_rl_s0p1_r10k_1 rwl_des 0 sky130_fd_pr__nfet_01v8 L=0.15 W=0.42 nf=1 ad=0.1218 as=0.1218 pd=1.42 ps=1.42 nrd=0.69047619047619  nrs=0.69047619047619 sa=0 sb=0 sd=0 mult=1 m=1
csn_op1_1000_rl_s0p1_r10k_1 sn_op1_1000_rl_s0p1_r10k_1 0 {C_SN}
XMWR_op1_1000_rl_s0p1_r10k_2 sn_op1_1000_rl_s0p1_r10k_2 wwl_des wbl_op1_1000_rl_s0p1_r10k 0 sky130_fd_pr__nfet_01v8 L=0.15 W=0.42 nf=1 ad=0.1218 as=0.1218 pd=1.42 ps=1.42 nrd=0.69047619047619  nrs=0.69047619047619 sa=0 sb=0 sd=0 mult=1 m=1
XMRD_op1_1000_rl_s0p1_r10k_2 rbl_op1_1000_rl_s0p1_r10k sn_op1_1000_rl_s0p1_r10k_2 rwl_des 0 sky130_fd_pr__nfet_01v8 L=0.15 W=0.42 nf=1 ad=0.1218 as=0.1218 pd=1.42 ps=1.42 nrd=0.69047619047619  nrs=0.69047619047619 sa=0 sb=0 sd=0 mult=1 m=1
csn_op1_1000_rl_s0p1_r10k_2 sn_op1_1000_rl_s0p1_r10k_2 0 {C_SN}
XMWR_op1_1000_rl_s0p1_r10k_3 sn_op1_1000_rl_s0p1_r10k_3 wwl_des wbl_op1_1000_rl_s0p1_r10k 0 sky130_fd_pr__nfet_01v8 L=0.15 W=0.42 nf=1 ad=0.1218 as=0.1218 pd=1.42 ps=1.42 nrd=0.69047619047619  nrs=0.69047619047619 sa=0 sb=0 sd=0 mult=1 m=1
XMRD_op1_1000_rl_s0p1_r10k_3 rbl_op1_1000_rl_s0p1_r10k sn_op1_1000_rl_s0p1_r10k_3 rwl_des 0 sky130_fd_pr__nfet_01v8 L=0.15 W=0.42 nf=1 ad=0.1218 as=0.1218 pd=1.42 ps=1.42 nrd=0.69047619047619  nrs=0.69047619047619 sa=0 sb=0 sd=0 mult=1 m=1
csn_op1_1000_rl_s0p1_r10k_3 sn_op1_1000_rl_s0p1_r10k_3 0 {C_SN}
XMN1_op1_1000_rl_s0p1_r10k rbl_op1_1000_rl_s0p1_r10k ref_op1_1000_rl_s0p1_r10k vn_op1_1000_rl_s0p1_r10k 0 sky130_fd_pr__nfet_01v8 L=0.15 W=1 nf=1 ad=0.29 as=0.29 pd=2.58 ps=2.58 mult=1 m=1
XMN2_op1_1000_rl_s0p1_r10k ref_op1_1000_rl_s0p1_r10k rbl_op1_1000_rl_s0p1_r10k vn_op1_1000_rl_s0p1_r10k 0 sky130_fd_pr__nfet_01v8 L=0.15 W=1 nf=1 ad=0.29 as=0.29 pd=2.58 ps=2.58 mult=1 m=1
XMP1_op1_1000_rl_s0p1_r10k rbl_op1_1000_rl_s0p1_r10k ref_op1_1000_rl_s0p1_r10k vp_op1_1000_rl_s0p1_r10k vdd sky130_fd_pr__pfet_01v8 L=0.15 W=2 nf=1 ad=0.58 as=0.58 pd=4.58 ps=4.58 mult=1 m=1
XMP2_op1_1000_rl_s0p1_r10k ref_op1_1000_rl_s0p1_r10k rbl_op1_1000_rl_s0p1_r10k vp_op1_1000_rl_s0p1_r10k vdd sky130_fd_pr__pfet_01v8 L=0.15 W=2 nf=1 ad=0.58 as=0.58 pd=4.58 ps=4.58 mult=1 m=1
XMNF_op1_1000_rl_s0p1_r10k vn_op1_1000_rl_s0p1_r10k en_op1_1000_rl_s0p1_r10k 0 0 sky130_fd_pr__nfet_01v8 L=0.15 W=2 nf=1 ad=0.58 as=0.58 pd=4.58 ps=4.58 mult=1 m=1
XMPH_op1_1000_rl_s0p1_r10k vp_op1_1000_rl_s0p1_r10k enb_op1_1000_rl_s0p1_r10k vdd vdd sky130_fd_pr__pfet_01v8 L=0.15 W=4 nf=1 ad=1.16 as=1.16 pd=8.58 ps=8.58 mult=1 m=1
bd_op1_1000_rl_s0p1_r10k d_op1_1000_rl_s0p1_r10k 0 v=v(rbl_op1_1000_rl_s0p1_r10k)-v(ref_op1_1000_rl_s0p1_r10k)

* ---- instance 187: op0_n100_rl_s0p1_r10k (variant rl_s0p1_r10k; probe dec 11.9 ns, release 34 ns, meas 36 ns) ----
vctl_op0_n100_rl_s0p1_r10k ctl_op0_n100_rl_s0p1_r10k 0 pwl(0.0000e+00 {VDD} 2.0000e-09 {VDD} 2.1000e-09 0)
* RWL driver model (EXPERIMENTAL): slew 0.1 ns, series R 10000 ohm; cell pin = rwls_op0_n100_rl_s0p1_r10k
vrs_op0_n100_rl_s0p1_r10k rwlsrc_op0_n100_rl_s0p1_r10k 0 pwl(0.0000e+00 {VDD} 2.0000e-09 {VDD} 2.1000e-09 0 3.4000e-08 0 3.4100e-08 {VDD})
rdrv_op0_n100_rl_s0p1_r10k rwlsrc_op0_n100_rl_s0p1_r10k rwls_op0_n100_rl_s0p1_r10k 10000
ven_op0_n100_rl_s0p1_r10k en_op0_n100_rl_s0p1_r10k 0 pwl(0.0000e+00 0 1.1000e-08 0 1.1100e-08 {VDD} 3.4000e-08 {VDD} 3.4100e-08 0)
venb_op0_n100_rl_s0p1_r10k enb_op0_n100_rl_s0p1_r10k 0 pwl(0.0000e+00 {VDD} 1.1000e-08 {VDD} 1.1100e-08 0 3.4000e-08 0 3.4100e-08 {VDD})
vww_op0_n100_rl_s0p1_r10k wwl_op0_n100_rl_s0p1_r10k 0 pwl(0.0000e+00 0 1.2000e-08 0 1.2100e-08 {VDD} 3.2000e-08 {VDD} 3.2100e-08 0)
vwc_op0_n100_rl_s0p1_r10k wbc_op0_n100_rl_s0p1_r10k 0 pwl(0.0000e+00 0 1.2000e-08 0 1.2100e-08 {VDD} 3.4000e-08 {VDD} 3.4100e-08 0)
swb_op0_n100_rl_s0p1_r10k ref_op0_n100_rl_s0p1_r10k wbl_op0_n100_rl_s0p1_r10k wbc_op0_n100_rl_s0p1_r10k 0 swwbl
cwbl_op0_n100_rl_s0p1_r10k wbl_op0_n100_rl_s0p1_r10k 0 {C_WBL}
spa_op0_n100_rl_s0p1_r10k prea rbl_op0_n100_rl_s0p1_r10k ctl_op0_n100_rl_s0p1_r10k 0 swpre
spr_op0_n100_rl_s0p1_r10k pref ref_op0_n100_rl_s0p1_r10k ctl_op0_n100_rl_s0p1_r10k 0 swpre
crbl_op0_n100_rl_s0p1_r10k rbl_op0_n100_rl_s0p1_r10k 0 {C_RBL}
cref_op0_n100_rl_s0p1_r10k ref_op0_n100_rl_s0p1_r10k 0 {C_RBL}   $ ASSUMPTION: ideal matched dummy load
XMWR_op0_n100_rl_s0p1_r10k_0 sn_op0_n100_rl_s0p1_r10k_0 wwl_op0_n100_rl_s0p1_r10k wbl_op0_n100_rl_s0p1_r10k 0 sky130_fd_pr__nfet_01v8 L=0.15 W=0.42 nf=1 ad=0.1218 as=0.1218 pd=1.42 ps=1.42 nrd=0.69047619047619  nrs=0.69047619047619 sa=0 sb=0 sd=0 mult=1 m=1
XMRD_op0_n100_rl_s0p1_r10k_0 rbl_op0_n100_rl_s0p1_r10k sn_op0_n100_rl_s0p1_r10k_0 rwls_op0_n100_rl_s0p1_r10k 0 sky130_fd_pr__nfet_01v8 L=0.15 W=0.42 nf=1 ad=0.1218 as=0.1218 pd=1.42 ps=1.42 nrd=0.69047619047619  nrs=0.69047619047619 sa=0 sb=0 sd=0 mult=1 m=1
csn_op0_n100_rl_s0p1_r10k_0 sn_op0_n100_rl_s0p1_r10k_0 0 {C_SN}
XMWR_op0_n100_rl_s0p1_r10k_1 sn_op0_n100_rl_s0p1_r10k_1 wwl_des wbl_op0_n100_rl_s0p1_r10k 0 sky130_fd_pr__nfet_01v8 L=0.15 W=0.42 nf=1 ad=0.1218 as=0.1218 pd=1.42 ps=1.42 nrd=0.69047619047619  nrs=0.69047619047619 sa=0 sb=0 sd=0 mult=1 m=1
XMRD_op0_n100_rl_s0p1_r10k_1 rbl_op0_n100_rl_s0p1_r10k sn_op0_n100_rl_s0p1_r10k_1 rwl_des 0 sky130_fd_pr__nfet_01v8 L=0.15 W=0.42 nf=1 ad=0.1218 as=0.1218 pd=1.42 ps=1.42 nrd=0.69047619047619  nrs=0.69047619047619 sa=0 sb=0 sd=0 mult=1 m=1
csn_op0_n100_rl_s0p1_r10k_1 sn_op0_n100_rl_s0p1_r10k_1 0 {C_SN}
XMWR_op0_n100_rl_s0p1_r10k_2 sn_op0_n100_rl_s0p1_r10k_2 wwl_des wbl_op0_n100_rl_s0p1_r10k 0 sky130_fd_pr__nfet_01v8 L=0.15 W=0.42 nf=1 ad=0.1218 as=0.1218 pd=1.42 ps=1.42 nrd=0.69047619047619  nrs=0.69047619047619 sa=0 sb=0 sd=0 mult=1 m=1
XMRD_op0_n100_rl_s0p1_r10k_2 rbl_op0_n100_rl_s0p1_r10k sn_op0_n100_rl_s0p1_r10k_2 rwl_des 0 sky130_fd_pr__nfet_01v8 L=0.15 W=0.42 nf=1 ad=0.1218 as=0.1218 pd=1.42 ps=1.42 nrd=0.69047619047619  nrs=0.69047619047619 sa=0 sb=0 sd=0 mult=1 m=1
csn_op0_n100_rl_s0p1_r10k_2 sn_op0_n100_rl_s0p1_r10k_2 0 {C_SN}
XMWR_op0_n100_rl_s0p1_r10k_3 sn_op0_n100_rl_s0p1_r10k_3 wwl_des wbl_op0_n100_rl_s0p1_r10k 0 sky130_fd_pr__nfet_01v8 L=0.15 W=0.42 nf=1 ad=0.1218 as=0.1218 pd=1.42 ps=1.42 nrd=0.69047619047619  nrs=0.69047619047619 sa=0 sb=0 sd=0 mult=1 m=1
XMRD_op0_n100_rl_s0p1_r10k_3 rbl_op0_n100_rl_s0p1_r10k sn_op0_n100_rl_s0p1_r10k_3 rwl_des 0 sky130_fd_pr__nfet_01v8 L=0.15 W=0.42 nf=1 ad=0.1218 as=0.1218 pd=1.42 ps=1.42 nrd=0.69047619047619  nrs=0.69047619047619 sa=0 sb=0 sd=0 mult=1 m=1
csn_op0_n100_rl_s0p1_r10k_3 sn_op0_n100_rl_s0p1_r10k_3 0 {C_SN}
XMN1_op0_n100_rl_s0p1_r10k rbl_op0_n100_rl_s0p1_r10k ref_op0_n100_rl_s0p1_r10k vn_op0_n100_rl_s0p1_r10k 0 sky130_fd_pr__nfet_01v8 L=0.15 W=1 nf=1 ad=0.29 as=0.29 pd=2.58 ps=2.58 mult=1 m=1
XMN2_op0_n100_rl_s0p1_r10k ref_op0_n100_rl_s0p1_r10k rbl_op0_n100_rl_s0p1_r10k vn_op0_n100_rl_s0p1_r10k 0 sky130_fd_pr__nfet_01v8 L=0.15 W=1 nf=1 ad=0.29 as=0.29 pd=2.58 ps=2.58 mult=1 m=1
XMP1_op0_n100_rl_s0p1_r10k rbl_op0_n100_rl_s0p1_r10k ref_op0_n100_rl_s0p1_r10k vp_op0_n100_rl_s0p1_r10k vdd sky130_fd_pr__pfet_01v8 L=0.15 W=2 nf=1 ad=0.58 as=0.58 pd=4.58 ps=4.58 mult=1 m=1
XMP2_op0_n100_rl_s0p1_r10k ref_op0_n100_rl_s0p1_r10k rbl_op0_n100_rl_s0p1_r10k vp_op0_n100_rl_s0p1_r10k vdd sky130_fd_pr__pfet_01v8 L=0.15 W=2 nf=1 ad=0.58 as=0.58 pd=4.58 ps=4.58 mult=1 m=1
XMNF_op0_n100_rl_s0p1_r10k vn_op0_n100_rl_s0p1_r10k en_op0_n100_rl_s0p1_r10k 0 0 sky130_fd_pr__nfet_01v8 L=0.15 W=2 nf=1 ad=0.58 as=0.58 pd=4.58 ps=4.58 mult=1 m=1
XMPH_op0_n100_rl_s0p1_r10k vp_op0_n100_rl_s0p1_r10k enb_op0_n100_rl_s0p1_r10k vdd vdd sky130_fd_pr__pfet_01v8 L=0.15 W=4 nf=1 ad=1.16 as=1.16 pd=8.58 ps=8.58 mult=1 m=1
bd_op0_n100_rl_s0p1_r10k d_op0_n100_rl_s0p1_r10k 0 v=v(rbl_op0_n100_rl_s0p1_r10k)-v(ref_op0_n100_rl_s0p1_r10k)

* ---- instance 188: op0_0000_rl_s0p1_r10k (variant rl_s0p1_r10k; probe dec 11.9 ns, release 34 ns, meas 36 ns) ----
vctl_op0_0000_rl_s0p1_r10k ctl_op0_0000_rl_s0p1_r10k 0 pwl(0.0000e+00 {VDD} 2.0000e-09 {VDD} 2.1000e-09 0)
* RWL driver model (EXPERIMENTAL): slew 0.1 ns, series R 10000 ohm; cell pin = rwls_op0_0000_rl_s0p1_r10k
vrs_op0_0000_rl_s0p1_r10k rwlsrc_op0_0000_rl_s0p1_r10k 0 pwl(0.0000e+00 {VDD} 2.0000e-09 {VDD} 2.1000e-09 0 3.4000e-08 0 3.4100e-08 {VDD})
rdrv_op0_0000_rl_s0p1_r10k rwlsrc_op0_0000_rl_s0p1_r10k rwls_op0_0000_rl_s0p1_r10k 10000
ven_op0_0000_rl_s0p1_r10k en_op0_0000_rl_s0p1_r10k 0 pwl(0.0000e+00 0 1.1000e-08 0 1.1100e-08 {VDD} 3.4000e-08 {VDD} 3.4100e-08 0)
venb_op0_0000_rl_s0p1_r10k enb_op0_0000_rl_s0p1_r10k 0 pwl(0.0000e+00 {VDD} 1.1000e-08 {VDD} 1.1100e-08 0 3.4000e-08 0 3.4100e-08 {VDD})
vww_op0_0000_rl_s0p1_r10k wwl_op0_0000_rl_s0p1_r10k 0 pwl(0.0000e+00 0 1.2000e-08 0 1.2100e-08 {VDD} 3.2000e-08 {VDD} 3.2100e-08 0)
vwc_op0_0000_rl_s0p1_r10k wbc_op0_0000_rl_s0p1_r10k 0 pwl(0.0000e+00 0 1.2000e-08 0 1.2100e-08 {VDD} 3.4000e-08 {VDD} 3.4100e-08 0)
swb_op0_0000_rl_s0p1_r10k ref_op0_0000_rl_s0p1_r10k wbl_op0_0000_rl_s0p1_r10k wbc_op0_0000_rl_s0p1_r10k 0 swwbl
cwbl_op0_0000_rl_s0p1_r10k wbl_op0_0000_rl_s0p1_r10k 0 {C_WBL}
spa_op0_0000_rl_s0p1_r10k prea rbl_op0_0000_rl_s0p1_r10k ctl_op0_0000_rl_s0p1_r10k 0 swpre
spr_op0_0000_rl_s0p1_r10k pref ref_op0_0000_rl_s0p1_r10k ctl_op0_0000_rl_s0p1_r10k 0 swpre
crbl_op0_0000_rl_s0p1_r10k rbl_op0_0000_rl_s0p1_r10k 0 {C_RBL}
cref_op0_0000_rl_s0p1_r10k ref_op0_0000_rl_s0p1_r10k 0 {C_RBL}   $ ASSUMPTION: ideal matched dummy load
XMWR_op0_0000_rl_s0p1_r10k_0 sn_op0_0000_rl_s0p1_r10k_0 wwl_op0_0000_rl_s0p1_r10k wbl_op0_0000_rl_s0p1_r10k 0 sky130_fd_pr__nfet_01v8 L=0.15 W=0.42 nf=1 ad=0.1218 as=0.1218 pd=1.42 ps=1.42 nrd=0.69047619047619  nrs=0.69047619047619 sa=0 sb=0 sd=0 mult=1 m=1
XMRD_op0_0000_rl_s0p1_r10k_0 rbl_op0_0000_rl_s0p1_r10k sn_op0_0000_rl_s0p1_r10k_0 rwls_op0_0000_rl_s0p1_r10k 0 sky130_fd_pr__nfet_01v8 L=0.15 W=0.42 nf=1 ad=0.1218 as=0.1218 pd=1.42 ps=1.42 nrd=0.69047619047619  nrs=0.69047619047619 sa=0 sb=0 sd=0 mult=1 m=1
csn_op0_0000_rl_s0p1_r10k_0 sn_op0_0000_rl_s0p1_r10k_0 0 {C_SN}
XMWR_op0_0000_rl_s0p1_r10k_1 sn_op0_0000_rl_s0p1_r10k_1 wwl_des wbl_op0_0000_rl_s0p1_r10k 0 sky130_fd_pr__nfet_01v8 L=0.15 W=0.42 nf=1 ad=0.1218 as=0.1218 pd=1.42 ps=1.42 nrd=0.69047619047619  nrs=0.69047619047619 sa=0 sb=0 sd=0 mult=1 m=1
XMRD_op0_0000_rl_s0p1_r10k_1 rbl_op0_0000_rl_s0p1_r10k sn_op0_0000_rl_s0p1_r10k_1 rwl_des 0 sky130_fd_pr__nfet_01v8 L=0.15 W=0.42 nf=1 ad=0.1218 as=0.1218 pd=1.42 ps=1.42 nrd=0.69047619047619  nrs=0.69047619047619 sa=0 sb=0 sd=0 mult=1 m=1
csn_op0_0000_rl_s0p1_r10k_1 sn_op0_0000_rl_s0p1_r10k_1 0 {C_SN}
XMWR_op0_0000_rl_s0p1_r10k_2 sn_op0_0000_rl_s0p1_r10k_2 wwl_des wbl_op0_0000_rl_s0p1_r10k 0 sky130_fd_pr__nfet_01v8 L=0.15 W=0.42 nf=1 ad=0.1218 as=0.1218 pd=1.42 ps=1.42 nrd=0.69047619047619  nrs=0.69047619047619 sa=0 sb=0 sd=0 mult=1 m=1
XMRD_op0_0000_rl_s0p1_r10k_2 rbl_op0_0000_rl_s0p1_r10k sn_op0_0000_rl_s0p1_r10k_2 rwl_des 0 sky130_fd_pr__nfet_01v8 L=0.15 W=0.42 nf=1 ad=0.1218 as=0.1218 pd=1.42 ps=1.42 nrd=0.69047619047619  nrs=0.69047619047619 sa=0 sb=0 sd=0 mult=1 m=1
csn_op0_0000_rl_s0p1_r10k_2 sn_op0_0000_rl_s0p1_r10k_2 0 {C_SN}
XMWR_op0_0000_rl_s0p1_r10k_3 sn_op0_0000_rl_s0p1_r10k_3 wwl_des wbl_op0_0000_rl_s0p1_r10k 0 sky130_fd_pr__nfet_01v8 L=0.15 W=0.42 nf=1 ad=0.1218 as=0.1218 pd=1.42 ps=1.42 nrd=0.69047619047619  nrs=0.69047619047619 sa=0 sb=0 sd=0 mult=1 m=1
XMRD_op0_0000_rl_s0p1_r10k_3 rbl_op0_0000_rl_s0p1_r10k sn_op0_0000_rl_s0p1_r10k_3 rwl_des 0 sky130_fd_pr__nfet_01v8 L=0.15 W=0.42 nf=1 ad=0.1218 as=0.1218 pd=1.42 ps=1.42 nrd=0.69047619047619  nrs=0.69047619047619 sa=0 sb=0 sd=0 mult=1 m=1
csn_op0_0000_rl_s0p1_r10k_3 sn_op0_0000_rl_s0p1_r10k_3 0 {C_SN}
XMN1_op0_0000_rl_s0p1_r10k rbl_op0_0000_rl_s0p1_r10k ref_op0_0000_rl_s0p1_r10k vn_op0_0000_rl_s0p1_r10k 0 sky130_fd_pr__nfet_01v8 L=0.15 W=1 nf=1 ad=0.29 as=0.29 pd=2.58 ps=2.58 mult=1 m=1
XMN2_op0_0000_rl_s0p1_r10k ref_op0_0000_rl_s0p1_r10k rbl_op0_0000_rl_s0p1_r10k vn_op0_0000_rl_s0p1_r10k 0 sky130_fd_pr__nfet_01v8 L=0.15 W=1 nf=1 ad=0.29 as=0.29 pd=2.58 ps=2.58 mult=1 m=1
XMP1_op0_0000_rl_s0p1_r10k rbl_op0_0000_rl_s0p1_r10k ref_op0_0000_rl_s0p1_r10k vp_op0_0000_rl_s0p1_r10k vdd sky130_fd_pr__pfet_01v8 L=0.15 W=2 nf=1 ad=0.58 as=0.58 pd=4.58 ps=4.58 mult=1 m=1
XMP2_op0_0000_rl_s0p1_r10k ref_op0_0000_rl_s0p1_r10k rbl_op0_0000_rl_s0p1_r10k vp_op0_0000_rl_s0p1_r10k vdd sky130_fd_pr__pfet_01v8 L=0.15 W=2 nf=1 ad=0.58 as=0.58 pd=4.58 ps=4.58 mult=1 m=1
XMNF_op0_0000_rl_s0p1_r10k vn_op0_0000_rl_s0p1_r10k en_op0_0000_rl_s0p1_r10k 0 0 sky130_fd_pr__nfet_01v8 L=0.15 W=2 nf=1 ad=0.58 as=0.58 pd=4.58 ps=4.58 mult=1 m=1
XMPH_op0_0000_rl_s0p1_r10k vp_op0_0000_rl_s0p1_r10k enb_op0_0000_rl_s0p1_r10k vdd vdd sky130_fd_pr__pfet_01v8 L=0.15 W=4 nf=1 ad=1.16 as=1.16 pd=8.58 ps=8.58 mult=1 m=1
bd_op0_0000_rl_s0p1_r10k d_op0_0000_rl_s0p1_r10k 0 v=v(rbl_op0_0000_rl_s0p1_r10k)-v(ref_op0_0000_rl_s0p1_r10k)

* ---- instance 189: op1_0900_rl_s0p1_r30k (variant rl_s0p1_r30k; probe dec 11.9 ns, release 34 ns, meas 36 ns) ----
vctl_op1_0900_rl_s0p1_r30k ctl_op1_0900_rl_s0p1_r30k 0 pwl(0.0000e+00 {VDD} 2.0000e-09 {VDD} 2.1000e-09 0)
* RWL driver model (EXPERIMENTAL): slew 0.1 ns, series R 30000 ohm; cell pin = rwls_op1_0900_rl_s0p1_r30k
vrs_op1_0900_rl_s0p1_r30k rwlsrc_op1_0900_rl_s0p1_r30k 0 pwl(0.0000e+00 {VDD} 2.0000e-09 {VDD} 2.1000e-09 0 3.4000e-08 0 3.4100e-08 {VDD})
rdrv_op1_0900_rl_s0p1_r30k rwlsrc_op1_0900_rl_s0p1_r30k rwls_op1_0900_rl_s0p1_r30k 30000
ven_op1_0900_rl_s0p1_r30k en_op1_0900_rl_s0p1_r30k 0 pwl(0.0000e+00 0 1.1000e-08 0 1.1100e-08 {VDD} 3.4000e-08 {VDD} 3.4100e-08 0)
venb_op1_0900_rl_s0p1_r30k enb_op1_0900_rl_s0p1_r30k 0 pwl(0.0000e+00 {VDD} 1.1000e-08 {VDD} 1.1100e-08 0 3.4000e-08 0 3.4100e-08 {VDD})
vww_op1_0900_rl_s0p1_r30k wwl_op1_0900_rl_s0p1_r30k 0 pwl(0.0000e+00 0 1.2000e-08 0 1.2100e-08 {VDD} 3.2000e-08 {VDD} 3.2100e-08 0)
vwc_op1_0900_rl_s0p1_r30k wbc_op1_0900_rl_s0p1_r30k 0 pwl(0.0000e+00 0 1.2000e-08 0 1.2100e-08 {VDD} 3.4000e-08 {VDD} 3.4100e-08 0)
swb_op1_0900_rl_s0p1_r30k ref_op1_0900_rl_s0p1_r30k wbl_op1_0900_rl_s0p1_r30k wbc_op1_0900_rl_s0p1_r30k 0 swwbl
cwbl_op1_0900_rl_s0p1_r30k wbl_op1_0900_rl_s0p1_r30k 0 {C_WBL}
spa_op1_0900_rl_s0p1_r30k prea rbl_op1_0900_rl_s0p1_r30k ctl_op1_0900_rl_s0p1_r30k 0 swpre
spr_op1_0900_rl_s0p1_r30k pref ref_op1_0900_rl_s0p1_r30k ctl_op1_0900_rl_s0p1_r30k 0 swpre
crbl_op1_0900_rl_s0p1_r30k rbl_op1_0900_rl_s0p1_r30k 0 {C_RBL}
cref_op1_0900_rl_s0p1_r30k ref_op1_0900_rl_s0p1_r30k 0 {C_RBL}   $ ASSUMPTION: ideal matched dummy load
XMWR_op1_0900_rl_s0p1_r30k_0 sn_op1_0900_rl_s0p1_r30k_0 wwl_op1_0900_rl_s0p1_r30k wbl_op1_0900_rl_s0p1_r30k 0 sky130_fd_pr__nfet_01v8 L=0.15 W=0.42 nf=1 ad=0.1218 as=0.1218 pd=1.42 ps=1.42 nrd=0.69047619047619  nrs=0.69047619047619 sa=0 sb=0 sd=0 mult=1 m=1
XMRD_op1_0900_rl_s0p1_r30k_0 rbl_op1_0900_rl_s0p1_r30k sn_op1_0900_rl_s0p1_r30k_0 rwls_op1_0900_rl_s0p1_r30k 0 sky130_fd_pr__nfet_01v8 L=0.15 W=0.42 nf=1 ad=0.1218 as=0.1218 pd=1.42 ps=1.42 nrd=0.69047619047619  nrs=0.69047619047619 sa=0 sb=0 sd=0 mult=1 m=1
csn_op1_0900_rl_s0p1_r30k_0 sn_op1_0900_rl_s0p1_r30k_0 0 {C_SN}
XMWR_op1_0900_rl_s0p1_r30k_1 sn_op1_0900_rl_s0p1_r30k_1 wwl_des wbl_op1_0900_rl_s0p1_r30k 0 sky130_fd_pr__nfet_01v8 L=0.15 W=0.42 nf=1 ad=0.1218 as=0.1218 pd=1.42 ps=1.42 nrd=0.69047619047619  nrs=0.69047619047619 sa=0 sb=0 sd=0 mult=1 m=1
XMRD_op1_0900_rl_s0p1_r30k_1 rbl_op1_0900_rl_s0p1_r30k sn_op1_0900_rl_s0p1_r30k_1 rwl_des 0 sky130_fd_pr__nfet_01v8 L=0.15 W=0.42 nf=1 ad=0.1218 as=0.1218 pd=1.42 ps=1.42 nrd=0.69047619047619  nrs=0.69047619047619 sa=0 sb=0 sd=0 mult=1 m=1
csn_op1_0900_rl_s0p1_r30k_1 sn_op1_0900_rl_s0p1_r30k_1 0 {C_SN}
XMWR_op1_0900_rl_s0p1_r30k_2 sn_op1_0900_rl_s0p1_r30k_2 wwl_des wbl_op1_0900_rl_s0p1_r30k 0 sky130_fd_pr__nfet_01v8 L=0.15 W=0.42 nf=1 ad=0.1218 as=0.1218 pd=1.42 ps=1.42 nrd=0.69047619047619  nrs=0.69047619047619 sa=0 sb=0 sd=0 mult=1 m=1
XMRD_op1_0900_rl_s0p1_r30k_2 rbl_op1_0900_rl_s0p1_r30k sn_op1_0900_rl_s0p1_r30k_2 rwl_des 0 sky130_fd_pr__nfet_01v8 L=0.15 W=0.42 nf=1 ad=0.1218 as=0.1218 pd=1.42 ps=1.42 nrd=0.69047619047619  nrs=0.69047619047619 sa=0 sb=0 sd=0 mult=1 m=1
csn_op1_0900_rl_s0p1_r30k_2 sn_op1_0900_rl_s0p1_r30k_2 0 {C_SN}
XMWR_op1_0900_rl_s0p1_r30k_3 sn_op1_0900_rl_s0p1_r30k_3 wwl_des wbl_op1_0900_rl_s0p1_r30k 0 sky130_fd_pr__nfet_01v8 L=0.15 W=0.42 nf=1 ad=0.1218 as=0.1218 pd=1.42 ps=1.42 nrd=0.69047619047619  nrs=0.69047619047619 sa=0 sb=0 sd=0 mult=1 m=1
XMRD_op1_0900_rl_s0p1_r30k_3 rbl_op1_0900_rl_s0p1_r30k sn_op1_0900_rl_s0p1_r30k_3 rwl_des 0 sky130_fd_pr__nfet_01v8 L=0.15 W=0.42 nf=1 ad=0.1218 as=0.1218 pd=1.42 ps=1.42 nrd=0.69047619047619  nrs=0.69047619047619 sa=0 sb=0 sd=0 mult=1 m=1
csn_op1_0900_rl_s0p1_r30k_3 sn_op1_0900_rl_s0p1_r30k_3 0 {C_SN}
XMN1_op1_0900_rl_s0p1_r30k rbl_op1_0900_rl_s0p1_r30k ref_op1_0900_rl_s0p1_r30k vn_op1_0900_rl_s0p1_r30k 0 sky130_fd_pr__nfet_01v8 L=0.15 W=1 nf=1 ad=0.29 as=0.29 pd=2.58 ps=2.58 mult=1 m=1
XMN2_op1_0900_rl_s0p1_r30k ref_op1_0900_rl_s0p1_r30k rbl_op1_0900_rl_s0p1_r30k vn_op1_0900_rl_s0p1_r30k 0 sky130_fd_pr__nfet_01v8 L=0.15 W=1 nf=1 ad=0.29 as=0.29 pd=2.58 ps=2.58 mult=1 m=1
XMP1_op1_0900_rl_s0p1_r30k rbl_op1_0900_rl_s0p1_r30k ref_op1_0900_rl_s0p1_r30k vp_op1_0900_rl_s0p1_r30k vdd sky130_fd_pr__pfet_01v8 L=0.15 W=2 nf=1 ad=0.58 as=0.58 pd=4.58 ps=4.58 mult=1 m=1
XMP2_op1_0900_rl_s0p1_r30k ref_op1_0900_rl_s0p1_r30k rbl_op1_0900_rl_s0p1_r30k vp_op1_0900_rl_s0p1_r30k vdd sky130_fd_pr__pfet_01v8 L=0.15 W=2 nf=1 ad=0.58 as=0.58 pd=4.58 ps=4.58 mult=1 m=1
XMNF_op1_0900_rl_s0p1_r30k vn_op1_0900_rl_s0p1_r30k en_op1_0900_rl_s0p1_r30k 0 0 sky130_fd_pr__nfet_01v8 L=0.15 W=2 nf=1 ad=0.58 as=0.58 pd=4.58 ps=4.58 mult=1 m=1
XMPH_op1_0900_rl_s0p1_r30k vp_op1_0900_rl_s0p1_r30k enb_op1_0900_rl_s0p1_r30k vdd vdd sky130_fd_pr__pfet_01v8 L=0.15 W=4 nf=1 ad=1.16 as=1.16 pd=8.58 ps=8.58 mult=1 m=1
bd_op1_0900_rl_s0p1_r30k d_op1_0900_rl_s0p1_r30k 0 v=v(rbl_op1_0900_rl_s0p1_r30k)-v(ref_op1_0900_rl_s0p1_r30k)

* ---- instance 190: op1_1000_rl_s0p1_r30k (variant rl_s0p1_r30k; probe dec 11.9 ns, release 34 ns, meas 36 ns) ----
vctl_op1_1000_rl_s0p1_r30k ctl_op1_1000_rl_s0p1_r30k 0 pwl(0.0000e+00 {VDD} 2.0000e-09 {VDD} 2.1000e-09 0)
* RWL driver model (EXPERIMENTAL): slew 0.1 ns, series R 30000 ohm; cell pin = rwls_op1_1000_rl_s0p1_r30k
vrs_op1_1000_rl_s0p1_r30k rwlsrc_op1_1000_rl_s0p1_r30k 0 pwl(0.0000e+00 {VDD} 2.0000e-09 {VDD} 2.1000e-09 0 3.4000e-08 0 3.4100e-08 {VDD})
rdrv_op1_1000_rl_s0p1_r30k rwlsrc_op1_1000_rl_s0p1_r30k rwls_op1_1000_rl_s0p1_r30k 30000
ven_op1_1000_rl_s0p1_r30k en_op1_1000_rl_s0p1_r30k 0 pwl(0.0000e+00 0 1.1000e-08 0 1.1100e-08 {VDD} 3.4000e-08 {VDD} 3.4100e-08 0)
venb_op1_1000_rl_s0p1_r30k enb_op1_1000_rl_s0p1_r30k 0 pwl(0.0000e+00 {VDD} 1.1000e-08 {VDD} 1.1100e-08 0 3.4000e-08 0 3.4100e-08 {VDD})
vww_op1_1000_rl_s0p1_r30k wwl_op1_1000_rl_s0p1_r30k 0 pwl(0.0000e+00 0 1.2000e-08 0 1.2100e-08 {VDD} 3.2000e-08 {VDD} 3.2100e-08 0)
vwc_op1_1000_rl_s0p1_r30k wbc_op1_1000_rl_s0p1_r30k 0 pwl(0.0000e+00 0 1.2000e-08 0 1.2100e-08 {VDD} 3.4000e-08 {VDD} 3.4100e-08 0)
swb_op1_1000_rl_s0p1_r30k ref_op1_1000_rl_s0p1_r30k wbl_op1_1000_rl_s0p1_r30k wbc_op1_1000_rl_s0p1_r30k 0 swwbl
cwbl_op1_1000_rl_s0p1_r30k wbl_op1_1000_rl_s0p1_r30k 0 {C_WBL}
spa_op1_1000_rl_s0p1_r30k prea rbl_op1_1000_rl_s0p1_r30k ctl_op1_1000_rl_s0p1_r30k 0 swpre
spr_op1_1000_rl_s0p1_r30k pref ref_op1_1000_rl_s0p1_r30k ctl_op1_1000_rl_s0p1_r30k 0 swpre
crbl_op1_1000_rl_s0p1_r30k rbl_op1_1000_rl_s0p1_r30k 0 {C_RBL}
cref_op1_1000_rl_s0p1_r30k ref_op1_1000_rl_s0p1_r30k 0 {C_RBL}   $ ASSUMPTION: ideal matched dummy load
XMWR_op1_1000_rl_s0p1_r30k_0 sn_op1_1000_rl_s0p1_r30k_0 wwl_op1_1000_rl_s0p1_r30k wbl_op1_1000_rl_s0p1_r30k 0 sky130_fd_pr__nfet_01v8 L=0.15 W=0.42 nf=1 ad=0.1218 as=0.1218 pd=1.42 ps=1.42 nrd=0.69047619047619  nrs=0.69047619047619 sa=0 sb=0 sd=0 mult=1 m=1
XMRD_op1_1000_rl_s0p1_r30k_0 rbl_op1_1000_rl_s0p1_r30k sn_op1_1000_rl_s0p1_r30k_0 rwls_op1_1000_rl_s0p1_r30k 0 sky130_fd_pr__nfet_01v8 L=0.15 W=0.42 nf=1 ad=0.1218 as=0.1218 pd=1.42 ps=1.42 nrd=0.69047619047619  nrs=0.69047619047619 sa=0 sb=0 sd=0 mult=1 m=1
csn_op1_1000_rl_s0p1_r30k_0 sn_op1_1000_rl_s0p1_r30k_0 0 {C_SN}
XMWR_op1_1000_rl_s0p1_r30k_1 sn_op1_1000_rl_s0p1_r30k_1 wwl_des wbl_op1_1000_rl_s0p1_r30k 0 sky130_fd_pr__nfet_01v8 L=0.15 W=0.42 nf=1 ad=0.1218 as=0.1218 pd=1.42 ps=1.42 nrd=0.69047619047619  nrs=0.69047619047619 sa=0 sb=0 sd=0 mult=1 m=1
XMRD_op1_1000_rl_s0p1_r30k_1 rbl_op1_1000_rl_s0p1_r30k sn_op1_1000_rl_s0p1_r30k_1 rwl_des 0 sky130_fd_pr__nfet_01v8 L=0.15 W=0.42 nf=1 ad=0.1218 as=0.1218 pd=1.42 ps=1.42 nrd=0.69047619047619  nrs=0.69047619047619 sa=0 sb=0 sd=0 mult=1 m=1
csn_op1_1000_rl_s0p1_r30k_1 sn_op1_1000_rl_s0p1_r30k_1 0 {C_SN}
XMWR_op1_1000_rl_s0p1_r30k_2 sn_op1_1000_rl_s0p1_r30k_2 wwl_des wbl_op1_1000_rl_s0p1_r30k 0 sky130_fd_pr__nfet_01v8 L=0.15 W=0.42 nf=1 ad=0.1218 as=0.1218 pd=1.42 ps=1.42 nrd=0.69047619047619  nrs=0.69047619047619 sa=0 sb=0 sd=0 mult=1 m=1
XMRD_op1_1000_rl_s0p1_r30k_2 rbl_op1_1000_rl_s0p1_r30k sn_op1_1000_rl_s0p1_r30k_2 rwl_des 0 sky130_fd_pr__nfet_01v8 L=0.15 W=0.42 nf=1 ad=0.1218 as=0.1218 pd=1.42 ps=1.42 nrd=0.69047619047619  nrs=0.69047619047619 sa=0 sb=0 sd=0 mult=1 m=1
csn_op1_1000_rl_s0p1_r30k_2 sn_op1_1000_rl_s0p1_r30k_2 0 {C_SN}
XMWR_op1_1000_rl_s0p1_r30k_3 sn_op1_1000_rl_s0p1_r30k_3 wwl_des wbl_op1_1000_rl_s0p1_r30k 0 sky130_fd_pr__nfet_01v8 L=0.15 W=0.42 nf=1 ad=0.1218 as=0.1218 pd=1.42 ps=1.42 nrd=0.69047619047619  nrs=0.69047619047619 sa=0 sb=0 sd=0 mult=1 m=1
XMRD_op1_1000_rl_s0p1_r30k_3 rbl_op1_1000_rl_s0p1_r30k sn_op1_1000_rl_s0p1_r30k_3 rwl_des 0 sky130_fd_pr__nfet_01v8 L=0.15 W=0.42 nf=1 ad=0.1218 as=0.1218 pd=1.42 ps=1.42 nrd=0.69047619047619  nrs=0.69047619047619 sa=0 sb=0 sd=0 mult=1 m=1
csn_op1_1000_rl_s0p1_r30k_3 sn_op1_1000_rl_s0p1_r30k_3 0 {C_SN}
XMN1_op1_1000_rl_s0p1_r30k rbl_op1_1000_rl_s0p1_r30k ref_op1_1000_rl_s0p1_r30k vn_op1_1000_rl_s0p1_r30k 0 sky130_fd_pr__nfet_01v8 L=0.15 W=1 nf=1 ad=0.29 as=0.29 pd=2.58 ps=2.58 mult=1 m=1
XMN2_op1_1000_rl_s0p1_r30k ref_op1_1000_rl_s0p1_r30k rbl_op1_1000_rl_s0p1_r30k vn_op1_1000_rl_s0p1_r30k 0 sky130_fd_pr__nfet_01v8 L=0.15 W=1 nf=1 ad=0.29 as=0.29 pd=2.58 ps=2.58 mult=1 m=1
XMP1_op1_1000_rl_s0p1_r30k rbl_op1_1000_rl_s0p1_r30k ref_op1_1000_rl_s0p1_r30k vp_op1_1000_rl_s0p1_r30k vdd sky130_fd_pr__pfet_01v8 L=0.15 W=2 nf=1 ad=0.58 as=0.58 pd=4.58 ps=4.58 mult=1 m=1
XMP2_op1_1000_rl_s0p1_r30k ref_op1_1000_rl_s0p1_r30k rbl_op1_1000_rl_s0p1_r30k vp_op1_1000_rl_s0p1_r30k vdd sky130_fd_pr__pfet_01v8 L=0.15 W=2 nf=1 ad=0.58 as=0.58 pd=4.58 ps=4.58 mult=1 m=1
XMNF_op1_1000_rl_s0p1_r30k vn_op1_1000_rl_s0p1_r30k en_op1_1000_rl_s0p1_r30k 0 0 sky130_fd_pr__nfet_01v8 L=0.15 W=2 nf=1 ad=0.58 as=0.58 pd=4.58 ps=4.58 mult=1 m=1
XMPH_op1_1000_rl_s0p1_r30k vp_op1_1000_rl_s0p1_r30k enb_op1_1000_rl_s0p1_r30k vdd vdd sky130_fd_pr__pfet_01v8 L=0.15 W=4 nf=1 ad=1.16 as=1.16 pd=8.58 ps=8.58 mult=1 m=1
bd_op1_1000_rl_s0p1_r30k d_op1_1000_rl_s0p1_r30k 0 v=v(rbl_op1_1000_rl_s0p1_r30k)-v(ref_op1_1000_rl_s0p1_r30k)

* ---- instance 191: op0_n100_rl_s0p1_r30k (variant rl_s0p1_r30k; probe dec 11.9 ns, release 34 ns, meas 36 ns) ----
vctl_op0_n100_rl_s0p1_r30k ctl_op0_n100_rl_s0p1_r30k 0 pwl(0.0000e+00 {VDD} 2.0000e-09 {VDD} 2.1000e-09 0)
* RWL driver model (EXPERIMENTAL): slew 0.1 ns, series R 30000 ohm; cell pin = rwls_op0_n100_rl_s0p1_r30k
vrs_op0_n100_rl_s0p1_r30k rwlsrc_op0_n100_rl_s0p1_r30k 0 pwl(0.0000e+00 {VDD} 2.0000e-09 {VDD} 2.1000e-09 0 3.4000e-08 0 3.4100e-08 {VDD})
rdrv_op0_n100_rl_s0p1_r30k rwlsrc_op0_n100_rl_s0p1_r30k rwls_op0_n100_rl_s0p1_r30k 30000
ven_op0_n100_rl_s0p1_r30k en_op0_n100_rl_s0p1_r30k 0 pwl(0.0000e+00 0 1.1000e-08 0 1.1100e-08 {VDD} 3.4000e-08 {VDD} 3.4100e-08 0)
venb_op0_n100_rl_s0p1_r30k enb_op0_n100_rl_s0p1_r30k 0 pwl(0.0000e+00 {VDD} 1.1000e-08 {VDD} 1.1100e-08 0 3.4000e-08 0 3.4100e-08 {VDD})
vww_op0_n100_rl_s0p1_r30k wwl_op0_n100_rl_s0p1_r30k 0 pwl(0.0000e+00 0 1.2000e-08 0 1.2100e-08 {VDD} 3.2000e-08 {VDD} 3.2100e-08 0)
vwc_op0_n100_rl_s0p1_r30k wbc_op0_n100_rl_s0p1_r30k 0 pwl(0.0000e+00 0 1.2000e-08 0 1.2100e-08 {VDD} 3.4000e-08 {VDD} 3.4100e-08 0)
swb_op0_n100_rl_s0p1_r30k ref_op0_n100_rl_s0p1_r30k wbl_op0_n100_rl_s0p1_r30k wbc_op0_n100_rl_s0p1_r30k 0 swwbl
cwbl_op0_n100_rl_s0p1_r30k wbl_op0_n100_rl_s0p1_r30k 0 {C_WBL}
spa_op0_n100_rl_s0p1_r30k prea rbl_op0_n100_rl_s0p1_r30k ctl_op0_n100_rl_s0p1_r30k 0 swpre
spr_op0_n100_rl_s0p1_r30k pref ref_op0_n100_rl_s0p1_r30k ctl_op0_n100_rl_s0p1_r30k 0 swpre
crbl_op0_n100_rl_s0p1_r30k rbl_op0_n100_rl_s0p1_r30k 0 {C_RBL}
cref_op0_n100_rl_s0p1_r30k ref_op0_n100_rl_s0p1_r30k 0 {C_RBL}   $ ASSUMPTION: ideal matched dummy load
XMWR_op0_n100_rl_s0p1_r30k_0 sn_op0_n100_rl_s0p1_r30k_0 wwl_op0_n100_rl_s0p1_r30k wbl_op0_n100_rl_s0p1_r30k 0 sky130_fd_pr__nfet_01v8 L=0.15 W=0.42 nf=1 ad=0.1218 as=0.1218 pd=1.42 ps=1.42 nrd=0.69047619047619  nrs=0.69047619047619 sa=0 sb=0 sd=0 mult=1 m=1
XMRD_op0_n100_rl_s0p1_r30k_0 rbl_op0_n100_rl_s0p1_r30k sn_op0_n100_rl_s0p1_r30k_0 rwls_op0_n100_rl_s0p1_r30k 0 sky130_fd_pr__nfet_01v8 L=0.15 W=0.42 nf=1 ad=0.1218 as=0.1218 pd=1.42 ps=1.42 nrd=0.69047619047619  nrs=0.69047619047619 sa=0 sb=0 sd=0 mult=1 m=1
csn_op0_n100_rl_s0p1_r30k_0 sn_op0_n100_rl_s0p1_r30k_0 0 {C_SN}
XMWR_op0_n100_rl_s0p1_r30k_1 sn_op0_n100_rl_s0p1_r30k_1 wwl_des wbl_op0_n100_rl_s0p1_r30k 0 sky130_fd_pr__nfet_01v8 L=0.15 W=0.42 nf=1 ad=0.1218 as=0.1218 pd=1.42 ps=1.42 nrd=0.69047619047619  nrs=0.69047619047619 sa=0 sb=0 sd=0 mult=1 m=1
XMRD_op0_n100_rl_s0p1_r30k_1 rbl_op0_n100_rl_s0p1_r30k sn_op0_n100_rl_s0p1_r30k_1 rwl_des 0 sky130_fd_pr__nfet_01v8 L=0.15 W=0.42 nf=1 ad=0.1218 as=0.1218 pd=1.42 ps=1.42 nrd=0.69047619047619  nrs=0.69047619047619 sa=0 sb=0 sd=0 mult=1 m=1
csn_op0_n100_rl_s0p1_r30k_1 sn_op0_n100_rl_s0p1_r30k_1 0 {C_SN}
XMWR_op0_n100_rl_s0p1_r30k_2 sn_op0_n100_rl_s0p1_r30k_2 wwl_des wbl_op0_n100_rl_s0p1_r30k 0 sky130_fd_pr__nfet_01v8 L=0.15 W=0.42 nf=1 ad=0.1218 as=0.1218 pd=1.42 ps=1.42 nrd=0.69047619047619  nrs=0.69047619047619 sa=0 sb=0 sd=0 mult=1 m=1
XMRD_op0_n100_rl_s0p1_r30k_2 rbl_op0_n100_rl_s0p1_r30k sn_op0_n100_rl_s0p1_r30k_2 rwl_des 0 sky130_fd_pr__nfet_01v8 L=0.15 W=0.42 nf=1 ad=0.1218 as=0.1218 pd=1.42 ps=1.42 nrd=0.69047619047619  nrs=0.69047619047619 sa=0 sb=0 sd=0 mult=1 m=1
csn_op0_n100_rl_s0p1_r30k_2 sn_op0_n100_rl_s0p1_r30k_2 0 {C_SN}
XMWR_op0_n100_rl_s0p1_r30k_3 sn_op0_n100_rl_s0p1_r30k_3 wwl_des wbl_op0_n100_rl_s0p1_r30k 0 sky130_fd_pr__nfet_01v8 L=0.15 W=0.42 nf=1 ad=0.1218 as=0.1218 pd=1.42 ps=1.42 nrd=0.69047619047619  nrs=0.69047619047619 sa=0 sb=0 sd=0 mult=1 m=1
XMRD_op0_n100_rl_s0p1_r30k_3 rbl_op0_n100_rl_s0p1_r30k sn_op0_n100_rl_s0p1_r30k_3 rwl_des 0 sky130_fd_pr__nfet_01v8 L=0.15 W=0.42 nf=1 ad=0.1218 as=0.1218 pd=1.42 ps=1.42 nrd=0.69047619047619  nrs=0.69047619047619 sa=0 sb=0 sd=0 mult=1 m=1
csn_op0_n100_rl_s0p1_r30k_3 sn_op0_n100_rl_s0p1_r30k_3 0 {C_SN}
XMN1_op0_n100_rl_s0p1_r30k rbl_op0_n100_rl_s0p1_r30k ref_op0_n100_rl_s0p1_r30k vn_op0_n100_rl_s0p1_r30k 0 sky130_fd_pr__nfet_01v8 L=0.15 W=1 nf=1 ad=0.29 as=0.29 pd=2.58 ps=2.58 mult=1 m=1
XMN2_op0_n100_rl_s0p1_r30k ref_op0_n100_rl_s0p1_r30k rbl_op0_n100_rl_s0p1_r30k vn_op0_n100_rl_s0p1_r30k 0 sky130_fd_pr__nfet_01v8 L=0.15 W=1 nf=1 ad=0.29 as=0.29 pd=2.58 ps=2.58 mult=1 m=1
XMP1_op0_n100_rl_s0p1_r30k rbl_op0_n100_rl_s0p1_r30k ref_op0_n100_rl_s0p1_r30k vp_op0_n100_rl_s0p1_r30k vdd sky130_fd_pr__pfet_01v8 L=0.15 W=2 nf=1 ad=0.58 as=0.58 pd=4.58 ps=4.58 mult=1 m=1
XMP2_op0_n100_rl_s0p1_r30k ref_op0_n100_rl_s0p1_r30k rbl_op0_n100_rl_s0p1_r30k vp_op0_n100_rl_s0p1_r30k vdd sky130_fd_pr__pfet_01v8 L=0.15 W=2 nf=1 ad=0.58 as=0.58 pd=4.58 ps=4.58 mult=1 m=1
XMNF_op0_n100_rl_s0p1_r30k vn_op0_n100_rl_s0p1_r30k en_op0_n100_rl_s0p1_r30k 0 0 sky130_fd_pr__nfet_01v8 L=0.15 W=2 nf=1 ad=0.58 as=0.58 pd=4.58 ps=4.58 mult=1 m=1
XMPH_op0_n100_rl_s0p1_r30k vp_op0_n100_rl_s0p1_r30k enb_op0_n100_rl_s0p1_r30k vdd vdd sky130_fd_pr__pfet_01v8 L=0.15 W=4 nf=1 ad=1.16 as=1.16 pd=8.58 ps=8.58 mult=1 m=1
bd_op0_n100_rl_s0p1_r30k d_op0_n100_rl_s0p1_r30k 0 v=v(rbl_op0_n100_rl_s0p1_r30k)-v(ref_op0_n100_rl_s0p1_r30k)

* ---- instance 192: op0_0000_rl_s0p1_r30k (variant rl_s0p1_r30k; probe dec 11.9 ns, release 34 ns, meas 36 ns) ----
vctl_op0_0000_rl_s0p1_r30k ctl_op0_0000_rl_s0p1_r30k 0 pwl(0.0000e+00 {VDD} 2.0000e-09 {VDD} 2.1000e-09 0)
* RWL driver model (EXPERIMENTAL): slew 0.1 ns, series R 30000 ohm; cell pin = rwls_op0_0000_rl_s0p1_r30k
vrs_op0_0000_rl_s0p1_r30k rwlsrc_op0_0000_rl_s0p1_r30k 0 pwl(0.0000e+00 {VDD} 2.0000e-09 {VDD} 2.1000e-09 0 3.4000e-08 0 3.4100e-08 {VDD})
rdrv_op0_0000_rl_s0p1_r30k rwlsrc_op0_0000_rl_s0p1_r30k rwls_op0_0000_rl_s0p1_r30k 30000
ven_op0_0000_rl_s0p1_r30k en_op0_0000_rl_s0p1_r30k 0 pwl(0.0000e+00 0 1.1000e-08 0 1.1100e-08 {VDD} 3.4000e-08 {VDD} 3.4100e-08 0)
venb_op0_0000_rl_s0p1_r30k enb_op0_0000_rl_s0p1_r30k 0 pwl(0.0000e+00 {VDD} 1.1000e-08 {VDD} 1.1100e-08 0 3.4000e-08 0 3.4100e-08 {VDD})
vww_op0_0000_rl_s0p1_r30k wwl_op0_0000_rl_s0p1_r30k 0 pwl(0.0000e+00 0 1.2000e-08 0 1.2100e-08 {VDD} 3.2000e-08 {VDD} 3.2100e-08 0)
vwc_op0_0000_rl_s0p1_r30k wbc_op0_0000_rl_s0p1_r30k 0 pwl(0.0000e+00 0 1.2000e-08 0 1.2100e-08 {VDD} 3.4000e-08 {VDD} 3.4100e-08 0)
swb_op0_0000_rl_s0p1_r30k ref_op0_0000_rl_s0p1_r30k wbl_op0_0000_rl_s0p1_r30k wbc_op0_0000_rl_s0p1_r30k 0 swwbl
cwbl_op0_0000_rl_s0p1_r30k wbl_op0_0000_rl_s0p1_r30k 0 {C_WBL}
spa_op0_0000_rl_s0p1_r30k prea rbl_op0_0000_rl_s0p1_r30k ctl_op0_0000_rl_s0p1_r30k 0 swpre
spr_op0_0000_rl_s0p1_r30k pref ref_op0_0000_rl_s0p1_r30k ctl_op0_0000_rl_s0p1_r30k 0 swpre
crbl_op0_0000_rl_s0p1_r30k rbl_op0_0000_rl_s0p1_r30k 0 {C_RBL}
cref_op0_0000_rl_s0p1_r30k ref_op0_0000_rl_s0p1_r30k 0 {C_RBL}   $ ASSUMPTION: ideal matched dummy load
XMWR_op0_0000_rl_s0p1_r30k_0 sn_op0_0000_rl_s0p1_r30k_0 wwl_op0_0000_rl_s0p1_r30k wbl_op0_0000_rl_s0p1_r30k 0 sky130_fd_pr__nfet_01v8 L=0.15 W=0.42 nf=1 ad=0.1218 as=0.1218 pd=1.42 ps=1.42 nrd=0.69047619047619  nrs=0.69047619047619 sa=0 sb=0 sd=0 mult=1 m=1
XMRD_op0_0000_rl_s0p1_r30k_0 rbl_op0_0000_rl_s0p1_r30k sn_op0_0000_rl_s0p1_r30k_0 rwls_op0_0000_rl_s0p1_r30k 0 sky130_fd_pr__nfet_01v8 L=0.15 W=0.42 nf=1 ad=0.1218 as=0.1218 pd=1.42 ps=1.42 nrd=0.69047619047619  nrs=0.69047619047619 sa=0 sb=0 sd=0 mult=1 m=1
csn_op0_0000_rl_s0p1_r30k_0 sn_op0_0000_rl_s0p1_r30k_0 0 {C_SN}
XMWR_op0_0000_rl_s0p1_r30k_1 sn_op0_0000_rl_s0p1_r30k_1 wwl_des wbl_op0_0000_rl_s0p1_r30k 0 sky130_fd_pr__nfet_01v8 L=0.15 W=0.42 nf=1 ad=0.1218 as=0.1218 pd=1.42 ps=1.42 nrd=0.69047619047619  nrs=0.69047619047619 sa=0 sb=0 sd=0 mult=1 m=1
XMRD_op0_0000_rl_s0p1_r30k_1 rbl_op0_0000_rl_s0p1_r30k sn_op0_0000_rl_s0p1_r30k_1 rwl_des 0 sky130_fd_pr__nfet_01v8 L=0.15 W=0.42 nf=1 ad=0.1218 as=0.1218 pd=1.42 ps=1.42 nrd=0.69047619047619  nrs=0.69047619047619 sa=0 sb=0 sd=0 mult=1 m=1
csn_op0_0000_rl_s0p1_r30k_1 sn_op0_0000_rl_s0p1_r30k_1 0 {C_SN}
XMWR_op0_0000_rl_s0p1_r30k_2 sn_op0_0000_rl_s0p1_r30k_2 wwl_des wbl_op0_0000_rl_s0p1_r30k 0 sky130_fd_pr__nfet_01v8 L=0.15 W=0.42 nf=1 ad=0.1218 as=0.1218 pd=1.42 ps=1.42 nrd=0.69047619047619  nrs=0.69047619047619 sa=0 sb=0 sd=0 mult=1 m=1
XMRD_op0_0000_rl_s0p1_r30k_2 rbl_op0_0000_rl_s0p1_r30k sn_op0_0000_rl_s0p1_r30k_2 rwl_des 0 sky130_fd_pr__nfet_01v8 L=0.15 W=0.42 nf=1 ad=0.1218 as=0.1218 pd=1.42 ps=1.42 nrd=0.69047619047619  nrs=0.69047619047619 sa=0 sb=0 sd=0 mult=1 m=1
csn_op0_0000_rl_s0p1_r30k_2 sn_op0_0000_rl_s0p1_r30k_2 0 {C_SN}
XMWR_op0_0000_rl_s0p1_r30k_3 sn_op0_0000_rl_s0p1_r30k_3 wwl_des wbl_op0_0000_rl_s0p1_r30k 0 sky130_fd_pr__nfet_01v8 L=0.15 W=0.42 nf=1 ad=0.1218 as=0.1218 pd=1.42 ps=1.42 nrd=0.69047619047619  nrs=0.69047619047619 sa=0 sb=0 sd=0 mult=1 m=1
XMRD_op0_0000_rl_s0p1_r30k_3 rbl_op0_0000_rl_s0p1_r30k sn_op0_0000_rl_s0p1_r30k_3 rwl_des 0 sky130_fd_pr__nfet_01v8 L=0.15 W=0.42 nf=1 ad=0.1218 as=0.1218 pd=1.42 ps=1.42 nrd=0.69047619047619  nrs=0.69047619047619 sa=0 sb=0 sd=0 mult=1 m=1
csn_op0_0000_rl_s0p1_r30k_3 sn_op0_0000_rl_s0p1_r30k_3 0 {C_SN}
XMN1_op0_0000_rl_s0p1_r30k rbl_op0_0000_rl_s0p1_r30k ref_op0_0000_rl_s0p1_r30k vn_op0_0000_rl_s0p1_r30k 0 sky130_fd_pr__nfet_01v8 L=0.15 W=1 nf=1 ad=0.29 as=0.29 pd=2.58 ps=2.58 mult=1 m=1
XMN2_op0_0000_rl_s0p1_r30k ref_op0_0000_rl_s0p1_r30k rbl_op0_0000_rl_s0p1_r30k vn_op0_0000_rl_s0p1_r30k 0 sky130_fd_pr__nfet_01v8 L=0.15 W=1 nf=1 ad=0.29 as=0.29 pd=2.58 ps=2.58 mult=1 m=1
XMP1_op0_0000_rl_s0p1_r30k rbl_op0_0000_rl_s0p1_r30k ref_op0_0000_rl_s0p1_r30k vp_op0_0000_rl_s0p1_r30k vdd sky130_fd_pr__pfet_01v8 L=0.15 W=2 nf=1 ad=0.58 as=0.58 pd=4.58 ps=4.58 mult=1 m=1
XMP2_op0_0000_rl_s0p1_r30k ref_op0_0000_rl_s0p1_r30k rbl_op0_0000_rl_s0p1_r30k vp_op0_0000_rl_s0p1_r30k vdd sky130_fd_pr__pfet_01v8 L=0.15 W=2 nf=1 ad=0.58 as=0.58 pd=4.58 ps=4.58 mult=1 m=1
XMNF_op0_0000_rl_s0p1_r30k vn_op0_0000_rl_s0p1_r30k en_op0_0000_rl_s0p1_r30k 0 0 sky130_fd_pr__nfet_01v8 L=0.15 W=2 nf=1 ad=0.58 as=0.58 pd=4.58 ps=4.58 mult=1 m=1
XMPH_op0_0000_rl_s0p1_r30k vp_op0_0000_rl_s0p1_r30k enb_op0_0000_rl_s0p1_r30k vdd vdd sky130_fd_pr__pfet_01v8 L=0.15 W=4 nf=1 ad=1.16 as=1.16 pd=8.58 ps=8.58 mult=1 m=1
bd_op0_0000_rl_s0p1_r30k d_op0_0000_rl_s0p1_r30k 0 v=v(rbl_op0_0000_rl_s0p1_r30k)-v(ref_op0_0000_rl_s0p1_r30k)

* ---- instance 193: op1_0900_rl_s0p1_r100k (variant rl_s0p1_r100k; probe dec 11.9 ns, release 34 ns, meas 36 ns) ----
vctl_op1_0900_rl_s0p1_r100k ctl_op1_0900_rl_s0p1_r100k 0 pwl(0.0000e+00 {VDD} 2.0000e-09 {VDD} 2.1000e-09 0)
* RWL driver model (EXPERIMENTAL): slew 0.1 ns, series R 100000 ohm; cell pin = rwls_op1_0900_rl_s0p1_r100k
vrs_op1_0900_rl_s0p1_r100k rwlsrc_op1_0900_rl_s0p1_r100k 0 pwl(0.0000e+00 {VDD} 2.0000e-09 {VDD} 2.1000e-09 0 3.4000e-08 0 3.4100e-08 {VDD})
rdrv_op1_0900_rl_s0p1_r100k rwlsrc_op1_0900_rl_s0p1_r100k rwls_op1_0900_rl_s0p1_r100k 100000
ven_op1_0900_rl_s0p1_r100k en_op1_0900_rl_s0p1_r100k 0 pwl(0.0000e+00 0 1.1000e-08 0 1.1100e-08 {VDD} 3.4000e-08 {VDD} 3.4100e-08 0)
venb_op1_0900_rl_s0p1_r100k enb_op1_0900_rl_s0p1_r100k 0 pwl(0.0000e+00 {VDD} 1.1000e-08 {VDD} 1.1100e-08 0 3.4000e-08 0 3.4100e-08 {VDD})
vww_op1_0900_rl_s0p1_r100k wwl_op1_0900_rl_s0p1_r100k 0 pwl(0.0000e+00 0 1.2000e-08 0 1.2100e-08 {VDD} 3.2000e-08 {VDD} 3.2100e-08 0)
vwc_op1_0900_rl_s0p1_r100k wbc_op1_0900_rl_s0p1_r100k 0 pwl(0.0000e+00 0 1.2000e-08 0 1.2100e-08 {VDD} 3.4000e-08 {VDD} 3.4100e-08 0)
swb_op1_0900_rl_s0p1_r100k ref_op1_0900_rl_s0p1_r100k wbl_op1_0900_rl_s0p1_r100k wbc_op1_0900_rl_s0p1_r100k 0 swwbl
cwbl_op1_0900_rl_s0p1_r100k wbl_op1_0900_rl_s0p1_r100k 0 {C_WBL}
spa_op1_0900_rl_s0p1_r100k prea rbl_op1_0900_rl_s0p1_r100k ctl_op1_0900_rl_s0p1_r100k 0 swpre
spr_op1_0900_rl_s0p1_r100k pref ref_op1_0900_rl_s0p1_r100k ctl_op1_0900_rl_s0p1_r100k 0 swpre
crbl_op1_0900_rl_s0p1_r100k rbl_op1_0900_rl_s0p1_r100k 0 {C_RBL}
cref_op1_0900_rl_s0p1_r100k ref_op1_0900_rl_s0p1_r100k 0 {C_RBL}   $ ASSUMPTION: ideal matched dummy load
XMWR_op1_0900_rl_s0p1_r100k_0 sn_op1_0900_rl_s0p1_r100k_0 wwl_op1_0900_rl_s0p1_r100k wbl_op1_0900_rl_s0p1_r100k 0 sky130_fd_pr__nfet_01v8 L=0.15 W=0.42 nf=1 ad=0.1218 as=0.1218 pd=1.42 ps=1.42 nrd=0.69047619047619  nrs=0.69047619047619 sa=0 sb=0 sd=0 mult=1 m=1
XMRD_op1_0900_rl_s0p1_r100k_0 rbl_op1_0900_rl_s0p1_r100k sn_op1_0900_rl_s0p1_r100k_0 rwls_op1_0900_rl_s0p1_r100k 0 sky130_fd_pr__nfet_01v8 L=0.15 W=0.42 nf=1 ad=0.1218 as=0.1218 pd=1.42 ps=1.42 nrd=0.69047619047619  nrs=0.69047619047619 sa=0 sb=0 sd=0 mult=1 m=1
csn_op1_0900_rl_s0p1_r100k_0 sn_op1_0900_rl_s0p1_r100k_0 0 {C_SN}
XMWR_op1_0900_rl_s0p1_r100k_1 sn_op1_0900_rl_s0p1_r100k_1 wwl_des wbl_op1_0900_rl_s0p1_r100k 0 sky130_fd_pr__nfet_01v8 L=0.15 W=0.42 nf=1 ad=0.1218 as=0.1218 pd=1.42 ps=1.42 nrd=0.69047619047619  nrs=0.69047619047619 sa=0 sb=0 sd=0 mult=1 m=1
XMRD_op1_0900_rl_s0p1_r100k_1 rbl_op1_0900_rl_s0p1_r100k sn_op1_0900_rl_s0p1_r100k_1 rwl_des 0 sky130_fd_pr__nfet_01v8 L=0.15 W=0.42 nf=1 ad=0.1218 as=0.1218 pd=1.42 ps=1.42 nrd=0.69047619047619  nrs=0.69047619047619 sa=0 sb=0 sd=0 mult=1 m=1
csn_op1_0900_rl_s0p1_r100k_1 sn_op1_0900_rl_s0p1_r100k_1 0 {C_SN}
XMWR_op1_0900_rl_s0p1_r100k_2 sn_op1_0900_rl_s0p1_r100k_2 wwl_des wbl_op1_0900_rl_s0p1_r100k 0 sky130_fd_pr__nfet_01v8 L=0.15 W=0.42 nf=1 ad=0.1218 as=0.1218 pd=1.42 ps=1.42 nrd=0.69047619047619  nrs=0.69047619047619 sa=0 sb=0 sd=0 mult=1 m=1
XMRD_op1_0900_rl_s0p1_r100k_2 rbl_op1_0900_rl_s0p1_r100k sn_op1_0900_rl_s0p1_r100k_2 rwl_des 0 sky130_fd_pr__nfet_01v8 L=0.15 W=0.42 nf=1 ad=0.1218 as=0.1218 pd=1.42 ps=1.42 nrd=0.69047619047619  nrs=0.69047619047619 sa=0 sb=0 sd=0 mult=1 m=1
csn_op1_0900_rl_s0p1_r100k_2 sn_op1_0900_rl_s0p1_r100k_2 0 {C_SN}
XMWR_op1_0900_rl_s0p1_r100k_3 sn_op1_0900_rl_s0p1_r100k_3 wwl_des wbl_op1_0900_rl_s0p1_r100k 0 sky130_fd_pr__nfet_01v8 L=0.15 W=0.42 nf=1 ad=0.1218 as=0.1218 pd=1.42 ps=1.42 nrd=0.69047619047619  nrs=0.69047619047619 sa=0 sb=0 sd=0 mult=1 m=1
XMRD_op1_0900_rl_s0p1_r100k_3 rbl_op1_0900_rl_s0p1_r100k sn_op1_0900_rl_s0p1_r100k_3 rwl_des 0 sky130_fd_pr__nfet_01v8 L=0.15 W=0.42 nf=1 ad=0.1218 as=0.1218 pd=1.42 ps=1.42 nrd=0.69047619047619  nrs=0.69047619047619 sa=0 sb=0 sd=0 mult=1 m=1
csn_op1_0900_rl_s0p1_r100k_3 sn_op1_0900_rl_s0p1_r100k_3 0 {C_SN}
XMN1_op1_0900_rl_s0p1_r100k rbl_op1_0900_rl_s0p1_r100k ref_op1_0900_rl_s0p1_r100k vn_op1_0900_rl_s0p1_r100k 0 sky130_fd_pr__nfet_01v8 L=0.15 W=1 nf=1 ad=0.29 as=0.29 pd=2.58 ps=2.58 mult=1 m=1
XMN2_op1_0900_rl_s0p1_r100k ref_op1_0900_rl_s0p1_r100k rbl_op1_0900_rl_s0p1_r100k vn_op1_0900_rl_s0p1_r100k 0 sky130_fd_pr__nfet_01v8 L=0.15 W=1 nf=1 ad=0.29 as=0.29 pd=2.58 ps=2.58 mult=1 m=1
XMP1_op1_0900_rl_s0p1_r100k rbl_op1_0900_rl_s0p1_r100k ref_op1_0900_rl_s0p1_r100k vp_op1_0900_rl_s0p1_r100k vdd sky130_fd_pr__pfet_01v8 L=0.15 W=2 nf=1 ad=0.58 as=0.58 pd=4.58 ps=4.58 mult=1 m=1
XMP2_op1_0900_rl_s0p1_r100k ref_op1_0900_rl_s0p1_r100k rbl_op1_0900_rl_s0p1_r100k vp_op1_0900_rl_s0p1_r100k vdd sky130_fd_pr__pfet_01v8 L=0.15 W=2 nf=1 ad=0.58 as=0.58 pd=4.58 ps=4.58 mult=1 m=1
XMNF_op1_0900_rl_s0p1_r100k vn_op1_0900_rl_s0p1_r100k en_op1_0900_rl_s0p1_r100k 0 0 sky130_fd_pr__nfet_01v8 L=0.15 W=2 nf=1 ad=0.58 as=0.58 pd=4.58 ps=4.58 mult=1 m=1
XMPH_op1_0900_rl_s0p1_r100k vp_op1_0900_rl_s0p1_r100k enb_op1_0900_rl_s0p1_r100k vdd vdd sky130_fd_pr__pfet_01v8 L=0.15 W=4 nf=1 ad=1.16 as=1.16 pd=8.58 ps=8.58 mult=1 m=1
bd_op1_0900_rl_s0p1_r100k d_op1_0900_rl_s0p1_r100k 0 v=v(rbl_op1_0900_rl_s0p1_r100k)-v(ref_op1_0900_rl_s0p1_r100k)

* ---- instance 194: op1_1000_rl_s0p1_r100k (variant rl_s0p1_r100k; probe dec 11.9 ns, release 34 ns, meas 36 ns) ----
vctl_op1_1000_rl_s0p1_r100k ctl_op1_1000_rl_s0p1_r100k 0 pwl(0.0000e+00 {VDD} 2.0000e-09 {VDD} 2.1000e-09 0)
* RWL driver model (EXPERIMENTAL): slew 0.1 ns, series R 100000 ohm; cell pin = rwls_op1_1000_rl_s0p1_r100k
vrs_op1_1000_rl_s0p1_r100k rwlsrc_op1_1000_rl_s0p1_r100k 0 pwl(0.0000e+00 {VDD} 2.0000e-09 {VDD} 2.1000e-09 0 3.4000e-08 0 3.4100e-08 {VDD})
rdrv_op1_1000_rl_s0p1_r100k rwlsrc_op1_1000_rl_s0p1_r100k rwls_op1_1000_rl_s0p1_r100k 100000
ven_op1_1000_rl_s0p1_r100k en_op1_1000_rl_s0p1_r100k 0 pwl(0.0000e+00 0 1.1000e-08 0 1.1100e-08 {VDD} 3.4000e-08 {VDD} 3.4100e-08 0)
venb_op1_1000_rl_s0p1_r100k enb_op1_1000_rl_s0p1_r100k 0 pwl(0.0000e+00 {VDD} 1.1000e-08 {VDD} 1.1100e-08 0 3.4000e-08 0 3.4100e-08 {VDD})
vww_op1_1000_rl_s0p1_r100k wwl_op1_1000_rl_s0p1_r100k 0 pwl(0.0000e+00 0 1.2000e-08 0 1.2100e-08 {VDD} 3.2000e-08 {VDD} 3.2100e-08 0)
vwc_op1_1000_rl_s0p1_r100k wbc_op1_1000_rl_s0p1_r100k 0 pwl(0.0000e+00 0 1.2000e-08 0 1.2100e-08 {VDD} 3.4000e-08 {VDD} 3.4100e-08 0)
swb_op1_1000_rl_s0p1_r100k ref_op1_1000_rl_s0p1_r100k wbl_op1_1000_rl_s0p1_r100k wbc_op1_1000_rl_s0p1_r100k 0 swwbl
cwbl_op1_1000_rl_s0p1_r100k wbl_op1_1000_rl_s0p1_r100k 0 {C_WBL}
spa_op1_1000_rl_s0p1_r100k prea rbl_op1_1000_rl_s0p1_r100k ctl_op1_1000_rl_s0p1_r100k 0 swpre
spr_op1_1000_rl_s0p1_r100k pref ref_op1_1000_rl_s0p1_r100k ctl_op1_1000_rl_s0p1_r100k 0 swpre
crbl_op1_1000_rl_s0p1_r100k rbl_op1_1000_rl_s0p1_r100k 0 {C_RBL}
cref_op1_1000_rl_s0p1_r100k ref_op1_1000_rl_s0p1_r100k 0 {C_RBL}   $ ASSUMPTION: ideal matched dummy load
XMWR_op1_1000_rl_s0p1_r100k_0 sn_op1_1000_rl_s0p1_r100k_0 wwl_op1_1000_rl_s0p1_r100k wbl_op1_1000_rl_s0p1_r100k 0 sky130_fd_pr__nfet_01v8 L=0.15 W=0.42 nf=1 ad=0.1218 as=0.1218 pd=1.42 ps=1.42 nrd=0.69047619047619  nrs=0.69047619047619 sa=0 sb=0 sd=0 mult=1 m=1
XMRD_op1_1000_rl_s0p1_r100k_0 rbl_op1_1000_rl_s0p1_r100k sn_op1_1000_rl_s0p1_r100k_0 rwls_op1_1000_rl_s0p1_r100k 0 sky130_fd_pr__nfet_01v8 L=0.15 W=0.42 nf=1 ad=0.1218 as=0.1218 pd=1.42 ps=1.42 nrd=0.69047619047619  nrs=0.69047619047619 sa=0 sb=0 sd=0 mult=1 m=1
csn_op1_1000_rl_s0p1_r100k_0 sn_op1_1000_rl_s0p1_r100k_0 0 {C_SN}
XMWR_op1_1000_rl_s0p1_r100k_1 sn_op1_1000_rl_s0p1_r100k_1 wwl_des wbl_op1_1000_rl_s0p1_r100k 0 sky130_fd_pr__nfet_01v8 L=0.15 W=0.42 nf=1 ad=0.1218 as=0.1218 pd=1.42 ps=1.42 nrd=0.69047619047619  nrs=0.69047619047619 sa=0 sb=0 sd=0 mult=1 m=1
XMRD_op1_1000_rl_s0p1_r100k_1 rbl_op1_1000_rl_s0p1_r100k sn_op1_1000_rl_s0p1_r100k_1 rwl_des 0 sky130_fd_pr__nfet_01v8 L=0.15 W=0.42 nf=1 ad=0.1218 as=0.1218 pd=1.42 ps=1.42 nrd=0.69047619047619  nrs=0.69047619047619 sa=0 sb=0 sd=0 mult=1 m=1
csn_op1_1000_rl_s0p1_r100k_1 sn_op1_1000_rl_s0p1_r100k_1 0 {C_SN}
XMWR_op1_1000_rl_s0p1_r100k_2 sn_op1_1000_rl_s0p1_r100k_2 wwl_des wbl_op1_1000_rl_s0p1_r100k 0 sky130_fd_pr__nfet_01v8 L=0.15 W=0.42 nf=1 ad=0.1218 as=0.1218 pd=1.42 ps=1.42 nrd=0.69047619047619  nrs=0.69047619047619 sa=0 sb=0 sd=0 mult=1 m=1
XMRD_op1_1000_rl_s0p1_r100k_2 rbl_op1_1000_rl_s0p1_r100k sn_op1_1000_rl_s0p1_r100k_2 rwl_des 0 sky130_fd_pr__nfet_01v8 L=0.15 W=0.42 nf=1 ad=0.1218 as=0.1218 pd=1.42 ps=1.42 nrd=0.69047619047619  nrs=0.69047619047619 sa=0 sb=0 sd=0 mult=1 m=1
csn_op1_1000_rl_s0p1_r100k_2 sn_op1_1000_rl_s0p1_r100k_2 0 {C_SN}
XMWR_op1_1000_rl_s0p1_r100k_3 sn_op1_1000_rl_s0p1_r100k_3 wwl_des wbl_op1_1000_rl_s0p1_r100k 0 sky130_fd_pr__nfet_01v8 L=0.15 W=0.42 nf=1 ad=0.1218 as=0.1218 pd=1.42 ps=1.42 nrd=0.69047619047619  nrs=0.69047619047619 sa=0 sb=0 sd=0 mult=1 m=1
XMRD_op1_1000_rl_s0p1_r100k_3 rbl_op1_1000_rl_s0p1_r100k sn_op1_1000_rl_s0p1_r100k_3 rwl_des 0 sky130_fd_pr__nfet_01v8 L=0.15 W=0.42 nf=1 ad=0.1218 as=0.1218 pd=1.42 ps=1.42 nrd=0.69047619047619  nrs=0.69047619047619 sa=0 sb=0 sd=0 mult=1 m=1
csn_op1_1000_rl_s0p1_r100k_3 sn_op1_1000_rl_s0p1_r100k_3 0 {C_SN}
XMN1_op1_1000_rl_s0p1_r100k rbl_op1_1000_rl_s0p1_r100k ref_op1_1000_rl_s0p1_r100k vn_op1_1000_rl_s0p1_r100k 0 sky130_fd_pr__nfet_01v8 L=0.15 W=1 nf=1 ad=0.29 as=0.29 pd=2.58 ps=2.58 mult=1 m=1
XMN2_op1_1000_rl_s0p1_r100k ref_op1_1000_rl_s0p1_r100k rbl_op1_1000_rl_s0p1_r100k vn_op1_1000_rl_s0p1_r100k 0 sky130_fd_pr__nfet_01v8 L=0.15 W=1 nf=1 ad=0.29 as=0.29 pd=2.58 ps=2.58 mult=1 m=1
XMP1_op1_1000_rl_s0p1_r100k rbl_op1_1000_rl_s0p1_r100k ref_op1_1000_rl_s0p1_r100k vp_op1_1000_rl_s0p1_r100k vdd sky130_fd_pr__pfet_01v8 L=0.15 W=2 nf=1 ad=0.58 as=0.58 pd=4.58 ps=4.58 mult=1 m=1
XMP2_op1_1000_rl_s0p1_r100k ref_op1_1000_rl_s0p1_r100k rbl_op1_1000_rl_s0p1_r100k vp_op1_1000_rl_s0p1_r100k vdd sky130_fd_pr__pfet_01v8 L=0.15 W=2 nf=1 ad=0.58 as=0.58 pd=4.58 ps=4.58 mult=1 m=1
XMNF_op1_1000_rl_s0p1_r100k vn_op1_1000_rl_s0p1_r100k en_op1_1000_rl_s0p1_r100k 0 0 sky130_fd_pr__nfet_01v8 L=0.15 W=2 nf=1 ad=0.58 as=0.58 pd=4.58 ps=4.58 mult=1 m=1
XMPH_op1_1000_rl_s0p1_r100k vp_op1_1000_rl_s0p1_r100k enb_op1_1000_rl_s0p1_r100k vdd vdd sky130_fd_pr__pfet_01v8 L=0.15 W=4 nf=1 ad=1.16 as=1.16 pd=8.58 ps=8.58 mult=1 m=1
bd_op1_1000_rl_s0p1_r100k d_op1_1000_rl_s0p1_r100k 0 v=v(rbl_op1_1000_rl_s0p1_r100k)-v(ref_op1_1000_rl_s0p1_r100k)

* ---- instance 195: op0_n100_rl_s0p1_r100k (variant rl_s0p1_r100k; probe dec 11.9 ns, release 34 ns, meas 36 ns) ----
vctl_op0_n100_rl_s0p1_r100k ctl_op0_n100_rl_s0p1_r100k 0 pwl(0.0000e+00 {VDD} 2.0000e-09 {VDD} 2.1000e-09 0)
* RWL driver model (EXPERIMENTAL): slew 0.1 ns, series R 100000 ohm; cell pin = rwls_op0_n100_rl_s0p1_r100k
vrs_op0_n100_rl_s0p1_r100k rwlsrc_op0_n100_rl_s0p1_r100k 0 pwl(0.0000e+00 {VDD} 2.0000e-09 {VDD} 2.1000e-09 0 3.4000e-08 0 3.4100e-08 {VDD})
rdrv_op0_n100_rl_s0p1_r100k rwlsrc_op0_n100_rl_s0p1_r100k rwls_op0_n100_rl_s0p1_r100k 100000
ven_op0_n100_rl_s0p1_r100k en_op0_n100_rl_s0p1_r100k 0 pwl(0.0000e+00 0 1.1000e-08 0 1.1100e-08 {VDD} 3.4000e-08 {VDD} 3.4100e-08 0)
venb_op0_n100_rl_s0p1_r100k enb_op0_n100_rl_s0p1_r100k 0 pwl(0.0000e+00 {VDD} 1.1000e-08 {VDD} 1.1100e-08 0 3.4000e-08 0 3.4100e-08 {VDD})
vww_op0_n100_rl_s0p1_r100k wwl_op0_n100_rl_s0p1_r100k 0 pwl(0.0000e+00 0 1.2000e-08 0 1.2100e-08 {VDD} 3.2000e-08 {VDD} 3.2100e-08 0)
vwc_op0_n100_rl_s0p1_r100k wbc_op0_n100_rl_s0p1_r100k 0 pwl(0.0000e+00 0 1.2000e-08 0 1.2100e-08 {VDD} 3.4000e-08 {VDD} 3.4100e-08 0)
swb_op0_n100_rl_s0p1_r100k ref_op0_n100_rl_s0p1_r100k wbl_op0_n100_rl_s0p1_r100k wbc_op0_n100_rl_s0p1_r100k 0 swwbl
cwbl_op0_n100_rl_s0p1_r100k wbl_op0_n100_rl_s0p1_r100k 0 {C_WBL}
spa_op0_n100_rl_s0p1_r100k prea rbl_op0_n100_rl_s0p1_r100k ctl_op0_n100_rl_s0p1_r100k 0 swpre
spr_op0_n100_rl_s0p1_r100k pref ref_op0_n100_rl_s0p1_r100k ctl_op0_n100_rl_s0p1_r100k 0 swpre
crbl_op0_n100_rl_s0p1_r100k rbl_op0_n100_rl_s0p1_r100k 0 {C_RBL}
cref_op0_n100_rl_s0p1_r100k ref_op0_n100_rl_s0p1_r100k 0 {C_RBL}   $ ASSUMPTION: ideal matched dummy load
XMWR_op0_n100_rl_s0p1_r100k_0 sn_op0_n100_rl_s0p1_r100k_0 wwl_op0_n100_rl_s0p1_r100k wbl_op0_n100_rl_s0p1_r100k 0 sky130_fd_pr__nfet_01v8 L=0.15 W=0.42 nf=1 ad=0.1218 as=0.1218 pd=1.42 ps=1.42 nrd=0.69047619047619  nrs=0.69047619047619 sa=0 sb=0 sd=0 mult=1 m=1
XMRD_op0_n100_rl_s0p1_r100k_0 rbl_op0_n100_rl_s0p1_r100k sn_op0_n100_rl_s0p1_r100k_0 rwls_op0_n100_rl_s0p1_r100k 0 sky130_fd_pr__nfet_01v8 L=0.15 W=0.42 nf=1 ad=0.1218 as=0.1218 pd=1.42 ps=1.42 nrd=0.69047619047619  nrs=0.69047619047619 sa=0 sb=0 sd=0 mult=1 m=1
csn_op0_n100_rl_s0p1_r100k_0 sn_op0_n100_rl_s0p1_r100k_0 0 {C_SN}
XMWR_op0_n100_rl_s0p1_r100k_1 sn_op0_n100_rl_s0p1_r100k_1 wwl_des wbl_op0_n100_rl_s0p1_r100k 0 sky130_fd_pr__nfet_01v8 L=0.15 W=0.42 nf=1 ad=0.1218 as=0.1218 pd=1.42 ps=1.42 nrd=0.69047619047619  nrs=0.69047619047619 sa=0 sb=0 sd=0 mult=1 m=1
XMRD_op0_n100_rl_s0p1_r100k_1 rbl_op0_n100_rl_s0p1_r100k sn_op0_n100_rl_s0p1_r100k_1 rwl_des 0 sky130_fd_pr__nfet_01v8 L=0.15 W=0.42 nf=1 ad=0.1218 as=0.1218 pd=1.42 ps=1.42 nrd=0.69047619047619  nrs=0.69047619047619 sa=0 sb=0 sd=0 mult=1 m=1
csn_op0_n100_rl_s0p1_r100k_1 sn_op0_n100_rl_s0p1_r100k_1 0 {C_SN}
XMWR_op0_n100_rl_s0p1_r100k_2 sn_op0_n100_rl_s0p1_r100k_2 wwl_des wbl_op0_n100_rl_s0p1_r100k 0 sky130_fd_pr__nfet_01v8 L=0.15 W=0.42 nf=1 ad=0.1218 as=0.1218 pd=1.42 ps=1.42 nrd=0.69047619047619  nrs=0.69047619047619 sa=0 sb=0 sd=0 mult=1 m=1
XMRD_op0_n100_rl_s0p1_r100k_2 rbl_op0_n100_rl_s0p1_r100k sn_op0_n100_rl_s0p1_r100k_2 rwl_des 0 sky130_fd_pr__nfet_01v8 L=0.15 W=0.42 nf=1 ad=0.1218 as=0.1218 pd=1.42 ps=1.42 nrd=0.69047619047619  nrs=0.69047619047619 sa=0 sb=0 sd=0 mult=1 m=1
csn_op0_n100_rl_s0p1_r100k_2 sn_op0_n100_rl_s0p1_r100k_2 0 {C_SN}
XMWR_op0_n100_rl_s0p1_r100k_3 sn_op0_n100_rl_s0p1_r100k_3 wwl_des wbl_op0_n100_rl_s0p1_r100k 0 sky130_fd_pr__nfet_01v8 L=0.15 W=0.42 nf=1 ad=0.1218 as=0.1218 pd=1.42 ps=1.42 nrd=0.69047619047619  nrs=0.69047619047619 sa=0 sb=0 sd=0 mult=1 m=1
XMRD_op0_n100_rl_s0p1_r100k_3 rbl_op0_n100_rl_s0p1_r100k sn_op0_n100_rl_s0p1_r100k_3 rwl_des 0 sky130_fd_pr__nfet_01v8 L=0.15 W=0.42 nf=1 ad=0.1218 as=0.1218 pd=1.42 ps=1.42 nrd=0.69047619047619  nrs=0.69047619047619 sa=0 sb=0 sd=0 mult=1 m=1
csn_op0_n100_rl_s0p1_r100k_3 sn_op0_n100_rl_s0p1_r100k_3 0 {C_SN}
XMN1_op0_n100_rl_s0p1_r100k rbl_op0_n100_rl_s0p1_r100k ref_op0_n100_rl_s0p1_r100k vn_op0_n100_rl_s0p1_r100k 0 sky130_fd_pr__nfet_01v8 L=0.15 W=1 nf=1 ad=0.29 as=0.29 pd=2.58 ps=2.58 mult=1 m=1
XMN2_op0_n100_rl_s0p1_r100k ref_op0_n100_rl_s0p1_r100k rbl_op0_n100_rl_s0p1_r100k vn_op0_n100_rl_s0p1_r100k 0 sky130_fd_pr__nfet_01v8 L=0.15 W=1 nf=1 ad=0.29 as=0.29 pd=2.58 ps=2.58 mult=1 m=1
XMP1_op0_n100_rl_s0p1_r100k rbl_op0_n100_rl_s0p1_r100k ref_op0_n100_rl_s0p1_r100k vp_op0_n100_rl_s0p1_r100k vdd sky130_fd_pr__pfet_01v8 L=0.15 W=2 nf=1 ad=0.58 as=0.58 pd=4.58 ps=4.58 mult=1 m=1
XMP2_op0_n100_rl_s0p1_r100k ref_op0_n100_rl_s0p1_r100k rbl_op0_n100_rl_s0p1_r100k vp_op0_n100_rl_s0p1_r100k vdd sky130_fd_pr__pfet_01v8 L=0.15 W=2 nf=1 ad=0.58 as=0.58 pd=4.58 ps=4.58 mult=1 m=1
XMNF_op0_n100_rl_s0p1_r100k vn_op0_n100_rl_s0p1_r100k en_op0_n100_rl_s0p1_r100k 0 0 sky130_fd_pr__nfet_01v8 L=0.15 W=2 nf=1 ad=0.58 as=0.58 pd=4.58 ps=4.58 mult=1 m=1
XMPH_op0_n100_rl_s0p1_r100k vp_op0_n100_rl_s0p1_r100k enb_op0_n100_rl_s0p1_r100k vdd vdd sky130_fd_pr__pfet_01v8 L=0.15 W=4 nf=1 ad=1.16 as=1.16 pd=8.58 ps=8.58 mult=1 m=1
bd_op0_n100_rl_s0p1_r100k d_op0_n100_rl_s0p1_r100k 0 v=v(rbl_op0_n100_rl_s0p1_r100k)-v(ref_op0_n100_rl_s0p1_r100k)

* ---- instance 196: op0_0000_rl_s0p1_r100k (variant rl_s0p1_r100k; probe dec 11.9 ns, release 34 ns, meas 36 ns) ----
vctl_op0_0000_rl_s0p1_r100k ctl_op0_0000_rl_s0p1_r100k 0 pwl(0.0000e+00 {VDD} 2.0000e-09 {VDD} 2.1000e-09 0)
* RWL driver model (EXPERIMENTAL): slew 0.1 ns, series R 100000 ohm; cell pin = rwls_op0_0000_rl_s0p1_r100k
vrs_op0_0000_rl_s0p1_r100k rwlsrc_op0_0000_rl_s0p1_r100k 0 pwl(0.0000e+00 {VDD} 2.0000e-09 {VDD} 2.1000e-09 0 3.4000e-08 0 3.4100e-08 {VDD})
rdrv_op0_0000_rl_s0p1_r100k rwlsrc_op0_0000_rl_s0p1_r100k rwls_op0_0000_rl_s0p1_r100k 100000
ven_op0_0000_rl_s0p1_r100k en_op0_0000_rl_s0p1_r100k 0 pwl(0.0000e+00 0 1.1000e-08 0 1.1100e-08 {VDD} 3.4000e-08 {VDD} 3.4100e-08 0)
venb_op0_0000_rl_s0p1_r100k enb_op0_0000_rl_s0p1_r100k 0 pwl(0.0000e+00 {VDD} 1.1000e-08 {VDD} 1.1100e-08 0 3.4000e-08 0 3.4100e-08 {VDD})
vww_op0_0000_rl_s0p1_r100k wwl_op0_0000_rl_s0p1_r100k 0 pwl(0.0000e+00 0 1.2000e-08 0 1.2100e-08 {VDD} 3.2000e-08 {VDD} 3.2100e-08 0)
vwc_op0_0000_rl_s0p1_r100k wbc_op0_0000_rl_s0p1_r100k 0 pwl(0.0000e+00 0 1.2000e-08 0 1.2100e-08 {VDD} 3.4000e-08 {VDD} 3.4100e-08 0)
swb_op0_0000_rl_s0p1_r100k ref_op0_0000_rl_s0p1_r100k wbl_op0_0000_rl_s0p1_r100k wbc_op0_0000_rl_s0p1_r100k 0 swwbl
cwbl_op0_0000_rl_s0p1_r100k wbl_op0_0000_rl_s0p1_r100k 0 {C_WBL}
spa_op0_0000_rl_s0p1_r100k prea rbl_op0_0000_rl_s0p1_r100k ctl_op0_0000_rl_s0p1_r100k 0 swpre
spr_op0_0000_rl_s0p1_r100k pref ref_op0_0000_rl_s0p1_r100k ctl_op0_0000_rl_s0p1_r100k 0 swpre
crbl_op0_0000_rl_s0p1_r100k rbl_op0_0000_rl_s0p1_r100k 0 {C_RBL}
cref_op0_0000_rl_s0p1_r100k ref_op0_0000_rl_s0p1_r100k 0 {C_RBL}   $ ASSUMPTION: ideal matched dummy load
XMWR_op0_0000_rl_s0p1_r100k_0 sn_op0_0000_rl_s0p1_r100k_0 wwl_op0_0000_rl_s0p1_r100k wbl_op0_0000_rl_s0p1_r100k 0 sky130_fd_pr__nfet_01v8 L=0.15 W=0.42 nf=1 ad=0.1218 as=0.1218 pd=1.42 ps=1.42 nrd=0.69047619047619  nrs=0.69047619047619 sa=0 sb=0 sd=0 mult=1 m=1
XMRD_op0_0000_rl_s0p1_r100k_0 rbl_op0_0000_rl_s0p1_r100k sn_op0_0000_rl_s0p1_r100k_0 rwls_op0_0000_rl_s0p1_r100k 0 sky130_fd_pr__nfet_01v8 L=0.15 W=0.42 nf=1 ad=0.1218 as=0.1218 pd=1.42 ps=1.42 nrd=0.69047619047619  nrs=0.69047619047619 sa=0 sb=0 sd=0 mult=1 m=1
csn_op0_0000_rl_s0p1_r100k_0 sn_op0_0000_rl_s0p1_r100k_0 0 {C_SN}
XMWR_op0_0000_rl_s0p1_r100k_1 sn_op0_0000_rl_s0p1_r100k_1 wwl_des wbl_op0_0000_rl_s0p1_r100k 0 sky130_fd_pr__nfet_01v8 L=0.15 W=0.42 nf=1 ad=0.1218 as=0.1218 pd=1.42 ps=1.42 nrd=0.69047619047619  nrs=0.69047619047619 sa=0 sb=0 sd=0 mult=1 m=1
XMRD_op0_0000_rl_s0p1_r100k_1 rbl_op0_0000_rl_s0p1_r100k sn_op0_0000_rl_s0p1_r100k_1 rwl_des 0 sky130_fd_pr__nfet_01v8 L=0.15 W=0.42 nf=1 ad=0.1218 as=0.1218 pd=1.42 ps=1.42 nrd=0.69047619047619  nrs=0.69047619047619 sa=0 sb=0 sd=0 mult=1 m=1
csn_op0_0000_rl_s0p1_r100k_1 sn_op0_0000_rl_s0p1_r100k_1 0 {C_SN}
XMWR_op0_0000_rl_s0p1_r100k_2 sn_op0_0000_rl_s0p1_r100k_2 wwl_des wbl_op0_0000_rl_s0p1_r100k 0 sky130_fd_pr__nfet_01v8 L=0.15 W=0.42 nf=1 ad=0.1218 as=0.1218 pd=1.42 ps=1.42 nrd=0.69047619047619  nrs=0.69047619047619 sa=0 sb=0 sd=0 mult=1 m=1
XMRD_op0_0000_rl_s0p1_r100k_2 rbl_op0_0000_rl_s0p1_r100k sn_op0_0000_rl_s0p1_r100k_2 rwl_des 0 sky130_fd_pr__nfet_01v8 L=0.15 W=0.42 nf=1 ad=0.1218 as=0.1218 pd=1.42 ps=1.42 nrd=0.69047619047619  nrs=0.69047619047619 sa=0 sb=0 sd=0 mult=1 m=1
csn_op0_0000_rl_s0p1_r100k_2 sn_op0_0000_rl_s0p1_r100k_2 0 {C_SN}
XMWR_op0_0000_rl_s0p1_r100k_3 sn_op0_0000_rl_s0p1_r100k_3 wwl_des wbl_op0_0000_rl_s0p1_r100k 0 sky130_fd_pr__nfet_01v8 L=0.15 W=0.42 nf=1 ad=0.1218 as=0.1218 pd=1.42 ps=1.42 nrd=0.69047619047619  nrs=0.69047619047619 sa=0 sb=0 sd=0 mult=1 m=1
XMRD_op0_0000_rl_s0p1_r100k_3 rbl_op0_0000_rl_s0p1_r100k sn_op0_0000_rl_s0p1_r100k_3 rwl_des 0 sky130_fd_pr__nfet_01v8 L=0.15 W=0.42 nf=1 ad=0.1218 as=0.1218 pd=1.42 ps=1.42 nrd=0.69047619047619  nrs=0.69047619047619 sa=0 sb=0 sd=0 mult=1 m=1
csn_op0_0000_rl_s0p1_r100k_3 sn_op0_0000_rl_s0p1_r100k_3 0 {C_SN}
XMN1_op0_0000_rl_s0p1_r100k rbl_op0_0000_rl_s0p1_r100k ref_op0_0000_rl_s0p1_r100k vn_op0_0000_rl_s0p1_r100k 0 sky130_fd_pr__nfet_01v8 L=0.15 W=1 nf=1 ad=0.29 as=0.29 pd=2.58 ps=2.58 mult=1 m=1
XMN2_op0_0000_rl_s0p1_r100k ref_op0_0000_rl_s0p1_r100k rbl_op0_0000_rl_s0p1_r100k vn_op0_0000_rl_s0p1_r100k 0 sky130_fd_pr__nfet_01v8 L=0.15 W=1 nf=1 ad=0.29 as=0.29 pd=2.58 ps=2.58 mult=1 m=1
XMP1_op0_0000_rl_s0p1_r100k rbl_op0_0000_rl_s0p1_r100k ref_op0_0000_rl_s0p1_r100k vp_op0_0000_rl_s0p1_r100k vdd sky130_fd_pr__pfet_01v8 L=0.15 W=2 nf=1 ad=0.58 as=0.58 pd=4.58 ps=4.58 mult=1 m=1
XMP2_op0_0000_rl_s0p1_r100k ref_op0_0000_rl_s0p1_r100k rbl_op0_0000_rl_s0p1_r100k vp_op0_0000_rl_s0p1_r100k vdd sky130_fd_pr__pfet_01v8 L=0.15 W=2 nf=1 ad=0.58 as=0.58 pd=4.58 ps=4.58 mult=1 m=1
XMNF_op0_0000_rl_s0p1_r100k vn_op0_0000_rl_s0p1_r100k en_op0_0000_rl_s0p1_r100k 0 0 sky130_fd_pr__nfet_01v8 L=0.15 W=2 nf=1 ad=0.58 as=0.58 pd=4.58 ps=4.58 mult=1 m=1
XMPH_op0_0000_rl_s0p1_r100k vp_op0_0000_rl_s0p1_r100k enb_op0_0000_rl_s0p1_r100k vdd vdd sky130_fd_pr__pfet_01v8 L=0.15 W=4 nf=1 ad=1.16 as=1.16 pd=8.58 ps=8.58 mult=1 m=1
bd_op0_0000_rl_s0p1_r100k d_op0_0000_rl_s0p1_r100k 0 v=v(rbl_op0_0000_rl_s0p1_r100k)-v(ref_op0_0000_rl_s0p1_r100k)

* ---- instance 197: op1_0900_rl_s0p1_r300k (variant rl_s0p1_r300k; probe dec 11.9 ns, release 34 ns, meas 36 ns) ----
vctl_op1_0900_rl_s0p1_r300k ctl_op1_0900_rl_s0p1_r300k 0 pwl(0.0000e+00 {VDD} 2.0000e-09 {VDD} 2.1000e-09 0)
* RWL driver model (EXPERIMENTAL): slew 0.1 ns, series R 300000 ohm; cell pin = rwls_op1_0900_rl_s0p1_r300k
vrs_op1_0900_rl_s0p1_r300k rwlsrc_op1_0900_rl_s0p1_r300k 0 pwl(0.0000e+00 {VDD} 2.0000e-09 {VDD} 2.1000e-09 0 3.4000e-08 0 3.4100e-08 {VDD})
rdrv_op1_0900_rl_s0p1_r300k rwlsrc_op1_0900_rl_s0p1_r300k rwls_op1_0900_rl_s0p1_r300k 300000
ven_op1_0900_rl_s0p1_r300k en_op1_0900_rl_s0p1_r300k 0 pwl(0.0000e+00 0 1.1000e-08 0 1.1100e-08 {VDD} 3.4000e-08 {VDD} 3.4100e-08 0)
venb_op1_0900_rl_s0p1_r300k enb_op1_0900_rl_s0p1_r300k 0 pwl(0.0000e+00 {VDD} 1.1000e-08 {VDD} 1.1100e-08 0 3.4000e-08 0 3.4100e-08 {VDD})
vww_op1_0900_rl_s0p1_r300k wwl_op1_0900_rl_s0p1_r300k 0 pwl(0.0000e+00 0 1.2000e-08 0 1.2100e-08 {VDD} 3.2000e-08 {VDD} 3.2100e-08 0)
vwc_op1_0900_rl_s0p1_r300k wbc_op1_0900_rl_s0p1_r300k 0 pwl(0.0000e+00 0 1.2000e-08 0 1.2100e-08 {VDD} 3.4000e-08 {VDD} 3.4100e-08 0)
swb_op1_0900_rl_s0p1_r300k ref_op1_0900_rl_s0p1_r300k wbl_op1_0900_rl_s0p1_r300k wbc_op1_0900_rl_s0p1_r300k 0 swwbl
cwbl_op1_0900_rl_s0p1_r300k wbl_op1_0900_rl_s0p1_r300k 0 {C_WBL}
spa_op1_0900_rl_s0p1_r300k prea rbl_op1_0900_rl_s0p1_r300k ctl_op1_0900_rl_s0p1_r300k 0 swpre
spr_op1_0900_rl_s0p1_r300k pref ref_op1_0900_rl_s0p1_r300k ctl_op1_0900_rl_s0p1_r300k 0 swpre
crbl_op1_0900_rl_s0p1_r300k rbl_op1_0900_rl_s0p1_r300k 0 {C_RBL}
cref_op1_0900_rl_s0p1_r300k ref_op1_0900_rl_s0p1_r300k 0 {C_RBL}   $ ASSUMPTION: ideal matched dummy load
XMWR_op1_0900_rl_s0p1_r300k_0 sn_op1_0900_rl_s0p1_r300k_0 wwl_op1_0900_rl_s0p1_r300k wbl_op1_0900_rl_s0p1_r300k 0 sky130_fd_pr__nfet_01v8 L=0.15 W=0.42 nf=1 ad=0.1218 as=0.1218 pd=1.42 ps=1.42 nrd=0.69047619047619  nrs=0.69047619047619 sa=0 sb=0 sd=0 mult=1 m=1
XMRD_op1_0900_rl_s0p1_r300k_0 rbl_op1_0900_rl_s0p1_r300k sn_op1_0900_rl_s0p1_r300k_0 rwls_op1_0900_rl_s0p1_r300k 0 sky130_fd_pr__nfet_01v8 L=0.15 W=0.42 nf=1 ad=0.1218 as=0.1218 pd=1.42 ps=1.42 nrd=0.69047619047619  nrs=0.69047619047619 sa=0 sb=0 sd=0 mult=1 m=1
csn_op1_0900_rl_s0p1_r300k_0 sn_op1_0900_rl_s0p1_r300k_0 0 {C_SN}
XMWR_op1_0900_rl_s0p1_r300k_1 sn_op1_0900_rl_s0p1_r300k_1 wwl_des wbl_op1_0900_rl_s0p1_r300k 0 sky130_fd_pr__nfet_01v8 L=0.15 W=0.42 nf=1 ad=0.1218 as=0.1218 pd=1.42 ps=1.42 nrd=0.69047619047619  nrs=0.69047619047619 sa=0 sb=0 sd=0 mult=1 m=1
XMRD_op1_0900_rl_s0p1_r300k_1 rbl_op1_0900_rl_s0p1_r300k sn_op1_0900_rl_s0p1_r300k_1 rwl_des 0 sky130_fd_pr__nfet_01v8 L=0.15 W=0.42 nf=1 ad=0.1218 as=0.1218 pd=1.42 ps=1.42 nrd=0.69047619047619  nrs=0.69047619047619 sa=0 sb=0 sd=0 mult=1 m=1
csn_op1_0900_rl_s0p1_r300k_1 sn_op1_0900_rl_s0p1_r300k_1 0 {C_SN}
XMWR_op1_0900_rl_s0p1_r300k_2 sn_op1_0900_rl_s0p1_r300k_2 wwl_des wbl_op1_0900_rl_s0p1_r300k 0 sky130_fd_pr__nfet_01v8 L=0.15 W=0.42 nf=1 ad=0.1218 as=0.1218 pd=1.42 ps=1.42 nrd=0.69047619047619  nrs=0.69047619047619 sa=0 sb=0 sd=0 mult=1 m=1
XMRD_op1_0900_rl_s0p1_r300k_2 rbl_op1_0900_rl_s0p1_r300k sn_op1_0900_rl_s0p1_r300k_2 rwl_des 0 sky130_fd_pr__nfet_01v8 L=0.15 W=0.42 nf=1 ad=0.1218 as=0.1218 pd=1.42 ps=1.42 nrd=0.69047619047619  nrs=0.69047619047619 sa=0 sb=0 sd=0 mult=1 m=1
csn_op1_0900_rl_s0p1_r300k_2 sn_op1_0900_rl_s0p1_r300k_2 0 {C_SN}
XMWR_op1_0900_rl_s0p1_r300k_3 sn_op1_0900_rl_s0p1_r300k_3 wwl_des wbl_op1_0900_rl_s0p1_r300k 0 sky130_fd_pr__nfet_01v8 L=0.15 W=0.42 nf=1 ad=0.1218 as=0.1218 pd=1.42 ps=1.42 nrd=0.69047619047619  nrs=0.69047619047619 sa=0 sb=0 sd=0 mult=1 m=1
XMRD_op1_0900_rl_s0p1_r300k_3 rbl_op1_0900_rl_s0p1_r300k sn_op1_0900_rl_s0p1_r300k_3 rwl_des 0 sky130_fd_pr__nfet_01v8 L=0.15 W=0.42 nf=1 ad=0.1218 as=0.1218 pd=1.42 ps=1.42 nrd=0.69047619047619  nrs=0.69047619047619 sa=0 sb=0 sd=0 mult=1 m=1
csn_op1_0900_rl_s0p1_r300k_3 sn_op1_0900_rl_s0p1_r300k_3 0 {C_SN}
XMN1_op1_0900_rl_s0p1_r300k rbl_op1_0900_rl_s0p1_r300k ref_op1_0900_rl_s0p1_r300k vn_op1_0900_rl_s0p1_r300k 0 sky130_fd_pr__nfet_01v8 L=0.15 W=1 nf=1 ad=0.29 as=0.29 pd=2.58 ps=2.58 mult=1 m=1
XMN2_op1_0900_rl_s0p1_r300k ref_op1_0900_rl_s0p1_r300k rbl_op1_0900_rl_s0p1_r300k vn_op1_0900_rl_s0p1_r300k 0 sky130_fd_pr__nfet_01v8 L=0.15 W=1 nf=1 ad=0.29 as=0.29 pd=2.58 ps=2.58 mult=1 m=1
XMP1_op1_0900_rl_s0p1_r300k rbl_op1_0900_rl_s0p1_r300k ref_op1_0900_rl_s0p1_r300k vp_op1_0900_rl_s0p1_r300k vdd sky130_fd_pr__pfet_01v8 L=0.15 W=2 nf=1 ad=0.58 as=0.58 pd=4.58 ps=4.58 mult=1 m=1
XMP2_op1_0900_rl_s0p1_r300k ref_op1_0900_rl_s0p1_r300k rbl_op1_0900_rl_s0p1_r300k vp_op1_0900_rl_s0p1_r300k vdd sky130_fd_pr__pfet_01v8 L=0.15 W=2 nf=1 ad=0.58 as=0.58 pd=4.58 ps=4.58 mult=1 m=1
XMNF_op1_0900_rl_s0p1_r300k vn_op1_0900_rl_s0p1_r300k en_op1_0900_rl_s0p1_r300k 0 0 sky130_fd_pr__nfet_01v8 L=0.15 W=2 nf=1 ad=0.58 as=0.58 pd=4.58 ps=4.58 mult=1 m=1
XMPH_op1_0900_rl_s0p1_r300k vp_op1_0900_rl_s0p1_r300k enb_op1_0900_rl_s0p1_r300k vdd vdd sky130_fd_pr__pfet_01v8 L=0.15 W=4 nf=1 ad=1.16 as=1.16 pd=8.58 ps=8.58 mult=1 m=1
bd_op1_0900_rl_s0p1_r300k d_op1_0900_rl_s0p1_r300k 0 v=v(rbl_op1_0900_rl_s0p1_r300k)-v(ref_op1_0900_rl_s0p1_r300k)

* ---- instance 198: op1_1000_rl_s0p1_r300k (variant rl_s0p1_r300k; probe dec 11.9 ns, release 34 ns, meas 36 ns) ----
vctl_op1_1000_rl_s0p1_r300k ctl_op1_1000_rl_s0p1_r300k 0 pwl(0.0000e+00 {VDD} 2.0000e-09 {VDD} 2.1000e-09 0)
* RWL driver model (EXPERIMENTAL): slew 0.1 ns, series R 300000 ohm; cell pin = rwls_op1_1000_rl_s0p1_r300k
vrs_op1_1000_rl_s0p1_r300k rwlsrc_op1_1000_rl_s0p1_r300k 0 pwl(0.0000e+00 {VDD} 2.0000e-09 {VDD} 2.1000e-09 0 3.4000e-08 0 3.4100e-08 {VDD})
rdrv_op1_1000_rl_s0p1_r300k rwlsrc_op1_1000_rl_s0p1_r300k rwls_op1_1000_rl_s0p1_r300k 300000
ven_op1_1000_rl_s0p1_r300k en_op1_1000_rl_s0p1_r300k 0 pwl(0.0000e+00 0 1.1000e-08 0 1.1100e-08 {VDD} 3.4000e-08 {VDD} 3.4100e-08 0)
venb_op1_1000_rl_s0p1_r300k enb_op1_1000_rl_s0p1_r300k 0 pwl(0.0000e+00 {VDD} 1.1000e-08 {VDD} 1.1100e-08 0 3.4000e-08 0 3.4100e-08 {VDD})
vww_op1_1000_rl_s0p1_r300k wwl_op1_1000_rl_s0p1_r300k 0 pwl(0.0000e+00 0 1.2000e-08 0 1.2100e-08 {VDD} 3.2000e-08 {VDD} 3.2100e-08 0)
vwc_op1_1000_rl_s0p1_r300k wbc_op1_1000_rl_s0p1_r300k 0 pwl(0.0000e+00 0 1.2000e-08 0 1.2100e-08 {VDD} 3.4000e-08 {VDD} 3.4100e-08 0)
swb_op1_1000_rl_s0p1_r300k ref_op1_1000_rl_s0p1_r300k wbl_op1_1000_rl_s0p1_r300k wbc_op1_1000_rl_s0p1_r300k 0 swwbl
cwbl_op1_1000_rl_s0p1_r300k wbl_op1_1000_rl_s0p1_r300k 0 {C_WBL}
spa_op1_1000_rl_s0p1_r300k prea rbl_op1_1000_rl_s0p1_r300k ctl_op1_1000_rl_s0p1_r300k 0 swpre
spr_op1_1000_rl_s0p1_r300k pref ref_op1_1000_rl_s0p1_r300k ctl_op1_1000_rl_s0p1_r300k 0 swpre
crbl_op1_1000_rl_s0p1_r300k rbl_op1_1000_rl_s0p1_r300k 0 {C_RBL}
cref_op1_1000_rl_s0p1_r300k ref_op1_1000_rl_s0p1_r300k 0 {C_RBL}   $ ASSUMPTION: ideal matched dummy load
XMWR_op1_1000_rl_s0p1_r300k_0 sn_op1_1000_rl_s0p1_r300k_0 wwl_op1_1000_rl_s0p1_r300k wbl_op1_1000_rl_s0p1_r300k 0 sky130_fd_pr__nfet_01v8 L=0.15 W=0.42 nf=1 ad=0.1218 as=0.1218 pd=1.42 ps=1.42 nrd=0.69047619047619  nrs=0.69047619047619 sa=0 sb=0 sd=0 mult=1 m=1
XMRD_op1_1000_rl_s0p1_r300k_0 rbl_op1_1000_rl_s0p1_r300k sn_op1_1000_rl_s0p1_r300k_0 rwls_op1_1000_rl_s0p1_r300k 0 sky130_fd_pr__nfet_01v8 L=0.15 W=0.42 nf=1 ad=0.1218 as=0.1218 pd=1.42 ps=1.42 nrd=0.69047619047619  nrs=0.69047619047619 sa=0 sb=0 sd=0 mult=1 m=1
csn_op1_1000_rl_s0p1_r300k_0 sn_op1_1000_rl_s0p1_r300k_0 0 {C_SN}
XMWR_op1_1000_rl_s0p1_r300k_1 sn_op1_1000_rl_s0p1_r300k_1 wwl_des wbl_op1_1000_rl_s0p1_r300k 0 sky130_fd_pr__nfet_01v8 L=0.15 W=0.42 nf=1 ad=0.1218 as=0.1218 pd=1.42 ps=1.42 nrd=0.69047619047619  nrs=0.69047619047619 sa=0 sb=0 sd=0 mult=1 m=1
XMRD_op1_1000_rl_s0p1_r300k_1 rbl_op1_1000_rl_s0p1_r300k sn_op1_1000_rl_s0p1_r300k_1 rwl_des 0 sky130_fd_pr__nfet_01v8 L=0.15 W=0.42 nf=1 ad=0.1218 as=0.1218 pd=1.42 ps=1.42 nrd=0.69047619047619  nrs=0.69047619047619 sa=0 sb=0 sd=0 mult=1 m=1
csn_op1_1000_rl_s0p1_r300k_1 sn_op1_1000_rl_s0p1_r300k_1 0 {C_SN}
XMWR_op1_1000_rl_s0p1_r300k_2 sn_op1_1000_rl_s0p1_r300k_2 wwl_des wbl_op1_1000_rl_s0p1_r300k 0 sky130_fd_pr__nfet_01v8 L=0.15 W=0.42 nf=1 ad=0.1218 as=0.1218 pd=1.42 ps=1.42 nrd=0.69047619047619  nrs=0.69047619047619 sa=0 sb=0 sd=0 mult=1 m=1
XMRD_op1_1000_rl_s0p1_r300k_2 rbl_op1_1000_rl_s0p1_r300k sn_op1_1000_rl_s0p1_r300k_2 rwl_des 0 sky130_fd_pr__nfet_01v8 L=0.15 W=0.42 nf=1 ad=0.1218 as=0.1218 pd=1.42 ps=1.42 nrd=0.69047619047619  nrs=0.69047619047619 sa=0 sb=0 sd=0 mult=1 m=1
csn_op1_1000_rl_s0p1_r300k_2 sn_op1_1000_rl_s0p1_r300k_2 0 {C_SN}
XMWR_op1_1000_rl_s0p1_r300k_3 sn_op1_1000_rl_s0p1_r300k_3 wwl_des wbl_op1_1000_rl_s0p1_r300k 0 sky130_fd_pr__nfet_01v8 L=0.15 W=0.42 nf=1 ad=0.1218 as=0.1218 pd=1.42 ps=1.42 nrd=0.69047619047619  nrs=0.69047619047619 sa=0 sb=0 sd=0 mult=1 m=1
XMRD_op1_1000_rl_s0p1_r300k_3 rbl_op1_1000_rl_s0p1_r300k sn_op1_1000_rl_s0p1_r300k_3 rwl_des 0 sky130_fd_pr__nfet_01v8 L=0.15 W=0.42 nf=1 ad=0.1218 as=0.1218 pd=1.42 ps=1.42 nrd=0.69047619047619  nrs=0.69047619047619 sa=0 sb=0 sd=0 mult=1 m=1
csn_op1_1000_rl_s0p1_r300k_3 sn_op1_1000_rl_s0p1_r300k_3 0 {C_SN}
XMN1_op1_1000_rl_s0p1_r300k rbl_op1_1000_rl_s0p1_r300k ref_op1_1000_rl_s0p1_r300k vn_op1_1000_rl_s0p1_r300k 0 sky130_fd_pr__nfet_01v8 L=0.15 W=1 nf=1 ad=0.29 as=0.29 pd=2.58 ps=2.58 mult=1 m=1
XMN2_op1_1000_rl_s0p1_r300k ref_op1_1000_rl_s0p1_r300k rbl_op1_1000_rl_s0p1_r300k vn_op1_1000_rl_s0p1_r300k 0 sky130_fd_pr__nfet_01v8 L=0.15 W=1 nf=1 ad=0.29 as=0.29 pd=2.58 ps=2.58 mult=1 m=1
XMP1_op1_1000_rl_s0p1_r300k rbl_op1_1000_rl_s0p1_r300k ref_op1_1000_rl_s0p1_r300k vp_op1_1000_rl_s0p1_r300k vdd sky130_fd_pr__pfet_01v8 L=0.15 W=2 nf=1 ad=0.58 as=0.58 pd=4.58 ps=4.58 mult=1 m=1
XMP2_op1_1000_rl_s0p1_r300k ref_op1_1000_rl_s0p1_r300k rbl_op1_1000_rl_s0p1_r300k vp_op1_1000_rl_s0p1_r300k vdd sky130_fd_pr__pfet_01v8 L=0.15 W=2 nf=1 ad=0.58 as=0.58 pd=4.58 ps=4.58 mult=1 m=1
XMNF_op1_1000_rl_s0p1_r300k vn_op1_1000_rl_s0p1_r300k en_op1_1000_rl_s0p1_r300k 0 0 sky130_fd_pr__nfet_01v8 L=0.15 W=2 nf=1 ad=0.58 as=0.58 pd=4.58 ps=4.58 mult=1 m=1
XMPH_op1_1000_rl_s0p1_r300k vp_op1_1000_rl_s0p1_r300k enb_op1_1000_rl_s0p1_r300k vdd vdd sky130_fd_pr__pfet_01v8 L=0.15 W=4 nf=1 ad=1.16 as=1.16 pd=8.58 ps=8.58 mult=1 m=1
bd_op1_1000_rl_s0p1_r300k d_op1_1000_rl_s0p1_r300k 0 v=v(rbl_op1_1000_rl_s0p1_r300k)-v(ref_op1_1000_rl_s0p1_r300k)

* ---- instance 199: op0_n100_rl_s0p1_r300k (variant rl_s0p1_r300k; probe dec 11.9 ns, release 34 ns, meas 36 ns) ----
vctl_op0_n100_rl_s0p1_r300k ctl_op0_n100_rl_s0p1_r300k 0 pwl(0.0000e+00 {VDD} 2.0000e-09 {VDD} 2.1000e-09 0)
* RWL driver model (EXPERIMENTAL): slew 0.1 ns, series R 300000 ohm; cell pin = rwls_op0_n100_rl_s0p1_r300k
vrs_op0_n100_rl_s0p1_r300k rwlsrc_op0_n100_rl_s0p1_r300k 0 pwl(0.0000e+00 {VDD} 2.0000e-09 {VDD} 2.1000e-09 0 3.4000e-08 0 3.4100e-08 {VDD})
rdrv_op0_n100_rl_s0p1_r300k rwlsrc_op0_n100_rl_s0p1_r300k rwls_op0_n100_rl_s0p1_r300k 300000
ven_op0_n100_rl_s0p1_r300k en_op0_n100_rl_s0p1_r300k 0 pwl(0.0000e+00 0 1.1000e-08 0 1.1100e-08 {VDD} 3.4000e-08 {VDD} 3.4100e-08 0)
venb_op0_n100_rl_s0p1_r300k enb_op0_n100_rl_s0p1_r300k 0 pwl(0.0000e+00 {VDD} 1.1000e-08 {VDD} 1.1100e-08 0 3.4000e-08 0 3.4100e-08 {VDD})
vww_op0_n100_rl_s0p1_r300k wwl_op0_n100_rl_s0p1_r300k 0 pwl(0.0000e+00 0 1.2000e-08 0 1.2100e-08 {VDD} 3.2000e-08 {VDD} 3.2100e-08 0)
vwc_op0_n100_rl_s0p1_r300k wbc_op0_n100_rl_s0p1_r300k 0 pwl(0.0000e+00 0 1.2000e-08 0 1.2100e-08 {VDD} 3.4000e-08 {VDD} 3.4100e-08 0)
swb_op0_n100_rl_s0p1_r300k ref_op0_n100_rl_s0p1_r300k wbl_op0_n100_rl_s0p1_r300k wbc_op0_n100_rl_s0p1_r300k 0 swwbl
cwbl_op0_n100_rl_s0p1_r300k wbl_op0_n100_rl_s0p1_r300k 0 {C_WBL}
spa_op0_n100_rl_s0p1_r300k prea rbl_op0_n100_rl_s0p1_r300k ctl_op0_n100_rl_s0p1_r300k 0 swpre
spr_op0_n100_rl_s0p1_r300k pref ref_op0_n100_rl_s0p1_r300k ctl_op0_n100_rl_s0p1_r300k 0 swpre
crbl_op0_n100_rl_s0p1_r300k rbl_op0_n100_rl_s0p1_r300k 0 {C_RBL}
cref_op0_n100_rl_s0p1_r300k ref_op0_n100_rl_s0p1_r300k 0 {C_RBL}   $ ASSUMPTION: ideal matched dummy load
XMWR_op0_n100_rl_s0p1_r300k_0 sn_op0_n100_rl_s0p1_r300k_0 wwl_op0_n100_rl_s0p1_r300k wbl_op0_n100_rl_s0p1_r300k 0 sky130_fd_pr__nfet_01v8 L=0.15 W=0.42 nf=1 ad=0.1218 as=0.1218 pd=1.42 ps=1.42 nrd=0.69047619047619  nrs=0.69047619047619 sa=0 sb=0 sd=0 mult=1 m=1
XMRD_op0_n100_rl_s0p1_r300k_0 rbl_op0_n100_rl_s0p1_r300k sn_op0_n100_rl_s0p1_r300k_0 rwls_op0_n100_rl_s0p1_r300k 0 sky130_fd_pr__nfet_01v8 L=0.15 W=0.42 nf=1 ad=0.1218 as=0.1218 pd=1.42 ps=1.42 nrd=0.69047619047619  nrs=0.69047619047619 sa=0 sb=0 sd=0 mult=1 m=1
csn_op0_n100_rl_s0p1_r300k_0 sn_op0_n100_rl_s0p1_r300k_0 0 {C_SN}
XMWR_op0_n100_rl_s0p1_r300k_1 sn_op0_n100_rl_s0p1_r300k_1 wwl_des wbl_op0_n100_rl_s0p1_r300k 0 sky130_fd_pr__nfet_01v8 L=0.15 W=0.42 nf=1 ad=0.1218 as=0.1218 pd=1.42 ps=1.42 nrd=0.69047619047619  nrs=0.69047619047619 sa=0 sb=0 sd=0 mult=1 m=1
XMRD_op0_n100_rl_s0p1_r300k_1 rbl_op0_n100_rl_s0p1_r300k sn_op0_n100_rl_s0p1_r300k_1 rwl_des 0 sky130_fd_pr__nfet_01v8 L=0.15 W=0.42 nf=1 ad=0.1218 as=0.1218 pd=1.42 ps=1.42 nrd=0.69047619047619  nrs=0.69047619047619 sa=0 sb=0 sd=0 mult=1 m=1
csn_op0_n100_rl_s0p1_r300k_1 sn_op0_n100_rl_s0p1_r300k_1 0 {C_SN}
XMWR_op0_n100_rl_s0p1_r300k_2 sn_op0_n100_rl_s0p1_r300k_2 wwl_des wbl_op0_n100_rl_s0p1_r300k 0 sky130_fd_pr__nfet_01v8 L=0.15 W=0.42 nf=1 ad=0.1218 as=0.1218 pd=1.42 ps=1.42 nrd=0.69047619047619  nrs=0.69047619047619 sa=0 sb=0 sd=0 mult=1 m=1
XMRD_op0_n100_rl_s0p1_r300k_2 rbl_op0_n100_rl_s0p1_r300k sn_op0_n100_rl_s0p1_r300k_2 rwl_des 0 sky130_fd_pr__nfet_01v8 L=0.15 W=0.42 nf=1 ad=0.1218 as=0.1218 pd=1.42 ps=1.42 nrd=0.69047619047619  nrs=0.69047619047619 sa=0 sb=0 sd=0 mult=1 m=1
csn_op0_n100_rl_s0p1_r300k_2 sn_op0_n100_rl_s0p1_r300k_2 0 {C_SN}
XMWR_op0_n100_rl_s0p1_r300k_3 sn_op0_n100_rl_s0p1_r300k_3 wwl_des wbl_op0_n100_rl_s0p1_r300k 0 sky130_fd_pr__nfet_01v8 L=0.15 W=0.42 nf=1 ad=0.1218 as=0.1218 pd=1.42 ps=1.42 nrd=0.69047619047619  nrs=0.69047619047619 sa=0 sb=0 sd=0 mult=1 m=1
XMRD_op0_n100_rl_s0p1_r300k_3 rbl_op0_n100_rl_s0p1_r300k sn_op0_n100_rl_s0p1_r300k_3 rwl_des 0 sky130_fd_pr__nfet_01v8 L=0.15 W=0.42 nf=1 ad=0.1218 as=0.1218 pd=1.42 ps=1.42 nrd=0.69047619047619  nrs=0.69047619047619 sa=0 sb=0 sd=0 mult=1 m=1
csn_op0_n100_rl_s0p1_r300k_3 sn_op0_n100_rl_s0p1_r300k_3 0 {C_SN}
XMN1_op0_n100_rl_s0p1_r300k rbl_op0_n100_rl_s0p1_r300k ref_op0_n100_rl_s0p1_r300k vn_op0_n100_rl_s0p1_r300k 0 sky130_fd_pr__nfet_01v8 L=0.15 W=1 nf=1 ad=0.29 as=0.29 pd=2.58 ps=2.58 mult=1 m=1
XMN2_op0_n100_rl_s0p1_r300k ref_op0_n100_rl_s0p1_r300k rbl_op0_n100_rl_s0p1_r300k vn_op0_n100_rl_s0p1_r300k 0 sky130_fd_pr__nfet_01v8 L=0.15 W=1 nf=1 ad=0.29 as=0.29 pd=2.58 ps=2.58 mult=1 m=1
XMP1_op0_n100_rl_s0p1_r300k rbl_op0_n100_rl_s0p1_r300k ref_op0_n100_rl_s0p1_r300k vp_op0_n100_rl_s0p1_r300k vdd sky130_fd_pr__pfet_01v8 L=0.15 W=2 nf=1 ad=0.58 as=0.58 pd=4.58 ps=4.58 mult=1 m=1
XMP2_op0_n100_rl_s0p1_r300k ref_op0_n100_rl_s0p1_r300k rbl_op0_n100_rl_s0p1_r300k vp_op0_n100_rl_s0p1_r300k vdd sky130_fd_pr__pfet_01v8 L=0.15 W=2 nf=1 ad=0.58 as=0.58 pd=4.58 ps=4.58 mult=1 m=1
XMNF_op0_n100_rl_s0p1_r300k vn_op0_n100_rl_s0p1_r300k en_op0_n100_rl_s0p1_r300k 0 0 sky130_fd_pr__nfet_01v8 L=0.15 W=2 nf=1 ad=0.58 as=0.58 pd=4.58 ps=4.58 mult=1 m=1
XMPH_op0_n100_rl_s0p1_r300k vp_op0_n100_rl_s0p1_r300k enb_op0_n100_rl_s0p1_r300k vdd vdd sky130_fd_pr__pfet_01v8 L=0.15 W=4 nf=1 ad=1.16 as=1.16 pd=8.58 ps=8.58 mult=1 m=1
bd_op0_n100_rl_s0p1_r300k d_op0_n100_rl_s0p1_r300k 0 v=v(rbl_op0_n100_rl_s0p1_r300k)-v(ref_op0_n100_rl_s0p1_r300k)

* ---- instance 200: op0_0000_rl_s0p1_r300k (variant rl_s0p1_r300k; probe dec 11.9 ns, release 34 ns, meas 36 ns) ----
vctl_op0_0000_rl_s0p1_r300k ctl_op0_0000_rl_s0p1_r300k 0 pwl(0.0000e+00 {VDD} 2.0000e-09 {VDD} 2.1000e-09 0)
* RWL driver model (EXPERIMENTAL): slew 0.1 ns, series R 300000 ohm; cell pin = rwls_op0_0000_rl_s0p1_r300k
vrs_op0_0000_rl_s0p1_r300k rwlsrc_op0_0000_rl_s0p1_r300k 0 pwl(0.0000e+00 {VDD} 2.0000e-09 {VDD} 2.1000e-09 0 3.4000e-08 0 3.4100e-08 {VDD})
rdrv_op0_0000_rl_s0p1_r300k rwlsrc_op0_0000_rl_s0p1_r300k rwls_op0_0000_rl_s0p1_r300k 300000
ven_op0_0000_rl_s0p1_r300k en_op0_0000_rl_s0p1_r300k 0 pwl(0.0000e+00 0 1.1000e-08 0 1.1100e-08 {VDD} 3.4000e-08 {VDD} 3.4100e-08 0)
venb_op0_0000_rl_s0p1_r300k enb_op0_0000_rl_s0p1_r300k 0 pwl(0.0000e+00 {VDD} 1.1000e-08 {VDD} 1.1100e-08 0 3.4000e-08 0 3.4100e-08 {VDD})
vww_op0_0000_rl_s0p1_r300k wwl_op0_0000_rl_s0p1_r300k 0 pwl(0.0000e+00 0 1.2000e-08 0 1.2100e-08 {VDD} 3.2000e-08 {VDD} 3.2100e-08 0)
vwc_op0_0000_rl_s0p1_r300k wbc_op0_0000_rl_s0p1_r300k 0 pwl(0.0000e+00 0 1.2000e-08 0 1.2100e-08 {VDD} 3.4000e-08 {VDD} 3.4100e-08 0)
swb_op0_0000_rl_s0p1_r300k ref_op0_0000_rl_s0p1_r300k wbl_op0_0000_rl_s0p1_r300k wbc_op0_0000_rl_s0p1_r300k 0 swwbl
cwbl_op0_0000_rl_s0p1_r300k wbl_op0_0000_rl_s0p1_r300k 0 {C_WBL}
spa_op0_0000_rl_s0p1_r300k prea rbl_op0_0000_rl_s0p1_r300k ctl_op0_0000_rl_s0p1_r300k 0 swpre
spr_op0_0000_rl_s0p1_r300k pref ref_op0_0000_rl_s0p1_r300k ctl_op0_0000_rl_s0p1_r300k 0 swpre
crbl_op0_0000_rl_s0p1_r300k rbl_op0_0000_rl_s0p1_r300k 0 {C_RBL}
cref_op0_0000_rl_s0p1_r300k ref_op0_0000_rl_s0p1_r300k 0 {C_RBL}   $ ASSUMPTION: ideal matched dummy load
XMWR_op0_0000_rl_s0p1_r300k_0 sn_op0_0000_rl_s0p1_r300k_0 wwl_op0_0000_rl_s0p1_r300k wbl_op0_0000_rl_s0p1_r300k 0 sky130_fd_pr__nfet_01v8 L=0.15 W=0.42 nf=1 ad=0.1218 as=0.1218 pd=1.42 ps=1.42 nrd=0.69047619047619  nrs=0.69047619047619 sa=0 sb=0 sd=0 mult=1 m=1
XMRD_op0_0000_rl_s0p1_r300k_0 rbl_op0_0000_rl_s0p1_r300k sn_op0_0000_rl_s0p1_r300k_0 rwls_op0_0000_rl_s0p1_r300k 0 sky130_fd_pr__nfet_01v8 L=0.15 W=0.42 nf=1 ad=0.1218 as=0.1218 pd=1.42 ps=1.42 nrd=0.69047619047619  nrs=0.69047619047619 sa=0 sb=0 sd=0 mult=1 m=1
csn_op0_0000_rl_s0p1_r300k_0 sn_op0_0000_rl_s0p1_r300k_0 0 {C_SN}
XMWR_op0_0000_rl_s0p1_r300k_1 sn_op0_0000_rl_s0p1_r300k_1 wwl_des wbl_op0_0000_rl_s0p1_r300k 0 sky130_fd_pr__nfet_01v8 L=0.15 W=0.42 nf=1 ad=0.1218 as=0.1218 pd=1.42 ps=1.42 nrd=0.69047619047619  nrs=0.69047619047619 sa=0 sb=0 sd=0 mult=1 m=1
XMRD_op0_0000_rl_s0p1_r300k_1 rbl_op0_0000_rl_s0p1_r300k sn_op0_0000_rl_s0p1_r300k_1 rwl_des 0 sky130_fd_pr__nfet_01v8 L=0.15 W=0.42 nf=1 ad=0.1218 as=0.1218 pd=1.42 ps=1.42 nrd=0.69047619047619  nrs=0.69047619047619 sa=0 sb=0 sd=0 mult=1 m=1
csn_op0_0000_rl_s0p1_r300k_1 sn_op0_0000_rl_s0p1_r300k_1 0 {C_SN}
XMWR_op0_0000_rl_s0p1_r300k_2 sn_op0_0000_rl_s0p1_r300k_2 wwl_des wbl_op0_0000_rl_s0p1_r300k 0 sky130_fd_pr__nfet_01v8 L=0.15 W=0.42 nf=1 ad=0.1218 as=0.1218 pd=1.42 ps=1.42 nrd=0.69047619047619  nrs=0.69047619047619 sa=0 sb=0 sd=0 mult=1 m=1
XMRD_op0_0000_rl_s0p1_r300k_2 rbl_op0_0000_rl_s0p1_r300k sn_op0_0000_rl_s0p1_r300k_2 rwl_des 0 sky130_fd_pr__nfet_01v8 L=0.15 W=0.42 nf=1 ad=0.1218 as=0.1218 pd=1.42 ps=1.42 nrd=0.69047619047619  nrs=0.69047619047619 sa=0 sb=0 sd=0 mult=1 m=1
csn_op0_0000_rl_s0p1_r300k_2 sn_op0_0000_rl_s0p1_r300k_2 0 {C_SN}
XMWR_op0_0000_rl_s0p1_r300k_3 sn_op0_0000_rl_s0p1_r300k_3 wwl_des wbl_op0_0000_rl_s0p1_r300k 0 sky130_fd_pr__nfet_01v8 L=0.15 W=0.42 nf=1 ad=0.1218 as=0.1218 pd=1.42 ps=1.42 nrd=0.69047619047619  nrs=0.69047619047619 sa=0 sb=0 sd=0 mult=1 m=1
XMRD_op0_0000_rl_s0p1_r300k_3 rbl_op0_0000_rl_s0p1_r300k sn_op0_0000_rl_s0p1_r300k_3 rwl_des 0 sky130_fd_pr__nfet_01v8 L=0.15 W=0.42 nf=1 ad=0.1218 as=0.1218 pd=1.42 ps=1.42 nrd=0.69047619047619  nrs=0.69047619047619 sa=0 sb=0 sd=0 mult=1 m=1
csn_op0_0000_rl_s0p1_r300k_3 sn_op0_0000_rl_s0p1_r300k_3 0 {C_SN}
XMN1_op0_0000_rl_s0p1_r300k rbl_op0_0000_rl_s0p1_r300k ref_op0_0000_rl_s0p1_r300k vn_op0_0000_rl_s0p1_r300k 0 sky130_fd_pr__nfet_01v8 L=0.15 W=1 nf=1 ad=0.29 as=0.29 pd=2.58 ps=2.58 mult=1 m=1
XMN2_op0_0000_rl_s0p1_r300k ref_op0_0000_rl_s0p1_r300k rbl_op0_0000_rl_s0p1_r300k vn_op0_0000_rl_s0p1_r300k 0 sky130_fd_pr__nfet_01v8 L=0.15 W=1 nf=1 ad=0.29 as=0.29 pd=2.58 ps=2.58 mult=1 m=1
XMP1_op0_0000_rl_s0p1_r300k rbl_op0_0000_rl_s0p1_r300k ref_op0_0000_rl_s0p1_r300k vp_op0_0000_rl_s0p1_r300k vdd sky130_fd_pr__pfet_01v8 L=0.15 W=2 nf=1 ad=0.58 as=0.58 pd=4.58 ps=4.58 mult=1 m=1
XMP2_op0_0000_rl_s0p1_r300k ref_op0_0000_rl_s0p1_r300k rbl_op0_0000_rl_s0p1_r300k vp_op0_0000_rl_s0p1_r300k vdd sky130_fd_pr__pfet_01v8 L=0.15 W=2 nf=1 ad=0.58 as=0.58 pd=4.58 ps=4.58 mult=1 m=1
XMNF_op0_0000_rl_s0p1_r300k vn_op0_0000_rl_s0p1_r300k en_op0_0000_rl_s0p1_r300k 0 0 sky130_fd_pr__nfet_01v8 L=0.15 W=2 nf=1 ad=0.58 as=0.58 pd=4.58 ps=4.58 mult=1 m=1
XMPH_op0_0000_rl_s0p1_r300k vp_op0_0000_rl_s0p1_r300k enb_op0_0000_rl_s0p1_r300k vdd vdd sky130_fd_pr__pfet_01v8 L=0.15 W=4 nf=1 ad=1.16 as=1.16 pd=8.58 ps=8.58 mult=1 m=1
bd_op0_0000_rl_s0p1_r300k d_op0_0000_rl_s0p1_r300k 0 v=v(rbl_op0_0000_rl_s0p1_r300k)-v(ref_op0_0000_rl_s0p1_r300k)

* ---- instance 201: op1_0900_rl_s0p1_r1000k (variant rl_s0p1_r1000k; probe dec 11.9 ns, release 34 ns, meas 36 ns) ----
vctl_op1_0900_rl_s0p1_r1000k ctl_op1_0900_rl_s0p1_r1000k 0 pwl(0.0000e+00 {VDD} 2.0000e-09 {VDD} 2.1000e-09 0)
* RWL driver model (EXPERIMENTAL): slew 0.1 ns, series R 1e+06 ohm; cell pin = rwls_op1_0900_rl_s0p1_r1000k
vrs_op1_0900_rl_s0p1_r1000k rwlsrc_op1_0900_rl_s0p1_r1000k 0 pwl(0.0000e+00 {VDD} 2.0000e-09 {VDD} 2.1000e-09 0 3.4000e-08 0 3.4100e-08 {VDD})
rdrv_op1_0900_rl_s0p1_r1000k rwlsrc_op1_0900_rl_s0p1_r1000k rwls_op1_0900_rl_s0p1_r1000k 1e+06
ven_op1_0900_rl_s0p1_r1000k en_op1_0900_rl_s0p1_r1000k 0 pwl(0.0000e+00 0 1.1000e-08 0 1.1100e-08 {VDD} 3.4000e-08 {VDD} 3.4100e-08 0)
venb_op1_0900_rl_s0p1_r1000k enb_op1_0900_rl_s0p1_r1000k 0 pwl(0.0000e+00 {VDD} 1.1000e-08 {VDD} 1.1100e-08 0 3.4000e-08 0 3.4100e-08 {VDD})
vww_op1_0900_rl_s0p1_r1000k wwl_op1_0900_rl_s0p1_r1000k 0 pwl(0.0000e+00 0 1.2000e-08 0 1.2100e-08 {VDD} 3.2000e-08 {VDD} 3.2100e-08 0)
vwc_op1_0900_rl_s0p1_r1000k wbc_op1_0900_rl_s0p1_r1000k 0 pwl(0.0000e+00 0 1.2000e-08 0 1.2100e-08 {VDD} 3.4000e-08 {VDD} 3.4100e-08 0)
swb_op1_0900_rl_s0p1_r1000k ref_op1_0900_rl_s0p1_r1000k wbl_op1_0900_rl_s0p1_r1000k wbc_op1_0900_rl_s0p1_r1000k 0 swwbl
cwbl_op1_0900_rl_s0p1_r1000k wbl_op1_0900_rl_s0p1_r1000k 0 {C_WBL}
spa_op1_0900_rl_s0p1_r1000k prea rbl_op1_0900_rl_s0p1_r1000k ctl_op1_0900_rl_s0p1_r1000k 0 swpre
spr_op1_0900_rl_s0p1_r1000k pref ref_op1_0900_rl_s0p1_r1000k ctl_op1_0900_rl_s0p1_r1000k 0 swpre
crbl_op1_0900_rl_s0p1_r1000k rbl_op1_0900_rl_s0p1_r1000k 0 {C_RBL}
cref_op1_0900_rl_s0p1_r1000k ref_op1_0900_rl_s0p1_r1000k 0 {C_RBL}   $ ASSUMPTION: ideal matched dummy load
XMWR_op1_0900_rl_s0p1_r1000k_0 sn_op1_0900_rl_s0p1_r1000k_0 wwl_op1_0900_rl_s0p1_r1000k wbl_op1_0900_rl_s0p1_r1000k 0 sky130_fd_pr__nfet_01v8 L=0.15 W=0.42 nf=1 ad=0.1218 as=0.1218 pd=1.42 ps=1.42 nrd=0.69047619047619  nrs=0.69047619047619 sa=0 sb=0 sd=0 mult=1 m=1
XMRD_op1_0900_rl_s0p1_r1000k_0 rbl_op1_0900_rl_s0p1_r1000k sn_op1_0900_rl_s0p1_r1000k_0 rwls_op1_0900_rl_s0p1_r1000k 0 sky130_fd_pr__nfet_01v8 L=0.15 W=0.42 nf=1 ad=0.1218 as=0.1218 pd=1.42 ps=1.42 nrd=0.69047619047619  nrs=0.69047619047619 sa=0 sb=0 sd=0 mult=1 m=1
csn_op1_0900_rl_s0p1_r1000k_0 sn_op1_0900_rl_s0p1_r1000k_0 0 {C_SN}
XMWR_op1_0900_rl_s0p1_r1000k_1 sn_op1_0900_rl_s0p1_r1000k_1 wwl_des wbl_op1_0900_rl_s0p1_r1000k 0 sky130_fd_pr__nfet_01v8 L=0.15 W=0.42 nf=1 ad=0.1218 as=0.1218 pd=1.42 ps=1.42 nrd=0.69047619047619  nrs=0.69047619047619 sa=0 sb=0 sd=0 mult=1 m=1
XMRD_op1_0900_rl_s0p1_r1000k_1 rbl_op1_0900_rl_s0p1_r1000k sn_op1_0900_rl_s0p1_r1000k_1 rwl_des 0 sky130_fd_pr__nfet_01v8 L=0.15 W=0.42 nf=1 ad=0.1218 as=0.1218 pd=1.42 ps=1.42 nrd=0.69047619047619  nrs=0.69047619047619 sa=0 sb=0 sd=0 mult=1 m=1
csn_op1_0900_rl_s0p1_r1000k_1 sn_op1_0900_rl_s0p1_r1000k_1 0 {C_SN}
XMWR_op1_0900_rl_s0p1_r1000k_2 sn_op1_0900_rl_s0p1_r1000k_2 wwl_des wbl_op1_0900_rl_s0p1_r1000k 0 sky130_fd_pr__nfet_01v8 L=0.15 W=0.42 nf=1 ad=0.1218 as=0.1218 pd=1.42 ps=1.42 nrd=0.69047619047619  nrs=0.69047619047619 sa=0 sb=0 sd=0 mult=1 m=1
XMRD_op1_0900_rl_s0p1_r1000k_2 rbl_op1_0900_rl_s0p1_r1000k sn_op1_0900_rl_s0p1_r1000k_2 rwl_des 0 sky130_fd_pr__nfet_01v8 L=0.15 W=0.42 nf=1 ad=0.1218 as=0.1218 pd=1.42 ps=1.42 nrd=0.69047619047619  nrs=0.69047619047619 sa=0 sb=0 sd=0 mult=1 m=1
csn_op1_0900_rl_s0p1_r1000k_2 sn_op1_0900_rl_s0p1_r1000k_2 0 {C_SN}
XMWR_op1_0900_rl_s0p1_r1000k_3 sn_op1_0900_rl_s0p1_r1000k_3 wwl_des wbl_op1_0900_rl_s0p1_r1000k 0 sky130_fd_pr__nfet_01v8 L=0.15 W=0.42 nf=1 ad=0.1218 as=0.1218 pd=1.42 ps=1.42 nrd=0.69047619047619  nrs=0.69047619047619 sa=0 sb=0 sd=0 mult=1 m=1
XMRD_op1_0900_rl_s0p1_r1000k_3 rbl_op1_0900_rl_s0p1_r1000k sn_op1_0900_rl_s0p1_r1000k_3 rwl_des 0 sky130_fd_pr__nfet_01v8 L=0.15 W=0.42 nf=1 ad=0.1218 as=0.1218 pd=1.42 ps=1.42 nrd=0.69047619047619  nrs=0.69047619047619 sa=0 sb=0 sd=0 mult=1 m=1
csn_op1_0900_rl_s0p1_r1000k_3 sn_op1_0900_rl_s0p1_r1000k_3 0 {C_SN}
XMN1_op1_0900_rl_s0p1_r1000k rbl_op1_0900_rl_s0p1_r1000k ref_op1_0900_rl_s0p1_r1000k vn_op1_0900_rl_s0p1_r1000k 0 sky130_fd_pr__nfet_01v8 L=0.15 W=1 nf=1 ad=0.29 as=0.29 pd=2.58 ps=2.58 mult=1 m=1
XMN2_op1_0900_rl_s0p1_r1000k ref_op1_0900_rl_s0p1_r1000k rbl_op1_0900_rl_s0p1_r1000k vn_op1_0900_rl_s0p1_r1000k 0 sky130_fd_pr__nfet_01v8 L=0.15 W=1 nf=1 ad=0.29 as=0.29 pd=2.58 ps=2.58 mult=1 m=1
XMP1_op1_0900_rl_s0p1_r1000k rbl_op1_0900_rl_s0p1_r1000k ref_op1_0900_rl_s0p1_r1000k vp_op1_0900_rl_s0p1_r1000k vdd sky130_fd_pr__pfet_01v8 L=0.15 W=2 nf=1 ad=0.58 as=0.58 pd=4.58 ps=4.58 mult=1 m=1
XMP2_op1_0900_rl_s0p1_r1000k ref_op1_0900_rl_s0p1_r1000k rbl_op1_0900_rl_s0p1_r1000k vp_op1_0900_rl_s0p1_r1000k vdd sky130_fd_pr__pfet_01v8 L=0.15 W=2 nf=1 ad=0.58 as=0.58 pd=4.58 ps=4.58 mult=1 m=1
XMNF_op1_0900_rl_s0p1_r1000k vn_op1_0900_rl_s0p1_r1000k en_op1_0900_rl_s0p1_r1000k 0 0 sky130_fd_pr__nfet_01v8 L=0.15 W=2 nf=1 ad=0.58 as=0.58 pd=4.58 ps=4.58 mult=1 m=1
XMPH_op1_0900_rl_s0p1_r1000k vp_op1_0900_rl_s0p1_r1000k enb_op1_0900_rl_s0p1_r1000k vdd vdd sky130_fd_pr__pfet_01v8 L=0.15 W=4 nf=1 ad=1.16 as=1.16 pd=8.58 ps=8.58 mult=1 m=1
bd_op1_0900_rl_s0p1_r1000k d_op1_0900_rl_s0p1_r1000k 0 v=v(rbl_op1_0900_rl_s0p1_r1000k)-v(ref_op1_0900_rl_s0p1_r1000k)

* ---- instance 202: op1_1000_rl_s0p1_r1000k (variant rl_s0p1_r1000k; probe dec 11.9 ns, release 34 ns, meas 36 ns) ----
vctl_op1_1000_rl_s0p1_r1000k ctl_op1_1000_rl_s0p1_r1000k 0 pwl(0.0000e+00 {VDD} 2.0000e-09 {VDD} 2.1000e-09 0)
* RWL driver model (EXPERIMENTAL): slew 0.1 ns, series R 1e+06 ohm; cell pin = rwls_op1_1000_rl_s0p1_r1000k
vrs_op1_1000_rl_s0p1_r1000k rwlsrc_op1_1000_rl_s0p1_r1000k 0 pwl(0.0000e+00 {VDD} 2.0000e-09 {VDD} 2.1000e-09 0 3.4000e-08 0 3.4100e-08 {VDD})
rdrv_op1_1000_rl_s0p1_r1000k rwlsrc_op1_1000_rl_s0p1_r1000k rwls_op1_1000_rl_s0p1_r1000k 1e+06
ven_op1_1000_rl_s0p1_r1000k en_op1_1000_rl_s0p1_r1000k 0 pwl(0.0000e+00 0 1.1000e-08 0 1.1100e-08 {VDD} 3.4000e-08 {VDD} 3.4100e-08 0)
venb_op1_1000_rl_s0p1_r1000k enb_op1_1000_rl_s0p1_r1000k 0 pwl(0.0000e+00 {VDD} 1.1000e-08 {VDD} 1.1100e-08 0 3.4000e-08 0 3.4100e-08 {VDD})
vww_op1_1000_rl_s0p1_r1000k wwl_op1_1000_rl_s0p1_r1000k 0 pwl(0.0000e+00 0 1.2000e-08 0 1.2100e-08 {VDD} 3.2000e-08 {VDD} 3.2100e-08 0)
vwc_op1_1000_rl_s0p1_r1000k wbc_op1_1000_rl_s0p1_r1000k 0 pwl(0.0000e+00 0 1.2000e-08 0 1.2100e-08 {VDD} 3.4000e-08 {VDD} 3.4100e-08 0)
swb_op1_1000_rl_s0p1_r1000k ref_op1_1000_rl_s0p1_r1000k wbl_op1_1000_rl_s0p1_r1000k wbc_op1_1000_rl_s0p1_r1000k 0 swwbl
cwbl_op1_1000_rl_s0p1_r1000k wbl_op1_1000_rl_s0p1_r1000k 0 {C_WBL}
spa_op1_1000_rl_s0p1_r1000k prea rbl_op1_1000_rl_s0p1_r1000k ctl_op1_1000_rl_s0p1_r1000k 0 swpre
spr_op1_1000_rl_s0p1_r1000k pref ref_op1_1000_rl_s0p1_r1000k ctl_op1_1000_rl_s0p1_r1000k 0 swpre
crbl_op1_1000_rl_s0p1_r1000k rbl_op1_1000_rl_s0p1_r1000k 0 {C_RBL}
cref_op1_1000_rl_s0p1_r1000k ref_op1_1000_rl_s0p1_r1000k 0 {C_RBL}   $ ASSUMPTION: ideal matched dummy load
XMWR_op1_1000_rl_s0p1_r1000k_0 sn_op1_1000_rl_s0p1_r1000k_0 wwl_op1_1000_rl_s0p1_r1000k wbl_op1_1000_rl_s0p1_r1000k 0 sky130_fd_pr__nfet_01v8 L=0.15 W=0.42 nf=1 ad=0.1218 as=0.1218 pd=1.42 ps=1.42 nrd=0.69047619047619  nrs=0.69047619047619 sa=0 sb=0 sd=0 mult=1 m=1
XMRD_op1_1000_rl_s0p1_r1000k_0 rbl_op1_1000_rl_s0p1_r1000k sn_op1_1000_rl_s0p1_r1000k_0 rwls_op1_1000_rl_s0p1_r1000k 0 sky130_fd_pr__nfet_01v8 L=0.15 W=0.42 nf=1 ad=0.1218 as=0.1218 pd=1.42 ps=1.42 nrd=0.69047619047619  nrs=0.69047619047619 sa=0 sb=0 sd=0 mult=1 m=1
csn_op1_1000_rl_s0p1_r1000k_0 sn_op1_1000_rl_s0p1_r1000k_0 0 {C_SN}
XMWR_op1_1000_rl_s0p1_r1000k_1 sn_op1_1000_rl_s0p1_r1000k_1 wwl_des wbl_op1_1000_rl_s0p1_r1000k 0 sky130_fd_pr__nfet_01v8 L=0.15 W=0.42 nf=1 ad=0.1218 as=0.1218 pd=1.42 ps=1.42 nrd=0.69047619047619  nrs=0.69047619047619 sa=0 sb=0 sd=0 mult=1 m=1
XMRD_op1_1000_rl_s0p1_r1000k_1 rbl_op1_1000_rl_s0p1_r1000k sn_op1_1000_rl_s0p1_r1000k_1 rwl_des 0 sky130_fd_pr__nfet_01v8 L=0.15 W=0.42 nf=1 ad=0.1218 as=0.1218 pd=1.42 ps=1.42 nrd=0.69047619047619  nrs=0.69047619047619 sa=0 sb=0 sd=0 mult=1 m=1
csn_op1_1000_rl_s0p1_r1000k_1 sn_op1_1000_rl_s0p1_r1000k_1 0 {C_SN}
XMWR_op1_1000_rl_s0p1_r1000k_2 sn_op1_1000_rl_s0p1_r1000k_2 wwl_des wbl_op1_1000_rl_s0p1_r1000k 0 sky130_fd_pr__nfet_01v8 L=0.15 W=0.42 nf=1 ad=0.1218 as=0.1218 pd=1.42 ps=1.42 nrd=0.69047619047619  nrs=0.69047619047619 sa=0 sb=0 sd=0 mult=1 m=1
XMRD_op1_1000_rl_s0p1_r1000k_2 rbl_op1_1000_rl_s0p1_r1000k sn_op1_1000_rl_s0p1_r1000k_2 rwl_des 0 sky130_fd_pr__nfet_01v8 L=0.15 W=0.42 nf=1 ad=0.1218 as=0.1218 pd=1.42 ps=1.42 nrd=0.69047619047619  nrs=0.69047619047619 sa=0 sb=0 sd=0 mult=1 m=1
csn_op1_1000_rl_s0p1_r1000k_2 sn_op1_1000_rl_s0p1_r1000k_2 0 {C_SN}
XMWR_op1_1000_rl_s0p1_r1000k_3 sn_op1_1000_rl_s0p1_r1000k_3 wwl_des wbl_op1_1000_rl_s0p1_r1000k 0 sky130_fd_pr__nfet_01v8 L=0.15 W=0.42 nf=1 ad=0.1218 as=0.1218 pd=1.42 ps=1.42 nrd=0.69047619047619  nrs=0.69047619047619 sa=0 sb=0 sd=0 mult=1 m=1
XMRD_op1_1000_rl_s0p1_r1000k_3 rbl_op1_1000_rl_s0p1_r1000k sn_op1_1000_rl_s0p1_r1000k_3 rwl_des 0 sky130_fd_pr__nfet_01v8 L=0.15 W=0.42 nf=1 ad=0.1218 as=0.1218 pd=1.42 ps=1.42 nrd=0.69047619047619  nrs=0.69047619047619 sa=0 sb=0 sd=0 mult=1 m=1
csn_op1_1000_rl_s0p1_r1000k_3 sn_op1_1000_rl_s0p1_r1000k_3 0 {C_SN}
XMN1_op1_1000_rl_s0p1_r1000k rbl_op1_1000_rl_s0p1_r1000k ref_op1_1000_rl_s0p1_r1000k vn_op1_1000_rl_s0p1_r1000k 0 sky130_fd_pr__nfet_01v8 L=0.15 W=1 nf=1 ad=0.29 as=0.29 pd=2.58 ps=2.58 mult=1 m=1
XMN2_op1_1000_rl_s0p1_r1000k ref_op1_1000_rl_s0p1_r1000k rbl_op1_1000_rl_s0p1_r1000k vn_op1_1000_rl_s0p1_r1000k 0 sky130_fd_pr__nfet_01v8 L=0.15 W=1 nf=1 ad=0.29 as=0.29 pd=2.58 ps=2.58 mult=1 m=1
XMP1_op1_1000_rl_s0p1_r1000k rbl_op1_1000_rl_s0p1_r1000k ref_op1_1000_rl_s0p1_r1000k vp_op1_1000_rl_s0p1_r1000k vdd sky130_fd_pr__pfet_01v8 L=0.15 W=2 nf=1 ad=0.58 as=0.58 pd=4.58 ps=4.58 mult=1 m=1
XMP2_op1_1000_rl_s0p1_r1000k ref_op1_1000_rl_s0p1_r1000k rbl_op1_1000_rl_s0p1_r1000k vp_op1_1000_rl_s0p1_r1000k vdd sky130_fd_pr__pfet_01v8 L=0.15 W=2 nf=1 ad=0.58 as=0.58 pd=4.58 ps=4.58 mult=1 m=1
XMNF_op1_1000_rl_s0p1_r1000k vn_op1_1000_rl_s0p1_r1000k en_op1_1000_rl_s0p1_r1000k 0 0 sky130_fd_pr__nfet_01v8 L=0.15 W=2 nf=1 ad=0.58 as=0.58 pd=4.58 ps=4.58 mult=1 m=1
XMPH_op1_1000_rl_s0p1_r1000k vp_op1_1000_rl_s0p1_r1000k enb_op1_1000_rl_s0p1_r1000k vdd vdd sky130_fd_pr__pfet_01v8 L=0.15 W=4 nf=1 ad=1.16 as=1.16 pd=8.58 ps=8.58 mult=1 m=1
bd_op1_1000_rl_s0p1_r1000k d_op1_1000_rl_s0p1_r1000k 0 v=v(rbl_op1_1000_rl_s0p1_r1000k)-v(ref_op1_1000_rl_s0p1_r1000k)

* ---- instance 203: op0_n100_rl_s0p1_r1000k (variant rl_s0p1_r1000k; probe dec 11.9 ns, release 34 ns, meas 36 ns) ----
vctl_op0_n100_rl_s0p1_r1000k ctl_op0_n100_rl_s0p1_r1000k 0 pwl(0.0000e+00 {VDD} 2.0000e-09 {VDD} 2.1000e-09 0)
* RWL driver model (EXPERIMENTAL): slew 0.1 ns, series R 1e+06 ohm; cell pin = rwls_op0_n100_rl_s0p1_r1000k
vrs_op0_n100_rl_s0p1_r1000k rwlsrc_op0_n100_rl_s0p1_r1000k 0 pwl(0.0000e+00 {VDD} 2.0000e-09 {VDD} 2.1000e-09 0 3.4000e-08 0 3.4100e-08 {VDD})
rdrv_op0_n100_rl_s0p1_r1000k rwlsrc_op0_n100_rl_s0p1_r1000k rwls_op0_n100_rl_s0p1_r1000k 1e+06
ven_op0_n100_rl_s0p1_r1000k en_op0_n100_rl_s0p1_r1000k 0 pwl(0.0000e+00 0 1.1000e-08 0 1.1100e-08 {VDD} 3.4000e-08 {VDD} 3.4100e-08 0)
venb_op0_n100_rl_s0p1_r1000k enb_op0_n100_rl_s0p1_r1000k 0 pwl(0.0000e+00 {VDD} 1.1000e-08 {VDD} 1.1100e-08 0 3.4000e-08 0 3.4100e-08 {VDD})
vww_op0_n100_rl_s0p1_r1000k wwl_op0_n100_rl_s0p1_r1000k 0 pwl(0.0000e+00 0 1.2000e-08 0 1.2100e-08 {VDD} 3.2000e-08 {VDD} 3.2100e-08 0)
vwc_op0_n100_rl_s0p1_r1000k wbc_op0_n100_rl_s0p1_r1000k 0 pwl(0.0000e+00 0 1.2000e-08 0 1.2100e-08 {VDD} 3.4000e-08 {VDD} 3.4100e-08 0)
swb_op0_n100_rl_s0p1_r1000k ref_op0_n100_rl_s0p1_r1000k wbl_op0_n100_rl_s0p1_r1000k wbc_op0_n100_rl_s0p1_r1000k 0 swwbl
cwbl_op0_n100_rl_s0p1_r1000k wbl_op0_n100_rl_s0p1_r1000k 0 {C_WBL}
spa_op0_n100_rl_s0p1_r1000k prea rbl_op0_n100_rl_s0p1_r1000k ctl_op0_n100_rl_s0p1_r1000k 0 swpre
spr_op0_n100_rl_s0p1_r1000k pref ref_op0_n100_rl_s0p1_r1000k ctl_op0_n100_rl_s0p1_r1000k 0 swpre
crbl_op0_n100_rl_s0p1_r1000k rbl_op0_n100_rl_s0p1_r1000k 0 {C_RBL}
cref_op0_n100_rl_s0p1_r1000k ref_op0_n100_rl_s0p1_r1000k 0 {C_RBL}   $ ASSUMPTION: ideal matched dummy load
XMWR_op0_n100_rl_s0p1_r1000k_0 sn_op0_n100_rl_s0p1_r1000k_0 wwl_op0_n100_rl_s0p1_r1000k wbl_op0_n100_rl_s0p1_r1000k 0 sky130_fd_pr__nfet_01v8 L=0.15 W=0.42 nf=1 ad=0.1218 as=0.1218 pd=1.42 ps=1.42 nrd=0.69047619047619  nrs=0.69047619047619 sa=0 sb=0 sd=0 mult=1 m=1
XMRD_op0_n100_rl_s0p1_r1000k_0 rbl_op0_n100_rl_s0p1_r1000k sn_op0_n100_rl_s0p1_r1000k_0 rwls_op0_n100_rl_s0p1_r1000k 0 sky130_fd_pr__nfet_01v8 L=0.15 W=0.42 nf=1 ad=0.1218 as=0.1218 pd=1.42 ps=1.42 nrd=0.69047619047619  nrs=0.69047619047619 sa=0 sb=0 sd=0 mult=1 m=1
csn_op0_n100_rl_s0p1_r1000k_0 sn_op0_n100_rl_s0p1_r1000k_0 0 {C_SN}
XMWR_op0_n100_rl_s0p1_r1000k_1 sn_op0_n100_rl_s0p1_r1000k_1 wwl_des wbl_op0_n100_rl_s0p1_r1000k 0 sky130_fd_pr__nfet_01v8 L=0.15 W=0.42 nf=1 ad=0.1218 as=0.1218 pd=1.42 ps=1.42 nrd=0.69047619047619  nrs=0.69047619047619 sa=0 sb=0 sd=0 mult=1 m=1
XMRD_op0_n100_rl_s0p1_r1000k_1 rbl_op0_n100_rl_s0p1_r1000k sn_op0_n100_rl_s0p1_r1000k_1 rwl_des 0 sky130_fd_pr__nfet_01v8 L=0.15 W=0.42 nf=1 ad=0.1218 as=0.1218 pd=1.42 ps=1.42 nrd=0.69047619047619  nrs=0.69047619047619 sa=0 sb=0 sd=0 mult=1 m=1
csn_op0_n100_rl_s0p1_r1000k_1 sn_op0_n100_rl_s0p1_r1000k_1 0 {C_SN}
XMWR_op0_n100_rl_s0p1_r1000k_2 sn_op0_n100_rl_s0p1_r1000k_2 wwl_des wbl_op0_n100_rl_s0p1_r1000k 0 sky130_fd_pr__nfet_01v8 L=0.15 W=0.42 nf=1 ad=0.1218 as=0.1218 pd=1.42 ps=1.42 nrd=0.69047619047619  nrs=0.69047619047619 sa=0 sb=0 sd=0 mult=1 m=1
XMRD_op0_n100_rl_s0p1_r1000k_2 rbl_op0_n100_rl_s0p1_r1000k sn_op0_n100_rl_s0p1_r1000k_2 rwl_des 0 sky130_fd_pr__nfet_01v8 L=0.15 W=0.42 nf=1 ad=0.1218 as=0.1218 pd=1.42 ps=1.42 nrd=0.69047619047619  nrs=0.69047619047619 sa=0 sb=0 sd=0 mult=1 m=1
csn_op0_n100_rl_s0p1_r1000k_2 sn_op0_n100_rl_s0p1_r1000k_2 0 {C_SN}
XMWR_op0_n100_rl_s0p1_r1000k_3 sn_op0_n100_rl_s0p1_r1000k_3 wwl_des wbl_op0_n100_rl_s0p1_r1000k 0 sky130_fd_pr__nfet_01v8 L=0.15 W=0.42 nf=1 ad=0.1218 as=0.1218 pd=1.42 ps=1.42 nrd=0.69047619047619  nrs=0.69047619047619 sa=0 sb=0 sd=0 mult=1 m=1
XMRD_op0_n100_rl_s0p1_r1000k_3 rbl_op0_n100_rl_s0p1_r1000k sn_op0_n100_rl_s0p1_r1000k_3 rwl_des 0 sky130_fd_pr__nfet_01v8 L=0.15 W=0.42 nf=1 ad=0.1218 as=0.1218 pd=1.42 ps=1.42 nrd=0.69047619047619  nrs=0.69047619047619 sa=0 sb=0 sd=0 mult=1 m=1
csn_op0_n100_rl_s0p1_r1000k_3 sn_op0_n100_rl_s0p1_r1000k_3 0 {C_SN}
XMN1_op0_n100_rl_s0p1_r1000k rbl_op0_n100_rl_s0p1_r1000k ref_op0_n100_rl_s0p1_r1000k vn_op0_n100_rl_s0p1_r1000k 0 sky130_fd_pr__nfet_01v8 L=0.15 W=1 nf=1 ad=0.29 as=0.29 pd=2.58 ps=2.58 mult=1 m=1
XMN2_op0_n100_rl_s0p1_r1000k ref_op0_n100_rl_s0p1_r1000k rbl_op0_n100_rl_s0p1_r1000k vn_op0_n100_rl_s0p1_r1000k 0 sky130_fd_pr__nfet_01v8 L=0.15 W=1 nf=1 ad=0.29 as=0.29 pd=2.58 ps=2.58 mult=1 m=1
XMP1_op0_n100_rl_s0p1_r1000k rbl_op0_n100_rl_s0p1_r1000k ref_op0_n100_rl_s0p1_r1000k vp_op0_n100_rl_s0p1_r1000k vdd sky130_fd_pr__pfet_01v8 L=0.15 W=2 nf=1 ad=0.58 as=0.58 pd=4.58 ps=4.58 mult=1 m=1
XMP2_op0_n100_rl_s0p1_r1000k ref_op0_n100_rl_s0p1_r1000k rbl_op0_n100_rl_s0p1_r1000k vp_op0_n100_rl_s0p1_r1000k vdd sky130_fd_pr__pfet_01v8 L=0.15 W=2 nf=1 ad=0.58 as=0.58 pd=4.58 ps=4.58 mult=1 m=1
XMNF_op0_n100_rl_s0p1_r1000k vn_op0_n100_rl_s0p1_r1000k en_op0_n100_rl_s0p1_r1000k 0 0 sky130_fd_pr__nfet_01v8 L=0.15 W=2 nf=1 ad=0.58 as=0.58 pd=4.58 ps=4.58 mult=1 m=1
XMPH_op0_n100_rl_s0p1_r1000k vp_op0_n100_rl_s0p1_r1000k enb_op0_n100_rl_s0p1_r1000k vdd vdd sky130_fd_pr__pfet_01v8 L=0.15 W=4 nf=1 ad=1.16 as=1.16 pd=8.58 ps=8.58 mult=1 m=1
bd_op0_n100_rl_s0p1_r1000k d_op0_n100_rl_s0p1_r1000k 0 v=v(rbl_op0_n100_rl_s0p1_r1000k)-v(ref_op0_n100_rl_s0p1_r1000k)

* ---- instance 204: op0_0000_rl_s0p1_r1000k (variant rl_s0p1_r1000k; probe dec 11.9 ns, release 34 ns, meas 36 ns) ----
vctl_op0_0000_rl_s0p1_r1000k ctl_op0_0000_rl_s0p1_r1000k 0 pwl(0.0000e+00 {VDD} 2.0000e-09 {VDD} 2.1000e-09 0)
* RWL driver model (EXPERIMENTAL): slew 0.1 ns, series R 1e+06 ohm; cell pin = rwls_op0_0000_rl_s0p1_r1000k
vrs_op0_0000_rl_s0p1_r1000k rwlsrc_op0_0000_rl_s0p1_r1000k 0 pwl(0.0000e+00 {VDD} 2.0000e-09 {VDD} 2.1000e-09 0 3.4000e-08 0 3.4100e-08 {VDD})
rdrv_op0_0000_rl_s0p1_r1000k rwlsrc_op0_0000_rl_s0p1_r1000k rwls_op0_0000_rl_s0p1_r1000k 1e+06
ven_op0_0000_rl_s0p1_r1000k en_op0_0000_rl_s0p1_r1000k 0 pwl(0.0000e+00 0 1.1000e-08 0 1.1100e-08 {VDD} 3.4000e-08 {VDD} 3.4100e-08 0)
venb_op0_0000_rl_s0p1_r1000k enb_op0_0000_rl_s0p1_r1000k 0 pwl(0.0000e+00 {VDD} 1.1000e-08 {VDD} 1.1100e-08 0 3.4000e-08 0 3.4100e-08 {VDD})
vww_op0_0000_rl_s0p1_r1000k wwl_op0_0000_rl_s0p1_r1000k 0 pwl(0.0000e+00 0 1.2000e-08 0 1.2100e-08 {VDD} 3.2000e-08 {VDD} 3.2100e-08 0)
vwc_op0_0000_rl_s0p1_r1000k wbc_op0_0000_rl_s0p1_r1000k 0 pwl(0.0000e+00 0 1.2000e-08 0 1.2100e-08 {VDD} 3.4000e-08 {VDD} 3.4100e-08 0)
swb_op0_0000_rl_s0p1_r1000k ref_op0_0000_rl_s0p1_r1000k wbl_op0_0000_rl_s0p1_r1000k wbc_op0_0000_rl_s0p1_r1000k 0 swwbl
cwbl_op0_0000_rl_s0p1_r1000k wbl_op0_0000_rl_s0p1_r1000k 0 {C_WBL}
spa_op0_0000_rl_s0p1_r1000k prea rbl_op0_0000_rl_s0p1_r1000k ctl_op0_0000_rl_s0p1_r1000k 0 swpre
spr_op0_0000_rl_s0p1_r1000k pref ref_op0_0000_rl_s0p1_r1000k ctl_op0_0000_rl_s0p1_r1000k 0 swpre
crbl_op0_0000_rl_s0p1_r1000k rbl_op0_0000_rl_s0p1_r1000k 0 {C_RBL}
cref_op0_0000_rl_s0p1_r1000k ref_op0_0000_rl_s0p1_r1000k 0 {C_RBL}   $ ASSUMPTION: ideal matched dummy load
XMWR_op0_0000_rl_s0p1_r1000k_0 sn_op0_0000_rl_s0p1_r1000k_0 wwl_op0_0000_rl_s0p1_r1000k wbl_op0_0000_rl_s0p1_r1000k 0 sky130_fd_pr__nfet_01v8 L=0.15 W=0.42 nf=1 ad=0.1218 as=0.1218 pd=1.42 ps=1.42 nrd=0.69047619047619  nrs=0.69047619047619 sa=0 sb=0 sd=0 mult=1 m=1
XMRD_op0_0000_rl_s0p1_r1000k_0 rbl_op0_0000_rl_s0p1_r1000k sn_op0_0000_rl_s0p1_r1000k_0 rwls_op0_0000_rl_s0p1_r1000k 0 sky130_fd_pr__nfet_01v8 L=0.15 W=0.42 nf=1 ad=0.1218 as=0.1218 pd=1.42 ps=1.42 nrd=0.69047619047619  nrs=0.69047619047619 sa=0 sb=0 sd=0 mult=1 m=1
csn_op0_0000_rl_s0p1_r1000k_0 sn_op0_0000_rl_s0p1_r1000k_0 0 {C_SN}
XMWR_op0_0000_rl_s0p1_r1000k_1 sn_op0_0000_rl_s0p1_r1000k_1 wwl_des wbl_op0_0000_rl_s0p1_r1000k 0 sky130_fd_pr__nfet_01v8 L=0.15 W=0.42 nf=1 ad=0.1218 as=0.1218 pd=1.42 ps=1.42 nrd=0.69047619047619  nrs=0.69047619047619 sa=0 sb=0 sd=0 mult=1 m=1
XMRD_op0_0000_rl_s0p1_r1000k_1 rbl_op0_0000_rl_s0p1_r1000k sn_op0_0000_rl_s0p1_r1000k_1 rwl_des 0 sky130_fd_pr__nfet_01v8 L=0.15 W=0.42 nf=1 ad=0.1218 as=0.1218 pd=1.42 ps=1.42 nrd=0.69047619047619  nrs=0.69047619047619 sa=0 sb=0 sd=0 mult=1 m=1
csn_op0_0000_rl_s0p1_r1000k_1 sn_op0_0000_rl_s0p1_r1000k_1 0 {C_SN}
XMWR_op0_0000_rl_s0p1_r1000k_2 sn_op0_0000_rl_s0p1_r1000k_2 wwl_des wbl_op0_0000_rl_s0p1_r1000k 0 sky130_fd_pr__nfet_01v8 L=0.15 W=0.42 nf=1 ad=0.1218 as=0.1218 pd=1.42 ps=1.42 nrd=0.69047619047619  nrs=0.69047619047619 sa=0 sb=0 sd=0 mult=1 m=1
XMRD_op0_0000_rl_s0p1_r1000k_2 rbl_op0_0000_rl_s0p1_r1000k sn_op0_0000_rl_s0p1_r1000k_2 rwl_des 0 sky130_fd_pr__nfet_01v8 L=0.15 W=0.42 nf=1 ad=0.1218 as=0.1218 pd=1.42 ps=1.42 nrd=0.69047619047619  nrs=0.69047619047619 sa=0 sb=0 sd=0 mult=1 m=1
csn_op0_0000_rl_s0p1_r1000k_2 sn_op0_0000_rl_s0p1_r1000k_2 0 {C_SN}
XMWR_op0_0000_rl_s0p1_r1000k_3 sn_op0_0000_rl_s0p1_r1000k_3 wwl_des wbl_op0_0000_rl_s0p1_r1000k 0 sky130_fd_pr__nfet_01v8 L=0.15 W=0.42 nf=1 ad=0.1218 as=0.1218 pd=1.42 ps=1.42 nrd=0.69047619047619  nrs=0.69047619047619 sa=0 sb=0 sd=0 mult=1 m=1
XMRD_op0_0000_rl_s0p1_r1000k_3 rbl_op0_0000_rl_s0p1_r1000k sn_op0_0000_rl_s0p1_r1000k_3 rwl_des 0 sky130_fd_pr__nfet_01v8 L=0.15 W=0.42 nf=1 ad=0.1218 as=0.1218 pd=1.42 ps=1.42 nrd=0.69047619047619  nrs=0.69047619047619 sa=0 sb=0 sd=0 mult=1 m=1
csn_op0_0000_rl_s0p1_r1000k_3 sn_op0_0000_rl_s0p1_r1000k_3 0 {C_SN}
XMN1_op0_0000_rl_s0p1_r1000k rbl_op0_0000_rl_s0p1_r1000k ref_op0_0000_rl_s0p1_r1000k vn_op0_0000_rl_s0p1_r1000k 0 sky130_fd_pr__nfet_01v8 L=0.15 W=1 nf=1 ad=0.29 as=0.29 pd=2.58 ps=2.58 mult=1 m=1
XMN2_op0_0000_rl_s0p1_r1000k ref_op0_0000_rl_s0p1_r1000k rbl_op0_0000_rl_s0p1_r1000k vn_op0_0000_rl_s0p1_r1000k 0 sky130_fd_pr__nfet_01v8 L=0.15 W=1 nf=1 ad=0.29 as=0.29 pd=2.58 ps=2.58 mult=1 m=1
XMP1_op0_0000_rl_s0p1_r1000k rbl_op0_0000_rl_s0p1_r1000k ref_op0_0000_rl_s0p1_r1000k vp_op0_0000_rl_s0p1_r1000k vdd sky130_fd_pr__pfet_01v8 L=0.15 W=2 nf=1 ad=0.58 as=0.58 pd=4.58 ps=4.58 mult=1 m=1
XMP2_op0_0000_rl_s0p1_r1000k ref_op0_0000_rl_s0p1_r1000k rbl_op0_0000_rl_s0p1_r1000k vp_op0_0000_rl_s0p1_r1000k vdd sky130_fd_pr__pfet_01v8 L=0.15 W=2 nf=1 ad=0.58 as=0.58 pd=4.58 ps=4.58 mult=1 m=1
XMNF_op0_0000_rl_s0p1_r1000k vn_op0_0000_rl_s0p1_r1000k en_op0_0000_rl_s0p1_r1000k 0 0 sky130_fd_pr__nfet_01v8 L=0.15 W=2 nf=1 ad=0.58 as=0.58 pd=4.58 ps=4.58 mult=1 m=1
XMPH_op0_0000_rl_s0p1_r1000k vp_op0_0000_rl_s0p1_r1000k enb_op0_0000_rl_s0p1_r1000k vdd vdd sky130_fd_pr__pfet_01v8 L=0.15 W=4 nf=1 ad=1.16 as=1.16 pd=8.58 ps=8.58 mult=1 m=1
bd_op0_0000_rl_s0p1_r1000k d_op0_0000_rl_s0p1_r1000k 0 v=v(rbl_op0_0000_rl_s0p1_r1000k)-v(ref_op0_0000_rl_s0p1_r1000k)

* ---- instance 205: op1_0900_rl_s1_r10k (variant rl_s1_r10k; probe dec 11.9 ns, release 34 ns, meas 36 ns) ----
vctl_op1_0900_rl_s1_r10k ctl_op1_0900_rl_s1_r10k 0 pwl(0.0000e+00 {VDD} 2.0000e-09 {VDD} 2.1000e-09 0)
* RWL driver model (EXPERIMENTAL): slew 1 ns, series R 10000 ohm; cell pin = rwls_op1_0900_rl_s1_r10k
vrs_op1_0900_rl_s1_r10k rwlsrc_op1_0900_rl_s1_r10k 0 pwl(0.0000e+00 {VDD} 2.0000e-09 {VDD} 3.0000e-09 0 3.4000e-08 0 3.5000e-08 {VDD})
rdrv_op1_0900_rl_s1_r10k rwlsrc_op1_0900_rl_s1_r10k rwls_op1_0900_rl_s1_r10k 10000
ven_op1_0900_rl_s1_r10k en_op1_0900_rl_s1_r10k 0 pwl(0.0000e+00 0 1.1000e-08 0 1.1100e-08 {VDD} 3.4000e-08 {VDD} 3.4100e-08 0)
venb_op1_0900_rl_s1_r10k enb_op1_0900_rl_s1_r10k 0 pwl(0.0000e+00 {VDD} 1.1000e-08 {VDD} 1.1100e-08 0 3.4000e-08 0 3.4100e-08 {VDD})
vww_op1_0900_rl_s1_r10k wwl_op1_0900_rl_s1_r10k 0 pwl(0.0000e+00 0 1.2000e-08 0 1.2100e-08 {VDD} 3.2000e-08 {VDD} 3.2100e-08 0)
vwc_op1_0900_rl_s1_r10k wbc_op1_0900_rl_s1_r10k 0 pwl(0.0000e+00 0 1.2000e-08 0 1.2100e-08 {VDD} 3.4000e-08 {VDD} 3.4100e-08 0)
swb_op1_0900_rl_s1_r10k ref_op1_0900_rl_s1_r10k wbl_op1_0900_rl_s1_r10k wbc_op1_0900_rl_s1_r10k 0 swwbl
cwbl_op1_0900_rl_s1_r10k wbl_op1_0900_rl_s1_r10k 0 {C_WBL}
spa_op1_0900_rl_s1_r10k prea rbl_op1_0900_rl_s1_r10k ctl_op1_0900_rl_s1_r10k 0 swpre
spr_op1_0900_rl_s1_r10k pref ref_op1_0900_rl_s1_r10k ctl_op1_0900_rl_s1_r10k 0 swpre
crbl_op1_0900_rl_s1_r10k rbl_op1_0900_rl_s1_r10k 0 {C_RBL}
cref_op1_0900_rl_s1_r10k ref_op1_0900_rl_s1_r10k 0 {C_RBL}   $ ASSUMPTION: ideal matched dummy load
XMWR_op1_0900_rl_s1_r10k_0 sn_op1_0900_rl_s1_r10k_0 wwl_op1_0900_rl_s1_r10k wbl_op1_0900_rl_s1_r10k 0 sky130_fd_pr__nfet_01v8 L=0.15 W=0.42 nf=1 ad=0.1218 as=0.1218 pd=1.42 ps=1.42 nrd=0.69047619047619  nrs=0.69047619047619 sa=0 sb=0 sd=0 mult=1 m=1
XMRD_op1_0900_rl_s1_r10k_0 rbl_op1_0900_rl_s1_r10k sn_op1_0900_rl_s1_r10k_0 rwls_op1_0900_rl_s1_r10k 0 sky130_fd_pr__nfet_01v8 L=0.15 W=0.42 nf=1 ad=0.1218 as=0.1218 pd=1.42 ps=1.42 nrd=0.69047619047619  nrs=0.69047619047619 sa=0 sb=0 sd=0 mult=1 m=1
csn_op1_0900_rl_s1_r10k_0 sn_op1_0900_rl_s1_r10k_0 0 {C_SN}
XMWR_op1_0900_rl_s1_r10k_1 sn_op1_0900_rl_s1_r10k_1 wwl_des wbl_op1_0900_rl_s1_r10k 0 sky130_fd_pr__nfet_01v8 L=0.15 W=0.42 nf=1 ad=0.1218 as=0.1218 pd=1.42 ps=1.42 nrd=0.69047619047619  nrs=0.69047619047619 sa=0 sb=0 sd=0 mult=1 m=1
XMRD_op1_0900_rl_s1_r10k_1 rbl_op1_0900_rl_s1_r10k sn_op1_0900_rl_s1_r10k_1 rwl_des 0 sky130_fd_pr__nfet_01v8 L=0.15 W=0.42 nf=1 ad=0.1218 as=0.1218 pd=1.42 ps=1.42 nrd=0.69047619047619  nrs=0.69047619047619 sa=0 sb=0 sd=0 mult=1 m=1
csn_op1_0900_rl_s1_r10k_1 sn_op1_0900_rl_s1_r10k_1 0 {C_SN}
XMWR_op1_0900_rl_s1_r10k_2 sn_op1_0900_rl_s1_r10k_2 wwl_des wbl_op1_0900_rl_s1_r10k 0 sky130_fd_pr__nfet_01v8 L=0.15 W=0.42 nf=1 ad=0.1218 as=0.1218 pd=1.42 ps=1.42 nrd=0.69047619047619  nrs=0.69047619047619 sa=0 sb=0 sd=0 mult=1 m=1
XMRD_op1_0900_rl_s1_r10k_2 rbl_op1_0900_rl_s1_r10k sn_op1_0900_rl_s1_r10k_2 rwl_des 0 sky130_fd_pr__nfet_01v8 L=0.15 W=0.42 nf=1 ad=0.1218 as=0.1218 pd=1.42 ps=1.42 nrd=0.69047619047619  nrs=0.69047619047619 sa=0 sb=0 sd=0 mult=1 m=1
csn_op1_0900_rl_s1_r10k_2 sn_op1_0900_rl_s1_r10k_2 0 {C_SN}
XMWR_op1_0900_rl_s1_r10k_3 sn_op1_0900_rl_s1_r10k_3 wwl_des wbl_op1_0900_rl_s1_r10k 0 sky130_fd_pr__nfet_01v8 L=0.15 W=0.42 nf=1 ad=0.1218 as=0.1218 pd=1.42 ps=1.42 nrd=0.69047619047619  nrs=0.69047619047619 sa=0 sb=0 sd=0 mult=1 m=1
XMRD_op1_0900_rl_s1_r10k_3 rbl_op1_0900_rl_s1_r10k sn_op1_0900_rl_s1_r10k_3 rwl_des 0 sky130_fd_pr__nfet_01v8 L=0.15 W=0.42 nf=1 ad=0.1218 as=0.1218 pd=1.42 ps=1.42 nrd=0.69047619047619  nrs=0.69047619047619 sa=0 sb=0 sd=0 mult=1 m=1
csn_op1_0900_rl_s1_r10k_3 sn_op1_0900_rl_s1_r10k_3 0 {C_SN}
XMN1_op1_0900_rl_s1_r10k rbl_op1_0900_rl_s1_r10k ref_op1_0900_rl_s1_r10k vn_op1_0900_rl_s1_r10k 0 sky130_fd_pr__nfet_01v8 L=0.15 W=1 nf=1 ad=0.29 as=0.29 pd=2.58 ps=2.58 mult=1 m=1
XMN2_op1_0900_rl_s1_r10k ref_op1_0900_rl_s1_r10k rbl_op1_0900_rl_s1_r10k vn_op1_0900_rl_s1_r10k 0 sky130_fd_pr__nfet_01v8 L=0.15 W=1 nf=1 ad=0.29 as=0.29 pd=2.58 ps=2.58 mult=1 m=1
XMP1_op1_0900_rl_s1_r10k rbl_op1_0900_rl_s1_r10k ref_op1_0900_rl_s1_r10k vp_op1_0900_rl_s1_r10k vdd sky130_fd_pr__pfet_01v8 L=0.15 W=2 nf=1 ad=0.58 as=0.58 pd=4.58 ps=4.58 mult=1 m=1
XMP2_op1_0900_rl_s1_r10k ref_op1_0900_rl_s1_r10k rbl_op1_0900_rl_s1_r10k vp_op1_0900_rl_s1_r10k vdd sky130_fd_pr__pfet_01v8 L=0.15 W=2 nf=1 ad=0.58 as=0.58 pd=4.58 ps=4.58 mult=1 m=1
XMNF_op1_0900_rl_s1_r10k vn_op1_0900_rl_s1_r10k en_op1_0900_rl_s1_r10k 0 0 sky130_fd_pr__nfet_01v8 L=0.15 W=2 nf=1 ad=0.58 as=0.58 pd=4.58 ps=4.58 mult=1 m=1
XMPH_op1_0900_rl_s1_r10k vp_op1_0900_rl_s1_r10k enb_op1_0900_rl_s1_r10k vdd vdd sky130_fd_pr__pfet_01v8 L=0.15 W=4 nf=1 ad=1.16 as=1.16 pd=8.58 ps=8.58 mult=1 m=1
bd_op1_0900_rl_s1_r10k d_op1_0900_rl_s1_r10k 0 v=v(rbl_op1_0900_rl_s1_r10k)-v(ref_op1_0900_rl_s1_r10k)

* ---- instance 206: op1_1000_rl_s1_r10k (variant rl_s1_r10k; probe dec 11.9 ns, release 34 ns, meas 36 ns) ----
vctl_op1_1000_rl_s1_r10k ctl_op1_1000_rl_s1_r10k 0 pwl(0.0000e+00 {VDD} 2.0000e-09 {VDD} 2.1000e-09 0)
* RWL driver model (EXPERIMENTAL): slew 1 ns, series R 10000 ohm; cell pin = rwls_op1_1000_rl_s1_r10k
vrs_op1_1000_rl_s1_r10k rwlsrc_op1_1000_rl_s1_r10k 0 pwl(0.0000e+00 {VDD} 2.0000e-09 {VDD} 3.0000e-09 0 3.4000e-08 0 3.5000e-08 {VDD})
rdrv_op1_1000_rl_s1_r10k rwlsrc_op1_1000_rl_s1_r10k rwls_op1_1000_rl_s1_r10k 10000
ven_op1_1000_rl_s1_r10k en_op1_1000_rl_s1_r10k 0 pwl(0.0000e+00 0 1.1000e-08 0 1.1100e-08 {VDD} 3.4000e-08 {VDD} 3.4100e-08 0)
venb_op1_1000_rl_s1_r10k enb_op1_1000_rl_s1_r10k 0 pwl(0.0000e+00 {VDD} 1.1000e-08 {VDD} 1.1100e-08 0 3.4000e-08 0 3.4100e-08 {VDD})
vww_op1_1000_rl_s1_r10k wwl_op1_1000_rl_s1_r10k 0 pwl(0.0000e+00 0 1.2000e-08 0 1.2100e-08 {VDD} 3.2000e-08 {VDD} 3.2100e-08 0)
vwc_op1_1000_rl_s1_r10k wbc_op1_1000_rl_s1_r10k 0 pwl(0.0000e+00 0 1.2000e-08 0 1.2100e-08 {VDD} 3.4000e-08 {VDD} 3.4100e-08 0)
swb_op1_1000_rl_s1_r10k ref_op1_1000_rl_s1_r10k wbl_op1_1000_rl_s1_r10k wbc_op1_1000_rl_s1_r10k 0 swwbl
cwbl_op1_1000_rl_s1_r10k wbl_op1_1000_rl_s1_r10k 0 {C_WBL}
spa_op1_1000_rl_s1_r10k prea rbl_op1_1000_rl_s1_r10k ctl_op1_1000_rl_s1_r10k 0 swpre
spr_op1_1000_rl_s1_r10k pref ref_op1_1000_rl_s1_r10k ctl_op1_1000_rl_s1_r10k 0 swpre
crbl_op1_1000_rl_s1_r10k rbl_op1_1000_rl_s1_r10k 0 {C_RBL}
cref_op1_1000_rl_s1_r10k ref_op1_1000_rl_s1_r10k 0 {C_RBL}   $ ASSUMPTION: ideal matched dummy load
XMWR_op1_1000_rl_s1_r10k_0 sn_op1_1000_rl_s1_r10k_0 wwl_op1_1000_rl_s1_r10k wbl_op1_1000_rl_s1_r10k 0 sky130_fd_pr__nfet_01v8 L=0.15 W=0.42 nf=1 ad=0.1218 as=0.1218 pd=1.42 ps=1.42 nrd=0.69047619047619  nrs=0.69047619047619 sa=0 sb=0 sd=0 mult=1 m=1
XMRD_op1_1000_rl_s1_r10k_0 rbl_op1_1000_rl_s1_r10k sn_op1_1000_rl_s1_r10k_0 rwls_op1_1000_rl_s1_r10k 0 sky130_fd_pr__nfet_01v8 L=0.15 W=0.42 nf=1 ad=0.1218 as=0.1218 pd=1.42 ps=1.42 nrd=0.69047619047619  nrs=0.69047619047619 sa=0 sb=0 sd=0 mult=1 m=1
csn_op1_1000_rl_s1_r10k_0 sn_op1_1000_rl_s1_r10k_0 0 {C_SN}
XMWR_op1_1000_rl_s1_r10k_1 sn_op1_1000_rl_s1_r10k_1 wwl_des wbl_op1_1000_rl_s1_r10k 0 sky130_fd_pr__nfet_01v8 L=0.15 W=0.42 nf=1 ad=0.1218 as=0.1218 pd=1.42 ps=1.42 nrd=0.69047619047619  nrs=0.69047619047619 sa=0 sb=0 sd=0 mult=1 m=1
XMRD_op1_1000_rl_s1_r10k_1 rbl_op1_1000_rl_s1_r10k sn_op1_1000_rl_s1_r10k_1 rwl_des 0 sky130_fd_pr__nfet_01v8 L=0.15 W=0.42 nf=1 ad=0.1218 as=0.1218 pd=1.42 ps=1.42 nrd=0.69047619047619  nrs=0.69047619047619 sa=0 sb=0 sd=0 mult=1 m=1
csn_op1_1000_rl_s1_r10k_1 sn_op1_1000_rl_s1_r10k_1 0 {C_SN}
XMWR_op1_1000_rl_s1_r10k_2 sn_op1_1000_rl_s1_r10k_2 wwl_des wbl_op1_1000_rl_s1_r10k 0 sky130_fd_pr__nfet_01v8 L=0.15 W=0.42 nf=1 ad=0.1218 as=0.1218 pd=1.42 ps=1.42 nrd=0.69047619047619  nrs=0.69047619047619 sa=0 sb=0 sd=0 mult=1 m=1
XMRD_op1_1000_rl_s1_r10k_2 rbl_op1_1000_rl_s1_r10k sn_op1_1000_rl_s1_r10k_2 rwl_des 0 sky130_fd_pr__nfet_01v8 L=0.15 W=0.42 nf=1 ad=0.1218 as=0.1218 pd=1.42 ps=1.42 nrd=0.69047619047619  nrs=0.69047619047619 sa=0 sb=0 sd=0 mult=1 m=1
csn_op1_1000_rl_s1_r10k_2 sn_op1_1000_rl_s1_r10k_2 0 {C_SN}
XMWR_op1_1000_rl_s1_r10k_3 sn_op1_1000_rl_s1_r10k_3 wwl_des wbl_op1_1000_rl_s1_r10k 0 sky130_fd_pr__nfet_01v8 L=0.15 W=0.42 nf=1 ad=0.1218 as=0.1218 pd=1.42 ps=1.42 nrd=0.69047619047619  nrs=0.69047619047619 sa=0 sb=0 sd=0 mult=1 m=1
XMRD_op1_1000_rl_s1_r10k_3 rbl_op1_1000_rl_s1_r10k sn_op1_1000_rl_s1_r10k_3 rwl_des 0 sky130_fd_pr__nfet_01v8 L=0.15 W=0.42 nf=1 ad=0.1218 as=0.1218 pd=1.42 ps=1.42 nrd=0.69047619047619  nrs=0.69047619047619 sa=0 sb=0 sd=0 mult=1 m=1
csn_op1_1000_rl_s1_r10k_3 sn_op1_1000_rl_s1_r10k_3 0 {C_SN}
XMN1_op1_1000_rl_s1_r10k rbl_op1_1000_rl_s1_r10k ref_op1_1000_rl_s1_r10k vn_op1_1000_rl_s1_r10k 0 sky130_fd_pr__nfet_01v8 L=0.15 W=1 nf=1 ad=0.29 as=0.29 pd=2.58 ps=2.58 mult=1 m=1
XMN2_op1_1000_rl_s1_r10k ref_op1_1000_rl_s1_r10k rbl_op1_1000_rl_s1_r10k vn_op1_1000_rl_s1_r10k 0 sky130_fd_pr__nfet_01v8 L=0.15 W=1 nf=1 ad=0.29 as=0.29 pd=2.58 ps=2.58 mult=1 m=1
XMP1_op1_1000_rl_s1_r10k rbl_op1_1000_rl_s1_r10k ref_op1_1000_rl_s1_r10k vp_op1_1000_rl_s1_r10k vdd sky130_fd_pr__pfet_01v8 L=0.15 W=2 nf=1 ad=0.58 as=0.58 pd=4.58 ps=4.58 mult=1 m=1
XMP2_op1_1000_rl_s1_r10k ref_op1_1000_rl_s1_r10k rbl_op1_1000_rl_s1_r10k vp_op1_1000_rl_s1_r10k vdd sky130_fd_pr__pfet_01v8 L=0.15 W=2 nf=1 ad=0.58 as=0.58 pd=4.58 ps=4.58 mult=1 m=1
XMNF_op1_1000_rl_s1_r10k vn_op1_1000_rl_s1_r10k en_op1_1000_rl_s1_r10k 0 0 sky130_fd_pr__nfet_01v8 L=0.15 W=2 nf=1 ad=0.58 as=0.58 pd=4.58 ps=4.58 mult=1 m=1
XMPH_op1_1000_rl_s1_r10k vp_op1_1000_rl_s1_r10k enb_op1_1000_rl_s1_r10k vdd vdd sky130_fd_pr__pfet_01v8 L=0.15 W=4 nf=1 ad=1.16 as=1.16 pd=8.58 ps=8.58 mult=1 m=1
bd_op1_1000_rl_s1_r10k d_op1_1000_rl_s1_r10k 0 v=v(rbl_op1_1000_rl_s1_r10k)-v(ref_op1_1000_rl_s1_r10k)

* ---- instance 207: op0_n100_rl_s1_r10k (variant rl_s1_r10k; probe dec 11.9 ns, release 34 ns, meas 36 ns) ----
vctl_op0_n100_rl_s1_r10k ctl_op0_n100_rl_s1_r10k 0 pwl(0.0000e+00 {VDD} 2.0000e-09 {VDD} 2.1000e-09 0)
* RWL driver model (EXPERIMENTAL): slew 1 ns, series R 10000 ohm; cell pin = rwls_op0_n100_rl_s1_r10k
vrs_op0_n100_rl_s1_r10k rwlsrc_op0_n100_rl_s1_r10k 0 pwl(0.0000e+00 {VDD} 2.0000e-09 {VDD} 3.0000e-09 0 3.4000e-08 0 3.5000e-08 {VDD})
rdrv_op0_n100_rl_s1_r10k rwlsrc_op0_n100_rl_s1_r10k rwls_op0_n100_rl_s1_r10k 10000
ven_op0_n100_rl_s1_r10k en_op0_n100_rl_s1_r10k 0 pwl(0.0000e+00 0 1.1000e-08 0 1.1100e-08 {VDD} 3.4000e-08 {VDD} 3.4100e-08 0)
venb_op0_n100_rl_s1_r10k enb_op0_n100_rl_s1_r10k 0 pwl(0.0000e+00 {VDD} 1.1000e-08 {VDD} 1.1100e-08 0 3.4000e-08 0 3.4100e-08 {VDD})
vww_op0_n100_rl_s1_r10k wwl_op0_n100_rl_s1_r10k 0 pwl(0.0000e+00 0 1.2000e-08 0 1.2100e-08 {VDD} 3.2000e-08 {VDD} 3.2100e-08 0)
vwc_op0_n100_rl_s1_r10k wbc_op0_n100_rl_s1_r10k 0 pwl(0.0000e+00 0 1.2000e-08 0 1.2100e-08 {VDD} 3.4000e-08 {VDD} 3.4100e-08 0)
swb_op0_n100_rl_s1_r10k ref_op0_n100_rl_s1_r10k wbl_op0_n100_rl_s1_r10k wbc_op0_n100_rl_s1_r10k 0 swwbl
cwbl_op0_n100_rl_s1_r10k wbl_op0_n100_rl_s1_r10k 0 {C_WBL}
spa_op0_n100_rl_s1_r10k prea rbl_op0_n100_rl_s1_r10k ctl_op0_n100_rl_s1_r10k 0 swpre
spr_op0_n100_rl_s1_r10k pref ref_op0_n100_rl_s1_r10k ctl_op0_n100_rl_s1_r10k 0 swpre
crbl_op0_n100_rl_s1_r10k rbl_op0_n100_rl_s1_r10k 0 {C_RBL}
cref_op0_n100_rl_s1_r10k ref_op0_n100_rl_s1_r10k 0 {C_RBL}   $ ASSUMPTION: ideal matched dummy load
XMWR_op0_n100_rl_s1_r10k_0 sn_op0_n100_rl_s1_r10k_0 wwl_op0_n100_rl_s1_r10k wbl_op0_n100_rl_s1_r10k 0 sky130_fd_pr__nfet_01v8 L=0.15 W=0.42 nf=1 ad=0.1218 as=0.1218 pd=1.42 ps=1.42 nrd=0.69047619047619  nrs=0.69047619047619 sa=0 sb=0 sd=0 mult=1 m=1
XMRD_op0_n100_rl_s1_r10k_0 rbl_op0_n100_rl_s1_r10k sn_op0_n100_rl_s1_r10k_0 rwls_op0_n100_rl_s1_r10k 0 sky130_fd_pr__nfet_01v8 L=0.15 W=0.42 nf=1 ad=0.1218 as=0.1218 pd=1.42 ps=1.42 nrd=0.69047619047619  nrs=0.69047619047619 sa=0 sb=0 sd=0 mult=1 m=1
csn_op0_n100_rl_s1_r10k_0 sn_op0_n100_rl_s1_r10k_0 0 {C_SN}
XMWR_op0_n100_rl_s1_r10k_1 sn_op0_n100_rl_s1_r10k_1 wwl_des wbl_op0_n100_rl_s1_r10k 0 sky130_fd_pr__nfet_01v8 L=0.15 W=0.42 nf=1 ad=0.1218 as=0.1218 pd=1.42 ps=1.42 nrd=0.69047619047619  nrs=0.69047619047619 sa=0 sb=0 sd=0 mult=1 m=1
XMRD_op0_n100_rl_s1_r10k_1 rbl_op0_n100_rl_s1_r10k sn_op0_n100_rl_s1_r10k_1 rwl_des 0 sky130_fd_pr__nfet_01v8 L=0.15 W=0.42 nf=1 ad=0.1218 as=0.1218 pd=1.42 ps=1.42 nrd=0.69047619047619  nrs=0.69047619047619 sa=0 sb=0 sd=0 mult=1 m=1
csn_op0_n100_rl_s1_r10k_1 sn_op0_n100_rl_s1_r10k_1 0 {C_SN}
XMWR_op0_n100_rl_s1_r10k_2 sn_op0_n100_rl_s1_r10k_2 wwl_des wbl_op0_n100_rl_s1_r10k 0 sky130_fd_pr__nfet_01v8 L=0.15 W=0.42 nf=1 ad=0.1218 as=0.1218 pd=1.42 ps=1.42 nrd=0.69047619047619  nrs=0.69047619047619 sa=0 sb=0 sd=0 mult=1 m=1
XMRD_op0_n100_rl_s1_r10k_2 rbl_op0_n100_rl_s1_r10k sn_op0_n100_rl_s1_r10k_2 rwl_des 0 sky130_fd_pr__nfet_01v8 L=0.15 W=0.42 nf=1 ad=0.1218 as=0.1218 pd=1.42 ps=1.42 nrd=0.69047619047619  nrs=0.69047619047619 sa=0 sb=0 sd=0 mult=1 m=1
csn_op0_n100_rl_s1_r10k_2 sn_op0_n100_rl_s1_r10k_2 0 {C_SN}
XMWR_op0_n100_rl_s1_r10k_3 sn_op0_n100_rl_s1_r10k_3 wwl_des wbl_op0_n100_rl_s1_r10k 0 sky130_fd_pr__nfet_01v8 L=0.15 W=0.42 nf=1 ad=0.1218 as=0.1218 pd=1.42 ps=1.42 nrd=0.69047619047619  nrs=0.69047619047619 sa=0 sb=0 sd=0 mult=1 m=1
XMRD_op0_n100_rl_s1_r10k_3 rbl_op0_n100_rl_s1_r10k sn_op0_n100_rl_s1_r10k_3 rwl_des 0 sky130_fd_pr__nfet_01v8 L=0.15 W=0.42 nf=1 ad=0.1218 as=0.1218 pd=1.42 ps=1.42 nrd=0.69047619047619  nrs=0.69047619047619 sa=0 sb=0 sd=0 mult=1 m=1
csn_op0_n100_rl_s1_r10k_3 sn_op0_n100_rl_s1_r10k_3 0 {C_SN}
XMN1_op0_n100_rl_s1_r10k rbl_op0_n100_rl_s1_r10k ref_op0_n100_rl_s1_r10k vn_op0_n100_rl_s1_r10k 0 sky130_fd_pr__nfet_01v8 L=0.15 W=1 nf=1 ad=0.29 as=0.29 pd=2.58 ps=2.58 mult=1 m=1
XMN2_op0_n100_rl_s1_r10k ref_op0_n100_rl_s1_r10k rbl_op0_n100_rl_s1_r10k vn_op0_n100_rl_s1_r10k 0 sky130_fd_pr__nfet_01v8 L=0.15 W=1 nf=1 ad=0.29 as=0.29 pd=2.58 ps=2.58 mult=1 m=1
XMP1_op0_n100_rl_s1_r10k rbl_op0_n100_rl_s1_r10k ref_op0_n100_rl_s1_r10k vp_op0_n100_rl_s1_r10k vdd sky130_fd_pr__pfet_01v8 L=0.15 W=2 nf=1 ad=0.58 as=0.58 pd=4.58 ps=4.58 mult=1 m=1
XMP2_op0_n100_rl_s1_r10k ref_op0_n100_rl_s1_r10k rbl_op0_n100_rl_s1_r10k vp_op0_n100_rl_s1_r10k vdd sky130_fd_pr__pfet_01v8 L=0.15 W=2 nf=1 ad=0.58 as=0.58 pd=4.58 ps=4.58 mult=1 m=1
XMNF_op0_n100_rl_s1_r10k vn_op0_n100_rl_s1_r10k en_op0_n100_rl_s1_r10k 0 0 sky130_fd_pr__nfet_01v8 L=0.15 W=2 nf=1 ad=0.58 as=0.58 pd=4.58 ps=4.58 mult=1 m=1
XMPH_op0_n100_rl_s1_r10k vp_op0_n100_rl_s1_r10k enb_op0_n100_rl_s1_r10k vdd vdd sky130_fd_pr__pfet_01v8 L=0.15 W=4 nf=1 ad=1.16 as=1.16 pd=8.58 ps=8.58 mult=1 m=1
bd_op0_n100_rl_s1_r10k d_op0_n100_rl_s1_r10k 0 v=v(rbl_op0_n100_rl_s1_r10k)-v(ref_op0_n100_rl_s1_r10k)

* ---- instance 208: op0_0000_rl_s1_r10k (variant rl_s1_r10k; probe dec 11.9 ns, release 34 ns, meas 36 ns) ----
vctl_op0_0000_rl_s1_r10k ctl_op0_0000_rl_s1_r10k 0 pwl(0.0000e+00 {VDD} 2.0000e-09 {VDD} 2.1000e-09 0)
* RWL driver model (EXPERIMENTAL): slew 1 ns, series R 10000 ohm; cell pin = rwls_op0_0000_rl_s1_r10k
vrs_op0_0000_rl_s1_r10k rwlsrc_op0_0000_rl_s1_r10k 0 pwl(0.0000e+00 {VDD} 2.0000e-09 {VDD} 3.0000e-09 0 3.4000e-08 0 3.5000e-08 {VDD})
rdrv_op0_0000_rl_s1_r10k rwlsrc_op0_0000_rl_s1_r10k rwls_op0_0000_rl_s1_r10k 10000
ven_op0_0000_rl_s1_r10k en_op0_0000_rl_s1_r10k 0 pwl(0.0000e+00 0 1.1000e-08 0 1.1100e-08 {VDD} 3.4000e-08 {VDD} 3.4100e-08 0)
venb_op0_0000_rl_s1_r10k enb_op0_0000_rl_s1_r10k 0 pwl(0.0000e+00 {VDD} 1.1000e-08 {VDD} 1.1100e-08 0 3.4000e-08 0 3.4100e-08 {VDD})
vww_op0_0000_rl_s1_r10k wwl_op0_0000_rl_s1_r10k 0 pwl(0.0000e+00 0 1.2000e-08 0 1.2100e-08 {VDD} 3.2000e-08 {VDD} 3.2100e-08 0)
vwc_op0_0000_rl_s1_r10k wbc_op0_0000_rl_s1_r10k 0 pwl(0.0000e+00 0 1.2000e-08 0 1.2100e-08 {VDD} 3.4000e-08 {VDD} 3.4100e-08 0)
swb_op0_0000_rl_s1_r10k ref_op0_0000_rl_s1_r10k wbl_op0_0000_rl_s1_r10k wbc_op0_0000_rl_s1_r10k 0 swwbl
cwbl_op0_0000_rl_s1_r10k wbl_op0_0000_rl_s1_r10k 0 {C_WBL}
spa_op0_0000_rl_s1_r10k prea rbl_op0_0000_rl_s1_r10k ctl_op0_0000_rl_s1_r10k 0 swpre
spr_op0_0000_rl_s1_r10k pref ref_op0_0000_rl_s1_r10k ctl_op0_0000_rl_s1_r10k 0 swpre
crbl_op0_0000_rl_s1_r10k rbl_op0_0000_rl_s1_r10k 0 {C_RBL}
cref_op0_0000_rl_s1_r10k ref_op0_0000_rl_s1_r10k 0 {C_RBL}   $ ASSUMPTION: ideal matched dummy load
XMWR_op0_0000_rl_s1_r10k_0 sn_op0_0000_rl_s1_r10k_0 wwl_op0_0000_rl_s1_r10k wbl_op0_0000_rl_s1_r10k 0 sky130_fd_pr__nfet_01v8 L=0.15 W=0.42 nf=1 ad=0.1218 as=0.1218 pd=1.42 ps=1.42 nrd=0.69047619047619  nrs=0.69047619047619 sa=0 sb=0 sd=0 mult=1 m=1
XMRD_op0_0000_rl_s1_r10k_0 rbl_op0_0000_rl_s1_r10k sn_op0_0000_rl_s1_r10k_0 rwls_op0_0000_rl_s1_r10k 0 sky130_fd_pr__nfet_01v8 L=0.15 W=0.42 nf=1 ad=0.1218 as=0.1218 pd=1.42 ps=1.42 nrd=0.69047619047619  nrs=0.69047619047619 sa=0 sb=0 sd=0 mult=1 m=1
csn_op0_0000_rl_s1_r10k_0 sn_op0_0000_rl_s1_r10k_0 0 {C_SN}
XMWR_op0_0000_rl_s1_r10k_1 sn_op0_0000_rl_s1_r10k_1 wwl_des wbl_op0_0000_rl_s1_r10k 0 sky130_fd_pr__nfet_01v8 L=0.15 W=0.42 nf=1 ad=0.1218 as=0.1218 pd=1.42 ps=1.42 nrd=0.69047619047619  nrs=0.69047619047619 sa=0 sb=0 sd=0 mult=1 m=1
XMRD_op0_0000_rl_s1_r10k_1 rbl_op0_0000_rl_s1_r10k sn_op0_0000_rl_s1_r10k_1 rwl_des 0 sky130_fd_pr__nfet_01v8 L=0.15 W=0.42 nf=1 ad=0.1218 as=0.1218 pd=1.42 ps=1.42 nrd=0.69047619047619  nrs=0.69047619047619 sa=0 sb=0 sd=0 mult=1 m=1
csn_op0_0000_rl_s1_r10k_1 sn_op0_0000_rl_s1_r10k_1 0 {C_SN}
XMWR_op0_0000_rl_s1_r10k_2 sn_op0_0000_rl_s1_r10k_2 wwl_des wbl_op0_0000_rl_s1_r10k 0 sky130_fd_pr__nfet_01v8 L=0.15 W=0.42 nf=1 ad=0.1218 as=0.1218 pd=1.42 ps=1.42 nrd=0.69047619047619  nrs=0.69047619047619 sa=0 sb=0 sd=0 mult=1 m=1
XMRD_op0_0000_rl_s1_r10k_2 rbl_op0_0000_rl_s1_r10k sn_op0_0000_rl_s1_r10k_2 rwl_des 0 sky130_fd_pr__nfet_01v8 L=0.15 W=0.42 nf=1 ad=0.1218 as=0.1218 pd=1.42 ps=1.42 nrd=0.69047619047619  nrs=0.69047619047619 sa=0 sb=0 sd=0 mult=1 m=1
csn_op0_0000_rl_s1_r10k_2 sn_op0_0000_rl_s1_r10k_2 0 {C_SN}
XMWR_op0_0000_rl_s1_r10k_3 sn_op0_0000_rl_s1_r10k_3 wwl_des wbl_op0_0000_rl_s1_r10k 0 sky130_fd_pr__nfet_01v8 L=0.15 W=0.42 nf=1 ad=0.1218 as=0.1218 pd=1.42 ps=1.42 nrd=0.69047619047619  nrs=0.69047619047619 sa=0 sb=0 sd=0 mult=1 m=1
XMRD_op0_0000_rl_s1_r10k_3 rbl_op0_0000_rl_s1_r10k sn_op0_0000_rl_s1_r10k_3 rwl_des 0 sky130_fd_pr__nfet_01v8 L=0.15 W=0.42 nf=1 ad=0.1218 as=0.1218 pd=1.42 ps=1.42 nrd=0.69047619047619  nrs=0.69047619047619 sa=0 sb=0 sd=0 mult=1 m=1
csn_op0_0000_rl_s1_r10k_3 sn_op0_0000_rl_s1_r10k_3 0 {C_SN}
XMN1_op0_0000_rl_s1_r10k rbl_op0_0000_rl_s1_r10k ref_op0_0000_rl_s1_r10k vn_op0_0000_rl_s1_r10k 0 sky130_fd_pr__nfet_01v8 L=0.15 W=1 nf=1 ad=0.29 as=0.29 pd=2.58 ps=2.58 mult=1 m=1
XMN2_op0_0000_rl_s1_r10k ref_op0_0000_rl_s1_r10k rbl_op0_0000_rl_s1_r10k vn_op0_0000_rl_s1_r10k 0 sky130_fd_pr__nfet_01v8 L=0.15 W=1 nf=1 ad=0.29 as=0.29 pd=2.58 ps=2.58 mult=1 m=1
XMP1_op0_0000_rl_s1_r10k rbl_op0_0000_rl_s1_r10k ref_op0_0000_rl_s1_r10k vp_op0_0000_rl_s1_r10k vdd sky130_fd_pr__pfet_01v8 L=0.15 W=2 nf=1 ad=0.58 as=0.58 pd=4.58 ps=4.58 mult=1 m=1
XMP2_op0_0000_rl_s1_r10k ref_op0_0000_rl_s1_r10k rbl_op0_0000_rl_s1_r10k vp_op0_0000_rl_s1_r10k vdd sky130_fd_pr__pfet_01v8 L=0.15 W=2 nf=1 ad=0.58 as=0.58 pd=4.58 ps=4.58 mult=1 m=1
XMNF_op0_0000_rl_s1_r10k vn_op0_0000_rl_s1_r10k en_op0_0000_rl_s1_r10k 0 0 sky130_fd_pr__nfet_01v8 L=0.15 W=2 nf=1 ad=0.58 as=0.58 pd=4.58 ps=4.58 mult=1 m=1
XMPH_op0_0000_rl_s1_r10k vp_op0_0000_rl_s1_r10k enb_op0_0000_rl_s1_r10k vdd vdd sky130_fd_pr__pfet_01v8 L=0.15 W=4 nf=1 ad=1.16 as=1.16 pd=8.58 ps=8.58 mult=1 m=1
bd_op0_0000_rl_s1_r10k d_op0_0000_rl_s1_r10k 0 v=v(rbl_op0_0000_rl_s1_r10k)-v(ref_op0_0000_rl_s1_r10k)

* ---- instance 209: op1_0900_rl_s1_r100k (variant rl_s1_r100k; probe dec 11.9 ns, release 34 ns, meas 36 ns) ----
vctl_op1_0900_rl_s1_r100k ctl_op1_0900_rl_s1_r100k 0 pwl(0.0000e+00 {VDD} 2.0000e-09 {VDD} 2.1000e-09 0)
* RWL driver model (EXPERIMENTAL): slew 1 ns, series R 100000 ohm; cell pin = rwls_op1_0900_rl_s1_r100k
vrs_op1_0900_rl_s1_r100k rwlsrc_op1_0900_rl_s1_r100k 0 pwl(0.0000e+00 {VDD} 2.0000e-09 {VDD} 3.0000e-09 0 3.4000e-08 0 3.5000e-08 {VDD})
rdrv_op1_0900_rl_s1_r100k rwlsrc_op1_0900_rl_s1_r100k rwls_op1_0900_rl_s1_r100k 100000
ven_op1_0900_rl_s1_r100k en_op1_0900_rl_s1_r100k 0 pwl(0.0000e+00 0 1.1000e-08 0 1.1100e-08 {VDD} 3.4000e-08 {VDD} 3.4100e-08 0)
venb_op1_0900_rl_s1_r100k enb_op1_0900_rl_s1_r100k 0 pwl(0.0000e+00 {VDD} 1.1000e-08 {VDD} 1.1100e-08 0 3.4000e-08 0 3.4100e-08 {VDD})
vww_op1_0900_rl_s1_r100k wwl_op1_0900_rl_s1_r100k 0 pwl(0.0000e+00 0 1.2000e-08 0 1.2100e-08 {VDD} 3.2000e-08 {VDD} 3.2100e-08 0)
vwc_op1_0900_rl_s1_r100k wbc_op1_0900_rl_s1_r100k 0 pwl(0.0000e+00 0 1.2000e-08 0 1.2100e-08 {VDD} 3.4000e-08 {VDD} 3.4100e-08 0)
swb_op1_0900_rl_s1_r100k ref_op1_0900_rl_s1_r100k wbl_op1_0900_rl_s1_r100k wbc_op1_0900_rl_s1_r100k 0 swwbl
cwbl_op1_0900_rl_s1_r100k wbl_op1_0900_rl_s1_r100k 0 {C_WBL}
spa_op1_0900_rl_s1_r100k prea rbl_op1_0900_rl_s1_r100k ctl_op1_0900_rl_s1_r100k 0 swpre
spr_op1_0900_rl_s1_r100k pref ref_op1_0900_rl_s1_r100k ctl_op1_0900_rl_s1_r100k 0 swpre
crbl_op1_0900_rl_s1_r100k rbl_op1_0900_rl_s1_r100k 0 {C_RBL}
cref_op1_0900_rl_s1_r100k ref_op1_0900_rl_s1_r100k 0 {C_RBL}   $ ASSUMPTION: ideal matched dummy load
XMWR_op1_0900_rl_s1_r100k_0 sn_op1_0900_rl_s1_r100k_0 wwl_op1_0900_rl_s1_r100k wbl_op1_0900_rl_s1_r100k 0 sky130_fd_pr__nfet_01v8 L=0.15 W=0.42 nf=1 ad=0.1218 as=0.1218 pd=1.42 ps=1.42 nrd=0.69047619047619  nrs=0.69047619047619 sa=0 sb=0 sd=0 mult=1 m=1
XMRD_op1_0900_rl_s1_r100k_0 rbl_op1_0900_rl_s1_r100k sn_op1_0900_rl_s1_r100k_0 rwls_op1_0900_rl_s1_r100k 0 sky130_fd_pr__nfet_01v8 L=0.15 W=0.42 nf=1 ad=0.1218 as=0.1218 pd=1.42 ps=1.42 nrd=0.69047619047619  nrs=0.69047619047619 sa=0 sb=0 sd=0 mult=1 m=1
csn_op1_0900_rl_s1_r100k_0 sn_op1_0900_rl_s1_r100k_0 0 {C_SN}
XMWR_op1_0900_rl_s1_r100k_1 sn_op1_0900_rl_s1_r100k_1 wwl_des wbl_op1_0900_rl_s1_r100k 0 sky130_fd_pr__nfet_01v8 L=0.15 W=0.42 nf=1 ad=0.1218 as=0.1218 pd=1.42 ps=1.42 nrd=0.69047619047619  nrs=0.69047619047619 sa=0 sb=0 sd=0 mult=1 m=1
XMRD_op1_0900_rl_s1_r100k_1 rbl_op1_0900_rl_s1_r100k sn_op1_0900_rl_s1_r100k_1 rwl_des 0 sky130_fd_pr__nfet_01v8 L=0.15 W=0.42 nf=1 ad=0.1218 as=0.1218 pd=1.42 ps=1.42 nrd=0.69047619047619  nrs=0.69047619047619 sa=0 sb=0 sd=0 mult=1 m=1
csn_op1_0900_rl_s1_r100k_1 sn_op1_0900_rl_s1_r100k_1 0 {C_SN}
XMWR_op1_0900_rl_s1_r100k_2 sn_op1_0900_rl_s1_r100k_2 wwl_des wbl_op1_0900_rl_s1_r100k 0 sky130_fd_pr__nfet_01v8 L=0.15 W=0.42 nf=1 ad=0.1218 as=0.1218 pd=1.42 ps=1.42 nrd=0.69047619047619  nrs=0.69047619047619 sa=0 sb=0 sd=0 mult=1 m=1
XMRD_op1_0900_rl_s1_r100k_2 rbl_op1_0900_rl_s1_r100k sn_op1_0900_rl_s1_r100k_2 rwl_des 0 sky130_fd_pr__nfet_01v8 L=0.15 W=0.42 nf=1 ad=0.1218 as=0.1218 pd=1.42 ps=1.42 nrd=0.69047619047619  nrs=0.69047619047619 sa=0 sb=0 sd=0 mult=1 m=1
csn_op1_0900_rl_s1_r100k_2 sn_op1_0900_rl_s1_r100k_2 0 {C_SN}
XMWR_op1_0900_rl_s1_r100k_3 sn_op1_0900_rl_s1_r100k_3 wwl_des wbl_op1_0900_rl_s1_r100k 0 sky130_fd_pr__nfet_01v8 L=0.15 W=0.42 nf=1 ad=0.1218 as=0.1218 pd=1.42 ps=1.42 nrd=0.69047619047619  nrs=0.69047619047619 sa=0 sb=0 sd=0 mult=1 m=1
XMRD_op1_0900_rl_s1_r100k_3 rbl_op1_0900_rl_s1_r100k sn_op1_0900_rl_s1_r100k_3 rwl_des 0 sky130_fd_pr__nfet_01v8 L=0.15 W=0.42 nf=1 ad=0.1218 as=0.1218 pd=1.42 ps=1.42 nrd=0.69047619047619  nrs=0.69047619047619 sa=0 sb=0 sd=0 mult=1 m=1
csn_op1_0900_rl_s1_r100k_3 sn_op1_0900_rl_s1_r100k_3 0 {C_SN}
XMN1_op1_0900_rl_s1_r100k rbl_op1_0900_rl_s1_r100k ref_op1_0900_rl_s1_r100k vn_op1_0900_rl_s1_r100k 0 sky130_fd_pr__nfet_01v8 L=0.15 W=1 nf=1 ad=0.29 as=0.29 pd=2.58 ps=2.58 mult=1 m=1
XMN2_op1_0900_rl_s1_r100k ref_op1_0900_rl_s1_r100k rbl_op1_0900_rl_s1_r100k vn_op1_0900_rl_s1_r100k 0 sky130_fd_pr__nfet_01v8 L=0.15 W=1 nf=1 ad=0.29 as=0.29 pd=2.58 ps=2.58 mult=1 m=1
XMP1_op1_0900_rl_s1_r100k rbl_op1_0900_rl_s1_r100k ref_op1_0900_rl_s1_r100k vp_op1_0900_rl_s1_r100k vdd sky130_fd_pr__pfet_01v8 L=0.15 W=2 nf=1 ad=0.58 as=0.58 pd=4.58 ps=4.58 mult=1 m=1
XMP2_op1_0900_rl_s1_r100k ref_op1_0900_rl_s1_r100k rbl_op1_0900_rl_s1_r100k vp_op1_0900_rl_s1_r100k vdd sky130_fd_pr__pfet_01v8 L=0.15 W=2 nf=1 ad=0.58 as=0.58 pd=4.58 ps=4.58 mult=1 m=1
XMNF_op1_0900_rl_s1_r100k vn_op1_0900_rl_s1_r100k en_op1_0900_rl_s1_r100k 0 0 sky130_fd_pr__nfet_01v8 L=0.15 W=2 nf=1 ad=0.58 as=0.58 pd=4.58 ps=4.58 mult=1 m=1
XMPH_op1_0900_rl_s1_r100k vp_op1_0900_rl_s1_r100k enb_op1_0900_rl_s1_r100k vdd vdd sky130_fd_pr__pfet_01v8 L=0.15 W=4 nf=1 ad=1.16 as=1.16 pd=8.58 ps=8.58 mult=1 m=1
bd_op1_0900_rl_s1_r100k d_op1_0900_rl_s1_r100k 0 v=v(rbl_op1_0900_rl_s1_r100k)-v(ref_op1_0900_rl_s1_r100k)

* ---- instance 210: op1_1000_rl_s1_r100k (variant rl_s1_r100k; probe dec 11.9 ns, release 34 ns, meas 36 ns) ----
vctl_op1_1000_rl_s1_r100k ctl_op1_1000_rl_s1_r100k 0 pwl(0.0000e+00 {VDD} 2.0000e-09 {VDD} 2.1000e-09 0)
* RWL driver model (EXPERIMENTAL): slew 1 ns, series R 100000 ohm; cell pin = rwls_op1_1000_rl_s1_r100k
vrs_op1_1000_rl_s1_r100k rwlsrc_op1_1000_rl_s1_r100k 0 pwl(0.0000e+00 {VDD} 2.0000e-09 {VDD} 3.0000e-09 0 3.4000e-08 0 3.5000e-08 {VDD})
rdrv_op1_1000_rl_s1_r100k rwlsrc_op1_1000_rl_s1_r100k rwls_op1_1000_rl_s1_r100k 100000
ven_op1_1000_rl_s1_r100k en_op1_1000_rl_s1_r100k 0 pwl(0.0000e+00 0 1.1000e-08 0 1.1100e-08 {VDD} 3.4000e-08 {VDD} 3.4100e-08 0)
venb_op1_1000_rl_s1_r100k enb_op1_1000_rl_s1_r100k 0 pwl(0.0000e+00 {VDD} 1.1000e-08 {VDD} 1.1100e-08 0 3.4000e-08 0 3.4100e-08 {VDD})
vww_op1_1000_rl_s1_r100k wwl_op1_1000_rl_s1_r100k 0 pwl(0.0000e+00 0 1.2000e-08 0 1.2100e-08 {VDD} 3.2000e-08 {VDD} 3.2100e-08 0)
vwc_op1_1000_rl_s1_r100k wbc_op1_1000_rl_s1_r100k 0 pwl(0.0000e+00 0 1.2000e-08 0 1.2100e-08 {VDD} 3.4000e-08 {VDD} 3.4100e-08 0)
swb_op1_1000_rl_s1_r100k ref_op1_1000_rl_s1_r100k wbl_op1_1000_rl_s1_r100k wbc_op1_1000_rl_s1_r100k 0 swwbl
cwbl_op1_1000_rl_s1_r100k wbl_op1_1000_rl_s1_r100k 0 {C_WBL}
spa_op1_1000_rl_s1_r100k prea rbl_op1_1000_rl_s1_r100k ctl_op1_1000_rl_s1_r100k 0 swpre
spr_op1_1000_rl_s1_r100k pref ref_op1_1000_rl_s1_r100k ctl_op1_1000_rl_s1_r100k 0 swpre
crbl_op1_1000_rl_s1_r100k rbl_op1_1000_rl_s1_r100k 0 {C_RBL}
cref_op1_1000_rl_s1_r100k ref_op1_1000_rl_s1_r100k 0 {C_RBL}   $ ASSUMPTION: ideal matched dummy load
XMWR_op1_1000_rl_s1_r100k_0 sn_op1_1000_rl_s1_r100k_0 wwl_op1_1000_rl_s1_r100k wbl_op1_1000_rl_s1_r100k 0 sky130_fd_pr__nfet_01v8 L=0.15 W=0.42 nf=1 ad=0.1218 as=0.1218 pd=1.42 ps=1.42 nrd=0.69047619047619  nrs=0.69047619047619 sa=0 sb=0 sd=0 mult=1 m=1
XMRD_op1_1000_rl_s1_r100k_0 rbl_op1_1000_rl_s1_r100k sn_op1_1000_rl_s1_r100k_0 rwls_op1_1000_rl_s1_r100k 0 sky130_fd_pr__nfet_01v8 L=0.15 W=0.42 nf=1 ad=0.1218 as=0.1218 pd=1.42 ps=1.42 nrd=0.69047619047619  nrs=0.69047619047619 sa=0 sb=0 sd=0 mult=1 m=1
csn_op1_1000_rl_s1_r100k_0 sn_op1_1000_rl_s1_r100k_0 0 {C_SN}
XMWR_op1_1000_rl_s1_r100k_1 sn_op1_1000_rl_s1_r100k_1 wwl_des wbl_op1_1000_rl_s1_r100k 0 sky130_fd_pr__nfet_01v8 L=0.15 W=0.42 nf=1 ad=0.1218 as=0.1218 pd=1.42 ps=1.42 nrd=0.69047619047619  nrs=0.69047619047619 sa=0 sb=0 sd=0 mult=1 m=1
XMRD_op1_1000_rl_s1_r100k_1 rbl_op1_1000_rl_s1_r100k sn_op1_1000_rl_s1_r100k_1 rwl_des 0 sky130_fd_pr__nfet_01v8 L=0.15 W=0.42 nf=1 ad=0.1218 as=0.1218 pd=1.42 ps=1.42 nrd=0.69047619047619  nrs=0.69047619047619 sa=0 sb=0 sd=0 mult=1 m=1
csn_op1_1000_rl_s1_r100k_1 sn_op1_1000_rl_s1_r100k_1 0 {C_SN}
XMWR_op1_1000_rl_s1_r100k_2 sn_op1_1000_rl_s1_r100k_2 wwl_des wbl_op1_1000_rl_s1_r100k 0 sky130_fd_pr__nfet_01v8 L=0.15 W=0.42 nf=1 ad=0.1218 as=0.1218 pd=1.42 ps=1.42 nrd=0.69047619047619  nrs=0.69047619047619 sa=0 sb=0 sd=0 mult=1 m=1
XMRD_op1_1000_rl_s1_r100k_2 rbl_op1_1000_rl_s1_r100k sn_op1_1000_rl_s1_r100k_2 rwl_des 0 sky130_fd_pr__nfet_01v8 L=0.15 W=0.42 nf=1 ad=0.1218 as=0.1218 pd=1.42 ps=1.42 nrd=0.69047619047619  nrs=0.69047619047619 sa=0 sb=0 sd=0 mult=1 m=1
csn_op1_1000_rl_s1_r100k_2 sn_op1_1000_rl_s1_r100k_2 0 {C_SN}
XMWR_op1_1000_rl_s1_r100k_3 sn_op1_1000_rl_s1_r100k_3 wwl_des wbl_op1_1000_rl_s1_r100k 0 sky130_fd_pr__nfet_01v8 L=0.15 W=0.42 nf=1 ad=0.1218 as=0.1218 pd=1.42 ps=1.42 nrd=0.69047619047619  nrs=0.69047619047619 sa=0 sb=0 sd=0 mult=1 m=1
XMRD_op1_1000_rl_s1_r100k_3 rbl_op1_1000_rl_s1_r100k sn_op1_1000_rl_s1_r100k_3 rwl_des 0 sky130_fd_pr__nfet_01v8 L=0.15 W=0.42 nf=1 ad=0.1218 as=0.1218 pd=1.42 ps=1.42 nrd=0.69047619047619  nrs=0.69047619047619 sa=0 sb=0 sd=0 mult=1 m=1
csn_op1_1000_rl_s1_r100k_3 sn_op1_1000_rl_s1_r100k_3 0 {C_SN}
XMN1_op1_1000_rl_s1_r100k rbl_op1_1000_rl_s1_r100k ref_op1_1000_rl_s1_r100k vn_op1_1000_rl_s1_r100k 0 sky130_fd_pr__nfet_01v8 L=0.15 W=1 nf=1 ad=0.29 as=0.29 pd=2.58 ps=2.58 mult=1 m=1
XMN2_op1_1000_rl_s1_r100k ref_op1_1000_rl_s1_r100k rbl_op1_1000_rl_s1_r100k vn_op1_1000_rl_s1_r100k 0 sky130_fd_pr__nfet_01v8 L=0.15 W=1 nf=1 ad=0.29 as=0.29 pd=2.58 ps=2.58 mult=1 m=1
XMP1_op1_1000_rl_s1_r100k rbl_op1_1000_rl_s1_r100k ref_op1_1000_rl_s1_r100k vp_op1_1000_rl_s1_r100k vdd sky130_fd_pr__pfet_01v8 L=0.15 W=2 nf=1 ad=0.58 as=0.58 pd=4.58 ps=4.58 mult=1 m=1
XMP2_op1_1000_rl_s1_r100k ref_op1_1000_rl_s1_r100k rbl_op1_1000_rl_s1_r100k vp_op1_1000_rl_s1_r100k vdd sky130_fd_pr__pfet_01v8 L=0.15 W=2 nf=1 ad=0.58 as=0.58 pd=4.58 ps=4.58 mult=1 m=1
XMNF_op1_1000_rl_s1_r100k vn_op1_1000_rl_s1_r100k en_op1_1000_rl_s1_r100k 0 0 sky130_fd_pr__nfet_01v8 L=0.15 W=2 nf=1 ad=0.58 as=0.58 pd=4.58 ps=4.58 mult=1 m=1
XMPH_op1_1000_rl_s1_r100k vp_op1_1000_rl_s1_r100k enb_op1_1000_rl_s1_r100k vdd vdd sky130_fd_pr__pfet_01v8 L=0.15 W=4 nf=1 ad=1.16 as=1.16 pd=8.58 ps=8.58 mult=1 m=1
bd_op1_1000_rl_s1_r100k d_op1_1000_rl_s1_r100k 0 v=v(rbl_op1_1000_rl_s1_r100k)-v(ref_op1_1000_rl_s1_r100k)

* ---- instance 211: op0_n100_rl_s1_r100k (variant rl_s1_r100k; probe dec 11.9 ns, release 34 ns, meas 36 ns) ----
vctl_op0_n100_rl_s1_r100k ctl_op0_n100_rl_s1_r100k 0 pwl(0.0000e+00 {VDD} 2.0000e-09 {VDD} 2.1000e-09 0)
* RWL driver model (EXPERIMENTAL): slew 1 ns, series R 100000 ohm; cell pin = rwls_op0_n100_rl_s1_r100k
vrs_op0_n100_rl_s1_r100k rwlsrc_op0_n100_rl_s1_r100k 0 pwl(0.0000e+00 {VDD} 2.0000e-09 {VDD} 3.0000e-09 0 3.4000e-08 0 3.5000e-08 {VDD})
rdrv_op0_n100_rl_s1_r100k rwlsrc_op0_n100_rl_s1_r100k rwls_op0_n100_rl_s1_r100k 100000
ven_op0_n100_rl_s1_r100k en_op0_n100_rl_s1_r100k 0 pwl(0.0000e+00 0 1.1000e-08 0 1.1100e-08 {VDD} 3.4000e-08 {VDD} 3.4100e-08 0)
venb_op0_n100_rl_s1_r100k enb_op0_n100_rl_s1_r100k 0 pwl(0.0000e+00 {VDD} 1.1000e-08 {VDD} 1.1100e-08 0 3.4000e-08 0 3.4100e-08 {VDD})
vww_op0_n100_rl_s1_r100k wwl_op0_n100_rl_s1_r100k 0 pwl(0.0000e+00 0 1.2000e-08 0 1.2100e-08 {VDD} 3.2000e-08 {VDD} 3.2100e-08 0)
vwc_op0_n100_rl_s1_r100k wbc_op0_n100_rl_s1_r100k 0 pwl(0.0000e+00 0 1.2000e-08 0 1.2100e-08 {VDD} 3.4000e-08 {VDD} 3.4100e-08 0)
swb_op0_n100_rl_s1_r100k ref_op0_n100_rl_s1_r100k wbl_op0_n100_rl_s1_r100k wbc_op0_n100_rl_s1_r100k 0 swwbl
cwbl_op0_n100_rl_s1_r100k wbl_op0_n100_rl_s1_r100k 0 {C_WBL}
spa_op0_n100_rl_s1_r100k prea rbl_op0_n100_rl_s1_r100k ctl_op0_n100_rl_s1_r100k 0 swpre
spr_op0_n100_rl_s1_r100k pref ref_op0_n100_rl_s1_r100k ctl_op0_n100_rl_s1_r100k 0 swpre
crbl_op0_n100_rl_s1_r100k rbl_op0_n100_rl_s1_r100k 0 {C_RBL}
cref_op0_n100_rl_s1_r100k ref_op0_n100_rl_s1_r100k 0 {C_RBL}   $ ASSUMPTION: ideal matched dummy load
XMWR_op0_n100_rl_s1_r100k_0 sn_op0_n100_rl_s1_r100k_0 wwl_op0_n100_rl_s1_r100k wbl_op0_n100_rl_s1_r100k 0 sky130_fd_pr__nfet_01v8 L=0.15 W=0.42 nf=1 ad=0.1218 as=0.1218 pd=1.42 ps=1.42 nrd=0.69047619047619  nrs=0.69047619047619 sa=0 sb=0 sd=0 mult=1 m=1
XMRD_op0_n100_rl_s1_r100k_0 rbl_op0_n100_rl_s1_r100k sn_op0_n100_rl_s1_r100k_0 rwls_op0_n100_rl_s1_r100k 0 sky130_fd_pr__nfet_01v8 L=0.15 W=0.42 nf=1 ad=0.1218 as=0.1218 pd=1.42 ps=1.42 nrd=0.69047619047619  nrs=0.69047619047619 sa=0 sb=0 sd=0 mult=1 m=1
csn_op0_n100_rl_s1_r100k_0 sn_op0_n100_rl_s1_r100k_0 0 {C_SN}
XMWR_op0_n100_rl_s1_r100k_1 sn_op0_n100_rl_s1_r100k_1 wwl_des wbl_op0_n100_rl_s1_r100k 0 sky130_fd_pr__nfet_01v8 L=0.15 W=0.42 nf=1 ad=0.1218 as=0.1218 pd=1.42 ps=1.42 nrd=0.69047619047619  nrs=0.69047619047619 sa=0 sb=0 sd=0 mult=1 m=1
XMRD_op0_n100_rl_s1_r100k_1 rbl_op0_n100_rl_s1_r100k sn_op0_n100_rl_s1_r100k_1 rwl_des 0 sky130_fd_pr__nfet_01v8 L=0.15 W=0.42 nf=1 ad=0.1218 as=0.1218 pd=1.42 ps=1.42 nrd=0.69047619047619  nrs=0.69047619047619 sa=0 sb=0 sd=0 mult=1 m=1
csn_op0_n100_rl_s1_r100k_1 sn_op0_n100_rl_s1_r100k_1 0 {C_SN}
XMWR_op0_n100_rl_s1_r100k_2 sn_op0_n100_rl_s1_r100k_2 wwl_des wbl_op0_n100_rl_s1_r100k 0 sky130_fd_pr__nfet_01v8 L=0.15 W=0.42 nf=1 ad=0.1218 as=0.1218 pd=1.42 ps=1.42 nrd=0.69047619047619  nrs=0.69047619047619 sa=0 sb=0 sd=0 mult=1 m=1
XMRD_op0_n100_rl_s1_r100k_2 rbl_op0_n100_rl_s1_r100k sn_op0_n100_rl_s1_r100k_2 rwl_des 0 sky130_fd_pr__nfet_01v8 L=0.15 W=0.42 nf=1 ad=0.1218 as=0.1218 pd=1.42 ps=1.42 nrd=0.69047619047619  nrs=0.69047619047619 sa=0 sb=0 sd=0 mult=1 m=1
csn_op0_n100_rl_s1_r100k_2 sn_op0_n100_rl_s1_r100k_2 0 {C_SN}
XMWR_op0_n100_rl_s1_r100k_3 sn_op0_n100_rl_s1_r100k_3 wwl_des wbl_op0_n100_rl_s1_r100k 0 sky130_fd_pr__nfet_01v8 L=0.15 W=0.42 nf=1 ad=0.1218 as=0.1218 pd=1.42 ps=1.42 nrd=0.69047619047619  nrs=0.69047619047619 sa=0 sb=0 sd=0 mult=1 m=1
XMRD_op0_n100_rl_s1_r100k_3 rbl_op0_n100_rl_s1_r100k sn_op0_n100_rl_s1_r100k_3 rwl_des 0 sky130_fd_pr__nfet_01v8 L=0.15 W=0.42 nf=1 ad=0.1218 as=0.1218 pd=1.42 ps=1.42 nrd=0.69047619047619  nrs=0.69047619047619 sa=0 sb=0 sd=0 mult=1 m=1
csn_op0_n100_rl_s1_r100k_3 sn_op0_n100_rl_s1_r100k_3 0 {C_SN}
XMN1_op0_n100_rl_s1_r100k rbl_op0_n100_rl_s1_r100k ref_op0_n100_rl_s1_r100k vn_op0_n100_rl_s1_r100k 0 sky130_fd_pr__nfet_01v8 L=0.15 W=1 nf=1 ad=0.29 as=0.29 pd=2.58 ps=2.58 mult=1 m=1
XMN2_op0_n100_rl_s1_r100k ref_op0_n100_rl_s1_r100k rbl_op0_n100_rl_s1_r100k vn_op0_n100_rl_s1_r100k 0 sky130_fd_pr__nfet_01v8 L=0.15 W=1 nf=1 ad=0.29 as=0.29 pd=2.58 ps=2.58 mult=1 m=1
XMP1_op0_n100_rl_s1_r100k rbl_op0_n100_rl_s1_r100k ref_op0_n100_rl_s1_r100k vp_op0_n100_rl_s1_r100k vdd sky130_fd_pr__pfet_01v8 L=0.15 W=2 nf=1 ad=0.58 as=0.58 pd=4.58 ps=4.58 mult=1 m=1
XMP2_op0_n100_rl_s1_r100k ref_op0_n100_rl_s1_r100k rbl_op0_n100_rl_s1_r100k vp_op0_n100_rl_s1_r100k vdd sky130_fd_pr__pfet_01v8 L=0.15 W=2 nf=1 ad=0.58 as=0.58 pd=4.58 ps=4.58 mult=1 m=1
XMNF_op0_n100_rl_s1_r100k vn_op0_n100_rl_s1_r100k en_op0_n100_rl_s1_r100k 0 0 sky130_fd_pr__nfet_01v8 L=0.15 W=2 nf=1 ad=0.58 as=0.58 pd=4.58 ps=4.58 mult=1 m=1
XMPH_op0_n100_rl_s1_r100k vp_op0_n100_rl_s1_r100k enb_op0_n100_rl_s1_r100k vdd vdd sky130_fd_pr__pfet_01v8 L=0.15 W=4 nf=1 ad=1.16 as=1.16 pd=8.58 ps=8.58 mult=1 m=1
bd_op0_n100_rl_s1_r100k d_op0_n100_rl_s1_r100k 0 v=v(rbl_op0_n100_rl_s1_r100k)-v(ref_op0_n100_rl_s1_r100k)

* ---- instance 212: op0_0000_rl_s1_r100k (variant rl_s1_r100k; probe dec 11.9 ns, release 34 ns, meas 36 ns) ----
vctl_op0_0000_rl_s1_r100k ctl_op0_0000_rl_s1_r100k 0 pwl(0.0000e+00 {VDD} 2.0000e-09 {VDD} 2.1000e-09 0)
* RWL driver model (EXPERIMENTAL): slew 1 ns, series R 100000 ohm; cell pin = rwls_op0_0000_rl_s1_r100k
vrs_op0_0000_rl_s1_r100k rwlsrc_op0_0000_rl_s1_r100k 0 pwl(0.0000e+00 {VDD} 2.0000e-09 {VDD} 3.0000e-09 0 3.4000e-08 0 3.5000e-08 {VDD})
rdrv_op0_0000_rl_s1_r100k rwlsrc_op0_0000_rl_s1_r100k rwls_op0_0000_rl_s1_r100k 100000
ven_op0_0000_rl_s1_r100k en_op0_0000_rl_s1_r100k 0 pwl(0.0000e+00 0 1.1000e-08 0 1.1100e-08 {VDD} 3.4000e-08 {VDD} 3.4100e-08 0)
venb_op0_0000_rl_s1_r100k enb_op0_0000_rl_s1_r100k 0 pwl(0.0000e+00 {VDD} 1.1000e-08 {VDD} 1.1100e-08 0 3.4000e-08 0 3.4100e-08 {VDD})
vww_op0_0000_rl_s1_r100k wwl_op0_0000_rl_s1_r100k 0 pwl(0.0000e+00 0 1.2000e-08 0 1.2100e-08 {VDD} 3.2000e-08 {VDD} 3.2100e-08 0)
vwc_op0_0000_rl_s1_r100k wbc_op0_0000_rl_s1_r100k 0 pwl(0.0000e+00 0 1.2000e-08 0 1.2100e-08 {VDD} 3.4000e-08 {VDD} 3.4100e-08 0)
swb_op0_0000_rl_s1_r100k ref_op0_0000_rl_s1_r100k wbl_op0_0000_rl_s1_r100k wbc_op0_0000_rl_s1_r100k 0 swwbl
cwbl_op0_0000_rl_s1_r100k wbl_op0_0000_rl_s1_r100k 0 {C_WBL}
spa_op0_0000_rl_s1_r100k prea rbl_op0_0000_rl_s1_r100k ctl_op0_0000_rl_s1_r100k 0 swpre
spr_op0_0000_rl_s1_r100k pref ref_op0_0000_rl_s1_r100k ctl_op0_0000_rl_s1_r100k 0 swpre
crbl_op0_0000_rl_s1_r100k rbl_op0_0000_rl_s1_r100k 0 {C_RBL}
cref_op0_0000_rl_s1_r100k ref_op0_0000_rl_s1_r100k 0 {C_RBL}   $ ASSUMPTION: ideal matched dummy load
XMWR_op0_0000_rl_s1_r100k_0 sn_op0_0000_rl_s1_r100k_0 wwl_op0_0000_rl_s1_r100k wbl_op0_0000_rl_s1_r100k 0 sky130_fd_pr__nfet_01v8 L=0.15 W=0.42 nf=1 ad=0.1218 as=0.1218 pd=1.42 ps=1.42 nrd=0.69047619047619  nrs=0.69047619047619 sa=0 sb=0 sd=0 mult=1 m=1
XMRD_op0_0000_rl_s1_r100k_0 rbl_op0_0000_rl_s1_r100k sn_op0_0000_rl_s1_r100k_0 rwls_op0_0000_rl_s1_r100k 0 sky130_fd_pr__nfet_01v8 L=0.15 W=0.42 nf=1 ad=0.1218 as=0.1218 pd=1.42 ps=1.42 nrd=0.69047619047619  nrs=0.69047619047619 sa=0 sb=0 sd=0 mult=1 m=1
csn_op0_0000_rl_s1_r100k_0 sn_op0_0000_rl_s1_r100k_0 0 {C_SN}
XMWR_op0_0000_rl_s1_r100k_1 sn_op0_0000_rl_s1_r100k_1 wwl_des wbl_op0_0000_rl_s1_r100k 0 sky130_fd_pr__nfet_01v8 L=0.15 W=0.42 nf=1 ad=0.1218 as=0.1218 pd=1.42 ps=1.42 nrd=0.69047619047619  nrs=0.69047619047619 sa=0 sb=0 sd=0 mult=1 m=1
XMRD_op0_0000_rl_s1_r100k_1 rbl_op0_0000_rl_s1_r100k sn_op0_0000_rl_s1_r100k_1 rwl_des 0 sky130_fd_pr__nfet_01v8 L=0.15 W=0.42 nf=1 ad=0.1218 as=0.1218 pd=1.42 ps=1.42 nrd=0.69047619047619  nrs=0.69047619047619 sa=0 sb=0 sd=0 mult=1 m=1
csn_op0_0000_rl_s1_r100k_1 sn_op0_0000_rl_s1_r100k_1 0 {C_SN}
XMWR_op0_0000_rl_s1_r100k_2 sn_op0_0000_rl_s1_r100k_2 wwl_des wbl_op0_0000_rl_s1_r100k 0 sky130_fd_pr__nfet_01v8 L=0.15 W=0.42 nf=1 ad=0.1218 as=0.1218 pd=1.42 ps=1.42 nrd=0.69047619047619  nrs=0.69047619047619 sa=0 sb=0 sd=0 mult=1 m=1
XMRD_op0_0000_rl_s1_r100k_2 rbl_op0_0000_rl_s1_r100k sn_op0_0000_rl_s1_r100k_2 rwl_des 0 sky130_fd_pr__nfet_01v8 L=0.15 W=0.42 nf=1 ad=0.1218 as=0.1218 pd=1.42 ps=1.42 nrd=0.69047619047619  nrs=0.69047619047619 sa=0 sb=0 sd=0 mult=1 m=1
csn_op0_0000_rl_s1_r100k_2 sn_op0_0000_rl_s1_r100k_2 0 {C_SN}
XMWR_op0_0000_rl_s1_r100k_3 sn_op0_0000_rl_s1_r100k_3 wwl_des wbl_op0_0000_rl_s1_r100k 0 sky130_fd_pr__nfet_01v8 L=0.15 W=0.42 nf=1 ad=0.1218 as=0.1218 pd=1.42 ps=1.42 nrd=0.69047619047619  nrs=0.69047619047619 sa=0 sb=0 sd=0 mult=1 m=1
XMRD_op0_0000_rl_s1_r100k_3 rbl_op0_0000_rl_s1_r100k sn_op0_0000_rl_s1_r100k_3 rwl_des 0 sky130_fd_pr__nfet_01v8 L=0.15 W=0.42 nf=1 ad=0.1218 as=0.1218 pd=1.42 ps=1.42 nrd=0.69047619047619  nrs=0.69047619047619 sa=0 sb=0 sd=0 mult=1 m=1
csn_op0_0000_rl_s1_r100k_3 sn_op0_0000_rl_s1_r100k_3 0 {C_SN}
XMN1_op0_0000_rl_s1_r100k rbl_op0_0000_rl_s1_r100k ref_op0_0000_rl_s1_r100k vn_op0_0000_rl_s1_r100k 0 sky130_fd_pr__nfet_01v8 L=0.15 W=1 nf=1 ad=0.29 as=0.29 pd=2.58 ps=2.58 mult=1 m=1
XMN2_op0_0000_rl_s1_r100k ref_op0_0000_rl_s1_r100k rbl_op0_0000_rl_s1_r100k vn_op0_0000_rl_s1_r100k 0 sky130_fd_pr__nfet_01v8 L=0.15 W=1 nf=1 ad=0.29 as=0.29 pd=2.58 ps=2.58 mult=1 m=1
XMP1_op0_0000_rl_s1_r100k rbl_op0_0000_rl_s1_r100k ref_op0_0000_rl_s1_r100k vp_op0_0000_rl_s1_r100k vdd sky130_fd_pr__pfet_01v8 L=0.15 W=2 nf=1 ad=0.58 as=0.58 pd=4.58 ps=4.58 mult=1 m=1
XMP2_op0_0000_rl_s1_r100k ref_op0_0000_rl_s1_r100k rbl_op0_0000_rl_s1_r100k vp_op0_0000_rl_s1_r100k vdd sky130_fd_pr__pfet_01v8 L=0.15 W=2 nf=1 ad=0.58 as=0.58 pd=4.58 ps=4.58 mult=1 m=1
XMNF_op0_0000_rl_s1_r100k vn_op0_0000_rl_s1_r100k en_op0_0000_rl_s1_r100k 0 0 sky130_fd_pr__nfet_01v8 L=0.15 W=2 nf=1 ad=0.58 as=0.58 pd=4.58 ps=4.58 mult=1 m=1
XMPH_op0_0000_rl_s1_r100k vp_op0_0000_rl_s1_r100k enb_op0_0000_rl_s1_r100k vdd vdd sky130_fd_pr__pfet_01v8 L=0.15 W=4 nf=1 ad=1.16 as=1.16 pd=8.58 ps=8.58 mult=1 m=1
bd_op0_0000_rl_s1_r100k d_op0_0000_rl_s1_r100k 0 v=v(rbl_op0_0000_rl_s1_r100k)-v(ref_op0_0000_rl_s1_r100k)

* ---- instance 213: op1_0900_rl_s2_r10k (variant rl_s2_r10k; probe dec 11.9 ns, release 34 ns, meas 36 ns) ----
vctl_op1_0900_rl_s2_r10k ctl_op1_0900_rl_s2_r10k 0 pwl(0.0000e+00 {VDD} 2.0000e-09 {VDD} 2.1000e-09 0)
* RWL driver model (EXPERIMENTAL): slew 2 ns, series R 10000 ohm; cell pin = rwls_op1_0900_rl_s2_r10k
vrs_op1_0900_rl_s2_r10k rwlsrc_op1_0900_rl_s2_r10k 0 pwl(0.0000e+00 {VDD} 2.0000e-09 {VDD} 4.0000e-09 0 3.4000e-08 0 3.6000e-08 {VDD})
rdrv_op1_0900_rl_s2_r10k rwlsrc_op1_0900_rl_s2_r10k rwls_op1_0900_rl_s2_r10k 10000
ven_op1_0900_rl_s2_r10k en_op1_0900_rl_s2_r10k 0 pwl(0.0000e+00 0 1.1000e-08 0 1.1100e-08 {VDD} 3.4000e-08 {VDD} 3.4100e-08 0)
venb_op1_0900_rl_s2_r10k enb_op1_0900_rl_s2_r10k 0 pwl(0.0000e+00 {VDD} 1.1000e-08 {VDD} 1.1100e-08 0 3.4000e-08 0 3.4100e-08 {VDD})
vww_op1_0900_rl_s2_r10k wwl_op1_0900_rl_s2_r10k 0 pwl(0.0000e+00 0 1.2000e-08 0 1.2100e-08 {VDD} 3.2000e-08 {VDD} 3.2100e-08 0)
vwc_op1_0900_rl_s2_r10k wbc_op1_0900_rl_s2_r10k 0 pwl(0.0000e+00 0 1.2000e-08 0 1.2100e-08 {VDD} 3.4000e-08 {VDD} 3.4100e-08 0)
swb_op1_0900_rl_s2_r10k ref_op1_0900_rl_s2_r10k wbl_op1_0900_rl_s2_r10k wbc_op1_0900_rl_s2_r10k 0 swwbl
cwbl_op1_0900_rl_s2_r10k wbl_op1_0900_rl_s2_r10k 0 {C_WBL}
spa_op1_0900_rl_s2_r10k prea rbl_op1_0900_rl_s2_r10k ctl_op1_0900_rl_s2_r10k 0 swpre
spr_op1_0900_rl_s2_r10k pref ref_op1_0900_rl_s2_r10k ctl_op1_0900_rl_s2_r10k 0 swpre
crbl_op1_0900_rl_s2_r10k rbl_op1_0900_rl_s2_r10k 0 {C_RBL}
cref_op1_0900_rl_s2_r10k ref_op1_0900_rl_s2_r10k 0 {C_RBL}   $ ASSUMPTION: ideal matched dummy load
XMWR_op1_0900_rl_s2_r10k_0 sn_op1_0900_rl_s2_r10k_0 wwl_op1_0900_rl_s2_r10k wbl_op1_0900_rl_s2_r10k 0 sky130_fd_pr__nfet_01v8 L=0.15 W=0.42 nf=1 ad=0.1218 as=0.1218 pd=1.42 ps=1.42 nrd=0.69047619047619  nrs=0.69047619047619 sa=0 sb=0 sd=0 mult=1 m=1
XMRD_op1_0900_rl_s2_r10k_0 rbl_op1_0900_rl_s2_r10k sn_op1_0900_rl_s2_r10k_0 rwls_op1_0900_rl_s2_r10k 0 sky130_fd_pr__nfet_01v8 L=0.15 W=0.42 nf=1 ad=0.1218 as=0.1218 pd=1.42 ps=1.42 nrd=0.69047619047619  nrs=0.69047619047619 sa=0 sb=0 sd=0 mult=1 m=1
csn_op1_0900_rl_s2_r10k_0 sn_op1_0900_rl_s2_r10k_0 0 {C_SN}
XMWR_op1_0900_rl_s2_r10k_1 sn_op1_0900_rl_s2_r10k_1 wwl_des wbl_op1_0900_rl_s2_r10k 0 sky130_fd_pr__nfet_01v8 L=0.15 W=0.42 nf=1 ad=0.1218 as=0.1218 pd=1.42 ps=1.42 nrd=0.69047619047619  nrs=0.69047619047619 sa=0 sb=0 sd=0 mult=1 m=1
XMRD_op1_0900_rl_s2_r10k_1 rbl_op1_0900_rl_s2_r10k sn_op1_0900_rl_s2_r10k_1 rwl_des 0 sky130_fd_pr__nfet_01v8 L=0.15 W=0.42 nf=1 ad=0.1218 as=0.1218 pd=1.42 ps=1.42 nrd=0.69047619047619  nrs=0.69047619047619 sa=0 sb=0 sd=0 mult=1 m=1
csn_op1_0900_rl_s2_r10k_1 sn_op1_0900_rl_s2_r10k_1 0 {C_SN}
XMWR_op1_0900_rl_s2_r10k_2 sn_op1_0900_rl_s2_r10k_2 wwl_des wbl_op1_0900_rl_s2_r10k 0 sky130_fd_pr__nfet_01v8 L=0.15 W=0.42 nf=1 ad=0.1218 as=0.1218 pd=1.42 ps=1.42 nrd=0.69047619047619  nrs=0.69047619047619 sa=0 sb=0 sd=0 mult=1 m=1
XMRD_op1_0900_rl_s2_r10k_2 rbl_op1_0900_rl_s2_r10k sn_op1_0900_rl_s2_r10k_2 rwl_des 0 sky130_fd_pr__nfet_01v8 L=0.15 W=0.42 nf=1 ad=0.1218 as=0.1218 pd=1.42 ps=1.42 nrd=0.69047619047619  nrs=0.69047619047619 sa=0 sb=0 sd=0 mult=1 m=1
csn_op1_0900_rl_s2_r10k_2 sn_op1_0900_rl_s2_r10k_2 0 {C_SN}
XMWR_op1_0900_rl_s2_r10k_3 sn_op1_0900_rl_s2_r10k_3 wwl_des wbl_op1_0900_rl_s2_r10k 0 sky130_fd_pr__nfet_01v8 L=0.15 W=0.42 nf=1 ad=0.1218 as=0.1218 pd=1.42 ps=1.42 nrd=0.69047619047619  nrs=0.69047619047619 sa=0 sb=0 sd=0 mult=1 m=1
XMRD_op1_0900_rl_s2_r10k_3 rbl_op1_0900_rl_s2_r10k sn_op1_0900_rl_s2_r10k_3 rwl_des 0 sky130_fd_pr__nfet_01v8 L=0.15 W=0.42 nf=1 ad=0.1218 as=0.1218 pd=1.42 ps=1.42 nrd=0.69047619047619  nrs=0.69047619047619 sa=0 sb=0 sd=0 mult=1 m=1
csn_op1_0900_rl_s2_r10k_3 sn_op1_0900_rl_s2_r10k_3 0 {C_SN}
XMN1_op1_0900_rl_s2_r10k rbl_op1_0900_rl_s2_r10k ref_op1_0900_rl_s2_r10k vn_op1_0900_rl_s2_r10k 0 sky130_fd_pr__nfet_01v8 L=0.15 W=1 nf=1 ad=0.29 as=0.29 pd=2.58 ps=2.58 mult=1 m=1
XMN2_op1_0900_rl_s2_r10k ref_op1_0900_rl_s2_r10k rbl_op1_0900_rl_s2_r10k vn_op1_0900_rl_s2_r10k 0 sky130_fd_pr__nfet_01v8 L=0.15 W=1 nf=1 ad=0.29 as=0.29 pd=2.58 ps=2.58 mult=1 m=1
XMP1_op1_0900_rl_s2_r10k rbl_op1_0900_rl_s2_r10k ref_op1_0900_rl_s2_r10k vp_op1_0900_rl_s2_r10k vdd sky130_fd_pr__pfet_01v8 L=0.15 W=2 nf=1 ad=0.58 as=0.58 pd=4.58 ps=4.58 mult=1 m=1
XMP2_op1_0900_rl_s2_r10k ref_op1_0900_rl_s2_r10k rbl_op1_0900_rl_s2_r10k vp_op1_0900_rl_s2_r10k vdd sky130_fd_pr__pfet_01v8 L=0.15 W=2 nf=1 ad=0.58 as=0.58 pd=4.58 ps=4.58 mult=1 m=1
XMNF_op1_0900_rl_s2_r10k vn_op1_0900_rl_s2_r10k en_op1_0900_rl_s2_r10k 0 0 sky130_fd_pr__nfet_01v8 L=0.15 W=2 nf=1 ad=0.58 as=0.58 pd=4.58 ps=4.58 mult=1 m=1
XMPH_op1_0900_rl_s2_r10k vp_op1_0900_rl_s2_r10k enb_op1_0900_rl_s2_r10k vdd vdd sky130_fd_pr__pfet_01v8 L=0.15 W=4 nf=1 ad=1.16 as=1.16 pd=8.58 ps=8.58 mult=1 m=1
bd_op1_0900_rl_s2_r10k d_op1_0900_rl_s2_r10k 0 v=v(rbl_op1_0900_rl_s2_r10k)-v(ref_op1_0900_rl_s2_r10k)

* ---- instance 214: op1_1000_rl_s2_r10k (variant rl_s2_r10k; probe dec 11.9 ns, release 34 ns, meas 36 ns) ----
vctl_op1_1000_rl_s2_r10k ctl_op1_1000_rl_s2_r10k 0 pwl(0.0000e+00 {VDD} 2.0000e-09 {VDD} 2.1000e-09 0)
* RWL driver model (EXPERIMENTAL): slew 2 ns, series R 10000 ohm; cell pin = rwls_op1_1000_rl_s2_r10k
vrs_op1_1000_rl_s2_r10k rwlsrc_op1_1000_rl_s2_r10k 0 pwl(0.0000e+00 {VDD} 2.0000e-09 {VDD} 4.0000e-09 0 3.4000e-08 0 3.6000e-08 {VDD})
rdrv_op1_1000_rl_s2_r10k rwlsrc_op1_1000_rl_s2_r10k rwls_op1_1000_rl_s2_r10k 10000
ven_op1_1000_rl_s2_r10k en_op1_1000_rl_s2_r10k 0 pwl(0.0000e+00 0 1.1000e-08 0 1.1100e-08 {VDD} 3.4000e-08 {VDD} 3.4100e-08 0)
venb_op1_1000_rl_s2_r10k enb_op1_1000_rl_s2_r10k 0 pwl(0.0000e+00 {VDD} 1.1000e-08 {VDD} 1.1100e-08 0 3.4000e-08 0 3.4100e-08 {VDD})
vww_op1_1000_rl_s2_r10k wwl_op1_1000_rl_s2_r10k 0 pwl(0.0000e+00 0 1.2000e-08 0 1.2100e-08 {VDD} 3.2000e-08 {VDD} 3.2100e-08 0)
vwc_op1_1000_rl_s2_r10k wbc_op1_1000_rl_s2_r10k 0 pwl(0.0000e+00 0 1.2000e-08 0 1.2100e-08 {VDD} 3.4000e-08 {VDD} 3.4100e-08 0)
swb_op1_1000_rl_s2_r10k ref_op1_1000_rl_s2_r10k wbl_op1_1000_rl_s2_r10k wbc_op1_1000_rl_s2_r10k 0 swwbl
cwbl_op1_1000_rl_s2_r10k wbl_op1_1000_rl_s2_r10k 0 {C_WBL}
spa_op1_1000_rl_s2_r10k prea rbl_op1_1000_rl_s2_r10k ctl_op1_1000_rl_s2_r10k 0 swpre
spr_op1_1000_rl_s2_r10k pref ref_op1_1000_rl_s2_r10k ctl_op1_1000_rl_s2_r10k 0 swpre
crbl_op1_1000_rl_s2_r10k rbl_op1_1000_rl_s2_r10k 0 {C_RBL}
cref_op1_1000_rl_s2_r10k ref_op1_1000_rl_s2_r10k 0 {C_RBL}   $ ASSUMPTION: ideal matched dummy load
XMWR_op1_1000_rl_s2_r10k_0 sn_op1_1000_rl_s2_r10k_0 wwl_op1_1000_rl_s2_r10k wbl_op1_1000_rl_s2_r10k 0 sky130_fd_pr__nfet_01v8 L=0.15 W=0.42 nf=1 ad=0.1218 as=0.1218 pd=1.42 ps=1.42 nrd=0.69047619047619  nrs=0.69047619047619 sa=0 sb=0 sd=0 mult=1 m=1
XMRD_op1_1000_rl_s2_r10k_0 rbl_op1_1000_rl_s2_r10k sn_op1_1000_rl_s2_r10k_0 rwls_op1_1000_rl_s2_r10k 0 sky130_fd_pr__nfet_01v8 L=0.15 W=0.42 nf=1 ad=0.1218 as=0.1218 pd=1.42 ps=1.42 nrd=0.69047619047619  nrs=0.69047619047619 sa=0 sb=0 sd=0 mult=1 m=1
csn_op1_1000_rl_s2_r10k_0 sn_op1_1000_rl_s2_r10k_0 0 {C_SN}
XMWR_op1_1000_rl_s2_r10k_1 sn_op1_1000_rl_s2_r10k_1 wwl_des wbl_op1_1000_rl_s2_r10k 0 sky130_fd_pr__nfet_01v8 L=0.15 W=0.42 nf=1 ad=0.1218 as=0.1218 pd=1.42 ps=1.42 nrd=0.69047619047619  nrs=0.69047619047619 sa=0 sb=0 sd=0 mult=1 m=1
XMRD_op1_1000_rl_s2_r10k_1 rbl_op1_1000_rl_s2_r10k sn_op1_1000_rl_s2_r10k_1 rwl_des 0 sky130_fd_pr__nfet_01v8 L=0.15 W=0.42 nf=1 ad=0.1218 as=0.1218 pd=1.42 ps=1.42 nrd=0.69047619047619  nrs=0.69047619047619 sa=0 sb=0 sd=0 mult=1 m=1
csn_op1_1000_rl_s2_r10k_1 sn_op1_1000_rl_s2_r10k_1 0 {C_SN}
XMWR_op1_1000_rl_s2_r10k_2 sn_op1_1000_rl_s2_r10k_2 wwl_des wbl_op1_1000_rl_s2_r10k 0 sky130_fd_pr__nfet_01v8 L=0.15 W=0.42 nf=1 ad=0.1218 as=0.1218 pd=1.42 ps=1.42 nrd=0.69047619047619  nrs=0.69047619047619 sa=0 sb=0 sd=0 mult=1 m=1
XMRD_op1_1000_rl_s2_r10k_2 rbl_op1_1000_rl_s2_r10k sn_op1_1000_rl_s2_r10k_2 rwl_des 0 sky130_fd_pr__nfet_01v8 L=0.15 W=0.42 nf=1 ad=0.1218 as=0.1218 pd=1.42 ps=1.42 nrd=0.69047619047619  nrs=0.69047619047619 sa=0 sb=0 sd=0 mult=1 m=1
csn_op1_1000_rl_s2_r10k_2 sn_op1_1000_rl_s2_r10k_2 0 {C_SN}
XMWR_op1_1000_rl_s2_r10k_3 sn_op1_1000_rl_s2_r10k_3 wwl_des wbl_op1_1000_rl_s2_r10k 0 sky130_fd_pr__nfet_01v8 L=0.15 W=0.42 nf=1 ad=0.1218 as=0.1218 pd=1.42 ps=1.42 nrd=0.69047619047619  nrs=0.69047619047619 sa=0 sb=0 sd=0 mult=1 m=1
XMRD_op1_1000_rl_s2_r10k_3 rbl_op1_1000_rl_s2_r10k sn_op1_1000_rl_s2_r10k_3 rwl_des 0 sky130_fd_pr__nfet_01v8 L=0.15 W=0.42 nf=1 ad=0.1218 as=0.1218 pd=1.42 ps=1.42 nrd=0.69047619047619  nrs=0.69047619047619 sa=0 sb=0 sd=0 mult=1 m=1
csn_op1_1000_rl_s2_r10k_3 sn_op1_1000_rl_s2_r10k_3 0 {C_SN}
XMN1_op1_1000_rl_s2_r10k rbl_op1_1000_rl_s2_r10k ref_op1_1000_rl_s2_r10k vn_op1_1000_rl_s2_r10k 0 sky130_fd_pr__nfet_01v8 L=0.15 W=1 nf=1 ad=0.29 as=0.29 pd=2.58 ps=2.58 mult=1 m=1
XMN2_op1_1000_rl_s2_r10k ref_op1_1000_rl_s2_r10k rbl_op1_1000_rl_s2_r10k vn_op1_1000_rl_s2_r10k 0 sky130_fd_pr__nfet_01v8 L=0.15 W=1 nf=1 ad=0.29 as=0.29 pd=2.58 ps=2.58 mult=1 m=1
XMP1_op1_1000_rl_s2_r10k rbl_op1_1000_rl_s2_r10k ref_op1_1000_rl_s2_r10k vp_op1_1000_rl_s2_r10k vdd sky130_fd_pr__pfet_01v8 L=0.15 W=2 nf=1 ad=0.58 as=0.58 pd=4.58 ps=4.58 mult=1 m=1
XMP2_op1_1000_rl_s2_r10k ref_op1_1000_rl_s2_r10k rbl_op1_1000_rl_s2_r10k vp_op1_1000_rl_s2_r10k vdd sky130_fd_pr__pfet_01v8 L=0.15 W=2 nf=1 ad=0.58 as=0.58 pd=4.58 ps=4.58 mult=1 m=1
XMNF_op1_1000_rl_s2_r10k vn_op1_1000_rl_s2_r10k en_op1_1000_rl_s2_r10k 0 0 sky130_fd_pr__nfet_01v8 L=0.15 W=2 nf=1 ad=0.58 as=0.58 pd=4.58 ps=4.58 mult=1 m=1
XMPH_op1_1000_rl_s2_r10k vp_op1_1000_rl_s2_r10k enb_op1_1000_rl_s2_r10k vdd vdd sky130_fd_pr__pfet_01v8 L=0.15 W=4 nf=1 ad=1.16 as=1.16 pd=8.58 ps=8.58 mult=1 m=1
bd_op1_1000_rl_s2_r10k d_op1_1000_rl_s2_r10k 0 v=v(rbl_op1_1000_rl_s2_r10k)-v(ref_op1_1000_rl_s2_r10k)

* ---- instance 215: op0_n100_rl_s2_r10k (variant rl_s2_r10k; probe dec 11.9 ns, release 34 ns, meas 36 ns) ----
vctl_op0_n100_rl_s2_r10k ctl_op0_n100_rl_s2_r10k 0 pwl(0.0000e+00 {VDD} 2.0000e-09 {VDD} 2.1000e-09 0)
* RWL driver model (EXPERIMENTAL): slew 2 ns, series R 10000 ohm; cell pin = rwls_op0_n100_rl_s2_r10k
vrs_op0_n100_rl_s2_r10k rwlsrc_op0_n100_rl_s2_r10k 0 pwl(0.0000e+00 {VDD} 2.0000e-09 {VDD} 4.0000e-09 0 3.4000e-08 0 3.6000e-08 {VDD})
rdrv_op0_n100_rl_s2_r10k rwlsrc_op0_n100_rl_s2_r10k rwls_op0_n100_rl_s2_r10k 10000
ven_op0_n100_rl_s2_r10k en_op0_n100_rl_s2_r10k 0 pwl(0.0000e+00 0 1.1000e-08 0 1.1100e-08 {VDD} 3.4000e-08 {VDD} 3.4100e-08 0)
venb_op0_n100_rl_s2_r10k enb_op0_n100_rl_s2_r10k 0 pwl(0.0000e+00 {VDD} 1.1000e-08 {VDD} 1.1100e-08 0 3.4000e-08 0 3.4100e-08 {VDD})
vww_op0_n100_rl_s2_r10k wwl_op0_n100_rl_s2_r10k 0 pwl(0.0000e+00 0 1.2000e-08 0 1.2100e-08 {VDD} 3.2000e-08 {VDD} 3.2100e-08 0)
vwc_op0_n100_rl_s2_r10k wbc_op0_n100_rl_s2_r10k 0 pwl(0.0000e+00 0 1.2000e-08 0 1.2100e-08 {VDD} 3.4000e-08 {VDD} 3.4100e-08 0)
swb_op0_n100_rl_s2_r10k ref_op0_n100_rl_s2_r10k wbl_op0_n100_rl_s2_r10k wbc_op0_n100_rl_s2_r10k 0 swwbl
cwbl_op0_n100_rl_s2_r10k wbl_op0_n100_rl_s2_r10k 0 {C_WBL}
spa_op0_n100_rl_s2_r10k prea rbl_op0_n100_rl_s2_r10k ctl_op0_n100_rl_s2_r10k 0 swpre
spr_op0_n100_rl_s2_r10k pref ref_op0_n100_rl_s2_r10k ctl_op0_n100_rl_s2_r10k 0 swpre
crbl_op0_n100_rl_s2_r10k rbl_op0_n100_rl_s2_r10k 0 {C_RBL}
cref_op0_n100_rl_s2_r10k ref_op0_n100_rl_s2_r10k 0 {C_RBL}   $ ASSUMPTION: ideal matched dummy load
XMWR_op0_n100_rl_s2_r10k_0 sn_op0_n100_rl_s2_r10k_0 wwl_op0_n100_rl_s2_r10k wbl_op0_n100_rl_s2_r10k 0 sky130_fd_pr__nfet_01v8 L=0.15 W=0.42 nf=1 ad=0.1218 as=0.1218 pd=1.42 ps=1.42 nrd=0.69047619047619  nrs=0.69047619047619 sa=0 sb=0 sd=0 mult=1 m=1
XMRD_op0_n100_rl_s2_r10k_0 rbl_op0_n100_rl_s2_r10k sn_op0_n100_rl_s2_r10k_0 rwls_op0_n100_rl_s2_r10k 0 sky130_fd_pr__nfet_01v8 L=0.15 W=0.42 nf=1 ad=0.1218 as=0.1218 pd=1.42 ps=1.42 nrd=0.69047619047619  nrs=0.69047619047619 sa=0 sb=0 sd=0 mult=1 m=1
csn_op0_n100_rl_s2_r10k_0 sn_op0_n100_rl_s2_r10k_0 0 {C_SN}
XMWR_op0_n100_rl_s2_r10k_1 sn_op0_n100_rl_s2_r10k_1 wwl_des wbl_op0_n100_rl_s2_r10k 0 sky130_fd_pr__nfet_01v8 L=0.15 W=0.42 nf=1 ad=0.1218 as=0.1218 pd=1.42 ps=1.42 nrd=0.69047619047619  nrs=0.69047619047619 sa=0 sb=0 sd=0 mult=1 m=1
XMRD_op0_n100_rl_s2_r10k_1 rbl_op0_n100_rl_s2_r10k sn_op0_n100_rl_s2_r10k_1 rwl_des 0 sky130_fd_pr__nfet_01v8 L=0.15 W=0.42 nf=1 ad=0.1218 as=0.1218 pd=1.42 ps=1.42 nrd=0.69047619047619  nrs=0.69047619047619 sa=0 sb=0 sd=0 mult=1 m=1
csn_op0_n100_rl_s2_r10k_1 sn_op0_n100_rl_s2_r10k_1 0 {C_SN}
XMWR_op0_n100_rl_s2_r10k_2 sn_op0_n100_rl_s2_r10k_2 wwl_des wbl_op0_n100_rl_s2_r10k 0 sky130_fd_pr__nfet_01v8 L=0.15 W=0.42 nf=1 ad=0.1218 as=0.1218 pd=1.42 ps=1.42 nrd=0.69047619047619  nrs=0.69047619047619 sa=0 sb=0 sd=0 mult=1 m=1
XMRD_op0_n100_rl_s2_r10k_2 rbl_op0_n100_rl_s2_r10k sn_op0_n100_rl_s2_r10k_2 rwl_des 0 sky130_fd_pr__nfet_01v8 L=0.15 W=0.42 nf=1 ad=0.1218 as=0.1218 pd=1.42 ps=1.42 nrd=0.69047619047619  nrs=0.69047619047619 sa=0 sb=0 sd=0 mult=1 m=1
csn_op0_n100_rl_s2_r10k_2 sn_op0_n100_rl_s2_r10k_2 0 {C_SN}
XMWR_op0_n100_rl_s2_r10k_3 sn_op0_n100_rl_s2_r10k_3 wwl_des wbl_op0_n100_rl_s2_r10k 0 sky130_fd_pr__nfet_01v8 L=0.15 W=0.42 nf=1 ad=0.1218 as=0.1218 pd=1.42 ps=1.42 nrd=0.69047619047619  nrs=0.69047619047619 sa=0 sb=0 sd=0 mult=1 m=1
XMRD_op0_n100_rl_s2_r10k_3 rbl_op0_n100_rl_s2_r10k sn_op0_n100_rl_s2_r10k_3 rwl_des 0 sky130_fd_pr__nfet_01v8 L=0.15 W=0.42 nf=1 ad=0.1218 as=0.1218 pd=1.42 ps=1.42 nrd=0.69047619047619  nrs=0.69047619047619 sa=0 sb=0 sd=0 mult=1 m=1
csn_op0_n100_rl_s2_r10k_3 sn_op0_n100_rl_s2_r10k_3 0 {C_SN}
XMN1_op0_n100_rl_s2_r10k rbl_op0_n100_rl_s2_r10k ref_op0_n100_rl_s2_r10k vn_op0_n100_rl_s2_r10k 0 sky130_fd_pr__nfet_01v8 L=0.15 W=1 nf=1 ad=0.29 as=0.29 pd=2.58 ps=2.58 mult=1 m=1
XMN2_op0_n100_rl_s2_r10k ref_op0_n100_rl_s2_r10k rbl_op0_n100_rl_s2_r10k vn_op0_n100_rl_s2_r10k 0 sky130_fd_pr__nfet_01v8 L=0.15 W=1 nf=1 ad=0.29 as=0.29 pd=2.58 ps=2.58 mult=1 m=1
XMP1_op0_n100_rl_s2_r10k rbl_op0_n100_rl_s2_r10k ref_op0_n100_rl_s2_r10k vp_op0_n100_rl_s2_r10k vdd sky130_fd_pr__pfet_01v8 L=0.15 W=2 nf=1 ad=0.58 as=0.58 pd=4.58 ps=4.58 mult=1 m=1
XMP2_op0_n100_rl_s2_r10k ref_op0_n100_rl_s2_r10k rbl_op0_n100_rl_s2_r10k vp_op0_n100_rl_s2_r10k vdd sky130_fd_pr__pfet_01v8 L=0.15 W=2 nf=1 ad=0.58 as=0.58 pd=4.58 ps=4.58 mult=1 m=1
XMNF_op0_n100_rl_s2_r10k vn_op0_n100_rl_s2_r10k en_op0_n100_rl_s2_r10k 0 0 sky130_fd_pr__nfet_01v8 L=0.15 W=2 nf=1 ad=0.58 as=0.58 pd=4.58 ps=4.58 mult=1 m=1
XMPH_op0_n100_rl_s2_r10k vp_op0_n100_rl_s2_r10k enb_op0_n100_rl_s2_r10k vdd vdd sky130_fd_pr__pfet_01v8 L=0.15 W=4 nf=1 ad=1.16 as=1.16 pd=8.58 ps=8.58 mult=1 m=1
bd_op0_n100_rl_s2_r10k d_op0_n100_rl_s2_r10k 0 v=v(rbl_op0_n100_rl_s2_r10k)-v(ref_op0_n100_rl_s2_r10k)

* ---- instance 216: op0_0000_rl_s2_r10k (variant rl_s2_r10k; probe dec 11.9 ns, release 34 ns, meas 36 ns) ----
vctl_op0_0000_rl_s2_r10k ctl_op0_0000_rl_s2_r10k 0 pwl(0.0000e+00 {VDD} 2.0000e-09 {VDD} 2.1000e-09 0)
* RWL driver model (EXPERIMENTAL): slew 2 ns, series R 10000 ohm; cell pin = rwls_op0_0000_rl_s2_r10k
vrs_op0_0000_rl_s2_r10k rwlsrc_op0_0000_rl_s2_r10k 0 pwl(0.0000e+00 {VDD} 2.0000e-09 {VDD} 4.0000e-09 0 3.4000e-08 0 3.6000e-08 {VDD})
rdrv_op0_0000_rl_s2_r10k rwlsrc_op0_0000_rl_s2_r10k rwls_op0_0000_rl_s2_r10k 10000
ven_op0_0000_rl_s2_r10k en_op0_0000_rl_s2_r10k 0 pwl(0.0000e+00 0 1.1000e-08 0 1.1100e-08 {VDD} 3.4000e-08 {VDD} 3.4100e-08 0)
venb_op0_0000_rl_s2_r10k enb_op0_0000_rl_s2_r10k 0 pwl(0.0000e+00 {VDD} 1.1000e-08 {VDD} 1.1100e-08 0 3.4000e-08 0 3.4100e-08 {VDD})
vww_op0_0000_rl_s2_r10k wwl_op0_0000_rl_s2_r10k 0 pwl(0.0000e+00 0 1.2000e-08 0 1.2100e-08 {VDD} 3.2000e-08 {VDD} 3.2100e-08 0)
vwc_op0_0000_rl_s2_r10k wbc_op0_0000_rl_s2_r10k 0 pwl(0.0000e+00 0 1.2000e-08 0 1.2100e-08 {VDD} 3.4000e-08 {VDD} 3.4100e-08 0)
swb_op0_0000_rl_s2_r10k ref_op0_0000_rl_s2_r10k wbl_op0_0000_rl_s2_r10k wbc_op0_0000_rl_s2_r10k 0 swwbl
cwbl_op0_0000_rl_s2_r10k wbl_op0_0000_rl_s2_r10k 0 {C_WBL}
spa_op0_0000_rl_s2_r10k prea rbl_op0_0000_rl_s2_r10k ctl_op0_0000_rl_s2_r10k 0 swpre
spr_op0_0000_rl_s2_r10k pref ref_op0_0000_rl_s2_r10k ctl_op0_0000_rl_s2_r10k 0 swpre
crbl_op0_0000_rl_s2_r10k rbl_op0_0000_rl_s2_r10k 0 {C_RBL}
cref_op0_0000_rl_s2_r10k ref_op0_0000_rl_s2_r10k 0 {C_RBL}   $ ASSUMPTION: ideal matched dummy load
XMWR_op0_0000_rl_s2_r10k_0 sn_op0_0000_rl_s2_r10k_0 wwl_op0_0000_rl_s2_r10k wbl_op0_0000_rl_s2_r10k 0 sky130_fd_pr__nfet_01v8 L=0.15 W=0.42 nf=1 ad=0.1218 as=0.1218 pd=1.42 ps=1.42 nrd=0.69047619047619  nrs=0.69047619047619 sa=0 sb=0 sd=0 mult=1 m=1
XMRD_op0_0000_rl_s2_r10k_0 rbl_op0_0000_rl_s2_r10k sn_op0_0000_rl_s2_r10k_0 rwls_op0_0000_rl_s2_r10k 0 sky130_fd_pr__nfet_01v8 L=0.15 W=0.42 nf=1 ad=0.1218 as=0.1218 pd=1.42 ps=1.42 nrd=0.69047619047619  nrs=0.69047619047619 sa=0 sb=0 sd=0 mult=1 m=1
csn_op0_0000_rl_s2_r10k_0 sn_op0_0000_rl_s2_r10k_0 0 {C_SN}
XMWR_op0_0000_rl_s2_r10k_1 sn_op0_0000_rl_s2_r10k_1 wwl_des wbl_op0_0000_rl_s2_r10k 0 sky130_fd_pr__nfet_01v8 L=0.15 W=0.42 nf=1 ad=0.1218 as=0.1218 pd=1.42 ps=1.42 nrd=0.69047619047619  nrs=0.69047619047619 sa=0 sb=0 sd=0 mult=1 m=1
XMRD_op0_0000_rl_s2_r10k_1 rbl_op0_0000_rl_s2_r10k sn_op0_0000_rl_s2_r10k_1 rwl_des 0 sky130_fd_pr__nfet_01v8 L=0.15 W=0.42 nf=1 ad=0.1218 as=0.1218 pd=1.42 ps=1.42 nrd=0.69047619047619  nrs=0.69047619047619 sa=0 sb=0 sd=0 mult=1 m=1
csn_op0_0000_rl_s2_r10k_1 sn_op0_0000_rl_s2_r10k_1 0 {C_SN}
XMWR_op0_0000_rl_s2_r10k_2 sn_op0_0000_rl_s2_r10k_2 wwl_des wbl_op0_0000_rl_s2_r10k 0 sky130_fd_pr__nfet_01v8 L=0.15 W=0.42 nf=1 ad=0.1218 as=0.1218 pd=1.42 ps=1.42 nrd=0.69047619047619  nrs=0.69047619047619 sa=0 sb=0 sd=0 mult=1 m=1
XMRD_op0_0000_rl_s2_r10k_2 rbl_op0_0000_rl_s2_r10k sn_op0_0000_rl_s2_r10k_2 rwl_des 0 sky130_fd_pr__nfet_01v8 L=0.15 W=0.42 nf=1 ad=0.1218 as=0.1218 pd=1.42 ps=1.42 nrd=0.69047619047619  nrs=0.69047619047619 sa=0 sb=0 sd=0 mult=1 m=1
csn_op0_0000_rl_s2_r10k_2 sn_op0_0000_rl_s2_r10k_2 0 {C_SN}
XMWR_op0_0000_rl_s2_r10k_3 sn_op0_0000_rl_s2_r10k_3 wwl_des wbl_op0_0000_rl_s2_r10k 0 sky130_fd_pr__nfet_01v8 L=0.15 W=0.42 nf=1 ad=0.1218 as=0.1218 pd=1.42 ps=1.42 nrd=0.69047619047619  nrs=0.69047619047619 sa=0 sb=0 sd=0 mult=1 m=1
XMRD_op0_0000_rl_s2_r10k_3 rbl_op0_0000_rl_s2_r10k sn_op0_0000_rl_s2_r10k_3 rwl_des 0 sky130_fd_pr__nfet_01v8 L=0.15 W=0.42 nf=1 ad=0.1218 as=0.1218 pd=1.42 ps=1.42 nrd=0.69047619047619  nrs=0.69047619047619 sa=0 sb=0 sd=0 mult=1 m=1
csn_op0_0000_rl_s2_r10k_3 sn_op0_0000_rl_s2_r10k_3 0 {C_SN}
XMN1_op0_0000_rl_s2_r10k rbl_op0_0000_rl_s2_r10k ref_op0_0000_rl_s2_r10k vn_op0_0000_rl_s2_r10k 0 sky130_fd_pr__nfet_01v8 L=0.15 W=1 nf=1 ad=0.29 as=0.29 pd=2.58 ps=2.58 mult=1 m=1
XMN2_op0_0000_rl_s2_r10k ref_op0_0000_rl_s2_r10k rbl_op0_0000_rl_s2_r10k vn_op0_0000_rl_s2_r10k 0 sky130_fd_pr__nfet_01v8 L=0.15 W=1 nf=1 ad=0.29 as=0.29 pd=2.58 ps=2.58 mult=1 m=1
XMP1_op0_0000_rl_s2_r10k rbl_op0_0000_rl_s2_r10k ref_op0_0000_rl_s2_r10k vp_op0_0000_rl_s2_r10k vdd sky130_fd_pr__pfet_01v8 L=0.15 W=2 nf=1 ad=0.58 as=0.58 pd=4.58 ps=4.58 mult=1 m=1
XMP2_op0_0000_rl_s2_r10k ref_op0_0000_rl_s2_r10k rbl_op0_0000_rl_s2_r10k vp_op0_0000_rl_s2_r10k vdd sky130_fd_pr__pfet_01v8 L=0.15 W=2 nf=1 ad=0.58 as=0.58 pd=4.58 ps=4.58 mult=1 m=1
XMNF_op0_0000_rl_s2_r10k vn_op0_0000_rl_s2_r10k en_op0_0000_rl_s2_r10k 0 0 sky130_fd_pr__nfet_01v8 L=0.15 W=2 nf=1 ad=0.58 as=0.58 pd=4.58 ps=4.58 mult=1 m=1
XMPH_op0_0000_rl_s2_r10k vp_op0_0000_rl_s2_r10k enb_op0_0000_rl_s2_r10k vdd vdd sky130_fd_pr__pfet_01v8 L=0.15 W=4 nf=1 ad=1.16 as=1.16 pd=8.58 ps=8.58 mult=1 m=1
bd_op0_0000_rl_s2_r10k d_op0_0000_rl_s2_r10k 0 v=v(rbl_op0_0000_rl_s2_r10k)-v(ref_op0_0000_rl_s2_r10k)

* ---- instance 217: op1_0900_rl_s2_r100k (variant rl_s2_r100k; probe dec 11.9 ns, release 34 ns, meas 36 ns) ----
vctl_op1_0900_rl_s2_r100k ctl_op1_0900_rl_s2_r100k 0 pwl(0.0000e+00 {VDD} 2.0000e-09 {VDD} 2.1000e-09 0)
* RWL driver model (EXPERIMENTAL): slew 2 ns, series R 100000 ohm; cell pin = rwls_op1_0900_rl_s2_r100k
vrs_op1_0900_rl_s2_r100k rwlsrc_op1_0900_rl_s2_r100k 0 pwl(0.0000e+00 {VDD} 2.0000e-09 {VDD} 4.0000e-09 0 3.4000e-08 0 3.6000e-08 {VDD})
rdrv_op1_0900_rl_s2_r100k rwlsrc_op1_0900_rl_s2_r100k rwls_op1_0900_rl_s2_r100k 100000
ven_op1_0900_rl_s2_r100k en_op1_0900_rl_s2_r100k 0 pwl(0.0000e+00 0 1.1000e-08 0 1.1100e-08 {VDD} 3.4000e-08 {VDD} 3.4100e-08 0)
venb_op1_0900_rl_s2_r100k enb_op1_0900_rl_s2_r100k 0 pwl(0.0000e+00 {VDD} 1.1000e-08 {VDD} 1.1100e-08 0 3.4000e-08 0 3.4100e-08 {VDD})
vww_op1_0900_rl_s2_r100k wwl_op1_0900_rl_s2_r100k 0 pwl(0.0000e+00 0 1.2000e-08 0 1.2100e-08 {VDD} 3.2000e-08 {VDD} 3.2100e-08 0)
vwc_op1_0900_rl_s2_r100k wbc_op1_0900_rl_s2_r100k 0 pwl(0.0000e+00 0 1.2000e-08 0 1.2100e-08 {VDD} 3.4000e-08 {VDD} 3.4100e-08 0)
swb_op1_0900_rl_s2_r100k ref_op1_0900_rl_s2_r100k wbl_op1_0900_rl_s2_r100k wbc_op1_0900_rl_s2_r100k 0 swwbl
cwbl_op1_0900_rl_s2_r100k wbl_op1_0900_rl_s2_r100k 0 {C_WBL}
spa_op1_0900_rl_s2_r100k prea rbl_op1_0900_rl_s2_r100k ctl_op1_0900_rl_s2_r100k 0 swpre
spr_op1_0900_rl_s2_r100k pref ref_op1_0900_rl_s2_r100k ctl_op1_0900_rl_s2_r100k 0 swpre
crbl_op1_0900_rl_s2_r100k rbl_op1_0900_rl_s2_r100k 0 {C_RBL}
cref_op1_0900_rl_s2_r100k ref_op1_0900_rl_s2_r100k 0 {C_RBL}   $ ASSUMPTION: ideal matched dummy load
XMWR_op1_0900_rl_s2_r100k_0 sn_op1_0900_rl_s2_r100k_0 wwl_op1_0900_rl_s2_r100k wbl_op1_0900_rl_s2_r100k 0 sky130_fd_pr__nfet_01v8 L=0.15 W=0.42 nf=1 ad=0.1218 as=0.1218 pd=1.42 ps=1.42 nrd=0.69047619047619  nrs=0.69047619047619 sa=0 sb=0 sd=0 mult=1 m=1
XMRD_op1_0900_rl_s2_r100k_0 rbl_op1_0900_rl_s2_r100k sn_op1_0900_rl_s2_r100k_0 rwls_op1_0900_rl_s2_r100k 0 sky130_fd_pr__nfet_01v8 L=0.15 W=0.42 nf=1 ad=0.1218 as=0.1218 pd=1.42 ps=1.42 nrd=0.69047619047619  nrs=0.69047619047619 sa=0 sb=0 sd=0 mult=1 m=1
csn_op1_0900_rl_s2_r100k_0 sn_op1_0900_rl_s2_r100k_0 0 {C_SN}
XMWR_op1_0900_rl_s2_r100k_1 sn_op1_0900_rl_s2_r100k_1 wwl_des wbl_op1_0900_rl_s2_r100k 0 sky130_fd_pr__nfet_01v8 L=0.15 W=0.42 nf=1 ad=0.1218 as=0.1218 pd=1.42 ps=1.42 nrd=0.69047619047619  nrs=0.69047619047619 sa=0 sb=0 sd=0 mult=1 m=1
XMRD_op1_0900_rl_s2_r100k_1 rbl_op1_0900_rl_s2_r100k sn_op1_0900_rl_s2_r100k_1 rwl_des 0 sky130_fd_pr__nfet_01v8 L=0.15 W=0.42 nf=1 ad=0.1218 as=0.1218 pd=1.42 ps=1.42 nrd=0.69047619047619  nrs=0.69047619047619 sa=0 sb=0 sd=0 mult=1 m=1
csn_op1_0900_rl_s2_r100k_1 sn_op1_0900_rl_s2_r100k_1 0 {C_SN}
XMWR_op1_0900_rl_s2_r100k_2 sn_op1_0900_rl_s2_r100k_2 wwl_des wbl_op1_0900_rl_s2_r100k 0 sky130_fd_pr__nfet_01v8 L=0.15 W=0.42 nf=1 ad=0.1218 as=0.1218 pd=1.42 ps=1.42 nrd=0.69047619047619  nrs=0.69047619047619 sa=0 sb=0 sd=0 mult=1 m=1
XMRD_op1_0900_rl_s2_r100k_2 rbl_op1_0900_rl_s2_r100k sn_op1_0900_rl_s2_r100k_2 rwl_des 0 sky130_fd_pr__nfet_01v8 L=0.15 W=0.42 nf=1 ad=0.1218 as=0.1218 pd=1.42 ps=1.42 nrd=0.69047619047619  nrs=0.69047619047619 sa=0 sb=0 sd=0 mult=1 m=1
csn_op1_0900_rl_s2_r100k_2 sn_op1_0900_rl_s2_r100k_2 0 {C_SN}
XMWR_op1_0900_rl_s2_r100k_3 sn_op1_0900_rl_s2_r100k_3 wwl_des wbl_op1_0900_rl_s2_r100k 0 sky130_fd_pr__nfet_01v8 L=0.15 W=0.42 nf=1 ad=0.1218 as=0.1218 pd=1.42 ps=1.42 nrd=0.69047619047619  nrs=0.69047619047619 sa=0 sb=0 sd=0 mult=1 m=1
XMRD_op1_0900_rl_s2_r100k_3 rbl_op1_0900_rl_s2_r100k sn_op1_0900_rl_s2_r100k_3 rwl_des 0 sky130_fd_pr__nfet_01v8 L=0.15 W=0.42 nf=1 ad=0.1218 as=0.1218 pd=1.42 ps=1.42 nrd=0.69047619047619  nrs=0.69047619047619 sa=0 sb=0 sd=0 mult=1 m=1
csn_op1_0900_rl_s2_r100k_3 sn_op1_0900_rl_s2_r100k_3 0 {C_SN}
XMN1_op1_0900_rl_s2_r100k rbl_op1_0900_rl_s2_r100k ref_op1_0900_rl_s2_r100k vn_op1_0900_rl_s2_r100k 0 sky130_fd_pr__nfet_01v8 L=0.15 W=1 nf=1 ad=0.29 as=0.29 pd=2.58 ps=2.58 mult=1 m=1
XMN2_op1_0900_rl_s2_r100k ref_op1_0900_rl_s2_r100k rbl_op1_0900_rl_s2_r100k vn_op1_0900_rl_s2_r100k 0 sky130_fd_pr__nfet_01v8 L=0.15 W=1 nf=1 ad=0.29 as=0.29 pd=2.58 ps=2.58 mult=1 m=1
XMP1_op1_0900_rl_s2_r100k rbl_op1_0900_rl_s2_r100k ref_op1_0900_rl_s2_r100k vp_op1_0900_rl_s2_r100k vdd sky130_fd_pr__pfet_01v8 L=0.15 W=2 nf=1 ad=0.58 as=0.58 pd=4.58 ps=4.58 mult=1 m=1
XMP2_op1_0900_rl_s2_r100k ref_op1_0900_rl_s2_r100k rbl_op1_0900_rl_s2_r100k vp_op1_0900_rl_s2_r100k vdd sky130_fd_pr__pfet_01v8 L=0.15 W=2 nf=1 ad=0.58 as=0.58 pd=4.58 ps=4.58 mult=1 m=1
XMNF_op1_0900_rl_s2_r100k vn_op1_0900_rl_s2_r100k en_op1_0900_rl_s2_r100k 0 0 sky130_fd_pr__nfet_01v8 L=0.15 W=2 nf=1 ad=0.58 as=0.58 pd=4.58 ps=4.58 mult=1 m=1
XMPH_op1_0900_rl_s2_r100k vp_op1_0900_rl_s2_r100k enb_op1_0900_rl_s2_r100k vdd vdd sky130_fd_pr__pfet_01v8 L=0.15 W=4 nf=1 ad=1.16 as=1.16 pd=8.58 ps=8.58 mult=1 m=1
bd_op1_0900_rl_s2_r100k d_op1_0900_rl_s2_r100k 0 v=v(rbl_op1_0900_rl_s2_r100k)-v(ref_op1_0900_rl_s2_r100k)

* ---- instance 218: op1_1000_rl_s2_r100k (variant rl_s2_r100k; probe dec 11.9 ns, release 34 ns, meas 36 ns) ----
vctl_op1_1000_rl_s2_r100k ctl_op1_1000_rl_s2_r100k 0 pwl(0.0000e+00 {VDD} 2.0000e-09 {VDD} 2.1000e-09 0)
* RWL driver model (EXPERIMENTAL): slew 2 ns, series R 100000 ohm; cell pin = rwls_op1_1000_rl_s2_r100k
vrs_op1_1000_rl_s2_r100k rwlsrc_op1_1000_rl_s2_r100k 0 pwl(0.0000e+00 {VDD} 2.0000e-09 {VDD} 4.0000e-09 0 3.4000e-08 0 3.6000e-08 {VDD})
rdrv_op1_1000_rl_s2_r100k rwlsrc_op1_1000_rl_s2_r100k rwls_op1_1000_rl_s2_r100k 100000
ven_op1_1000_rl_s2_r100k en_op1_1000_rl_s2_r100k 0 pwl(0.0000e+00 0 1.1000e-08 0 1.1100e-08 {VDD} 3.4000e-08 {VDD} 3.4100e-08 0)
venb_op1_1000_rl_s2_r100k enb_op1_1000_rl_s2_r100k 0 pwl(0.0000e+00 {VDD} 1.1000e-08 {VDD} 1.1100e-08 0 3.4000e-08 0 3.4100e-08 {VDD})
vww_op1_1000_rl_s2_r100k wwl_op1_1000_rl_s2_r100k 0 pwl(0.0000e+00 0 1.2000e-08 0 1.2100e-08 {VDD} 3.2000e-08 {VDD} 3.2100e-08 0)
vwc_op1_1000_rl_s2_r100k wbc_op1_1000_rl_s2_r100k 0 pwl(0.0000e+00 0 1.2000e-08 0 1.2100e-08 {VDD} 3.4000e-08 {VDD} 3.4100e-08 0)
swb_op1_1000_rl_s2_r100k ref_op1_1000_rl_s2_r100k wbl_op1_1000_rl_s2_r100k wbc_op1_1000_rl_s2_r100k 0 swwbl
cwbl_op1_1000_rl_s2_r100k wbl_op1_1000_rl_s2_r100k 0 {C_WBL}
spa_op1_1000_rl_s2_r100k prea rbl_op1_1000_rl_s2_r100k ctl_op1_1000_rl_s2_r100k 0 swpre
spr_op1_1000_rl_s2_r100k pref ref_op1_1000_rl_s2_r100k ctl_op1_1000_rl_s2_r100k 0 swpre
crbl_op1_1000_rl_s2_r100k rbl_op1_1000_rl_s2_r100k 0 {C_RBL}
cref_op1_1000_rl_s2_r100k ref_op1_1000_rl_s2_r100k 0 {C_RBL}   $ ASSUMPTION: ideal matched dummy load
XMWR_op1_1000_rl_s2_r100k_0 sn_op1_1000_rl_s2_r100k_0 wwl_op1_1000_rl_s2_r100k wbl_op1_1000_rl_s2_r100k 0 sky130_fd_pr__nfet_01v8 L=0.15 W=0.42 nf=1 ad=0.1218 as=0.1218 pd=1.42 ps=1.42 nrd=0.69047619047619  nrs=0.69047619047619 sa=0 sb=0 sd=0 mult=1 m=1
XMRD_op1_1000_rl_s2_r100k_0 rbl_op1_1000_rl_s2_r100k sn_op1_1000_rl_s2_r100k_0 rwls_op1_1000_rl_s2_r100k 0 sky130_fd_pr__nfet_01v8 L=0.15 W=0.42 nf=1 ad=0.1218 as=0.1218 pd=1.42 ps=1.42 nrd=0.69047619047619  nrs=0.69047619047619 sa=0 sb=0 sd=0 mult=1 m=1
csn_op1_1000_rl_s2_r100k_0 sn_op1_1000_rl_s2_r100k_0 0 {C_SN}
XMWR_op1_1000_rl_s2_r100k_1 sn_op1_1000_rl_s2_r100k_1 wwl_des wbl_op1_1000_rl_s2_r100k 0 sky130_fd_pr__nfet_01v8 L=0.15 W=0.42 nf=1 ad=0.1218 as=0.1218 pd=1.42 ps=1.42 nrd=0.69047619047619  nrs=0.69047619047619 sa=0 sb=0 sd=0 mult=1 m=1
XMRD_op1_1000_rl_s2_r100k_1 rbl_op1_1000_rl_s2_r100k sn_op1_1000_rl_s2_r100k_1 rwl_des 0 sky130_fd_pr__nfet_01v8 L=0.15 W=0.42 nf=1 ad=0.1218 as=0.1218 pd=1.42 ps=1.42 nrd=0.69047619047619  nrs=0.69047619047619 sa=0 sb=0 sd=0 mult=1 m=1
csn_op1_1000_rl_s2_r100k_1 sn_op1_1000_rl_s2_r100k_1 0 {C_SN}
XMWR_op1_1000_rl_s2_r100k_2 sn_op1_1000_rl_s2_r100k_2 wwl_des wbl_op1_1000_rl_s2_r100k 0 sky130_fd_pr__nfet_01v8 L=0.15 W=0.42 nf=1 ad=0.1218 as=0.1218 pd=1.42 ps=1.42 nrd=0.69047619047619  nrs=0.69047619047619 sa=0 sb=0 sd=0 mult=1 m=1
XMRD_op1_1000_rl_s2_r100k_2 rbl_op1_1000_rl_s2_r100k sn_op1_1000_rl_s2_r100k_2 rwl_des 0 sky130_fd_pr__nfet_01v8 L=0.15 W=0.42 nf=1 ad=0.1218 as=0.1218 pd=1.42 ps=1.42 nrd=0.69047619047619  nrs=0.69047619047619 sa=0 sb=0 sd=0 mult=1 m=1
csn_op1_1000_rl_s2_r100k_2 sn_op1_1000_rl_s2_r100k_2 0 {C_SN}
XMWR_op1_1000_rl_s2_r100k_3 sn_op1_1000_rl_s2_r100k_3 wwl_des wbl_op1_1000_rl_s2_r100k 0 sky130_fd_pr__nfet_01v8 L=0.15 W=0.42 nf=1 ad=0.1218 as=0.1218 pd=1.42 ps=1.42 nrd=0.69047619047619  nrs=0.69047619047619 sa=0 sb=0 sd=0 mult=1 m=1
XMRD_op1_1000_rl_s2_r100k_3 rbl_op1_1000_rl_s2_r100k sn_op1_1000_rl_s2_r100k_3 rwl_des 0 sky130_fd_pr__nfet_01v8 L=0.15 W=0.42 nf=1 ad=0.1218 as=0.1218 pd=1.42 ps=1.42 nrd=0.69047619047619  nrs=0.69047619047619 sa=0 sb=0 sd=0 mult=1 m=1
csn_op1_1000_rl_s2_r100k_3 sn_op1_1000_rl_s2_r100k_3 0 {C_SN}
XMN1_op1_1000_rl_s2_r100k rbl_op1_1000_rl_s2_r100k ref_op1_1000_rl_s2_r100k vn_op1_1000_rl_s2_r100k 0 sky130_fd_pr__nfet_01v8 L=0.15 W=1 nf=1 ad=0.29 as=0.29 pd=2.58 ps=2.58 mult=1 m=1
XMN2_op1_1000_rl_s2_r100k ref_op1_1000_rl_s2_r100k rbl_op1_1000_rl_s2_r100k vn_op1_1000_rl_s2_r100k 0 sky130_fd_pr__nfet_01v8 L=0.15 W=1 nf=1 ad=0.29 as=0.29 pd=2.58 ps=2.58 mult=1 m=1
XMP1_op1_1000_rl_s2_r100k rbl_op1_1000_rl_s2_r100k ref_op1_1000_rl_s2_r100k vp_op1_1000_rl_s2_r100k vdd sky130_fd_pr__pfet_01v8 L=0.15 W=2 nf=1 ad=0.58 as=0.58 pd=4.58 ps=4.58 mult=1 m=1
XMP2_op1_1000_rl_s2_r100k ref_op1_1000_rl_s2_r100k rbl_op1_1000_rl_s2_r100k vp_op1_1000_rl_s2_r100k vdd sky130_fd_pr__pfet_01v8 L=0.15 W=2 nf=1 ad=0.58 as=0.58 pd=4.58 ps=4.58 mult=1 m=1
XMNF_op1_1000_rl_s2_r100k vn_op1_1000_rl_s2_r100k en_op1_1000_rl_s2_r100k 0 0 sky130_fd_pr__nfet_01v8 L=0.15 W=2 nf=1 ad=0.58 as=0.58 pd=4.58 ps=4.58 mult=1 m=1
XMPH_op1_1000_rl_s2_r100k vp_op1_1000_rl_s2_r100k enb_op1_1000_rl_s2_r100k vdd vdd sky130_fd_pr__pfet_01v8 L=0.15 W=4 nf=1 ad=1.16 as=1.16 pd=8.58 ps=8.58 mult=1 m=1
bd_op1_1000_rl_s2_r100k d_op1_1000_rl_s2_r100k 0 v=v(rbl_op1_1000_rl_s2_r100k)-v(ref_op1_1000_rl_s2_r100k)

* ---- instance 219: op0_n100_rl_s2_r100k (variant rl_s2_r100k; probe dec 11.9 ns, release 34 ns, meas 36 ns) ----
vctl_op0_n100_rl_s2_r100k ctl_op0_n100_rl_s2_r100k 0 pwl(0.0000e+00 {VDD} 2.0000e-09 {VDD} 2.1000e-09 0)
* RWL driver model (EXPERIMENTAL): slew 2 ns, series R 100000 ohm; cell pin = rwls_op0_n100_rl_s2_r100k
vrs_op0_n100_rl_s2_r100k rwlsrc_op0_n100_rl_s2_r100k 0 pwl(0.0000e+00 {VDD} 2.0000e-09 {VDD} 4.0000e-09 0 3.4000e-08 0 3.6000e-08 {VDD})
rdrv_op0_n100_rl_s2_r100k rwlsrc_op0_n100_rl_s2_r100k rwls_op0_n100_rl_s2_r100k 100000
ven_op0_n100_rl_s2_r100k en_op0_n100_rl_s2_r100k 0 pwl(0.0000e+00 0 1.1000e-08 0 1.1100e-08 {VDD} 3.4000e-08 {VDD} 3.4100e-08 0)
venb_op0_n100_rl_s2_r100k enb_op0_n100_rl_s2_r100k 0 pwl(0.0000e+00 {VDD} 1.1000e-08 {VDD} 1.1100e-08 0 3.4000e-08 0 3.4100e-08 {VDD})
vww_op0_n100_rl_s2_r100k wwl_op0_n100_rl_s2_r100k 0 pwl(0.0000e+00 0 1.2000e-08 0 1.2100e-08 {VDD} 3.2000e-08 {VDD} 3.2100e-08 0)
vwc_op0_n100_rl_s2_r100k wbc_op0_n100_rl_s2_r100k 0 pwl(0.0000e+00 0 1.2000e-08 0 1.2100e-08 {VDD} 3.4000e-08 {VDD} 3.4100e-08 0)
swb_op0_n100_rl_s2_r100k ref_op0_n100_rl_s2_r100k wbl_op0_n100_rl_s2_r100k wbc_op0_n100_rl_s2_r100k 0 swwbl
cwbl_op0_n100_rl_s2_r100k wbl_op0_n100_rl_s2_r100k 0 {C_WBL}
spa_op0_n100_rl_s2_r100k prea rbl_op0_n100_rl_s2_r100k ctl_op0_n100_rl_s2_r100k 0 swpre
spr_op0_n100_rl_s2_r100k pref ref_op0_n100_rl_s2_r100k ctl_op0_n100_rl_s2_r100k 0 swpre
crbl_op0_n100_rl_s2_r100k rbl_op0_n100_rl_s2_r100k 0 {C_RBL}
cref_op0_n100_rl_s2_r100k ref_op0_n100_rl_s2_r100k 0 {C_RBL}   $ ASSUMPTION: ideal matched dummy load
XMWR_op0_n100_rl_s2_r100k_0 sn_op0_n100_rl_s2_r100k_0 wwl_op0_n100_rl_s2_r100k wbl_op0_n100_rl_s2_r100k 0 sky130_fd_pr__nfet_01v8 L=0.15 W=0.42 nf=1 ad=0.1218 as=0.1218 pd=1.42 ps=1.42 nrd=0.69047619047619  nrs=0.69047619047619 sa=0 sb=0 sd=0 mult=1 m=1
XMRD_op0_n100_rl_s2_r100k_0 rbl_op0_n100_rl_s2_r100k sn_op0_n100_rl_s2_r100k_0 rwls_op0_n100_rl_s2_r100k 0 sky130_fd_pr__nfet_01v8 L=0.15 W=0.42 nf=1 ad=0.1218 as=0.1218 pd=1.42 ps=1.42 nrd=0.69047619047619  nrs=0.69047619047619 sa=0 sb=0 sd=0 mult=1 m=1
csn_op0_n100_rl_s2_r100k_0 sn_op0_n100_rl_s2_r100k_0 0 {C_SN}
XMWR_op0_n100_rl_s2_r100k_1 sn_op0_n100_rl_s2_r100k_1 wwl_des wbl_op0_n100_rl_s2_r100k 0 sky130_fd_pr__nfet_01v8 L=0.15 W=0.42 nf=1 ad=0.1218 as=0.1218 pd=1.42 ps=1.42 nrd=0.69047619047619  nrs=0.69047619047619 sa=0 sb=0 sd=0 mult=1 m=1
XMRD_op0_n100_rl_s2_r100k_1 rbl_op0_n100_rl_s2_r100k sn_op0_n100_rl_s2_r100k_1 rwl_des 0 sky130_fd_pr__nfet_01v8 L=0.15 W=0.42 nf=1 ad=0.1218 as=0.1218 pd=1.42 ps=1.42 nrd=0.69047619047619  nrs=0.69047619047619 sa=0 sb=0 sd=0 mult=1 m=1
csn_op0_n100_rl_s2_r100k_1 sn_op0_n100_rl_s2_r100k_1 0 {C_SN}
XMWR_op0_n100_rl_s2_r100k_2 sn_op0_n100_rl_s2_r100k_2 wwl_des wbl_op0_n100_rl_s2_r100k 0 sky130_fd_pr__nfet_01v8 L=0.15 W=0.42 nf=1 ad=0.1218 as=0.1218 pd=1.42 ps=1.42 nrd=0.69047619047619  nrs=0.69047619047619 sa=0 sb=0 sd=0 mult=1 m=1
XMRD_op0_n100_rl_s2_r100k_2 rbl_op0_n100_rl_s2_r100k sn_op0_n100_rl_s2_r100k_2 rwl_des 0 sky130_fd_pr__nfet_01v8 L=0.15 W=0.42 nf=1 ad=0.1218 as=0.1218 pd=1.42 ps=1.42 nrd=0.69047619047619  nrs=0.69047619047619 sa=0 sb=0 sd=0 mult=1 m=1
csn_op0_n100_rl_s2_r100k_2 sn_op0_n100_rl_s2_r100k_2 0 {C_SN}
XMWR_op0_n100_rl_s2_r100k_3 sn_op0_n100_rl_s2_r100k_3 wwl_des wbl_op0_n100_rl_s2_r100k 0 sky130_fd_pr__nfet_01v8 L=0.15 W=0.42 nf=1 ad=0.1218 as=0.1218 pd=1.42 ps=1.42 nrd=0.69047619047619  nrs=0.69047619047619 sa=0 sb=0 sd=0 mult=1 m=1
XMRD_op0_n100_rl_s2_r100k_3 rbl_op0_n100_rl_s2_r100k sn_op0_n100_rl_s2_r100k_3 rwl_des 0 sky130_fd_pr__nfet_01v8 L=0.15 W=0.42 nf=1 ad=0.1218 as=0.1218 pd=1.42 ps=1.42 nrd=0.69047619047619  nrs=0.69047619047619 sa=0 sb=0 sd=0 mult=1 m=1
csn_op0_n100_rl_s2_r100k_3 sn_op0_n100_rl_s2_r100k_3 0 {C_SN}
XMN1_op0_n100_rl_s2_r100k rbl_op0_n100_rl_s2_r100k ref_op0_n100_rl_s2_r100k vn_op0_n100_rl_s2_r100k 0 sky130_fd_pr__nfet_01v8 L=0.15 W=1 nf=1 ad=0.29 as=0.29 pd=2.58 ps=2.58 mult=1 m=1
XMN2_op0_n100_rl_s2_r100k ref_op0_n100_rl_s2_r100k rbl_op0_n100_rl_s2_r100k vn_op0_n100_rl_s2_r100k 0 sky130_fd_pr__nfet_01v8 L=0.15 W=1 nf=1 ad=0.29 as=0.29 pd=2.58 ps=2.58 mult=1 m=1
XMP1_op0_n100_rl_s2_r100k rbl_op0_n100_rl_s2_r100k ref_op0_n100_rl_s2_r100k vp_op0_n100_rl_s2_r100k vdd sky130_fd_pr__pfet_01v8 L=0.15 W=2 nf=1 ad=0.58 as=0.58 pd=4.58 ps=4.58 mult=1 m=1
XMP2_op0_n100_rl_s2_r100k ref_op0_n100_rl_s2_r100k rbl_op0_n100_rl_s2_r100k vp_op0_n100_rl_s2_r100k vdd sky130_fd_pr__pfet_01v8 L=0.15 W=2 nf=1 ad=0.58 as=0.58 pd=4.58 ps=4.58 mult=1 m=1
XMNF_op0_n100_rl_s2_r100k vn_op0_n100_rl_s2_r100k en_op0_n100_rl_s2_r100k 0 0 sky130_fd_pr__nfet_01v8 L=0.15 W=2 nf=1 ad=0.58 as=0.58 pd=4.58 ps=4.58 mult=1 m=1
XMPH_op0_n100_rl_s2_r100k vp_op0_n100_rl_s2_r100k enb_op0_n100_rl_s2_r100k vdd vdd sky130_fd_pr__pfet_01v8 L=0.15 W=4 nf=1 ad=1.16 as=1.16 pd=8.58 ps=8.58 mult=1 m=1
bd_op0_n100_rl_s2_r100k d_op0_n100_rl_s2_r100k 0 v=v(rbl_op0_n100_rl_s2_r100k)-v(ref_op0_n100_rl_s2_r100k)

* ---- instance 220: op0_0000_rl_s2_r100k (variant rl_s2_r100k; probe dec 11.9 ns, release 34 ns, meas 36 ns) ----
vctl_op0_0000_rl_s2_r100k ctl_op0_0000_rl_s2_r100k 0 pwl(0.0000e+00 {VDD} 2.0000e-09 {VDD} 2.1000e-09 0)
* RWL driver model (EXPERIMENTAL): slew 2 ns, series R 100000 ohm; cell pin = rwls_op0_0000_rl_s2_r100k
vrs_op0_0000_rl_s2_r100k rwlsrc_op0_0000_rl_s2_r100k 0 pwl(0.0000e+00 {VDD} 2.0000e-09 {VDD} 4.0000e-09 0 3.4000e-08 0 3.6000e-08 {VDD})
rdrv_op0_0000_rl_s2_r100k rwlsrc_op0_0000_rl_s2_r100k rwls_op0_0000_rl_s2_r100k 100000
ven_op0_0000_rl_s2_r100k en_op0_0000_rl_s2_r100k 0 pwl(0.0000e+00 0 1.1000e-08 0 1.1100e-08 {VDD} 3.4000e-08 {VDD} 3.4100e-08 0)
venb_op0_0000_rl_s2_r100k enb_op0_0000_rl_s2_r100k 0 pwl(0.0000e+00 {VDD} 1.1000e-08 {VDD} 1.1100e-08 0 3.4000e-08 0 3.4100e-08 {VDD})
vww_op0_0000_rl_s2_r100k wwl_op0_0000_rl_s2_r100k 0 pwl(0.0000e+00 0 1.2000e-08 0 1.2100e-08 {VDD} 3.2000e-08 {VDD} 3.2100e-08 0)
vwc_op0_0000_rl_s2_r100k wbc_op0_0000_rl_s2_r100k 0 pwl(0.0000e+00 0 1.2000e-08 0 1.2100e-08 {VDD} 3.4000e-08 {VDD} 3.4100e-08 0)
swb_op0_0000_rl_s2_r100k ref_op0_0000_rl_s2_r100k wbl_op0_0000_rl_s2_r100k wbc_op0_0000_rl_s2_r100k 0 swwbl
cwbl_op0_0000_rl_s2_r100k wbl_op0_0000_rl_s2_r100k 0 {C_WBL}
spa_op0_0000_rl_s2_r100k prea rbl_op0_0000_rl_s2_r100k ctl_op0_0000_rl_s2_r100k 0 swpre
spr_op0_0000_rl_s2_r100k pref ref_op0_0000_rl_s2_r100k ctl_op0_0000_rl_s2_r100k 0 swpre
crbl_op0_0000_rl_s2_r100k rbl_op0_0000_rl_s2_r100k 0 {C_RBL}
cref_op0_0000_rl_s2_r100k ref_op0_0000_rl_s2_r100k 0 {C_RBL}   $ ASSUMPTION: ideal matched dummy load
XMWR_op0_0000_rl_s2_r100k_0 sn_op0_0000_rl_s2_r100k_0 wwl_op0_0000_rl_s2_r100k wbl_op0_0000_rl_s2_r100k 0 sky130_fd_pr__nfet_01v8 L=0.15 W=0.42 nf=1 ad=0.1218 as=0.1218 pd=1.42 ps=1.42 nrd=0.69047619047619  nrs=0.69047619047619 sa=0 sb=0 sd=0 mult=1 m=1
XMRD_op0_0000_rl_s2_r100k_0 rbl_op0_0000_rl_s2_r100k sn_op0_0000_rl_s2_r100k_0 rwls_op0_0000_rl_s2_r100k 0 sky130_fd_pr__nfet_01v8 L=0.15 W=0.42 nf=1 ad=0.1218 as=0.1218 pd=1.42 ps=1.42 nrd=0.69047619047619  nrs=0.69047619047619 sa=0 sb=0 sd=0 mult=1 m=1
csn_op0_0000_rl_s2_r100k_0 sn_op0_0000_rl_s2_r100k_0 0 {C_SN}
XMWR_op0_0000_rl_s2_r100k_1 sn_op0_0000_rl_s2_r100k_1 wwl_des wbl_op0_0000_rl_s2_r100k 0 sky130_fd_pr__nfet_01v8 L=0.15 W=0.42 nf=1 ad=0.1218 as=0.1218 pd=1.42 ps=1.42 nrd=0.69047619047619  nrs=0.69047619047619 sa=0 sb=0 sd=0 mult=1 m=1
XMRD_op0_0000_rl_s2_r100k_1 rbl_op0_0000_rl_s2_r100k sn_op0_0000_rl_s2_r100k_1 rwl_des 0 sky130_fd_pr__nfet_01v8 L=0.15 W=0.42 nf=1 ad=0.1218 as=0.1218 pd=1.42 ps=1.42 nrd=0.69047619047619  nrs=0.69047619047619 sa=0 sb=0 sd=0 mult=1 m=1
csn_op0_0000_rl_s2_r100k_1 sn_op0_0000_rl_s2_r100k_1 0 {C_SN}
XMWR_op0_0000_rl_s2_r100k_2 sn_op0_0000_rl_s2_r100k_2 wwl_des wbl_op0_0000_rl_s2_r100k 0 sky130_fd_pr__nfet_01v8 L=0.15 W=0.42 nf=1 ad=0.1218 as=0.1218 pd=1.42 ps=1.42 nrd=0.69047619047619  nrs=0.69047619047619 sa=0 sb=0 sd=0 mult=1 m=1
XMRD_op0_0000_rl_s2_r100k_2 rbl_op0_0000_rl_s2_r100k sn_op0_0000_rl_s2_r100k_2 rwl_des 0 sky130_fd_pr__nfet_01v8 L=0.15 W=0.42 nf=1 ad=0.1218 as=0.1218 pd=1.42 ps=1.42 nrd=0.69047619047619  nrs=0.69047619047619 sa=0 sb=0 sd=0 mult=1 m=1
csn_op0_0000_rl_s2_r100k_2 sn_op0_0000_rl_s2_r100k_2 0 {C_SN}
XMWR_op0_0000_rl_s2_r100k_3 sn_op0_0000_rl_s2_r100k_3 wwl_des wbl_op0_0000_rl_s2_r100k 0 sky130_fd_pr__nfet_01v8 L=0.15 W=0.42 nf=1 ad=0.1218 as=0.1218 pd=1.42 ps=1.42 nrd=0.69047619047619  nrs=0.69047619047619 sa=0 sb=0 sd=0 mult=1 m=1
XMRD_op0_0000_rl_s2_r100k_3 rbl_op0_0000_rl_s2_r100k sn_op0_0000_rl_s2_r100k_3 rwl_des 0 sky130_fd_pr__nfet_01v8 L=0.15 W=0.42 nf=1 ad=0.1218 as=0.1218 pd=1.42 ps=1.42 nrd=0.69047619047619  nrs=0.69047619047619 sa=0 sb=0 sd=0 mult=1 m=1
csn_op0_0000_rl_s2_r100k_3 sn_op0_0000_rl_s2_r100k_3 0 {C_SN}
XMN1_op0_0000_rl_s2_r100k rbl_op0_0000_rl_s2_r100k ref_op0_0000_rl_s2_r100k vn_op0_0000_rl_s2_r100k 0 sky130_fd_pr__nfet_01v8 L=0.15 W=1 nf=1 ad=0.29 as=0.29 pd=2.58 ps=2.58 mult=1 m=1
XMN2_op0_0000_rl_s2_r100k ref_op0_0000_rl_s2_r100k rbl_op0_0000_rl_s2_r100k vn_op0_0000_rl_s2_r100k 0 sky130_fd_pr__nfet_01v8 L=0.15 W=1 nf=1 ad=0.29 as=0.29 pd=2.58 ps=2.58 mult=1 m=1
XMP1_op0_0000_rl_s2_r100k rbl_op0_0000_rl_s2_r100k ref_op0_0000_rl_s2_r100k vp_op0_0000_rl_s2_r100k vdd sky130_fd_pr__pfet_01v8 L=0.15 W=2 nf=1 ad=0.58 as=0.58 pd=4.58 ps=4.58 mult=1 m=1
XMP2_op0_0000_rl_s2_r100k ref_op0_0000_rl_s2_r100k rbl_op0_0000_rl_s2_r100k vp_op0_0000_rl_s2_r100k vdd sky130_fd_pr__pfet_01v8 L=0.15 W=2 nf=1 ad=0.58 as=0.58 pd=4.58 ps=4.58 mult=1 m=1
XMNF_op0_0000_rl_s2_r100k vn_op0_0000_rl_s2_r100k en_op0_0000_rl_s2_r100k 0 0 sky130_fd_pr__nfet_01v8 L=0.15 W=2 nf=1 ad=0.58 as=0.58 pd=4.58 ps=4.58 mult=1 m=1
XMPH_op0_0000_rl_s2_r100k vp_op0_0000_rl_s2_r100k enb_op0_0000_rl_s2_r100k vdd vdd sky130_fd_pr__pfet_01v8 L=0.15 W=4 nf=1 ad=1.16 as=1.16 pd=8.58 ps=8.58 mult=1 m=1
bd_op0_0000_rl_s2_r100k d_op0_0000_rl_s2_r100k 0 v=v(rbl_op0_0000_rl_s2_r100k)-v(ref_op0_0000_rl_s2_r100k)

* ---- instance 221: op1_0900_rl_s0p1_r0_dm016p0 (variant rl_s0p1_r0_dm016p0; probe dec 11.9 ns, release 34 ns, meas 36 ns) ----
vctl_op1_0900_rl_s0p1_r0_dm016p0 ctl_op1_0900_rl_s0p1_r0_dm016p0 0 pwl(0.0000e+00 {VDD} 2.0000e-09 {VDD} 2.1000e-09 0)
* RWL driver model (EXPERIMENTAL): slew 0.1 ns, series R 0 ohm; cell pin = rwls_op1_0900_rl_s0p1_r0_dm016p0
vrs_op1_0900_rl_s0p1_r0_dm016p0 rwls_op1_0900_rl_s0p1_r0_dm016p0 0 pwl(0.0000e+00 {VDD} 2.0000e-09 {VDD} 2.1000e-09 0 1.6000e-08 0 1.6100e-08 {VDD})
ven_op1_0900_rl_s0p1_r0_dm016p0 en_op1_0900_rl_s0p1_r0_dm016p0 0 pwl(0.0000e+00 0 1.1000e-08 0 1.1100e-08 {VDD} 3.4000e-08 {VDD} 3.4100e-08 0)
venb_op1_0900_rl_s0p1_r0_dm016p0 enb_op1_0900_rl_s0p1_r0_dm016p0 0 pwl(0.0000e+00 {VDD} 1.1000e-08 {VDD} 1.1100e-08 0 3.4000e-08 0 3.4100e-08 {VDD})
vww_op1_0900_rl_s0p1_r0_dm016p0 wwl_op1_0900_rl_s0p1_r0_dm016p0 0 pwl(0.0000e+00 0 1.2000e-08 0 1.2100e-08 {VDD} 3.2000e-08 {VDD} 3.2100e-08 0)
vwc_op1_0900_rl_s0p1_r0_dm016p0 wbc_op1_0900_rl_s0p1_r0_dm016p0 0 pwl(0.0000e+00 0 1.2000e-08 0 1.2100e-08 {VDD} 3.4000e-08 {VDD} 3.4100e-08 0)
swb_op1_0900_rl_s0p1_r0_dm016p0 ref_op1_0900_rl_s0p1_r0_dm016p0 wbl_op1_0900_rl_s0p1_r0_dm016p0 wbc_op1_0900_rl_s0p1_r0_dm016p0 0 swwbl
cwbl_op1_0900_rl_s0p1_r0_dm016p0 wbl_op1_0900_rl_s0p1_r0_dm016p0 0 {C_WBL}
spa_op1_0900_rl_s0p1_r0_dm016p0 prea rbl_op1_0900_rl_s0p1_r0_dm016p0 ctl_op1_0900_rl_s0p1_r0_dm016p0 0 swpre
spr_op1_0900_rl_s0p1_r0_dm016p0 pref ref_op1_0900_rl_s0p1_r0_dm016p0 ctl_op1_0900_rl_s0p1_r0_dm016p0 0 swpre
crbl_op1_0900_rl_s0p1_r0_dm016p0 rbl_op1_0900_rl_s0p1_r0_dm016p0 0 {C_RBL}
cref_op1_0900_rl_s0p1_r0_dm016p0 ref_op1_0900_rl_s0p1_r0_dm016p0 0 {C_RBL}   $ ASSUMPTION: ideal matched dummy load
XMWR_op1_0900_rl_s0p1_r0_dm016p0_0 sn_op1_0900_rl_s0p1_r0_dm016p0_0 wwl_op1_0900_rl_s0p1_r0_dm016p0 wbl_op1_0900_rl_s0p1_r0_dm016p0 0 sky130_fd_pr__nfet_01v8 L=0.15 W=0.42 nf=1 ad=0.1218 as=0.1218 pd=1.42 ps=1.42 nrd=0.69047619047619  nrs=0.69047619047619 sa=0 sb=0 sd=0 mult=1 m=1
XMRD_op1_0900_rl_s0p1_r0_dm016p0_0 rbl_op1_0900_rl_s0p1_r0_dm016p0 sn_op1_0900_rl_s0p1_r0_dm016p0_0 rwls_op1_0900_rl_s0p1_r0_dm016p0 0 sky130_fd_pr__nfet_01v8 L=0.15 W=0.42 nf=1 ad=0.1218 as=0.1218 pd=1.42 ps=1.42 nrd=0.69047619047619  nrs=0.69047619047619 sa=0 sb=0 sd=0 mult=1 m=1
csn_op1_0900_rl_s0p1_r0_dm016p0_0 sn_op1_0900_rl_s0p1_r0_dm016p0_0 0 {C_SN}
XMWR_op1_0900_rl_s0p1_r0_dm016p0_1 sn_op1_0900_rl_s0p1_r0_dm016p0_1 wwl_des wbl_op1_0900_rl_s0p1_r0_dm016p0 0 sky130_fd_pr__nfet_01v8 L=0.15 W=0.42 nf=1 ad=0.1218 as=0.1218 pd=1.42 ps=1.42 nrd=0.69047619047619  nrs=0.69047619047619 sa=0 sb=0 sd=0 mult=1 m=1
XMRD_op1_0900_rl_s0p1_r0_dm016p0_1 rbl_op1_0900_rl_s0p1_r0_dm016p0 sn_op1_0900_rl_s0p1_r0_dm016p0_1 rwl_des 0 sky130_fd_pr__nfet_01v8 L=0.15 W=0.42 nf=1 ad=0.1218 as=0.1218 pd=1.42 ps=1.42 nrd=0.69047619047619  nrs=0.69047619047619 sa=0 sb=0 sd=0 mult=1 m=1
csn_op1_0900_rl_s0p1_r0_dm016p0_1 sn_op1_0900_rl_s0p1_r0_dm016p0_1 0 {C_SN}
XMWR_op1_0900_rl_s0p1_r0_dm016p0_2 sn_op1_0900_rl_s0p1_r0_dm016p0_2 wwl_des wbl_op1_0900_rl_s0p1_r0_dm016p0 0 sky130_fd_pr__nfet_01v8 L=0.15 W=0.42 nf=1 ad=0.1218 as=0.1218 pd=1.42 ps=1.42 nrd=0.69047619047619  nrs=0.69047619047619 sa=0 sb=0 sd=0 mult=1 m=1
XMRD_op1_0900_rl_s0p1_r0_dm016p0_2 rbl_op1_0900_rl_s0p1_r0_dm016p0 sn_op1_0900_rl_s0p1_r0_dm016p0_2 rwl_des 0 sky130_fd_pr__nfet_01v8 L=0.15 W=0.42 nf=1 ad=0.1218 as=0.1218 pd=1.42 ps=1.42 nrd=0.69047619047619  nrs=0.69047619047619 sa=0 sb=0 sd=0 mult=1 m=1
csn_op1_0900_rl_s0p1_r0_dm016p0_2 sn_op1_0900_rl_s0p1_r0_dm016p0_2 0 {C_SN}
XMWR_op1_0900_rl_s0p1_r0_dm016p0_3 sn_op1_0900_rl_s0p1_r0_dm016p0_3 wwl_des wbl_op1_0900_rl_s0p1_r0_dm016p0 0 sky130_fd_pr__nfet_01v8 L=0.15 W=0.42 nf=1 ad=0.1218 as=0.1218 pd=1.42 ps=1.42 nrd=0.69047619047619  nrs=0.69047619047619 sa=0 sb=0 sd=0 mult=1 m=1
XMRD_op1_0900_rl_s0p1_r0_dm016p0_3 rbl_op1_0900_rl_s0p1_r0_dm016p0 sn_op1_0900_rl_s0p1_r0_dm016p0_3 rwl_des 0 sky130_fd_pr__nfet_01v8 L=0.15 W=0.42 nf=1 ad=0.1218 as=0.1218 pd=1.42 ps=1.42 nrd=0.69047619047619  nrs=0.69047619047619 sa=0 sb=0 sd=0 mult=1 m=1
csn_op1_0900_rl_s0p1_r0_dm016p0_3 sn_op1_0900_rl_s0p1_r0_dm016p0_3 0 {C_SN}
XMN1_op1_0900_rl_s0p1_r0_dm016p0 rbl_op1_0900_rl_s0p1_r0_dm016p0 ref_op1_0900_rl_s0p1_r0_dm016p0 vn_op1_0900_rl_s0p1_r0_dm016p0 0 sky130_fd_pr__nfet_01v8 L=0.15 W=1 nf=1 ad=0.29 as=0.29 pd=2.58 ps=2.58 mult=1 m=1
XMN2_op1_0900_rl_s0p1_r0_dm016p0 ref_op1_0900_rl_s0p1_r0_dm016p0 rbl_op1_0900_rl_s0p1_r0_dm016p0 vn_op1_0900_rl_s0p1_r0_dm016p0 0 sky130_fd_pr__nfet_01v8 L=0.15 W=1 nf=1 ad=0.29 as=0.29 pd=2.58 ps=2.58 mult=1 m=1
XMP1_op1_0900_rl_s0p1_r0_dm016p0 rbl_op1_0900_rl_s0p1_r0_dm016p0 ref_op1_0900_rl_s0p1_r0_dm016p0 vp_op1_0900_rl_s0p1_r0_dm016p0 vdd sky130_fd_pr__pfet_01v8 L=0.15 W=2 nf=1 ad=0.58 as=0.58 pd=4.58 ps=4.58 mult=1 m=1
XMP2_op1_0900_rl_s0p1_r0_dm016p0 ref_op1_0900_rl_s0p1_r0_dm016p0 rbl_op1_0900_rl_s0p1_r0_dm016p0 vp_op1_0900_rl_s0p1_r0_dm016p0 vdd sky130_fd_pr__pfet_01v8 L=0.15 W=2 nf=1 ad=0.58 as=0.58 pd=4.58 ps=4.58 mult=1 m=1
XMNF_op1_0900_rl_s0p1_r0_dm016p0 vn_op1_0900_rl_s0p1_r0_dm016p0 en_op1_0900_rl_s0p1_r0_dm016p0 0 0 sky130_fd_pr__nfet_01v8 L=0.15 W=2 nf=1 ad=0.58 as=0.58 pd=4.58 ps=4.58 mult=1 m=1
XMPH_op1_0900_rl_s0p1_r0_dm016p0 vp_op1_0900_rl_s0p1_r0_dm016p0 enb_op1_0900_rl_s0p1_r0_dm016p0 vdd vdd sky130_fd_pr__pfet_01v8 L=0.15 W=4 nf=1 ad=1.16 as=1.16 pd=8.58 ps=8.58 mult=1 m=1
bd_op1_0900_rl_s0p1_r0_dm016p0 d_op1_0900_rl_s0p1_r0_dm016p0 0 v=v(rbl_op1_0900_rl_s0p1_r0_dm016p0)-v(ref_op1_0900_rl_s0p1_r0_dm016p0)

* ---- instance 222: op1_1000_rl_s0p1_r0_dm016p0 (variant rl_s0p1_r0_dm016p0; probe dec 11.9 ns, release 34 ns, meas 36 ns) ----
vctl_op1_1000_rl_s0p1_r0_dm016p0 ctl_op1_1000_rl_s0p1_r0_dm016p0 0 pwl(0.0000e+00 {VDD} 2.0000e-09 {VDD} 2.1000e-09 0)
* RWL driver model (EXPERIMENTAL): slew 0.1 ns, series R 0 ohm; cell pin = rwls_op1_1000_rl_s0p1_r0_dm016p0
vrs_op1_1000_rl_s0p1_r0_dm016p0 rwls_op1_1000_rl_s0p1_r0_dm016p0 0 pwl(0.0000e+00 {VDD} 2.0000e-09 {VDD} 2.1000e-09 0 1.6000e-08 0 1.6100e-08 {VDD})
ven_op1_1000_rl_s0p1_r0_dm016p0 en_op1_1000_rl_s0p1_r0_dm016p0 0 pwl(0.0000e+00 0 1.1000e-08 0 1.1100e-08 {VDD} 3.4000e-08 {VDD} 3.4100e-08 0)
venb_op1_1000_rl_s0p1_r0_dm016p0 enb_op1_1000_rl_s0p1_r0_dm016p0 0 pwl(0.0000e+00 {VDD} 1.1000e-08 {VDD} 1.1100e-08 0 3.4000e-08 0 3.4100e-08 {VDD})
vww_op1_1000_rl_s0p1_r0_dm016p0 wwl_op1_1000_rl_s0p1_r0_dm016p0 0 pwl(0.0000e+00 0 1.2000e-08 0 1.2100e-08 {VDD} 3.2000e-08 {VDD} 3.2100e-08 0)
vwc_op1_1000_rl_s0p1_r0_dm016p0 wbc_op1_1000_rl_s0p1_r0_dm016p0 0 pwl(0.0000e+00 0 1.2000e-08 0 1.2100e-08 {VDD} 3.4000e-08 {VDD} 3.4100e-08 0)
swb_op1_1000_rl_s0p1_r0_dm016p0 ref_op1_1000_rl_s0p1_r0_dm016p0 wbl_op1_1000_rl_s0p1_r0_dm016p0 wbc_op1_1000_rl_s0p1_r0_dm016p0 0 swwbl
cwbl_op1_1000_rl_s0p1_r0_dm016p0 wbl_op1_1000_rl_s0p1_r0_dm016p0 0 {C_WBL}
spa_op1_1000_rl_s0p1_r0_dm016p0 prea rbl_op1_1000_rl_s0p1_r0_dm016p0 ctl_op1_1000_rl_s0p1_r0_dm016p0 0 swpre
spr_op1_1000_rl_s0p1_r0_dm016p0 pref ref_op1_1000_rl_s0p1_r0_dm016p0 ctl_op1_1000_rl_s0p1_r0_dm016p0 0 swpre
crbl_op1_1000_rl_s0p1_r0_dm016p0 rbl_op1_1000_rl_s0p1_r0_dm016p0 0 {C_RBL}
cref_op1_1000_rl_s0p1_r0_dm016p0 ref_op1_1000_rl_s0p1_r0_dm016p0 0 {C_RBL}   $ ASSUMPTION: ideal matched dummy load
XMWR_op1_1000_rl_s0p1_r0_dm016p0_0 sn_op1_1000_rl_s0p1_r0_dm016p0_0 wwl_op1_1000_rl_s0p1_r0_dm016p0 wbl_op1_1000_rl_s0p1_r0_dm016p0 0 sky130_fd_pr__nfet_01v8 L=0.15 W=0.42 nf=1 ad=0.1218 as=0.1218 pd=1.42 ps=1.42 nrd=0.69047619047619  nrs=0.69047619047619 sa=0 sb=0 sd=0 mult=1 m=1
XMRD_op1_1000_rl_s0p1_r0_dm016p0_0 rbl_op1_1000_rl_s0p1_r0_dm016p0 sn_op1_1000_rl_s0p1_r0_dm016p0_0 rwls_op1_1000_rl_s0p1_r0_dm016p0 0 sky130_fd_pr__nfet_01v8 L=0.15 W=0.42 nf=1 ad=0.1218 as=0.1218 pd=1.42 ps=1.42 nrd=0.69047619047619  nrs=0.69047619047619 sa=0 sb=0 sd=0 mult=1 m=1
csn_op1_1000_rl_s0p1_r0_dm016p0_0 sn_op1_1000_rl_s0p1_r0_dm016p0_0 0 {C_SN}
XMWR_op1_1000_rl_s0p1_r0_dm016p0_1 sn_op1_1000_rl_s0p1_r0_dm016p0_1 wwl_des wbl_op1_1000_rl_s0p1_r0_dm016p0 0 sky130_fd_pr__nfet_01v8 L=0.15 W=0.42 nf=1 ad=0.1218 as=0.1218 pd=1.42 ps=1.42 nrd=0.69047619047619  nrs=0.69047619047619 sa=0 sb=0 sd=0 mult=1 m=1
XMRD_op1_1000_rl_s0p1_r0_dm016p0_1 rbl_op1_1000_rl_s0p1_r0_dm016p0 sn_op1_1000_rl_s0p1_r0_dm016p0_1 rwl_des 0 sky130_fd_pr__nfet_01v8 L=0.15 W=0.42 nf=1 ad=0.1218 as=0.1218 pd=1.42 ps=1.42 nrd=0.69047619047619  nrs=0.69047619047619 sa=0 sb=0 sd=0 mult=1 m=1
csn_op1_1000_rl_s0p1_r0_dm016p0_1 sn_op1_1000_rl_s0p1_r0_dm016p0_1 0 {C_SN}
XMWR_op1_1000_rl_s0p1_r0_dm016p0_2 sn_op1_1000_rl_s0p1_r0_dm016p0_2 wwl_des wbl_op1_1000_rl_s0p1_r0_dm016p0 0 sky130_fd_pr__nfet_01v8 L=0.15 W=0.42 nf=1 ad=0.1218 as=0.1218 pd=1.42 ps=1.42 nrd=0.69047619047619  nrs=0.69047619047619 sa=0 sb=0 sd=0 mult=1 m=1
XMRD_op1_1000_rl_s0p1_r0_dm016p0_2 rbl_op1_1000_rl_s0p1_r0_dm016p0 sn_op1_1000_rl_s0p1_r0_dm016p0_2 rwl_des 0 sky130_fd_pr__nfet_01v8 L=0.15 W=0.42 nf=1 ad=0.1218 as=0.1218 pd=1.42 ps=1.42 nrd=0.69047619047619  nrs=0.69047619047619 sa=0 sb=0 sd=0 mult=1 m=1
csn_op1_1000_rl_s0p1_r0_dm016p0_2 sn_op1_1000_rl_s0p1_r0_dm016p0_2 0 {C_SN}
XMWR_op1_1000_rl_s0p1_r0_dm016p0_3 sn_op1_1000_rl_s0p1_r0_dm016p0_3 wwl_des wbl_op1_1000_rl_s0p1_r0_dm016p0 0 sky130_fd_pr__nfet_01v8 L=0.15 W=0.42 nf=1 ad=0.1218 as=0.1218 pd=1.42 ps=1.42 nrd=0.69047619047619  nrs=0.69047619047619 sa=0 sb=0 sd=0 mult=1 m=1
XMRD_op1_1000_rl_s0p1_r0_dm016p0_3 rbl_op1_1000_rl_s0p1_r0_dm016p0 sn_op1_1000_rl_s0p1_r0_dm016p0_3 rwl_des 0 sky130_fd_pr__nfet_01v8 L=0.15 W=0.42 nf=1 ad=0.1218 as=0.1218 pd=1.42 ps=1.42 nrd=0.69047619047619  nrs=0.69047619047619 sa=0 sb=0 sd=0 mult=1 m=1
csn_op1_1000_rl_s0p1_r0_dm016p0_3 sn_op1_1000_rl_s0p1_r0_dm016p0_3 0 {C_SN}
XMN1_op1_1000_rl_s0p1_r0_dm016p0 rbl_op1_1000_rl_s0p1_r0_dm016p0 ref_op1_1000_rl_s0p1_r0_dm016p0 vn_op1_1000_rl_s0p1_r0_dm016p0 0 sky130_fd_pr__nfet_01v8 L=0.15 W=1 nf=1 ad=0.29 as=0.29 pd=2.58 ps=2.58 mult=1 m=1
XMN2_op1_1000_rl_s0p1_r0_dm016p0 ref_op1_1000_rl_s0p1_r0_dm016p0 rbl_op1_1000_rl_s0p1_r0_dm016p0 vn_op1_1000_rl_s0p1_r0_dm016p0 0 sky130_fd_pr__nfet_01v8 L=0.15 W=1 nf=1 ad=0.29 as=0.29 pd=2.58 ps=2.58 mult=1 m=1
XMP1_op1_1000_rl_s0p1_r0_dm016p0 rbl_op1_1000_rl_s0p1_r0_dm016p0 ref_op1_1000_rl_s0p1_r0_dm016p0 vp_op1_1000_rl_s0p1_r0_dm016p0 vdd sky130_fd_pr__pfet_01v8 L=0.15 W=2 nf=1 ad=0.58 as=0.58 pd=4.58 ps=4.58 mult=1 m=1
XMP2_op1_1000_rl_s0p1_r0_dm016p0 ref_op1_1000_rl_s0p1_r0_dm016p0 rbl_op1_1000_rl_s0p1_r0_dm016p0 vp_op1_1000_rl_s0p1_r0_dm016p0 vdd sky130_fd_pr__pfet_01v8 L=0.15 W=2 nf=1 ad=0.58 as=0.58 pd=4.58 ps=4.58 mult=1 m=1
XMNF_op1_1000_rl_s0p1_r0_dm016p0 vn_op1_1000_rl_s0p1_r0_dm016p0 en_op1_1000_rl_s0p1_r0_dm016p0 0 0 sky130_fd_pr__nfet_01v8 L=0.15 W=2 nf=1 ad=0.58 as=0.58 pd=4.58 ps=4.58 mult=1 m=1
XMPH_op1_1000_rl_s0p1_r0_dm016p0 vp_op1_1000_rl_s0p1_r0_dm016p0 enb_op1_1000_rl_s0p1_r0_dm016p0 vdd vdd sky130_fd_pr__pfet_01v8 L=0.15 W=4 nf=1 ad=1.16 as=1.16 pd=8.58 ps=8.58 mult=1 m=1
bd_op1_1000_rl_s0p1_r0_dm016p0 d_op1_1000_rl_s0p1_r0_dm016p0 0 v=v(rbl_op1_1000_rl_s0p1_r0_dm016p0)-v(ref_op1_1000_rl_s0p1_r0_dm016p0)

* ---- instance 223: op0_n100_rl_s0p1_r0_dm016p0 (variant rl_s0p1_r0_dm016p0; probe dec 11.9 ns, release 34 ns, meas 36 ns) ----
vctl_op0_n100_rl_s0p1_r0_dm016p0 ctl_op0_n100_rl_s0p1_r0_dm016p0 0 pwl(0.0000e+00 {VDD} 2.0000e-09 {VDD} 2.1000e-09 0)
* RWL driver model (EXPERIMENTAL): slew 0.1 ns, series R 0 ohm; cell pin = rwls_op0_n100_rl_s0p1_r0_dm016p0
vrs_op0_n100_rl_s0p1_r0_dm016p0 rwls_op0_n100_rl_s0p1_r0_dm016p0 0 pwl(0.0000e+00 {VDD} 2.0000e-09 {VDD} 2.1000e-09 0 1.6000e-08 0 1.6100e-08 {VDD})
ven_op0_n100_rl_s0p1_r0_dm016p0 en_op0_n100_rl_s0p1_r0_dm016p0 0 pwl(0.0000e+00 0 1.1000e-08 0 1.1100e-08 {VDD} 3.4000e-08 {VDD} 3.4100e-08 0)
venb_op0_n100_rl_s0p1_r0_dm016p0 enb_op0_n100_rl_s0p1_r0_dm016p0 0 pwl(0.0000e+00 {VDD} 1.1000e-08 {VDD} 1.1100e-08 0 3.4000e-08 0 3.4100e-08 {VDD})
vww_op0_n100_rl_s0p1_r0_dm016p0 wwl_op0_n100_rl_s0p1_r0_dm016p0 0 pwl(0.0000e+00 0 1.2000e-08 0 1.2100e-08 {VDD} 3.2000e-08 {VDD} 3.2100e-08 0)
vwc_op0_n100_rl_s0p1_r0_dm016p0 wbc_op0_n100_rl_s0p1_r0_dm016p0 0 pwl(0.0000e+00 0 1.2000e-08 0 1.2100e-08 {VDD} 3.4000e-08 {VDD} 3.4100e-08 0)
swb_op0_n100_rl_s0p1_r0_dm016p0 ref_op0_n100_rl_s0p1_r0_dm016p0 wbl_op0_n100_rl_s0p1_r0_dm016p0 wbc_op0_n100_rl_s0p1_r0_dm016p0 0 swwbl
cwbl_op0_n100_rl_s0p1_r0_dm016p0 wbl_op0_n100_rl_s0p1_r0_dm016p0 0 {C_WBL}
spa_op0_n100_rl_s0p1_r0_dm016p0 prea rbl_op0_n100_rl_s0p1_r0_dm016p0 ctl_op0_n100_rl_s0p1_r0_dm016p0 0 swpre
spr_op0_n100_rl_s0p1_r0_dm016p0 pref ref_op0_n100_rl_s0p1_r0_dm016p0 ctl_op0_n100_rl_s0p1_r0_dm016p0 0 swpre
crbl_op0_n100_rl_s0p1_r0_dm016p0 rbl_op0_n100_rl_s0p1_r0_dm016p0 0 {C_RBL}
cref_op0_n100_rl_s0p1_r0_dm016p0 ref_op0_n100_rl_s0p1_r0_dm016p0 0 {C_RBL}   $ ASSUMPTION: ideal matched dummy load
XMWR_op0_n100_rl_s0p1_r0_dm016p0_0 sn_op0_n100_rl_s0p1_r0_dm016p0_0 wwl_op0_n100_rl_s0p1_r0_dm016p0 wbl_op0_n100_rl_s0p1_r0_dm016p0 0 sky130_fd_pr__nfet_01v8 L=0.15 W=0.42 nf=1 ad=0.1218 as=0.1218 pd=1.42 ps=1.42 nrd=0.69047619047619  nrs=0.69047619047619 sa=0 sb=0 sd=0 mult=1 m=1
XMRD_op0_n100_rl_s0p1_r0_dm016p0_0 rbl_op0_n100_rl_s0p1_r0_dm016p0 sn_op0_n100_rl_s0p1_r0_dm016p0_0 rwls_op0_n100_rl_s0p1_r0_dm016p0 0 sky130_fd_pr__nfet_01v8 L=0.15 W=0.42 nf=1 ad=0.1218 as=0.1218 pd=1.42 ps=1.42 nrd=0.69047619047619  nrs=0.69047619047619 sa=0 sb=0 sd=0 mult=1 m=1
csn_op0_n100_rl_s0p1_r0_dm016p0_0 sn_op0_n100_rl_s0p1_r0_dm016p0_0 0 {C_SN}
XMWR_op0_n100_rl_s0p1_r0_dm016p0_1 sn_op0_n100_rl_s0p1_r0_dm016p0_1 wwl_des wbl_op0_n100_rl_s0p1_r0_dm016p0 0 sky130_fd_pr__nfet_01v8 L=0.15 W=0.42 nf=1 ad=0.1218 as=0.1218 pd=1.42 ps=1.42 nrd=0.69047619047619  nrs=0.69047619047619 sa=0 sb=0 sd=0 mult=1 m=1
XMRD_op0_n100_rl_s0p1_r0_dm016p0_1 rbl_op0_n100_rl_s0p1_r0_dm016p0 sn_op0_n100_rl_s0p1_r0_dm016p0_1 rwl_des 0 sky130_fd_pr__nfet_01v8 L=0.15 W=0.42 nf=1 ad=0.1218 as=0.1218 pd=1.42 ps=1.42 nrd=0.69047619047619  nrs=0.69047619047619 sa=0 sb=0 sd=0 mult=1 m=1
csn_op0_n100_rl_s0p1_r0_dm016p0_1 sn_op0_n100_rl_s0p1_r0_dm016p0_1 0 {C_SN}
XMWR_op0_n100_rl_s0p1_r0_dm016p0_2 sn_op0_n100_rl_s0p1_r0_dm016p0_2 wwl_des wbl_op0_n100_rl_s0p1_r0_dm016p0 0 sky130_fd_pr__nfet_01v8 L=0.15 W=0.42 nf=1 ad=0.1218 as=0.1218 pd=1.42 ps=1.42 nrd=0.69047619047619  nrs=0.69047619047619 sa=0 sb=0 sd=0 mult=1 m=1
XMRD_op0_n100_rl_s0p1_r0_dm016p0_2 rbl_op0_n100_rl_s0p1_r0_dm016p0 sn_op0_n100_rl_s0p1_r0_dm016p0_2 rwl_des 0 sky130_fd_pr__nfet_01v8 L=0.15 W=0.42 nf=1 ad=0.1218 as=0.1218 pd=1.42 ps=1.42 nrd=0.69047619047619  nrs=0.69047619047619 sa=0 sb=0 sd=0 mult=1 m=1
csn_op0_n100_rl_s0p1_r0_dm016p0_2 sn_op0_n100_rl_s0p1_r0_dm016p0_2 0 {C_SN}
XMWR_op0_n100_rl_s0p1_r0_dm016p0_3 sn_op0_n100_rl_s0p1_r0_dm016p0_3 wwl_des wbl_op0_n100_rl_s0p1_r0_dm016p0 0 sky130_fd_pr__nfet_01v8 L=0.15 W=0.42 nf=1 ad=0.1218 as=0.1218 pd=1.42 ps=1.42 nrd=0.69047619047619  nrs=0.69047619047619 sa=0 sb=0 sd=0 mult=1 m=1
XMRD_op0_n100_rl_s0p1_r0_dm016p0_3 rbl_op0_n100_rl_s0p1_r0_dm016p0 sn_op0_n100_rl_s0p1_r0_dm016p0_3 rwl_des 0 sky130_fd_pr__nfet_01v8 L=0.15 W=0.42 nf=1 ad=0.1218 as=0.1218 pd=1.42 ps=1.42 nrd=0.69047619047619  nrs=0.69047619047619 sa=0 sb=0 sd=0 mult=1 m=1
csn_op0_n100_rl_s0p1_r0_dm016p0_3 sn_op0_n100_rl_s0p1_r0_dm016p0_3 0 {C_SN}
XMN1_op0_n100_rl_s0p1_r0_dm016p0 rbl_op0_n100_rl_s0p1_r0_dm016p0 ref_op0_n100_rl_s0p1_r0_dm016p0 vn_op0_n100_rl_s0p1_r0_dm016p0 0 sky130_fd_pr__nfet_01v8 L=0.15 W=1 nf=1 ad=0.29 as=0.29 pd=2.58 ps=2.58 mult=1 m=1
XMN2_op0_n100_rl_s0p1_r0_dm016p0 ref_op0_n100_rl_s0p1_r0_dm016p0 rbl_op0_n100_rl_s0p1_r0_dm016p0 vn_op0_n100_rl_s0p1_r0_dm016p0 0 sky130_fd_pr__nfet_01v8 L=0.15 W=1 nf=1 ad=0.29 as=0.29 pd=2.58 ps=2.58 mult=1 m=1
XMP1_op0_n100_rl_s0p1_r0_dm016p0 rbl_op0_n100_rl_s0p1_r0_dm016p0 ref_op0_n100_rl_s0p1_r0_dm016p0 vp_op0_n100_rl_s0p1_r0_dm016p0 vdd sky130_fd_pr__pfet_01v8 L=0.15 W=2 nf=1 ad=0.58 as=0.58 pd=4.58 ps=4.58 mult=1 m=1
XMP2_op0_n100_rl_s0p1_r0_dm016p0 ref_op0_n100_rl_s0p1_r0_dm016p0 rbl_op0_n100_rl_s0p1_r0_dm016p0 vp_op0_n100_rl_s0p1_r0_dm016p0 vdd sky130_fd_pr__pfet_01v8 L=0.15 W=2 nf=1 ad=0.58 as=0.58 pd=4.58 ps=4.58 mult=1 m=1
XMNF_op0_n100_rl_s0p1_r0_dm016p0 vn_op0_n100_rl_s0p1_r0_dm016p0 en_op0_n100_rl_s0p1_r0_dm016p0 0 0 sky130_fd_pr__nfet_01v8 L=0.15 W=2 nf=1 ad=0.58 as=0.58 pd=4.58 ps=4.58 mult=1 m=1
XMPH_op0_n100_rl_s0p1_r0_dm016p0 vp_op0_n100_rl_s0p1_r0_dm016p0 enb_op0_n100_rl_s0p1_r0_dm016p0 vdd vdd sky130_fd_pr__pfet_01v8 L=0.15 W=4 nf=1 ad=1.16 as=1.16 pd=8.58 ps=8.58 mult=1 m=1
bd_op0_n100_rl_s0p1_r0_dm016p0 d_op0_n100_rl_s0p1_r0_dm016p0 0 v=v(rbl_op0_n100_rl_s0p1_r0_dm016p0)-v(ref_op0_n100_rl_s0p1_r0_dm016p0)

* ---- instance 224: op0_0000_rl_s0p1_r0_dm016p0 (variant rl_s0p1_r0_dm016p0; probe dec 11.9 ns, release 34 ns, meas 36 ns) ----
vctl_op0_0000_rl_s0p1_r0_dm016p0 ctl_op0_0000_rl_s0p1_r0_dm016p0 0 pwl(0.0000e+00 {VDD} 2.0000e-09 {VDD} 2.1000e-09 0)
* RWL driver model (EXPERIMENTAL): slew 0.1 ns, series R 0 ohm; cell pin = rwls_op0_0000_rl_s0p1_r0_dm016p0
vrs_op0_0000_rl_s0p1_r0_dm016p0 rwls_op0_0000_rl_s0p1_r0_dm016p0 0 pwl(0.0000e+00 {VDD} 2.0000e-09 {VDD} 2.1000e-09 0 1.6000e-08 0 1.6100e-08 {VDD})
ven_op0_0000_rl_s0p1_r0_dm016p0 en_op0_0000_rl_s0p1_r0_dm016p0 0 pwl(0.0000e+00 0 1.1000e-08 0 1.1100e-08 {VDD} 3.4000e-08 {VDD} 3.4100e-08 0)
venb_op0_0000_rl_s0p1_r0_dm016p0 enb_op0_0000_rl_s0p1_r0_dm016p0 0 pwl(0.0000e+00 {VDD} 1.1000e-08 {VDD} 1.1100e-08 0 3.4000e-08 0 3.4100e-08 {VDD})
vww_op0_0000_rl_s0p1_r0_dm016p0 wwl_op0_0000_rl_s0p1_r0_dm016p0 0 pwl(0.0000e+00 0 1.2000e-08 0 1.2100e-08 {VDD} 3.2000e-08 {VDD} 3.2100e-08 0)
vwc_op0_0000_rl_s0p1_r0_dm016p0 wbc_op0_0000_rl_s0p1_r0_dm016p0 0 pwl(0.0000e+00 0 1.2000e-08 0 1.2100e-08 {VDD} 3.4000e-08 {VDD} 3.4100e-08 0)
swb_op0_0000_rl_s0p1_r0_dm016p0 ref_op0_0000_rl_s0p1_r0_dm016p0 wbl_op0_0000_rl_s0p1_r0_dm016p0 wbc_op0_0000_rl_s0p1_r0_dm016p0 0 swwbl
cwbl_op0_0000_rl_s0p1_r0_dm016p0 wbl_op0_0000_rl_s0p1_r0_dm016p0 0 {C_WBL}
spa_op0_0000_rl_s0p1_r0_dm016p0 prea rbl_op0_0000_rl_s0p1_r0_dm016p0 ctl_op0_0000_rl_s0p1_r0_dm016p0 0 swpre
spr_op0_0000_rl_s0p1_r0_dm016p0 pref ref_op0_0000_rl_s0p1_r0_dm016p0 ctl_op0_0000_rl_s0p1_r0_dm016p0 0 swpre
crbl_op0_0000_rl_s0p1_r0_dm016p0 rbl_op0_0000_rl_s0p1_r0_dm016p0 0 {C_RBL}
cref_op0_0000_rl_s0p1_r0_dm016p0 ref_op0_0000_rl_s0p1_r0_dm016p0 0 {C_RBL}   $ ASSUMPTION: ideal matched dummy load
XMWR_op0_0000_rl_s0p1_r0_dm016p0_0 sn_op0_0000_rl_s0p1_r0_dm016p0_0 wwl_op0_0000_rl_s0p1_r0_dm016p0 wbl_op0_0000_rl_s0p1_r0_dm016p0 0 sky130_fd_pr__nfet_01v8 L=0.15 W=0.42 nf=1 ad=0.1218 as=0.1218 pd=1.42 ps=1.42 nrd=0.69047619047619  nrs=0.69047619047619 sa=0 sb=0 sd=0 mult=1 m=1
XMRD_op0_0000_rl_s0p1_r0_dm016p0_0 rbl_op0_0000_rl_s0p1_r0_dm016p0 sn_op0_0000_rl_s0p1_r0_dm016p0_0 rwls_op0_0000_rl_s0p1_r0_dm016p0 0 sky130_fd_pr__nfet_01v8 L=0.15 W=0.42 nf=1 ad=0.1218 as=0.1218 pd=1.42 ps=1.42 nrd=0.69047619047619  nrs=0.69047619047619 sa=0 sb=0 sd=0 mult=1 m=1
csn_op0_0000_rl_s0p1_r0_dm016p0_0 sn_op0_0000_rl_s0p1_r0_dm016p0_0 0 {C_SN}
XMWR_op0_0000_rl_s0p1_r0_dm016p0_1 sn_op0_0000_rl_s0p1_r0_dm016p0_1 wwl_des wbl_op0_0000_rl_s0p1_r0_dm016p0 0 sky130_fd_pr__nfet_01v8 L=0.15 W=0.42 nf=1 ad=0.1218 as=0.1218 pd=1.42 ps=1.42 nrd=0.69047619047619  nrs=0.69047619047619 sa=0 sb=0 sd=0 mult=1 m=1
XMRD_op0_0000_rl_s0p1_r0_dm016p0_1 rbl_op0_0000_rl_s0p1_r0_dm016p0 sn_op0_0000_rl_s0p1_r0_dm016p0_1 rwl_des 0 sky130_fd_pr__nfet_01v8 L=0.15 W=0.42 nf=1 ad=0.1218 as=0.1218 pd=1.42 ps=1.42 nrd=0.69047619047619  nrs=0.69047619047619 sa=0 sb=0 sd=0 mult=1 m=1
csn_op0_0000_rl_s0p1_r0_dm016p0_1 sn_op0_0000_rl_s0p1_r0_dm016p0_1 0 {C_SN}
XMWR_op0_0000_rl_s0p1_r0_dm016p0_2 sn_op0_0000_rl_s0p1_r0_dm016p0_2 wwl_des wbl_op0_0000_rl_s0p1_r0_dm016p0 0 sky130_fd_pr__nfet_01v8 L=0.15 W=0.42 nf=1 ad=0.1218 as=0.1218 pd=1.42 ps=1.42 nrd=0.69047619047619  nrs=0.69047619047619 sa=0 sb=0 sd=0 mult=1 m=1
XMRD_op0_0000_rl_s0p1_r0_dm016p0_2 rbl_op0_0000_rl_s0p1_r0_dm016p0 sn_op0_0000_rl_s0p1_r0_dm016p0_2 rwl_des 0 sky130_fd_pr__nfet_01v8 L=0.15 W=0.42 nf=1 ad=0.1218 as=0.1218 pd=1.42 ps=1.42 nrd=0.69047619047619  nrs=0.69047619047619 sa=0 sb=0 sd=0 mult=1 m=1
csn_op0_0000_rl_s0p1_r0_dm016p0_2 sn_op0_0000_rl_s0p1_r0_dm016p0_2 0 {C_SN}
XMWR_op0_0000_rl_s0p1_r0_dm016p0_3 sn_op0_0000_rl_s0p1_r0_dm016p0_3 wwl_des wbl_op0_0000_rl_s0p1_r0_dm016p0 0 sky130_fd_pr__nfet_01v8 L=0.15 W=0.42 nf=1 ad=0.1218 as=0.1218 pd=1.42 ps=1.42 nrd=0.69047619047619  nrs=0.69047619047619 sa=0 sb=0 sd=0 mult=1 m=1
XMRD_op0_0000_rl_s0p1_r0_dm016p0_3 rbl_op0_0000_rl_s0p1_r0_dm016p0 sn_op0_0000_rl_s0p1_r0_dm016p0_3 rwl_des 0 sky130_fd_pr__nfet_01v8 L=0.15 W=0.42 nf=1 ad=0.1218 as=0.1218 pd=1.42 ps=1.42 nrd=0.69047619047619  nrs=0.69047619047619 sa=0 sb=0 sd=0 mult=1 m=1
csn_op0_0000_rl_s0p1_r0_dm016p0_3 sn_op0_0000_rl_s0p1_r0_dm016p0_3 0 {C_SN}
XMN1_op0_0000_rl_s0p1_r0_dm016p0 rbl_op0_0000_rl_s0p1_r0_dm016p0 ref_op0_0000_rl_s0p1_r0_dm016p0 vn_op0_0000_rl_s0p1_r0_dm016p0 0 sky130_fd_pr__nfet_01v8 L=0.15 W=1 nf=1 ad=0.29 as=0.29 pd=2.58 ps=2.58 mult=1 m=1
XMN2_op0_0000_rl_s0p1_r0_dm016p0 ref_op0_0000_rl_s0p1_r0_dm016p0 rbl_op0_0000_rl_s0p1_r0_dm016p0 vn_op0_0000_rl_s0p1_r0_dm016p0 0 sky130_fd_pr__nfet_01v8 L=0.15 W=1 nf=1 ad=0.29 as=0.29 pd=2.58 ps=2.58 mult=1 m=1
XMP1_op0_0000_rl_s0p1_r0_dm016p0 rbl_op0_0000_rl_s0p1_r0_dm016p0 ref_op0_0000_rl_s0p1_r0_dm016p0 vp_op0_0000_rl_s0p1_r0_dm016p0 vdd sky130_fd_pr__pfet_01v8 L=0.15 W=2 nf=1 ad=0.58 as=0.58 pd=4.58 ps=4.58 mult=1 m=1
XMP2_op0_0000_rl_s0p1_r0_dm016p0 ref_op0_0000_rl_s0p1_r0_dm016p0 rbl_op0_0000_rl_s0p1_r0_dm016p0 vp_op0_0000_rl_s0p1_r0_dm016p0 vdd sky130_fd_pr__pfet_01v8 L=0.15 W=2 nf=1 ad=0.58 as=0.58 pd=4.58 ps=4.58 mult=1 m=1
XMNF_op0_0000_rl_s0p1_r0_dm016p0 vn_op0_0000_rl_s0p1_r0_dm016p0 en_op0_0000_rl_s0p1_r0_dm016p0 0 0 sky130_fd_pr__nfet_01v8 L=0.15 W=2 nf=1 ad=0.58 as=0.58 pd=4.58 ps=4.58 mult=1 m=1
XMPH_op0_0000_rl_s0p1_r0_dm016p0 vp_op0_0000_rl_s0p1_r0_dm016p0 enb_op0_0000_rl_s0p1_r0_dm016p0 vdd vdd sky130_fd_pr__pfet_01v8 L=0.15 W=4 nf=1 ad=1.16 as=1.16 pd=8.58 ps=8.58 mult=1 m=1
bd_op0_0000_rl_s0p1_r0_dm016p0 d_op0_0000_rl_s0p1_r0_dm016p0 0 v=v(rbl_op0_0000_rl_s0p1_r0_dm016p0)-v(ref_op0_0000_rl_s0p1_r0_dm016p0)

* ---- instance 225: op1_0900_rl_s0p1_r0_dm008p0 (variant rl_s0p1_r0_dm008p0; probe dec 11.9 ns, release 34 ns, meas 36 ns) ----
vctl_op1_0900_rl_s0p1_r0_dm008p0 ctl_op1_0900_rl_s0p1_r0_dm008p0 0 pwl(0.0000e+00 {VDD} 2.0000e-09 {VDD} 2.1000e-09 0)
* RWL driver model (EXPERIMENTAL): slew 0.1 ns, series R 0 ohm; cell pin = rwls_op1_0900_rl_s0p1_r0_dm008p0
vrs_op1_0900_rl_s0p1_r0_dm008p0 rwls_op1_0900_rl_s0p1_r0_dm008p0 0 pwl(0.0000e+00 {VDD} 2.0000e-09 {VDD} 2.1000e-09 0 2.4000e-08 0 2.4100e-08 {VDD})
ven_op1_0900_rl_s0p1_r0_dm008p0 en_op1_0900_rl_s0p1_r0_dm008p0 0 pwl(0.0000e+00 0 1.1000e-08 0 1.1100e-08 {VDD} 3.4000e-08 {VDD} 3.4100e-08 0)
venb_op1_0900_rl_s0p1_r0_dm008p0 enb_op1_0900_rl_s0p1_r0_dm008p0 0 pwl(0.0000e+00 {VDD} 1.1000e-08 {VDD} 1.1100e-08 0 3.4000e-08 0 3.4100e-08 {VDD})
vww_op1_0900_rl_s0p1_r0_dm008p0 wwl_op1_0900_rl_s0p1_r0_dm008p0 0 pwl(0.0000e+00 0 1.2000e-08 0 1.2100e-08 {VDD} 3.2000e-08 {VDD} 3.2100e-08 0)
vwc_op1_0900_rl_s0p1_r0_dm008p0 wbc_op1_0900_rl_s0p1_r0_dm008p0 0 pwl(0.0000e+00 0 1.2000e-08 0 1.2100e-08 {VDD} 3.4000e-08 {VDD} 3.4100e-08 0)
swb_op1_0900_rl_s0p1_r0_dm008p0 ref_op1_0900_rl_s0p1_r0_dm008p0 wbl_op1_0900_rl_s0p1_r0_dm008p0 wbc_op1_0900_rl_s0p1_r0_dm008p0 0 swwbl
cwbl_op1_0900_rl_s0p1_r0_dm008p0 wbl_op1_0900_rl_s0p1_r0_dm008p0 0 {C_WBL}
spa_op1_0900_rl_s0p1_r0_dm008p0 prea rbl_op1_0900_rl_s0p1_r0_dm008p0 ctl_op1_0900_rl_s0p1_r0_dm008p0 0 swpre
spr_op1_0900_rl_s0p1_r0_dm008p0 pref ref_op1_0900_rl_s0p1_r0_dm008p0 ctl_op1_0900_rl_s0p1_r0_dm008p0 0 swpre
crbl_op1_0900_rl_s0p1_r0_dm008p0 rbl_op1_0900_rl_s0p1_r0_dm008p0 0 {C_RBL}
cref_op1_0900_rl_s0p1_r0_dm008p0 ref_op1_0900_rl_s0p1_r0_dm008p0 0 {C_RBL}   $ ASSUMPTION: ideal matched dummy load
XMWR_op1_0900_rl_s0p1_r0_dm008p0_0 sn_op1_0900_rl_s0p1_r0_dm008p0_0 wwl_op1_0900_rl_s0p1_r0_dm008p0 wbl_op1_0900_rl_s0p1_r0_dm008p0 0 sky130_fd_pr__nfet_01v8 L=0.15 W=0.42 nf=1 ad=0.1218 as=0.1218 pd=1.42 ps=1.42 nrd=0.69047619047619  nrs=0.69047619047619 sa=0 sb=0 sd=0 mult=1 m=1
XMRD_op1_0900_rl_s0p1_r0_dm008p0_0 rbl_op1_0900_rl_s0p1_r0_dm008p0 sn_op1_0900_rl_s0p1_r0_dm008p0_0 rwls_op1_0900_rl_s0p1_r0_dm008p0 0 sky130_fd_pr__nfet_01v8 L=0.15 W=0.42 nf=1 ad=0.1218 as=0.1218 pd=1.42 ps=1.42 nrd=0.69047619047619  nrs=0.69047619047619 sa=0 sb=0 sd=0 mult=1 m=1
csn_op1_0900_rl_s0p1_r0_dm008p0_0 sn_op1_0900_rl_s0p1_r0_dm008p0_0 0 {C_SN}
XMWR_op1_0900_rl_s0p1_r0_dm008p0_1 sn_op1_0900_rl_s0p1_r0_dm008p0_1 wwl_des wbl_op1_0900_rl_s0p1_r0_dm008p0 0 sky130_fd_pr__nfet_01v8 L=0.15 W=0.42 nf=1 ad=0.1218 as=0.1218 pd=1.42 ps=1.42 nrd=0.69047619047619  nrs=0.69047619047619 sa=0 sb=0 sd=0 mult=1 m=1
XMRD_op1_0900_rl_s0p1_r0_dm008p0_1 rbl_op1_0900_rl_s0p1_r0_dm008p0 sn_op1_0900_rl_s0p1_r0_dm008p0_1 rwl_des 0 sky130_fd_pr__nfet_01v8 L=0.15 W=0.42 nf=1 ad=0.1218 as=0.1218 pd=1.42 ps=1.42 nrd=0.69047619047619  nrs=0.69047619047619 sa=0 sb=0 sd=0 mult=1 m=1
csn_op1_0900_rl_s0p1_r0_dm008p0_1 sn_op1_0900_rl_s0p1_r0_dm008p0_1 0 {C_SN}
XMWR_op1_0900_rl_s0p1_r0_dm008p0_2 sn_op1_0900_rl_s0p1_r0_dm008p0_2 wwl_des wbl_op1_0900_rl_s0p1_r0_dm008p0 0 sky130_fd_pr__nfet_01v8 L=0.15 W=0.42 nf=1 ad=0.1218 as=0.1218 pd=1.42 ps=1.42 nrd=0.69047619047619  nrs=0.69047619047619 sa=0 sb=0 sd=0 mult=1 m=1
XMRD_op1_0900_rl_s0p1_r0_dm008p0_2 rbl_op1_0900_rl_s0p1_r0_dm008p0 sn_op1_0900_rl_s0p1_r0_dm008p0_2 rwl_des 0 sky130_fd_pr__nfet_01v8 L=0.15 W=0.42 nf=1 ad=0.1218 as=0.1218 pd=1.42 ps=1.42 nrd=0.69047619047619  nrs=0.69047619047619 sa=0 sb=0 sd=0 mult=1 m=1
csn_op1_0900_rl_s0p1_r0_dm008p0_2 sn_op1_0900_rl_s0p1_r0_dm008p0_2 0 {C_SN}
XMWR_op1_0900_rl_s0p1_r0_dm008p0_3 sn_op1_0900_rl_s0p1_r0_dm008p0_3 wwl_des wbl_op1_0900_rl_s0p1_r0_dm008p0 0 sky130_fd_pr__nfet_01v8 L=0.15 W=0.42 nf=1 ad=0.1218 as=0.1218 pd=1.42 ps=1.42 nrd=0.69047619047619  nrs=0.69047619047619 sa=0 sb=0 sd=0 mult=1 m=1
XMRD_op1_0900_rl_s0p1_r0_dm008p0_3 rbl_op1_0900_rl_s0p1_r0_dm008p0 sn_op1_0900_rl_s0p1_r0_dm008p0_3 rwl_des 0 sky130_fd_pr__nfet_01v8 L=0.15 W=0.42 nf=1 ad=0.1218 as=0.1218 pd=1.42 ps=1.42 nrd=0.69047619047619  nrs=0.69047619047619 sa=0 sb=0 sd=0 mult=1 m=1
csn_op1_0900_rl_s0p1_r0_dm008p0_3 sn_op1_0900_rl_s0p1_r0_dm008p0_3 0 {C_SN}
XMN1_op1_0900_rl_s0p1_r0_dm008p0 rbl_op1_0900_rl_s0p1_r0_dm008p0 ref_op1_0900_rl_s0p1_r0_dm008p0 vn_op1_0900_rl_s0p1_r0_dm008p0 0 sky130_fd_pr__nfet_01v8 L=0.15 W=1 nf=1 ad=0.29 as=0.29 pd=2.58 ps=2.58 mult=1 m=1
XMN2_op1_0900_rl_s0p1_r0_dm008p0 ref_op1_0900_rl_s0p1_r0_dm008p0 rbl_op1_0900_rl_s0p1_r0_dm008p0 vn_op1_0900_rl_s0p1_r0_dm008p0 0 sky130_fd_pr__nfet_01v8 L=0.15 W=1 nf=1 ad=0.29 as=0.29 pd=2.58 ps=2.58 mult=1 m=1
XMP1_op1_0900_rl_s0p1_r0_dm008p0 rbl_op1_0900_rl_s0p1_r0_dm008p0 ref_op1_0900_rl_s0p1_r0_dm008p0 vp_op1_0900_rl_s0p1_r0_dm008p0 vdd sky130_fd_pr__pfet_01v8 L=0.15 W=2 nf=1 ad=0.58 as=0.58 pd=4.58 ps=4.58 mult=1 m=1
XMP2_op1_0900_rl_s0p1_r0_dm008p0 ref_op1_0900_rl_s0p1_r0_dm008p0 rbl_op1_0900_rl_s0p1_r0_dm008p0 vp_op1_0900_rl_s0p1_r0_dm008p0 vdd sky130_fd_pr__pfet_01v8 L=0.15 W=2 nf=1 ad=0.58 as=0.58 pd=4.58 ps=4.58 mult=1 m=1
XMNF_op1_0900_rl_s0p1_r0_dm008p0 vn_op1_0900_rl_s0p1_r0_dm008p0 en_op1_0900_rl_s0p1_r0_dm008p0 0 0 sky130_fd_pr__nfet_01v8 L=0.15 W=2 nf=1 ad=0.58 as=0.58 pd=4.58 ps=4.58 mult=1 m=1
XMPH_op1_0900_rl_s0p1_r0_dm008p0 vp_op1_0900_rl_s0p1_r0_dm008p0 enb_op1_0900_rl_s0p1_r0_dm008p0 vdd vdd sky130_fd_pr__pfet_01v8 L=0.15 W=4 nf=1 ad=1.16 as=1.16 pd=8.58 ps=8.58 mult=1 m=1
bd_op1_0900_rl_s0p1_r0_dm008p0 d_op1_0900_rl_s0p1_r0_dm008p0 0 v=v(rbl_op1_0900_rl_s0p1_r0_dm008p0)-v(ref_op1_0900_rl_s0p1_r0_dm008p0)

* ---- instance 226: op1_1000_rl_s0p1_r0_dm008p0 (variant rl_s0p1_r0_dm008p0; probe dec 11.9 ns, release 34 ns, meas 36 ns) ----
vctl_op1_1000_rl_s0p1_r0_dm008p0 ctl_op1_1000_rl_s0p1_r0_dm008p0 0 pwl(0.0000e+00 {VDD} 2.0000e-09 {VDD} 2.1000e-09 0)
* RWL driver model (EXPERIMENTAL): slew 0.1 ns, series R 0 ohm; cell pin = rwls_op1_1000_rl_s0p1_r0_dm008p0
vrs_op1_1000_rl_s0p1_r0_dm008p0 rwls_op1_1000_rl_s0p1_r0_dm008p0 0 pwl(0.0000e+00 {VDD} 2.0000e-09 {VDD} 2.1000e-09 0 2.4000e-08 0 2.4100e-08 {VDD})
ven_op1_1000_rl_s0p1_r0_dm008p0 en_op1_1000_rl_s0p1_r0_dm008p0 0 pwl(0.0000e+00 0 1.1000e-08 0 1.1100e-08 {VDD} 3.4000e-08 {VDD} 3.4100e-08 0)
venb_op1_1000_rl_s0p1_r0_dm008p0 enb_op1_1000_rl_s0p1_r0_dm008p0 0 pwl(0.0000e+00 {VDD} 1.1000e-08 {VDD} 1.1100e-08 0 3.4000e-08 0 3.4100e-08 {VDD})
vww_op1_1000_rl_s0p1_r0_dm008p0 wwl_op1_1000_rl_s0p1_r0_dm008p0 0 pwl(0.0000e+00 0 1.2000e-08 0 1.2100e-08 {VDD} 3.2000e-08 {VDD} 3.2100e-08 0)
vwc_op1_1000_rl_s0p1_r0_dm008p0 wbc_op1_1000_rl_s0p1_r0_dm008p0 0 pwl(0.0000e+00 0 1.2000e-08 0 1.2100e-08 {VDD} 3.4000e-08 {VDD} 3.4100e-08 0)
swb_op1_1000_rl_s0p1_r0_dm008p0 ref_op1_1000_rl_s0p1_r0_dm008p0 wbl_op1_1000_rl_s0p1_r0_dm008p0 wbc_op1_1000_rl_s0p1_r0_dm008p0 0 swwbl
cwbl_op1_1000_rl_s0p1_r0_dm008p0 wbl_op1_1000_rl_s0p1_r0_dm008p0 0 {C_WBL}
spa_op1_1000_rl_s0p1_r0_dm008p0 prea rbl_op1_1000_rl_s0p1_r0_dm008p0 ctl_op1_1000_rl_s0p1_r0_dm008p0 0 swpre
spr_op1_1000_rl_s0p1_r0_dm008p0 pref ref_op1_1000_rl_s0p1_r0_dm008p0 ctl_op1_1000_rl_s0p1_r0_dm008p0 0 swpre
crbl_op1_1000_rl_s0p1_r0_dm008p0 rbl_op1_1000_rl_s0p1_r0_dm008p0 0 {C_RBL}
cref_op1_1000_rl_s0p1_r0_dm008p0 ref_op1_1000_rl_s0p1_r0_dm008p0 0 {C_RBL}   $ ASSUMPTION: ideal matched dummy load
XMWR_op1_1000_rl_s0p1_r0_dm008p0_0 sn_op1_1000_rl_s0p1_r0_dm008p0_0 wwl_op1_1000_rl_s0p1_r0_dm008p0 wbl_op1_1000_rl_s0p1_r0_dm008p0 0 sky130_fd_pr__nfet_01v8 L=0.15 W=0.42 nf=1 ad=0.1218 as=0.1218 pd=1.42 ps=1.42 nrd=0.69047619047619  nrs=0.69047619047619 sa=0 sb=0 sd=0 mult=1 m=1
XMRD_op1_1000_rl_s0p1_r0_dm008p0_0 rbl_op1_1000_rl_s0p1_r0_dm008p0 sn_op1_1000_rl_s0p1_r0_dm008p0_0 rwls_op1_1000_rl_s0p1_r0_dm008p0 0 sky130_fd_pr__nfet_01v8 L=0.15 W=0.42 nf=1 ad=0.1218 as=0.1218 pd=1.42 ps=1.42 nrd=0.69047619047619  nrs=0.69047619047619 sa=0 sb=0 sd=0 mult=1 m=1
csn_op1_1000_rl_s0p1_r0_dm008p0_0 sn_op1_1000_rl_s0p1_r0_dm008p0_0 0 {C_SN}
XMWR_op1_1000_rl_s0p1_r0_dm008p0_1 sn_op1_1000_rl_s0p1_r0_dm008p0_1 wwl_des wbl_op1_1000_rl_s0p1_r0_dm008p0 0 sky130_fd_pr__nfet_01v8 L=0.15 W=0.42 nf=1 ad=0.1218 as=0.1218 pd=1.42 ps=1.42 nrd=0.69047619047619  nrs=0.69047619047619 sa=0 sb=0 sd=0 mult=1 m=1
XMRD_op1_1000_rl_s0p1_r0_dm008p0_1 rbl_op1_1000_rl_s0p1_r0_dm008p0 sn_op1_1000_rl_s0p1_r0_dm008p0_1 rwl_des 0 sky130_fd_pr__nfet_01v8 L=0.15 W=0.42 nf=1 ad=0.1218 as=0.1218 pd=1.42 ps=1.42 nrd=0.69047619047619  nrs=0.69047619047619 sa=0 sb=0 sd=0 mult=1 m=1
csn_op1_1000_rl_s0p1_r0_dm008p0_1 sn_op1_1000_rl_s0p1_r0_dm008p0_1 0 {C_SN}
XMWR_op1_1000_rl_s0p1_r0_dm008p0_2 sn_op1_1000_rl_s0p1_r0_dm008p0_2 wwl_des wbl_op1_1000_rl_s0p1_r0_dm008p0 0 sky130_fd_pr__nfet_01v8 L=0.15 W=0.42 nf=1 ad=0.1218 as=0.1218 pd=1.42 ps=1.42 nrd=0.69047619047619  nrs=0.69047619047619 sa=0 sb=0 sd=0 mult=1 m=1
XMRD_op1_1000_rl_s0p1_r0_dm008p0_2 rbl_op1_1000_rl_s0p1_r0_dm008p0 sn_op1_1000_rl_s0p1_r0_dm008p0_2 rwl_des 0 sky130_fd_pr__nfet_01v8 L=0.15 W=0.42 nf=1 ad=0.1218 as=0.1218 pd=1.42 ps=1.42 nrd=0.69047619047619  nrs=0.69047619047619 sa=0 sb=0 sd=0 mult=1 m=1
csn_op1_1000_rl_s0p1_r0_dm008p0_2 sn_op1_1000_rl_s0p1_r0_dm008p0_2 0 {C_SN}
XMWR_op1_1000_rl_s0p1_r0_dm008p0_3 sn_op1_1000_rl_s0p1_r0_dm008p0_3 wwl_des wbl_op1_1000_rl_s0p1_r0_dm008p0 0 sky130_fd_pr__nfet_01v8 L=0.15 W=0.42 nf=1 ad=0.1218 as=0.1218 pd=1.42 ps=1.42 nrd=0.69047619047619  nrs=0.69047619047619 sa=0 sb=0 sd=0 mult=1 m=1
XMRD_op1_1000_rl_s0p1_r0_dm008p0_3 rbl_op1_1000_rl_s0p1_r0_dm008p0 sn_op1_1000_rl_s0p1_r0_dm008p0_3 rwl_des 0 sky130_fd_pr__nfet_01v8 L=0.15 W=0.42 nf=1 ad=0.1218 as=0.1218 pd=1.42 ps=1.42 nrd=0.69047619047619  nrs=0.69047619047619 sa=0 sb=0 sd=0 mult=1 m=1
csn_op1_1000_rl_s0p1_r0_dm008p0_3 sn_op1_1000_rl_s0p1_r0_dm008p0_3 0 {C_SN}
XMN1_op1_1000_rl_s0p1_r0_dm008p0 rbl_op1_1000_rl_s0p1_r0_dm008p0 ref_op1_1000_rl_s0p1_r0_dm008p0 vn_op1_1000_rl_s0p1_r0_dm008p0 0 sky130_fd_pr__nfet_01v8 L=0.15 W=1 nf=1 ad=0.29 as=0.29 pd=2.58 ps=2.58 mult=1 m=1
XMN2_op1_1000_rl_s0p1_r0_dm008p0 ref_op1_1000_rl_s0p1_r0_dm008p0 rbl_op1_1000_rl_s0p1_r0_dm008p0 vn_op1_1000_rl_s0p1_r0_dm008p0 0 sky130_fd_pr__nfet_01v8 L=0.15 W=1 nf=1 ad=0.29 as=0.29 pd=2.58 ps=2.58 mult=1 m=1
XMP1_op1_1000_rl_s0p1_r0_dm008p0 rbl_op1_1000_rl_s0p1_r0_dm008p0 ref_op1_1000_rl_s0p1_r0_dm008p0 vp_op1_1000_rl_s0p1_r0_dm008p0 vdd sky130_fd_pr__pfet_01v8 L=0.15 W=2 nf=1 ad=0.58 as=0.58 pd=4.58 ps=4.58 mult=1 m=1
XMP2_op1_1000_rl_s0p1_r0_dm008p0 ref_op1_1000_rl_s0p1_r0_dm008p0 rbl_op1_1000_rl_s0p1_r0_dm008p0 vp_op1_1000_rl_s0p1_r0_dm008p0 vdd sky130_fd_pr__pfet_01v8 L=0.15 W=2 nf=1 ad=0.58 as=0.58 pd=4.58 ps=4.58 mult=1 m=1
XMNF_op1_1000_rl_s0p1_r0_dm008p0 vn_op1_1000_rl_s0p1_r0_dm008p0 en_op1_1000_rl_s0p1_r0_dm008p0 0 0 sky130_fd_pr__nfet_01v8 L=0.15 W=2 nf=1 ad=0.58 as=0.58 pd=4.58 ps=4.58 mult=1 m=1
XMPH_op1_1000_rl_s0p1_r0_dm008p0 vp_op1_1000_rl_s0p1_r0_dm008p0 enb_op1_1000_rl_s0p1_r0_dm008p0 vdd vdd sky130_fd_pr__pfet_01v8 L=0.15 W=4 nf=1 ad=1.16 as=1.16 pd=8.58 ps=8.58 mult=1 m=1
bd_op1_1000_rl_s0p1_r0_dm008p0 d_op1_1000_rl_s0p1_r0_dm008p0 0 v=v(rbl_op1_1000_rl_s0p1_r0_dm008p0)-v(ref_op1_1000_rl_s0p1_r0_dm008p0)

* ---- instance 227: op0_n100_rl_s0p1_r0_dm008p0 (variant rl_s0p1_r0_dm008p0; probe dec 11.9 ns, release 34 ns, meas 36 ns) ----
vctl_op0_n100_rl_s0p1_r0_dm008p0 ctl_op0_n100_rl_s0p1_r0_dm008p0 0 pwl(0.0000e+00 {VDD} 2.0000e-09 {VDD} 2.1000e-09 0)
* RWL driver model (EXPERIMENTAL): slew 0.1 ns, series R 0 ohm; cell pin = rwls_op0_n100_rl_s0p1_r0_dm008p0
vrs_op0_n100_rl_s0p1_r0_dm008p0 rwls_op0_n100_rl_s0p1_r0_dm008p0 0 pwl(0.0000e+00 {VDD} 2.0000e-09 {VDD} 2.1000e-09 0 2.4000e-08 0 2.4100e-08 {VDD})
ven_op0_n100_rl_s0p1_r0_dm008p0 en_op0_n100_rl_s0p1_r0_dm008p0 0 pwl(0.0000e+00 0 1.1000e-08 0 1.1100e-08 {VDD} 3.4000e-08 {VDD} 3.4100e-08 0)
venb_op0_n100_rl_s0p1_r0_dm008p0 enb_op0_n100_rl_s0p1_r0_dm008p0 0 pwl(0.0000e+00 {VDD} 1.1000e-08 {VDD} 1.1100e-08 0 3.4000e-08 0 3.4100e-08 {VDD})
vww_op0_n100_rl_s0p1_r0_dm008p0 wwl_op0_n100_rl_s0p1_r0_dm008p0 0 pwl(0.0000e+00 0 1.2000e-08 0 1.2100e-08 {VDD} 3.2000e-08 {VDD} 3.2100e-08 0)
vwc_op0_n100_rl_s0p1_r0_dm008p0 wbc_op0_n100_rl_s0p1_r0_dm008p0 0 pwl(0.0000e+00 0 1.2000e-08 0 1.2100e-08 {VDD} 3.4000e-08 {VDD} 3.4100e-08 0)
swb_op0_n100_rl_s0p1_r0_dm008p0 ref_op0_n100_rl_s0p1_r0_dm008p0 wbl_op0_n100_rl_s0p1_r0_dm008p0 wbc_op0_n100_rl_s0p1_r0_dm008p0 0 swwbl
cwbl_op0_n100_rl_s0p1_r0_dm008p0 wbl_op0_n100_rl_s0p1_r0_dm008p0 0 {C_WBL}
spa_op0_n100_rl_s0p1_r0_dm008p0 prea rbl_op0_n100_rl_s0p1_r0_dm008p0 ctl_op0_n100_rl_s0p1_r0_dm008p0 0 swpre
spr_op0_n100_rl_s0p1_r0_dm008p0 pref ref_op0_n100_rl_s0p1_r0_dm008p0 ctl_op0_n100_rl_s0p1_r0_dm008p0 0 swpre
crbl_op0_n100_rl_s0p1_r0_dm008p0 rbl_op0_n100_rl_s0p1_r0_dm008p0 0 {C_RBL}
cref_op0_n100_rl_s0p1_r0_dm008p0 ref_op0_n100_rl_s0p1_r0_dm008p0 0 {C_RBL}   $ ASSUMPTION: ideal matched dummy load
XMWR_op0_n100_rl_s0p1_r0_dm008p0_0 sn_op0_n100_rl_s0p1_r0_dm008p0_0 wwl_op0_n100_rl_s0p1_r0_dm008p0 wbl_op0_n100_rl_s0p1_r0_dm008p0 0 sky130_fd_pr__nfet_01v8 L=0.15 W=0.42 nf=1 ad=0.1218 as=0.1218 pd=1.42 ps=1.42 nrd=0.69047619047619  nrs=0.69047619047619 sa=0 sb=0 sd=0 mult=1 m=1
XMRD_op0_n100_rl_s0p1_r0_dm008p0_0 rbl_op0_n100_rl_s0p1_r0_dm008p0 sn_op0_n100_rl_s0p1_r0_dm008p0_0 rwls_op0_n100_rl_s0p1_r0_dm008p0 0 sky130_fd_pr__nfet_01v8 L=0.15 W=0.42 nf=1 ad=0.1218 as=0.1218 pd=1.42 ps=1.42 nrd=0.69047619047619  nrs=0.69047619047619 sa=0 sb=0 sd=0 mult=1 m=1
csn_op0_n100_rl_s0p1_r0_dm008p0_0 sn_op0_n100_rl_s0p1_r0_dm008p0_0 0 {C_SN}
XMWR_op0_n100_rl_s0p1_r0_dm008p0_1 sn_op0_n100_rl_s0p1_r0_dm008p0_1 wwl_des wbl_op0_n100_rl_s0p1_r0_dm008p0 0 sky130_fd_pr__nfet_01v8 L=0.15 W=0.42 nf=1 ad=0.1218 as=0.1218 pd=1.42 ps=1.42 nrd=0.69047619047619  nrs=0.69047619047619 sa=0 sb=0 sd=0 mult=1 m=1
XMRD_op0_n100_rl_s0p1_r0_dm008p0_1 rbl_op0_n100_rl_s0p1_r0_dm008p0 sn_op0_n100_rl_s0p1_r0_dm008p0_1 rwl_des 0 sky130_fd_pr__nfet_01v8 L=0.15 W=0.42 nf=1 ad=0.1218 as=0.1218 pd=1.42 ps=1.42 nrd=0.69047619047619  nrs=0.69047619047619 sa=0 sb=0 sd=0 mult=1 m=1
csn_op0_n100_rl_s0p1_r0_dm008p0_1 sn_op0_n100_rl_s0p1_r0_dm008p0_1 0 {C_SN}
XMWR_op0_n100_rl_s0p1_r0_dm008p0_2 sn_op0_n100_rl_s0p1_r0_dm008p0_2 wwl_des wbl_op0_n100_rl_s0p1_r0_dm008p0 0 sky130_fd_pr__nfet_01v8 L=0.15 W=0.42 nf=1 ad=0.1218 as=0.1218 pd=1.42 ps=1.42 nrd=0.69047619047619  nrs=0.69047619047619 sa=0 sb=0 sd=0 mult=1 m=1
XMRD_op0_n100_rl_s0p1_r0_dm008p0_2 rbl_op0_n100_rl_s0p1_r0_dm008p0 sn_op0_n100_rl_s0p1_r0_dm008p0_2 rwl_des 0 sky130_fd_pr__nfet_01v8 L=0.15 W=0.42 nf=1 ad=0.1218 as=0.1218 pd=1.42 ps=1.42 nrd=0.69047619047619  nrs=0.69047619047619 sa=0 sb=0 sd=0 mult=1 m=1
csn_op0_n100_rl_s0p1_r0_dm008p0_2 sn_op0_n100_rl_s0p1_r0_dm008p0_2 0 {C_SN}
XMWR_op0_n100_rl_s0p1_r0_dm008p0_3 sn_op0_n100_rl_s0p1_r0_dm008p0_3 wwl_des wbl_op0_n100_rl_s0p1_r0_dm008p0 0 sky130_fd_pr__nfet_01v8 L=0.15 W=0.42 nf=1 ad=0.1218 as=0.1218 pd=1.42 ps=1.42 nrd=0.69047619047619  nrs=0.69047619047619 sa=0 sb=0 sd=0 mult=1 m=1
XMRD_op0_n100_rl_s0p1_r0_dm008p0_3 rbl_op0_n100_rl_s0p1_r0_dm008p0 sn_op0_n100_rl_s0p1_r0_dm008p0_3 rwl_des 0 sky130_fd_pr__nfet_01v8 L=0.15 W=0.42 nf=1 ad=0.1218 as=0.1218 pd=1.42 ps=1.42 nrd=0.69047619047619  nrs=0.69047619047619 sa=0 sb=0 sd=0 mult=1 m=1
csn_op0_n100_rl_s0p1_r0_dm008p0_3 sn_op0_n100_rl_s0p1_r0_dm008p0_3 0 {C_SN}
XMN1_op0_n100_rl_s0p1_r0_dm008p0 rbl_op0_n100_rl_s0p1_r0_dm008p0 ref_op0_n100_rl_s0p1_r0_dm008p0 vn_op0_n100_rl_s0p1_r0_dm008p0 0 sky130_fd_pr__nfet_01v8 L=0.15 W=1 nf=1 ad=0.29 as=0.29 pd=2.58 ps=2.58 mult=1 m=1
XMN2_op0_n100_rl_s0p1_r0_dm008p0 ref_op0_n100_rl_s0p1_r0_dm008p0 rbl_op0_n100_rl_s0p1_r0_dm008p0 vn_op0_n100_rl_s0p1_r0_dm008p0 0 sky130_fd_pr__nfet_01v8 L=0.15 W=1 nf=1 ad=0.29 as=0.29 pd=2.58 ps=2.58 mult=1 m=1
XMP1_op0_n100_rl_s0p1_r0_dm008p0 rbl_op0_n100_rl_s0p1_r0_dm008p0 ref_op0_n100_rl_s0p1_r0_dm008p0 vp_op0_n100_rl_s0p1_r0_dm008p0 vdd sky130_fd_pr__pfet_01v8 L=0.15 W=2 nf=1 ad=0.58 as=0.58 pd=4.58 ps=4.58 mult=1 m=1
XMP2_op0_n100_rl_s0p1_r0_dm008p0 ref_op0_n100_rl_s0p1_r0_dm008p0 rbl_op0_n100_rl_s0p1_r0_dm008p0 vp_op0_n100_rl_s0p1_r0_dm008p0 vdd sky130_fd_pr__pfet_01v8 L=0.15 W=2 nf=1 ad=0.58 as=0.58 pd=4.58 ps=4.58 mult=1 m=1
XMNF_op0_n100_rl_s0p1_r0_dm008p0 vn_op0_n100_rl_s0p1_r0_dm008p0 en_op0_n100_rl_s0p1_r0_dm008p0 0 0 sky130_fd_pr__nfet_01v8 L=0.15 W=2 nf=1 ad=0.58 as=0.58 pd=4.58 ps=4.58 mult=1 m=1
XMPH_op0_n100_rl_s0p1_r0_dm008p0 vp_op0_n100_rl_s0p1_r0_dm008p0 enb_op0_n100_rl_s0p1_r0_dm008p0 vdd vdd sky130_fd_pr__pfet_01v8 L=0.15 W=4 nf=1 ad=1.16 as=1.16 pd=8.58 ps=8.58 mult=1 m=1
bd_op0_n100_rl_s0p1_r0_dm008p0 d_op0_n100_rl_s0p1_r0_dm008p0 0 v=v(rbl_op0_n100_rl_s0p1_r0_dm008p0)-v(ref_op0_n100_rl_s0p1_r0_dm008p0)

* ---- instance 228: op0_0000_rl_s0p1_r0_dm008p0 (variant rl_s0p1_r0_dm008p0; probe dec 11.9 ns, release 34 ns, meas 36 ns) ----
vctl_op0_0000_rl_s0p1_r0_dm008p0 ctl_op0_0000_rl_s0p1_r0_dm008p0 0 pwl(0.0000e+00 {VDD} 2.0000e-09 {VDD} 2.1000e-09 0)
* RWL driver model (EXPERIMENTAL): slew 0.1 ns, series R 0 ohm; cell pin = rwls_op0_0000_rl_s0p1_r0_dm008p0
vrs_op0_0000_rl_s0p1_r0_dm008p0 rwls_op0_0000_rl_s0p1_r0_dm008p0 0 pwl(0.0000e+00 {VDD} 2.0000e-09 {VDD} 2.1000e-09 0 2.4000e-08 0 2.4100e-08 {VDD})
ven_op0_0000_rl_s0p1_r0_dm008p0 en_op0_0000_rl_s0p1_r0_dm008p0 0 pwl(0.0000e+00 0 1.1000e-08 0 1.1100e-08 {VDD} 3.4000e-08 {VDD} 3.4100e-08 0)
venb_op0_0000_rl_s0p1_r0_dm008p0 enb_op0_0000_rl_s0p1_r0_dm008p0 0 pwl(0.0000e+00 {VDD} 1.1000e-08 {VDD} 1.1100e-08 0 3.4000e-08 0 3.4100e-08 {VDD})
vww_op0_0000_rl_s0p1_r0_dm008p0 wwl_op0_0000_rl_s0p1_r0_dm008p0 0 pwl(0.0000e+00 0 1.2000e-08 0 1.2100e-08 {VDD} 3.2000e-08 {VDD} 3.2100e-08 0)
vwc_op0_0000_rl_s0p1_r0_dm008p0 wbc_op0_0000_rl_s0p1_r0_dm008p0 0 pwl(0.0000e+00 0 1.2000e-08 0 1.2100e-08 {VDD} 3.4000e-08 {VDD} 3.4100e-08 0)
swb_op0_0000_rl_s0p1_r0_dm008p0 ref_op0_0000_rl_s0p1_r0_dm008p0 wbl_op0_0000_rl_s0p1_r0_dm008p0 wbc_op0_0000_rl_s0p1_r0_dm008p0 0 swwbl
cwbl_op0_0000_rl_s0p1_r0_dm008p0 wbl_op0_0000_rl_s0p1_r0_dm008p0 0 {C_WBL}
spa_op0_0000_rl_s0p1_r0_dm008p0 prea rbl_op0_0000_rl_s0p1_r0_dm008p0 ctl_op0_0000_rl_s0p1_r0_dm008p0 0 swpre
spr_op0_0000_rl_s0p1_r0_dm008p0 pref ref_op0_0000_rl_s0p1_r0_dm008p0 ctl_op0_0000_rl_s0p1_r0_dm008p0 0 swpre
crbl_op0_0000_rl_s0p1_r0_dm008p0 rbl_op0_0000_rl_s0p1_r0_dm008p0 0 {C_RBL}
cref_op0_0000_rl_s0p1_r0_dm008p0 ref_op0_0000_rl_s0p1_r0_dm008p0 0 {C_RBL}   $ ASSUMPTION: ideal matched dummy load
XMWR_op0_0000_rl_s0p1_r0_dm008p0_0 sn_op0_0000_rl_s0p1_r0_dm008p0_0 wwl_op0_0000_rl_s0p1_r0_dm008p0 wbl_op0_0000_rl_s0p1_r0_dm008p0 0 sky130_fd_pr__nfet_01v8 L=0.15 W=0.42 nf=1 ad=0.1218 as=0.1218 pd=1.42 ps=1.42 nrd=0.69047619047619  nrs=0.69047619047619 sa=0 sb=0 sd=0 mult=1 m=1
XMRD_op0_0000_rl_s0p1_r0_dm008p0_0 rbl_op0_0000_rl_s0p1_r0_dm008p0 sn_op0_0000_rl_s0p1_r0_dm008p0_0 rwls_op0_0000_rl_s0p1_r0_dm008p0 0 sky130_fd_pr__nfet_01v8 L=0.15 W=0.42 nf=1 ad=0.1218 as=0.1218 pd=1.42 ps=1.42 nrd=0.69047619047619  nrs=0.69047619047619 sa=0 sb=0 sd=0 mult=1 m=1
csn_op0_0000_rl_s0p1_r0_dm008p0_0 sn_op0_0000_rl_s0p1_r0_dm008p0_0 0 {C_SN}
XMWR_op0_0000_rl_s0p1_r0_dm008p0_1 sn_op0_0000_rl_s0p1_r0_dm008p0_1 wwl_des wbl_op0_0000_rl_s0p1_r0_dm008p0 0 sky130_fd_pr__nfet_01v8 L=0.15 W=0.42 nf=1 ad=0.1218 as=0.1218 pd=1.42 ps=1.42 nrd=0.69047619047619  nrs=0.69047619047619 sa=0 sb=0 sd=0 mult=1 m=1
XMRD_op0_0000_rl_s0p1_r0_dm008p0_1 rbl_op0_0000_rl_s0p1_r0_dm008p0 sn_op0_0000_rl_s0p1_r0_dm008p0_1 rwl_des 0 sky130_fd_pr__nfet_01v8 L=0.15 W=0.42 nf=1 ad=0.1218 as=0.1218 pd=1.42 ps=1.42 nrd=0.69047619047619  nrs=0.69047619047619 sa=0 sb=0 sd=0 mult=1 m=1
csn_op0_0000_rl_s0p1_r0_dm008p0_1 sn_op0_0000_rl_s0p1_r0_dm008p0_1 0 {C_SN}
XMWR_op0_0000_rl_s0p1_r0_dm008p0_2 sn_op0_0000_rl_s0p1_r0_dm008p0_2 wwl_des wbl_op0_0000_rl_s0p1_r0_dm008p0 0 sky130_fd_pr__nfet_01v8 L=0.15 W=0.42 nf=1 ad=0.1218 as=0.1218 pd=1.42 ps=1.42 nrd=0.69047619047619  nrs=0.69047619047619 sa=0 sb=0 sd=0 mult=1 m=1
XMRD_op0_0000_rl_s0p1_r0_dm008p0_2 rbl_op0_0000_rl_s0p1_r0_dm008p0 sn_op0_0000_rl_s0p1_r0_dm008p0_2 rwl_des 0 sky130_fd_pr__nfet_01v8 L=0.15 W=0.42 nf=1 ad=0.1218 as=0.1218 pd=1.42 ps=1.42 nrd=0.69047619047619  nrs=0.69047619047619 sa=0 sb=0 sd=0 mult=1 m=1
csn_op0_0000_rl_s0p1_r0_dm008p0_2 sn_op0_0000_rl_s0p1_r0_dm008p0_2 0 {C_SN}
XMWR_op0_0000_rl_s0p1_r0_dm008p0_3 sn_op0_0000_rl_s0p1_r0_dm008p0_3 wwl_des wbl_op0_0000_rl_s0p1_r0_dm008p0 0 sky130_fd_pr__nfet_01v8 L=0.15 W=0.42 nf=1 ad=0.1218 as=0.1218 pd=1.42 ps=1.42 nrd=0.69047619047619  nrs=0.69047619047619 sa=0 sb=0 sd=0 mult=1 m=1
XMRD_op0_0000_rl_s0p1_r0_dm008p0_3 rbl_op0_0000_rl_s0p1_r0_dm008p0 sn_op0_0000_rl_s0p1_r0_dm008p0_3 rwl_des 0 sky130_fd_pr__nfet_01v8 L=0.15 W=0.42 nf=1 ad=0.1218 as=0.1218 pd=1.42 ps=1.42 nrd=0.69047619047619  nrs=0.69047619047619 sa=0 sb=0 sd=0 mult=1 m=1
csn_op0_0000_rl_s0p1_r0_dm008p0_3 sn_op0_0000_rl_s0p1_r0_dm008p0_3 0 {C_SN}
XMN1_op0_0000_rl_s0p1_r0_dm008p0 rbl_op0_0000_rl_s0p1_r0_dm008p0 ref_op0_0000_rl_s0p1_r0_dm008p0 vn_op0_0000_rl_s0p1_r0_dm008p0 0 sky130_fd_pr__nfet_01v8 L=0.15 W=1 nf=1 ad=0.29 as=0.29 pd=2.58 ps=2.58 mult=1 m=1
XMN2_op0_0000_rl_s0p1_r0_dm008p0 ref_op0_0000_rl_s0p1_r0_dm008p0 rbl_op0_0000_rl_s0p1_r0_dm008p0 vn_op0_0000_rl_s0p1_r0_dm008p0 0 sky130_fd_pr__nfet_01v8 L=0.15 W=1 nf=1 ad=0.29 as=0.29 pd=2.58 ps=2.58 mult=1 m=1
XMP1_op0_0000_rl_s0p1_r0_dm008p0 rbl_op0_0000_rl_s0p1_r0_dm008p0 ref_op0_0000_rl_s0p1_r0_dm008p0 vp_op0_0000_rl_s0p1_r0_dm008p0 vdd sky130_fd_pr__pfet_01v8 L=0.15 W=2 nf=1 ad=0.58 as=0.58 pd=4.58 ps=4.58 mult=1 m=1
XMP2_op0_0000_rl_s0p1_r0_dm008p0 ref_op0_0000_rl_s0p1_r0_dm008p0 rbl_op0_0000_rl_s0p1_r0_dm008p0 vp_op0_0000_rl_s0p1_r0_dm008p0 vdd sky130_fd_pr__pfet_01v8 L=0.15 W=2 nf=1 ad=0.58 as=0.58 pd=4.58 ps=4.58 mult=1 m=1
XMNF_op0_0000_rl_s0p1_r0_dm008p0 vn_op0_0000_rl_s0p1_r0_dm008p0 en_op0_0000_rl_s0p1_r0_dm008p0 0 0 sky130_fd_pr__nfet_01v8 L=0.15 W=2 nf=1 ad=0.58 as=0.58 pd=4.58 ps=4.58 mult=1 m=1
XMPH_op0_0000_rl_s0p1_r0_dm008p0 vp_op0_0000_rl_s0p1_r0_dm008p0 enb_op0_0000_rl_s0p1_r0_dm008p0 vdd vdd sky130_fd_pr__pfet_01v8 L=0.15 W=4 nf=1 ad=1.16 as=1.16 pd=8.58 ps=8.58 mult=1 m=1
bd_op0_0000_rl_s0p1_r0_dm008p0 d_op0_0000_rl_s0p1_r0_dm008p0 0 v=v(rbl_op0_0000_rl_s0p1_r0_dm008p0)-v(ref_op0_0000_rl_s0p1_r0_dm008p0)

* ---- instance 229: op1_0900_rl_s0p1_r0_dm004p0 (variant rl_s0p1_r0_dm004p0; probe dec 11.9 ns, release 34 ns, meas 36 ns) ----
vctl_op1_0900_rl_s0p1_r0_dm004p0 ctl_op1_0900_rl_s0p1_r0_dm004p0 0 pwl(0.0000e+00 {VDD} 2.0000e-09 {VDD} 2.1000e-09 0)
* RWL driver model (EXPERIMENTAL): slew 0.1 ns, series R 0 ohm; cell pin = rwls_op1_0900_rl_s0p1_r0_dm004p0
vrs_op1_0900_rl_s0p1_r0_dm004p0 rwls_op1_0900_rl_s0p1_r0_dm004p0 0 pwl(0.0000e+00 {VDD} 2.0000e-09 {VDD} 2.1000e-09 0 2.8000e-08 0 2.8100e-08 {VDD})
ven_op1_0900_rl_s0p1_r0_dm004p0 en_op1_0900_rl_s0p1_r0_dm004p0 0 pwl(0.0000e+00 0 1.1000e-08 0 1.1100e-08 {VDD} 3.4000e-08 {VDD} 3.4100e-08 0)
venb_op1_0900_rl_s0p1_r0_dm004p0 enb_op1_0900_rl_s0p1_r0_dm004p0 0 pwl(0.0000e+00 {VDD} 1.1000e-08 {VDD} 1.1100e-08 0 3.4000e-08 0 3.4100e-08 {VDD})
vww_op1_0900_rl_s0p1_r0_dm004p0 wwl_op1_0900_rl_s0p1_r0_dm004p0 0 pwl(0.0000e+00 0 1.2000e-08 0 1.2100e-08 {VDD} 3.2000e-08 {VDD} 3.2100e-08 0)
vwc_op1_0900_rl_s0p1_r0_dm004p0 wbc_op1_0900_rl_s0p1_r0_dm004p0 0 pwl(0.0000e+00 0 1.2000e-08 0 1.2100e-08 {VDD} 3.4000e-08 {VDD} 3.4100e-08 0)
swb_op1_0900_rl_s0p1_r0_dm004p0 ref_op1_0900_rl_s0p1_r0_dm004p0 wbl_op1_0900_rl_s0p1_r0_dm004p0 wbc_op1_0900_rl_s0p1_r0_dm004p0 0 swwbl
cwbl_op1_0900_rl_s0p1_r0_dm004p0 wbl_op1_0900_rl_s0p1_r0_dm004p0 0 {C_WBL}
spa_op1_0900_rl_s0p1_r0_dm004p0 prea rbl_op1_0900_rl_s0p1_r0_dm004p0 ctl_op1_0900_rl_s0p1_r0_dm004p0 0 swpre
spr_op1_0900_rl_s0p1_r0_dm004p0 pref ref_op1_0900_rl_s0p1_r0_dm004p0 ctl_op1_0900_rl_s0p1_r0_dm004p0 0 swpre
crbl_op1_0900_rl_s0p1_r0_dm004p0 rbl_op1_0900_rl_s0p1_r0_dm004p0 0 {C_RBL}
cref_op1_0900_rl_s0p1_r0_dm004p0 ref_op1_0900_rl_s0p1_r0_dm004p0 0 {C_RBL}   $ ASSUMPTION: ideal matched dummy load
XMWR_op1_0900_rl_s0p1_r0_dm004p0_0 sn_op1_0900_rl_s0p1_r0_dm004p0_0 wwl_op1_0900_rl_s0p1_r0_dm004p0 wbl_op1_0900_rl_s0p1_r0_dm004p0 0 sky130_fd_pr__nfet_01v8 L=0.15 W=0.42 nf=1 ad=0.1218 as=0.1218 pd=1.42 ps=1.42 nrd=0.69047619047619  nrs=0.69047619047619 sa=0 sb=0 sd=0 mult=1 m=1
XMRD_op1_0900_rl_s0p1_r0_dm004p0_0 rbl_op1_0900_rl_s0p1_r0_dm004p0 sn_op1_0900_rl_s0p1_r0_dm004p0_0 rwls_op1_0900_rl_s0p1_r0_dm004p0 0 sky130_fd_pr__nfet_01v8 L=0.15 W=0.42 nf=1 ad=0.1218 as=0.1218 pd=1.42 ps=1.42 nrd=0.69047619047619  nrs=0.69047619047619 sa=0 sb=0 sd=0 mult=1 m=1
csn_op1_0900_rl_s0p1_r0_dm004p0_0 sn_op1_0900_rl_s0p1_r0_dm004p0_0 0 {C_SN}
XMWR_op1_0900_rl_s0p1_r0_dm004p0_1 sn_op1_0900_rl_s0p1_r0_dm004p0_1 wwl_des wbl_op1_0900_rl_s0p1_r0_dm004p0 0 sky130_fd_pr__nfet_01v8 L=0.15 W=0.42 nf=1 ad=0.1218 as=0.1218 pd=1.42 ps=1.42 nrd=0.69047619047619  nrs=0.69047619047619 sa=0 sb=0 sd=0 mult=1 m=1
XMRD_op1_0900_rl_s0p1_r0_dm004p0_1 rbl_op1_0900_rl_s0p1_r0_dm004p0 sn_op1_0900_rl_s0p1_r0_dm004p0_1 rwl_des 0 sky130_fd_pr__nfet_01v8 L=0.15 W=0.42 nf=1 ad=0.1218 as=0.1218 pd=1.42 ps=1.42 nrd=0.69047619047619  nrs=0.69047619047619 sa=0 sb=0 sd=0 mult=1 m=1
csn_op1_0900_rl_s0p1_r0_dm004p0_1 sn_op1_0900_rl_s0p1_r0_dm004p0_1 0 {C_SN}
XMWR_op1_0900_rl_s0p1_r0_dm004p0_2 sn_op1_0900_rl_s0p1_r0_dm004p0_2 wwl_des wbl_op1_0900_rl_s0p1_r0_dm004p0 0 sky130_fd_pr__nfet_01v8 L=0.15 W=0.42 nf=1 ad=0.1218 as=0.1218 pd=1.42 ps=1.42 nrd=0.69047619047619  nrs=0.69047619047619 sa=0 sb=0 sd=0 mult=1 m=1
XMRD_op1_0900_rl_s0p1_r0_dm004p0_2 rbl_op1_0900_rl_s0p1_r0_dm004p0 sn_op1_0900_rl_s0p1_r0_dm004p0_2 rwl_des 0 sky130_fd_pr__nfet_01v8 L=0.15 W=0.42 nf=1 ad=0.1218 as=0.1218 pd=1.42 ps=1.42 nrd=0.69047619047619  nrs=0.69047619047619 sa=0 sb=0 sd=0 mult=1 m=1
csn_op1_0900_rl_s0p1_r0_dm004p0_2 sn_op1_0900_rl_s0p1_r0_dm004p0_2 0 {C_SN}
XMWR_op1_0900_rl_s0p1_r0_dm004p0_3 sn_op1_0900_rl_s0p1_r0_dm004p0_3 wwl_des wbl_op1_0900_rl_s0p1_r0_dm004p0 0 sky130_fd_pr__nfet_01v8 L=0.15 W=0.42 nf=1 ad=0.1218 as=0.1218 pd=1.42 ps=1.42 nrd=0.69047619047619  nrs=0.69047619047619 sa=0 sb=0 sd=0 mult=1 m=1
XMRD_op1_0900_rl_s0p1_r0_dm004p0_3 rbl_op1_0900_rl_s0p1_r0_dm004p0 sn_op1_0900_rl_s0p1_r0_dm004p0_3 rwl_des 0 sky130_fd_pr__nfet_01v8 L=0.15 W=0.42 nf=1 ad=0.1218 as=0.1218 pd=1.42 ps=1.42 nrd=0.69047619047619  nrs=0.69047619047619 sa=0 sb=0 sd=0 mult=1 m=1
csn_op1_0900_rl_s0p1_r0_dm004p0_3 sn_op1_0900_rl_s0p1_r0_dm004p0_3 0 {C_SN}
XMN1_op1_0900_rl_s0p1_r0_dm004p0 rbl_op1_0900_rl_s0p1_r0_dm004p0 ref_op1_0900_rl_s0p1_r0_dm004p0 vn_op1_0900_rl_s0p1_r0_dm004p0 0 sky130_fd_pr__nfet_01v8 L=0.15 W=1 nf=1 ad=0.29 as=0.29 pd=2.58 ps=2.58 mult=1 m=1
XMN2_op1_0900_rl_s0p1_r0_dm004p0 ref_op1_0900_rl_s0p1_r0_dm004p0 rbl_op1_0900_rl_s0p1_r0_dm004p0 vn_op1_0900_rl_s0p1_r0_dm004p0 0 sky130_fd_pr__nfet_01v8 L=0.15 W=1 nf=1 ad=0.29 as=0.29 pd=2.58 ps=2.58 mult=1 m=1
XMP1_op1_0900_rl_s0p1_r0_dm004p0 rbl_op1_0900_rl_s0p1_r0_dm004p0 ref_op1_0900_rl_s0p1_r0_dm004p0 vp_op1_0900_rl_s0p1_r0_dm004p0 vdd sky130_fd_pr__pfet_01v8 L=0.15 W=2 nf=1 ad=0.58 as=0.58 pd=4.58 ps=4.58 mult=1 m=1
XMP2_op1_0900_rl_s0p1_r0_dm004p0 ref_op1_0900_rl_s0p1_r0_dm004p0 rbl_op1_0900_rl_s0p1_r0_dm004p0 vp_op1_0900_rl_s0p1_r0_dm004p0 vdd sky130_fd_pr__pfet_01v8 L=0.15 W=2 nf=1 ad=0.58 as=0.58 pd=4.58 ps=4.58 mult=1 m=1
XMNF_op1_0900_rl_s0p1_r0_dm004p0 vn_op1_0900_rl_s0p1_r0_dm004p0 en_op1_0900_rl_s0p1_r0_dm004p0 0 0 sky130_fd_pr__nfet_01v8 L=0.15 W=2 nf=1 ad=0.58 as=0.58 pd=4.58 ps=4.58 mult=1 m=1
XMPH_op1_0900_rl_s0p1_r0_dm004p0 vp_op1_0900_rl_s0p1_r0_dm004p0 enb_op1_0900_rl_s0p1_r0_dm004p0 vdd vdd sky130_fd_pr__pfet_01v8 L=0.15 W=4 nf=1 ad=1.16 as=1.16 pd=8.58 ps=8.58 mult=1 m=1
bd_op1_0900_rl_s0p1_r0_dm004p0 d_op1_0900_rl_s0p1_r0_dm004p0 0 v=v(rbl_op1_0900_rl_s0p1_r0_dm004p0)-v(ref_op1_0900_rl_s0p1_r0_dm004p0)

* ---- instance 230: op1_1000_rl_s0p1_r0_dm004p0 (variant rl_s0p1_r0_dm004p0; probe dec 11.9 ns, release 34 ns, meas 36 ns) ----
vctl_op1_1000_rl_s0p1_r0_dm004p0 ctl_op1_1000_rl_s0p1_r0_dm004p0 0 pwl(0.0000e+00 {VDD} 2.0000e-09 {VDD} 2.1000e-09 0)
* RWL driver model (EXPERIMENTAL): slew 0.1 ns, series R 0 ohm; cell pin = rwls_op1_1000_rl_s0p1_r0_dm004p0
vrs_op1_1000_rl_s0p1_r0_dm004p0 rwls_op1_1000_rl_s0p1_r0_dm004p0 0 pwl(0.0000e+00 {VDD} 2.0000e-09 {VDD} 2.1000e-09 0 2.8000e-08 0 2.8100e-08 {VDD})
ven_op1_1000_rl_s0p1_r0_dm004p0 en_op1_1000_rl_s0p1_r0_dm004p0 0 pwl(0.0000e+00 0 1.1000e-08 0 1.1100e-08 {VDD} 3.4000e-08 {VDD} 3.4100e-08 0)
venb_op1_1000_rl_s0p1_r0_dm004p0 enb_op1_1000_rl_s0p1_r0_dm004p0 0 pwl(0.0000e+00 {VDD} 1.1000e-08 {VDD} 1.1100e-08 0 3.4000e-08 0 3.4100e-08 {VDD})
vww_op1_1000_rl_s0p1_r0_dm004p0 wwl_op1_1000_rl_s0p1_r0_dm004p0 0 pwl(0.0000e+00 0 1.2000e-08 0 1.2100e-08 {VDD} 3.2000e-08 {VDD} 3.2100e-08 0)
vwc_op1_1000_rl_s0p1_r0_dm004p0 wbc_op1_1000_rl_s0p1_r0_dm004p0 0 pwl(0.0000e+00 0 1.2000e-08 0 1.2100e-08 {VDD} 3.4000e-08 {VDD} 3.4100e-08 0)
swb_op1_1000_rl_s0p1_r0_dm004p0 ref_op1_1000_rl_s0p1_r0_dm004p0 wbl_op1_1000_rl_s0p1_r0_dm004p0 wbc_op1_1000_rl_s0p1_r0_dm004p0 0 swwbl
cwbl_op1_1000_rl_s0p1_r0_dm004p0 wbl_op1_1000_rl_s0p1_r0_dm004p0 0 {C_WBL}
spa_op1_1000_rl_s0p1_r0_dm004p0 prea rbl_op1_1000_rl_s0p1_r0_dm004p0 ctl_op1_1000_rl_s0p1_r0_dm004p0 0 swpre
spr_op1_1000_rl_s0p1_r0_dm004p0 pref ref_op1_1000_rl_s0p1_r0_dm004p0 ctl_op1_1000_rl_s0p1_r0_dm004p0 0 swpre
crbl_op1_1000_rl_s0p1_r0_dm004p0 rbl_op1_1000_rl_s0p1_r0_dm004p0 0 {C_RBL}
cref_op1_1000_rl_s0p1_r0_dm004p0 ref_op1_1000_rl_s0p1_r0_dm004p0 0 {C_RBL}   $ ASSUMPTION: ideal matched dummy load
XMWR_op1_1000_rl_s0p1_r0_dm004p0_0 sn_op1_1000_rl_s0p1_r0_dm004p0_0 wwl_op1_1000_rl_s0p1_r0_dm004p0 wbl_op1_1000_rl_s0p1_r0_dm004p0 0 sky130_fd_pr__nfet_01v8 L=0.15 W=0.42 nf=1 ad=0.1218 as=0.1218 pd=1.42 ps=1.42 nrd=0.69047619047619  nrs=0.69047619047619 sa=0 sb=0 sd=0 mult=1 m=1
XMRD_op1_1000_rl_s0p1_r0_dm004p0_0 rbl_op1_1000_rl_s0p1_r0_dm004p0 sn_op1_1000_rl_s0p1_r0_dm004p0_0 rwls_op1_1000_rl_s0p1_r0_dm004p0 0 sky130_fd_pr__nfet_01v8 L=0.15 W=0.42 nf=1 ad=0.1218 as=0.1218 pd=1.42 ps=1.42 nrd=0.69047619047619  nrs=0.69047619047619 sa=0 sb=0 sd=0 mult=1 m=1
csn_op1_1000_rl_s0p1_r0_dm004p0_0 sn_op1_1000_rl_s0p1_r0_dm004p0_0 0 {C_SN}
XMWR_op1_1000_rl_s0p1_r0_dm004p0_1 sn_op1_1000_rl_s0p1_r0_dm004p0_1 wwl_des wbl_op1_1000_rl_s0p1_r0_dm004p0 0 sky130_fd_pr__nfet_01v8 L=0.15 W=0.42 nf=1 ad=0.1218 as=0.1218 pd=1.42 ps=1.42 nrd=0.69047619047619  nrs=0.69047619047619 sa=0 sb=0 sd=0 mult=1 m=1
XMRD_op1_1000_rl_s0p1_r0_dm004p0_1 rbl_op1_1000_rl_s0p1_r0_dm004p0 sn_op1_1000_rl_s0p1_r0_dm004p0_1 rwl_des 0 sky130_fd_pr__nfet_01v8 L=0.15 W=0.42 nf=1 ad=0.1218 as=0.1218 pd=1.42 ps=1.42 nrd=0.69047619047619  nrs=0.69047619047619 sa=0 sb=0 sd=0 mult=1 m=1
csn_op1_1000_rl_s0p1_r0_dm004p0_1 sn_op1_1000_rl_s0p1_r0_dm004p0_1 0 {C_SN}
XMWR_op1_1000_rl_s0p1_r0_dm004p0_2 sn_op1_1000_rl_s0p1_r0_dm004p0_2 wwl_des wbl_op1_1000_rl_s0p1_r0_dm004p0 0 sky130_fd_pr__nfet_01v8 L=0.15 W=0.42 nf=1 ad=0.1218 as=0.1218 pd=1.42 ps=1.42 nrd=0.69047619047619  nrs=0.69047619047619 sa=0 sb=0 sd=0 mult=1 m=1
XMRD_op1_1000_rl_s0p1_r0_dm004p0_2 rbl_op1_1000_rl_s0p1_r0_dm004p0 sn_op1_1000_rl_s0p1_r0_dm004p0_2 rwl_des 0 sky130_fd_pr__nfet_01v8 L=0.15 W=0.42 nf=1 ad=0.1218 as=0.1218 pd=1.42 ps=1.42 nrd=0.69047619047619  nrs=0.69047619047619 sa=0 sb=0 sd=0 mult=1 m=1
csn_op1_1000_rl_s0p1_r0_dm004p0_2 sn_op1_1000_rl_s0p1_r0_dm004p0_2 0 {C_SN}
XMWR_op1_1000_rl_s0p1_r0_dm004p0_3 sn_op1_1000_rl_s0p1_r0_dm004p0_3 wwl_des wbl_op1_1000_rl_s0p1_r0_dm004p0 0 sky130_fd_pr__nfet_01v8 L=0.15 W=0.42 nf=1 ad=0.1218 as=0.1218 pd=1.42 ps=1.42 nrd=0.69047619047619  nrs=0.69047619047619 sa=0 sb=0 sd=0 mult=1 m=1
XMRD_op1_1000_rl_s0p1_r0_dm004p0_3 rbl_op1_1000_rl_s0p1_r0_dm004p0 sn_op1_1000_rl_s0p1_r0_dm004p0_3 rwl_des 0 sky130_fd_pr__nfet_01v8 L=0.15 W=0.42 nf=1 ad=0.1218 as=0.1218 pd=1.42 ps=1.42 nrd=0.69047619047619  nrs=0.69047619047619 sa=0 sb=0 sd=0 mult=1 m=1
csn_op1_1000_rl_s0p1_r0_dm004p0_3 sn_op1_1000_rl_s0p1_r0_dm004p0_3 0 {C_SN}
XMN1_op1_1000_rl_s0p1_r0_dm004p0 rbl_op1_1000_rl_s0p1_r0_dm004p0 ref_op1_1000_rl_s0p1_r0_dm004p0 vn_op1_1000_rl_s0p1_r0_dm004p0 0 sky130_fd_pr__nfet_01v8 L=0.15 W=1 nf=1 ad=0.29 as=0.29 pd=2.58 ps=2.58 mult=1 m=1
XMN2_op1_1000_rl_s0p1_r0_dm004p0 ref_op1_1000_rl_s0p1_r0_dm004p0 rbl_op1_1000_rl_s0p1_r0_dm004p0 vn_op1_1000_rl_s0p1_r0_dm004p0 0 sky130_fd_pr__nfet_01v8 L=0.15 W=1 nf=1 ad=0.29 as=0.29 pd=2.58 ps=2.58 mult=1 m=1
XMP1_op1_1000_rl_s0p1_r0_dm004p0 rbl_op1_1000_rl_s0p1_r0_dm004p0 ref_op1_1000_rl_s0p1_r0_dm004p0 vp_op1_1000_rl_s0p1_r0_dm004p0 vdd sky130_fd_pr__pfet_01v8 L=0.15 W=2 nf=1 ad=0.58 as=0.58 pd=4.58 ps=4.58 mult=1 m=1
XMP2_op1_1000_rl_s0p1_r0_dm004p0 ref_op1_1000_rl_s0p1_r0_dm004p0 rbl_op1_1000_rl_s0p1_r0_dm004p0 vp_op1_1000_rl_s0p1_r0_dm004p0 vdd sky130_fd_pr__pfet_01v8 L=0.15 W=2 nf=1 ad=0.58 as=0.58 pd=4.58 ps=4.58 mult=1 m=1
XMNF_op1_1000_rl_s0p1_r0_dm004p0 vn_op1_1000_rl_s0p1_r0_dm004p0 en_op1_1000_rl_s0p1_r0_dm004p0 0 0 sky130_fd_pr__nfet_01v8 L=0.15 W=2 nf=1 ad=0.58 as=0.58 pd=4.58 ps=4.58 mult=1 m=1
XMPH_op1_1000_rl_s0p1_r0_dm004p0 vp_op1_1000_rl_s0p1_r0_dm004p0 enb_op1_1000_rl_s0p1_r0_dm004p0 vdd vdd sky130_fd_pr__pfet_01v8 L=0.15 W=4 nf=1 ad=1.16 as=1.16 pd=8.58 ps=8.58 mult=1 m=1
bd_op1_1000_rl_s0p1_r0_dm004p0 d_op1_1000_rl_s0p1_r0_dm004p0 0 v=v(rbl_op1_1000_rl_s0p1_r0_dm004p0)-v(ref_op1_1000_rl_s0p1_r0_dm004p0)

* ---- instance 231: op0_n100_rl_s0p1_r0_dm004p0 (variant rl_s0p1_r0_dm004p0; probe dec 11.9 ns, release 34 ns, meas 36 ns) ----
vctl_op0_n100_rl_s0p1_r0_dm004p0 ctl_op0_n100_rl_s0p1_r0_dm004p0 0 pwl(0.0000e+00 {VDD} 2.0000e-09 {VDD} 2.1000e-09 0)
* RWL driver model (EXPERIMENTAL): slew 0.1 ns, series R 0 ohm; cell pin = rwls_op0_n100_rl_s0p1_r0_dm004p0
vrs_op0_n100_rl_s0p1_r0_dm004p0 rwls_op0_n100_rl_s0p1_r0_dm004p0 0 pwl(0.0000e+00 {VDD} 2.0000e-09 {VDD} 2.1000e-09 0 2.8000e-08 0 2.8100e-08 {VDD})
ven_op0_n100_rl_s0p1_r0_dm004p0 en_op0_n100_rl_s0p1_r0_dm004p0 0 pwl(0.0000e+00 0 1.1000e-08 0 1.1100e-08 {VDD} 3.4000e-08 {VDD} 3.4100e-08 0)
venb_op0_n100_rl_s0p1_r0_dm004p0 enb_op0_n100_rl_s0p1_r0_dm004p0 0 pwl(0.0000e+00 {VDD} 1.1000e-08 {VDD} 1.1100e-08 0 3.4000e-08 0 3.4100e-08 {VDD})
vww_op0_n100_rl_s0p1_r0_dm004p0 wwl_op0_n100_rl_s0p1_r0_dm004p0 0 pwl(0.0000e+00 0 1.2000e-08 0 1.2100e-08 {VDD} 3.2000e-08 {VDD} 3.2100e-08 0)
vwc_op0_n100_rl_s0p1_r0_dm004p0 wbc_op0_n100_rl_s0p1_r0_dm004p0 0 pwl(0.0000e+00 0 1.2000e-08 0 1.2100e-08 {VDD} 3.4000e-08 {VDD} 3.4100e-08 0)
swb_op0_n100_rl_s0p1_r0_dm004p0 ref_op0_n100_rl_s0p1_r0_dm004p0 wbl_op0_n100_rl_s0p1_r0_dm004p0 wbc_op0_n100_rl_s0p1_r0_dm004p0 0 swwbl
cwbl_op0_n100_rl_s0p1_r0_dm004p0 wbl_op0_n100_rl_s0p1_r0_dm004p0 0 {C_WBL}
spa_op0_n100_rl_s0p1_r0_dm004p0 prea rbl_op0_n100_rl_s0p1_r0_dm004p0 ctl_op0_n100_rl_s0p1_r0_dm004p0 0 swpre
spr_op0_n100_rl_s0p1_r0_dm004p0 pref ref_op0_n100_rl_s0p1_r0_dm004p0 ctl_op0_n100_rl_s0p1_r0_dm004p0 0 swpre
crbl_op0_n100_rl_s0p1_r0_dm004p0 rbl_op0_n100_rl_s0p1_r0_dm004p0 0 {C_RBL}
cref_op0_n100_rl_s0p1_r0_dm004p0 ref_op0_n100_rl_s0p1_r0_dm004p0 0 {C_RBL}   $ ASSUMPTION: ideal matched dummy load
XMWR_op0_n100_rl_s0p1_r0_dm004p0_0 sn_op0_n100_rl_s0p1_r0_dm004p0_0 wwl_op0_n100_rl_s0p1_r0_dm004p0 wbl_op0_n100_rl_s0p1_r0_dm004p0 0 sky130_fd_pr__nfet_01v8 L=0.15 W=0.42 nf=1 ad=0.1218 as=0.1218 pd=1.42 ps=1.42 nrd=0.69047619047619  nrs=0.69047619047619 sa=0 sb=0 sd=0 mult=1 m=1
XMRD_op0_n100_rl_s0p1_r0_dm004p0_0 rbl_op0_n100_rl_s0p1_r0_dm004p0 sn_op0_n100_rl_s0p1_r0_dm004p0_0 rwls_op0_n100_rl_s0p1_r0_dm004p0 0 sky130_fd_pr__nfet_01v8 L=0.15 W=0.42 nf=1 ad=0.1218 as=0.1218 pd=1.42 ps=1.42 nrd=0.69047619047619  nrs=0.69047619047619 sa=0 sb=0 sd=0 mult=1 m=1
csn_op0_n100_rl_s0p1_r0_dm004p0_0 sn_op0_n100_rl_s0p1_r0_dm004p0_0 0 {C_SN}
XMWR_op0_n100_rl_s0p1_r0_dm004p0_1 sn_op0_n100_rl_s0p1_r0_dm004p0_1 wwl_des wbl_op0_n100_rl_s0p1_r0_dm004p0 0 sky130_fd_pr__nfet_01v8 L=0.15 W=0.42 nf=1 ad=0.1218 as=0.1218 pd=1.42 ps=1.42 nrd=0.69047619047619  nrs=0.69047619047619 sa=0 sb=0 sd=0 mult=1 m=1
XMRD_op0_n100_rl_s0p1_r0_dm004p0_1 rbl_op0_n100_rl_s0p1_r0_dm004p0 sn_op0_n100_rl_s0p1_r0_dm004p0_1 rwl_des 0 sky130_fd_pr__nfet_01v8 L=0.15 W=0.42 nf=1 ad=0.1218 as=0.1218 pd=1.42 ps=1.42 nrd=0.69047619047619  nrs=0.69047619047619 sa=0 sb=0 sd=0 mult=1 m=1
csn_op0_n100_rl_s0p1_r0_dm004p0_1 sn_op0_n100_rl_s0p1_r0_dm004p0_1 0 {C_SN}
XMWR_op0_n100_rl_s0p1_r0_dm004p0_2 sn_op0_n100_rl_s0p1_r0_dm004p0_2 wwl_des wbl_op0_n100_rl_s0p1_r0_dm004p0 0 sky130_fd_pr__nfet_01v8 L=0.15 W=0.42 nf=1 ad=0.1218 as=0.1218 pd=1.42 ps=1.42 nrd=0.69047619047619  nrs=0.69047619047619 sa=0 sb=0 sd=0 mult=1 m=1
XMRD_op0_n100_rl_s0p1_r0_dm004p0_2 rbl_op0_n100_rl_s0p1_r0_dm004p0 sn_op0_n100_rl_s0p1_r0_dm004p0_2 rwl_des 0 sky130_fd_pr__nfet_01v8 L=0.15 W=0.42 nf=1 ad=0.1218 as=0.1218 pd=1.42 ps=1.42 nrd=0.69047619047619  nrs=0.69047619047619 sa=0 sb=0 sd=0 mult=1 m=1
csn_op0_n100_rl_s0p1_r0_dm004p0_2 sn_op0_n100_rl_s0p1_r0_dm004p0_2 0 {C_SN}
XMWR_op0_n100_rl_s0p1_r0_dm004p0_3 sn_op0_n100_rl_s0p1_r0_dm004p0_3 wwl_des wbl_op0_n100_rl_s0p1_r0_dm004p0 0 sky130_fd_pr__nfet_01v8 L=0.15 W=0.42 nf=1 ad=0.1218 as=0.1218 pd=1.42 ps=1.42 nrd=0.69047619047619  nrs=0.69047619047619 sa=0 sb=0 sd=0 mult=1 m=1
XMRD_op0_n100_rl_s0p1_r0_dm004p0_3 rbl_op0_n100_rl_s0p1_r0_dm004p0 sn_op0_n100_rl_s0p1_r0_dm004p0_3 rwl_des 0 sky130_fd_pr__nfet_01v8 L=0.15 W=0.42 nf=1 ad=0.1218 as=0.1218 pd=1.42 ps=1.42 nrd=0.69047619047619  nrs=0.69047619047619 sa=0 sb=0 sd=0 mult=1 m=1
csn_op0_n100_rl_s0p1_r0_dm004p0_3 sn_op0_n100_rl_s0p1_r0_dm004p0_3 0 {C_SN}
XMN1_op0_n100_rl_s0p1_r0_dm004p0 rbl_op0_n100_rl_s0p1_r0_dm004p0 ref_op0_n100_rl_s0p1_r0_dm004p0 vn_op0_n100_rl_s0p1_r0_dm004p0 0 sky130_fd_pr__nfet_01v8 L=0.15 W=1 nf=1 ad=0.29 as=0.29 pd=2.58 ps=2.58 mult=1 m=1
XMN2_op0_n100_rl_s0p1_r0_dm004p0 ref_op0_n100_rl_s0p1_r0_dm004p0 rbl_op0_n100_rl_s0p1_r0_dm004p0 vn_op0_n100_rl_s0p1_r0_dm004p0 0 sky130_fd_pr__nfet_01v8 L=0.15 W=1 nf=1 ad=0.29 as=0.29 pd=2.58 ps=2.58 mult=1 m=1
XMP1_op0_n100_rl_s0p1_r0_dm004p0 rbl_op0_n100_rl_s0p1_r0_dm004p0 ref_op0_n100_rl_s0p1_r0_dm004p0 vp_op0_n100_rl_s0p1_r0_dm004p0 vdd sky130_fd_pr__pfet_01v8 L=0.15 W=2 nf=1 ad=0.58 as=0.58 pd=4.58 ps=4.58 mult=1 m=1
XMP2_op0_n100_rl_s0p1_r0_dm004p0 ref_op0_n100_rl_s0p1_r0_dm004p0 rbl_op0_n100_rl_s0p1_r0_dm004p0 vp_op0_n100_rl_s0p1_r0_dm004p0 vdd sky130_fd_pr__pfet_01v8 L=0.15 W=2 nf=1 ad=0.58 as=0.58 pd=4.58 ps=4.58 mult=1 m=1
XMNF_op0_n100_rl_s0p1_r0_dm004p0 vn_op0_n100_rl_s0p1_r0_dm004p0 en_op0_n100_rl_s0p1_r0_dm004p0 0 0 sky130_fd_pr__nfet_01v8 L=0.15 W=2 nf=1 ad=0.58 as=0.58 pd=4.58 ps=4.58 mult=1 m=1
XMPH_op0_n100_rl_s0p1_r0_dm004p0 vp_op0_n100_rl_s0p1_r0_dm004p0 enb_op0_n100_rl_s0p1_r0_dm004p0 vdd vdd sky130_fd_pr__pfet_01v8 L=0.15 W=4 nf=1 ad=1.16 as=1.16 pd=8.58 ps=8.58 mult=1 m=1
bd_op0_n100_rl_s0p1_r0_dm004p0 d_op0_n100_rl_s0p1_r0_dm004p0 0 v=v(rbl_op0_n100_rl_s0p1_r0_dm004p0)-v(ref_op0_n100_rl_s0p1_r0_dm004p0)

* ---- instance 232: op0_0000_rl_s0p1_r0_dm004p0 (variant rl_s0p1_r0_dm004p0; probe dec 11.9 ns, release 34 ns, meas 36 ns) ----
vctl_op0_0000_rl_s0p1_r0_dm004p0 ctl_op0_0000_rl_s0p1_r0_dm004p0 0 pwl(0.0000e+00 {VDD} 2.0000e-09 {VDD} 2.1000e-09 0)
* RWL driver model (EXPERIMENTAL): slew 0.1 ns, series R 0 ohm; cell pin = rwls_op0_0000_rl_s0p1_r0_dm004p0
vrs_op0_0000_rl_s0p1_r0_dm004p0 rwls_op0_0000_rl_s0p1_r0_dm004p0 0 pwl(0.0000e+00 {VDD} 2.0000e-09 {VDD} 2.1000e-09 0 2.8000e-08 0 2.8100e-08 {VDD})
ven_op0_0000_rl_s0p1_r0_dm004p0 en_op0_0000_rl_s0p1_r0_dm004p0 0 pwl(0.0000e+00 0 1.1000e-08 0 1.1100e-08 {VDD} 3.4000e-08 {VDD} 3.4100e-08 0)
venb_op0_0000_rl_s0p1_r0_dm004p0 enb_op0_0000_rl_s0p1_r0_dm004p0 0 pwl(0.0000e+00 {VDD} 1.1000e-08 {VDD} 1.1100e-08 0 3.4000e-08 0 3.4100e-08 {VDD})
vww_op0_0000_rl_s0p1_r0_dm004p0 wwl_op0_0000_rl_s0p1_r0_dm004p0 0 pwl(0.0000e+00 0 1.2000e-08 0 1.2100e-08 {VDD} 3.2000e-08 {VDD} 3.2100e-08 0)
vwc_op0_0000_rl_s0p1_r0_dm004p0 wbc_op0_0000_rl_s0p1_r0_dm004p0 0 pwl(0.0000e+00 0 1.2000e-08 0 1.2100e-08 {VDD} 3.4000e-08 {VDD} 3.4100e-08 0)
swb_op0_0000_rl_s0p1_r0_dm004p0 ref_op0_0000_rl_s0p1_r0_dm004p0 wbl_op0_0000_rl_s0p1_r0_dm004p0 wbc_op0_0000_rl_s0p1_r0_dm004p0 0 swwbl
cwbl_op0_0000_rl_s0p1_r0_dm004p0 wbl_op0_0000_rl_s0p1_r0_dm004p0 0 {C_WBL}
spa_op0_0000_rl_s0p1_r0_dm004p0 prea rbl_op0_0000_rl_s0p1_r0_dm004p0 ctl_op0_0000_rl_s0p1_r0_dm004p0 0 swpre
spr_op0_0000_rl_s0p1_r0_dm004p0 pref ref_op0_0000_rl_s0p1_r0_dm004p0 ctl_op0_0000_rl_s0p1_r0_dm004p0 0 swpre
crbl_op0_0000_rl_s0p1_r0_dm004p0 rbl_op0_0000_rl_s0p1_r0_dm004p0 0 {C_RBL}
cref_op0_0000_rl_s0p1_r0_dm004p0 ref_op0_0000_rl_s0p1_r0_dm004p0 0 {C_RBL}   $ ASSUMPTION: ideal matched dummy load
XMWR_op0_0000_rl_s0p1_r0_dm004p0_0 sn_op0_0000_rl_s0p1_r0_dm004p0_0 wwl_op0_0000_rl_s0p1_r0_dm004p0 wbl_op0_0000_rl_s0p1_r0_dm004p0 0 sky130_fd_pr__nfet_01v8 L=0.15 W=0.42 nf=1 ad=0.1218 as=0.1218 pd=1.42 ps=1.42 nrd=0.69047619047619  nrs=0.69047619047619 sa=0 sb=0 sd=0 mult=1 m=1
XMRD_op0_0000_rl_s0p1_r0_dm004p0_0 rbl_op0_0000_rl_s0p1_r0_dm004p0 sn_op0_0000_rl_s0p1_r0_dm004p0_0 rwls_op0_0000_rl_s0p1_r0_dm004p0 0 sky130_fd_pr__nfet_01v8 L=0.15 W=0.42 nf=1 ad=0.1218 as=0.1218 pd=1.42 ps=1.42 nrd=0.69047619047619  nrs=0.69047619047619 sa=0 sb=0 sd=0 mult=1 m=1
csn_op0_0000_rl_s0p1_r0_dm004p0_0 sn_op0_0000_rl_s0p1_r0_dm004p0_0 0 {C_SN}
XMWR_op0_0000_rl_s0p1_r0_dm004p0_1 sn_op0_0000_rl_s0p1_r0_dm004p0_1 wwl_des wbl_op0_0000_rl_s0p1_r0_dm004p0 0 sky130_fd_pr__nfet_01v8 L=0.15 W=0.42 nf=1 ad=0.1218 as=0.1218 pd=1.42 ps=1.42 nrd=0.69047619047619  nrs=0.69047619047619 sa=0 sb=0 sd=0 mult=1 m=1
XMRD_op0_0000_rl_s0p1_r0_dm004p0_1 rbl_op0_0000_rl_s0p1_r0_dm004p0 sn_op0_0000_rl_s0p1_r0_dm004p0_1 rwl_des 0 sky130_fd_pr__nfet_01v8 L=0.15 W=0.42 nf=1 ad=0.1218 as=0.1218 pd=1.42 ps=1.42 nrd=0.69047619047619  nrs=0.69047619047619 sa=0 sb=0 sd=0 mult=1 m=1
csn_op0_0000_rl_s0p1_r0_dm004p0_1 sn_op0_0000_rl_s0p1_r0_dm004p0_1 0 {C_SN}
XMWR_op0_0000_rl_s0p1_r0_dm004p0_2 sn_op0_0000_rl_s0p1_r0_dm004p0_2 wwl_des wbl_op0_0000_rl_s0p1_r0_dm004p0 0 sky130_fd_pr__nfet_01v8 L=0.15 W=0.42 nf=1 ad=0.1218 as=0.1218 pd=1.42 ps=1.42 nrd=0.69047619047619  nrs=0.69047619047619 sa=0 sb=0 sd=0 mult=1 m=1
XMRD_op0_0000_rl_s0p1_r0_dm004p0_2 rbl_op0_0000_rl_s0p1_r0_dm004p0 sn_op0_0000_rl_s0p1_r0_dm004p0_2 rwl_des 0 sky130_fd_pr__nfet_01v8 L=0.15 W=0.42 nf=1 ad=0.1218 as=0.1218 pd=1.42 ps=1.42 nrd=0.69047619047619  nrs=0.69047619047619 sa=0 sb=0 sd=0 mult=1 m=1
csn_op0_0000_rl_s0p1_r0_dm004p0_2 sn_op0_0000_rl_s0p1_r0_dm004p0_2 0 {C_SN}
XMWR_op0_0000_rl_s0p1_r0_dm004p0_3 sn_op0_0000_rl_s0p1_r0_dm004p0_3 wwl_des wbl_op0_0000_rl_s0p1_r0_dm004p0 0 sky130_fd_pr__nfet_01v8 L=0.15 W=0.42 nf=1 ad=0.1218 as=0.1218 pd=1.42 ps=1.42 nrd=0.69047619047619  nrs=0.69047619047619 sa=0 sb=0 sd=0 mult=1 m=1
XMRD_op0_0000_rl_s0p1_r0_dm004p0_3 rbl_op0_0000_rl_s0p1_r0_dm004p0 sn_op0_0000_rl_s0p1_r0_dm004p0_3 rwl_des 0 sky130_fd_pr__nfet_01v8 L=0.15 W=0.42 nf=1 ad=0.1218 as=0.1218 pd=1.42 ps=1.42 nrd=0.69047619047619  nrs=0.69047619047619 sa=0 sb=0 sd=0 mult=1 m=1
csn_op0_0000_rl_s0p1_r0_dm004p0_3 sn_op0_0000_rl_s0p1_r0_dm004p0_3 0 {C_SN}
XMN1_op0_0000_rl_s0p1_r0_dm004p0 rbl_op0_0000_rl_s0p1_r0_dm004p0 ref_op0_0000_rl_s0p1_r0_dm004p0 vn_op0_0000_rl_s0p1_r0_dm004p0 0 sky130_fd_pr__nfet_01v8 L=0.15 W=1 nf=1 ad=0.29 as=0.29 pd=2.58 ps=2.58 mult=1 m=1
XMN2_op0_0000_rl_s0p1_r0_dm004p0 ref_op0_0000_rl_s0p1_r0_dm004p0 rbl_op0_0000_rl_s0p1_r0_dm004p0 vn_op0_0000_rl_s0p1_r0_dm004p0 0 sky130_fd_pr__nfet_01v8 L=0.15 W=1 nf=1 ad=0.29 as=0.29 pd=2.58 ps=2.58 mult=1 m=1
XMP1_op0_0000_rl_s0p1_r0_dm004p0 rbl_op0_0000_rl_s0p1_r0_dm004p0 ref_op0_0000_rl_s0p1_r0_dm004p0 vp_op0_0000_rl_s0p1_r0_dm004p0 vdd sky130_fd_pr__pfet_01v8 L=0.15 W=2 nf=1 ad=0.58 as=0.58 pd=4.58 ps=4.58 mult=1 m=1
XMP2_op0_0000_rl_s0p1_r0_dm004p0 ref_op0_0000_rl_s0p1_r0_dm004p0 rbl_op0_0000_rl_s0p1_r0_dm004p0 vp_op0_0000_rl_s0p1_r0_dm004p0 vdd sky130_fd_pr__pfet_01v8 L=0.15 W=2 nf=1 ad=0.58 as=0.58 pd=4.58 ps=4.58 mult=1 m=1
XMNF_op0_0000_rl_s0p1_r0_dm004p0 vn_op0_0000_rl_s0p1_r0_dm004p0 en_op0_0000_rl_s0p1_r0_dm004p0 0 0 sky130_fd_pr__nfet_01v8 L=0.15 W=2 nf=1 ad=0.58 as=0.58 pd=4.58 ps=4.58 mult=1 m=1
XMPH_op0_0000_rl_s0p1_r0_dm004p0 vp_op0_0000_rl_s0p1_r0_dm004p0 enb_op0_0000_rl_s0p1_r0_dm004p0 vdd vdd sky130_fd_pr__pfet_01v8 L=0.15 W=4 nf=1 ad=1.16 as=1.16 pd=8.58 ps=8.58 mult=1 m=1
bd_op0_0000_rl_s0p1_r0_dm004p0 d_op0_0000_rl_s0p1_r0_dm004p0 0 v=v(rbl_op0_0000_rl_s0p1_r0_dm004p0)-v(ref_op0_0000_rl_s0p1_r0_dm004p0)

* ---- instance 233: op1_0900_rl_s0p1_r0_dm002p0 (variant rl_s0p1_r0_dm002p0; probe dec 11.9 ns, release 34 ns, meas 36 ns) ----
vctl_op1_0900_rl_s0p1_r0_dm002p0 ctl_op1_0900_rl_s0p1_r0_dm002p0 0 pwl(0.0000e+00 {VDD} 2.0000e-09 {VDD} 2.1000e-09 0)
* RWL driver model (EXPERIMENTAL): slew 0.1 ns, series R 0 ohm; cell pin = rwls_op1_0900_rl_s0p1_r0_dm002p0
vrs_op1_0900_rl_s0p1_r0_dm002p0 rwls_op1_0900_rl_s0p1_r0_dm002p0 0 pwl(0.0000e+00 {VDD} 2.0000e-09 {VDD} 2.1000e-09 0 3.0000e-08 0 3.0100e-08 {VDD})
ven_op1_0900_rl_s0p1_r0_dm002p0 en_op1_0900_rl_s0p1_r0_dm002p0 0 pwl(0.0000e+00 0 1.1000e-08 0 1.1100e-08 {VDD} 3.4000e-08 {VDD} 3.4100e-08 0)
venb_op1_0900_rl_s0p1_r0_dm002p0 enb_op1_0900_rl_s0p1_r0_dm002p0 0 pwl(0.0000e+00 {VDD} 1.1000e-08 {VDD} 1.1100e-08 0 3.4000e-08 0 3.4100e-08 {VDD})
vww_op1_0900_rl_s0p1_r0_dm002p0 wwl_op1_0900_rl_s0p1_r0_dm002p0 0 pwl(0.0000e+00 0 1.2000e-08 0 1.2100e-08 {VDD} 3.2000e-08 {VDD} 3.2100e-08 0)
vwc_op1_0900_rl_s0p1_r0_dm002p0 wbc_op1_0900_rl_s0p1_r0_dm002p0 0 pwl(0.0000e+00 0 1.2000e-08 0 1.2100e-08 {VDD} 3.4000e-08 {VDD} 3.4100e-08 0)
swb_op1_0900_rl_s0p1_r0_dm002p0 ref_op1_0900_rl_s0p1_r0_dm002p0 wbl_op1_0900_rl_s0p1_r0_dm002p0 wbc_op1_0900_rl_s0p1_r0_dm002p0 0 swwbl
cwbl_op1_0900_rl_s0p1_r0_dm002p0 wbl_op1_0900_rl_s0p1_r0_dm002p0 0 {C_WBL}
spa_op1_0900_rl_s0p1_r0_dm002p0 prea rbl_op1_0900_rl_s0p1_r0_dm002p0 ctl_op1_0900_rl_s0p1_r0_dm002p0 0 swpre
spr_op1_0900_rl_s0p1_r0_dm002p0 pref ref_op1_0900_rl_s0p1_r0_dm002p0 ctl_op1_0900_rl_s0p1_r0_dm002p0 0 swpre
crbl_op1_0900_rl_s0p1_r0_dm002p0 rbl_op1_0900_rl_s0p1_r0_dm002p0 0 {C_RBL}
cref_op1_0900_rl_s0p1_r0_dm002p0 ref_op1_0900_rl_s0p1_r0_dm002p0 0 {C_RBL}   $ ASSUMPTION: ideal matched dummy load
XMWR_op1_0900_rl_s0p1_r0_dm002p0_0 sn_op1_0900_rl_s0p1_r0_dm002p0_0 wwl_op1_0900_rl_s0p1_r0_dm002p0 wbl_op1_0900_rl_s0p1_r0_dm002p0 0 sky130_fd_pr__nfet_01v8 L=0.15 W=0.42 nf=1 ad=0.1218 as=0.1218 pd=1.42 ps=1.42 nrd=0.69047619047619  nrs=0.69047619047619 sa=0 sb=0 sd=0 mult=1 m=1
XMRD_op1_0900_rl_s0p1_r0_dm002p0_0 rbl_op1_0900_rl_s0p1_r0_dm002p0 sn_op1_0900_rl_s0p1_r0_dm002p0_0 rwls_op1_0900_rl_s0p1_r0_dm002p0 0 sky130_fd_pr__nfet_01v8 L=0.15 W=0.42 nf=1 ad=0.1218 as=0.1218 pd=1.42 ps=1.42 nrd=0.69047619047619  nrs=0.69047619047619 sa=0 sb=0 sd=0 mult=1 m=1
csn_op1_0900_rl_s0p1_r0_dm002p0_0 sn_op1_0900_rl_s0p1_r0_dm002p0_0 0 {C_SN}
XMWR_op1_0900_rl_s0p1_r0_dm002p0_1 sn_op1_0900_rl_s0p1_r0_dm002p0_1 wwl_des wbl_op1_0900_rl_s0p1_r0_dm002p0 0 sky130_fd_pr__nfet_01v8 L=0.15 W=0.42 nf=1 ad=0.1218 as=0.1218 pd=1.42 ps=1.42 nrd=0.69047619047619  nrs=0.69047619047619 sa=0 sb=0 sd=0 mult=1 m=1
XMRD_op1_0900_rl_s0p1_r0_dm002p0_1 rbl_op1_0900_rl_s0p1_r0_dm002p0 sn_op1_0900_rl_s0p1_r0_dm002p0_1 rwl_des 0 sky130_fd_pr__nfet_01v8 L=0.15 W=0.42 nf=1 ad=0.1218 as=0.1218 pd=1.42 ps=1.42 nrd=0.69047619047619  nrs=0.69047619047619 sa=0 sb=0 sd=0 mult=1 m=1
csn_op1_0900_rl_s0p1_r0_dm002p0_1 sn_op1_0900_rl_s0p1_r0_dm002p0_1 0 {C_SN}
XMWR_op1_0900_rl_s0p1_r0_dm002p0_2 sn_op1_0900_rl_s0p1_r0_dm002p0_2 wwl_des wbl_op1_0900_rl_s0p1_r0_dm002p0 0 sky130_fd_pr__nfet_01v8 L=0.15 W=0.42 nf=1 ad=0.1218 as=0.1218 pd=1.42 ps=1.42 nrd=0.69047619047619  nrs=0.69047619047619 sa=0 sb=0 sd=0 mult=1 m=1
XMRD_op1_0900_rl_s0p1_r0_dm002p0_2 rbl_op1_0900_rl_s0p1_r0_dm002p0 sn_op1_0900_rl_s0p1_r0_dm002p0_2 rwl_des 0 sky130_fd_pr__nfet_01v8 L=0.15 W=0.42 nf=1 ad=0.1218 as=0.1218 pd=1.42 ps=1.42 nrd=0.69047619047619  nrs=0.69047619047619 sa=0 sb=0 sd=0 mult=1 m=1
csn_op1_0900_rl_s0p1_r0_dm002p0_2 sn_op1_0900_rl_s0p1_r0_dm002p0_2 0 {C_SN}
XMWR_op1_0900_rl_s0p1_r0_dm002p0_3 sn_op1_0900_rl_s0p1_r0_dm002p0_3 wwl_des wbl_op1_0900_rl_s0p1_r0_dm002p0 0 sky130_fd_pr__nfet_01v8 L=0.15 W=0.42 nf=1 ad=0.1218 as=0.1218 pd=1.42 ps=1.42 nrd=0.69047619047619  nrs=0.69047619047619 sa=0 sb=0 sd=0 mult=1 m=1
XMRD_op1_0900_rl_s0p1_r0_dm002p0_3 rbl_op1_0900_rl_s0p1_r0_dm002p0 sn_op1_0900_rl_s0p1_r0_dm002p0_3 rwl_des 0 sky130_fd_pr__nfet_01v8 L=0.15 W=0.42 nf=1 ad=0.1218 as=0.1218 pd=1.42 ps=1.42 nrd=0.69047619047619  nrs=0.69047619047619 sa=0 sb=0 sd=0 mult=1 m=1
csn_op1_0900_rl_s0p1_r0_dm002p0_3 sn_op1_0900_rl_s0p1_r0_dm002p0_3 0 {C_SN}
XMN1_op1_0900_rl_s0p1_r0_dm002p0 rbl_op1_0900_rl_s0p1_r0_dm002p0 ref_op1_0900_rl_s0p1_r0_dm002p0 vn_op1_0900_rl_s0p1_r0_dm002p0 0 sky130_fd_pr__nfet_01v8 L=0.15 W=1 nf=1 ad=0.29 as=0.29 pd=2.58 ps=2.58 mult=1 m=1
XMN2_op1_0900_rl_s0p1_r0_dm002p0 ref_op1_0900_rl_s0p1_r0_dm002p0 rbl_op1_0900_rl_s0p1_r0_dm002p0 vn_op1_0900_rl_s0p1_r0_dm002p0 0 sky130_fd_pr__nfet_01v8 L=0.15 W=1 nf=1 ad=0.29 as=0.29 pd=2.58 ps=2.58 mult=1 m=1
XMP1_op1_0900_rl_s0p1_r0_dm002p0 rbl_op1_0900_rl_s0p1_r0_dm002p0 ref_op1_0900_rl_s0p1_r0_dm002p0 vp_op1_0900_rl_s0p1_r0_dm002p0 vdd sky130_fd_pr__pfet_01v8 L=0.15 W=2 nf=1 ad=0.58 as=0.58 pd=4.58 ps=4.58 mult=1 m=1
XMP2_op1_0900_rl_s0p1_r0_dm002p0 ref_op1_0900_rl_s0p1_r0_dm002p0 rbl_op1_0900_rl_s0p1_r0_dm002p0 vp_op1_0900_rl_s0p1_r0_dm002p0 vdd sky130_fd_pr__pfet_01v8 L=0.15 W=2 nf=1 ad=0.58 as=0.58 pd=4.58 ps=4.58 mult=1 m=1
XMNF_op1_0900_rl_s0p1_r0_dm002p0 vn_op1_0900_rl_s0p1_r0_dm002p0 en_op1_0900_rl_s0p1_r0_dm002p0 0 0 sky130_fd_pr__nfet_01v8 L=0.15 W=2 nf=1 ad=0.58 as=0.58 pd=4.58 ps=4.58 mult=1 m=1
XMPH_op1_0900_rl_s0p1_r0_dm002p0 vp_op1_0900_rl_s0p1_r0_dm002p0 enb_op1_0900_rl_s0p1_r0_dm002p0 vdd vdd sky130_fd_pr__pfet_01v8 L=0.15 W=4 nf=1 ad=1.16 as=1.16 pd=8.58 ps=8.58 mult=1 m=1
bd_op1_0900_rl_s0p1_r0_dm002p0 d_op1_0900_rl_s0p1_r0_dm002p0 0 v=v(rbl_op1_0900_rl_s0p1_r0_dm002p0)-v(ref_op1_0900_rl_s0p1_r0_dm002p0)

* ---- instance 234: op1_1000_rl_s0p1_r0_dm002p0 (variant rl_s0p1_r0_dm002p0; probe dec 11.9 ns, release 34 ns, meas 36 ns) ----
vctl_op1_1000_rl_s0p1_r0_dm002p0 ctl_op1_1000_rl_s0p1_r0_dm002p0 0 pwl(0.0000e+00 {VDD} 2.0000e-09 {VDD} 2.1000e-09 0)
* RWL driver model (EXPERIMENTAL): slew 0.1 ns, series R 0 ohm; cell pin = rwls_op1_1000_rl_s0p1_r0_dm002p0
vrs_op1_1000_rl_s0p1_r0_dm002p0 rwls_op1_1000_rl_s0p1_r0_dm002p0 0 pwl(0.0000e+00 {VDD} 2.0000e-09 {VDD} 2.1000e-09 0 3.0000e-08 0 3.0100e-08 {VDD})
ven_op1_1000_rl_s0p1_r0_dm002p0 en_op1_1000_rl_s0p1_r0_dm002p0 0 pwl(0.0000e+00 0 1.1000e-08 0 1.1100e-08 {VDD} 3.4000e-08 {VDD} 3.4100e-08 0)
venb_op1_1000_rl_s0p1_r0_dm002p0 enb_op1_1000_rl_s0p1_r0_dm002p0 0 pwl(0.0000e+00 {VDD} 1.1000e-08 {VDD} 1.1100e-08 0 3.4000e-08 0 3.4100e-08 {VDD})
vww_op1_1000_rl_s0p1_r0_dm002p0 wwl_op1_1000_rl_s0p1_r0_dm002p0 0 pwl(0.0000e+00 0 1.2000e-08 0 1.2100e-08 {VDD} 3.2000e-08 {VDD} 3.2100e-08 0)
vwc_op1_1000_rl_s0p1_r0_dm002p0 wbc_op1_1000_rl_s0p1_r0_dm002p0 0 pwl(0.0000e+00 0 1.2000e-08 0 1.2100e-08 {VDD} 3.4000e-08 {VDD} 3.4100e-08 0)
swb_op1_1000_rl_s0p1_r0_dm002p0 ref_op1_1000_rl_s0p1_r0_dm002p0 wbl_op1_1000_rl_s0p1_r0_dm002p0 wbc_op1_1000_rl_s0p1_r0_dm002p0 0 swwbl
cwbl_op1_1000_rl_s0p1_r0_dm002p0 wbl_op1_1000_rl_s0p1_r0_dm002p0 0 {C_WBL}
spa_op1_1000_rl_s0p1_r0_dm002p0 prea rbl_op1_1000_rl_s0p1_r0_dm002p0 ctl_op1_1000_rl_s0p1_r0_dm002p0 0 swpre
spr_op1_1000_rl_s0p1_r0_dm002p0 pref ref_op1_1000_rl_s0p1_r0_dm002p0 ctl_op1_1000_rl_s0p1_r0_dm002p0 0 swpre
crbl_op1_1000_rl_s0p1_r0_dm002p0 rbl_op1_1000_rl_s0p1_r0_dm002p0 0 {C_RBL}
cref_op1_1000_rl_s0p1_r0_dm002p0 ref_op1_1000_rl_s0p1_r0_dm002p0 0 {C_RBL}   $ ASSUMPTION: ideal matched dummy load
XMWR_op1_1000_rl_s0p1_r0_dm002p0_0 sn_op1_1000_rl_s0p1_r0_dm002p0_0 wwl_op1_1000_rl_s0p1_r0_dm002p0 wbl_op1_1000_rl_s0p1_r0_dm002p0 0 sky130_fd_pr__nfet_01v8 L=0.15 W=0.42 nf=1 ad=0.1218 as=0.1218 pd=1.42 ps=1.42 nrd=0.69047619047619  nrs=0.69047619047619 sa=0 sb=0 sd=0 mult=1 m=1
XMRD_op1_1000_rl_s0p1_r0_dm002p0_0 rbl_op1_1000_rl_s0p1_r0_dm002p0 sn_op1_1000_rl_s0p1_r0_dm002p0_0 rwls_op1_1000_rl_s0p1_r0_dm002p0 0 sky130_fd_pr__nfet_01v8 L=0.15 W=0.42 nf=1 ad=0.1218 as=0.1218 pd=1.42 ps=1.42 nrd=0.69047619047619  nrs=0.69047619047619 sa=0 sb=0 sd=0 mult=1 m=1
csn_op1_1000_rl_s0p1_r0_dm002p0_0 sn_op1_1000_rl_s0p1_r0_dm002p0_0 0 {C_SN}
XMWR_op1_1000_rl_s0p1_r0_dm002p0_1 sn_op1_1000_rl_s0p1_r0_dm002p0_1 wwl_des wbl_op1_1000_rl_s0p1_r0_dm002p0 0 sky130_fd_pr__nfet_01v8 L=0.15 W=0.42 nf=1 ad=0.1218 as=0.1218 pd=1.42 ps=1.42 nrd=0.69047619047619  nrs=0.69047619047619 sa=0 sb=0 sd=0 mult=1 m=1
XMRD_op1_1000_rl_s0p1_r0_dm002p0_1 rbl_op1_1000_rl_s0p1_r0_dm002p0 sn_op1_1000_rl_s0p1_r0_dm002p0_1 rwl_des 0 sky130_fd_pr__nfet_01v8 L=0.15 W=0.42 nf=1 ad=0.1218 as=0.1218 pd=1.42 ps=1.42 nrd=0.69047619047619  nrs=0.69047619047619 sa=0 sb=0 sd=0 mult=1 m=1
csn_op1_1000_rl_s0p1_r0_dm002p0_1 sn_op1_1000_rl_s0p1_r0_dm002p0_1 0 {C_SN}
XMWR_op1_1000_rl_s0p1_r0_dm002p0_2 sn_op1_1000_rl_s0p1_r0_dm002p0_2 wwl_des wbl_op1_1000_rl_s0p1_r0_dm002p0 0 sky130_fd_pr__nfet_01v8 L=0.15 W=0.42 nf=1 ad=0.1218 as=0.1218 pd=1.42 ps=1.42 nrd=0.69047619047619  nrs=0.69047619047619 sa=0 sb=0 sd=0 mult=1 m=1
XMRD_op1_1000_rl_s0p1_r0_dm002p0_2 rbl_op1_1000_rl_s0p1_r0_dm002p0 sn_op1_1000_rl_s0p1_r0_dm002p0_2 rwl_des 0 sky130_fd_pr__nfet_01v8 L=0.15 W=0.42 nf=1 ad=0.1218 as=0.1218 pd=1.42 ps=1.42 nrd=0.69047619047619  nrs=0.69047619047619 sa=0 sb=0 sd=0 mult=1 m=1
csn_op1_1000_rl_s0p1_r0_dm002p0_2 sn_op1_1000_rl_s0p1_r0_dm002p0_2 0 {C_SN}
XMWR_op1_1000_rl_s0p1_r0_dm002p0_3 sn_op1_1000_rl_s0p1_r0_dm002p0_3 wwl_des wbl_op1_1000_rl_s0p1_r0_dm002p0 0 sky130_fd_pr__nfet_01v8 L=0.15 W=0.42 nf=1 ad=0.1218 as=0.1218 pd=1.42 ps=1.42 nrd=0.69047619047619  nrs=0.69047619047619 sa=0 sb=0 sd=0 mult=1 m=1
XMRD_op1_1000_rl_s0p1_r0_dm002p0_3 rbl_op1_1000_rl_s0p1_r0_dm002p0 sn_op1_1000_rl_s0p1_r0_dm002p0_3 rwl_des 0 sky130_fd_pr__nfet_01v8 L=0.15 W=0.42 nf=1 ad=0.1218 as=0.1218 pd=1.42 ps=1.42 nrd=0.69047619047619  nrs=0.69047619047619 sa=0 sb=0 sd=0 mult=1 m=1
csn_op1_1000_rl_s0p1_r0_dm002p0_3 sn_op1_1000_rl_s0p1_r0_dm002p0_3 0 {C_SN}
XMN1_op1_1000_rl_s0p1_r0_dm002p0 rbl_op1_1000_rl_s0p1_r0_dm002p0 ref_op1_1000_rl_s0p1_r0_dm002p0 vn_op1_1000_rl_s0p1_r0_dm002p0 0 sky130_fd_pr__nfet_01v8 L=0.15 W=1 nf=1 ad=0.29 as=0.29 pd=2.58 ps=2.58 mult=1 m=1
XMN2_op1_1000_rl_s0p1_r0_dm002p0 ref_op1_1000_rl_s0p1_r0_dm002p0 rbl_op1_1000_rl_s0p1_r0_dm002p0 vn_op1_1000_rl_s0p1_r0_dm002p0 0 sky130_fd_pr__nfet_01v8 L=0.15 W=1 nf=1 ad=0.29 as=0.29 pd=2.58 ps=2.58 mult=1 m=1
XMP1_op1_1000_rl_s0p1_r0_dm002p0 rbl_op1_1000_rl_s0p1_r0_dm002p0 ref_op1_1000_rl_s0p1_r0_dm002p0 vp_op1_1000_rl_s0p1_r0_dm002p0 vdd sky130_fd_pr__pfet_01v8 L=0.15 W=2 nf=1 ad=0.58 as=0.58 pd=4.58 ps=4.58 mult=1 m=1
XMP2_op1_1000_rl_s0p1_r0_dm002p0 ref_op1_1000_rl_s0p1_r0_dm002p0 rbl_op1_1000_rl_s0p1_r0_dm002p0 vp_op1_1000_rl_s0p1_r0_dm002p0 vdd sky130_fd_pr__pfet_01v8 L=0.15 W=2 nf=1 ad=0.58 as=0.58 pd=4.58 ps=4.58 mult=1 m=1
XMNF_op1_1000_rl_s0p1_r0_dm002p0 vn_op1_1000_rl_s0p1_r0_dm002p0 en_op1_1000_rl_s0p1_r0_dm002p0 0 0 sky130_fd_pr__nfet_01v8 L=0.15 W=2 nf=1 ad=0.58 as=0.58 pd=4.58 ps=4.58 mult=1 m=1
XMPH_op1_1000_rl_s0p1_r0_dm002p0 vp_op1_1000_rl_s0p1_r0_dm002p0 enb_op1_1000_rl_s0p1_r0_dm002p0 vdd vdd sky130_fd_pr__pfet_01v8 L=0.15 W=4 nf=1 ad=1.16 as=1.16 pd=8.58 ps=8.58 mult=1 m=1
bd_op1_1000_rl_s0p1_r0_dm002p0 d_op1_1000_rl_s0p1_r0_dm002p0 0 v=v(rbl_op1_1000_rl_s0p1_r0_dm002p0)-v(ref_op1_1000_rl_s0p1_r0_dm002p0)

* ---- instance 235: op0_n100_rl_s0p1_r0_dm002p0 (variant rl_s0p1_r0_dm002p0; probe dec 11.9 ns, release 34 ns, meas 36 ns) ----
vctl_op0_n100_rl_s0p1_r0_dm002p0 ctl_op0_n100_rl_s0p1_r0_dm002p0 0 pwl(0.0000e+00 {VDD} 2.0000e-09 {VDD} 2.1000e-09 0)
* RWL driver model (EXPERIMENTAL): slew 0.1 ns, series R 0 ohm; cell pin = rwls_op0_n100_rl_s0p1_r0_dm002p0
vrs_op0_n100_rl_s0p1_r0_dm002p0 rwls_op0_n100_rl_s0p1_r0_dm002p0 0 pwl(0.0000e+00 {VDD} 2.0000e-09 {VDD} 2.1000e-09 0 3.0000e-08 0 3.0100e-08 {VDD})
ven_op0_n100_rl_s0p1_r0_dm002p0 en_op0_n100_rl_s0p1_r0_dm002p0 0 pwl(0.0000e+00 0 1.1000e-08 0 1.1100e-08 {VDD} 3.4000e-08 {VDD} 3.4100e-08 0)
venb_op0_n100_rl_s0p1_r0_dm002p0 enb_op0_n100_rl_s0p1_r0_dm002p0 0 pwl(0.0000e+00 {VDD} 1.1000e-08 {VDD} 1.1100e-08 0 3.4000e-08 0 3.4100e-08 {VDD})
vww_op0_n100_rl_s0p1_r0_dm002p0 wwl_op0_n100_rl_s0p1_r0_dm002p0 0 pwl(0.0000e+00 0 1.2000e-08 0 1.2100e-08 {VDD} 3.2000e-08 {VDD} 3.2100e-08 0)
vwc_op0_n100_rl_s0p1_r0_dm002p0 wbc_op0_n100_rl_s0p1_r0_dm002p0 0 pwl(0.0000e+00 0 1.2000e-08 0 1.2100e-08 {VDD} 3.4000e-08 {VDD} 3.4100e-08 0)
swb_op0_n100_rl_s0p1_r0_dm002p0 ref_op0_n100_rl_s0p1_r0_dm002p0 wbl_op0_n100_rl_s0p1_r0_dm002p0 wbc_op0_n100_rl_s0p1_r0_dm002p0 0 swwbl
cwbl_op0_n100_rl_s0p1_r0_dm002p0 wbl_op0_n100_rl_s0p1_r0_dm002p0 0 {C_WBL}
spa_op0_n100_rl_s0p1_r0_dm002p0 prea rbl_op0_n100_rl_s0p1_r0_dm002p0 ctl_op0_n100_rl_s0p1_r0_dm002p0 0 swpre
spr_op0_n100_rl_s0p1_r0_dm002p0 pref ref_op0_n100_rl_s0p1_r0_dm002p0 ctl_op0_n100_rl_s0p1_r0_dm002p0 0 swpre
crbl_op0_n100_rl_s0p1_r0_dm002p0 rbl_op0_n100_rl_s0p1_r0_dm002p0 0 {C_RBL}
cref_op0_n100_rl_s0p1_r0_dm002p0 ref_op0_n100_rl_s0p1_r0_dm002p0 0 {C_RBL}   $ ASSUMPTION: ideal matched dummy load
XMWR_op0_n100_rl_s0p1_r0_dm002p0_0 sn_op0_n100_rl_s0p1_r0_dm002p0_0 wwl_op0_n100_rl_s0p1_r0_dm002p0 wbl_op0_n100_rl_s0p1_r0_dm002p0 0 sky130_fd_pr__nfet_01v8 L=0.15 W=0.42 nf=1 ad=0.1218 as=0.1218 pd=1.42 ps=1.42 nrd=0.69047619047619  nrs=0.69047619047619 sa=0 sb=0 sd=0 mult=1 m=1
XMRD_op0_n100_rl_s0p1_r0_dm002p0_0 rbl_op0_n100_rl_s0p1_r0_dm002p0 sn_op0_n100_rl_s0p1_r0_dm002p0_0 rwls_op0_n100_rl_s0p1_r0_dm002p0 0 sky130_fd_pr__nfet_01v8 L=0.15 W=0.42 nf=1 ad=0.1218 as=0.1218 pd=1.42 ps=1.42 nrd=0.69047619047619  nrs=0.69047619047619 sa=0 sb=0 sd=0 mult=1 m=1
csn_op0_n100_rl_s0p1_r0_dm002p0_0 sn_op0_n100_rl_s0p1_r0_dm002p0_0 0 {C_SN}
XMWR_op0_n100_rl_s0p1_r0_dm002p0_1 sn_op0_n100_rl_s0p1_r0_dm002p0_1 wwl_des wbl_op0_n100_rl_s0p1_r0_dm002p0 0 sky130_fd_pr__nfet_01v8 L=0.15 W=0.42 nf=1 ad=0.1218 as=0.1218 pd=1.42 ps=1.42 nrd=0.69047619047619  nrs=0.69047619047619 sa=0 sb=0 sd=0 mult=1 m=1
XMRD_op0_n100_rl_s0p1_r0_dm002p0_1 rbl_op0_n100_rl_s0p1_r0_dm002p0 sn_op0_n100_rl_s0p1_r0_dm002p0_1 rwl_des 0 sky130_fd_pr__nfet_01v8 L=0.15 W=0.42 nf=1 ad=0.1218 as=0.1218 pd=1.42 ps=1.42 nrd=0.69047619047619  nrs=0.69047619047619 sa=0 sb=0 sd=0 mult=1 m=1
csn_op0_n100_rl_s0p1_r0_dm002p0_1 sn_op0_n100_rl_s0p1_r0_dm002p0_1 0 {C_SN}
XMWR_op0_n100_rl_s0p1_r0_dm002p0_2 sn_op0_n100_rl_s0p1_r0_dm002p0_2 wwl_des wbl_op0_n100_rl_s0p1_r0_dm002p0 0 sky130_fd_pr__nfet_01v8 L=0.15 W=0.42 nf=1 ad=0.1218 as=0.1218 pd=1.42 ps=1.42 nrd=0.69047619047619  nrs=0.69047619047619 sa=0 sb=0 sd=0 mult=1 m=1
XMRD_op0_n100_rl_s0p1_r0_dm002p0_2 rbl_op0_n100_rl_s0p1_r0_dm002p0 sn_op0_n100_rl_s0p1_r0_dm002p0_2 rwl_des 0 sky130_fd_pr__nfet_01v8 L=0.15 W=0.42 nf=1 ad=0.1218 as=0.1218 pd=1.42 ps=1.42 nrd=0.69047619047619  nrs=0.69047619047619 sa=0 sb=0 sd=0 mult=1 m=1
csn_op0_n100_rl_s0p1_r0_dm002p0_2 sn_op0_n100_rl_s0p1_r0_dm002p0_2 0 {C_SN}
XMWR_op0_n100_rl_s0p1_r0_dm002p0_3 sn_op0_n100_rl_s0p1_r0_dm002p0_3 wwl_des wbl_op0_n100_rl_s0p1_r0_dm002p0 0 sky130_fd_pr__nfet_01v8 L=0.15 W=0.42 nf=1 ad=0.1218 as=0.1218 pd=1.42 ps=1.42 nrd=0.69047619047619  nrs=0.69047619047619 sa=0 sb=0 sd=0 mult=1 m=1
XMRD_op0_n100_rl_s0p1_r0_dm002p0_3 rbl_op0_n100_rl_s0p1_r0_dm002p0 sn_op0_n100_rl_s0p1_r0_dm002p0_3 rwl_des 0 sky130_fd_pr__nfet_01v8 L=0.15 W=0.42 nf=1 ad=0.1218 as=0.1218 pd=1.42 ps=1.42 nrd=0.69047619047619  nrs=0.69047619047619 sa=0 sb=0 sd=0 mult=1 m=1
csn_op0_n100_rl_s0p1_r0_dm002p0_3 sn_op0_n100_rl_s0p1_r0_dm002p0_3 0 {C_SN}
XMN1_op0_n100_rl_s0p1_r0_dm002p0 rbl_op0_n100_rl_s0p1_r0_dm002p0 ref_op0_n100_rl_s0p1_r0_dm002p0 vn_op0_n100_rl_s0p1_r0_dm002p0 0 sky130_fd_pr__nfet_01v8 L=0.15 W=1 nf=1 ad=0.29 as=0.29 pd=2.58 ps=2.58 mult=1 m=1
XMN2_op0_n100_rl_s0p1_r0_dm002p0 ref_op0_n100_rl_s0p1_r0_dm002p0 rbl_op0_n100_rl_s0p1_r0_dm002p0 vn_op0_n100_rl_s0p1_r0_dm002p0 0 sky130_fd_pr__nfet_01v8 L=0.15 W=1 nf=1 ad=0.29 as=0.29 pd=2.58 ps=2.58 mult=1 m=1
XMP1_op0_n100_rl_s0p1_r0_dm002p0 rbl_op0_n100_rl_s0p1_r0_dm002p0 ref_op0_n100_rl_s0p1_r0_dm002p0 vp_op0_n100_rl_s0p1_r0_dm002p0 vdd sky130_fd_pr__pfet_01v8 L=0.15 W=2 nf=1 ad=0.58 as=0.58 pd=4.58 ps=4.58 mult=1 m=1
XMP2_op0_n100_rl_s0p1_r0_dm002p0 ref_op0_n100_rl_s0p1_r0_dm002p0 rbl_op0_n100_rl_s0p1_r0_dm002p0 vp_op0_n100_rl_s0p1_r0_dm002p0 vdd sky130_fd_pr__pfet_01v8 L=0.15 W=2 nf=1 ad=0.58 as=0.58 pd=4.58 ps=4.58 mult=1 m=1
XMNF_op0_n100_rl_s0p1_r0_dm002p0 vn_op0_n100_rl_s0p1_r0_dm002p0 en_op0_n100_rl_s0p1_r0_dm002p0 0 0 sky130_fd_pr__nfet_01v8 L=0.15 W=2 nf=1 ad=0.58 as=0.58 pd=4.58 ps=4.58 mult=1 m=1
XMPH_op0_n100_rl_s0p1_r0_dm002p0 vp_op0_n100_rl_s0p1_r0_dm002p0 enb_op0_n100_rl_s0p1_r0_dm002p0 vdd vdd sky130_fd_pr__pfet_01v8 L=0.15 W=4 nf=1 ad=1.16 as=1.16 pd=8.58 ps=8.58 mult=1 m=1
bd_op0_n100_rl_s0p1_r0_dm002p0 d_op0_n100_rl_s0p1_r0_dm002p0 0 v=v(rbl_op0_n100_rl_s0p1_r0_dm002p0)-v(ref_op0_n100_rl_s0p1_r0_dm002p0)

* ---- instance 236: op0_0000_rl_s0p1_r0_dm002p0 (variant rl_s0p1_r0_dm002p0; probe dec 11.9 ns, release 34 ns, meas 36 ns) ----
vctl_op0_0000_rl_s0p1_r0_dm002p0 ctl_op0_0000_rl_s0p1_r0_dm002p0 0 pwl(0.0000e+00 {VDD} 2.0000e-09 {VDD} 2.1000e-09 0)
* RWL driver model (EXPERIMENTAL): slew 0.1 ns, series R 0 ohm; cell pin = rwls_op0_0000_rl_s0p1_r0_dm002p0
vrs_op0_0000_rl_s0p1_r0_dm002p0 rwls_op0_0000_rl_s0p1_r0_dm002p0 0 pwl(0.0000e+00 {VDD} 2.0000e-09 {VDD} 2.1000e-09 0 3.0000e-08 0 3.0100e-08 {VDD})
ven_op0_0000_rl_s0p1_r0_dm002p0 en_op0_0000_rl_s0p1_r0_dm002p0 0 pwl(0.0000e+00 0 1.1000e-08 0 1.1100e-08 {VDD} 3.4000e-08 {VDD} 3.4100e-08 0)
venb_op0_0000_rl_s0p1_r0_dm002p0 enb_op0_0000_rl_s0p1_r0_dm002p0 0 pwl(0.0000e+00 {VDD} 1.1000e-08 {VDD} 1.1100e-08 0 3.4000e-08 0 3.4100e-08 {VDD})
vww_op0_0000_rl_s0p1_r0_dm002p0 wwl_op0_0000_rl_s0p1_r0_dm002p0 0 pwl(0.0000e+00 0 1.2000e-08 0 1.2100e-08 {VDD} 3.2000e-08 {VDD} 3.2100e-08 0)
vwc_op0_0000_rl_s0p1_r0_dm002p0 wbc_op0_0000_rl_s0p1_r0_dm002p0 0 pwl(0.0000e+00 0 1.2000e-08 0 1.2100e-08 {VDD} 3.4000e-08 {VDD} 3.4100e-08 0)
swb_op0_0000_rl_s0p1_r0_dm002p0 ref_op0_0000_rl_s0p1_r0_dm002p0 wbl_op0_0000_rl_s0p1_r0_dm002p0 wbc_op0_0000_rl_s0p1_r0_dm002p0 0 swwbl
cwbl_op0_0000_rl_s0p1_r0_dm002p0 wbl_op0_0000_rl_s0p1_r0_dm002p0 0 {C_WBL}
spa_op0_0000_rl_s0p1_r0_dm002p0 prea rbl_op0_0000_rl_s0p1_r0_dm002p0 ctl_op0_0000_rl_s0p1_r0_dm002p0 0 swpre
spr_op0_0000_rl_s0p1_r0_dm002p0 pref ref_op0_0000_rl_s0p1_r0_dm002p0 ctl_op0_0000_rl_s0p1_r0_dm002p0 0 swpre
crbl_op0_0000_rl_s0p1_r0_dm002p0 rbl_op0_0000_rl_s0p1_r0_dm002p0 0 {C_RBL}
cref_op0_0000_rl_s0p1_r0_dm002p0 ref_op0_0000_rl_s0p1_r0_dm002p0 0 {C_RBL}   $ ASSUMPTION: ideal matched dummy load
XMWR_op0_0000_rl_s0p1_r0_dm002p0_0 sn_op0_0000_rl_s0p1_r0_dm002p0_0 wwl_op0_0000_rl_s0p1_r0_dm002p0 wbl_op0_0000_rl_s0p1_r0_dm002p0 0 sky130_fd_pr__nfet_01v8 L=0.15 W=0.42 nf=1 ad=0.1218 as=0.1218 pd=1.42 ps=1.42 nrd=0.69047619047619  nrs=0.69047619047619 sa=0 sb=0 sd=0 mult=1 m=1
XMRD_op0_0000_rl_s0p1_r0_dm002p0_0 rbl_op0_0000_rl_s0p1_r0_dm002p0 sn_op0_0000_rl_s0p1_r0_dm002p0_0 rwls_op0_0000_rl_s0p1_r0_dm002p0 0 sky130_fd_pr__nfet_01v8 L=0.15 W=0.42 nf=1 ad=0.1218 as=0.1218 pd=1.42 ps=1.42 nrd=0.69047619047619  nrs=0.69047619047619 sa=0 sb=0 sd=0 mult=1 m=1
csn_op0_0000_rl_s0p1_r0_dm002p0_0 sn_op0_0000_rl_s0p1_r0_dm002p0_0 0 {C_SN}
XMWR_op0_0000_rl_s0p1_r0_dm002p0_1 sn_op0_0000_rl_s0p1_r0_dm002p0_1 wwl_des wbl_op0_0000_rl_s0p1_r0_dm002p0 0 sky130_fd_pr__nfet_01v8 L=0.15 W=0.42 nf=1 ad=0.1218 as=0.1218 pd=1.42 ps=1.42 nrd=0.69047619047619  nrs=0.69047619047619 sa=0 sb=0 sd=0 mult=1 m=1
XMRD_op0_0000_rl_s0p1_r0_dm002p0_1 rbl_op0_0000_rl_s0p1_r0_dm002p0 sn_op0_0000_rl_s0p1_r0_dm002p0_1 rwl_des 0 sky130_fd_pr__nfet_01v8 L=0.15 W=0.42 nf=1 ad=0.1218 as=0.1218 pd=1.42 ps=1.42 nrd=0.69047619047619  nrs=0.69047619047619 sa=0 sb=0 sd=0 mult=1 m=1
csn_op0_0000_rl_s0p1_r0_dm002p0_1 sn_op0_0000_rl_s0p1_r0_dm002p0_1 0 {C_SN}
XMWR_op0_0000_rl_s0p1_r0_dm002p0_2 sn_op0_0000_rl_s0p1_r0_dm002p0_2 wwl_des wbl_op0_0000_rl_s0p1_r0_dm002p0 0 sky130_fd_pr__nfet_01v8 L=0.15 W=0.42 nf=1 ad=0.1218 as=0.1218 pd=1.42 ps=1.42 nrd=0.69047619047619  nrs=0.69047619047619 sa=0 sb=0 sd=0 mult=1 m=1
XMRD_op0_0000_rl_s0p1_r0_dm002p0_2 rbl_op0_0000_rl_s0p1_r0_dm002p0 sn_op0_0000_rl_s0p1_r0_dm002p0_2 rwl_des 0 sky130_fd_pr__nfet_01v8 L=0.15 W=0.42 nf=1 ad=0.1218 as=0.1218 pd=1.42 ps=1.42 nrd=0.69047619047619  nrs=0.69047619047619 sa=0 sb=0 sd=0 mult=1 m=1
csn_op0_0000_rl_s0p1_r0_dm002p0_2 sn_op0_0000_rl_s0p1_r0_dm002p0_2 0 {C_SN}
XMWR_op0_0000_rl_s0p1_r0_dm002p0_3 sn_op0_0000_rl_s0p1_r0_dm002p0_3 wwl_des wbl_op0_0000_rl_s0p1_r0_dm002p0 0 sky130_fd_pr__nfet_01v8 L=0.15 W=0.42 nf=1 ad=0.1218 as=0.1218 pd=1.42 ps=1.42 nrd=0.69047619047619  nrs=0.69047619047619 sa=0 sb=0 sd=0 mult=1 m=1
XMRD_op0_0000_rl_s0p1_r0_dm002p0_3 rbl_op0_0000_rl_s0p1_r0_dm002p0 sn_op0_0000_rl_s0p1_r0_dm002p0_3 rwl_des 0 sky130_fd_pr__nfet_01v8 L=0.15 W=0.42 nf=1 ad=0.1218 as=0.1218 pd=1.42 ps=1.42 nrd=0.69047619047619  nrs=0.69047619047619 sa=0 sb=0 sd=0 mult=1 m=1
csn_op0_0000_rl_s0p1_r0_dm002p0_3 sn_op0_0000_rl_s0p1_r0_dm002p0_3 0 {C_SN}
XMN1_op0_0000_rl_s0p1_r0_dm002p0 rbl_op0_0000_rl_s0p1_r0_dm002p0 ref_op0_0000_rl_s0p1_r0_dm002p0 vn_op0_0000_rl_s0p1_r0_dm002p0 0 sky130_fd_pr__nfet_01v8 L=0.15 W=1 nf=1 ad=0.29 as=0.29 pd=2.58 ps=2.58 mult=1 m=1
XMN2_op0_0000_rl_s0p1_r0_dm002p0 ref_op0_0000_rl_s0p1_r0_dm002p0 rbl_op0_0000_rl_s0p1_r0_dm002p0 vn_op0_0000_rl_s0p1_r0_dm002p0 0 sky130_fd_pr__nfet_01v8 L=0.15 W=1 nf=1 ad=0.29 as=0.29 pd=2.58 ps=2.58 mult=1 m=1
XMP1_op0_0000_rl_s0p1_r0_dm002p0 rbl_op0_0000_rl_s0p1_r0_dm002p0 ref_op0_0000_rl_s0p1_r0_dm002p0 vp_op0_0000_rl_s0p1_r0_dm002p0 vdd sky130_fd_pr__pfet_01v8 L=0.15 W=2 nf=1 ad=0.58 as=0.58 pd=4.58 ps=4.58 mult=1 m=1
XMP2_op0_0000_rl_s0p1_r0_dm002p0 ref_op0_0000_rl_s0p1_r0_dm002p0 rbl_op0_0000_rl_s0p1_r0_dm002p0 vp_op0_0000_rl_s0p1_r0_dm002p0 vdd sky130_fd_pr__pfet_01v8 L=0.15 W=2 nf=1 ad=0.58 as=0.58 pd=4.58 ps=4.58 mult=1 m=1
XMNF_op0_0000_rl_s0p1_r0_dm002p0 vn_op0_0000_rl_s0p1_r0_dm002p0 en_op0_0000_rl_s0p1_r0_dm002p0 0 0 sky130_fd_pr__nfet_01v8 L=0.15 W=2 nf=1 ad=0.58 as=0.58 pd=4.58 ps=4.58 mult=1 m=1
XMPH_op0_0000_rl_s0p1_r0_dm002p0 vp_op0_0000_rl_s0p1_r0_dm002p0 enb_op0_0000_rl_s0p1_r0_dm002p0 vdd vdd sky130_fd_pr__pfet_01v8 L=0.15 W=4 nf=1 ad=1.16 as=1.16 pd=8.58 ps=8.58 mult=1 m=1
bd_op0_0000_rl_s0p1_r0_dm002p0 d_op0_0000_rl_s0p1_r0_dm002p0 0 v=v(rbl_op0_0000_rl_s0p1_r0_dm002p0)-v(ref_op0_0000_rl_s0p1_r0_dm002p0)

* ---- instance 237: op1_0900_rl_s0p1_r0_dp000p0 (variant rl_s0p1_r0_dp000p0; probe dec 11.9 ns, release 34 ns, meas 36 ns) ----
vctl_op1_0900_rl_s0p1_r0_dp000p0 ctl_op1_0900_rl_s0p1_r0_dp000p0 0 pwl(0.0000e+00 {VDD} 2.0000e-09 {VDD} 2.1000e-09 0)
* RWL driver model (EXPERIMENTAL): slew 0.1 ns, series R 0 ohm; cell pin = rwls_op1_0900_rl_s0p1_r0_dp000p0
vrs_op1_0900_rl_s0p1_r0_dp000p0 rwls_op1_0900_rl_s0p1_r0_dp000p0 0 pwl(0.0000e+00 {VDD} 2.0000e-09 {VDD} 2.1000e-09 0 3.2000e-08 0 3.2100e-08 {VDD})
ven_op1_0900_rl_s0p1_r0_dp000p0 en_op1_0900_rl_s0p1_r0_dp000p0 0 pwl(0.0000e+00 0 1.1000e-08 0 1.1100e-08 {VDD} 3.4000e-08 {VDD} 3.4100e-08 0)
venb_op1_0900_rl_s0p1_r0_dp000p0 enb_op1_0900_rl_s0p1_r0_dp000p0 0 pwl(0.0000e+00 {VDD} 1.1000e-08 {VDD} 1.1100e-08 0 3.4000e-08 0 3.4100e-08 {VDD})
vww_op1_0900_rl_s0p1_r0_dp000p0 wwl_op1_0900_rl_s0p1_r0_dp000p0 0 pwl(0.0000e+00 0 1.2000e-08 0 1.2100e-08 {VDD} 3.2000e-08 {VDD} 3.2100e-08 0)
vwc_op1_0900_rl_s0p1_r0_dp000p0 wbc_op1_0900_rl_s0p1_r0_dp000p0 0 pwl(0.0000e+00 0 1.2000e-08 0 1.2100e-08 {VDD} 3.4000e-08 {VDD} 3.4100e-08 0)
swb_op1_0900_rl_s0p1_r0_dp000p0 ref_op1_0900_rl_s0p1_r0_dp000p0 wbl_op1_0900_rl_s0p1_r0_dp000p0 wbc_op1_0900_rl_s0p1_r0_dp000p0 0 swwbl
cwbl_op1_0900_rl_s0p1_r0_dp000p0 wbl_op1_0900_rl_s0p1_r0_dp000p0 0 {C_WBL}
spa_op1_0900_rl_s0p1_r0_dp000p0 prea rbl_op1_0900_rl_s0p1_r0_dp000p0 ctl_op1_0900_rl_s0p1_r0_dp000p0 0 swpre
spr_op1_0900_rl_s0p1_r0_dp000p0 pref ref_op1_0900_rl_s0p1_r0_dp000p0 ctl_op1_0900_rl_s0p1_r0_dp000p0 0 swpre
crbl_op1_0900_rl_s0p1_r0_dp000p0 rbl_op1_0900_rl_s0p1_r0_dp000p0 0 {C_RBL}
cref_op1_0900_rl_s0p1_r0_dp000p0 ref_op1_0900_rl_s0p1_r0_dp000p0 0 {C_RBL}   $ ASSUMPTION: ideal matched dummy load
XMWR_op1_0900_rl_s0p1_r0_dp000p0_0 sn_op1_0900_rl_s0p1_r0_dp000p0_0 wwl_op1_0900_rl_s0p1_r0_dp000p0 wbl_op1_0900_rl_s0p1_r0_dp000p0 0 sky130_fd_pr__nfet_01v8 L=0.15 W=0.42 nf=1 ad=0.1218 as=0.1218 pd=1.42 ps=1.42 nrd=0.69047619047619  nrs=0.69047619047619 sa=0 sb=0 sd=0 mult=1 m=1
XMRD_op1_0900_rl_s0p1_r0_dp000p0_0 rbl_op1_0900_rl_s0p1_r0_dp000p0 sn_op1_0900_rl_s0p1_r0_dp000p0_0 rwls_op1_0900_rl_s0p1_r0_dp000p0 0 sky130_fd_pr__nfet_01v8 L=0.15 W=0.42 nf=1 ad=0.1218 as=0.1218 pd=1.42 ps=1.42 nrd=0.69047619047619  nrs=0.69047619047619 sa=0 sb=0 sd=0 mult=1 m=1
csn_op1_0900_rl_s0p1_r0_dp000p0_0 sn_op1_0900_rl_s0p1_r0_dp000p0_0 0 {C_SN}
XMWR_op1_0900_rl_s0p1_r0_dp000p0_1 sn_op1_0900_rl_s0p1_r0_dp000p0_1 wwl_des wbl_op1_0900_rl_s0p1_r0_dp000p0 0 sky130_fd_pr__nfet_01v8 L=0.15 W=0.42 nf=1 ad=0.1218 as=0.1218 pd=1.42 ps=1.42 nrd=0.69047619047619  nrs=0.69047619047619 sa=0 sb=0 sd=0 mult=1 m=1
XMRD_op1_0900_rl_s0p1_r0_dp000p0_1 rbl_op1_0900_rl_s0p1_r0_dp000p0 sn_op1_0900_rl_s0p1_r0_dp000p0_1 rwl_des 0 sky130_fd_pr__nfet_01v8 L=0.15 W=0.42 nf=1 ad=0.1218 as=0.1218 pd=1.42 ps=1.42 nrd=0.69047619047619  nrs=0.69047619047619 sa=0 sb=0 sd=0 mult=1 m=1
csn_op1_0900_rl_s0p1_r0_dp000p0_1 sn_op1_0900_rl_s0p1_r0_dp000p0_1 0 {C_SN}
XMWR_op1_0900_rl_s0p1_r0_dp000p0_2 sn_op1_0900_rl_s0p1_r0_dp000p0_2 wwl_des wbl_op1_0900_rl_s0p1_r0_dp000p0 0 sky130_fd_pr__nfet_01v8 L=0.15 W=0.42 nf=1 ad=0.1218 as=0.1218 pd=1.42 ps=1.42 nrd=0.69047619047619  nrs=0.69047619047619 sa=0 sb=0 sd=0 mult=1 m=1
XMRD_op1_0900_rl_s0p1_r0_dp000p0_2 rbl_op1_0900_rl_s0p1_r0_dp000p0 sn_op1_0900_rl_s0p1_r0_dp000p0_2 rwl_des 0 sky130_fd_pr__nfet_01v8 L=0.15 W=0.42 nf=1 ad=0.1218 as=0.1218 pd=1.42 ps=1.42 nrd=0.69047619047619  nrs=0.69047619047619 sa=0 sb=0 sd=0 mult=1 m=1
csn_op1_0900_rl_s0p1_r0_dp000p0_2 sn_op1_0900_rl_s0p1_r0_dp000p0_2 0 {C_SN}
XMWR_op1_0900_rl_s0p1_r0_dp000p0_3 sn_op1_0900_rl_s0p1_r0_dp000p0_3 wwl_des wbl_op1_0900_rl_s0p1_r0_dp000p0 0 sky130_fd_pr__nfet_01v8 L=0.15 W=0.42 nf=1 ad=0.1218 as=0.1218 pd=1.42 ps=1.42 nrd=0.69047619047619  nrs=0.69047619047619 sa=0 sb=0 sd=0 mult=1 m=1
XMRD_op1_0900_rl_s0p1_r0_dp000p0_3 rbl_op1_0900_rl_s0p1_r0_dp000p0 sn_op1_0900_rl_s0p1_r0_dp000p0_3 rwl_des 0 sky130_fd_pr__nfet_01v8 L=0.15 W=0.42 nf=1 ad=0.1218 as=0.1218 pd=1.42 ps=1.42 nrd=0.69047619047619  nrs=0.69047619047619 sa=0 sb=0 sd=0 mult=1 m=1
csn_op1_0900_rl_s0p1_r0_dp000p0_3 sn_op1_0900_rl_s0p1_r0_dp000p0_3 0 {C_SN}
XMN1_op1_0900_rl_s0p1_r0_dp000p0 rbl_op1_0900_rl_s0p1_r0_dp000p0 ref_op1_0900_rl_s0p1_r0_dp000p0 vn_op1_0900_rl_s0p1_r0_dp000p0 0 sky130_fd_pr__nfet_01v8 L=0.15 W=1 nf=1 ad=0.29 as=0.29 pd=2.58 ps=2.58 mult=1 m=1
XMN2_op1_0900_rl_s0p1_r0_dp000p0 ref_op1_0900_rl_s0p1_r0_dp000p0 rbl_op1_0900_rl_s0p1_r0_dp000p0 vn_op1_0900_rl_s0p1_r0_dp000p0 0 sky130_fd_pr__nfet_01v8 L=0.15 W=1 nf=1 ad=0.29 as=0.29 pd=2.58 ps=2.58 mult=1 m=1
XMP1_op1_0900_rl_s0p1_r0_dp000p0 rbl_op1_0900_rl_s0p1_r0_dp000p0 ref_op1_0900_rl_s0p1_r0_dp000p0 vp_op1_0900_rl_s0p1_r0_dp000p0 vdd sky130_fd_pr__pfet_01v8 L=0.15 W=2 nf=1 ad=0.58 as=0.58 pd=4.58 ps=4.58 mult=1 m=1
XMP2_op1_0900_rl_s0p1_r0_dp000p0 ref_op1_0900_rl_s0p1_r0_dp000p0 rbl_op1_0900_rl_s0p1_r0_dp000p0 vp_op1_0900_rl_s0p1_r0_dp000p0 vdd sky130_fd_pr__pfet_01v8 L=0.15 W=2 nf=1 ad=0.58 as=0.58 pd=4.58 ps=4.58 mult=1 m=1
XMNF_op1_0900_rl_s0p1_r0_dp000p0 vn_op1_0900_rl_s0p1_r0_dp000p0 en_op1_0900_rl_s0p1_r0_dp000p0 0 0 sky130_fd_pr__nfet_01v8 L=0.15 W=2 nf=1 ad=0.58 as=0.58 pd=4.58 ps=4.58 mult=1 m=1
XMPH_op1_0900_rl_s0p1_r0_dp000p0 vp_op1_0900_rl_s0p1_r0_dp000p0 enb_op1_0900_rl_s0p1_r0_dp000p0 vdd vdd sky130_fd_pr__pfet_01v8 L=0.15 W=4 nf=1 ad=1.16 as=1.16 pd=8.58 ps=8.58 mult=1 m=1
bd_op1_0900_rl_s0p1_r0_dp000p0 d_op1_0900_rl_s0p1_r0_dp000p0 0 v=v(rbl_op1_0900_rl_s0p1_r0_dp000p0)-v(ref_op1_0900_rl_s0p1_r0_dp000p0)

* ---- instance 238: op1_1000_rl_s0p1_r0_dp000p0 (variant rl_s0p1_r0_dp000p0; probe dec 11.9 ns, release 34 ns, meas 36 ns) ----
vctl_op1_1000_rl_s0p1_r0_dp000p0 ctl_op1_1000_rl_s0p1_r0_dp000p0 0 pwl(0.0000e+00 {VDD} 2.0000e-09 {VDD} 2.1000e-09 0)
* RWL driver model (EXPERIMENTAL): slew 0.1 ns, series R 0 ohm; cell pin = rwls_op1_1000_rl_s0p1_r0_dp000p0
vrs_op1_1000_rl_s0p1_r0_dp000p0 rwls_op1_1000_rl_s0p1_r0_dp000p0 0 pwl(0.0000e+00 {VDD} 2.0000e-09 {VDD} 2.1000e-09 0 3.2000e-08 0 3.2100e-08 {VDD})
ven_op1_1000_rl_s0p1_r0_dp000p0 en_op1_1000_rl_s0p1_r0_dp000p0 0 pwl(0.0000e+00 0 1.1000e-08 0 1.1100e-08 {VDD} 3.4000e-08 {VDD} 3.4100e-08 0)
venb_op1_1000_rl_s0p1_r0_dp000p0 enb_op1_1000_rl_s0p1_r0_dp000p0 0 pwl(0.0000e+00 {VDD} 1.1000e-08 {VDD} 1.1100e-08 0 3.4000e-08 0 3.4100e-08 {VDD})
vww_op1_1000_rl_s0p1_r0_dp000p0 wwl_op1_1000_rl_s0p1_r0_dp000p0 0 pwl(0.0000e+00 0 1.2000e-08 0 1.2100e-08 {VDD} 3.2000e-08 {VDD} 3.2100e-08 0)
vwc_op1_1000_rl_s0p1_r0_dp000p0 wbc_op1_1000_rl_s0p1_r0_dp000p0 0 pwl(0.0000e+00 0 1.2000e-08 0 1.2100e-08 {VDD} 3.4000e-08 {VDD} 3.4100e-08 0)
swb_op1_1000_rl_s0p1_r0_dp000p0 ref_op1_1000_rl_s0p1_r0_dp000p0 wbl_op1_1000_rl_s0p1_r0_dp000p0 wbc_op1_1000_rl_s0p1_r0_dp000p0 0 swwbl
cwbl_op1_1000_rl_s0p1_r0_dp000p0 wbl_op1_1000_rl_s0p1_r0_dp000p0 0 {C_WBL}
spa_op1_1000_rl_s0p1_r0_dp000p0 prea rbl_op1_1000_rl_s0p1_r0_dp000p0 ctl_op1_1000_rl_s0p1_r0_dp000p0 0 swpre
spr_op1_1000_rl_s0p1_r0_dp000p0 pref ref_op1_1000_rl_s0p1_r0_dp000p0 ctl_op1_1000_rl_s0p1_r0_dp000p0 0 swpre
crbl_op1_1000_rl_s0p1_r0_dp000p0 rbl_op1_1000_rl_s0p1_r0_dp000p0 0 {C_RBL}
cref_op1_1000_rl_s0p1_r0_dp000p0 ref_op1_1000_rl_s0p1_r0_dp000p0 0 {C_RBL}   $ ASSUMPTION: ideal matched dummy load
XMWR_op1_1000_rl_s0p1_r0_dp000p0_0 sn_op1_1000_rl_s0p1_r0_dp000p0_0 wwl_op1_1000_rl_s0p1_r0_dp000p0 wbl_op1_1000_rl_s0p1_r0_dp000p0 0 sky130_fd_pr__nfet_01v8 L=0.15 W=0.42 nf=1 ad=0.1218 as=0.1218 pd=1.42 ps=1.42 nrd=0.69047619047619  nrs=0.69047619047619 sa=0 sb=0 sd=0 mult=1 m=1
XMRD_op1_1000_rl_s0p1_r0_dp000p0_0 rbl_op1_1000_rl_s0p1_r0_dp000p0 sn_op1_1000_rl_s0p1_r0_dp000p0_0 rwls_op1_1000_rl_s0p1_r0_dp000p0 0 sky130_fd_pr__nfet_01v8 L=0.15 W=0.42 nf=1 ad=0.1218 as=0.1218 pd=1.42 ps=1.42 nrd=0.69047619047619  nrs=0.69047619047619 sa=0 sb=0 sd=0 mult=1 m=1
csn_op1_1000_rl_s0p1_r0_dp000p0_0 sn_op1_1000_rl_s0p1_r0_dp000p0_0 0 {C_SN}
XMWR_op1_1000_rl_s0p1_r0_dp000p0_1 sn_op1_1000_rl_s0p1_r0_dp000p0_1 wwl_des wbl_op1_1000_rl_s0p1_r0_dp000p0 0 sky130_fd_pr__nfet_01v8 L=0.15 W=0.42 nf=1 ad=0.1218 as=0.1218 pd=1.42 ps=1.42 nrd=0.69047619047619  nrs=0.69047619047619 sa=0 sb=0 sd=0 mult=1 m=1
XMRD_op1_1000_rl_s0p1_r0_dp000p0_1 rbl_op1_1000_rl_s0p1_r0_dp000p0 sn_op1_1000_rl_s0p1_r0_dp000p0_1 rwl_des 0 sky130_fd_pr__nfet_01v8 L=0.15 W=0.42 nf=1 ad=0.1218 as=0.1218 pd=1.42 ps=1.42 nrd=0.69047619047619  nrs=0.69047619047619 sa=0 sb=0 sd=0 mult=1 m=1
csn_op1_1000_rl_s0p1_r0_dp000p0_1 sn_op1_1000_rl_s0p1_r0_dp000p0_1 0 {C_SN}
XMWR_op1_1000_rl_s0p1_r0_dp000p0_2 sn_op1_1000_rl_s0p1_r0_dp000p0_2 wwl_des wbl_op1_1000_rl_s0p1_r0_dp000p0 0 sky130_fd_pr__nfet_01v8 L=0.15 W=0.42 nf=1 ad=0.1218 as=0.1218 pd=1.42 ps=1.42 nrd=0.69047619047619  nrs=0.69047619047619 sa=0 sb=0 sd=0 mult=1 m=1
XMRD_op1_1000_rl_s0p1_r0_dp000p0_2 rbl_op1_1000_rl_s0p1_r0_dp000p0 sn_op1_1000_rl_s0p1_r0_dp000p0_2 rwl_des 0 sky130_fd_pr__nfet_01v8 L=0.15 W=0.42 nf=1 ad=0.1218 as=0.1218 pd=1.42 ps=1.42 nrd=0.69047619047619  nrs=0.69047619047619 sa=0 sb=0 sd=0 mult=1 m=1
csn_op1_1000_rl_s0p1_r0_dp000p0_2 sn_op1_1000_rl_s0p1_r0_dp000p0_2 0 {C_SN}
XMWR_op1_1000_rl_s0p1_r0_dp000p0_3 sn_op1_1000_rl_s0p1_r0_dp000p0_3 wwl_des wbl_op1_1000_rl_s0p1_r0_dp000p0 0 sky130_fd_pr__nfet_01v8 L=0.15 W=0.42 nf=1 ad=0.1218 as=0.1218 pd=1.42 ps=1.42 nrd=0.69047619047619  nrs=0.69047619047619 sa=0 sb=0 sd=0 mult=1 m=1
XMRD_op1_1000_rl_s0p1_r0_dp000p0_3 rbl_op1_1000_rl_s0p1_r0_dp000p0 sn_op1_1000_rl_s0p1_r0_dp000p0_3 rwl_des 0 sky130_fd_pr__nfet_01v8 L=0.15 W=0.42 nf=1 ad=0.1218 as=0.1218 pd=1.42 ps=1.42 nrd=0.69047619047619  nrs=0.69047619047619 sa=0 sb=0 sd=0 mult=1 m=1
csn_op1_1000_rl_s0p1_r0_dp000p0_3 sn_op1_1000_rl_s0p1_r0_dp000p0_3 0 {C_SN}
XMN1_op1_1000_rl_s0p1_r0_dp000p0 rbl_op1_1000_rl_s0p1_r0_dp000p0 ref_op1_1000_rl_s0p1_r0_dp000p0 vn_op1_1000_rl_s0p1_r0_dp000p0 0 sky130_fd_pr__nfet_01v8 L=0.15 W=1 nf=1 ad=0.29 as=0.29 pd=2.58 ps=2.58 mult=1 m=1
XMN2_op1_1000_rl_s0p1_r0_dp000p0 ref_op1_1000_rl_s0p1_r0_dp000p0 rbl_op1_1000_rl_s0p1_r0_dp000p0 vn_op1_1000_rl_s0p1_r0_dp000p0 0 sky130_fd_pr__nfet_01v8 L=0.15 W=1 nf=1 ad=0.29 as=0.29 pd=2.58 ps=2.58 mult=1 m=1
XMP1_op1_1000_rl_s0p1_r0_dp000p0 rbl_op1_1000_rl_s0p1_r0_dp000p0 ref_op1_1000_rl_s0p1_r0_dp000p0 vp_op1_1000_rl_s0p1_r0_dp000p0 vdd sky130_fd_pr__pfet_01v8 L=0.15 W=2 nf=1 ad=0.58 as=0.58 pd=4.58 ps=4.58 mult=1 m=1
XMP2_op1_1000_rl_s0p1_r0_dp000p0 ref_op1_1000_rl_s0p1_r0_dp000p0 rbl_op1_1000_rl_s0p1_r0_dp000p0 vp_op1_1000_rl_s0p1_r0_dp000p0 vdd sky130_fd_pr__pfet_01v8 L=0.15 W=2 nf=1 ad=0.58 as=0.58 pd=4.58 ps=4.58 mult=1 m=1
XMNF_op1_1000_rl_s0p1_r0_dp000p0 vn_op1_1000_rl_s0p1_r0_dp000p0 en_op1_1000_rl_s0p1_r0_dp000p0 0 0 sky130_fd_pr__nfet_01v8 L=0.15 W=2 nf=1 ad=0.58 as=0.58 pd=4.58 ps=4.58 mult=1 m=1
XMPH_op1_1000_rl_s0p1_r0_dp000p0 vp_op1_1000_rl_s0p1_r0_dp000p0 enb_op1_1000_rl_s0p1_r0_dp000p0 vdd vdd sky130_fd_pr__pfet_01v8 L=0.15 W=4 nf=1 ad=1.16 as=1.16 pd=8.58 ps=8.58 mult=1 m=1
bd_op1_1000_rl_s0p1_r0_dp000p0 d_op1_1000_rl_s0p1_r0_dp000p0 0 v=v(rbl_op1_1000_rl_s0p1_r0_dp000p0)-v(ref_op1_1000_rl_s0p1_r0_dp000p0)

* ---- instance 239: op0_n100_rl_s0p1_r0_dp000p0 (variant rl_s0p1_r0_dp000p0; probe dec 11.9 ns, release 34 ns, meas 36 ns) ----
vctl_op0_n100_rl_s0p1_r0_dp000p0 ctl_op0_n100_rl_s0p1_r0_dp000p0 0 pwl(0.0000e+00 {VDD} 2.0000e-09 {VDD} 2.1000e-09 0)
* RWL driver model (EXPERIMENTAL): slew 0.1 ns, series R 0 ohm; cell pin = rwls_op0_n100_rl_s0p1_r0_dp000p0
vrs_op0_n100_rl_s0p1_r0_dp000p0 rwls_op0_n100_rl_s0p1_r0_dp000p0 0 pwl(0.0000e+00 {VDD} 2.0000e-09 {VDD} 2.1000e-09 0 3.2000e-08 0 3.2100e-08 {VDD})
ven_op0_n100_rl_s0p1_r0_dp000p0 en_op0_n100_rl_s0p1_r0_dp000p0 0 pwl(0.0000e+00 0 1.1000e-08 0 1.1100e-08 {VDD} 3.4000e-08 {VDD} 3.4100e-08 0)
venb_op0_n100_rl_s0p1_r0_dp000p0 enb_op0_n100_rl_s0p1_r0_dp000p0 0 pwl(0.0000e+00 {VDD} 1.1000e-08 {VDD} 1.1100e-08 0 3.4000e-08 0 3.4100e-08 {VDD})
vww_op0_n100_rl_s0p1_r0_dp000p0 wwl_op0_n100_rl_s0p1_r0_dp000p0 0 pwl(0.0000e+00 0 1.2000e-08 0 1.2100e-08 {VDD} 3.2000e-08 {VDD} 3.2100e-08 0)
vwc_op0_n100_rl_s0p1_r0_dp000p0 wbc_op0_n100_rl_s0p1_r0_dp000p0 0 pwl(0.0000e+00 0 1.2000e-08 0 1.2100e-08 {VDD} 3.4000e-08 {VDD} 3.4100e-08 0)
swb_op0_n100_rl_s0p1_r0_dp000p0 ref_op0_n100_rl_s0p1_r0_dp000p0 wbl_op0_n100_rl_s0p1_r0_dp000p0 wbc_op0_n100_rl_s0p1_r0_dp000p0 0 swwbl
cwbl_op0_n100_rl_s0p1_r0_dp000p0 wbl_op0_n100_rl_s0p1_r0_dp000p0 0 {C_WBL}
spa_op0_n100_rl_s0p1_r0_dp000p0 prea rbl_op0_n100_rl_s0p1_r0_dp000p0 ctl_op0_n100_rl_s0p1_r0_dp000p0 0 swpre
spr_op0_n100_rl_s0p1_r0_dp000p0 pref ref_op0_n100_rl_s0p1_r0_dp000p0 ctl_op0_n100_rl_s0p1_r0_dp000p0 0 swpre
crbl_op0_n100_rl_s0p1_r0_dp000p0 rbl_op0_n100_rl_s0p1_r0_dp000p0 0 {C_RBL}
cref_op0_n100_rl_s0p1_r0_dp000p0 ref_op0_n100_rl_s0p1_r0_dp000p0 0 {C_RBL}   $ ASSUMPTION: ideal matched dummy load
XMWR_op0_n100_rl_s0p1_r0_dp000p0_0 sn_op0_n100_rl_s0p1_r0_dp000p0_0 wwl_op0_n100_rl_s0p1_r0_dp000p0 wbl_op0_n100_rl_s0p1_r0_dp000p0 0 sky130_fd_pr__nfet_01v8 L=0.15 W=0.42 nf=1 ad=0.1218 as=0.1218 pd=1.42 ps=1.42 nrd=0.69047619047619  nrs=0.69047619047619 sa=0 sb=0 sd=0 mult=1 m=1
XMRD_op0_n100_rl_s0p1_r0_dp000p0_0 rbl_op0_n100_rl_s0p1_r0_dp000p0 sn_op0_n100_rl_s0p1_r0_dp000p0_0 rwls_op0_n100_rl_s0p1_r0_dp000p0 0 sky130_fd_pr__nfet_01v8 L=0.15 W=0.42 nf=1 ad=0.1218 as=0.1218 pd=1.42 ps=1.42 nrd=0.69047619047619  nrs=0.69047619047619 sa=0 sb=0 sd=0 mult=1 m=1
csn_op0_n100_rl_s0p1_r0_dp000p0_0 sn_op0_n100_rl_s0p1_r0_dp000p0_0 0 {C_SN}
XMWR_op0_n100_rl_s0p1_r0_dp000p0_1 sn_op0_n100_rl_s0p1_r0_dp000p0_1 wwl_des wbl_op0_n100_rl_s0p1_r0_dp000p0 0 sky130_fd_pr__nfet_01v8 L=0.15 W=0.42 nf=1 ad=0.1218 as=0.1218 pd=1.42 ps=1.42 nrd=0.69047619047619  nrs=0.69047619047619 sa=0 sb=0 sd=0 mult=1 m=1
XMRD_op0_n100_rl_s0p1_r0_dp000p0_1 rbl_op0_n100_rl_s0p1_r0_dp000p0 sn_op0_n100_rl_s0p1_r0_dp000p0_1 rwl_des 0 sky130_fd_pr__nfet_01v8 L=0.15 W=0.42 nf=1 ad=0.1218 as=0.1218 pd=1.42 ps=1.42 nrd=0.69047619047619  nrs=0.69047619047619 sa=0 sb=0 sd=0 mult=1 m=1
csn_op0_n100_rl_s0p1_r0_dp000p0_1 sn_op0_n100_rl_s0p1_r0_dp000p0_1 0 {C_SN}
XMWR_op0_n100_rl_s0p1_r0_dp000p0_2 sn_op0_n100_rl_s0p1_r0_dp000p0_2 wwl_des wbl_op0_n100_rl_s0p1_r0_dp000p0 0 sky130_fd_pr__nfet_01v8 L=0.15 W=0.42 nf=1 ad=0.1218 as=0.1218 pd=1.42 ps=1.42 nrd=0.69047619047619  nrs=0.69047619047619 sa=0 sb=0 sd=0 mult=1 m=1
XMRD_op0_n100_rl_s0p1_r0_dp000p0_2 rbl_op0_n100_rl_s0p1_r0_dp000p0 sn_op0_n100_rl_s0p1_r0_dp000p0_2 rwl_des 0 sky130_fd_pr__nfet_01v8 L=0.15 W=0.42 nf=1 ad=0.1218 as=0.1218 pd=1.42 ps=1.42 nrd=0.69047619047619  nrs=0.69047619047619 sa=0 sb=0 sd=0 mult=1 m=1
csn_op0_n100_rl_s0p1_r0_dp000p0_2 sn_op0_n100_rl_s0p1_r0_dp000p0_2 0 {C_SN}
XMWR_op0_n100_rl_s0p1_r0_dp000p0_3 sn_op0_n100_rl_s0p1_r0_dp000p0_3 wwl_des wbl_op0_n100_rl_s0p1_r0_dp000p0 0 sky130_fd_pr__nfet_01v8 L=0.15 W=0.42 nf=1 ad=0.1218 as=0.1218 pd=1.42 ps=1.42 nrd=0.69047619047619  nrs=0.69047619047619 sa=0 sb=0 sd=0 mult=1 m=1
XMRD_op0_n100_rl_s0p1_r0_dp000p0_3 rbl_op0_n100_rl_s0p1_r0_dp000p0 sn_op0_n100_rl_s0p1_r0_dp000p0_3 rwl_des 0 sky130_fd_pr__nfet_01v8 L=0.15 W=0.42 nf=1 ad=0.1218 as=0.1218 pd=1.42 ps=1.42 nrd=0.69047619047619  nrs=0.69047619047619 sa=0 sb=0 sd=0 mult=1 m=1
csn_op0_n100_rl_s0p1_r0_dp000p0_3 sn_op0_n100_rl_s0p1_r0_dp000p0_3 0 {C_SN}
XMN1_op0_n100_rl_s0p1_r0_dp000p0 rbl_op0_n100_rl_s0p1_r0_dp000p0 ref_op0_n100_rl_s0p1_r0_dp000p0 vn_op0_n100_rl_s0p1_r0_dp000p0 0 sky130_fd_pr__nfet_01v8 L=0.15 W=1 nf=1 ad=0.29 as=0.29 pd=2.58 ps=2.58 mult=1 m=1
XMN2_op0_n100_rl_s0p1_r0_dp000p0 ref_op0_n100_rl_s0p1_r0_dp000p0 rbl_op0_n100_rl_s0p1_r0_dp000p0 vn_op0_n100_rl_s0p1_r0_dp000p0 0 sky130_fd_pr__nfet_01v8 L=0.15 W=1 nf=1 ad=0.29 as=0.29 pd=2.58 ps=2.58 mult=1 m=1
XMP1_op0_n100_rl_s0p1_r0_dp000p0 rbl_op0_n100_rl_s0p1_r0_dp000p0 ref_op0_n100_rl_s0p1_r0_dp000p0 vp_op0_n100_rl_s0p1_r0_dp000p0 vdd sky130_fd_pr__pfet_01v8 L=0.15 W=2 nf=1 ad=0.58 as=0.58 pd=4.58 ps=4.58 mult=1 m=1
XMP2_op0_n100_rl_s0p1_r0_dp000p0 ref_op0_n100_rl_s0p1_r0_dp000p0 rbl_op0_n100_rl_s0p1_r0_dp000p0 vp_op0_n100_rl_s0p1_r0_dp000p0 vdd sky130_fd_pr__pfet_01v8 L=0.15 W=2 nf=1 ad=0.58 as=0.58 pd=4.58 ps=4.58 mult=1 m=1
XMNF_op0_n100_rl_s0p1_r0_dp000p0 vn_op0_n100_rl_s0p1_r0_dp000p0 en_op0_n100_rl_s0p1_r0_dp000p0 0 0 sky130_fd_pr__nfet_01v8 L=0.15 W=2 nf=1 ad=0.58 as=0.58 pd=4.58 ps=4.58 mult=1 m=1
XMPH_op0_n100_rl_s0p1_r0_dp000p0 vp_op0_n100_rl_s0p1_r0_dp000p0 enb_op0_n100_rl_s0p1_r0_dp000p0 vdd vdd sky130_fd_pr__pfet_01v8 L=0.15 W=4 nf=1 ad=1.16 as=1.16 pd=8.58 ps=8.58 mult=1 m=1
bd_op0_n100_rl_s0p1_r0_dp000p0 d_op0_n100_rl_s0p1_r0_dp000p0 0 v=v(rbl_op0_n100_rl_s0p1_r0_dp000p0)-v(ref_op0_n100_rl_s0p1_r0_dp000p0)

* ---- instance 240: op0_0000_rl_s0p1_r0_dp000p0 (variant rl_s0p1_r0_dp000p0; probe dec 11.9 ns, release 34 ns, meas 36 ns) ----
vctl_op0_0000_rl_s0p1_r0_dp000p0 ctl_op0_0000_rl_s0p1_r0_dp000p0 0 pwl(0.0000e+00 {VDD} 2.0000e-09 {VDD} 2.1000e-09 0)
* RWL driver model (EXPERIMENTAL): slew 0.1 ns, series R 0 ohm; cell pin = rwls_op0_0000_rl_s0p1_r0_dp000p0
vrs_op0_0000_rl_s0p1_r0_dp000p0 rwls_op0_0000_rl_s0p1_r0_dp000p0 0 pwl(0.0000e+00 {VDD} 2.0000e-09 {VDD} 2.1000e-09 0 3.2000e-08 0 3.2100e-08 {VDD})
ven_op0_0000_rl_s0p1_r0_dp000p0 en_op0_0000_rl_s0p1_r0_dp000p0 0 pwl(0.0000e+00 0 1.1000e-08 0 1.1100e-08 {VDD} 3.4000e-08 {VDD} 3.4100e-08 0)
venb_op0_0000_rl_s0p1_r0_dp000p0 enb_op0_0000_rl_s0p1_r0_dp000p0 0 pwl(0.0000e+00 {VDD} 1.1000e-08 {VDD} 1.1100e-08 0 3.4000e-08 0 3.4100e-08 {VDD})
vww_op0_0000_rl_s0p1_r0_dp000p0 wwl_op0_0000_rl_s0p1_r0_dp000p0 0 pwl(0.0000e+00 0 1.2000e-08 0 1.2100e-08 {VDD} 3.2000e-08 {VDD} 3.2100e-08 0)
vwc_op0_0000_rl_s0p1_r0_dp000p0 wbc_op0_0000_rl_s0p1_r0_dp000p0 0 pwl(0.0000e+00 0 1.2000e-08 0 1.2100e-08 {VDD} 3.4000e-08 {VDD} 3.4100e-08 0)
swb_op0_0000_rl_s0p1_r0_dp000p0 ref_op0_0000_rl_s0p1_r0_dp000p0 wbl_op0_0000_rl_s0p1_r0_dp000p0 wbc_op0_0000_rl_s0p1_r0_dp000p0 0 swwbl
cwbl_op0_0000_rl_s0p1_r0_dp000p0 wbl_op0_0000_rl_s0p1_r0_dp000p0 0 {C_WBL}
spa_op0_0000_rl_s0p1_r0_dp000p0 prea rbl_op0_0000_rl_s0p1_r0_dp000p0 ctl_op0_0000_rl_s0p1_r0_dp000p0 0 swpre
spr_op0_0000_rl_s0p1_r0_dp000p0 pref ref_op0_0000_rl_s0p1_r0_dp000p0 ctl_op0_0000_rl_s0p1_r0_dp000p0 0 swpre
crbl_op0_0000_rl_s0p1_r0_dp000p0 rbl_op0_0000_rl_s0p1_r0_dp000p0 0 {C_RBL}
cref_op0_0000_rl_s0p1_r0_dp000p0 ref_op0_0000_rl_s0p1_r0_dp000p0 0 {C_RBL}   $ ASSUMPTION: ideal matched dummy load
XMWR_op0_0000_rl_s0p1_r0_dp000p0_0 sn_op0_0000_rl_s0p1_r0_dp000p0_0 wwl_op0_0000_rl_s0p1_r0_dp000p0 wbl_op0_0000_rl_s0p1_r0_dp000p0 0 sky130_fd_pr__nfet_01v8 L=0.15 W=0.42 nf=1 ad=0.1218 as=0.1218 pd=1.42 ps=1.42 nrd=0.69047619047619  nrs=0.69047619047619 sa=0 sb=0 sd=0 mult=1 m=1
XMRD_op0_0000_rl_s0p1_r0_dp000p0_0 rbl_op0_0000_rl_s0p1_r0_dp000p0 sn_op0_0000_rl_s0p1_r0_dp000p0_0 rwls_op0_0000_rl_s0p1_r0_dp000p0 0 sky130_fd_pr__nfet_01v8 L=0.15 W=0.42 nf=1 ad=0.1218 as=0.1218 pd=1.42 ps=1.42 nrd=0.69047619047619  nrs=0.69047619047619 sa=0 sb=0 sd=0 mult=1 m=1
csn_op0_0000_rl_s0p1_r0_dp000p0_0 sn_op0_0000_rl_s0p1_r0_dp000p0_0 0 {C_SN}
XMWR_op0_0000_rl_s0p1_r0_dp000p0_1 sn_op0_0000_rl_s0p1_r0_dp000p0_1 wwl_des wbl_op0_0000_rl_s0p1_r0_dp000p0 0 sky130_fd_pr__nfet_01v8 L=0.15 W=0.42 nf=1 ad=0.1218 as=0.1218 pd=1.42 ps=1.42 nrd=0.69047619047619  nrs=0.69047619047619 sa=0 sb=0 sd=0 mult=1 m=1
XMRD_op0_0000_rl_s0p1_r0_dp000p0_1 rbl_op0_0000_rl_s0p1_r0_dp000p0 sn_op0_0000_rl_s0p1_r0_dp000p0_1 rwl_des 0 sky130_fd_pr__nfet_01v8 L=0.15 W=0.42 nf=1 ad=0.1218 as=0.1218 pd=1.42 ps=1.42 nrd=0.69047619047619  nrs=0.69047619047619 sa=0 sb=0 sd=0 mult=1 m=1
csn_op0_0000_rl_s0p1_r0_dp000p0_1 sn_op0_0000_rl_s0p1_r0_dp000p0_1 0 {C_SN}
XMWR_op0_0000_rl_s0p1_r0_dp000p0_2 sn_op0_0000_rl_s0p1_r0_dp000p0_2 wwl_des wbl_op0_0000_rl_s0p1_r0_dp000p0 0 sky130_fd_pr__nfet_01v8 L=0.15 W=0.42 nf=1 ad=0.1218 as=0.1218 pd=1.42 ps=1.42 nrd=0.69047619047619  nrs=0.69047619047619 sa=0 sb=0 sd=0 mult=1 m=1
XMRD_op0_0000_rl_s0p1_r0_dp000p0_2 rbl_op0_0000_rl_s0p1_r0_dp000p0 sn_op0_0000_rl_s0p1_r0_dp000p0_2 rwl_des 0 sky130_fd_pr__nfet_01v8 L=0.15 W=0.42 nf=1 ad=0.1218 as=0.1218 pd=1.42 ps=1.42 nrd=0.69047619047619  nrs=0.69047619047619 sa=0 sb=0 sd=0 mult=1 m=1
csn_op0_0000_rl_s0p1_r0_dp000p0_2 sn_op0_0000_rl_s0p1_r0_dp000p0_2 0 {C_SN}
XMWR_op0_0000_rl_s0p1_r0_dp000p0_3 sn_op0_0000_rl_s0p1_r0_dp000p0_3 wwl_des wbl_op0_0000_rl_s0p1_r0_dp000p0 0 sky130_fd_pr__nfet_01v8 L=0.15 W=0.42 nf=1 ad=0.1218 as=0.1218 pd=1.42 ps=1.42 nrd=0.69047619047619  nrs=0.69047619047619 sa=0 sb=0 sd=0 mult=1 m=1
XMRD_op0_0000_rl_s0p1_r0_dp000p0_3 rbl_op0_0000_rl_s0p1_r0_dp000p0 sn_op0_0000_rl_s0p1_r0_dp000p0_3 rwl_des 0 sky130_fd_pr__nfet_01v8 L=0.15 W=0.42 nf=1 ad=0.1218 as=0.1218 pd=1.42 ps=1.42 nrd=0.69047619047619  nrs=0.69047619047619 sa=0 sb=0 sd=0 mult=1 m=1
csn_op0_0000_rl_s0p1_r0_dp000p0_3 sn_op0_0000_rl_s0p1_r0_dp000p0_3 0 {C_SN}
XMN1_op0_0000_rl_s0p1_r0_dp000p0 rbl_op0_0000_rl_s0p1_r0_dp000p0 ref_op0_0000_rl_s0p1_r0_dp000p0 vn_op0_0000_rl_s0p1_r0_dp000p0 0 sky130_fd_pr__nfet_01v8 L=0.15 W=1 nf=1 ad=0.29 as=0.29 pd=2.58 ps=2.58 mult=1 m=1
XMN2_op0_0000_rl_s0p1_r0_dp000p0 ref_op0_0000_rl_s0p1_r0_dp000p0 rbl_op0_0000_rl_s0p1_r0_dp000p0 vn_op0_0000_rl_s0p1_r0_dp000p0 0 sky130_fd_pr__nfet_01v8 L=0.15 W=1 nf=1 ad=0.29 as=0.29 pd=2.58 ps=2.58 mult=1 m=1
XMP1_op0_0000_rl_s0p1_r0_dp000p0 rbl_op0_0000_rl_s0p1_r0_dp000p0 ref_op0_0000_rl_s0p1_r0_dp000p0 vp_op0_0000_rl_s0p1_r0_dp000p0 vdd sky130_fd_pr__pfet_01v8 L=0.15 W=2 nf=1 ad=0.58 as=0.58 pd=4.58 ps=4.58 mult=1 m=1
XMP2_op0_0000_rl_s0p1_r0_dp000p0 ref_op0_0000_rl_s0p1_r0_dp000p0 rbl_op0_0000_rl_s0p1_r0_dp000p0 vp_op0_0000_rl_s0p1_r0_dp000p0 vdd sky130_fd_pr__pfet_01v8 L=0.15 W=2 nf=1 ad=0.58 as=0.58 pd=4.58 ps=4.58 mult=1 m=1
XMNF_op0_0000_rl_s0p1_r0_dp000p0 vn_op0_0000_rl_s0p1_r0_dp000p0 en_op0_0000_rl_s0p1_r0_dp000p0 0 0 sky130_fd_pr__nfet_01v8 L=0.15 W=2 nf=1 ad=0.58 as=0.58 pd=4.58 ps=4.58 mult=1 m=1
XMPH_op0_0000_rl_s0p1_r0_dp000p0 vp_op0_0000_rl_s0p1_r0_dp000p0 enb_op0_0000_rl_s0p1_r0_dp000p0 vdd vdd sky130_fd_pr__pfet_01v8 L=0.15 W=4 nf=1 ad=1.16 as=1.16 pd=8.58 ps=8.58 mult=1 m=1
bd_op0_0000_rl_s0p1_r0_dp000p0 d_op0_0000_rl_s0p1_r0_dp000p0 0 v=v(rbl_op0_0000_rl_s0p1_r0_dp000p0)-v(ref_op0_0000_rl_s0p1_r0_dp000p0)

* ---- instance 241: op1_0900_rl_s0p1_r0_dp001p0 (variant rl_s0p1_r0_dp001p0; probe dec 11.9 ns, release 34 ns, meas 36 ns) ----
vctl_op1_0900_rl_s0p1_r0_dp001p0 ctl_op1_0900_rl_s0p1_r0_dp001p0 0 pwl(0.0000e+00 {VDD} 2.0000e-09 {VDD} 2.1000e-09 0)
* RWL driver model (EXPERIMENTAL): slew 0.1 ns, series R 0 ohm; cell pin = rwls_op1_0900_rl_s0p1_r0_dp001p0
vrs_op1_0900_rl_s0p1_r0_dp001p0 rwls_op1_0900_rl_s0p1_r0_dp001p0 0 pwl(0.0000e+00 {VDD} 2.0000e-09 {VDD} 2.1000e-09 0 3.3000e-08 0 3.3100e-08 {VDD})
ven_op1_0900_rl_s0p1_r0_dp001p0 en_op1_0900_rl_s0p1_r0_dp001p0 0 pwl(0.0000e+00 0 1.1000e-08 0 1.1100e-08 {VDD} 3.4000e-08 {VDD} 3.4100e-08 0)
venb_op1_0900_rl_s0p1_r0_dp001p0 enb_op1_0900_rl_s0p1_r0_dp001p0 0 pwl(0.0000e+00 {VDD} 1.1000e-08 {VDD} 1.1100e-08 0 3.4000e-08 0 3.4100e-08 {VDD})
vww_op1_0900_rl_s0p1_r0_dp001p0 wwl_op1_0900_rl_s0p1_r0_dp001p0 0 pwl(0.0000e+00 0 1.2000e-08 0 1.2100e-08 {VDD} 3.2000e-08 {VDD} 3.2100e-08 0)
vwc_op1_0900_rl_s0p1_r0_dp001p0 wbc_op1_0900_rl_s0p1_r0_dp001p0 0 pwl(0.0000e+00 0 1.2000e-08 0 1.2100e-08 {VDD} 3.4000e-08 {VDD} 3.4100e-08 0)
swb_op1_0900_rl_s0p1_r0_dp001p0 ref_op1_0900_rl_s0p1_r0_dp001p0 wbl_op1_0900_rl_s0p1_r0_dp001p0 wbc_op1_0900_rl_s0p1_r0_dp001p0 0 swwbl
cwbl_op1_0900_rl_s0p1_r0_dp001p0 wbl_op1_0900_rl_s0p1_r0_dp001p0 0 {C_WBL}
spa_op1_0900_rl_s0p1_r0_dp001p0 prea rbl_op1_0900_rl_s0p1_r0_dp001p0 ctl_op1_0900_rl_s0p1_r0_dp001p0 0 swpre
spr_op1_0900_rl_s0p1_r0_dp001p0 pref ref_op1_0900_rl_s0p1_r0_dp001p0 ctl_op1_0900_rl_s0p1_r0_dp001p0 0 swpre
crbl_op1_0900_rl_s0p1_r0_dp001p0 rbl_op1_0900_rl_s0p1_r0_dp001p0 0 {C_RBL}
cref_op1_0900_rl_s0p1_r0_dp001p0 ref_op1_0900_rl_s0p1_r0_dp001p0 0 {C_RBL}   $ ASSUMPTION: ideal matched dummy load
XMWR_op1_0900_rl_s0p1_r0_dp001p0_0 sn_op1_0900_rl_s0p1_r0_dp001p0_0 wwl_op1_0900_rl_s0p1_r0_dp001p0 wbl_op1_0900_rl_s0p1_r0_dp001p0 0 sky130_fd_pr__nfet_01v8 L=0.15 W=0.42 nf=1 ad=0.1218 as=0.1218 pd=1.42 ps=1.42 nrd=0.69047619047619  nrs=0.69047619047619 sa=0 sb=0 sd=0 mult=1 m=1
XMRD_op1_0900_rl_s0p1_r0_dp001p0_0 rbl_op1_0900_rl_s0p1_r0_dp001p0 sn_op1_0900_rl_s0p1_r0_dp001p0_0 rwls_op1_0900_rl_s0p1_r0_dp001p0 0 sky130_fd_pr__nfet_01v8 L=0.15 W=0.42 nf=1 ad=0.1218 as=0.1218 pd=1.42 ps=1.42 nrd=0.69047619047619  nrs=0.69047619047619 sa=0 sb=0 sd=0 mult=1 m=1
csn_op1_0900_rl_s0p1_r0_dp001p0_0 sn_op1_0900_rl_s0p1_r0_dp001p0_0 0 {C_SN}
XMWR_op1_0900_rl_s0p1_r0_dp001p0_1 sn_op1_0900_rl_s0p1_r0_dp001p0_1 wwl_des wbl_op1_0900_rl_s0p1_r0_dp001p0 0 sky130_fd_pr__nfet_01v8 L=0.15 W=0.42 nf=1 ad=0.1218 as=0.1218 pd=1.42 ps=1.42 nrd=0.69047619047619  nrs=0.69047619047619 sa=0 sb=0 sd=0 mult=1 m=1
XMRD_op1_0900_rl_s0p1_r0_dp001p0_1 rbl_op1_0900_rl_s0p1_r0_dp001p0 sn_op1_0900_rl_s0p1_r0_dp001p0_1 rwl_des 0 sky130_fd_pr__nfet_01v8 L=0.15 W=0.42 nf=1 ad=0.1218 as=0.1218 pd=1.42 ps=1.42 nrd=0.69047619047619  nrs=0.69047619047619 sa=0 sb=0 sd=0 mult=1 m=1
csn_op1_0900_rl_s0p1_r0_dp001p0_1 sn_op1_0900_rl_s0p1_r0_dp001p0_1 0 {C_SN}
XMWR_op1_0900_rl_s0p1_r0_dp001p0_2 sn_op1_0900_rl_s0p1_r0_dp001p0_2 wwl_des wbl_op1_0900_rl_s0p1_r0_dp001p0 0 sky130_fd_pr__nfet_01v8 L=0.15 W=0.42 nf=1 ad=0.1218 as=0.1218 pd=1.42 ps=1.42 nrd=0.69047619047619  nrs=0.69047619047619 sa=0 sb=0 sd=0 mult=1 m=1
XMRD_op1_0900_rl_s0p1_r0_dp001p0_2 rbl_op1_0900_rl_s0p1_r0_dp001p0 sn_op1_0900_rl_s0p1_r0_dp001p0_2 rwl_des 0 sky130_fd_pr__nfet_01v8 L=0.15 W=0.42 nf=1 ad=0.1218 as=0.1218 pd=1.42 ps=1.42 nrd=0.69047619047619  nrs=0.69047619047619 sa=0 sb=0 sd=0 mult=1 m=1
csn_op1_0900_rl_s0p1_r0_dp001p0_2 sn_op1_0900_rl_s0p1_r0_dp001p0_2 0 {C_SN}
XMWR_op1_0900_rl_s0p1_r0_dp001p0_3 sn_op1_0900_rl_s0p1_r0_dp001p0_3 wwl_des wbl_op1_0900_rl_s0p1_r0_dp001p0 0 sky130_fd_pr__nfet_01v8 L=0.15 W=0.42 nf=1 ad=0.1218 as=0.1218 pd=1.42 ps=1.42 nrd=0.69047619047619  nrs=0.69047619047619 sa=0 sb=0 sd=0 mult=1 m=1
XMRD_op1_0900_rl_s0p1_r0_dp001p0_3 rbl_op1_0900_rl_s0p1_r0_dp001p0 sn_op1_0900_rl_s0p1_r0_dp001p0_3 rwl_des 0 sky130_fd_pr__nfet_01v8 L=0.15 W=0.42 nf=1 ad=0.1218 as=0.1218 pd=1.42 ps=1.42 nrd=0.69047619047619  nrs=0.69047619047619 sa=0 sb=0 sd=0 mult=1 m=1
csn_op1_0900_rl_s0p1_r0_dp001p0_3 sn_op1_0900_rl_s0p1_r0_dp001p0_3 0 {C_SN}
XMN1_op1_0900_rl_s0p1_r0_dp001p0 rbl_op1_0900_rl_s0p1_r0_dp001p0 ref_op1_0900_rl_s0p1_r0_dp001p0 vn_op1_0900_rl_s0p1_r0_dp001p0 0 sky130_fd_pr__nfet_01v8 L=0.15 W=1 nf=1 ad=0.29 as=0.29 pd=2.58 ps=2.58 mult=1 m=1
XMN2_op1_0900_rl_s0p1_r0_dp001p0 ref_op1_0900_rl_s0p1_r0_dp001p0 rbl_op1_0900_rl_s0p1_r0_dp001p0 vn_op1_0900_rl_s0p1_r0_dp001p0 0 sky130_fd_pr__nfet_01v8 L=0.15 W=1 nf=1 ad=0.29 as=0.29 pd=2.58 ps=2.58 mult=1 m=1
XMP1_op1_0900_rl_s0p1_r0_dp001p0 rbl_op1_0900_rl_s0p1_r0_dp001p0 ref_op1_0900_rl_s0p1_r0_dp001p0 vp_op1_0900_rl_s0p1_r0_dp001p0 vdd sky130_fd_pr__pfet_01v8 L=0.15 W=2 nf=1 ad=0.58 as=0.58 pd=4.58 ps=4.58 mult=1 m=1
XMP2_op1_0900_rl_s0p1_r0_dp001p0 ref_op1_0900_rl_s0p1_r0_dp001p0 rbl_op1_0900_rl_s0p1_r0_dp001p0 vp_op1_0900_rl_s0p1_r0_dp001p0 vdd sky130_fd_pr__pfet_01v8 L=0.15 W=2 nf=1 ad=0.58 as=0.58 pd=4.58 ps=4.58 mult=1 m=1
XMNF_op1_0900_rl_s0p1_r0_dp001p0 vn_op1_0900_rl_s0p1_r0_dp001p0 en_op1_0900_rl_s0p1_r0_dp001p0 0 0 sky130_fd_pr__nfet_01v8 L=0.15 W=2 nf=1 ad=0.58 as=0.58 pd=4.58 ps=4.58 mult=1 m=1
XMPH_op1_0900_rl_s0p1_r0_dp001p0 vp_op1_0900_rl_s0p1_r0_dp001p0 enb_op1_0900_rl_s0p1_r0_dp001p0 vdd vdd sky130_fd_pr__pfet_01v8 L=0.15 W=4 nf=1 ad=1.16 as=1.16 pd=8.58 ps=8.58 mult=1 m=1
bd_op1_0900_rl_s0p1_r0_dp001p0 d_op1_0900_rl_s0p1_r0_dp001p0 0 v=v(rbl_op1_0900_rl_s0p1_r0_dp001p0)-v(ref_op1_0900_rl_s0p1_r0_dp001p0)

* ---- instance 242: op1_1000_rl_s0p1_r0_dp001p0 (variant rl_s0p1_r0_dp001p0; probe dec 11.9 ns, release 34 ns, meas 36 ns) ----
vctl_op1_1000_rl_s0p1_r0_dp001p0 ctl_op1_1000_rl_s0p1_r0_dp001p0 0 pwl(0.0000e+00 {VDD} 2.0000e-09 {VDD} 2.1000e-09 0)
* RWL driver model (EXPERIMENTAL): slew 0.1 ns, series R 0 ohm; cell pin = rwls_op1_1000_rl_s0p1_r0_dp001p0
vrs_op1_1000_rl_s0p1_r0_dp001p0 rwls_op1_1000_rl_s0p1_r0_dp001p0 0 pwl(0.0000e+00 {VDD} 2.0000e-09 {VDD} 2.1000e-09 0 3.3000e-08 0 3.3100e-08 {VDD})
ven_op1_1000_rl_s0p1_r0_dp001p0 en_op1_1000_rl_s0p1_r0_dp001p0 0 pwl(0.0000e+00 0 1.1000e-08 0 1.1100e-08 {VDD} 3.4000e-08 {VDD} 3.4100e-08 0)
venb_op1_1000_rl_s0p1_r0_dp001p0 enb_op1_1000_rl_s0p1_r0_dp001p0 0 pwl(0.0000e+00 {VDD} 1.1000e-08 {VDD} 1.1100e-08 0 3.4000e-08 0 3.4100e-08 {VDD})
vww_op1_1000_rl_s0p1_r0_dp001p0 wwl_op1_1000_rl_s0p1_r0_dp001p0 0 pwl(0.0000e+00 0 1.2000e-08 0 1.2100e-08 {VDD} 3.2000e-08 {VDD} 3.2100e-08 0)
vwc_op1_1000_rl_s0p1_r0_dp001p0 wbc_op1_1000_rl_s0p1_r0_dp001p0 0 pwl(0.0000e+00 0 1.2000e-08 0 1.2100e-08 {VDD} 3.4000e-08 {VDD} 3.4100e-08 0)
swb_op1_1000_rl_s0p1_r0_dp001p0 ref_op1_1000_rl_s0p1_r0_dp001p0 wbl_op1_1000_rl_s0p1_r0_dp001p0 wbc_op1_1000_rl_s0p1_r0_dp001p0 0 swwbl
cwbl_op1_1000_rl_s0p1_r0_dp001p0 wbl_op1_1000_rl_s0p1_r0_dp001p0 0 {C_WBL}
spa_op1_1000_rl_s0p1_r0_dp001p0 prea rbl_op1_1000_rl_s0p1_r0_dp001p0 ctl_op1_1000_rl_s0p1_r0_dp001p0 0 swpre
spr_op1_1000_rl_s0p1_r0_dp001p0 pref ref_op1_1000_rl_s0p1_r0_dp001p0 ctl_op1_1000_rl_s0p1_r0_dp001p0 0 swpre
crbl_op1_1000_rl_s0p1_r0_dp001p0 rbl_op1_1000_rl_s0p1_r0_dp001p0 0 {C_RBL}
cref_op1_1000_rl_s0p1_r0_dp001p0 ref_op1_1000_rl_s0p1_r0_dp001p0 0 {C_RBL}   $ ASSUMPTION: ideal matched dummy load
XMWR_op1_1000_rl_s0p1_r0_dp001p0_0 sn_op1_1000_rl_s0p1_r0_dp001p0_0 wwl_op1_1000_rl_s0p1_r0_dp001p0 wbl_op1_1000_rl_s0p1_r0_dp001p0 0 sky130_fd_pr__nfet_01v8 L=0.15 W=0.42 nf=1 ad=0.1218 as=0.1218 pd=1.42 ps=1.42 nrd=0.69047619047619  nrs=0.69047619047619 sa=0 sb=0 sd=0 mult=1 m=1
XMRD_op1_1000_rl_s0p1_r0_dp001p0_0 rbl_op1_1000_rl_s0p1_r0_dp001p0 sn_op1_1000_rl_s0p1_r0_dp001p0_0 rwls_op1_1000_rl_s0p1_r0_dp001p0 0 sky130_fd_pr__nfet_01v8 L=0.15 W=0.42 nf=1 ad=0.1218 as=0.1218 pd=1.42 ps=1.42 nrd=0.69047619047619  nrs=0.69047619047619 sa=0 sb=0 sd=0 mult=1 m=1
csn_op1_1000_rl_s0p1_r0_dp001p0_0 sn_op1_1000_rl_s0p1_r0_dp001p0_0 0 {C_SN}
XMWR_op1_1000_rl_s0p1_r0_dp001p0_1 sn_op1_1000_rl_s0p1_r0_dp001p0_1 wwl_des wbl_op1_1000_rl_s0p1_r0_dp001p0 0 sky130_fd_pr__nfet_01v8 L=0.15 W=0.42 nf=1 ad=0.1218 as=0.1218 pd=1.42 ps=1.42 nrd=0.69047619047619  nrs=0.69047619047619 sa=0 sb=0 sd=0 mult=1 m=1
XMRD_op1_1000_rl_s0p1_r0_dp001p0_1 rbl_op1_1000_rl_s0p1_r0_dp001p0 sn_op1_1000_rl_s0p1_r0_dp001p0_1 rwl_des 0 sky130_fd_pr__nfet_01v8 L=0.15 W=0.42 nf=1 ad=0.1218 as=0.1218 pd=1.42 ps=1.42 nrd=0.69047619047619  nrs=0.69047619047619 sa=0 sb=0 sd=0 mult=1 m=1
csn_op1_1000_rl_s0p1_r0_dp001p0_1 sn_op1_1000_rl_s0p1_r0_dp001p0_1 0 {C_SN}
XMWR_op1_1000_rl_s0p1_r0_dp001p0_2 sn_op1_1000_rl_s0p1_r0_dp001p0_2 wwl_des wbl_op1_1000_rl_s0p1_r0_dp001p0 0 sky130_fd_pr__nfet_01v8 L=0.15 W=0.42 nf=1 ad=0.1218 as=0.1218 pd=1.42 ps=1.42 nrd=0.69047619047619  nrs=0.69047619047619 sa=0 sb=0 sd=0 mult=1 m=1
XMRD_op1_1000_rl_s0p1_r0_dp001p0_2 rbl_op1_1000_rl_s0p1_r0_dp001p0 sn_op1_1000_rl_s0p1_r0_dp001p0_2 rwl_des 0 sky130_fd_pr__nfet_01v8 L=0.15 W=0.42 nf=1 ad=0.1218 as=0.1218 pd=1.42 ps=1.42 nrd=0.69047619047619  nrs=0.69047619047619 sa=0 sb=0 sd=0 mult=1 m=1
csn_op1_1000_rl_s0p1_r0_dp001p0_2 sn_op1_1000_rl_s0p1_r0_dp001p0_2 0 {C_SN}
XMWR_op1_1000_rl_s0p1_r0_dp001p0_3 sn_op1_1000_rl_s0p1_r0_dp001p0_3 wwl_des wbl_op1_1000_rl_s0p1_r0_dp001p0 0 sky130_fd_pr__nfet_01v8 L=0.15 W=0.42 nf=1 ad=0.1218 as=0.1218 pd=1.42 ps=1.42 nrd=0.69047619047619  nrs=0.69047619047619 sa=0 sb=0 sd=0 mult=1 m=1
XMRD_op1_1000_rl_s0p1_r0_dp001p0_3 rbl_op1_1000_rl_s0p1_r0_dp001p0 sn_op1_1000_rl_s0p1_r0_dp001p0_3 rwl_des 0 sky130_fd_pr__nfet_01v8 L=0.15 W=0.42 nf=1 ad=0.1218 as=0.1218 pd=1.42 ps=1.42 nrd=0.69047619047619  nrs=0.69047619047619 sa=0 sb=0 sd=0 mult=1 m=1
csn_op1_1000_rl_s0p1_r0_dp001p0_3 sn_op1_1000_rl_s0p1_r0_dp001p0_3 0 {C_SN}
XMN1_op1_1000_rl_s0p1_r0_dp001p0 rbl_op1_1000_rl_s0p1_r0_dp001p0 ref_op1_1000_rl_s0p1_r0_dp001p0 vn_op1_1000_rl_s0p1_r0_dp001p0 0 sky130_fd_pr__nfet_01v8 L=0.15 W=1 nf=1 ad=0.29 as=0.29 pd=2.58 ps=2.58 mult=1 m=1
XMN2_op1_1000_rl_s0p1_r0_dp001p0 ref_op1_1000_rl_s0p1_r0_dp001p0 rbl_op1_1000_rl_s0p1_r0_dp001p0 vn_op1_1000_rl_s0p1_r0_dp001p0 0 sky130_fd_pr__nfet_01v8 L=0.15 W=1 nf=1 ad=0.29 as=0.29 pd=2.58 ps=2.58 mult=1 m=1
XMP1_op1_1000_rl_s0p1_r0_dp001p0 rbl_op1_1000_rl_s0p1_r0_dp001p0 ref_op1_1000_rl_s0p1_r0_dp001p0 vp_op1_1000_rl_s0p1_r0_dp001p0 vdd sky130_fd_pr__pfet_01v8 L=0.15 W=2 nf=1 ad=0.58 as=0.58 pd=4.58 ps=4.58 mult=1 m=1
XMP2_op1_1000_rl_s0p1_r0_dp001p0 ref_op1_1000_rl_s0p1_r0_dp001p0 rbl_op1_1000_rl_s0p1_r0_dp001p0 vp_op1_1000_rl_s0p1_r0_dp001p0 vdd sky130_fd_pr__pfet_01v8 L=0.15 W=2 nf=1 ad=0.58 as=0.58 pd=4.58 ps=4.58 mult=1 m=1
XMNF_op1_1000_rl_s0p1_r0_dp001p0 vn_op1_1000_rl_s0p1_r0_dp001p0 en_op1_1000_rl_s0p1_r0_dp001p0 0 0 sky130_fd_pr__nfet_01v8 L=0.15 W=2 nf=1 ad=0.58 as=0.58 pd=4.58 ps=4.58 mult=1 m=1
XMPH_op1_1000_rl_s0p1_r0_dp001p0 vp_op1_1000_rl_s0p1_r0_dp001p0 enb_op1_1000_rl_s0p1_r0_dp001p0 vdd vdd sky130_fd_pr__pfet_01v8 L=0.15 W=4 nf=1 ad=1.16 as=1.16 pd=8.58 ps=8.58 mult=1 m=1
bd_op1_1000_rl_s0p1_r0_dp001p0 d_op1_1000_rl_s0p1_r0_dp001p0 0 v=v(rbl_op1_1000_rl_s0p1_r0_dp001p0)-v(ref_op1_1000_rl_s0p1_r0_dp001p0)

* ---- instance 243: op0_n100_rl_s0p1_r0_dp001p0 (variant rl_s0p1_r0_dp001p0; probe dec 11.9 ns, release 34 ns, meas 36 ns) ----
vctl_op0_n100_rl_s0p1_r0_dp001p0 ctl_op0_n100_rl_s0p1_r0_dp001p0 0 pwl(0.0000e+00 {VDD} 2.0000e-09 {VDD} 2.1000e-09 0)
* RWL driver model (EXPERIMENTAL): slew 0.1 ns, series R 0 ohm; cell pin = rwls_op0_n100_rl_s0p1_r0_dp001p0
vrs_op0_n100_rl_s0p1_r0_dp001p0 rwls_op0_n100_rl_s0p1_r0_dp001p0 0 pwl(0.0000e+00 {VDD} 2.0000e-09 {VDD} 2.1000e-09 0 3.3000e-08 0 3.3100e-08 {VDD})
ven_op0_n100_rl_s0p1_r0_dp001p0 en_op0_n100_rl_s0p1_r0_dp001p0 0 pwl(0.0000e+00 0 1.1000e-08 0 1.1100e-08 {VDD} 3.4000e-08 {VDD} 3.4100e-08 0)
venb_op0_n100_rl_s0p1_r0_dp001p0 enb_op0_n100_rl_s0p1_r0_dp001p0 0 pwl(0.0000e+00 {VDD} 1.1000e-08 {VDD} 1.1100e-08 0 3.4000e-08 0 3.4100e-08 {VDD})
vww_op0_n100_rl_s0p1_r0_dp001p0 wwl_op0_n100_rl_s0p1_r0_dp001p0 0 pwl(0.0000e+00 0 1.2000e-08 0 1.2100e-08 {VDD} 3.2000e-08 {VDD} 3.2100e-08 0)
vwc_op0_n100_rl_s0p1_r0_dp001p0 wbc_op0_n100_rl_s0p1_r0_dp001p0 0 pwl(0.0000e+00 0 1.2000e-08 0 1.2100e-08 {VDD} 3.4000e-08 {VDD} 3.4100e-08 0)
swb_op0_n100_rl_s0p1_r0_dp001p0 ref_op0_n100_rl_s0p1_r0_dp001p0 wbl_op0_n100_rl_s0p1_r0_dp001p0 wbc_op0_n100_rl_s0p1_r0_dp001p0 0 swwbl
cwbl_op0_n100_rl_s0p1_r0_dp001p0 wbl_op0_n100_rl_s0p1_r0_dp001p0 0 {C_WBL}
spa_op0_n100_rl_s0p1_r0_dp001p0 prea rbl_op0_n100_rl_s0p1_r0_dp001p0 ctl_op0_n100_rl_s0p1_r0_dp001p0 0 swpre
spr_op0_n100_rl_s0p1_r0_dp001p0 pref ref_op0_n100_rl_s0p1_r0_dp001p0 ctl_op0_n100_rl_s0p1_r0_dp001p0 0 swpre
crbl_op0_n100_rl_s0p1_r0_dp001p0 rbl_op0_n100_rl_s0p1_r0_dp001p0 0 {C_RBL}
cref_op0_n100_rl_s0p1_r0_dp001p0 ref_op0_n100_rl_s0p1_r0_dp001p0 0 {C_RBL}   $ ASSUMPTION: ideal matched dummy load
XMWR_op0_n100_rl_s0p1_r0_dp001p0_0 sn_op0_n100_rl_s0p1_r0_dp001p0_0 wwl_op0_n100_rl_s0p1_r0_dp001p0 wbl_op0_n100_rl_s0p1_r0_dp001p0 0 sky130_fd_pr__nfet_01v8 L=0.15 W=0.42 nf=1 ad=0.1218 as=0.1218 pd=1.42 ps=1.42 nrd=0.69047619047619  nrs=0.69047619047619 sa=0 sb=0 sd=0 mult=1 m=1
XMRD_op0_n100_rl_s0p1_r0_dp001p0_0 rbl_op0_n100_rl_s0p1_r0_dp001p0 sn_op0_n100_rl_s0p1_r0_dp001p0_0 rwls_op0_n100_rl_s0p1_r0_dp001p0 0 sky130_fd_pr__nfet_01v8 L=0.15 W=0.42 nf=1 ad=0.1218 as=0.1218 pd=1.42 ps=1.42 nrd=0.69047619047619  nrs=0.69047619047619 sa=0 sb=0 sd=0 mult=1 m=1
csn_op0_n100_rl_s0p1_r0_dp001p0_0 sn_op0_n100_rl_s0p1_r0_dp001p0_0 0 {C_SN}
XMWR_op0_n100_rl_s0p1_r0_dp001p0_1 sn_op0_n100_rl_s0p1_r0_dp001p0_1 wwl_des wbl_op0_n100_rl_s0p1_r0_dp001p0 0 sky130_fd_pr__nfet_01v8 L=0.15 W=0.42 nf=1 ad=0.1218 as=0.1218 pd=1.42 ps=1.42 nrd=0.69047619047619  nrs=0.69047619047619 sa=0 sb=0 sd=0 mult=1 m=1
XMRD_op0_n100_rl_s0p1_r0_dp001p0_1 rbl_op0_n100_rl_s0p1_r0_dp001p0 sn_op0_n100_rl_s0p1_r0_dp001p0_1 rwl_des 0 sky130_fd_pr__nfet_01v8 L=0.15 W=0.42 nf=1 ad=0.1218 as=0.1218 pd=1.42 ps=1.42 nrd=0.69047619047619  nrs=0.69047619047619 sa=0 sb=0 sd=0 mult=1 m=1
csn_op0_n100_rl_s0p1_r0_dp001p0_1 sn_op0_n100_rl_s0p1_r0_dp001p0_1 0 {C_SN}
XMWR_op0_n100_rl_s0p1_r0_dp001p0_2 sn_op0_n100_rl_s0p1_r0_dp001p0_2 wwl_des wbl_op0_n100_rl_s0p1_r0_dp001p0 0 sky130_fd_pr__nfet_01v8 L=0.15 W=0.42 nf=1 ad=0.1218 as=0.1218 pd=1.42 ps=1.42 nrd=0.69047619047619  nrs=0.69047619047619 sa=0 sb=0 sd=0 mult=1 m=1
XMRD_op0_n100_rl_s0p1_r0_dp001p0_2 rbl_op0_n100_rl_s0p1_r0_dp001p0 sn_op0_n100_rl_s0p1_r0_dp001p0_2 rwl_des 0 sky130_fd_pr__nfet_01v8 L=0.15 W=0.42 nf=1 ad=0.1218 as=0.1218 pd=1.42 ps=1.42 nrd=0.69047619047619  nrs=0.69047619047619 sa=0 sb=0 sd=0 mult=1 m=1
csn_op0_n100_rl_s0p1_r0_dp001p0_2 sn_op0_n100_rl_s0p1_r0_dp001p0_2 0 {C_SN}
XMWR_op0_n100_rl_s0p1_r0_dp001p0_3 sn_op0_n100_rl_s0p1_r0_dp001p0_3 wwl_des wbl_op0_n100_rl_s0p1_r0_dp001p0 0 sky130_fd_pr__nfet_01v8 L=0.15 W=0.42 nf=1 ad=0.1218 as=0.1218 pd=1.42 ps=1.42 nrd=0.69047619047619  nrs=0.69047619047619 sa=0 sb=0 sd=0 mult=1 m=1
XMRD_op0_n100_rl_s0p1_r0_dp001p0_3 rbl_op0_n100_rl_s0p1_r0_dp001p0 sn_op0_n100_rl_s0p1_r0_dp001p0_3 rwl_des 0 sky130_fd_pr__nfet_01v8 L=0.15 W=0.42 nf=1 ad=0.1218 as=0.1218 pd=1.42 ps=1.42 nrd=0.69047619047619  nrs=0.69047619047619 sa=0 sb=0 sd=0 mult=1 m=1
csn_op0_n100_rl_s0p1_r0_dp001p0_3 sn_op0_n100_rl_s0p1_r0_dp001p0_3 0 {C_SN}
XMN1_op0_n100_rl_s0p1_r0_dp001p0 rbl_op0_n100_rl_s0p1_r0_dp001p0 ref_op0_n100_rl_s0p1_r0_dp001p0 vn_op0_n100_rl_s0p1_r0_dp001p0 0 sky130_fd_pr__nfet_01v8 L=0.15 W=1 nf=1 ad=0.29 as=0.29 pd=2.58 ps=2.58 mult=1 m=1
XMN2_op0_n100_rl_s0p1_r0_dp001p0 ref_op0_n100_rl_s0p1_r0_dp001p0 rbl_op0_n100_rl_s0p1_r0_dp001p0 vn_op0_n100_rl_s0p1_r0_dp001p0 0 sky130_fd_pr__nfet_01v8 L=0.15 W=1 nf=1 ad=0.29 as=0.29 pd=2.58 ps=2.58 mult=1 m=1
XMP1_op0_n100_rl_s0p1_r0_dp001p0 rbl_op0_n100_rl_s0p1_r0_dp001p0 ref_op0_n100_rl_s0p1_r0_dp001p0 vp_op0_n100_rl_s0p1_r0_dp001p0 vdd sky130_fd_pr__pfet_01v8 L=0.15 W=2 nf=1 ad=0.58 as=0.58 pd=4.58 ps=4.58 mult=1 m=1
XMP2_op0_n100_rl_s0p1_r0_dp001p0 ref_op0_n100_rl_s0p1_r0_dp001p0 rbl_op0_n100_rl_s0p1_r0_dp001p0 vp_op0_n100_rl_s0p1_r0_dp001p0 vdd sky130_fd_pr__pfet_01v8 L=0.15 W=2 nf=1 ad=0.58 as=0.58 pd=4.58 ps=4.58 mult=1 m=1
XMNF_op0_n100_rl_s0p1_r0_dp001p0 vn_op0_n100_rl_s0p1_r0_dp001p0 en_op0_n100_rl_s0p1_r0_dp001p0 0 0 sky130_fd_pr__nfet_01v8 L=0.15 W=2 nf=1 ad=0.58 as=0.58 pd=4.58 ps=4.58 mult=1 m=1
XMPH_op0_n100_rl_s0p1_r0_dp001p0 vp_op0_n100_rl_s0p1_r0_dp001p0 enb_op0_n100_rl_s0p1_r0_dp001p0 vdd vdd sky130_fd_pr__pfet_01v8 L=0.15 W=4 nf=1 ad=1.16 as=1.16 pd=8.58 ps=8.58 mult=1 m=1
bd_op0_n100_rl_s0p1_r0_dp001p0 d_op0_n100_rl_s0p1_r0_dp001p0 0 v=v(rbl_op0_n100_rl_s0p1_r0_dp001p0)-v(ref_op0_n100_rl_s0p1_r0_dp001p0)

* ---- instance 244: op0_0000_rl_s0p1_r0_dp001p0 (variant rl_s0p1_r0_dp001p0; probe dec 11.9 ns, release 34 ns, meas 36 ns) ----
vctl_op0_0000_rl_s0p1_r0_dp001p0 ctl_op0_0000_rl_s0p1_r0_dp001p0 0 pwl(0.0000e+00 {VDD} 2.0000e-09 {VDD} 2.1000e-09 0)
* RWL driver model (EXPERIMENTAL): slew 0.1 ns, series R 0 ohm; cell pin = rwls_op0_0000_rl_s0p1_r0_dp001p0
vrs_op0_0000_rl_s0p1_r0_dp001p0 rwls_op0_0000_rl_s0p1_r0_dp001p0 0 pwl(0.0000e+00 {VDD} 2.0000e-09 {VDD} 2.1000e-09 0 3.3000e-08 0 3.3100e-08 {VDD})
ven_op0_0000_rl_s0p1_r0_dp001p0 en_op0_0000_rl_s0p1_r0_dp001p0 0 pwl(0.0000e+00 0 1.1000e-08 0 1.1100e-08 {VDD} 3.4000e-08 {VDD} 3.4100e-08 0)
venb_op0_0000_rl_s0p1_r0_dp001p0 enb_op0_0000_rl_s0p1_r0_dp001p0 0 pwl(0.0000e+00 {VDD} 1.1000e-08 {VDD} 1.1100e-08 0 3.4000e-08 0 3.4100e-08 {VDD})
vww_op0_0000_rl_s0p1_r0_dp001p0 wwl_op0_0000_rl_s0p1_r0_dp001p0 0 pwl(0.0000e+00 0 1.2000e-08 0 1.2100e-08 {VDD} 3.2000e-08 {VDD} 3.2100e-08 0)
vwc_op0_0000_rl_s0p1_r0_dp001p0 wbc_op0_0000_rl_s0p1_r0_dp001p0 0 pwl(0.0000e+00 0 1.2000e-08 0 1.2100e-08 {VDD} 3.4000e-08 {VDD} 3.4100e-08 0)
swb_op0_0000_rl_s0p1_r0_dp001p0 ref_op0_0000_rl_s0p1_r0_dp001p0 wbl_op0_0000_rl_s0p1_r0_dp001p0 wbc_op0_0000_rl_s0p1_r0_dp001p0 0 swwbl
cwbl_op0_0000_rl_s0p1_r0_dp001p0 wbl_op0_0000_rl_s0p1_r0_dp001p0 0 {C_WBL}
spa_op0_0000_rl_s0p1_r0_dp001p0 prea rbl_op0_0000_rl_s0p1_r0_dp001p0 ctl_op0_0000_rl_s0p1_r0_dp001p0 0 swpre
spr_op0_0000_rl_s0p1_r0_dp001p0 pref ref_op0_0000_rl_s0p1_r0_dp001p0 ctl_op0_0000_rl_s0p1_r0_dp001p0 0 swpre
crbl_op0_0000_rl_s0p1_r0_dp001p0 rbl_op0_0000_rl_s0p1_r0_dp001p0 0 {C_RBL}
cref_op0_0000_rl_s0p1_r0_dp001p0 ref_op0_0000_rl_s0p1_r0_dp001p0 0 {C_RBL}   $ ASSUMPTION: ideal matched dummy load
XMWR_op0_0000_rl_s0p1_r0_dp001p0_0 sn_op0_0000_rl_s0p1_r0_dp001p0_0 wwl_op0_0000_rl_s0p1_r0_dp001p0 wbl_op0_0000_rl_s0p1_r0_dp001p0 0 sky130_fd_pr__nfet_01v8 L=0.15 W=0.42 nf=1 ad=0.1218 as=0.1218 pd=1.42 ps=1.42 nrd=0.69047619047619  nrs=0.69047619047619 sa=0 sb=0 sd=0 mult=1 m=1
XMRD_op0_0000_rl_s0p1_r0_dp001p0_0 rbl_op0_0000_rl_s0p1_r0_dp001p0 sn_op0_0000_rl_s0p1_r0_dp001p0_0 rwls_op0_0000_rl_s0p1_r0_dp001p0 0 sky130_fd_pr__nfet_01v8 L=0.15 W=0.42 nf=1 ad=0.1218 as=0.1218 pd=1.42 ps=1.42 nrd=0.69047619047619  nrs=0.69047619047619 sa=0 sb=0 sd=0 mult=1 m=1
csn_op0_0000_rl_s0p1_r0_dp001p0_0 sn_op0_0000_rl_s0p1_r0_dp001p0_0 0 {C_SN}
XMWR_op0_0000_rl_s0p1_r0_dp001p0_1 sn_op0_0000_rl_s0p1_r0_dp001p0_1 wwl_des wbl_op0_0000_rl_s0p1_r0_dp001p0 0 sky130_fd_pr__nfet_01v8 L=0.15 W=0.42 nf=1 ad=0.1218 as=0.1218 pd=1.42 ps=1.42 nrd=0.69047619047619  nrs=0.69047619047619 sa=0 sb=0 sd=0 mult=1 m=1
XMRD_op0_0000_rl_s0p1_r0_dp001p0_1 rbl_op0_0000_rl_s0p1_r0_dp001p0 sn_op0_0000_rl_s0p1_r0_dp001p0_1 rwl_des 0 sky130_fd_pr__nfet_01v8 L=0.15 W=0.42 nf=1 ad=0.1218 as=0.1218 pd=1.42 ps=1.42 nrd=0.69047619047619  nrs=0.69047619047619 sa=0 sb=0 sd=0 mult=1 m=1
csn_op0_0000_rl_s0p1_r0_dp001p0_1 sn_op0_0000_rl_s0p1_r0_dp001p0_1 0 {C_SN}
XMWR_op0_0000_rl_s0p1_r0_dp001p0_2 sn_op0_0000_rl_s0p1_r0_dp001p0_2 wwl_des wbl_op0_0000_rl_s0p1_r0_dp001p0 0 sky130_fd_pr__nfet_01v8 L=0.15 W=0.42 nf=1 ad=0.1218 as=0.1218 pd=1.42 ps=1.42 nrd=0.69047619047619  nrs=0.69047619047619 sa=0 sb=0 sd=0 mult=1 m=1
XMRD_op0_0000_rl_s0p1_r0_dp001p0_2 rbl_op0_0000_rl_s0p1_r0_dp001p0 sn_op0_0000_rl_s0p1_r0_dp001p0_2 rwl_des 0 sky130_fd_pr__nfet_01v8 L=0.15 W=0.42 nf=1 ad=0.1218 as=0.1218 pd=1.42 ps=1.42 nrd=0.69047619047619  nrs=0.69047619047619 sa=0 sb=0 sd=0 mult=1 m=1
csn_op0_0000_rl_s0p1_r0_dp001p0_2 sn_op0_0000_rl_s0p1_r0_dp001p0_2 0 {C_SN}
XMWR_op0_0000_rl_s0p1_r0_dp001p0_3 sn_op0_0000_rl_s0p1_r0_dp001p0_3 wwl_des wbl_op0_0000_rl_s0p1_r0_dp001p0 0 sky130_fd_pr__nfet_01v8 L=0.15 W=0.42 nf=1 ad=0.1218 as=0.1218 pd=1.42 ps=1.42 nrd=0.69047619047619  nrs=0.69047619047619 sa=0 sb=0 sd=0 mult=1 m=1
XMRD_op0_0000_rl_s0p1_r0_dp001p0_3 rbl_op0_0000_rl_s0p1_r0_dp001p0 sn_op0_0000_rl_s0p1_r0_dp001p0_3 rwl_des 0 sky130_fd_pr__nfet_01v8 L=0.15 W=0.42 nf=1 ad=0.1218 as=0.1218 pd=1.42 ps=1.42 nrd=0.69047619047619  nrs=0.69047619047619 sa=0 sb=0 sd=0 mult=1 m=1
csn_op0_0000_rl_s0p1_r0_dp001p0_3 sn_op0_0000_rl_s0p1_r0_dp001p0_3 0 {C_SN}
XMN1_op0_0000_rl_s0p1_r0_dp001p0 rbl_op0_0000_rl_s0p1_r0_dp001p0 ref_op0_0000_rl_s0p1_r0_dp001p0 vn_op0_0000_rl_s0p1_r0_dp001p0 0 sky130_fd_pr__nfet_01v8 L=0.15 W=1 nf=1 ad=0.29 as=0.29 pd=2.58 ps=2.58 mult=1 m=1
XMN2_op0_0000_rl_s0p1_r0_dp001p0 ref_op0_0000_rl_s0p1_r0_dp001p0 rbl_op0_0000_rl_s0p1_r0_dp001p0 vn_op0_0000_rl_s0p1_r0_dp001p0 0 sky130_fd_pr__nfet_01v8 L=0.15 W=1 nf=1 ad=0.29 as=0.29 pd=2.58 ps=2.58 mult=1 m=1
XMP1_op0_0000_rl_s0p1_r0_dp001p0 rbl_op0_0000_rl_s0p1_r0_dp001p0 ref_op0_0000_rl_s0p1_r0_dp001p0 vp_op0_0000_rl_s0p1_r0_dp001p0 vdd sky130_fd_pr__pfet_01v8 L=0.15 W=2 nf=1 ad=0.58 as=0.58 pd=4.58 ps=4.58 mult=1 m=1
XMP2_op0_0000_rl_s0p1_r0_dp001p0 ref_op0_0000_rl_s0p1_r0_dp001p0 rbl_op0_0000_rl_s0p1_r0_dp001p0 vp_op0_0000_rl_s0p1_r0_dp001p0 vdd sky130_fd_pr__pfet_01v8 L=0.15 W=2 nf=1 ad=0.58 as=0.58 pd=4.58 ps=4.58 mult=1 m=1
XMNF_op0_0000_rl_s0p1_r0_dp001p0 vn_op0_0000_rl_s0p1_r0_dp001p0 en_op0_0000_rl_s0p1_r0_dp001p0 0 0 sky130_fd_pr__nfet_01v8 L=0.15 W=2 nf=1 ad=0.58 as=0.58 pd=4.58 ps=4.58 mult=1 m=1
XMPH_op0_0000_rl_s0p1_r0_dp001p0 vp_op0_0000_rl_s0p1_r0_dp001p0 enb_op0_0000_rl_s0p1_r0_dp001p0 vdd vdd sky130_fd_pr__pfet_01v8 L=0.15 W=4 nf=1 ad=1.16 as=1.16 pd=8.58 ps=8.58 mult=1 m=1
bd_op0_0000_rl_s0p1_r0_dp001p0 d_op0_0000_rl_s0p1_r0_dp001p0 0 v=v(rbl_op0_0000_rl_s0p1_r0_dp001p0)-v(ref_op0_0000_rl_s0p1_r0_dp001p0)

* ---- instance 245: op1_0900_rl_s0p1_r0_dp002p0 (variant rl_s0p1_r0_dp002p0; probe dec 11.9 ns, release 34 ns, meas 36 ns) ----
vctl_op1_0900_rl_s0p1_r0_dp002p0 ctl_op1_0900_rl_s0p1_r0_dp002p0 0 pwl(0.0000e+00 {VDD} 2.0000e-09 {VDD} 2.1000e-09 0)
* RWL driver model (EXPERIMENTAL): slew 0.1 ns, series R 0 ohm; cell pin = rwls_op1_0900_rl_s0p1_r0_dp002p0
vrs_op1_0900_rl_s0p1_r0_dp002p0 rwls_op1_0900_rl_s0p1_r0_dp002p0 0 pwl(0.0000e+00 {VDD} 2.0000e-09 {VDD} 2.1000e-09 0 3.4000e-08 0 3.4100e-08 {VDD})
ven_op1_0900_rl_s0p1_r0_dp002p0 en_op1_0900_rl_s0p1_r0_dp002p0 0 pwl(0.0000e+00 0 1.1000e-08 0 1.1100e-08 {VDD} 3.4000e-08 {VDD} 3.4100e-08 0)
venb_op1_0900_rl_s0p1_r0_dp002p0 enb_op1_0900_rl_s0p1_r0_dp002p0 0 pwl(0.0000e+00 {VDD} 1.1000e-08 {VDD} 1.1100e-08 0 3.4000e-08 0 3.4100e-08 {VDD})
vww_op1_0900_rl_s0p1_r0_dp002p0 wwl_op1_0900_rl_s0p1_r0_dp002p0 0 pwl(0.0000e+00 0 1.2000e-08 0 1.2100e-08 {VDD} 3.2000e-08 {VDD} 3.2100e-08 0)
vwc_op1_0900_rl_s0p1_r0_dp002p0 wbc_op1_0900_rl_s0p1_r0_dp002p0 0 pwl(0.0000e+00 0 1.2000e-08 0 1.2100e-08 {VDD} 3.4000e-08 {VDD} 3.4100e-08 0)
swb_op1_0900_rl_s0p1_r0_dp002p0 ref_op1_0900_rl_s0p1_r0_dp002p0 wbl_op1_0900_rl_s0p1_r0_dp002p0 wbc_op1_0900_rl_s0p1_r0_dp002p0 0 swwbl
cwbl_op1_0900_rl_s0p1_r0_dp002p0 wbl_op1_0900_rl_s0p1_r0_dp002p0 0 {C_WBL}
spa_op1_0900_rl_s0p1_r0_dp002p0 prea rbl_op1_0900_rl_s0p1_r0_dp002p0 ctl_op1_0900_rl_s0p1_r0_dp002p0 0 swpre
spr_op1_0900_rl_s0p1_r0_dp002p0 pref ref_op1_0900_rl_s0p1_r0_dp002p0 ctl_op1_0900_rl_s0p1_r0_dp002p0 0 swpre
crbl_op1_0900_rl_s0p1_r0_dp002p0 rbl_op1_0900_rl_s0p1_r0_dp002p0 0 {C_RBL}
cref_op1_0900_rl_s0p1_r0_dp002p0 ref_op1_0900_rl_s0p1_r0_dp002p0 0 {C_RBL}   $ ASSUMPTION: ideal matched dummy load
XMWR_op1_0900_rl_s0p1_r0_dp002p0_0 sn_op1_0900_rl_s0p1_r0_dp002p0_0 wwl_op1_0900_rl_s0p1_r0_dp002p0 wbl_op1_0900_rl_s0p1_r0_dp002p0 0 sky130_fd_pr__nfet_01v8 L=0.15 W=0.42 nf=1 ad=0.1218 as=0.1218 pd=1.42 ps=1.42 nrd=0.69047619047619  nrs=0.69047619047619 sa=0 sb=0 sd=0 mult=1 m=1
XMRD_op1_0900_rl_s0p1_r0_dp002p0_0 rbl_op1_0900_rl_s0p1_r0_dp002p0 sn_op1_0900_rl_s0p1_r0_dp002p0_0 rwls_op1_0900_rl_s0p1_r0_dp002p0 0 sky130_fd_pr__nfet_01v8 L=0.15 W=0.42 nf=1 ad=0.1218 as=0.1218 pd=1.42 ps=1.42 nrd=0.69047619047619  nrs=0.69047619047619 sa=0 sb=0 sd=0 mult=1 m=1
csn_op1_0900_rl_s0p1_r0_dp002p0_0 sn_op1_0900_rl_s0p1_r0_dp002p0_0 0 {C_SN}
XMWR_op1_0900_rl_s0p1_r0_dp002p0_1 sn_op1_0900_rl_s0p1_r0_dp002p0_1 wwl_des wbl_op1_0900_rl_s0p1_r0_dp002p0 0 sky130_fd_pr__nfet_01v8 L=0.15 W=0.42 nf=1 ad=0.1218 as=0.1218 pd=1.42 ps=1.42 nrd=0.69047619047619  nrs=0.69047619047619 sa=0 sb=0 sd=0 mult=1 m=1
XMRD_op1_0900_rl_s0p1_r0_dp002p0_1 rbl_op1_0900_rl_s0p1_r0_dp002p0 sn_op1_0900_rl_s0p1_r0_dp002p0_1 rwl_des 0 sky130_fd_pr__nfet_01v8 L=0.15 W=0.42 nf=1 ad=0.1218 as=0.1218 pd=1.42 ps=1.42 nrd=0.69047619047619  nrs=0.69047619047619 sa=0 sb=0 sd=0 mult=1 m=1
csn_op1_0900_rl_s0p1_r0_dp002p0_1 sn_op1_0900_rl_s0p1_r0_dp002p0_1 0 {C_SN}
XMWR_op1_0900_rl_s0p1_r0_dp002p0_2 sn_op1_0900_rl_s0p1_r0_dp002p0_2 wwl_des wbl_op1_0900_rl_s0p1_r0_dp002p0 0 sky130_fd_pr__nfet_01v8 L=0.15 W=0.42 nf=1 ad=0.1218 as=0.1218 pd=1.42 ps=1.42 nrd=0.69047619047619  nrs=0.69047619047619 sa=0 sb=0 sd=0 mult=1 m=1
XMRD_op1_0900_rl_s0p1_r0_dp002p0_2 rbl_op1_0900_rl_s0p1_r0_dp002p0 sn_op1_0900_rl_s0p1_r0_dp002p0_2 rwl_des 0 sky130_fd_pr__nfet_01v8 L=0.15 W=0.42 nf=1 ad=0.1218 as=0.1218 pd=1.42 ps=1.42 nrd=0.69047619047619  nrs=0.69047619047619 sa=0 sb=0 sd=0 mult=1 m=1
csn_op1_0900_rl_s0p1_r0_dp002p0_2 sn_op1_0900_rl_s0p1_r0_dp002p0_2 0 {C_SN}
XMWR_op1_0900_rl_s0p1_r0_dp002p0_3 sn_op1_0900_rl_s0p1_r0_dp002p0_3 wwl_des wbl_op1_0900_rl_s0p1_r0_dp002p0 0 sky130_fd_pr__nfet_01v8 L=0.15 W=0.42 nf=1 ad=0.1218 as=0.1218 pd=1.42 ps=1.42 nrd=0.69047619047619  nrs=0.69047619047619 sa=0 sb=0 sd=0 mult=1 m=1
XMRD_op1_0900_rl_s0p1_r0_dp002p0_3 rbl_op1_0900_rl_s0p1_r0_dp002p0 sn_op1_0900_rl_s0p1_r0_dp002p0_3 rwl_des 0 sky130_fd_pr__nfet_01v8 L=0.15 W=0.42 nf=1 ad=0.1218 as=0.1218 pd=1.42 ps=1.42 nrd=0.69047619047619  nrs=0.69047619047619 sa=0 sb=0 sd=0 mult=1 m=1
csn_op1_0900_rl_s0p1_r0_dp002p0_3 sn_op1_0900_rl_s0p1_r0_dp002p0_3 0 {C_SN}
XMN1_op1_0900_rl_s0p1_r0_dp002p0 rbl_op1_0900_rl_s0p1_r0_dp002p0 ref_op1_0900_rl_s0p1_r0_dp002p0 vn_op1_0900_rl_s0p1_r0_dp002p0 0 sky130_fd_pr__nfet_01v8 L=0.15 W=1 nf=1 ad=0.29 as=0.29 pd=2.58 ps=2.58 mult=1 m=1
XMN2_op1_0900_rl_s0p1_r0_dp002p0 ref_op1_0900_rl_s0p1_r0_dp002p0 rbl_op1_0900_rl_s0p1_r0_dp002p0 vn_op1_0900_rl_s0p1_r0_dp002p0 0 sky130_fd_pr__nfet_01v8 L=0.15 W=1 nf=1 ad=0.29 as=0.29 pd=2.58 ps=2.58 mult=1 m=1
XMP1_op1_0900_rl_s0p1_r0_dp002p0 rbl_op1_0900_rl_s0p1_r0_dp002p0 ref_op1_0900_rl_s0p1_r0_dp002p0 vp_op1_0900_rl_s0p1_r0_dp002p0 vdd sky130_fd_pr__pfet_01v8 L=0.15 W=2 nf=1 ad=0.58 as=0.58 pd=4.58 ps=4.58 mult=1 m=1
XMP2_op1_0900_rl_s0p1_r0_dp002p0 ref_op1_0900_rl_s0p1_r0_dp002p0 rbl_op1_0900_rl_s0p1_r0_dp002p0 vp_op1_0900_rl_s0p1_r0_dp002p0 vdd sky130_fd_pr__pfet_01v8 L=0.15 W=2 nf=1 ad=0.58 as=0.58 pd=4.58 ps=4.58 mult=1 m=1
XMNF_op1_0900_rl_s0p1_r0_dp002p0 vn_op1_0900_rl_s0p1_r0_dp002p0 en_op1_0900_rl_s0p1_r0_dp002p0 0 0 sky130_fd_pr__nfet_01v8 L=0.15 W=2 nf=1 ad=0.58 as=0.58 pd=4.58 ps=4.58 mult=1 m=1
XMPH_op1_0900_rl_s0p1_r0_dp002p0 vp_op1_0900_rl_s0p1_r0_dp002p0 enb_op1_0900_rl_s0p1_r0_dp002p0 vdd vdd sky130_fd_pr__pfet_01v8 L=0.15 W=4 nf=1 ad=1.16 as=1.16 pd=8.58 ps=8.58 mult=1 m=1
bd_op1_0900_rl_s0p1_r0_dp002p0 d_op1_0900_rl_s0p1_r0_dp002p0 0 v=v(rbl_op1_0900_rl_s0p1_r0_dp002p0)-v(ref_op1_0900_rl_s0p1_r0_dp002p0)

* ---- instance 246: op1_1000_rl_s0p1_r0_dp002p0 (variant rl_s0p1_r0_dp002p0; probe dec 11.9 ns, release 34 ns, meas 36 ns) ----
vctl_op1_1000_rl_s0p1_r0_dp002p0 ctl_op1_1000_rl_s0p1_r0_dp002p0 0 pwl(0.0000e+00 {VDD} 2.0000e-09 {VDD} 2.1000e-09 0)
* RWL driver model (EXPERIMENTAL): slew 0.1 ns, series R 0 ohm; cell pin = rwls_op1_1000_rl_s0p1_r0_dp002p0
vrs_op1_1000_rl_s0p1_r0_dp002p0 rwls_op1_1000_rl_s0p1_r0_dp002p0 0 pwl(0.0000e+00 {VDD} 2.0000e-09 {VDD} 2.1000e-09 0 3.4000e-08 0 3.4100e-08 {VDD})
ven_op1_1000_rl_s0p1_r0_dp002p0 en_op1_1000_rl_s0p1_r0_dp002p0 0 pwl(0.0000e+00 0 1.1000e-08 0 1.1100e-08 {VDD} 3.4000e-08 {VDD} 3.4100e-08 0)
venb_op1_1000_rl_s0p1_r0_dp002p0 enb_op1_1000_rl_s0p1_r0_dp002p0 0 pwl(0.0000e+00 {VDD} 1.1000e-08 {VDD} 1.1100e-08 0 3.4000e-08 0 3.4100e-08 {VDD})
vww_op1_1000_rl_s0p1_r0_dp002p0 wwl_op1_1000_rl_s0p1_r0_dp002p0 0 pwl(0.0000e+00 0 1.2000e-08 0 1.2100e-08 {VDD} 3.2000e-08 {VDD} 3.2100e-08 0)
vwc_op1_1000_rl_s0p1_r0_dp002p0 wbc_op1_1000_rl_s0p1_r0_dp002p0 0 pwl(0.0000e+00 0 1.2000e-08 0 1.2100e-08 {VDD} 3.4000e-08 {VDD} 3.4100e-08 0)
swb_op1_1000_rl_s0p1_r0_dp002p0 ref_op1_1000_rl_s0p1_r0_dp002p0 wbl_op1_1000_rl_s0p1_r0_dp002p0 wbc_op1_1000_rl_s0p1_r0_dp002p0 0 swwbl
cwbl_op1_1000_rl_s0p1_r0_dp002p0 wbl_op1_1000_rl_s0p1_r0_dp002p0 0 {C_WBL}
spa_op1_1000_rl_s0p1_r0_dp002p0 prea rbl_op1_1000_rl_s0p1_r0_dp002p0 ctl_op1_1000_rl_s0p1_r0_dp002p0 0 swpre
spr_op1_1000_rl_s0p1_r0_dp002p0 pref ref_op1_1000_rl_s0p1_r0_dp002p0 ctl_op1_1000_rl_s0p1_r0_dp002p0 0 swpre
crbl_op1_1000_rl_s0p1_r0_dp002p0 rbl_op1_1000_rl_s0p1_r0_dp002p0 0 {C_RBL}
cref_op1_1000_rl_s0p1_r0_dp002p0 ref_op1_1000_rl_s0p1_r0_dp002p0 0 {C_RBL}   $ ASSUMPTION: ideal matched dummy load
XMWR_op1_1000_rl_s0p1_r0_dp002p0_0 sn_op1_1000_rl_s0p1_r0_dp002p0_0 wwl_op1_1000_rl_s0p1_r0_dp002p0 wbl_op1_1000_rl_s0p1_r0_dp002p0 0 sky130_fd_pr__nfet_01v8 L=0.15 W=0.42 nf=1 ad=0.1218 as=0.1218 pd=1.42 ps=1.42 nrd=0.69047619047619  nrs=0.69047619047619 sa=0 sb=0 sd=0 mult=1 m=1
XMRD_op1_1000_rl_s0p1_r0_dp002p0_0 rbl_op1_1000_rl_s0p1_r0_dp002p0 sn_op1_1000_rl_s0p1_r0_dp002p0_0 rwls_op1_1000_rl_s0p1_r0_dp002p0 0 sky130_fd_pr__nfet_01v8 L=0.15 W=0.42 nf=1 ad=0.1218 as=0.1218 pd=1.42 ps=1.42 nrd=0.69047619047619  nrs=0.69047619047619 sa=0 sb=0 sd=0 mult=1 m=1
csn_op1_1000_rl_s0p1_r0_dp002p0_0 sn_op1_1000_rl_s0p1_r0_dp002p0_0 0 {C_SN}
XMWR_op1_1000_rl_s0p1_r0_dp002p0_1 sn_op1_1000_rl_s0p1_r0_dp002p0_1 wwl_des wbl_op1_1000_rl_s0p1_r0_dp002p0 0 sky130_fd_pr__nfet_01v8 L=0.15 W=0.42 nf=1 ad=0.1218 as=0.1218 pd=1.42 ps=1.42 nrd=0.69047619047619  nrs=0.69047619047619 sa=0 sb=0 sd=0 mult=1 m=1
XMRD_op1_1000_rl_s0p1_r0_dp002p0_1 rbl_op1_1000_rl_s0p1_r0_dp002p0 sn_op1_1000_rl_s0p1_r0_dp002p0_1 rwl_des 0 sky130_fd_pr__nfet_01v8 L=0.15 W=0.42 nf=1 ad=0.1218 as=0.1218 pd=1.42 ps=1.42 nrd=0.69047619047619  nrs=0.69047619047619 sa=0 sb=0 sd=0 mult=1 m=1
csn_op1_1000_rl_s0p1_r0_dp002p0_1 sn_op1_1000_rl_s0p1_r0_dp002p0_1 0 {C_SN}
XMWR_op1_1000_rl_s0p1_r0_dp002p0_2 sn_op1_1000_rl_s0p1_r0_dp002p0_2 wwl_des wbl_op1_1000_rl_s0p1_r0_dp002p0 0 sky130_fd_pr__nfet_01v8 L=0.15 W=0.42 nf=1 ad=0.1218 as=0.1218 pd=1.42 ps=1.42 nrd=0.69047619047619  nrs=0.69047619047619 sa=0 sb=0 sd=0 mult=1 m=1
XMRD_op1_1000_rl_s0p1_r0_dp002p0_2 rbl_op1_1000_rl_s0p1_r0_dp002p0 sn_op1_1000_rl_s0p1_r0_dp002p0_2 rwl_des 0 sky130_fd_pr__nfet_01v8 L=0.15 W=0.42 nf=1 ad=0.1218 as=0.1218 pd=1.42 ps=1.42 nrd=0.69047619047619  nrs=0.69047619047619 sa=0 sb=0 sd=0 mult=1 m=1
csn_op1_1000_rl_s0p1_r0_dp002p0_2 sn_op1_1000_rl_s0p1_r0_dp002p0_2 0 {C_SN}
XMWR_op1_1000_rl_s0p1_r0_dp002p0_3 sn_op1_1000_rl_s0p1_r0_dp002p0_3 wwl_des wbl_op1_1000_rl_s0p1_r0_dp002p0 0 sky130_fd_pr__nfet_01v8 L=0.15 W=0.42 nf=1 ad=0.1218 as=0.1218 pd=1.42 ps=1.42 nrd=0.69047619047619  nrs=0.69047619047619 sa=0 sb=0 sd=0 mult=1 m=1
XMRD_op1_1000_rl_s0p1_r0_dp002p0_3 rbl_op1_1000_rl_s0p1_r0_dp002p0 sn_op1_1000_rl_s0p1_r0_dp002p0_3 rwl_des 0 sky130_fd_pr__nfet_01v8 L=0.15 W=0.42 nf=1 ad=0.1218 as=0.1218 pd=1.42 ps=1.42 nrd=0.69047619047619  nrs=0.69047619047619 sa=0 sb=0 sd=0 mult=1 m=1
csn_op1_1000_rl_s0p1_r0_dp002p0_3 sn_op1_1000_rl_s0p1_r0_dp002p0_3 0 {C_SN}
XMN1_op1_1000_rl_s0p1_r0_dp002p0 rbl_op1_1000_rl_s0p1_r0_dp002p0 ref_op1_1000_rl_s0p1_r0_dp002p0 vn_op1_1000_rl_s0p1_r0_dp002p0 0 sky130_fd_pr__nfet_01v8 L=0.15 W=1 nf=1 ad=0.29 as=0.29 pd=2.58 ps=2.58 mult=1 m=1
XMN2_op1_1000_rl_s0p1_r0_dp002p0 ref_op1_1000_rl_s0p1_r0_dp002p0 rbl_op1_1000_rl_s0p1_r0_dp002p0 vn_op1_1000_rl_s0p1_r0_dp002p0 0 sky130_fd_pr__nfet_01v8 L=0.15 W=1 nf=1 ad=0.29 as=0.29 pd=2.58 ps=2.58 mult=1 m=1
XMP1_op1_1000_rl_s0p1_r0_dp002p0 rbl_op1_1000_rl_s0p1_r0_dp002p0 ref_op1_1000_rl_s0p1_r0_dp002p0 vp_op1_1000_rl_s0p1_r0_dp002p0 vdd sky130_fd_pr__pfet_01v8 L=0.15 W=2 nf=1 ad=0.58 as=0.58 pd=4.58 ps=4.58 mult=1 m=1
XMP2_op1_1000_rl_s0p1_r0_dp002p0 ref_op1_1000_rl_s0p1_r0_dp002p0 rbl_op1_1000_rl_s0p1_r0_dp002p0 vp_op1_1000_rl_s0p1_r0_dp002p0 vdd sky130_fd_pr__pfet_01v8 L=0.15 W=2 nf=1 ad=0.58 as=0.58 pd=4.58 ps=4.58 mult=1 m=1
XMNF_op1_1000_rl_s0p1_r0_dp002p0 vn_op1_1000_rl_s0p1_r0_dp002p0 en_op1_1000_rl_s0p1_r0_dp002p0 0 0 sky130_fd_pr__nfet_01v8 L=0.15 W=2 nf=1 ad=0.58 as=0.58 pd=4.58 ps=4.58 mult=1 m=1
XMPH_op1_1000_rl_s0p1_r0_dp002p0 vp_op1_1000_rl_s0p1_r0_dp002p0 enb_op1_1000_rl_s0p1_r0_dp002p0 vdd vdd sky130_fd_pr__pfet_01v8 L=0.15 W=4 nf=1 ad=1.16 as=1.16 pd=8.58 ps=8.58 mult=1 m=1
bd_op1_1000_rl_s0p1_r0_dp002p0 d_op1_1000_rl_s0p1_r0_dp002p0 0 v=v(rbl_op1_1000_rl_s0p1_r0_dp002p0)-v(ref_op1_1000_rl_s0p1_r0_dp002p0)

* ---- instance 247: op0_n100_rl_s0p1_r0_dp002p0 (variant rl_s0p1_r0_dp002p0; probe dec 11.9 ns, release 34 ns, meas 36 ns) ----
vctl_op0_n100_rl_s0p1_r0_dp002p0 ctl_op0_n100_rl_s0p1_r0_dp002p0 0 pwl(0.0000e+00 {VDD} 2.0000e-09 {VDD} 2.1000e-09 0)
* RWL driver model (EXPERIMENTAL): slew 0.1 ns, series R 0 ohm; cell pin = rwls_op0_n100_rl_s0p1_r0_dp002p0
vrs_op0_n100_rl_s0p1_r0_dp002p0 rwls_op0_n100_rl_s0p1_r0_dp002p0 0 pwl(0.0000e+00 {VDD} 2.0000e-09 {VDD} 2.1000e-09 0 3.4000e-08 0 3.4100e-08 {VDD})
ven_op0_n100_rl_s0p1_r0_dp002p0 en_op0_n100_rl_s0p1_r0_dp002p0 0 pwl(0.0000e+00 0 1.1000e-08 0 1.1100e-08 {VDD} 3.4000e-08 {VDD} 3.4100e-08 0)
venb_op0_n100_rl_s0p1_r0_dp002p0 enb_op0_n100_rl_s0p1_r0_dp002p0 0 pwl(0.0000e+00 {VDD} 1.1000e-08 {VDD} 1.1100e-08 0 3.4000e-08 0 3.4100e-08 {VDD})
vww_op0_n100_rl_s0p1_r0_dp002p0 wwl_op0_n100_rl_s0p1_r0_dp002p0 0 pwl(0.0000e+00 0 1.2000e-08 0 1.2100e-08 {VDD} 3.2000e-08 {VDD} 3.2100e-08 0)
vwc_op0_n100_rl_s0p1_r0_dp002p0 wbc_op0_n100_rl_s0p1_r0_dp002p0 0 pwl(0.0000e+00 0 1.2000e-08 0 1.2100e-08 {VDD} 3.4000e-08 {VDD} 3.4100e-08 0)
swb_op0_n100_rl_s0p1_r0_dp002p0 ref_op0_n100_rl_s0p1_r0_dp002p0 wbl_op0_n100_rl_s0p1_r0_dp002p0 wbc_op0_n100_rl_s0p1_r0_dp002p0 0 swwbl
cwbl_op0_n100_rl_s0p1_r0_dp002p0 wbl_op0_n100_rl_s0p1_r0_dp002p0 0 {C_WBL}
spa_op0_n100_rl_s0p1_r0_dp002p0 prea rbl_op0_n100_rl_s0p1_r0_dp002p0 ctl_op0_n100_rl_s0p1_r0_dp002p0 0 swpre
spr_op0_n100_rl_s0p1_r0_dp002p0 pref ref_op0_n100_rl_s0p1_r0_dp002p0 ctl_op0_n100_rl_s0p1_r0_dp002p0 0 swpre
crbl_op0_n100_rl_s0p1_r0_dp002p0 rbl_op0_n100_rl_s0p1_r0_dp002p0 0 {C_RBL}
cref_op0_n100_rl_s0p1_r0_dp002p0 ref_op0_n100_rl_s0p1_r0_dp002p0 0 {C_RBL}   $ ASSUMPTION: ideal matched dummy load
XMWR_op0_n100_rl_s0p1_r0_dp002p0_0 sn_op0_n100_rl_s0p1_r0_dp002p0_0 wwl_op0_n100_rl_s0p1_r0_dp002p0 wbl_op0_n100_rl_s0p1_r0_dp002p0 0 sky130_fd_pr__nfet_01v8 L=0.15 W=0.42 nf=1 ad=0.1218 as=0.1218 pd=1.42 ps=1.42 nrd=0.69047619047619  nrs=0.69047619047619 sa=0 sb=0 sd=0 mult=1 m=1
XMRD_op0_n100_rl_s0p1_r0_dp002p0_0 rbl_op0_n100_rl_s0p1_r0_dp002p0 sn_op0_n100_rl_s0p1_r0_dp002p0_0 rwls_op0_n100_rl_s0p1_r0_dp002p0 0 sky130_fd_pr__nfet_01v8 L=0.15 W=0.42 nf=1 ad=0.1218 as=0.1218 pd=1.42 ps=1.42 nrd=0.69047619047619  nrs=0.69047619047619 sa=0 sb=0 sd=0 mult=1 m=1
csn_op0_n100_rl_s0p1_r0_dp002p0_0 sn_op0_n100_rl_s0p1_r0_dp002p0_0 0 {C_SN}
XMWR_op0_n100_rl_s0p1_r0_dp002p0_1 sn_op0_n100_rl_s0p1_r0_dp002p0_1 wwl_des wbl_op0_n100_rl_s0p1_r0_dp002p0 0 sky130_fd_pr__nfet_01v8 L=0.15 W=0.42 nf=1 ad=0.1218 as=0.1218 pd=1.42 ps=1.42 nrd=0.69047619047619  nrs=0.69047619047619 sa=0 sb=0 sd=0 mult=1 m=1
XMRD_op0_n100_rl_s0p1_r0_dp002p0_1 rbl_op0_n100_rl_s0p1_r0_dp002p0 sn_op0_n100_rl_s0p1_r0_dp002p0_1 rwl_des 0 sky130_fd_pr__nfet_01v8 L=0.15 W=0.42 nf=1 ad=0.1218 as=0.1218 pd=1.42 ps=1.42 nrd=0.69047619047619  nrs=0.69047619047619 sa=0 sb=0 sd=0 mult=1 m=1
csn_op0_n100_rl_s0p1_r0_dp002p0_1 sn_op0_n100_rl_s0p1_r0_dp002p0_1 0 {C_SN}
XMWR_op0_n100_rl_s0p1_r0_dp002p0_2 sn_op0_n100_rl_s0p1_r0_dp002p0_2 wwl_des wbl_op0_n100_rl_s0p1_r0_dp002p0 0 sky130_fd_pr__nfet_01v8 L=0.15 W=0.42 nf=1 ad=0.1218 as=0.1218 pd=1.42 ps=1.42 nrd=0.69047619047619  nrs=0.69047619047619 sa=0 sb=0 sd=0 mult=1 m=1
XMRD_op0_n100_rl_s0p1_r0_dp002p0_2 rbl_op0_n100_rl_s0p1_r0_dp002p0 sn_op0_n100_rl_s0p1_r0_dp002p0_2 rwl_des 0 sky130_fd_pr__nfet_01v8 L=0.15 W=0.42 nf=1 ad=0.1218 as=0.1218 pd=1.42 ps=1.42 nrd=0.69047619047619  nrs=0.69047619047619 sa=0 sb=0 sd=0 mult=1 m=1
csn_op0_n100_rl_s0p1_r0_dp002p0_2 sn_op0_n100_rl_s0p1_r0_dp002p0_2 0 {C_SN}
XMWR_op0_n100_rl_s0p1_r0_dp002p0_3 sn_op0_n100_rl_s0p1_r0_dp002p0_3 wwl_des wbl_op0_n100_rl_s0p1_r0_dp002p0 0 sky130_fd_pr__nfet_01v8 L=0.15 W=0.42 nf=1 ad=0.1218 as=0.1218 pd=1.42 ps=1.42 nrd=0.69047619047619  nrs=0.69047619047619 sa=0 sb=0 sd=0 mult=1 m=1
XMRD_op0_n100_rl_s0p1_r0_dp002p0_3 rbl_op0_n100_rl_s0p1_r0_dp002p0 sn_op0_n100_rl_s0p1_r0_dp002p0_3 rwl_des 0 sky130_fd_pr__nfet_01v8 L=0.15 W=0.42 nf=1 ad=0.1218 as=0.1218 pd=1.42 ps=1.42 nrd=0.69047619047619  nrs=0.69047619047619 sa=0 sb=0 sd=0 mult=1 m=1
csn_op0_n100_rl_s0p1_r0_dp002p0_3 sn_op0_n100_rl_s0p1_r0_dp002p0_3 0 {C_SN}
XMN1_op0_n100_rl_s0p1_r0_dp002p0 rbl_op0_n100_rl_s0p1_r0_dp002p0 ref_op0_n100_rl_s0p1_r0_dp002p0 vn_op0_n100_rl_s0p1_r0_dp002p0 0 sky130_fd_pr__nfet_01v8 L=0.15 W=1 nf=1 ad=0.29 as=0.29 pd=2.58 ps=2.58 mult=1 m=1
XMN2_op0_n100_rl_s0p1_r0_dp002p0 ref_op0_n100_rl_s0p1_r0_dp002p0 rbl_op0_n100_rl_s0p1_r0_dp002p0 vn_op0_n100_rl_s0p1_r0_dp002p0 0 sky130_fd_pr__nfet_01v8 L=0.15 W=1 nf=1 ad=0.29 as=0.29 pd=2.58 ps=2.58 mult=1 m=1
XMP1_op0_n100_rl_s0p1_r0_dp002p0 rbl_op0_n100_rl_s0p1_r0_dp002p0 ref_op0_n100_rl_s0p1_r0_dp002p0 vp_op0_n100_rl_s0p1_r0_dp002p0 vdd sky130_fd_pr__pfet_01v8 L=0.15 W=2 nf=1 ad=0.58 as=0.58 pd=4.58 ps=4.58 mult=1 m=1
XMP2_op0_n100_rl_s0p1_r0_dp002p0 ref_op0_n100_rl_s0p1_r0_dp002p0 rbl_op0_n100_rl_s0p1_r0_dp002p0 vp_op0_n100_rl_s0p1_r0_dp002p0 vdd sky130_fd_pr__pfet_01v8 L=0.15 W=2 nf=1 ad=0.58 as=0.58 pd=4.58 ps=4.58 mult=1 m=1
XMNF_op0_n100_rl_s0p1_r0_dp002p0 vn_op0_n100_rl_s0p1_r0_dp002p0 en_op0_n100_rl_s0p1_r0_dp002p0 0 0 sky130_fd_pr__nfet_01v8 L=0.15 W=2 nf=1 ad=0.58 as=0.58 pd=4.58 ps=4.58 mult=1 m=1
XMPH_op0_n100_rl_s0p1_r0_dp002p0 vp_op0_n100_rl_s0p1_r0_dp002p0 enb_op0_n100_rl_s0p1_r0_dp002p0 vdd vdd sky130_fd_pr__pfet_01v8 L=0.15 W=4 nf=1 ad=1.16 as=1.16 pd=8.58 ps=8.58 mult=1 m=1
bd_op0_n100_rl_s0p1_r0_dp002p0 d_op0_n100_rl_s0p1_r0_dp002p0 0 v=v(rbl_op0_n100_rl_s0p1_r0_dp002p0)-v(ref_op0_n100_rl_s0p1_r0_dp002p0)

* ---- instance 248: op0_0000_rl_s0p1_r0_dp002p0 (variant rl_s0p1_r0_dp002p0; probe dec 11.9 ns, release 34 ns, meas 36 ns) ----
vctl_op0_0000_rl_s0p1_r0_dp002p0 ctl_op0_0000_rl_s0p1_r0_dp002p0 0 pwl(0.0000e+00 {VDD} 2.0000e-09 {VDD} 2.1000e-09 0)
* RWL driver model (EXPERIMENTAL): slew 0.1 ns, series R 0 ohm; cell pin = rwls_op0_0000_rl_s0p1_r0_dp002p0
vrs_op0_0000_rl_s0p1_r0_dp002p0 rwls_op0_0000_rl_s0p1_r0_dp002p0 0 pwl(0.0000e+00 {VDD} 2.0000e-09 {VDD} 2.1000e-09 0 3.4000e-08 0 3.4100e-08 {VDD})
ven_op0_0000_rl_s0p1_r0_dp002p0 en_op0_0000_rl_s0p1_r0_dp002p0 0 pwl(0.0000e+00 0 1.1000e-08 0 1.1100e-08 {VDD} 3.4000e-08 {VDD} 3.4100e-08 0)
venb_op0_0000_rl_s0p1_r0_dp002p0 enb_op0_0000_rl_s0p1_r0_dp002p0 0 pwl(0.0000e+00 {VDD} 1.1000e-08 {VDD} 1.1100e-08 0 3.4000e-08 0 3.4100e-08 {VDD})
vww_op0_0000_rl_s0p1_r0_dp002p0 wwl_op0_0000_rl_s0p1_r0_dp002p0 0 pwl(0.0000e+00 0 1.2000e-08 0 1.2100e-08 {VDD} 3.2000e-08 {VDD} 3.2100e-08 0)
vwc_op0_0000_rl_s0p1_r0_dp002p0 wbc_op0_0000_rl_s0p1_r0_dp002p0 0 pwl(0.0000e+00 0 1.2000e-08 0 1.2100e-08 {VDD} 3.4000e-08 {VDD} 3.4100e-08 0)
swb_op0_0000_rl_s0p1_r0_dp002p0 ref_op0_0000_rl_s0p1_r0_dp002p0 wbl_op0_0000_rl_s0p1_r0_dp002p0 wbc_op0_0000_rl_s0p1_r0_dp002p0 0 swwbl
cwbl_op0_0000_rl_s0p1_r0_dp002p0 wbl_op0_0000_rl_s0p1_r0_dp002p0 0 {C_WBL}
spa_op0_0000_rl_s0p1_r0_dp002p0 prea rbl_op0_0000_rl_s0p1_r0_dp002p0 ctl_op0_0000_rl_s0p1_r0_dp002p0 0 swpre
spr_op0_0000_rl_s0p1_r0_dp002p0 pref ref_op0_0000_rl_s0p1_r0_dp002p0 ctl_op0_0000_rl_s0p1_r0_dp002p0 0 swpre
crbl_op0_0000_rl_s0p1_r0_dp002p0 rbl_op0_0000_rl_s0p1_r0_dp002p0 0 {C_RBL}
cref_op0_0000_rl_s0p1_r0_dp002p0 ref_op0_0000_rl_s0p1_r0_dp002p0 0 {C_RBL}   $ ASSUMPTION: ideal matched dummy load
XMWR_op0_0000_rl_s0p1_r0_dp002p0_0 sn_op0_0000_rl_s0p1_r0_dp002p0_0 wwl_op0_0000_rl_s0p1_r0_dp002p0 wbl_op0_0000_rl_s0p1_r0_dp002p0 0 sky130_fd_pr__nfet_01v8 L=0.15 W=0.42 nf=1 ad=0.1218 as=0.1218 pd=1.42 ps=1.42 nrd=0.69047619047619  nrs=0.69047619047619 sa=0 sb=0 sd=0 mult=1 m=1
XMRD_op0_0000_rl_s0p1_r0_dp002p0_0 rbl_op0_0000_rl_s0p1_r0_dp002p0 sn_op0_0000_rl_s0p1_r0_dp002p0_0 rwls_op0_0000_rl_s0p1_r0_dp002p0 0 sky130_fd_pr__nfet_01v8 L=0.15 W=0.42 nf=1 ad=0.1218 as=0.1218 pd=1.42 ps=1.42 nrd=0.69047619047619  nrs=0.69047619047619 sa=0 sb=0 sd=0 mult=1 m=1
csn_op0_0000_rl_s0p1_r0_dp002p0_0 sn_op0_0000_rl_s0p1_r0_dp002p0_0 0 {C_SN}
XMWR_op0_0000_rl_s0p1_r0_dp002p0_1 sn_op0_0000_rl_s0p1_r0_dp002p0_1 wwl_des wbl_op0_0000_rl_s0p1_r0_dp002p0 0 sky130_fd_pr__nfet_01v8 L=0.15 W=0.42 nf=1 ad=0.1218 as=0.1218 pd=1.42 ps=1.42 nrd=0.69047619047619  nrs=0.69047619047619 sa=0 sb=0 sd=0 mult=1 m=1
XMRD_op0_0000_rl_s0p1_r0_dp002p0_1 rbl_op0_0000_rl_s0p1_r0_dp002p0 sn_op0_0000_rl_s0p1_r0_dp002p0_1 rwl_des 0 sky130_fd_pr__nfet_01v8 L=0.15 W=0.42 nf=1 ad=0.1218 as=0.1218 pd=1.42 ps=1.42 nrd=0.69047619047619  nrs=0.69047619047619 sa=0 sb=0 sd=0 mult=1 m=1
csn_op0_0000_rl_s0p1_r0_dp002p0_1 sn_op0_0000_rl_s0p1_r0_dp002p0_1 0 {C_SN}
XMWR_op0_0000_rl_s0p1_r0_dp002p0_2 sn_op0_0000_rl_s0p1_r0_dp002p0_2 wwl_des wbl_op0_0000_rl_s0p1_r0_dp002p0 0 sky130_fd_pr__nfet_01v8 L=0.15 W=0.42 nf=1 ad=0.1218 as=0.1218 pd=1.42 ps=1.42 nrd=0.69047619047619  nrs=0.69047619047619 sa=0 sb=0 sd=0 mult=1 m=1
XMRD_op0_0000_rl_s0p1_r0_dp002p0_2 rbl_op0_0000_rl_s0p1_r0_dp002p0 sn_op0_0000_rl_s0p1_r0_dp002p0_2 rwl_des 0 sky130_fd_pr__nfet_01v8 L=0.15 W=0.42 nf=1 ad=0.1218 as=0.1218 pd=1.42 ps=1.42 nrd=0.69047619047619  nrs=0.69047619047619 sa=0 sb=0 sd=0 mult=1 m=1
csn_op0_0000_rl_s0p1_r0_dp002p0_2 sn_op0_0000_rl_s0p1_r0_dp002p0_2 0 {C_SN}
XMWR_op0_0000_rl_s0p1_r0_dp002p0_3 sn_op0_0000_rl_s0p1_r0_dp002p0_3 wwl_des wbl_op0_0000_rl_s0p1_r0_dp002p0 0 sky130_fd_pr__nfet_01v8 L=0.15 W=0.42 nf=1 ad=0.1218 as=0.1218 pd=1.42 ps=1.42 nrd=0.69047619047619  nrs=0.69047619047619 sa=0 sb=0 sd=0 mult=1 m=1
XMRD_op0_0000_rl_s0p1_r0_dp002p0_3 rbl_op0_0000_rl_s0p1_r0_dp002p0 sn_op0_0000_rl_s0p1_r0_dp002p0_3 rwl_des 0 sky130_fd_pr__nfet_01v8 L=0.15 W=0.42 nf=1 ad=0.1218 as=0.1218 pd=1.42 ps=1.42 nrd=0.69047619047619  nrs=0.69047619047619 sa=0 sb=0 sd=0 mult=1 m=1
csn_op0_0000_rl_s0p1_r0_dp002p0_3 sn_op0_0000_rl_s0p1_r0_dp002p0_3 0 {C_SN}
XMN1_op0_0000_rl_s0p1_r0_dp002p0 rbl_op0_0000_rl_s0p1_r0_dp002p0 ref_op0_0000_rl_s0p1_r0_dp002p0 vn_op0_0000_rl_s0p1_r0_dp002p0 0 sky130_fd_pr__nfet_01v8 L=0.15 W=1 nf=1 ad=0.29 as=0.29 pd=2.58 ps=2.58 mult=1 m=1
XMN2_op0_0000_rl_s0p1_r0_dp002p0 ref_op0_0000_rl_s0p1_r0_dp002p0 rbl_op0_0000_rl_s0p1_r0_dp002p0 vn_op0_0000_rl_s0p1_r0_dp002p0 0 sky130_fd_pr__nfet_01v8 L=0.15 W=1 nf=1 ad=0.29 as=0.29 pd=2.58 ps=2.58 mult=1 m=1
XMP1_op0_0000_rl_s0p1_r0_dp002p0 rbl_op0_0000_rl_s0p1_r0_dp002p0 ref_op0_0000_rl_s0p1_r0_dp002p0 vp_op0_0000_rl_s0p1_r0_dp002p0 vdd sky130_fd_pr__pfet_01v8 L=0.15 W=2 nf=1 ad=0.58 as=0.58 pd=4.58 ps=4.58 mult=1 m=1
XMP2_op0_0000_rl_s0p1_r0_dp002p0 ref_op0_0000_rl_s0p1_r0_dp002p0 rbl_op0_0000_rl_s0p1_r0_dp002p0 vp_op0_0000_rl_s0p1_r0_dp002p0 vdd sky130_fd_pr__pfet_01v8 L=0.15 W=2 nf=1 ad=0.58 as=0.58 pd=4.58 ps=4.58 mult=1 m=1
XMNF_op0_0000_rl_s0p1_r0_dp002p0 vn_op0_0000_rl_s0p1_r0_dp002p0 en_op0_0000_rl_s0p1_r0_dp002p0 0 0 sky130_fd_pr__nfet_01v8 L=0.15 W=2 nf=1 ad=0.58 as=0.58 pd=4.58 ps=4.58 mult=1 m=1
XMPH_op0_0000_rl_s0p1_r0_dp002p0 vp_op0_0000_rl_s0p1_r0_dp002p0 enb_op0_0000_rl_s0p1_r0_dp002p0 vdd vdd sky130_fd_pr__pfet_01v8 L=0.15 W=4 nf=1 ad=1.16 as=1.16 pd=8.58 ps=8.58 mult=1 m=1
bd_op0_0000_rl_s0p1_r0_dp002p0 d_op0_0000_rl_s0p1_r0_dp002p0 0 v=v(rbl_op0_0000_rl_s0p1_r0_dp002p0)-v(ref_op0_0000_rl_s0p1_r0_dp002p0)

* ---- instance 249: op1_0900_rl_s0p1_r0_dp003p0 (variant rl_s0p1_r0_dp003p0; probe dec 11.9 ns, release 35 ns, meas 36 ns) ----
vctl_op1_0900_rl_s0p1_r0_dp003p0 ctl_op1_0900_rl_s0p1_r0_dp003p0 0 pwl(0.0000e+00 {VDD} 2.0000e-09 {VDD} 2.1000e-09 0)
* RWL driver model (EXPERIMENTAL): slew 0.1 ns, series R 0 ohm; cell pin = rwls_op1_0900_rl_s0p1_r0_dp003p0
vrs_op1_0900_rl_s0p1_r0_dp003p0 rwls_op1_0900_rl_s0p1_r0_dp003p0 0 pwl(0.0000e+00 {VDD} 2.0000e-09 {VDD} 2.1000e-09 0 3.5000e-08 0 3.5100e-08 {VDD})
ven_op1_0900_rl_s0p1_r0_dp003p0 en_op1_0900_rl_s0p1_r0_dp003p0 0 pwl(0.0000e+00 0 1.1000e-08 0 1.1100e-08 {VDD} 3.4000e-08 {VDD} 3.4100e-08 0)
venb_op1_0900_rl_s0p1_r0_dp003p0 enb_op1_0900_rl_s0p1_r0_dp003p0 0 pwl(0.0000e+00 {VDD} 1.1000e-08 {VDD} 1.1100e-08 0 3.4000e-08 0 3.4100e-08 {VDD})
vww_op1_0900_rl_s0p1_r0_dp003p0 wwl_op1_0900_rl_s0p1_r0_dp003p0 0 pwl(0.0000e+00 0 1.2000e-08 0 1.2100e-08 {VDD} 3.2000e-08 {VDD} 3.2100e-08 0)
vwc_op1_0900_rl_s0p1_r0_dp003p0 wbc_op1_0900_rl_s0p1_r0_dp003p0 0 pwl(0.0000e+00 0 1.2000e-08 0 1.2100e-08 {VDD} 3.4000e-08 {VDD} 3.4100e-08 0)
swb_op1_0900_rl_s0p1_r0_dp003p0 ref_op1_0900_rl_s0p1_r0_dp003p0 wbl_op1_0900_rl_s0p1_r0_dp003p0 wbc_op1_0900_rl_s0p1_r0_dp003p0 0 swwbl
cwbl_op1_0900_rl_s0p1_r0_dp003p0 wbl_op1_0900_rl_s0p1_r0_dp003p0 0 {C_WBL}
spa_op1_0900_rl_s0p1_r0_dp003p0 prea rbl_op1_0900_rl_s0p1_r0_dp003p0 ctl_op1_0900_rl_s0p1_r0_dp003p0 0 swpre
spr_op1_0900_rl_s0p1_r0_dp003p0 pref ref_op1_0900_rl_s0p1_r0_dp003p0 ctl_op1_0900_rl_s0p1_r0_dp003p0 0 swpre
crbl_op1_0900_rl_s0p1_r0_dp003p0 rbl_op1_0900_rl_s0p1_r0_dp003p0 0 {C_RBL}
cref_op1_0900_rl_s0p1_r0_dp003p0 ref_op1_0900_rl_s0p1_r0_dp003p0 0 {C_RBL}   $ ASSUMPTION: ideal matched dummy load
XMWR_op1_0900_rl_s0p1_r0_dp003p0_0 sn_op1_0900_rl_s0p1_r0_dp003p0_0 wwl_op1_0900_rl_s0p1_r0_dp003p0 wbl_op1_0900_rl_s0p1_r0_dp003p0 0 sky130_fd_pr__nfet_01v8 L=0.15 W=0.42 nf=1 ad=0.1218 as=0.1218 pd=1.42 ps=1.42 nrd=0.69047619047619  nrs=0.69047619047619 sa=0 sb=0 sd=0 mult=1 m=1
XMRD_op1_0900_rl_s0p1_r0_dp003p0_0 rbl_op1_0900_rl_s0p1_r0_dp003p0 sn_op1_0900_rl_s0p1_r0_dp003p0_0 rwls_op1_0900_rl_s0p1_r0_dp003p0 0 sky130_fd_pr__nfet_01v8 L=0.15 W=0.42 nf=1 ad=0.1218 as=0.1218 pd=1.42 ps=1.42 nrd=0.69047619047619  nrs=0.69047619047619 sa=0 sb=0 sd=0 mult=1 m=1
csn_op1_0900_rl_s0p1_r0_dp003p0_0 sn_op1_0900_rl_s0p1_r0_dp003p0_0 0 {C_SN}
XMWR_op1_0900_rl_s0p1_r0_dp003p0_1 sn_op1_0900_rl_s0p1_r0_dp003p0_1 wwl_des wbl_op1_0900_rl_s0p1_r0_dp003p0 0 sky130_fd_pr__nfet_01v8 L=0.15 W=0.42 nf=1 ad=0.1218 as=0.1218 pd=1.42 ps=1.42 nrd=0.69047619047619  nrs=0.69047619047619 sa=0 sb=0 sd=0 mult=1 m=1
XMRD_op1_0900_rl_s0p1_r0_dp003p0_1 rbl_op1_0900_rl_s0p1_r0_dp003p0 sn_op1_0900_rl_s0p1_r0_dp003p0_1 rwl_des 0 sky130_fd_pr__nfet_01v8 L=0.15 W=0.42 nf=1 ad=0.1218 as=0.1218 pd=1.42 ps=1.42 nrd=0.69047619047619  nrs=0.69047619047619 sa=0 sb=0 sd=0 mult=1 m=1
csn_op1_0900_rl_s0p1_r0_dp003p0_1 sn_op1_0900_rl_s0p1_r0_dp003p0_1 0 {C_SN}
XMWR_op1_0900_rl_s0p1_r0_dp003p0_2 sn_op1_0900_rl_s0p1_r0_dp003p0_2 wwl_des wbl_op1_0900_rl_s0p1_r0_dp003p0 0 sky130_fd_pr__nfet_01v8 L=0.15 W=0.42 nf=1 ad=0.1218 as=0.1218 pd=1.42 ps=1.42 nrd=0.69047619047619  nrs=0.69047619047619 sa=0 sb=0 sd=0 mult=1 m=1
XMRD_op1_0900_rl_s0p1_r0_dp003p0_2 rbl_op1_0900_rl_s0p1_r0_dp003p0 sn_op1_0900_rl_s0p1_r0_dp003p0_2 rwl_des 0 sky130_fd_pr__nfet_01v8 L=0.15 W=0.42 nf=1 ad=0.1218 as=0.1218 pd=1.42 ps=1.42 nrd=0.69047619047619  nrs=0.69047619047619 sa=0 sb=0 sd=0 mult=1 m=1
csn_op1_0900_rl_s0p1_r0_dp003p0_2 sn_op1_0900_rl_s0p1_r0_dp003p0_2 0 {C_SN}
XMWR_op1_0900_rl_s0p1_r0_dp003p0_3 sn_op1_0900_rl_s0p1_r0_dp003p0_3 wwl_des wbl_op1_0900_rl_s0p1_r0_dp003p0 0 sky130_fd_pr__nfet_01v8 L=0.15 W=0.42 nf=1 ad=0.1218 as=0.1218 pd=1.42 ps=1.42 nrd=0.69047619047619  nrs=0.69047619047619 sa=0 sb=0 sd=0 mult=1 m=1
XMRD_op1_0900_rl_s0p1_r0_dp003p0_3 rbl_op1_0900_rl_s0p1_r0_dp003p0 sn_op1_0900_rl_s0p1_r0_dp003p0_3 rwl_des 0 sky130_fd_pr__nfet_01v8 L=0.15 W=0.42 nf=1 ad=0.1218 as=0.1218 pd=1.42 ps=1.42 nrd=0.69047619047619  nrs=0.69047619047619 sa=0 sb=0 sd=0 mult=1 m=1
csn_op1_0900_rl_s0p1_r0_dp003p0_3 sn_op1_0900_rl_s0p1_r0_dp003p0_3 0 {C_SN}
XMN1_op1_0900_rl_s0p1_r0_dp003p0 rbl_op1_0900_rl_s0p1_r0_dp003p0 ref_op1_0900_rl_s0p1_r0_dp003p0 vn_op1_0900_rl_s0p1_r0_dp003p0 0 sky130_fd_pr__nfet_01v8 L=0.15 W=1 nf=1 ad=0.29 as=0.29 pd=2.58 ps=2.58 mult=1 m=1
XMN2_op1_0900_rl_s0p1_r0_dp003p0 ref_op1_0900_rl_s0p1_r0_dp003p0 rbl_op1_0900_rl_s0p1_r0_dp003p0 vn_op1_0900_rl_s0p1_r0_dp003p0 0 sky130_fd_pr__nfet_01v8 L=0.15 W=1 nf=1 ad=0.29 as=0.29 pd=2.58 ps=2.58 mult=1 m=1
XMP1_op1_0900_rl_s0p1_r0_dp003p0 rbl_op1_0900_rl_s0p1_r0_dp003p0 ref_op1_0900_rl_s0p1_r0_dp003p0 vp_op1_0900_rl_s0p1_r0_dp003p0 vdd sky130_fd_pr__pfet_01v8 L=0.15 W=2 nf=1 ad=0.58 as=0.58 pd=4.58 ps=4.58 mult=1 m=1
XMP2_op1_0900_rl_s0p1_r0_dp003p0 ref_op1_0900_rl_s0p1_r0_dp003p0 rbl_op1_0900_rl_s0p1_r0_dp003p0 vp_op1_0900_rl_s0p1_r0_dp003p0 vdd sky130_fd_pr__pfet_01v8 L=0.15 W=2 nf=1 ad=0.58 as=0.58 pd=4.58 ps=4.58 mult=1 m=1
XMNF_op1_0900_rl_s0p1_r0_dp003p0 vn_op1_0900_rl_s0p1_r0_dp003p0 en_op1_0900_rl_s0p1_r0_dp003p0 0 0 sky130_fd_pr__nfet_01v8 L=0.15 W=2 nf=1 ad=0.58 as=0.58 pd=4.58 ps=4.58 mult=1 m=1
XMPH_op1_0900_rl_s0p1_r0_dp003p0 vp_op1_0900_rl_s0p1_r0_dp003p0 enb_op1_0900_rl_s0p1_r0_dp003p0 vdd vdd sky130_fd_pr__pfet_01v8 L=0.15 W=4 nf=1 ad=1.16 as=1.16 pd=8.58 ps=8.58 mult=1 m=1
bd_op1_0900_rl_s0p1_r0_dp003p0 d_op1_0900_rl_s0p1_r0_dp003p0 0 v=v(rbl_op1_0900_rl_s0p1_r0_dp003p0)-v(ref_op1_0900_rl_s0p1_r0_dp003p0)

* ---- instance 250: op1_1000_rl_s0p1_r0_dp003p0 (variant rl_s0p1_r0_dp003p0; probe dec 11.9 ns, release 35 ns, meas 36 ns) ----
vctl_op1_1000_rl_s0p1_r0_dp003p0 ctl_op1_1000_rl_s0p1_r0_dp003p0 0 pwl(0.0000e+00 {VDD} 2.0000e-09 {VDD} 2.1000e-09 0)
* RWL driver model (EXPERIMENTAL): slew 0.1 ns, series R 0 ohm; cell pin = rwls_op1_1000_rl_s0p1_r0_dp003p0
vrs_op1_1000_rl_s0p1_r0_dp003p0 rwls_op1_1000_rl_s0p1_r0_dp003p0 0 pwl(0.0000e+00 {VDD} 2.0000e-09 {VDD} 2.1000e-09 0 3.5000e-08 0 3.5100e-08 {VDD})
ven_op1_1000_rl_s0p1_r0_dp003p0 en_op1_1000_rl_s0p1_r0_dp003p0 0 pwl(0.0000e+00 0 1.1000e-08 0 1.1100e-08 {VDD} 3.4000e-08 {VDD} 3.4100e-08 0)
venb_op1_1000_rl_s0p1_r0_dp003p0 enb_op1_1000_rl_s0p1_r0_dp003p0 0 pwl(0.0000e+00 {VDD} 1.1000e-08 {VDD} 1.1100e-08 0 3.4000e-08 0 3.4100e-08 {VDD})
vww_op1_1000_rl_s0p1_r0_dp003p0 wwl_op1_1000_rl_s0p1_r0_dp003p0 0 pwl(0.0000e+00 0 1.2000e-08 0 1.2100e-08 {VDD} 3.2000e-08 {VDD} 3.2100e-08 0)
vwc_op1_1000_rl_s0p1_r0_dp003p0 wbc_op1_1000_rl_s0p1_r0_dp003p0 0 pwl(0.0000e+00 0 1.2000e-08 0 1.2100e-08 {VDD} 3.4000e-08 {VDD} 3.4100e-08 0)
swb_op1_1000_rl_s0p1_r0_dp003p0 ref_op1_1000_rl_s0p1_r0_dp003p0 wbl_op1_1000_rl_s0p1_r0_dp003p0 wbc_op1_1000_rl_s0p1_r0_dp003p0 0 swwbl
cwbl_op1_1000_rl_s0p1_r0_dp003p0 wbl_op1_1000_rl_s0p1_r0_dp003p0 0 {C_WBL}
spa_op1_1000_rl_s0p1_r0_dp003p0 prea rbl_op1_1000_rl_s0p1_r0_dp003p0 ctl_op1_1000_rl_s0p1_r0_dp003p0 0 swpre
spr_op1_1000_rl_s0p1_r0_dp003p0 pref ref_op1_1000_rl_s0p1_r0_dp003p0 ctl_op1_1000_rl_s0p1_r0_dp003p0 0 swpre
crbl_op1_1000_rl_s0p1_r0_dp003p0 rbl_op1_1000_rl_s0p1_r0_dp003p0 0 {C_RBL}
cref_op1_1000_rl_s0p1_r0_dp003p0 ref_op1_1000_rl_s0p1_r0_dp003p0 0 {C_RBL}   $ ASSUMPTION: ideal matched dummy load
XMWR_op1_1000_rl_s0p1_r0_dp003p0_0 sn_op1_1000_rl_s0p1_r0_dp003p0_0 wwl_op1_1000_rl_s0p1_r0_dp003p0 wbl_op1_1000_rl_s0p1_r0_dp003p0 0 sky130_fd_pr__nfet_01v8 L=0.15 W=0.42 nf=1 ad=0.1218 as=0.1218 pd=1.42 ps=1.42 nrd=0.69047619047619  nrs=0.69047619047619 sa=0 sb=0 sd=0 mult=1 m=1
XMRD_op1_1000_rl_s0p1_r0_dp003p0_0 rbl_op1_1000_rl_s0p1_r0_dp003p0 sn_op1_1000_rl_s0p1_r0_dp003p0_0 rwls_op1_1000_rl_s0p1_r0_dp003p0 0 sky130_fd_pr__nfet_01v8 L=0.15 W=0.42 nf=1 ad=0.1218 as=0.1218 pd=1.42 ps=1.42 nrd=0.69047619047619  nrs=0.69047619047619 sa=0 sb=0 sd=0 mult=1 m=1
csn_op1_1000_rl_s0p1_r0_dp003p0_0 sn_op1_1000_rl_s0p1_r0_dp003p0_0 0 {C_SN}
XMWR_op1_1000_rl_s0p1_r0_dp003p0_1 sn_op1_1000_rl_s0p1_r0_dp003p0_1 wwl_des wbl_op1_1000_rl_s0p1_r0_dp003p0 0 sky130_fd_pr__nfet_01v8 L=0.15 W=0.42 nf=1 ad=0.1218 as=0.1218 pd=1.42 ps=1.42 nrd=0.69047619047619  nrs=0.69047619047619 sa=0 sb=0 sd=0 mult=1 m=1
XMRD_op1_1000_rl_s0p1_r0_dp003p0_1 rbl_op1_1000_rl_s0p1_r0_dp003p0 sn_op1_1000_rl_s0p1_r0_dp003p0_1 rwl_des 0 sky130_fd_pr__nfet_01v8 L=0.15 W=0.42 nf=1 ad=0.1218 as=0.1218 pd=1.42 ps=1.42 nrd=0.69047619047619  nrs=0.69047619047619 sa=0 sb=0 sd=0 mult=1 m=1
csn_op1_1000_rl_s0p1_r0_dp003p0_1 sn_op1_1000_rl_s0p1_r0_dp003p0_1 0 {C_SN}
XMWR_op1_1000_rl_s0p1_r0_dp003p0_2 sn_op1_1000_rl_s0p1_r0_dp003p0_2 wwl_des wbl_op1_1000_rl_s0p1_r0_dp003p0 0 sky130_fd_pr__nfet_01v8 L=0.15 W=0.42 nf=1 ad=0.1218 as=0.1218 pd=1.42 ps=1.42 nrd=0.69047619047619  nrs=0.69047619047619 sa=0 sb=0 sd=0 mult=1 m=1
XMRD_op1_1000_rl_s0p1_r0_dp003p0_2 rbl_op1_1000_rl_s0p1_r0_dp003p0 sn_op1_1000_rl_s0p1_r0_dp003p0_2 rwl_des 0 sky130_fd_pr__nfet_01v8 L=0.15 W=0.42 nf=1 ad=0.1218 as=0.1218 pd=1.42 ps=1.42 nrd=0.69047619047619  nrs=0.69047619047619 sa=0 sb=0 sd=0 mult=1 m=1
csn_op1_1000_rl_s0p1_r0_dp003p0_2 sn_op1_1000_rl_s0p1_r0_dp003p0_2 0 {C_SN}
XMWR_op1_1000_rl_s0p1_r0_dp003p0_3 sn_op1_1000_rl_s0p1_r0_dp003p0_3 wwl_des wbl_op1_1000_rl_s0p1_r0_dp003p0 0 sky130_fd_pr__nfet_01v8 L=0.15 W=0.42 nf=1 ad=0.1218 as=0.1218 pd=1.42 ps=1.42 nrd=0.69047619047619  nrs=0.69047619047619 sa=0 sb=0 sd=0 mult=1 m=1
XMRD_op1_1000_rl_s0p1_r0_dp003p0_3 rbl_op1_1000_rl_s0p1_r0_dp003p0 sn_op1_1000_rl_s0p1_r0_dp003p0_3 rwl_des 0 sky130_fd_pr__nfet_01v8 L=0.15 W=0.42 nf=1 ad=0.1218 as=0.1218 pd=1.42 ps=1.42 nrd=0.69047619047619  nrs=0.69047619047619 sa=0 sb=0 sd=0 mult=1 m=1
csn_op1_1000_rl_s0p1_r0_dp003p0_3 sn_op1_1000_rl_s0p1_r0_dp003p0_3 0 {C_SN}
XMN1_op1_1000_rl_s0p1_r0_dp003p0 rbl_op1_1000_rl_s0p1_r0_dp003p0 ref_op1_1000_rl_s0p1_r0_dp003p0 vn_op1_1000_rl_s0p1_r0_dp003p0 0 sky130_fd_pr__nfet_01v8 L=0.15 W=1 nf=1 ad=0.29 as=0.29 pd=2.58 ps=2.58 mult=1 m=1
XMN2_op1_1000_rl_s0p1_r0_dp003p0 ref_op1_1000_rl_s0p1_r0_dp003p0 rbl_op1_1000_rl_s0p1_r0_dp003p0 vn_op1_1000_rl_s0p1_r0_dp003p0 0 sky130_fd_pr__nfet_01v8 L=0.15 W=1 nf=1 ad=0.29 as=0.29 pd=2.58 ps=2.58 mult=1 m=1
XMP1_op1_1000_rl_s0p1_r0_dp003p0 rbl_op1_1000_rl_s0p1_r0_dp003p0 ref_op1_1000_rl_s0p1_r0_dp003p0 vp_op1_1000_rl_s0p1_r0_dp003p0 vdd sky130_fd_pr__pfet_01v8 L=0.15 W=2 nf=1 ad=0.58 as=0.58 pd=4.58 ps=4.58 mult=1 m=1
XMP2_op1_1000_rl_s0p1_r0_dp003p0 ref_op1_1000_rl_s0p1_r0_dp003p0 rbl_op1_1000_rl_s0p1_r0_dp003p0 vp_op1_1000_rl_s0p1_r0_dp003p0 vdd sky130_fd_pr__pfet_01v8 L=0.15 W=2 nf=1 ad=0.58 as=0.58 pd=4.58 ps=4.58 mult=1 m=1
XMNF_op1_1000_rl_s0p1_r0_dp003p0 vn_op1_1000_rl_s0p1_r0_dp003p0 en_op1_1000_rl_s0p1_r0_dp003p0 0 0 sky130_fd_pr__nfet_01v8 L=0.15 W=2 nf=1 ad=0.58 as=0.58 pd=4.58 ps=4.58 mult=1 m=1
XMPH_op1_1000_rl_s0p1_r0_dp003p0 vp_op1_1000_rl_s0p1_r0_dp003p0 enb_op1_1000_rl_s0p1_r0_dp003p0 vdd vdd sky130_fd_pr__pfet_01v8 L=0.15 W=4 nf=1 ad=1.16 as=1.16 pd=8.58 ps=8.58 mult=1 m=1
bd_op1_1000_rl_s0p1_r0_dp003p0 d_op1_1000_rl_s0p1_r0_dp003p0 0 v=v(rbl_op1_1000_rl_s0p1_r0_dp003p0)-v(ref_op1_1000_rl_s0p1_r0_dp003p0)

* ---- instance 251: op0_n100_rl_s0p1_r0_dp003p0 (variant rl_s0p1_r0_dp003p0; probe dec 11.9 ns, release 35 ns, meas 36 ns) ----
vctl_op0_n100_rl_s0p1_r0_dp003p0 ctl_op0_n100_rl_s0p1_r0_dp003p0 0 pwl(0.0000e+00 {VDD} 2.0000e-09 {VDD} 2.1000e-09 0)
* RWL driver model (EXPERIMENTAL): slew 0.1 ns, series R 0 ohm; cell pin = rwls_op0_n100_rl_s0p1_r0_dp003p0
vrs_op0_n100_rl_s0p1_r0_dp003p0 rwls_op0_n100_rl_s0p1_r0_dp003p0 0 pwl(0.0000e+00 {VDD} 2.0000e-09 {VDD} 2.1000e-09 0 3.5000e-08 0 3.5100e-08 {VDD})
ven_op0_n100_rl_s0p1_r0_dp003p0 en_op0_n100_rl_s0p1_r0_dp003p0 0 pwl(0.0000e+00 0 1.1000e-08 0 1.1100e-08 {VDD} 3.4000e-08 {VDD} 3.4100e-08 0)
venb_op0_n100_rl_s0p1_r0_dp003p0 enb_op0_n100_rl_s0p1_r0_dp003p0 0 pwl(0.0000e+00 {VDD} 1.1000e-08 {VDD} 1.1100e-08 0 3.4000e-08 0 3.4100e-08 {VDD})
vww_op0_n100_rl_s0p1_r0_dp003p0 wwl_op0_n100_rl_s0p1_r0_dp003p0 0 pwl(0.0000e+00 0 1.2000e-08 0 1.2100e-08 {VDD} 3.2000e-08 {VDD} 3.2100e-08 0)
vwc_op0_n100_rl_s0p1_r0_dp003p0 wbc_op0_n100_rl_s0p1_r0_dp003p0 0 pwl(0.0000e+00 0 1.2000e-08 0 1.2100e-08 {VDD} 3.4000e-08 {VDD} 3.4100e-08 0)
swb_op0_n100_rl_s0p1_r0_dp003p0 ref_op0_n100_rl_s0p1_r0_dp003p0 wbl_op0_n100_rl_s0p1_r0_dp003p0 wbc_op0_n100_rl_s0p1_r0_dp003p0 0 swwbl
cwbl_op0_n100_rl_s0p1_r0_dp003p0 wbl_op0_n100_rl_s0p1_r0_dp003p0 0 {C_WBL}
spa_op0_n100_rl_s0p1_r0_dp003p0 prea rbl_op0_n100_rl_s0p1_r0_dp003p0 ctl_op0_n100_rl_s0p1_r0_dp003p0 0 swpre
spr_op0_n100_rl_s0p1_r0_dp003p0 pref ref_op0_n100_rl_s0p1_r0_dp003p0 ctl_op0_n100_rl_s0p1_r0_dp003p0 0 swpre
crbl_op0_n100_rl_s0p1_r0_dp003p0 rbl_op0_n100_rl_s0p1_r0_dp003p0 0 {C_RBL}
cref_op0_n100_rl_s0p1_r0_dp003p0 ref_op0_n100_rl_s0p1_r0_dp003p0 0 {C_RBL}   $ ASSUMPTION: ideal matched dummy load
XMWR_op0_n100_rl_s0p1_r0_dp003p0_0 sn_op0_n100_rl_s0p1_r0_dp003p0_0 wwl_op0_n100_rl_s0p1_r0_dp003p0 wbl_op0_n100_rl_s0p1_r0_dp003p0 0 sky130_fd_pr__nfet_01v8 L=0.15 W=0.42 nf=1 ad=0.1218 as=0.1218 pd=1.42 ps=1.42 nrd=0.69047619047619  nrs=0.69047619047619 sa=0 sb=0 sd=0 mult=1 m=1
XMRD_op0_n100_rl_s0p1_r0_dp003p0_0 rbl_op0_n100_rl_s0p1_r0_dp003p0 sn_op0_n100_rl_s0p1_r0_dp003p0_0 rwls_op0_n100_rl_s0p1_r0_dp003p0 0 sky130_fd_pr__nfet_01v8 L=0.15 W=0.42 nf=1 ad=0.1218 as=0.1218 pd=1.42 ps=1.42 nrd=0.69047619047619  nrs=0.69047619047619 sa=0 sb=0 sd=0 mult=1 m=1
csn_op0_n100_rl_s0p1_r0_dp003p0_0 sn_op0_n100_rl_s0p1_r0_dp003p0_0 0 {C_SN}
XMWR_op0_n100_rl_s0p1_r0_dp003p0_1 sn_op0_n100_rl_s0p1_r0_dp003p0_1 wwl_des wbl_op0_n100_rl_s0p1_r0_dp003p0 0 sky130_fd_pr__nfet_01v8 L=0.15 W=0.42 nf=1 ad=0.1218 as=0.1218 pd=1.42 ps=1.42 nrd=0.69047619047619  nrs=0.69047619047619 sa=0 sb=0 sd=0 mult=1 m=1
XMRD_op0_n100_rl_s0p1_r0_dp003p0_1 rbl_op0_n100_rl_s0p1_r0_dp003p0 sn_op0_n100_rl_s0p1_r0_dp003p0_1 rwl_des 0 sky130_fd_pr__nfet_01v8 L=0.15 W=0.42 nf=1 ad=0.1218 as=0.1218 pd=1.42 ps=1.42 nrd=0.69047619047619  nrs=0.69047619047619 sa=0 sb=0 sd=0 mult=1 m=1
csn_op0_n100_rl_s0p1_r0_dp003p0_1 sn_op0_n100_rl_s0p1_r0_dp003p0_1 0 {C_SN}
XMWR_op0_n100_rl_s0p1_r0_dp003p0_2 sn_op0_n100_rl_s0p1_r0_dp003p0_2 wwl_des wbl_op0_n100_rl_s0p1_r0_dp003p0 0 sky130_fd_pr__nfet_01v8 L=0.15 W=0.42 nf=1 ad=0.1218 as=0.1218 pd=1.42 ps=1.42 nrd=0.69047619047619  nrs=0.69047619047619 sa=0 sb=0 sd=0 mult=1 m=1
XMRD_op0_n100_rl_s0p1_r0_dp003p0_2 rbl_op0_n100_rl_s0p1_r0_dp003p0 sn_op0_n100_rl_s0p1_r0_dp003p0_2 rwl_des 0 sky130_fd_pr__nfet_01v8 L=0.15 W=0.42 nf=1 ad=0.1218 as=0.1218 pd=1.42 ps=1.42 nrd=0.69047619047619  nrs=0.69047619047619 sa=0 sb=0 sd=0 mult=1 m=1
csn_op0_n100_rl_s0p1_r0_dp003p0_2 sn_op0_n100_rl_s0p1_r0_dp003p0_2 0 {C_SN}
XMWR_op0_n100_rl_s0p1_r0_dp003p0_3 sn_op0_n100_rl_s0p1_r0_dp003p0_3 wwl_des wbl_op0_n100_rl_s0p1_r0_dp003p0 0 sky130_fd_pr__nfet_01v8 L=0.15 W=0.42 nf=1 ad=0.1218 as=0.1218 pd=1.42 ps=1.42 nrd=0.69047619047619  nrs=0.69047619047619 sa=0 sb=0 sd=0 mult=1 m=1
XMRD_op0_n100_rl_s0p1_r0_dp003p0_3 rbl_op0_n100_rl_s0p1_r0_dp003p0 sn_op0_n100_rl_s0p1_r0_dp003p0_3 rwl_des 0 sky130_fd_pr__nfet_01v8 L=0.15 W=0.42 nf=1 ad=0.1218 as=0.1218 pd=1.42 ps=1.42 nrd=0.69047619047619  nrs=0.69047619047619 sa=0 sb=0 sd=0 mult=1 m=1
csn_op0_n100_rl_s0p1_r0_dp003p0_3 sn_op0_n100_rl_s0p1_r0_dp003p0_3 0 {C_SN}
XMN1_op0_n100_rl_s0p1_r0_dp003p0 rbl_op0_n100_rl_s0p1_r0_dp003p0 ref_op0_n100_rl_s0p1_r0_dp003p0 vn_op0_n100_rl_s0p1_r0_dp003p0 0 sky130_fd_pr__nfet_01v8 L=0.15 W=1 nf=1 ad=0.29 as=0.29 pd=2.58 ps=2.58 mult=1 m=1
XMN2_op0_n100_rl_s0p1_r0_dp003p0 ref_op0_n100_rl_s0p1_r0_dp003p0 rbl_op0_n100_rl_s0p1_r0_dp003p0 vn_op0_n100_rl_s0p1_r0_dp003p0 0 sky130_fd_pr__nfet_01v8 L=0.15 W=1 nf=1 ad=0.29 as=0.29 pd=2.58 ps=2.58 mult=1 m=1
XMP1_op0_n100_rl_s0p1_r0_dp003p0 rbl_op0_n100_rl_s0p1_r0_dp003p0 ref_op0_n100_rl_s0p1_r0_dp003p0 vp_op0_n100_rl_s0p1_r0_dp003p0 vdd sky130_fd_pr__pfet_01v8 L=0.15 W=2 nf=1 ad=0.58 as=0.58 pd=4.58 ps=4.58 mult=1 m=1
XMP2_op0_n100_rl_s0p1_r0_dp003p0 ref_op0_n100_rl_s0p1_r0_dp003p0 rbl_op0_n100_rl_s0p1_r0_dp003p0 vp_op0_n100_rl_s0p1_r0_dp003p0 vdd sky130_fd_pr__pfet_01v8 L=0.15 W=2 nf=1 ad=0.58 as=0.58 pd=4.58 ps=4.58 mult=1 m=1
XMNF_op0_n100_rl_s0p1_r0_dp003p0 vn_op0_n100_rl_s0p1_r0_dp003p0 en_op0_n100_rl_s0p1_r0_dp003p0 0 0 sky130_fd_pr__nfet_01v8 L=0.15 W=2 nf=1 ad=0.58 as=0.58 pd=4.58 ps=4.58 mult=1 m=1
XMPH_op0_n100_rl_s0p1_r0_dp003p0 vp_op0_n100_rl_s0p1_r0_dp003p0 enb_op0_n100_rl_s0p1_r0_dp003p0 vdd vdd sky130_fd_pr__pfet_01v8 L=0.15 W=4 nf=1 ad=1.16 as=1.16 pd=8.58 ps=8.58 mult=1 m=1
bd_op0_n100_rl_s0p1_r0_dp003p0 d_op0_n100_rl_s0p1_r0_dp003p0 0 v=v(rbl_op0_n100_rl_s0p1_r0_dp003p0)-v(ref_op0_n100_rl_s0p1_r0_dp003p0)

* ---- instance 252: op0_0000_rl_s0p1_r0_dp003p0 (variant rl_s0p1_r0_dp003p0; probe dec 11.9 ns, release 35 ns, meas 36 ns) ----
vctl_op0_0000_rl_s0p1_r0_dp003p0 ctl_op0_0000_rl_s0p1_r0_dp003p0 0 pwl(0.0000e+00 {VDD} 2.0000e-09 {VDD} 2.1000e-09 0)
* RWL driver model (EXPERIMENTAL): slew 0.1 ns, series R 0 ohm; cell pin = rwls_op0_0000_rl_s0p1_r0_dp003p0
vrs_op0_0000_rl_s0p1_r0_dp003p0 rwls_op0_0000_rl_s0p1_r0_dp003p0 0 pwl(0.0000e+00 {VDD} 2.0000e-09 {VDD} 2.1000e-09 0 3.5000e-08 0 3.5100e-08 {VDD})
ven_op0_0000_rl_s0p1_r0_dp003p0 en_op0_0000_rl_s0p1_r0_dp003p0 0 pwl(0.0000e+00 0 1.1000e-08 0 1.1100e-08 {VDD} 3.4000e-08 {VDD} 3.4100e-08 0)
venb_op0_0000_rl_s0p1_r0_dp003p0 enb_op0_0000_rl_s0p1_r0_dp003p0 0 pwl(0.0000e+00 {VDD} 1.1000e-08 {VDD} 1.1100e-08 0 3.4000e-08 0 3.4100e-08 {VDD})
vww_op0_0000_rl_s0p1_r0_dp003p0 wwl_op0_0000_rl_s0p1_r0_dp003p0 0 pwl(0.0000e+00 0 1.2000e-08 0 1.2100e-08 {VDD} 3.2000e-08 {VDD} 3.2100e-08 0)
vwc_op0_0000_rl_s0p1_r0_dp003p0 wbc_op0_0000_rl_s0p1_r0_dp003p0 0 pwl(0.0000e+00 0 1.2000e-08 0 1.2100e-08 {VDD} 3.4000e-08 {VDD} 3.4100e-08 0)
swb_op0_0000_rl_s0p1_r0_dp003p0 ref_op0_0000_rl_s0p1_r0_dp003p0 wbl_op0_0000_rl_s0p1_r0_dp003p0 wbc_op0_0000_rl_s0p1_r0_dp003p0 0 swwbl
cwbl_op0_0000_rl_s0p1_r0_dp003p0 wbl_op0_0000_rl_s0p1_r0_dp003p0 0 {C_WBL}
spa_op0_0000_rl_s0p1_r0_dp003p0 prea rbl_op0_0000_rl_s0p1_r0_dp003p0 ctl_op0_0000_rl_s0p1_r0_dp003p0 0 swpre
spr_op0_0000_rl_s0p1_r0_dp003p0 pref ref_op0_0000_rl_s0p1_r0_dp003p0 ctl_op0_0000_rl_s0p1_r0_dp003p0 0 swpre
crbl_op0_0000_rl_s0p1_r0_dp003p0 rbl_op0_0000_rl_s0p1_r0_dp003p0 0 {C_RBL}
cref_op0_0000_rl_s0p1_r0_dp003p0 ref_op0_0000_rl_s0p1_r0_dp003p0 0 {C_RBL}   $ ASSUMPTION: ideal matched dummy load
XMWR_op0_0000_rl_s0p1_r0_dp003p0_0 sn_op0_0000_rl_s0p1_r0_dp003p0_0 wwl_op0_0000_rl_s0p1_r0_dp003p0 wbl_op0_0000_rl_s0p1_r0_dp003p0 0 sky130_fd_pr__nfet_01v8 L=0.15 W=0.42 nf=1 ad=0.1218 as=0.1218 pd=1.42 ps=1.42 nrd=0.69047619047619  nrs=0.69047619047619 sa=0 sb=0 sd=0 mult=1 m=1
XMRD_op0_0000_rl_s0p1_r0_dp003p0_0 rbl_op0_0000_rl_s0p1_r0_dp003p0 sn_op0_0000_rl_s0p1_r0_dp003p0_0 rwls_op0_0000_rl_s0p1_r0_dp003p0 0 sky130_fd_pr__nfet_01v8 L=0.15 W=0.42 nf=1 ad=0.1218 as=0.1218 pd=1.42 ps=1.42 nrd=0.69047619047619  nrs=0.69047619047619 sa=0 sb=0 sd=0 mult=1 m=1
csn_op0_0000_rl_s0p1_r0_dp003p0_0 sn_op0_0000_rl_s0p1_r0_dp003p0_0 0 {C_SN}
XMWR_op0_0000_rl_s0p1_r0_dp003p0_1 sn_op0_0000_rl_s0p1_r0_dp003p0_1 wwl_des wbl_op0_0000_rl_s0p1_r0_dp003p0 0 sky130_fd_pr__nfet_01v8 L=0.15 W=0.42 nf=1 ad=0.1218 as=0.1218 pd=1.42 ps=1.42 nrd=0.69047619047619  nrs=0.69047619047619 sa=0 sb=0 sd=0 mult=1 m=1
XMRD_op0_0000_rl_s0p1_r0_dp003p0_1 rbl_op0_0000_rl_s0p1_r0_dp003p0 sn_op0_0000_rl_s0p1_r0_dp003p0_1 rwl_des 0 sky130_fd_pr__nfet_01v8 L=0.15 W=0.42 nf=1 ad=0.1218 as=0.1218 pd=1.42 ps=1.42 nrd=0.69047619047619  nrs=0.69047619047619 sa=0 sb=0 sd=0 mult=1 m=1
csn_op0_0000_rl_s0p1_r0_dp003p0_1 sn_op0_0000_rl_s0p1_r0_dp003p0_1 0 {C_SN}
XMWR_op0_0000_rl_s0p1_r0_dp003p0_2 sn_op0_0000_rl_s0p1_r0_dp003p0_2 wwl_des wbl_op0_0000_rl_s0p1_r0_dp003p0 0 sky130_fd_pr__nfet_01v8 L=0.15 W=0.42 nf=1 ad=0.1218 as=0.1218 pd=1.42 ps=1.42 nrd=0.69047619047619  nrs=0.69047619047619 sa=0 sb=0 sd=0 mult=1 m=1
XMRD_op0_0000_rl_s0p1_r0_dp003p0_2 rbl_op0_0000_rl_s0p1_r0_dp003p0 sn_op0_0000_rl_s0p1_r0_dp003p0_2 rwl_des 0 sky130_fd_pr__nfet_01v8 L=0.15 W=0.42 nf=1 ad=0.1218 as=0.1218 pd=1.42 ps=1.42 nrd=0.69047619047619  nrs=0.69047619047619 sa=0 sb=0 sd=0 mult=1 m=1
csn_op0_0000_rl_s0p1_r0_dp003p0_2 sn_op0_0000_rl_s0p1_r0_dp003p0_2 0 {C_SN}
XMWR_op0_0000_rl_s0p1_r0_dp003p0_3 sn_op0_0000_rl_s0p1_r0_dp003p0_3 wwl_des wbl_op0_0000_rl_s0p1_r0_dp003p0 0 sky130_fd_pr__nfet_01v8 L=0.15 W=0.42 nf=1 ad=0.1218 as=0.1218 pd=1.42 ps=1.42 nrd=0.69047619047619  nrs=0.69047619047619 sa=0 sb=0 sd=0 mult=1 m=1
XMRD_op0_0000_rl_s0p1_r0_dp003p0_3 rbl_op0_0000_rl_s0p1_r0_dp003p0 sn_op0_0000_rl_s0p1_r0_dp003p0_3 rwl_des 0 sky130_fd_pr__nfet_01v8 L=0.15 W=0.42 nf=1 ad=0.1218 as=0.1218 pd=1.42 ps=1.42 nrd=0.69047619047619  nrs=0.69047619047619 sa=0 sb=0 sd=0 mult=1 m=1
csn_op0_0000_rl_s0p1_r0_dp003p0_3 sn_op0_0000_rl_s0p1_r0_dp003p0_3 0 {C_SN}
XMN1_op0_0000_rl_s0p1_r0_dp003p0 rbl_op0_0000_rl_s0p1_r0_dp003p0 ref_op0_0000_rl_s0p1_r0_dp003p0 vn_op0_0000_rl_s0p1_r0_dp003p0 0 sky130_fd_pr__nfet_01v8 L=0.15 W=1 nf=1 ad=0.29 as=0.29 pd=2.58 ps=2.58 mult=1 m=1
XMN2_op0_0000_rl_s0p1_r0_dp003p0 ref_op0_0000_rl_s0p1_r0_dp003p0 rbl_op0_0000_rl_s0p1_r0_dp003p0 vn_op0_0000_rl_s0p1_r0_dp003p0 0 sky130_fd_pr__nfet_01v8 L=0.15 W=1 nf=1 ad=0.29 as=0.29 pd=2.58 ps=2.58 mult=1 m=1
XMP1_op0_0000_rl_s0p1_r0_dp003p0 rbl_op0_0000_rl_s0p1_r0_dp003p0 ref_op0_0000_rl_s0p1_r0_dp003p0 vp_op0_0000_rl_s0p1_r0_dp003p0 vdd sky130_fd_pr__pfet_01v8 L=0.15 W=2 nf=1 ad=0.58 as=0.58 pd=4.58 ps=4.58 mult=1 m=1
XMP2_op0_0000_rl_s0p1_r0_dp003p0 ref_op0_0000_rl_s0p1_r0_dp003p0 rbl_op0_0000_rl_s0p1_r0_dp003p0 vp_op0_0000_rl_s0p1_r0_dp003p0 vdd sky130_fd_pr__pfet_01v8 L=0.15 W=2 nf=1 ad=0.58 as=0.58 pd=4.58 ps=4.58 mult=1 m=1
XMNF_op0_0000_rl_s0p1_r0_dp003p0 vn_op0_0000_rl_s0p1_r0_dp003p0 en_op0_0000_rl_s0p1_r0_dp003p0 0 0 sky130_fd_pr__nfet_01v8 L=0.15 W=2 nf=1 ad=0.58 as=0.58 pd=4.58 ps=4.58 mult=1 m=1
XMPH_op0_0000_rl_s0p1_r0_dp003p0 vp_op0_0000_rl_s0p1_r0_dp003p0 enb_op0_0000_rl_s0p1_r0_dp003p0 vdd vdd sky130_fd_pr__pfet_01v8 L=0.15 W=4 nf=1 ad=1.16 as=1.16 pd=8.58 ps=8.58 mult=1 m=1
bd_op0_0000_rl_s0p1_r0_dp003p0 d_op0_0000_rl_s0p1_r0_dp003p0 0 v=v(rbl_op0_0000_rl_s0p1_r0_dp003p0)-v(ref_op0_0000_rl_s0p1_r0_dp003p0)

* ---- instance 253: op1_0900_rl_s1_r10k_dm016p0 (variant rl_s1_r10k_dm016p0; probe dec 11.9 ns, release 34 ns, meas 36 ns) ----
vctl_op1_0900_rl_s1_r10k_dm016p0 ctl_op1_0900_rl_s1_r10k_dm016p0 0 pwl(0.0000e+00 {VDD} 2.0000e-09 {VDD} 2.1000e-09 0)
* RWL driver model (EXPERIMENTAL): slew 1 ns, series R 10000 ohm; cell pin = rwls_op1_0900_rl_s1_r10k_dm016p0
vrs_op1_0900_rl_s1_r10k_dm016p0 rwlsrc_op1_0900_rl_s1_r10k_dm016p0 0 pwl(0.0000e+00 {VDD} 2.0000e-09 {VDD} 3.0000e-09 0 1.6000e-08 0 1.7000e-08 {VDD})
rdrv_op1_0900_rl_s1_r10k_dm016p0 rwlsrc_op1_0900_rl_s1_r10k_dm016p0 rwls_op1_0900_rl_s1_r10k_dm016p0 10000
ven_op1_0900_rl_s1_r10k_dm016p0 en_op1_0900_rl_s1_r10k_dm016p0 0 pwl(0.0000e+00 0 1.1000e-08 0 1.1100e-08 {VDD} 3.4000e-08 {VDD} 3.4100e-08 0)
venb_op1_0900_rl_s1_r10k_dm016p0 enb_op1_0900_rl_s1_r10k_dm016p0 0 pwl(0.0000e+00 {VDD} 1.1000e-08 {VDD} 1.1100e-08 0 3.4000e-08 0 3.4100e-08 {VDD})
vww_op1_0900_rl_s1_r10k_dm016p0 wwl_op1_0900_rl_s1_r10k_dm016p0 0 pwl(0.0000e+00 0 1.2000e-08 0 1.2100e-08 {VDD} 3.2000e-08 {VDD} 3.2100e-08 0)
vwc_op1_0900_rl_s1_r10k_dm016p0 wbc_op1_0900_rl_s1_r10k_dm016p0 0 pwl(0.0000e+00 0 1.2000e-08 0 1.2100e-08 {VDD} 3.4000e-08 {VDD} 3.4100e-08 0)
swb_op1_0900_rl_s1_r10k_dm016p0 ref_op1_0900_rl_s1_r10k_dm016p0 wbl_op1_0900_rl_s1_r10k_dm016p0 wbc_op1_0900_rl_s1_r10k_dm016p0 0 swwbl
cwbl_op1_0900_rl_s1_r10k_dm016p0 wbl_op1_0900_rl_s1_r10k_dm016p0 0 {C_WBL}
spa_op1_0900_rl_s1_r10k_dm016p0 prea rbl_op1_0900_rl_s1_r10k_dm016p0 ctl_op1_0900_rl_s1_r10k_dm016p0 0 swpre
spr_op1_0900_rl_s1_r10k_dm016p0 pref ref_op1_0900_rl_s1_r10k_dm016p0 ctl_op1_0900_rl_s1_r10k_dm016p0 0 swpre
crbl_op1_0900_rl_s1_r10k_dm016p0 rbl_op1_0900_rl_s1_r10k_dm016p0 0 {C_RBL}
cref_op1_0900_rl_s1_r10k_dm016p0 ref_op1_0900_rl_s1_r10k_dm016p0 0 {C_RBL}   $ ASSUMPTION: ideal matched dummy load
XMWR_op1_0900_rl_s1_r10k_dm016p0_0 sn_op1_0900_rl_s1_r10k_dm016p0_0 wwl_op1_0900_rl_s1_r10k_dm016p0 wbl_op1_0900_rl_s1_r10k_dm016p0 0 sky130_fd_pr__nfet_01v8 L=0.15 W=0.42 nf=1 ad=0.1218 as=0.1218 pd=1.42 ps=1.42 nrd=0.69047619047619  nrs=0.69047619047619 sa=0 sb=0 sd=0 mult=1 m=1
XMRD_op1_0900_rl_s1_r10k_dm016p0_0 rbl_op1_0900_rl_s1_r10k_dm016p0 sn_op1_0900_rl_s1_r10k_dm016p0_0 rwls_op1_0900_rl_s1_r10k_dm016p0 0 sky130_fd_pr__nfet_01v8 L=0.15 W=0.42 nf=1 ad=0.1218 as=0.1218 pd=1.42 ps=1.42 nrd=0.69047619047619  nrs=0.69047619047619 sa=0 sb=0 sd=0 mult=1 m=1
csn_op1_0900_rl_s1_r10k_dm016p0_0 sn_op1_0900_rl_s1_r10k_dm016p0_0 0 {C_SN}
XMWR_op1_0900_rl_s1_r10k_dm016p0_1 sn_op1_0900_rl_s1_r10k_dm016p0_1 wwl_des wbl_op1_0900_rl_s1_r10k_dm016p0 0 sky130_fd_pr__nfet_01v8 L=0.15 W=0.42 nf=1 ad=0.1218 as=0.1218 pd=1.42 ps=1.42 nrd=0.69047619047619  nrs=0.69047619047619 sa=0 sb=0 sd=0 mult=1 m=1
XMRD_op1_0900_rl_s1_r10k_dm016p0_1 rbl_op1_0900_rl_s1_r10k_dm016p0 sn_op1_0900_rl_s1_r10k_dm016p0_1 rwl_des 0 sky130_fd_pr__nfet_01v8 L=0.15 W=0.42 nf=1 ad=0.1218 as=0.1218 pd=1.42 ps=1.42 nrd=0.69047619047619  nrs=0.69047619047619 sa=0 sb=0 sd=0 mult=1 m=1
csn_op1_0900_rl_s1_r10k_dm016p0_1 sn_op1_0900_rl_s1_r10k_dm016p0_1 0 {C_SN}
XMWR_op1_0900_rl_s1_r10k_dm016p0_2 sn_op1_0900_rl_s1_r10k_dm016p0_2 wwl_des wbl_op1_0900_rl_s1_r10k_dm016p0 0 sky130_fd_pr__nfet_01v8 L=0.15 W=0.42 nf=1 ad=0.1218 as=0.1218 pd=1.42 ps=1.42 nrd=0.69047619047619  nrs=0.69047619047619 sa=0 sb=0 sd=0 mult=1 m=1
XMRD_op1_0900_rl_s1_r10k_dm016p0_2 rbl_op1_0900_rl_s1_r10k_dm016p0 sn_op1_0900_rl_s1_r10k_dm016p0_2 rwl_des 0 sky130_fd_pr__nfet_01v8 L=0.15 W=0.42 nf=1 ad=0.1218 as=0.1218 pd=1.42 ps=1.42 nrd=0.69047619047619  nrs=0.69047619047619 sa=0 sb=0 sd=0 mult=1 m=1
csn_op1_0900_rl_s1_r10k_dm016p0_2 sn_op1_0900_rl_s1_r10k_dm016p0_2 0 {C_SN}
XMWR_op1_0900_rl_s1_r10k_dm016p0_3 sn_op1_0900_rl_s1_r10k_dm016p0_3 wwl_des wbl_op1_0900_rl_s1_r10k_dm016p0 0 sky130_fd_pr__nfet_01v8 L=0.15 W=0.42 nf=1 ad=0.1218 as=0.1218 pd=1.42 ps=1.42 nrd=0.69047619047619  nrs=0.69047619047619 sa=0 sb=0 sd=0 mult=1 m=1
XMRD_op1_0900_rl_s1_r10k_dm016p0_3 rbl_op1_0900_rl_s1_r10k_dm016p0 sn_op1_0900_rl_s1_r10k_dm016p0_3 rwl_des 0 sky130_fd_pr__nfet_01v8 L=0.15 W=0.42 nf=1 ad=0.1218 as=0.1218 pd=1.42 ps=1.42 nrd=0.69047619047619  nrs=0.69047619047619 sa=0 sb=0 sd=0 mult=1 m=1
csn_op1_0900_rl_s1_r10k_dm016p0_3 sn_op1_0900_rl_s1_r10k_dm016p0_3 0 {C_SN}
XMN1_op1_0900_rl_s1_r10k_dm016p0 rbl_op1_0900_rl_s1_r10k_dm016p0 ref_op1_0900_rl_s1_r10k_dm016p0 vn_op1_0900_rl_s1_r10k_dm016p0 0 sky130_fd_pr__nfet_01v8 L=0.15 W=1 nf=1 ad=0.29 as=0.29 pd=2.58 ps=2.58 mult=1 m=1
XMN2_op1_0900_rl_s1_r10k_dm016p0 ref_op1_0900_rl_s1_r10k_dm016p0 rbl_op1_0900_rl_s1_r10k_dm016p0 vn_op1_0900_rl_s1_r10k_dm016p0 0 sky130_fd_pr__nfet_01v8 L=0.15 W=1 nf=1 ad=0.29 as=0.29 pd=2.58 ps=2.58 mult=1 m=1
XMP1_op1_0900_rl_s1_r10k_dm016p0 rbl_op1_0900_rl_s1_r10k_dm016p0 ref_op1_0900_rl_s1_r10k_dm016p0 vp_op1_0900_rl_s1_r10k_dm016p0 vdd sky130_fd_pr__pfet_01v8 L=0.15 W=2 nf=1 ad=0.58 as=0.58 pd=4.58 ps=4.58 mult=1 m=1
XMP2_op1_0900_rl_s1_r10k_dm016p0 ref_op1_0900_rl_s1_r10k_dm016p0 rbl_op1_0900_rl_s1_r10k_dm016p0 vp_op1_0900_rl_s1_r10k_dm016p0 vdd sky130_fd_pr__pfet_01v8 L=0.15 W=2 nf=1 ad=0.58 as=0.58 pd=4.58 ps=4.58 mult=1 m=1
XMNF_op1_0900_rl_s1_r10k_dm016p0 vn_op1_0900_rl_s1_r10k_dm016p0 en_op1_0900_rl_s1_r10k_dm016p0 0 0 sky130_fd_pr__nfet_01v8 L=0.15 W=2 nf=1 ad=0.58 as=0.58 pd=4.58 ps=4.58 mult=1 m=1
XMPH_op1_0900_rl_s1_r10k_dm016p0 vp_op1_0900_rl_s1_r10k_dm016p0 enb_op1_0900_rl_s1_r10k_dm016p0 vdd vdd sky130_fd_pr__pfet_01v8 L=0.15 W=4 nf=1 ad=1.16 as=1.16 pd=8.58 ps=8.58 mult=1 m=1
bd_op1_0900_rl_s1_r10k_dm016p0 d_op1_0900_rl_s1_r10k_dm016p0 0 v=v(rbl_op1_0900_rl_s1_r10k_dm016p0)-v(ref_op1_0900_rl_s1_r10k_dm016p0)

* ---- instance 254: op1_1000_rl_s1_r10k_dm016p0 (variant rl_s1_r10k_dm016p0; probe dec 11.9 ns, release 34 ns, meas 36 ns) ----
vctl_op1_1000_rl_s1_r10k_dm016p0 ctl_op1_1000_rl_s1_r10k_dm016p0 0 pwl(0.0000e+00 {VDD} 2.0000e-09 {VDD} 2.1000e-09 0)
* RWL driver model (EXPERIMENTAL): slew 1 ns, series R 10000 ohm; cell pin = rwls_op1_1000_rl_s1_r10k_dm016p0
vrs_op1_1000_rl_s1_r10k_dm016p0 rwlsrc_op1_1000_rl_s1_r10k_dm016p0 0 pwl(0.0000e+00 {VDD} 2.0000e-09 {VDD} 3.0000e-09 0 1.6000e-08 0 1.7000e-08 {VDD})
rdrv_op1_1000_rl_s1_r10k_dm016p0 rwlsrc_op1_1000_rl_s1_r10k_dm016p0 rwls_op1_1000_rl_s1_r10k_dm016p0 10000
ven_op1_1000_rl_s1_r10k_dm016p0 en_op1_1000_rl_s1_r10k_dm016p0 0 pwl(0.0000e+00 0 1.1000e-08 0 1.1100e-08 {VDD} 3.4000e-08 {VDD} 3.4100e-08 0)
venb_op1_1000_rl_s1_r10k_dm016p0 enb_op1_1000_rl_s1_r10k_dm016p0 0 pwl(0.0000e+00 {VDD} 1.1000e-08 {VDD} 1.1100e-08 0 3.4000e-08 0 3.4100e-08 {VDD})
vww_op1_1000_rl_s1_r10k_dm016p0 wwl_op1_1000_rl_s1_r10k_dm016p0 0 pwl(0.0000e+00 0 1.2000e-08 0 1.2100e-08 {VDD} 3.2000e-08 {VDD} 3.2100e-08 0)
vwc_op1_1000_rl_s1_r10k_dm016p0 wbc_op1_1000_rl_s1_r10k_dm016p0 0 pwl(0.0000e+00 0 1.2000e-08 0 1.2100e-08 {VDD} 3.4000e-08 {VDD} 3.4100e-08 0)
swb_op1_1000_rl_s1_r10k_dm016p0 ref_op1_1000_rl_s1_r10k_dm016p0 wbl_op1_1000_rl_s1_r10k_dm016p0 wbc_op1_1000_rl_s1_r10k_dm016p0 0 swwbl
cwbl_op1_1000_rl_s1_r10k_dm016p0 wbl_op1_1000_rl_s1_r10k_dm016p0 0 {C_WBL}
spa_op1_1000_rl_s1_r10k_dm016p0 prea rbl_op1_1000_rl_s1_r10k_dm016p0 ctl_op1_1000_rl_s1_r10k_dm016p0 0 swpre
spr_op1_1000_rl_s1_r10k_dm016p0 pref ref_op1_1000_rl_s1_r10k_dm016p0 ctl_op1_1000_rl_s1_r10k_dm016p0 0 swpre
crbl_op1_1000_rl_s1_r10k_dm016p0 rbl_op1_1000_rl_s1_r10k_dm016p0 0 {C_RBL}
cref_op1_1000_rl_s1_r10k_dm016p0 ref_op1_1000_rl_s1_r10k_dm016p0 0 {C_RBL}   $ ASSUMPTION: ideal matched dummy load
XMWR_op1_1000_rl_s1_r10k_dm016p0_0 sn_op1_1000_rl_s1_r10k_dm016p0_0 wwl_op1_1000_rl_s1_r10k_dm016p0 wbl_op1_1000_rl_s1_r10k_dm016p0 0 sky130_fd_pr__nfet_01v8 L=0.15 W=0.42 nf=1 ad=0.1218 as=0.1218 pd=1.42 ps=1.42 nrd=0.69047619047619  nrs=0.69047619047619 sa=0 sb=0 sd=0 mult=1 m=1
XMRD_op1_1000_rl_s1_r10k_dm016p0_0 rbl_op1_1000_rl_s1_r10k_dm016p0 sn_op1_1000_rl_s1_r10k_dm016p0_0 rwls_op1_1000_rl_s1_r10k_dm016p0 0 sky130_fd_pr__nfet_01v8 L=0.15 W=0.42 nf=1 ad=0.1218 as=0.1218 pd=1.42 ps=1.42 nrd=0.69047619047619  nrs=0.69047619047619 sa=0 sb=0 sd=0 mult=1 m=1
csn_op1_1000_rl_s1_r10k_dm016p0_0 sn_op1_1000_rl_s1_r10k_dm016p0_0 0 {C_SN}
XMWR_op1_1000_rl_s1_r10k_dm016p0_1 sn_op1_1000_rl_s1_r10k_dm016p0_1 wwl_des wbl_op1_1000_rl_s1_r10k_dm016p0 0 sky130_fd_pr__nfet_01v8 L=0.15 W=0.42 nf=1 ad=0.1218 as=0.1218 pd=1.42 ps=1.42 nrd=0.69047619047619  nrs=0.69047619047619 sa=0 sb=0 sd=0 mult=1 m=1
XMRD_op1_1000_rl_s1_r10k_dm016p0_1 rbl_op1_1000_rl_s1_r10k_dm016p0 sn_op1_1000_rl_s1_r10k_dm016p0_1 rwl_des 0 sky130_fd_pr__nfet_01v8 L=0.15 W=0.42 nf=1 ad=0.1218 as=0.1218 pd=1.42 ps=1.42 nrd=0.69047619047619  nrs=0.69047619047619 sa=0 sb=0 sd=0 mult=1 m=1
csn_op1_1000_rl_s1_r10k_dm016p0_1 sn_op1_1000_rl_s1_r10k_dm016p0_1 0 {C_SN}
XMWR_op1_1000_rl_s1_r10k_dm016p0_2 sn_op1_1000_rl_s1_r10k_dm016p0_2 wwl_des wbl_op1_1000_rl_s1_r10k_dm016p0 0 sky130_fd_pr__nfet_01v8 L=0.15 W=0.42 nf=1 ad=0.1218 as=0.1218 pd=1.42 ps=1.42 nrd=0.69047619047619  nrs=0.69047619047619 sa=0 sb=0 sd=0 mult=1 m=1
XMRD_op1_1000_rl_s1_r10k_dm016p0_2 rbl_op1_1000_rl_s1_r10k_dm016p0 sn_op1_1000_rl_s1_r10k_dm016p0_2 rwl_des 0 sky130_fd_pr__nfet_01v8 L=0.15 W=0.42 nf=1 ad=0.1218 as=0.1218 pd=1.42 ps=1.42 nrd=0.69047619047619  nrs=0.69047619047619 sa=0 sb=0 sd=0 mult=1 m=1
csn_op1_1000_rl_s1_r10k_dm016p0_2 sn_op1_1000_rl_s1_r10k_dm016p0_2 0 {C_SN}
XMWR_op1_1000_rl_s1_r10k_dm016p0_3 sn_op1_1000_rl_s1_r10k_dm016p0_3 wwl_des wbl_op1_1000_rl_s1_r10k_dm016p0 0 sky130_fd_pr__nfet_01v8 L=0.15 W=0.42 nf=1 ad=0.1218 as=0.1218 pd=1.42 ps=1.42 nrd=0.69047619047619  nrs=0.69047619047619 sa=0 sb=0 sd=0 mult=1 m=1
XMRD_op1_1000_rl_s1_r10k_dm016p0_3 rbl_op1_1000_rl_s1_r10k_dm016p0 sn_op1_1000_rl_s1_r10k_dm016p0_3 rwl_des 0 sky130_fd_pr__nfet_01v8 L=0.15 W=0.42 nf=1 ad=0.1218 as=0.1218 pd=1.42 ps=1.42 nrd=0.69047619047619  nrs=0.69047619047619 sa=0 sb=0 sd=0 mult=1 m=1
csn_op1_1000_rl_s1_r10k_dm016p0_3 sn_op1_1000_rl_s1_r10k_dm016p0_3 0 {C_SN}
XMN1_op1_1000_rl_s1_r10k_dm016p0 rbl_op1_1000_rl_s1_r10k_dm016p0 ref_op1_1000_rl_s1_r10k_dm016p0 vn_op1_1000_rl_s1_r10k_dm016p0 0 sky130_fd_pr__nfet_01v8 L=0.15 W=1 nf=1 ad=0.29 as=0.29 pd=2.58 ps=2.58 mult=1 m=1
XMN2_op1_1000_rl_s1_r10k_dm016p0 ref_op1_1000_rl_s1_r10k_dm016p0 rbl_op1_1000_rl_s1_r10k_dm016p0 vn_op1_1000_rl_s1_r10k_dm016p0 0 sky130_fd_pr__nfet_01v8 L=0.15 W=1 nf=1 ad=0.29 as=0.29 pd=2.58 ps=2.58 mult=1 m=1
XMP1_op1_1000_rl_s1_r10k_dm016p0 rbl_op1_1000_rl_s1_r10k_dm016p0 ref_op1_1000_rl_s1_r10k_dm016p0 vp_op1_1000_rl_s1_r10k_dm016p0 vdd sky130_fd_pr__pfet_01v8 L=0.15 W=2 nf=1 ad=0.58 as=0.58 pd=4.58 ps=4.58 mult=1 m=1
XMP2_op1_1000_rl_s1_r10k_dm016p0 ref_op1_1000_rl_s1_r10k_dm016p0 rbl_op1_1000_rl_s1_r10k_dm016p0 vp_op1_1000_rl_s1_r10k_dm016p0 vdd sky130_fd_pr__pfet_01v8 L=0.15 W=2 nf=1 ad=0.58 as=0.58 pd=4.58 ps=4.58 mult=1 m=1
XMNF_op1_1000_rl_s1_r10k_dm016p0 vn_op1_1000_rl_s1_r10k_dm016p0 en_op1_1000_rl_s1_r10k_dm016p0 0 0 sky130_fd_pr__nfet_01v8 L=0.15 W=2 nf=1 ad=0.58 as=0.58 pd=4.58 ps=4.58 mult=1 m=1
XMPH_op1_1000_rl_s1_r10k_dm016p0 vp_op1_1000_rl_s1_r10k_dm016p0 enb_op1_1000_rl_s1_r10k_dm016p0 vdd vdd sky130_fd_pr__pfet_01v8 L=0.15 W=4 nf=1 ad=1.16 as=1.16 pd=8.58 ps=8.58 mult=1 m=1
bd_op1_1000_rl_s1_r10k_dm016p0 d_op1_1000_rl_s1_r10k_dm016p0 0 v=v(rbl_op1_1000_rl_s1_r10k_dm016p0)-v(ref_op1_1000_rl_s1_r10k_dm016p0)

* ---- instance 255: op0_n100_rl_s1_r10k_dm016p0 (variant rl_s1_r10k_dm016p0; probe dec 11.9 ns, release 34 ns, meas 36 ns) ----
vctl_op0_n100_rl_s1_r10k_dm016p0 ctl_op0_n100_rl_s1_r10k_dm016p0 0 pwl(0.0000e+00 {VDD} 2.0000e-09 {VDD} 2.1000e-09 0)
* RWL driver model (EXPERIMENTAL): slew 1 ns, series R 10000 ohm; cell pin = rwls_op0_n100_rl_s1_r10k_dm016p0
vrs_op0_n100_rl_s1_r10k_dm016p0 rwlsrc_op0_n100_rl_s1_r10k_dm016p0 0 pwl(0.0000e+00 {VDD} 2.0000e-09 {VDD} 3.0000e-09 0 1.6000e-08 0 1.7000e-08 {VDD})
rdrv_op0_n100_rl_s1_r10k_dm016p0 rwlsrc_op0_n100_rl_s1_r10k_dm016p0 rwls_op0_n100_rl_s1_r10k_dm016p0 10000
ven_op0_n100_rl_s1_r10k_dm016p0 en_op0_n100_rl_s1_r10k_dm016p0 0 pwl(0.0000e+00 0 1.1000e-08 0 1.1100e-08 {VDD} 3.4000e-08 {VDD} 3.4100e-08 0)
venb_op0_n100_rl_s1_r10k_dm016p0 enb_op0_n100_rl_s1_r10k_dm016p0 0 pwl(0.0000e+00 {VDD} 1.1000e-08 {VDD} 1.1100e-08 0 3.4000e-08 0 3.4100e-08 {VDD})
vww_op0_n100_rl_s1_r10k_dm016p0 wwl_op0_n100_rl_s1_r10k_dm016p0 0 pwl(0.0000e+00 0 1.2000e-08 0 1.2100e-08 {VDD} 3.2000e-08 {VDD} 3.2100e-08 0)
vwc_op0_n100_rl_s1_r10k_dm016p0 wbc_op0_n100_rl_s1_r10k_dm016p0 0 pwl(0.0000e+00 0 1.2000e-08 0 1.2100e-08 {VDD} 3.4000e-08 {VDD} 3.4100e-08 0)
swb_op0_n100_rl_s1_r10k_dm016p0 ref_op0_n100_rl_s1_r10k_dm016p0 wbl_op0_n100_rl_s1_r10k_dm016p0 wbc_op0_n100_rl_s1_r10k_dm016p0 0 swwbl
cwbl_op0_n100_rl_s1_r10k_dm016p0 wbl_op0_n100_rl_s1_r10k_dm016p0 0 {C_WBL}
spa_op0_n100_rl_s1_r10k_dm016p0 prea rbl_op0_n100_rl_s1_r10k_dm016p0 ctl_op0_n100_rl_s1_r10k_dm016p0 0 swpre
spr_op0_n100_rl_s1_r10k_dm016p0 pref ref_op0_n100_rl_s1_r10k_dm016p0 ctl_op0_n100_rl_s1_r10k_dm016p0 0 swpre
crbl_op0_n100_rl_s1_r10k_dm016p0 rbl_op0_n100_rl_s1_r10k_dm016p0 0 {C_RBL}
cref_op0_n100_rl_s1_r10k_dm016p0 ref_op0_n100_rl_s1_r10k_dm016p0 0 {C_RBL}   $ ASSUMPTION: ideal matched dummy load
XMWR_op0_n100_rl_s1_r10k_dm016p0_0 sn_op0_n100_rl_s1_r10k_dm016p0_0 wwl_op0_n100_rl_s1_r10k_dm016p0 wbl_op0_n100_rl_s1_r10k_dm016p0 0 sky130_fd_pr__nfet_01v8 L=0.15 W=0.42 nf=1 ad=0.1218 as=0.1218 pd=1.42 ps=1.42 nrd=0.69047619047619  nrs=0.69047619047619 sa=0 sb=0 sd=0 mult=1 m=1
XMRD_op0_n100_rl_s1_r10k_dm016p0_0 rbl_op0_n100_rl_s1_r10k_dm016p0 sn_op0_n100_rl_s1_r10k_dm016p0_0 rwls_op0_n100_rl_s1_r10k_dm016p0 0 sky130_fd_pr__nfet_01v8 L=0.15 W=0.42 nf=1 ad=0.1218 as=0.1218 pd=1.42 ps=1.42 nrd=0.69047619047619  nrs=0.69047619047619 sa=0 sb=0 sd=0 mult=1 m=1
csn_op0_n100_rl_s1_r10k_dm016p0_0 sn_op0_n100_rl_s1_r10k_dm016p0_0 0 {C_SN}
XMWR_op0_n100_rl_s1_r10k_dm016p0_1 sn_op0_n100_rl_s1_r10k_dm016p0_1 wwl_des wbl_op0_n100_rl_s1_r10k_dm016p0 0 sky130_fd_pr__nfet_01v8 L=0.15 W=0.42 nf=1 ad=0.1218 as=0.1218 pd=1.42 ps=1.42 nrd=0.69047619047619  nrs=0.69047619047619 sa=0 sb=0 sd=0 mult=1 m=1
XMRD_op0_n100_rl_s1_r10k_dm016p0_1 rbl_op0_n100_rl_s1_r10k_dm016p0 sn_op0_n100_rl_s1_r10k_dm016p0_1 rwl_des 0 sky130_fd_pr__nfet_01v8 L=0.15 W=0.42 nf=1 ad=0.1218 as=0.1218 pd=1.42 ps=1.42 nrd=0.69047619047619  nrs=0.69047619047619 sa=0 sb=0 sd=0 mult=1 m=1
csn_op0_n100_rl_s1_r10k_dm016p0_1 sn_op0_n100_rl_s1_r10k_dm016p0_1 0 {C_SN}
XMWR_op0_n100_rl_s1_r10k_dm016p0_2 sn_op0_n100_rl_s1_r10k_dm016p0_2 wwl_des wbl_op0_n100_rl_s1_r10k_dm016p0 0 sky130_fd_pr__nfet_01v8 L=0.15 W=0.42 nf=1 ad=0.1218 as=0.1218 pd=1.42 ps=1.42 nrd=0.69047619047619  nrs=0.69047619047619 sa=0 sb=0 sd=0 mult=1 m=1
XMRD_op0_n100_rl_s1_r10k_dm016p0_2 rbl_op0_n100_rl_s1_r10k_dm016p0 sn_op0_n100_rl_s1_r10k_dm016p0_2 rwl_des 0 sky130_fd_pr__nfet_01v8 L=0.15 W=0.42 nf=1 ad=0.1218 as=0.1218 pd=1.42 ps=1.42 nrd=0.69047619047619  nrs=0.69047619047619 sa=0 sb=0 sd=0 mult=1 m=1
csn_op0_n100_rl_s1_r10k_dm016p0_2 sn_op0_n100_rl_s1_r10k_dm016p0_2 0 {C_SN}
XMWR_op0_n100_rl_s1_r10k_dm016p0_3 sn_op0_n100_rl_s1_r10k_dm016p0_3 wwl_des wbl_op0_n100_rl_s1_r10k_dm016p0 0 sky130_fd_pr__nfet_01v8 L=0.15 W=0.42 nf=1 ad=0.1218 as=0.1218 pd=1.42 ps=1.42 nrd=0.69047619047619  nrs=0.69047619047619 sa=0 sb=0 sd=0 mult=1 m=1
XMRD_op0_n100_rl_s1_r10k_dm016p0_3 rbl_op0_n100_rl_s1_r10k_dm016p0 sn_op0_n100_rl_s1_r10k_dm016p0_3 rwl_des 0 sky130_fd_pr__nfet_01v8 L=0.15 W=0.42 nf=1 ad=0.1218 as=0.1218 pd=1.42 ps=1.42 nrd=0.69047619047619  nrs=0.69047619047619 sa=0 sb=0 sd=0 mult=1 m=1
csn_op0_n100_rl_s1_r10k_dm016p0_3 sn_op0_n100_rl_s1_r10k_dm016p0_3 0 {C_SN}
XMN1_op0_n100_rl_s1_r10k_dm016p0 rbl_op0_n100_rl_s1_r10k_dm016p0 ref_op0_n100_rl_s1_r10k_dm016p0 vn_op0_n100_rl_s1_r10k_dm016p0 0 sky130_fd_pr__nfet_01v8 L=0.15 W=1 nf=1 ad=0.29 as=0.29 pd=2.58 ps=2.58 mult=1 m=1
XMN2_op0_n100_rl_s1_r10k_dm016p0 ref_op0_n100_rl_s1_r10k_dm016p0 rbl_op0_n100_rl_s1_r10k_dm016p0 vn_op0_n100_rl_s1_r10k_dm016p0 0 sky130_fd_pr__nfet_01v8 L=0.15 W=1 nf=1 ad=0.29 as=0.29 pd=2.58 ps=2.58 mult=1 m=1
XMP1_op0_n100_rl_s1_r10k_dm016p0 rbl_op0_n100_rl_s1_r10k_dm016p0 ref_op0_n100_rl_s1_r10k_dm016p0 vp_op0_n100_rl_s1_r10k_dm016p0 vdd sky130_fd_pr__pfet_01v8 L=0.15 W=2 nf=1 ad=0.58 as=0.58 pd=4.58 ps=4.58 mult=1 m=1
XMP2_op0_n100_rl_s1_r10k_dm016p0 ref_op0_n100_rl_s1_r10k_dm016p0 rbl_op0_n100_rl_s1_r10k_dm016p0 vp_op0_n100_rl_s1_r10k_dm016p0 vdd sky130_fd_pr__pfet_01v8 L=0.15 W=2 nf=1 ad=0.58 as=0.58 pd=4.58 ps=4.58 mult=1 m=1
XMNF_op0_n100_rl_s1_r10k_dm016p0 vn_op0_n100_rl_s1_r10k_dm016p0 en_op0_n100_rl_s1_r10k_dm016p0 0 0 sky130_fd_pr__nfet_01v8 L=0.15 W=2 nf=1 ad=0.58 as=0.58 pd=4.58 ps=4.58 mult=1 m=1
XMPH_op0_n100_rl_s1_r10k_dm016p0 vp_op0_n100_rl_s1_r10k_dm016p0 enb_op0_n100_rl_s1_r10k_dm016p0 vdd vdd sky130_fd_pr__pfet_01v8 L=0.15 W=4 nf=1 ad=1.16 as=1.16 pd=8.58 ps=8.58 mult=1 m=1
bd_op0_n100_rl_s1_r10k_dm016p0 d_op0_n100_rl_s1_r10k_dm016p0 0 v=v(rbl_op0_n100_rl_s1_r10k_dm016p0)-v(ref_op0_n100_rl_s1_r10k_dm016p0)

* ---- instance 256: op0_0000_rl_s1_r10k_dm016p0 (variant rl_s1_r10k_dm016p0; probe dec 11.9 ns, release 34 ns, meas 36 ns) ----
vctl_op0_0000_rl_s1_r10k_dm016p0 ctl_op0_0000_rl_s1_r10k_dm016p0 0 pwl(0.0000e+00 {VDD} 2.0000e-09 {VDD} 2.1000e-09 0)
* RWL driver model (EXPERIMENTAL): slew 1 ns, series R 10000 ohm; cell pin = rwls_op0_0000_rl_s1_r10k_dm016p0
vrs_op0_0000_rl_s1_r10k_dm016p0 rwlsrc_op0_0000_rl_s1_r10k_dm016p0 0 pwl(0.0000e+00 {VDD} 2.0000e-09 {VDD} 3.0000e-09 0 1.6000e-08 0 1.7000e-08 {VDD})
rdrv_op0_0000_rl_s1_r10k_dm016p0 rwlsrc_op0_0000_rl_s1_r10k_dm016p0 rwls_op0_0000_rl_s1_r10k_dm016p0 10000
ven_op0_0000_rl_s1_r10k_dm016p0 en_op0_0000_rl_s1_r10k_dm016p0 0 pwl(0.0000e+00 0 1.1000e-08 0 1.1100e-08 {VDD} 3.4000e-08 {VDD} 3.4100e-08 0)
venb_op0_0000_rl_s1_r10k_dm016p0 enb_op0_0000_rl_s1_r10k_dm016p0 0 pwl(0.0000e+00 {VDD} 1.1000e-08 {VDD} 1.1100e-08 0 3.4000e-08 0 3.4100e-08 {VDD})
vww_op0_0000_rl_s1_r10k_dm016p0 wwl_op0_0000_rl_s1_r10k_dm016p0 0 pwl(0.0000e+00 0 1.2000e-08 0 1.2100e-08 {VDD} 3.2000e-08 {VDD} 3.2100e-08 0)
vwc_op0_0000_rl_s1_r10k_dm016p0 wbc_op0_0000_rl_s1_r10k_dm016p0 0 pwl(0.0000e+00 0 1.2000e-08 0 1.2100e-08 {VDD} 3.4000e-08 {VDD} 3.4100e-08 0)
swb_op0_0000_rl_s1_r10k_dm016p0 ref_op0_0000_rl_s1_r10k_dm016p0 wbl_op0_0000_rl_s1_r10k_dm016p0 wbc_op0_0000_rl_s1_r10k_dm016p0 0 swwbl
cwbl_op0_0000_rl_s1_r10k_dm016p0 wbl_op0_0000_rl_s1_r10k_dm016p0 0 {C_WBL}
spa_op0_0000_rl_s1_r10k_dm016p0 prea rbl_op0_0000_rl_s1_r10k_dm016p0 ctl_op0_0000_rl_s1_r10k_dm016p0 0 swpre
spr_op0_0000_rl_s1_r10k_dm016p0 pref ref_op0_0000_rl_s1_r10k_dm016p0 ctl_op0_0000_rl_s1_r10k_dm016p0 0 swpre
crbl_op0_0000_rl_s1_r10k_dm016p0 rbl_op0_0000_rl_s1_r10k_dm016p0 0 {C_RBL}
cref_op0_0000_rl_s1_r10k_dm016p0 ref_op0_0000_rl_s1_r10k_dm016p0 0 {C_RBL}   $ ASSUMPTION: ideal matched dummy load
XMWR_op0_0000_rl_s1_r10k_dm016p0_0 sn_op0_0000_rl_s1_r10k_dm016p0_0 wwl_op0_0000_rl_s1_r10k_dm016p0 wbl_op0_0000_rl_s1_r10k_dm016p0 0 sky130_fd_pr__nfet_01v8 L=0.15 W=0.42 nf=1 ad=0.1218 as=0.1218 pd=1.42 ps=1.42 nrd=0.69047619047619  nrs=0.69047619047619 sa=0 sb=0 sd=0 mult=1 m=1
XMRD_op0_0000_rl_s1_r10k_dm016p0_0 rbl_op0_0000_rl_s1_r10k_dm016p0 sn_op0_0000_rl_s1_r10k_dm016p0_0 rwls_op0_0000_rl_s1_r10k_dm016p0 0 sky130_fd_pr__nfet_01v8 L=0.15 W=0.42 nf=1 ad=0.1218 as=0.1218 pd=1.42 ps=1.42 nrd=0.69047619047619  nrs=0.69047619047619 sa=0 sb=0 sd=0 mult=1 m=1
csn_op0_0000_rl_s1_r10k_dm016p0_0 sn_op0_0000_rl_s1_r10k_dm016p0_0 0 {C_SN}
XMWR_op0_0000_rl_s1_r10k_dm016p0_1 sn_op0_0000_rl_s1_r10k_dm016p0_1 wwl_des wbl_op0_0000_rl_s1_r10k_dm016p0 0 sky130_fd_pr__nfet_01v8 L=0.15 W=0.42 nf=1 ad=0.1218 as=0.1218 pd=1.42 ps=1.42 nrd=0.69047619047619  nrs=0.69047619047619 sa=0 sb=0 sd=0 mult=1 m=1
XMRD_op0_0000_rl_s1_r10k_dm016p0_1 rbl_op0_0000_rl_s1_r10k_dm016p0 sn_op0_0000_rl_s1_r10k_dm016p0_1 rwl_des 0 sky130_fd_pr__nfet_01v8 L=0.15 W=0.42 nf=1 ad=0.1218 as=0.1218 pd=1.42 ps=1.42 nrd=0.69047619047619  nrs=0.69047619047619 sa=0 sb=0 sd=0 mult=1 m=1
csn_op0_0000_rl_s1_r10k_dm016p0_1 sn_op0_0000_rl_s1_r10k_dm016p0_1 0 {C_SN}
XMWR_op0_0000_rl_s1_r10k_dm016p0_2 sn_op0_0000_rl_s1_r10k_dm016p0_2 wwl_des wbl_op0_0000_rl_s1_r10k_dm016p0 0 sky130_fd_pr__nfet_01v8 L=0.15 W=0.42 nf=1 ad=0.1218 as=0.1218 pd=1.42 ps=1.42 nrd=0.69047619047619  nrs=0.69047619047619 sa=0 sb=0 sd=0 mult=1 m=1
XMRD_op0_0000_rl_s1_r10k_dm016p0_2 rbl_op0_0000_rl_s1_r10k_dm016p0 sn_op0_0000_rl_s1_r10k_dm016p0_2 rwl_des 0 sky130_fd_pr__nfet_01v8 L=0.15 W=0.42 nf=1 ad=0.1218 as=0.1218 pd=1.42 ps=1.42 nrd=0.69047619047619  nrs=0.69047619047619 sa=0 sb=0 sd=0 mult=1 m=1
csn_op0_0000_rl_s1_r10k_dm016p0_2 sn_op0_0000_rl_s1_r10k_dm016p0_2 0 {C_SN}
XMWR_op0_0000_rl_s1_r10k_dm016p0_3 sn_op0_0000_rl_s1_r10k_dm016p0_3 wwl_des wbl_op0_0000_rl_s1_r10k_dm016p0 0 sky130_fd_pr__nfet_01v8 L=0.15 W=0.42 nf=1 ad=0.1218 as=0.1218 pd=1.42 ps=1.42 nrd=0.69047619047619  nrs=0.69047619047619 sa=0 sb=0 sd=0 mult=1 m=1
XMRD_op0_0000_rl_s1_r10k_dm016p0_3 rbl_op0_0000_rl_s1_r10k_dm016p0 sn_op0_0000_rl_s1_r10k_dm016p0_3 rwl_des 0 sky130_fd_pr__nfet_01v8 L=0.15 W=0.42 nf=1 ad=0.1218 as=0.1218 pd=1.42 ps=1.42 nrd=0.69047619047619  nrs=0.69047619047619 sa=0 sb=0 sd=0 mult=1 m=1
csn_op0_0000_rl_s1_r10k_dm016p0_3 sn_op0_0000_rl_s1_r10k_dm016p0_3 0 {C_SN}
XMN1_op0_0000_rl_s1_r10k_dm016p0 rbl_op0_0000_rl_s1_r10k_dm016p0 ref_op0_0000_rl_s1_r10k_dm016p0 vn_op0_0000_rl_s1_r10k_dm016p0 0 sky130_fd_pr__nfet_01v8 L=0.15 W=1 nf=1 ad=0.29 as=0.29 pd=2.58 ps=2.58 mult=1 m=1
XMN2_op0_0000_rl_s1_r10k_dm016p0 ref_op0_0000_rl_s1_r10k_dm016p0 rbl_op0_0000_rl_s1_r10k_dm016p0 vn_op0_0000_rl_s1_r10k_dm016p0 0 sky130_fd_pr__nfet_01v8 L=0.15 W=1 nf=1 ad=0.29 as=0.29 pd=2.58 ps=2.58 mult=1 m=1
XMP1_op0_0000_rl_s1_r10k_dm016p0 rbl_op0_0000_rl_s1_r10k_dm016p0 ref_op0_0000_rl_s1_r10k_dm016p0 vp_op0_0000_rl_s1_r10k_dm016p0 vdd sky130_fd_pr__pfet_01v8 L=0.15 W=2 nf=1 ad=0.58 as=0.58 pd=4.58 ps=4.58 mult=1 m=1
XMP2_op0_0000_rl_s1_r10k_dm016p0 ref_op0_0000_rl_s1_r10k_dm016p0 rbl_op0_0000_rl_s1_r10k_dm016p0 vp_op0_0000_rl_s1_r10k_dm016p0 vdd sky130_fd_pr__pfet_01v8 L=0.15 W=2 nf=1 ad=0.58 as=0.58 pd=4.58 ps=4.58 mult=1 m=1
XMNF_op0_0000_rl_s1_r10k_dm016p0 vn_op0_0000_rl_s1_r10k_dm016p0 en_op0_0000_rl_s1_r10k_dm016p0 0 0 sky130_fd_pr__nfet_01v8 L=0.15 W=2 nf=1 ad=0.58 as=0.58 pd=4.58 ps=4.58 mult=1 m=1
XMPH_op0_0000_rl_s1_r10k_dm016p0 vp_op0_0000_rl_s1_r10k_dm016p0 enb_op0_0000_rl_s1_r10k_dm016p0 vdd vdd sky130_fd_pr__pfet_01v8 L=0.15 W=4 nf=1 ad=1.16 as=1.16 pd=8.58 ps=8.58 mult=1 m=1
bd_op0_0000_rl_s1_r10k_dm016p0 d_op0_0000_rl_s1_r10k_dm016p0 0 v=v(rbl_op0_0000_rl_s1_r10k_dm016p0)-v(ref_op0_0000_rl_s1_r10k_dm016p0)

* ---- instance 257: op1_0900_rl_s1_r10k_dm008p0 (variant rl_s1_r10k_dm008p0; probe dec 11.9 ns, release 34 ns, meas 36 ns) ----
vctl_op1_0900_rl_s1_r10k_dm008p0 ctl_op1_0900_rl_s1_r10k_dm008p0 0 pwl(0.0000e+00 {VDD} 2.0000e-09 {VDD} 2.1000e-09 0)
* RWL driver model (EXPERIMENTAL): slew 1 ns, series R 10000 ohm; cell pin = rwls_op1_0900_rl_s1_r10k_dm008p0
vrs_op1_0900_rl_s1_r10k_dm008p0 rwlsrc_op1_0900_rl_s1_r10k_dm008p0 0 pwl(0.0000e+00 {VDD} 2.0000e-09 {VDD} 3.0000e-09 0 2.4000e-08 0 2.5000e-08 {VDD})
rdrv_op1_0900_rl_s1_r10k_dm008p0 rwlsrc_op1_0900_rl_s1_r10k_dm008p0 rwls_op1_0900_rl_s1_r10k_dm008p0 10000
ven_op1_0900_rl_s1_r10k_dm008p0 en_op1_0900_rl_s1_r10k_dm008p0 0 pwl(0.0000e+00 0 1.1000e-08 0 1.1100e-08 {VDD} 3.4000e-08 {VDD} 3.4100e-08 0)
venb_op1_0900_rl_s1_r10k_dm008p0 enb_op1_0900_rl_s1_r10k_dm008p0 0 pwl(0.0000e+00 {VDD} 1.1000e-08 {VDD} 1.1100e-08 0 3.4000e-08 0 3.4100e-08 {VDD})
vww_op1_0900_rl_s1_r10k_dm008p0 wwl_op1_0900_rl_s1_r10k_dm008p0 0 pwl(0.0000e+00 0 1.2000e-08 0 1.2100e-08 {VDD} 3.2000e-08 {VDD} 3.2100e-08 0)
vwc_op1_0900_rl_s1_r10k_dm008p0 wbc_op1_0900_rl_s1_r10k_dm008p0 0 pwl(0.0000e+00 0 1.2000e-08 0 1.2100e-08 {VDD} 3.4000e-08 {VDD} 3.4100e-08 0)
swb_op1_0900_rl_s1_r10k_dm008p0 ref_op1_0900_rl_s1_r10k_dm008p0 wbl_op1_0900_rl_s1_r10k_dm008p0 wbc_op1_0900_rl_s1_r10k_dm008p0 0 swwbl
cwbl_op1_0900_rl_s1_r10k_dm008p0 wbl_op1_0900_rl_s1_r10k_dm008p0 0 {C_WBL}
spa_op1_0900_rl_s1_r10k_dm008p0 prea rbl_op1_0900_rl_s1_r10k_dm008p0 ctl_op1_0900_rl_s1_r10k_dm008p0 0 swpre
spr_op1_0900_rl_s1_r10k_dm008p0 pref ref_op1_0900_rl_s1_r10k_dm008p0 ctl_op1_0900_rl_s1_r10k_dm008p0 0 swpre
crbl_op1_0900_rl_s1_r10k_dm008p0 rbl_op1_0900_rl_s1_r10k_dm008p0 0 {C_RBL}
cref_op1_0900_rl_s1_r10k_dm008p0 ref_op1_0900_rl_s1_r10k_dm008p0 0 {C_RBL}   $ ASSUMPTION: ideal matched dummy load
XMWR_op1_0900_rl_s1_r10k_dm008p0_0 sn_op1_0900_rl_s1_r10k_dm008p0_0 wwl_op1_0900_rl_s1_r10k_dm008p0 wbl_op1_0900_rl_s1_r10k_dm008p0 0 sky130_fd_pr__nfet_01v8 L=0.15 W=0.42 nf=1 ad=0.1218 as=0.1218 pd=1.42 ps=1.42 nrd=0.69047619047619  nrs=0.69047619047619 sa=0 sb=0 sd=0 mult=1 m=1
XMRD_op1_0900_rl_s1_r10k_dm008p0_0 rbl_op1_0900_rl_s1_r10k_dm008p0 sn_op1_0900_rl_s1_r10k_dm008p0_0 rwls_op1_0900_rl_s1_r10k_dm008p0 0 sky130_fd_pr__nfet_01v8 L=0.15 W=0.42 nf=1 ad=0.1218 as=0.1218 pd=1.42 ps=1.42 nrd=0.69047619047619  nrs=0.69047619047619 sa=0 sb=0 sd=0 mult=1 m=1
csn_op1_0900_rl_s1_r10k_dm008p0_0 sn_op1_0900_rl_s1_r10k_dm008p0_0 0 {C_SN}
XMWR_op1_0900_rl_s1_r10k_dm008p0_1 sn_op1_0900_rl_s1_r10k_dm008p0_1 wwl_des wbl_op1_0900_rl_s1_r10k_dm008p0 0 sky130_fd_pr__nfet_01v8 L=0.15 W=0.42 nf=1 ad=0.1218 as=0.1218 pd=1.42 ps=1.42 nrd=0.69047619047619  nrs=0.69047619047619 sa=0 sb=0 sd=0 mult=1 m=1
XMRD_op1_0900_rl_s1_r10k_dm008p0_1 rbl_op1_0900_rl_s1_r10k_dm008p0 sn_op1_0900_rl_s1_r10k_dm008p0_1 rwl_des 0 sky130_fd_pr__nfet_01v8 L=0.15 W=0.42 nf=1 ad=0.1218 as=0.1218 pd=1.42 ps=1.42 nrd=0.69047619047619  nrs=0.69047619047619 sa=0 sb=0 sd=0 mult=1 m=1
csn_op1_0900_rl_s1_r10k_dm008p0_1 sn_op1_0900_rl_s1_r10k_dm008p0_1 0 {C_SN}
XMWR_op1_0900_rl_s1_r10k_dm008p0_2 sn_op1_0900_rl_s1_r10k_dm008p0_2 wwl_des wbl_op1_0900_rl_s1_r10k_dm008p0 0 sky130_fd_pr__nfet_01v8 L=0.15 W=0.42 nf=1 ad=0.1218 as=0.1218 pd=1.42 ps=1.42 nrd=0.69047619047619  nrs=0.69047619047619 sa=0 sb=0 sd=0 mult=1 m=1
XMRD_op1_0900_rl_s1_r10k_dm008p0_2 rbl_op1_0900_rl_s1_r10k_dm008p0 sn_op1_0900_rl_s1_r10k_dm008p0_2 rwl_des 0 sky130_fd_pr__nfet_01v8 L=0.15 W=0.42 nf=1 ad=0.1218 as=0.1218 pd=1.42 ps=1.42 nrd=0.69047619047619  nrs=0.69047619047619 sa=0 sb=0 sd=0 mult=1 m=1
csn_op1_0900_rl_s1_r10k_dm008p0_2 sn_op1_0900_rl_s1_r10k_dm008p0_2 0 {C_SN}
XMWR_op1_0900_rl_s1_r10k_dm008p0_3 sn_op1_0900_rl_s1_r10k_dm008p0_3 wwl_des wbl_op1_0900_rl_s1_r10k_dm008p0 0 sky130_fd_pr__nfet_01v8 L=0.15 W=0.42 nf=1 ad=0.1218 as=0.1218 pd=1.42 ps=1.42 nrd=0.69047619047619  nrs=0.69047619047619 sa=0 sb=0 sd=0 mult=1 m=1
XMRD_op1_0900_rl_s1_r10k_dm008p0_3 rbl_op1_0900_rl_s1_r10k_dm008p0 sn_op1_0900_rl_s1_r10k_dm008p0_3 rwl_des 0 sky130_fd_pr__nfet_01v8 L=0.15 W=0.42 nf=1 ad=0.1218 as=0.1218 pd=1.42 ps=1.42 nrd=0.69047619047619  nrs=0.69047619047619 sa=0 sb=0 sd=0 mult=1 m=1
csn_op1_0900_rl_s1_r10k_dm008p0_3 sn_op1_0900_rl_s1_r10k_dm008p0_3 0 {C_SN}
XMN1_op1_0900_rl_s1_r10k_dm008p0 rbl_op1_0900_rl_s1_r10k_dm008p0 ref_op1_0900_rl_s1_r10k_dm008p0 vn_op1_0900_rl_s1_r10k_dm008p0 0 sky130_fd_pr__nfet_01v8 L=0.15 W=1 nf=1 ad=0.29 as=0.29 pd=2.58 ps=2.58 mult=1 m=1
XMN2_op1_0900_rl_s1_r10k_dm008p0 ref_op1_0900_rl_s1_r10k_dm008p0 rbl_op1_0900_rl_s1_r10k_dm008p0 vn_op1_0900_rl_s1_r10k_dm008p0 0 sky130_fd_pr__nfet_01v8 L=0.15 W=1 nf=1 ad=0.29 as=0.29 pd=2.58 ps=2.58 mult=1 m=1
XMP1_op1_0900_rl_s1_r10k_dm008p0 rbl_op1_0900_rl_s1_r10k_dm008p0 ref_op1_0900_rl_s1_r10k_dm008p0 vp_op1_0900_rl_s1_r10k_dm008p0 vdd sky130_fd_pr__pfet_01v8 L=0.15 W=2 nf=1 ad=0.58 as=0.58 pd=4.58 ps=4.58 mult=1 m=1
XMP2_op1_0900_rl_s1_r10k_dm008p0 ref_op1_0900_rl_s1_r10k_dm008p0 rbl_op1_0900_rl_s1_r10k_dm008p0 vp_op1_0900_rl_s1_r10k_dm008p0 vdd sky130_fd_pr__pfet_01v8 L=0.15 W=2 nf=1 ad=0.58 as=0.58 pd=4.58 ps=4.58 mult=1 m=1
XMNF_op1_0900_rl_s1_r10k_dm008p0 vn_op1_0900_rl_s1_r10k_dm008p0 en_op1_0900_rl_s1_r10k_dm008p0 0 0 sky130_fd_pr__nfet_01v8 L=0.15 W=2 nf=1 ad=0.58 as=0.58 pd=4.58 ps=4.58 mult=1 m=1
XMPH_op1_0900_rl_s1_r10k_dm008p0 vp_op1_0900_rl_s1_r10k_dm008p0 enb_op1_0900_rl_s1_r10k_dm008p0 vdd vdd sky130_fd_pr__pfet_01v8 L=0.15 W=4 nf=1 ad=1.16 as=1.16 pd=8.58 ps=8.58 mult=1 m=1
bd_op1_0900_rl_s1_r10k_dm008p0 d_op1_0900_rl_s1_r10k_dm008p0 0 v=v(rbl_op1_0900_rl_s1_r10k_dm008p0)-v(ref_op1_0900_rl_s1_r10k_dm008p0)

* ---- instance 258: op1_1000_rl_s1_r10k_dm008p0 (variant rl_s1_r10k_dm008p0; probe dec 11.9 ns, release 34 ns, meas 36 ns) ----
vctl_op1_1000_rl_s1_r10k_dm008p0 ctl_op1_1000_rl_s1_r10k_dm008p0 0 pwl(0.0000e+00 {VDD} 2.0000e-09 {VDD} 2.1000e-09 0)
* RWL driver model (EXPERIMENTAL): slew 1 ns, series R 10000 ohm; cell pin = rwls_op1_1000_rl_s1_r10k_dm008p0
vrs_op1_1000_rl_s1_r10k_dm008p0 rwlsrc_op1_1000_rl_s1_r10k_dm008p0 0 pwl(0.0000e+00 {VDD} 2.0000e-09 {VDD} 3.0000e-09 0 2.4000e-08 0 2.5000e-08 {VDD})
rdrv_op1_1000_rl_s1_r10k_dm008p0 rwlsrc_op1_1000_rl_s1_r10k_dm008p0 rwls_op1_1000_rl_s1_r10k_dm008p0 10000
ven_op1_1000_rl_s1_r10k_dm008p0 en_op1_1000_rl_s1_r10k_dm008p0 0 pwl(0.0000e+00 0 1.1000e-08 0 1.1100e-08 {VDD} 3.4000e-08 {VDD} 3.4100e-08 0)
venb_op1_1000_rl_s1_r10k_dm008p0 enb_op1_1000_rl_s1_r10k_dm008p0 0 pwl(0.0000e+00 {VDD} 1.1000e-08 {VDD} 1.1100e-08 0 3.4000e-08 0 3.4100e-08 {VDD})
vww_op1_1000_rl_s1_r10k_dm008p0 wwl_op1_1000_rl_s1_r10k_dm008p0 0 pwl(0.0000e+00 0 1.2000e-08 0 1.2100e-08 {VDD} 3.2000e-08 {VDD} 3.2100e-08 0)
vwc_op1_1000_rl_s1_r10k_dm008p0 wbc_op1_1000_rl_s1_r10k_dm008p0 0 pwl(0.0000e+00 0 1.2000e-08 0 1.2100e-08 {VDD} 3.4000e-08 {VDD} 3.4100e-08 0)
swb_op1_1000_rl_s1_r10k_dm008p0 ref_op1_1000_rl_s1_r10k_dm008p0 wbl_op1_1000_rl_s1_r10k_dm008p0 wbc_op1_1000_rl_s1_r10k_dm008p0 0 swwbl
cwbl_op1_1000_rl_s1_r10k_dm008p0 wbl_op1_1000_rl_s1_r10k_dm008p0 0 {C_WBL}
spa_op1_1000_rl_s1_r10k_dm008p0 prea rbl_op1_1000_rl_s1_r10k_dm008p0 ctl_op1_1000_rl_s1_r10k_dm008p0 0 swpre
spr_op1_1000_rl_s1_r10k_dm008p0 pref ref_op1_1000_rl_s1_r10k_dm008p0 ctl_op1_1000_rl_s1_r10k_dm008p0 0 swpre
crbl_op1_1000_rl_s1_r10k_dm008p0 rbl_op1_1000_rl_s1_r10k_dm008p0 0 {C_RBL}
cref_op1_1000_rl_s1_r10k_dm008p0 ref_op1_1000_rl_s1_r10k_dm008p0 0 {C_RBL}   $ ASSUMPTION: ideal matched dummy load
XMWR_op1_1000_rl_s1_r10k_dm008p0_0 sn_op1_1000_rl_s1_r10k_dm008p0_0 wwl_op1_1000_rl_s1_r10k_dm008p0 wbl_op1_1000_rl_s1_r10k_dm008p0 0 sky130_fd_pr__nfet_01v8 L=0.15 W=0.42 nf=1 ad=0.1218 as=0.1218 pd=1.42 ps=1.42 nrd=0.69047619047619  nrs=0.69047619047619 sa=0 sb=0 sd=0 mult=1 m=1
XMRD_op1_1000_rl_s1_r10k_dm008p0_0 rbl_op1_1000_rl_s1_r10k_dm008p0 sn_op1_1000_rl_s1_r10k_dm008p0_0 rwls_op1_1000_rl_s1_r10k_dm008p0 0 sky130_fd_pr__nfet_01v8 L=0.15 W=0.42 nf=1 ad=0.1218 as=0.1218 pd=1.42 ps=1.42 nrd=0.69047619047619  nrs=0.69047619047619 sa=0 sb=0 sd=0 mult=1 m=1
csn_op1_1000_rl_s1_r10k_dm008p0_0 sn_op1_1000_rl_s1_r10k_dm008p0_0 0 {C_SN}
XMWR_op1_1000_rl_s1_r10k_dm008p0_1 sn_op1_1000_rl_s1_r10k_dm008p0_1 wwl_des wbl_op1_1000_rl_s1_r10k_dm008p0 0 sky130_fd_pr__nfet_01v8 L=0.15 W=0.42 nf=1 ad=0.1218 as=0.1218 pd=1.42 ps=1.42 nrd=0.69047619047619  nrs=0.69047619047619 sa=0 sb=0 sd=0 mult=1 m=1
XMRD_op1_1000_rl_s1_r10k_dm008p0_1 rbl_op1_1000_rl_s1_r10k_dm008p0 sn_op1_1000_rl_s1_r10k_dm008p0_1 rwl_des 0 sky130_fd_pr__nfet_01v8 L=0.15 W=0.42 nf=1 ad=0.1218 as=0.1218 pd=1.42 ps=1.42 nrd=0.69047619047619  nrs=0.69047619047619 sa=0 sb=0 sd=0 mult=1 m=1
csn_op1_1000_rl_s1_r10k_dm008p0_1 sn_op1_1000_rl_s1_r10k_dm008p0_1 0 {C_SN}
XMWR_op1_1000_rl_s1_r10k_dm008p0_2 sn_op1_1000_rl_s1_r10k_dm008p0_2 wwl_des wbl_op1_1000_rl_s1_r10k_dm008p0 0 sky130_fd_pr__nfet_01v8 L=0.15 W=0.42 nf=1 ad=0.1218 as=0.1218 pd=1.42 ps=1.42 nrd=0.69047619047619  nrs=0.69047619047619 sa=0 sb=0 sd=0 mult=1 m=1
XMRD_op1_1000_rl_s1_r10k_dm008p0_2 rbl_op1_1000_rl_s1_r10k_dm008p0 sn_op1_1000_rl_s1_r10k_dm008p0_2 rwl_des 0 sky130_fd_pr__nfet_01v8 L=0.15 W=0.42 nf=1 ad=0.1218 as=0.1218 pd=1.42 ps=1.42 nrd=0.69047619047619  nrs=0.69047619047619 sa=0 sb=0 sd=0 mult=1 m=1
csn_op1_1000_rl_s1_r10k_dm008p0_2 sn_op1_1000_rl_s1_r10k_dm008p0_2 0 {C_SN}
XMWR_op1_1000_rl_s1_r10k_dm008p0_3 sn_op1_1000_rl_s1_r10k_dm008p0_3 wwl_des wbl_op1_1000_rl_s1_r10k_dm008p0 0 sky130_fd_pr__nfet_01v8 L=0.15 W=0.42 nf=1 ad=0.1218 as=0.1218 pd=1.42 ps=1.42 nrd=0.69047619047619  nrs=0.69047619047619 sa=0 sb=0 sd=0 mult=1 m=1
XMRD_op1_1000_rl_s1_r10k_dm008p0_3 rbl_op1_1000_rl_s1_r10k_dm008p0 sn_op1_1000_rl_s1_r10k_dm008p0_3 rwl_des 0 sky130_fd_pr__nfet_01v8 L=0.15 W=0.42 nf=1 ad=0.1218 as=0.1218 pd=1.42 ps=1.42 nrd=0.69047619047619  nrs=0.69047619047619 sa=0 sb=0 sd=0 mult=1 m=1
csn_op1_1000_rl_s1_r10k_dm008p0_3 sn_op1_1000_rl_s1_r10k_dm008p0_3 0 {C_SN}
XMN1_op1_1000_rl_s1_r10k_dm008p0 rbl_op1_1000_rl_s1_r10k_dm008p0 ref_op1_1000_rl_s1_r10k_dm008p0 vn_op1_1000_rl_s1_r10k_dm008p0 0 sky130_fd_pr__nfet_01v8 L=0.15 W=1 nf=1 ad=0.29 as=0.29 pd=2.58 ps=2.58 mult=1 m=1
XMN2_op1_1000_rl_s1_r10k_dm008p0 ref_op1_1000_rl_s1_r10k_dm008p0 rbl_op1_1000_rl_s1_r10k_dm008p0 vn_op1_1000_rl_s1_r10k_dm008p0 0 sky130_fd_pr__nfet_01v8 L=0.15 W=1 nf=1 ad=0.29 as=0.29 pd=2.58 ps=2.58 mult=1 m=1
XMP1_op1_1000_rl_s1_r10k_dm008p0 rbl_op1_1000_rl_s1_r10k_dm008p0 ref_op1_1000_rl_s1_r10k_dm008p0 vp_op1_1000_rl_s1_r10k_dm008p0 vdd sky130_fd_pr__pfet_01v8 L=0.15 W=2 nf=1 ad=0.58 as=0.58 pd=4.58 ps=4.58 mult=1 m=1
XMP2_op1_1000_rl_s1_r10k_dm008p0 ref_op1_1000_rl_s1_r10k_dm008p0 rbl_op1_1000_rl_s1_r10k_dm008p0 vp_op1_1000_rl_s1_r10k_dm008p0 vdd sky130_fd_pr__pfet_01v8 L=0.15 W=2 nf=1 ad=0.58 as=0.58 pd=4.58 ps=4.58 mult=1 m=1
XMNF_op1_1000_rl_s1_r10k_dm008p0 vn_op1_1000_rl_s1_r10k_dm008p0 en_op1_1000_rl_s1_r10k_dm008p0 0 0 sky130_fd_pr__nfet_01v8 L=0.15 W=2 nf=1 ad=0.58 as=0.58 pd=4.58 ps=4.58 mult=1 m=1
XMPH_op1_1000_rl_s1_r10k_dm008p0 vp_op1_1000_rl_s1_r10k_dm008p0 enb_op1_1000_rl_s1_r10k_dm008p0 vdd vdd sky130_fd_pr__pfet_01v8 L=0.15 W=4 nf=1 ad=1.16 as=1.16 pd=8.58 ps=8.58 mult=1 m=1
bd_op1_1000_rl_s1_r10k_dm008p0 d_op1_1000_rl_s1_r10k_dm008p0 0 v=v(rbl_op1_1000_rl_s1_r10k_dm008p0)-v(ref_op1_1000_rl_s1_r10k_dm008p0)

* ---- instance 259: op0_n100_rl_s1_r10k_dm008p0 (variant rl_s1_r10k_dm008p0; probe dec 11.9 ns, release 34 ns, meas 36 ns) ----
vctl_op0_n100_rl_s1_r10k_dm008p0 ctl_op0_n100_rl_s1_r10k_dm008p0 0 pwl(0.0000e+00 {VDD} 2.0000e-09 {VDD} 2.1000e-09 0)
* RWL driver model (EXPERIMENTAL): slew 1 ns, series R 10000 ohm; cell pin = rwls_op0_n100_rl_s1_r10k_dm008p0
vrs_op0_n100_rl_s1_r10k_dm008p0 rwlsrc_op0_n100_rl_s1_r10k_dm008p0 0 pwl(0.0000e+00 {VDD} 2.0000e-09 {VDD} 3.0000e-09 0 2.4000e-08 0 2.5000e-08 {VDD})
rdrv_op0_n100_rl_s1_r10k_dm008p0 rwlsrc_op0_n100_rl_s1_r10k_dm008p0 rwls_op0_n100_rl_s1_r10k_dm008p0 10000
ven_op0_n100_rl_s1_r10k_dm008p0 en_op0_n100_rl_s1_r10k_dm008p0 0 pwl(0.0000e+00 0 1.1000e-08 0 1.1100e-08 {VDD} 3.4000e-08 {VDD} 3.4100e-08 0)
venb_op0_n100_rl_s1_r10k_dm008p0 enb_op0_n100_rl_s1_r10k_dm008p0 0 pwl(0.0000e+00 {VDD} 1.1000e-08 {VDD} 1.1100e-08 0 3.4000e-08 0 3.4100e-08 {VDD})
vww_op0_n100_rl_s1_r10k_dm008p0 wwl_op0_n100_rl_s1_r10k_dm008p0 0 pwl(0.0000e+00 0 1.2000e-08 0 1.2100e-08 {VDD} 3.2000e-08 {VDD} 3.2100e-08 0)
vwc_op0_n100_rl_s1_r10k_dm008p0 wbc_op0_n100_rl_s1_r10k_dm008p0 0 pwl(0.0000e+00 0 1.2000e-08 0 1.2100e-08 {VDD} 3.4000e-08 {VDD} 3.4100e-08 0)
swb_op0_n100_rl_s1_r10k_dm008p0 ref_op0_n100_rl_s1_r10k_dm008p0 wbl_op0_n100_rl_s1_r10k_dm008p0 wbc_op0_n100_rl_s1_r10k_dm008p0 0 swwbl
cwbl_op0_n100_rl_s1_r10k_dm008p0 wbl_op0_n100_rl_s1_r10k_dm008p0 0 {C_WBL}
spa_op0_n100_rl_s1_r10k_dm008p0 prea rbl_op0_n100_rl_s1_r10k_dm008p0 ctl_op0_n100_rl_s1_r10k_dm008p0 0 swpre
spr_op0_n100_rl_s1_r10k_dm008p0 pref ref_op0_n100_rl_s1_r10k_dm008p0 ctl_op0_n100_rl_s1_r10k_dm008p0 0 swpre
crbl_op0_n100_rl_s1_r10k_dm008p0 rbl_op0_n100_rl_s1_r10k_dm008p0 0 {C_RBL}
cref_op0_n100_rl_s1_r10k_dm008p0 ref_op0_n100_rl_s1_r10k_dm008p0 0 {C_RBL}   $ ASSUMPTION: ideal matched dummy load
XMWR_op0_n100_rl_s1_r10k_dm008p0_0 sn_op0_n100_rl_s1_r10k_dm008p0_0 wwl_op0_n100_rl_s1_r10k_dm008p0 wbl_op0_n100_rl_s1_r10k_dm008p0 0 sky130_fd_pr__nfet_01v8 L=0.15 W=0.42 nf=1 ad=0.1218 as=0.1218 pd=1.42 ps=1.42 nrd=0.69047619047619  nrs=0.69047619047619 sa=0 sb=0 sd=0 mult=1 m=1
XMRD_op0_n100_rl_s1_r10k_dm008p0_0 rbl_op0_n100_rl_s1_r10k_dm008p0 sn_op0_n100_rl_s1_r10k_dm008p0_0 rwls_op0_n100_rl_s1_r10k_dm008p0 0 sky130_fd_pr__nfet_01v8 L=0.15 W=0.42 nf=1 ad=0.1218 as=0.1218 pd=1.42 ps=1.42 nrd=0.69047619047619  nrs=0.69047619047619 sa=0 sb=0 sd=0 mult=1 m=1
csn_op0_n100_rl_s1_r10k_dm008p0_0 sn_op0_n100_rl_s1_r10k_dm008p0_0 0 {C_SN}
XMWR_op0_n100_rl_s1_r10k_dm008p0_1 sn_op0_n100_rl_s1_r10k_dm008p0_1 wwl_des wbl_op0_n100_rl_s1_r10k_dm008p0 0 sky130_fd_pr__nfet_01v8 L=0.15 W=0.42 nf=1 ad=0.1218 as=0.1218 pd=1.42 ps=1.42 nrd=0.69047619047619  nrs=0.69047619047619 sa=0 sb=0 sd=0 mult=1 m=1
XMRD_op0_n100_rl_s1_r10k_dm008p0_1 rbl_op0_n100_rl_s1_r10k_dm008p0 sn_op0_n100_rl_s1_r10k_dm008p0_1 rwl_des 0 sky130_fd_pr__nfet_01v8 L=0.15 W=0.42 nf=1 ad=0.1218 as=0.1218 pd=1.42 ps=1.42 nrd=0.69047619047619  nrs=0.69047619047619 sa=0 sb=0 sd=0 mult=1 m=1
csn_op0_n100_rl_s1_r10k_dm008p0_1 sn_op0_n100_rl_s1_r10k_dm008p0_1 0 {C_SN}
XMWR_op0_n100_rl_s1_r10k_dm008p0_2 sn_op0_n100_rl_s1_r10k_dm008p0_2 wwl_des wbl_op0_n100_rl_s1_r10k_dm008p0 0 sky130_fd_pr__nfet_01v8 L=0.15 W=0.42 nf=1 ad=0.1218 as=0.1218 pd=1.42 ps=1.42 nrd=0.69047619047619  nrs=0.69047619047619 sa=0 sb=0 sd=0 mult=1 m=1
XMRD_op0_n100_rl_s1_r10k_dm008p0_2 rbl_op0_n100_rl_s1_r10k_dm008p0 sn_op0_n100_rl_s1_r10k_dm008p0_2 rwl_des 0 sky130_fd_pr__nfet_01v8 L=0.15 W=0.42 nf=1 ad=0.1218 as=0.1218 pd=1.42 ps=1.42 nrd=0.69047619047619  nrs=0.69047619047619 sa=0 sb=0 sd=0 mult=1 m=1
csn_op0_n100_rl_s1_r10k_dm008p0_2 sn_op0_n100_rl_s1_r10k_dm008p0_2 0 {C_SN}
XMWR_op0_n100_rl_s1_r10k_dm008p0_3 sn_op0_n100_rl_s1_r10k_dm008p0_3 wwl_des wbl_op0_n100_rl_s1_r10k_dm008p0 0 sky130_fd_pr__nfet_01v8 L=0.15 W=0.42 nf=1 ad=0.1218 as=0.1218 pd=1.42 ps=1.42 nrd=0.69047619047619  nrs=0.69047619047619 sa=0 sb=0 sd=0 mult=1 m=1
XMRD_op0_n100_rl_s1_r10k_dm008p0_3 rbl_op0_n100_rl_s1_r10k_dm008p0 sn_op0_n100_rl_s1_r10k_dm008p0_3 rwl_des 0 sky130_fd_pr__nfet_01v8 L=0.15 W=0.42 nf=1 ad=0.1218 as=0.1218 pd=1.42 ps=1.42 nrd=0.69047619047619  nrs=0.69047619047619 sa=0 sb=0 sd=0 mult=1 m=1
csn_op0_n100_rl_s1_r10k_dm008p0_3 sn_op0_n100_rl_s1_r10k_dm008p0_3 0 {C_SN}
XMN1_op0_n100_rl_s1_r10k_dm008p0 rbl_op0_n100_rl_s1_r10k_dm008p0 ref_op0_n100_rl_s1_r10k_dm008p0 vn_op0_n100_rl_s1_r10k_dm008p0 0 sky130_fd_pr__nfet_01v8 L=0.15 W=1 nf=1 ad=0.29 as=0.29 pd=2.58 ps=2.58 mult=1 m=1
XMN2_op0_n100_rl_s1_r10k_dm008p0 ref_op0_n100_rl_s1_r10k_dm008p0 rbl_op0_n100_rl_s1_r10k_dm008p0 vn_op0_n100_rl_s1_r10k_dm008p0 0 sky130_fd_pr__nfet_01v8 L=0.15 W=1 nf=1 ad=0.29 as=0.29 pd=2.58 ps=2.58 mult=1 m=1
XMP1_op0_n100_rl_s1_r10k_dm008p0 rbl_op0_n100_rl_s1_r10k_dm008p0 ref_op0_n100_rl_s1_r10k_dm008p0 vp_op0_n100_rl_s1_r10k_dm008p0 vdd sky130_fd_pr__pfet_01v8 L=0.15 W=2 nf=1 ad=0.58 as=0.58 pd=4.58 ps=4.58 mult=1 m=1
XMP2_op0_n100_rl_s1_r10k_dm008p0 ref_op0_n100_rl_s1_r10k_dm008p0 rbl_op0_n100_rl_s1_r10k_dm008p0 vp_op0_n100_rl_s1_r10k_dm008p0 vdd sky130_fd_pr__pfet_01v8 L=0.15 W=2 nf=1 ad=0.58 as=0.58 pd=4.58 ps=4.58 mult=1 m=1
XMNF_op0_n100_rl_s1_r10k_dm008p0 vn_op0_n100_rl_s1_r10k_dm008p0 en_op0_n100_rl_s1_r10k_dm008p0 0 0 sky130_fd_pr__nfet_01v8 L=0.15 W=2 nf=1 ad=0.58 as=0.58 pd=4.58 ps=4.58 mult=1 m=1
XMPH_op0_n100_rl_s1_r10k_dm008p0 vp_op0_n100_rl_s1_r10k_dm008p0 enb_op0_n100_rl_s1_r10k_dm008p0 vdd vdd sky130_fd_pr__pfet_01v8 L=0.15 W=4 nf=1 ad=1.16 as=1.16 pd=8.58 ps=8.58 mult=1 m=1
bd_op0_n100_rl_s1_r10k_dm008p0 d_op0_n100_rl_s1_r10k_dm008p0 0 v=v(rbl_op0_n100_rl_s1_r10k_dm008p0)-v(ref_op0_n100_rl_s1_r10k_dm008p0)

* ---- instance 260: op0_0000_rl_s1_r10k_dm008p0 (variant rl_s1_r10k_dm008p0; probe dec 11.9 ns, release 34 ns, meas 36 ns) ----
vctl_op0_0000_rl_s1_r10k_dm008p0 ctl_op0_0000_rl_s1_r10k_dm008p0 0 pwl(0.0000e+00 {VDD} 2.0000e-09 {VDD} 2.1000e-09 0)
* RWL driver model (EXPERIMENTAL): slew 1 ns, series R 10000 ohm; cell pin = rwls_op0_0000_rl_s1_r10k_dm008p0
vrs_op0_0000_rl_s1_r10k_dm008p0 rwlsrc_op0_0000_rl_s1_r10k_dm008p0 0 pwl(0.0000e+00 {VDD} 2.0000e-09 {VDD} 3.0000e-09 0 2.4000e-08 0 2.5000e-08 {VDD})
rdrv_op0_0000_rl_s1_r10k_dm008p0 rwlsrc_op0_0000_rl_s1_r10k_dm008p0 rwls_op0_0000_rl_s1_r10k_dm008p0 10000
ven_op0_0000_rl_s1_r10k_dm008p0 en_op0_0000_rl_s1_r10k_dm008p0 0 pwl(0.0000e+00 0 1.1000e-08 0 1.1100e-08 {VDD} 3.4000e-08 {VDD} 3.4100e-08 0)
venb_op0_0000_rl_s1_r10k_dm008p0 enb_op0_0000_rl_s1_r10k_dm008p0 0 pwl(0.0000e+00 {VDD} 1.1000e-08 {VDD} 1.1100e-08 0 3.4000e-08 0 3.4100e-08 {VDD})
vww_op0_0000_rl_s1_r10k_dm008p0 wwl_op0_0000_rl_s1_r10k_dm008p0 0 pwl(0.0000e+00 0 1.2000e-08 0 1.2100e-08 {VDD} 3.2000e-08 {VDD} 3.2100e-08 0)
vwc_op0_0000_rl_s1_r10k_dm008p0 wbc_op0_0000_rl_s1_r10k_dm008p0 0 pwl(0.0000e+00 0 1.2000e-08 0 1.2100e-08 {VDD} 3.4000e-08 {VDD} 3.4100e-08 0)
swb_op0_0000_rl_s1_r10k_dm008p0 ref_op0_0000_rl_s1_r10k_dm008p0 wbl_op0_0000_rl_s1_r10k_dm008p0 wbc_op0_0000_rl_s1_r10k_dm008p0 0 swwbl
cwbl_op0_0000_rl_s1_r10k_dm008p0 wbl_op0_0000_rl_s1_r10k_dm008p0 0 {C_WBL}
spa_op0_0000_rl_s1_r10k_dm008p0 prea rbl_op0_0000_rl_s1_r10k_dm008p0 ctl_op0_0000_rl_s1_r10k_dm008p0 0 swpre
spr_op0_0000_rl_s1_r10k_dm008p0 pref ref_op0_0000_rl_s1_r10k_dm008p0 ctl_op0_0000_rl_s1_r10k_dm008p0 0 swpre
crbl_op0_0000_rl_s1_r10k_dm008p0 rbl_op0_0000_rl_s1_r10k_dm008p0 0 {C_RBL}
cref_op0_0000_rl_s1_r10k_dm008p0 ref_op0_0000_rl_s1_r10k_dm008p0 0 {C_RBL}   $ ASSUMPTION: ideal matched dummy load
XMWR_op0_0000_rl_s1_r10k_dm008p0_0 sn_op0_0000_rl_s1_r10k_dm008p0_0 wwl_op0_0000_rl_s1_r10k_dm008p0 wbl_op0_0000_rl_s1_r10k_dm008p0 0 sky130_fd_pr__nfet_01v8 L=0.15 W=0.42 nf=1 ad=0.1218 as=0.1218 pd=1.42 ps=1.42 nrd=0.69047619047619  nrs=0.69047619047619 sa=0 sb=0 sd=0 mult=1 m=1
XMRD_op0_0000_rl_s1_r10k_dm008p0_0 rbl_op0_0000_rl_s1_r10k_dm008p0 sn_op0_0000_rl_s1_r10k_dm008p0_0 rwls_op0_0000_rl_s1_r10k_dm008p0 0 sky130_fd_pr__nfet_01v8 L=0.15 W=0.42 nf=1 ad=0.1218 as=0.1218 pd=1.42 ps=1.42 nrd=0.69047619047619  nrs=0.69047619047619 sa=0 sb=0 sd=0 mult=1 m=1
csn_op0_0000_rl_s1_r10k_dm008p0_0 sn_op0_0000_rl_s1_r10k_dm008p0_0 0 {C_SN}
XMWR_op0_0000_rl_s1_r10k_dm008p0_1 sn_op0_0000_rl_s1_r10k_dm008p0_1 wwl_des wbl_op0_0000_rl_s1_r10k_dm008p0 0 sky130_fd_pr__nfet_01v8 L=0.15 W=0.42 nf=1 ad=0.1218 as=0.1218 pd=1.42 ps=1.42 nrd=0.69047619047619  nrs=0.69047619047619 sa=0 sb=0 sd=0 mult=1 m=1
XMRD_op0_0000_rl_s1_r10k_dm008p0_1 rbl_op0_0000_rl_s1_r10k_dm008p0 sn_op0_0000_rl_s1_r10k_dm008p0_1 rwl_des 0 sky130_fd_pr__nfet_01v8 L=0.15 W=0.42 nf=1 ad=0.1218 as=0.1218 pd=1.42 ps=1.42 nrd=0.69047619047619  nrs=0.69047619047619 sa=0 sb=0 sd=0 mult=1 m=1
csn_op0_0000_rl_s1_r10k_dm008p0_1 sn_op0_0000_rl_s1_r10k_dm008p0_1 0 {C_SN}
XMWR_op0_0000_rl_s1_r10k_dm008p0_2 sn_op0_0000_rl_s1_r10k_dm008p0_2 wwl_des wbl_op0_0000_rl_s1_r10k_dm008p0 0 sky130_fd_pr__nfet_01v8 L=0.15 W=0.42 nf=1 ad=0.1218 as=0.1218 pd=1.42 ps=1.42 nrd=0.69047619047619  nrs=0.69047619047619 sa=0 sb=0 sd=0 mult=1 m=1
XMRD_op0_0000_rl_s1_r10k_dm008p0_2 rbl_op0_0000_rl_s1_r10k_dm008p0 sn_op0_0000_rl_s1_r10k_dm008p0_2 rwl_des 0 sky130_fd_pr__nfet_01v8 L=0.15 W=0.42 nf=1 ad=0.1218 as=0.1218 pd=1.42 ps=1.42 nrd=0.69047619047619  nrs=0.69047619047619 sa=0 sb=0 sd=0 mult=1 m=1
csn_op0_0000_rl_s1_r10k_dm008p0_2 sn_op0_0000_rl_s1_r10k_dm008p0_2 0 {C_SN}
XMWR_op0_0000_rl_s1_r10k_dm008p0_3 sn_op0_0000_rl_s1_r10k_dm008p0_3 wwl_des wbl_op0_0000_rl_s1_r10k_dm008p0 0 sky130_fd_pr__nfet_01v8 L=0.15 W=0.42 nf=1 ad=0.1218 as=0.1218 pd=1.42 ps=1.42 nrd=0.69047619047619  nrs=0.69047619047619 sa=0 sb=0 sd=0 mult=1 m=1
XMRD_op0_0000_rl_s1_r10k_dm008p0_3 rbl_op0_0000_rl_s1_r10k_dm008p0 sn_op0_0000_rl_s1_r10k_dm008p0_3 rwl_des 0 sky130_fd_pr__nfet_01v8 L=0.15 W=0.42 nf=1 ad=0.1218 as=0.1218 pd=1.42 ps=1.42 nrd=0.69047619047619  nrs=0.69047619047619 sa=0 sb=0 sd=0 mult=1 m=1
csn_op0_0000_rl_s1_r10k_dm008p0_3 sn_op0_0000_rl_s1_r10k_dm008p0_3 0 {C_SN}
XMN1_op0_0000_rl_s1_r10k_dm008p0 rbl_op0_0000_rl_s1_r10k_dm008p0 ref_op0_0000_rl_s1_r10k_dm008p0 vn_op0_0000_rl_s1_r10k_dm008p0 0 sky130_fd_pr__nfet_01v8 L=0.15 W=1 nf=1 ad=0.29 as=0.29 pd=2.58 ps=2.58 mult=1 m=1
XMN2_op0_0000_rl_s1_r10k_dm008p0 ref_op0_0000_rl_s1_r10k_dm008p0 rbl_op0_0000_rl_s1_r10k_dm008p0 vn_op0_0000_rl_s1_r10k_dm008p0 0 sky130_fd_pr__nfet_01v8 L=0.15 W=1 nf=1 ad=0.29 as=0.29 pd=2.58 ps=2.58 mult=1 m=1
XMP1_op0_0000_rl_s1_r10k_dm008p0 rbl_op0_0000_rl_s1_r10k_dm008p0 ref_op0_0000_rl_s1_r10k_dm008p0 vp_op0_0000_rl_s1_r10k_dm008p0 vdd sky130_fd_pr__pfet_01v8 L=0.15 W=2 nf=1 ad=0.58 as=0.58 pd=4.58 ps=4.58 mult=1 m=1
XMP2_op0_0000_rl_s1_r10k_dm008p0 ref_op0_0000_rl_s1_r10k_dm008p0 rbl_op0_0000_rl_s1_r10k_dm008p0 vp_op0_0000_rl_s1_r10k_dm008p0 vdd sky130_fd_pr__pfet_01v8 L=0.15 W=2 nf=1 ad=0.58 as=0.58 pd=4.58 ps=4.58 mult=1 m=1
XMNF_op0_0000_rl_s1_r10k_dm008p0 vn_op0_0000_rl_s1_r10k_dm008p0 en_op0_0000_rl_s1_r10k_dm008p0 0 0 sky130_fd_pr__nfet_01v8 L=0.15 W=2 nf=1 ad=0.58 as=0.58 pd=4.58 ps=4.58 mult=1 m=1
XMPH_op0_0000_rl_s1_r10k_dm008p0 vp_op0_0000_rl_s1_r10k_dm008p0 enb_op0_0000_rl_s1_r10k_dm008p0 vdd vdd sky130_fd_pr__pfet_01v8 L=0.15 W=4 nf=1 ad=1.16 as=1.16 pd=8.58 ps=8.58 mult=1 m=1
bd_op0_0000_rl_s1_r10k_dm008p0 d_op0_0000_rl_s1_r10k_dm008p0 0 v=v(rbl_op0_0000_rl_s1_r10k_dm008p0)-v(ref_op0_0000_rl_s1_r10k_dm008p0)

* ---- instance 261: op1_0900_rl_s1_r10k_dm004p0 (variant rl_s1_r10k_dm004p0; probe dec 11.9 ns, release 34 ns, meas 36 ns) ----
vctl_op1_0900_rl_s1_r10k_dm004p0 ctl_op1_0900_rl_s1_r10k_dm004p0 0 pwl(0.0000e+00 {VDD} 2.0000e-09 {VDD} 2.1000e-09 0)
* RWL driver model (EXPERIMENTAL): slew 1 ns, series R 10000 ohm; cell pin = rwls_op1_0900_rl_s1_r10k_dm004p0
vrs_op1_0900_rl_s1_r10k_dm004p0 rwlsrc_op1_0900_rl_s1_r10k_dm004p0 0 pwl(0.0000e+00 {VDD} 2.0000e-09 {VDD} 3.0000e-09 0 2.8000e-08 0 2.9000e-08 {VDD})
rdrv_op1_0900_rl_s1_r10k_dm004p0 rwlsrc_op1_0900_rl_s1_r10k_dm004p0 rwls_op1_0900_rl_s1_r10k_dm004p0 10000
ven_op1_0900_rl_s1_r10k_dm004p0 en_op1_0900_rl_s1_r10k_dm004p0 0 pwl(0.0000e+00 0 1.1000e-08 0 1.1100e-08 {VDD} 3.4000e-08 {VDD} 3.4100e-08 0)
venb_op1_0900_rl_s1_r10k_dm004p0 enb_op1_0900_rl_s1_r10k_dm004p0 0 pwl(0.0000e+00 {VDD} 1.1000e-08 {VDD} 1.1100e-08 0 3.4000e-08 0 3.4100e-08 {VDD})
vww_op1_0900_rl_s1_r10k_dm004p0 wwl_op1_0900_rl_s1_r10k_dm004p0 0 pwl(0.0000e+00 0 1.2000e-08 0 1.2100e-08 {VDD} 3.2000e-08 {VDD} 3.2100e-08 0)
vwc_op1_0900_rl_s1_r10k_dm004p0 wbc_op1_0900_rl_s1_r10k_dm004p0 0 pwl(0.0000e+00 0 1.2000e-08 0 1.2100e-08 {VDD} 3.4000e-08 {VDD} 3.4100e-08 0)
swb_op1_0900_rl_s1_r10k_dm004p0 ref_op1_0900_rl_s1_r10k_dm004p0 wbl_op1_0900_rl_s1_r10k_dm004p0 wbc_op1_0900_rl_s1_r10k_dm004p0 0 swwbl
cwbl_op1_0900_rl_s1_r10k_dm004p0 wbl_op1_0900_rl_s1_r10k_dm004p0 0 {C_WBL}
spa_op1_0900_rl_s1_r10k_dm004p0 prea rbl_op1_0900_rl_s1_r10k_dm004p0 ctl_op1_0900_rl_s1_r10k_dm004p0 0 swpre
spr_op1_0900_rl_s1_r10k_dm004p0 pref ref_op1_0900_rl_s1_r10k_dm004p0 ctl_op1_0900_rl_s1_r10k_dm004p0 0 swpre
crbl_op1_0900_rl_s1_r10k_dm004p0 rbl_op1_0900_rl_s1_r10k_dm004p0 0 {C_RBL}
cref_op1_0900_rl_s1_r10k_dm004p0 ref_op1_0900_rl_s1_r10k_dm004p0 0 {C_RBL}   $ ASSUMPTION: ideal matched dummy load
XMWR_op1_0900_rl_s1_r10k_dm004p0_0 sn_op1_0900_rl_s1_r10k_dm004p0_0 wwl_op1_0900_rl_s1_r10k_dm004p0 wbl_op1_0900_rl_s1_r10k_dm004p0 0 sky130_fd_pr__nfet_01v8 L=0.15 W=0.42 nf=1 ad=0.1218 as=0.1218 pd=1.42 ps=1.42 nrd=0.69047619047619  nrs=0.69047619047619 sa=0 sb=0 sd=0 mult=1 m=1
XMRD_op1_0900_rl_s1_r10k_dm004p0_0 rbl_op1_0900_rl_s1_r10k_dm004p0 sn_op1_0900_rl_s1_r10k_dm004p0_0 rwls_op1_0900_rl_s1_r10k_dm004p0 0 sky130_fd_pr__nfet_01v8 L=0.15 W=0.42 nf=1 ad=0.1218 as=0.1218 pd=1.42 ps=1.42 nrd=0.69047619047619  nrs=0.69047619047619 sa=0 sb=0 sd=0 mult=1 m=1
csn_op1_0900_rl_s1_r10k_dm004p0_0 sn_op1_0900_rl_s1_r10k_dm004p0_0 0 {C_SN}
XMWR_op1_0900_rl_s1_r10k_dm004p0_1 sn_op1_0900_rl_s1_r10k_dm004p0_1 wwl_des wbl_op1_0900_rl_s1_r10k_dm004p0 0 sky130_fd_pr__nfet_01v8 L=0.15 W=0.42 nf=1 ad=0.1218 as=0.1218 pd=1.42 ps=1.42 nrd=0.69047619047619  nrs=0.69047619047619 sa=0 sb=0 sd=0 mult=1 m=1
XMRD_op1_0900_rl_s1_r10k_dm004p0_1 rbl_op1_0900_rl_s1_r10k_dm004p0 sn_op1_0900_rl_s1_r10k_dm004p0_1 rwl_des 0 sky130_fd_pr__nfet_01v8 L=0.15 W=0.42 nf=1 ad=0.1218 as=0.1218 pd=1.42 ps=1.42 nrd=0.69047619047619  nrs=0.69047619047619 sa=0 sb=0 sd=0 mult=1 m=1
csn_op1_0900_rl_s1_r10k_dm004p0_1 sn_op1_0900_rl_s1_r10k_dm004p0_1 0 {C_SN}
XMWR_op1_0900_rl_s1_r10k_dm004p0_2 sn_op1_0900_rl_s1_r10k_dm004p0_2 wwl_des wbl_op1_0900_rl_s1_r10k_dm004p0 0 sky130_fd_pr__nfet_01v8 L=0.15 W=0.42 nf=1 ad=0.1218 as=0.1218 pd=1.42 ps=1.42 nrd=0.69047619047619  nrs=0.69047619047619 sa=0 sb=0 sd=0 mult=1 m=1
XMRD_op1_0900_rl_s1_r10k_dm004p0_2 rbl_op1_0900_rl_s1_r10k_dm004p0 sn_op1_0900_rl_s1_r10k_dm004p0_2 rwl_des 0 sky130_fd_pr__nfet_01v8 L=0.15 W=0.42 nf=1 ad=0.1218 as=0.1218 pd=1.42 ps=1.42 nrd=0.69047619047619  nrs=0.69047619047619 sa=0 sb=0 sd=0 mult=1 m=1
csn_op1_0900_rl_s1_r10k_dm004p0_2 sn_op1_0900_rl_s1_r10k_dm004p0_2 0 {C_SN}
XMWR_op1_0900_rl_s1_r10k_dm004p0_3 sn_op1_0900_rl_s1_r10k_dm004p0_3 wwl_des wbl_op1_0900_rl_s1_r10k_dm004p0 0 sky130_fd_pr__nfet_01v8 L=0.15 W=0.42 nf=1 ad=0.1218 as=0.1218 pd=1.42 ps=1.42 nrd=0.69047619047619  nrs=0.69047619047619 sa=0 sb=0 sd=0 mult=1 m=1
XMRD_op1_0900_rl_s1_r10k_dm004p0_3 rbl_op1_0900_rl_s1_r10k_dm004p0 sn_op1_0900_rl_s1_r10k_dm004p0_3 rwl_des 0 sky130_fd_pr__nfet_01v8 L=0.15 W=0.42 nf=1 ad=0.1218 as=0.1218 pd=1.42 ps=1.42 nrd=0.69047619047619  nrs=0.69047619047619 sa=0 sb=0 sd=0 mult=1 m=1
csn_op1_0900_rl_s1_r10k_dm004p0_3 sn_op1_0900_rl_s1_r10k_dm004p0_3 0 {C_SN}
XMN1_op1_0900_rl_s1_r10k_dm004p0 rbl_op1_0900_rl_s1_r10k_dm004p0 ref_op1_0900_rl_s1_r10k_dm004p0 vn_op1_0900_rl_s1_r10k_dm004p0 0 sky130_fd_pr__nfet_01v8 L=0.15 W=1 nf=1 ad=0.29 as=0.29 pd=2.58 ps=2.58 mult=1 m=1
XMN2_op1_0900_rl_s1_r10k_dm004p0 ref_op1_0900_rl_s1_r10k_dm004p0 rbl_op1_0900_rl_s1_r10k_dm004p0 vn_op1_0900_rl_s1_r10k_dm004p0 0 sky130_fd_pr__nfet_01v8 L=0.15 W=1 nf=1 ad=0.29 as=0.29 pd=2.58 ps=2.58 mult=1 m=1
XMP1_op1_0900_rl_s1_r10k_dm004p0 rbl_op1_0900_rl_s1_r10k_dm004p0 ref_op1_0900_rl_s1_r10k_dm004p0 vp_op1_0900_rl_s1_r10k_dm004p0 vdd sky130_fd_pr__pfet_01v8 L=0.15 W=2 nf=1 ad=0.58 as=0.58 pd=4.58 ps=4.58 mult=1 m=1
XMP2_op1_0900_rl_s1_r10k_dm004p0 ref_op1_0900_rl_s1_r10k_dm004p0 rbl_op1_0900_rl_s1_r10k_dm004p0 vp_op1_0900_rl_s1_r10k_dm004p0 vdd sky130_fd_pr__pfet_01v8 L=0.15 W=2 nf=1 ad=0.58 as=0.58 pd=4.58 ps=4.58 mult=1 m=1
XMNF_op1_0900_rl_s1_r10k_dm004p0 vn_op1_0900_rl_s1_r10k_dm004p0 en_op1_0900_rl_s1_r10k_dm004p0 0 0 sky130_fd_pr__nfet_01v8 L=0.15 W=2 nf=1 ad=0.58 as=0.58 pd=4.58 ps=4.58 mult=1 m=1
XMPH_op1_0900_rl_s1_r10k_dm004p0 vp_op1_0900_rl_s1_r10k_dm004p0 enb_op1_0900_rl_s1_r10k_dm004p0 vdd vdd sky130_fd_pr__pfet_01v8 L=0.15 W=4 nf=1 ad=1.16 as=1.16 pd=8.58 ps=8.58 mult=1 m=1
bd_op1_0900_rl_s1_r10k_dm004p0 d_op1_0900_rl_s1_r10k_dm004p0 0 v=v(rbl_op1_0900_rl_s1_r10k_dm004p0)-v(ref_op1_0900_rl_s1_r10k_dm004p0)

* ---- instance 262: op1_1000_rl_s1_r10k_dm004p0 (variant rl_s1_r10k_dm004p0; probe dec 11.9 ns, release 34 ns, meas 36 ns) ----
vctl_op1_1000_rl_s1_r10k_dm004p0 ctl_op1_1000_rl_s1_r10k_dm004p0 0 pwl(0.0000e+00 {VDD} 2.0000e-09 {VDD} 2.1000e-09 0)
* RWL driver model (EXPERIMENTAL): slew 1 ns, series R 10000 ohm; cell pin = rwls_op1_1000_rl_s1_r10k_dm004p0
vrs_op1_1000_rl_s1_r10k_dm004p0 rwlsrc_op1_1000_rl_s1_r10k_dm004p0 0 pwl(0.0000e+00 {VDD} 2.0000e-09 {VDD} 3.0000e-09 0 2.8000e-08 0 2.9000e-08 {VDD})
rdrv_op1_1000_rl_s1_r10k_dm004p0 rwlsrc_op1_1000_rl_s1_r10k_dm004p0 rwls_op1_1000_rl_s1_r10k_dm004p0 10000
ven_op1_1000_rl_s1_r10k_dm004p0 en_op1_1000_rl_s1_r10k_dm004p0 0 pwl(0.0000e+00 0 1.1000e-08 0 1.1100e-08 {VDD} 3.4000e-08 {VDD} 3.4100e-08 0)
venb_op1_1000_rl_s1_r10k_dm004p0 enb_op1_1000_rl_s1_r10k_dm004p0 0 pwl(0.0000e+00 {VDD} 1.1000e-08 {VDD} 1.1100e-08 0 3.4000e-08 0 3.4100e-08 {VDD})
vww_op1_1000_rl_s1_r10k_dm004p0 wwl_op1_1000_rl_s1_r10k_dm004p0 0 pwl(0.0000e+00 0 1.2000e-08 0 1.2100e-08 {VDD} 3.2000e-08 {VDD} 3.2100e-08 0)
vwc_op1_1000_rl_s1_r10k_dm004p0 wbc_op1_1000_rl_s1_r10k_dm004p0 0 pwl(0.0000e+00 0 1.2000e-08 0 1.2100e-08 {VDD} 3.4000e-08 {VDD} 3.4100e-08 0)
swb_op1_1000_rl_s1_r10k_dm004p0 ref_op1_1000_rl_s1_r10k_dm004p0 wbl_op1_1000_rl_s1_r10k_dm004p0 wbc_op1_1000_rl_s1_r10k_dm004p0 0 swwbl
cwbl_op1_1000_rl_s1_r10k_dm004p0 wbl_op1_1000_rl_s1_r10k_dm004p0 0 {C_WBL}
spa_op1_1000_rl_s1_r10k_dm004p0 prea rbl_op1_1000_rl_s1_r10k_dm004p0 ctl_op1_1000_rl_s1_r10k_dm004p0 0 swpre
spr_op1_1000_rl_s1_r10k_dm004p0 pref ref_op1_1000_rl_s1_r10k_dm004p0 ctl_op1_1000_rl_s1_r10k_dm004p0 0 swpre
crbl_op1_1000_rl_s1_r10k_dm004p0 rbl_op1_1000_rl_s1_r10k_dm004p0 0 {C_RBL}
cref_op1_1000_rl_s1_r10k_dm004p0 ref_op1_1000_rl_s1_r10k_dm004p0 0 {C_RBL}   $ ASSUMPTION: ideal matched dummy load
XMWR_op1_1000_rl_s1_r10k_dm004p0_0 sn_op1_1000_rl_s1_r10k_dm004p0_0 wwl_op1_1000_rl_s1_r10k_dm004p0 wbl_op1_1000_rl_s1_r10k_dm004p0 0 sky130_fd_pr__nfet_01v8 L=0.15 W=0.42 nf=1 ad=0.1218 as=0.1218 pd=1.42 ps=1.42 nrd=0.69047619047619  nrs=0.69047619047619 sa=0 sb=0 sd=0 mult=1 m=1
XMRD_op1_1000_rl_s1_r10k_dm004p0_0 rbl_op1_1000_rl_s1_r10k_dm004p0 sn_op1_1000_rl_s1_r10k_dm004p0_0 rwls_op1_1000_rl_s1_r10k_dm004p0 0 sky130_fd_pr__nfet_01v8 L=0.15 W=0.42 nf=1 ad=0.1218 as=0.1218 pd=1.42 ps=1.42 nrd=0.69047619047619  nrs=0.69047619047619 sa=0 sb=0 sd=0 mult=1 m=1
csn_op1_1000_rl_s1_r10k_dm004p0_0 sn_op1_1000_rl_s1_r10k_dm004p0_0 0 {C_SN}
XMWR_op1_1000_rl_s1_r10k_dm004p0_1 sn_op1_1000_rl_s1_r10k_dm004p0_1 wwl_des wbl_op1_1000_rl_s1_r10k_dm004p0 0 sky130_fd_pr__nfet_01v8 L=0.15 W=0.42 nf=1 ad=0.1218 as=0.1218 pd=1.42 ps=1.42 nrd=0.69047619047619  nrs=0.69047619047619 sa=0 sb=0 sd=0 mult=1 m=1
XMRD_op1_1000_rl_s1_r10k_dm004p0_1 rbl_op1_1000_rl_s1_r10k_dm004p0 sn_op1_1000_rl_s1_r10k_dm004p0_1 rwl_des 0 sky130_fd_pr__nfet_01v8 L=0.15 W=0.42 nf=1 ad=0.1218 as=0.1218 pd=1.42 ps=1.42 nrd=0.69047619047619  nrs=0.69047619047619 sa=0 sb=0 sd=0 mult=1 m=1
csn_op1_1000_rl_s1_r10k_dm004p0_1 sn_op1_1000_rl_s1_r10k_dm004p0_1 0 {C_SN}
XMWR_op1_1000_rl_s1_r10k_dm004p0_2 sn_op1_1000_rl_s1_r10k_dm004p0_2 wwl_des wbl_op1_1000_rl_s1_r10k_dm004p0 0 sky130_fd_pr__nfet_01v8 L=0.15 W=0.42 nf=1 ad=0.1218 as=0.1218 pd=1.42 ps=1.42 nrd=0.69047619047619  nrs=0.69047619047619 sa=0 sb=0 sd=0 mult=1 m=1
XMRD_op1_1000_rl_s1_r10k_dm004p0_2 rbl_op1_1000_rl_s1_r10k_dm004p0 sn_op1_1000_rl_s1_r10k_dm004p0_2 rwl_des 0 sky130_fd_pr__nfet_01v8 L=0.15 W=0.42 nf=1 ad=0.1218 as=0.1218 pd=1.42 ps=1.42 nrd=0.69047619047619  nrs=0.69047619047619 sa=0 sb=0 sd=0 mult=1 m=1
csn_op1_1000_rl_s1_r10k_dm004p0_2 sn_op1_1000_rl_s1_r10k_dm004p0_2 0 {C_SN}
XMWR_op1_1000_rl_s1_r10k_dm004p0_3 sn_op1_1000_rl_s1_r10k_dm004p0_3 wwl_des wbl_op1_1000_rl_s1_r10k_dm004p0 0 sky130_fd_pr__nfet_01v8 L=0.15 W=0.42 nf=1 ad=0.1218 as=0.1218 pd=1.42 ps=1.42 nrd=0.69047619047619  nrs=0.69047619047619 sa=0 sb=0 sd=0 mult=1 m=1
XMRD_op1_1000_rl_s1_r10k_dm004p0_3 rbl_op1_1000_rl_s1_r10k_dm004p0 sn_op1_1000_rl_s1_r10k_dm004p0_3 rwl_des 0 sky130_fd_pr__nfet_01v8 L=0.15 W=0.42 nf=1 ad=0.1218 as=0.1218 pd=1.42 ps=1.42 nrd=0.69047619047619  nrs=0.69047619047619 sa=0 sb=0 sd=0 mult=1 m=1
csn_op1_1000_rl_s1_r10k_dm004p0_3 sn_op1_1000_rl_s1_r10k_dm004p0_3 0 {C_SN}
XMN1_op1_1000_rl_s1_r10k_dm004p0 rbl_op1_1000_rl_s1_r10k_dm004p0 ref_op1_1000_rl_s1_r10k_dm004p0 vn_op1_1000_rl_s1_r10k_dm004p0 0 sky130_fd_pr__nfet_01v8 L=0.15 W=1 nf=1 ad=0.29 as=0.29 pd=2.58 ps=2.58 mult=1 m=1
XMN2_op1_1000_rl_s1_r10k_dm004p0 ref_op1_1000_rl_s1_r10k_dm004p0 rbl_op1_1000_rl_s1_r10k_dm004p0 vn_op1_1000_rl_s1_r10k_dm004p0 0 sky130_fd_pr__nfet_01v8 L=0.15 W=1 nf=1 ad=0.29 as=0.29 pd=2.58 ps=2.58 mult=1 m=1
XMP1_op1_1000_rl_s1_r10k_dm004p0 rbl_op1_1000_rl_s1_r10k_dm004p0 ref_op1_1000_rl_s1_r10k_dm004p0 vp_op1_1000_rl_s1_r10k_dm004p0 vdd sky130_fd_pr__pfet_01v8 L=0.15 W=2 nf=1 ad=0.58 as=0.58 pd=4.58 ps=4.58 mult=1 m=1
XMP2_op1_1000_rl_s1_r10k_dm004p0 ref_op1_1000_rl_s1_r10k_dm004p0 rbl_op1_1000_rl_s1_r10k_dm004p0 vp_op1_1000_rl_s1_r10k_dm004p0 vdd sky130_fd_pr__pfet_01v8 L=0.15 W=2 nf=1 ad=0.58 as=0.58 pd=4.58 ps=4.58 mult=1 m=1
XMNF_op1_1000_rl_s1_r10k_dm004p0 vn_op1_1000_rl_s1_r10k_dm004p0 en_op1_1000_rl_s1_r10k_dm004p0 0 0 sky130_fd_pr__nfet_01v8 L=0.15 W=2 nf=1 ad=0.58 as=0.58 pd=4.58 ps=4.58 mult=1 m=1
XMPH_op1_1000_rl_s1_r10k_dm004p0 vp_op1_1000_rl_s1_r10k_dm004p0 enb_op1_1000_rl_s1_r10k_dm004p0 vdd vdd sky130_fd_pr__pfet_01v8 L=0.15 W=4 nf=1 ad=1.16 as=1.16 pd=8.58 ps=8.58 mult=1 m=1
bd_op1_1000_rl_s1_r10k_dm004p0 d_op1_1000_rl_s1_r10k_dm004p0 0 v=v(rbl_op1_1000_rl_s1_r10k_dm004p0)-v(ref_op1_1000_rl_s1_r10k_dm004p0)

* ---- instance 263: op0_n100_rl_s1_r10k_dm004p0 (variant rl_s1_r10k_dm004p0; probe dec 11.9 ns, release 34 ns, meas 36 ns) ----
vctl_op0_n100_rl_s1_r10k_dm004p0 ctl_op0_n100_rl_s1_r10k_dm004p0 0 pwl(0.0000e+00 {VDD} 2.0000e-09 {VDD} 2.1000e-09 0)
* RWL driver model (EXPERIMENTAL): slew 1 ns, series R 10000 ohm; cell pin = rwls_op0_n100_rl_s1_r10k_dm004p0
vrs_op0_n100_rl_s1_r10k_dm004p0 rwlsrc_op0_n100_rl_s1_r10k_dm004p0 0 pwl(0.0000e+00 {VDD} 2.0000e-09 {VDD} 3.0000e-09 0 2.8000e-08 0 2.9000e-08 {VDD})
rdrv_op0_n100_rl_s1_r10k_dm004p0 rwlsrc_op0_n100_rl_s1_r10k_dm004p0 rwls_op0_n100_rl_s1_r10k_dm004p0 10000
ven_op0_n100_rl_s1_r10k_dm004p0 en_op0_n100_rl_s1_r10k_dm004p0 0 pwl(0.0000e+00 0 1.1000e-08 0 1.1100e-08 {VDD} 3.4000e-08 {VDD} 3.4100e-08 0)
venb_op0_n100_rl_s1_r10k_dm004p0 enb_op0_n100_rl_s1_r10k_dm004p0 0 pwl(0.0000e+00 {VDD} 1.1000e-08 {VDD} 1.1100e-08 0 3.4000e-08 0 3.4100e-08 {VDD})
vww_op0_n100_rl_s1_r10k_dm004p0 wwl_op0_n100_rl_s1_r10k_dm004p0 0 pwl(0.0000e+00 0 1.2000e-08 0 1.2100e-08 {VDD} 3.2000e-08 {VDD} 3.2100e-08 0)
vwc_op0_n100_rl_s1_r10k_dm004p0 wbc_op0_n100_rl_s1_r10k_dm004p0 0 pwl(0.0000e+00 0 1.2000e-08 0 1.2100e-08 {VDD} 3.4000e-08 {VDD} 3.4100e-08 0)
swb_op0_n100_rl_s1_r10k_dm004p0 ref_op0_n100_rl_s1_r10k_dm004p0 wbl_op0_n100_rl_s1_r10k_dm004p0 wbc_op0_n100_rl_s1_r10k_dm004p0 0 swwbl
cwbl_op0_n100_rl_s1_r10k_dm004p0 wbl_op0_n100_rl_s1_r10k_dm004p0 0 {C_WBL}
spa_op0_n100_rl_s1_r10k_dm004p0 prea rbl_op0_n100_rl_s1_r10k_dm004p0 ctl_op0_n100_rl_s1_r10k_dm004p0 0 swpre
spr_op0_n100_rl_s1_r10k_dm004p0 pref ref_op0_n100_rl_s1_r10k_dm004p0 ctl_op0_n100_rl_s1_r10k_dm004p0 0 swpre
crbl_op0_n100_rl_s1_r10k_dm004p0 rbl_op0_n100_rl_s1_r10k_dm004p0 0 {C_RBL}
cref_op0_n100_rl_s1_r10k_dm004p0 ref_op0_n100_rl_s1_r10k_dm004p0 0 {C_RBL}   $ ASSUMPTION: ideal matched dummy load
XMWR_op0_n100_rl_s1_r10k_dm004p0_0 sn_op0_n100_rl_s1_r10k_dm004p0_0 wwl_op0_n100_rl_s1_r10k_dm004p0 wbl_op0_n100_rl_s1_r10k_dm004p0 0 sky130_fd_pr__nfet_01v8 L=0.15 W=0.42 nf=1 ad=0.1218 as=0.1218 pd=1.42 ps=1.42 nrd=0.69047619047619  nrs=0.69047619047619 sa=0 sb=0 sd=0 mult=1 m=1
XMRD_op0_n100_rl_s1_r10k_dm004p0_0 rbl_op0_n100_rl_s1_r10k_dm004p0 sn_op0_n100_rl_s1_r10k_dm004p0_0 rwls_op0_n100_rl_s1_r10k_dm004p0 0 sky130_fd_pr__nfet_01v8 L=0.15 W=0.42 nf=1 ad=0.1218 as=0.1218 pd=1.42 ps=1.42 nrd=0.69047619047619  nrs=0.69047619047619 sa=0 sb=0 sd=0 mult=1 m=1
csn_op0_n100_rl_s1_r10k_dm004p0_0 sn_op0_n100_rl_s1_r10k_dm004p0_0 0 {C_SN}
XMWR_op0_n100_rl_s1_r10k_dm004p0_1 sn_op0_n100_rl_s1_r10k_dm004p0_1 wwl_des wbl_op0_n100_rl_s1_r10k_dm004p0 0 sky130_fd_pr__nfet_01v8 L=0.15 W=0.42 nf=1 ad=0.1218 as=0.1218 pd=1.42 ps=1.42 nrd=0.69047619047619  nrs=0.69047619047619 sa=0 sb=0 sd=0 mult=1 m=1
XMRD_op0_n100_rl_s1_r10k_dm004p0_1 rbl_op0_n100_rl_s1_r10k_dm004p0 sn_op0_n100_rl_s1_r10k_dm004p0_1 rwl_des 0 sky130_fd_pr__nfet_01v8 L=0.15 W=0.42 nf=1 ad=0.1218 as=0.1218 pd=1.42 ps=1.42 nrd=0.69047619047619  nrs=0.69047619047619 sa=0 sb=0 sd=0 mult=1 m=1
csn_op0_n100_rl_s1_r10k_dm004p0_1 sn_op0_n100_rl_s1_r10k_dm004p0_1 0 {C_SN}
XMWR_op0_n100_rl_s1_r10k_dm004p0_2 sn_op0_n100_rl_s1_r10k_dm004p0_2 wwl_des wbl_op0_n100_rl_s1_r10k_dm004p0 0 sky130_fd_pr__nfet_01v8 L=0.15 W=0.42 nf=1 ad=0.1218 as=0.1218 pd=1.42 ps=1.42 nrd=0.69047619047619  nrs=0.69047619047619 sa=0 sb=0 sd=0 mult=1 m=1
XMRD_op0_n100_rl_s1_r10k_dm004p0_2 rbl_op0_n100_rl_s1_r10k_dm004p0 sn_op0_n100_rl_s1_r10k_dm004p0_2 rwl_des 0 sky130_fd_pr__nfet_01v8 L=0.15 W=0.42 nf=1 ad=0.1218 as=0.1218 pd=1.42 ps=1.42 nrd=0.69047619047619  nrs=0.69047619047619 sa=0 sb=0 sd=0 mult=1 m=1
csn_op0_n100_rl_s1_r10k_dm004p0_2 sn_op0_n100_rl_s1_r10k_dm004p0_2 0 {C_SN}
XMWR_op0_n100_rl_s1_r10k_dm004p0_3 sn_op0_n100_rl_s1_r10k_dm004p0_3 wwl_des wbl_op0_n100_rl_s1_r10k_dm004p0 0 sky130_fd_pr__nfet_01v8 L=0.15 W=0.42 nf=1 ad=0.1218 as=0.1218 pd=1.42 ps=1.42 nrd=0.69047619047619  nrs=0.69047619047619 sa=0 sb=0 sd=0 mult=1 m=1
XMRD_op0_n100_rl_s1_r10k_dm004p0_3 rbl_op0_n100_rl_s1_r10k_dm004p0 sn_op0_n100_rl_s1_r10k_dm004p0_3 rwl_des 0 sky130_fd_pr__nfet_01v8 L=0.15 W=0.42 nf=1 ad=0.1218 as=0.1218 pd=1.42 ps=1.42 nrd=0.69047619047619  nrs=0.69047619047619 sa=0 sb=0 sd=0 mult=1 m=1
csn_op0_n100_rl_s1_r10k_dm004p0_3 sn_op0_n100_rl_s1_r10k_dm004p0_3 0 {C_SN}
XMN1_op0_n100_rl_s1_r10k_dm004p0 rbl_op0_n100_rl_s1_r10k_dm004p0 ref_op0_n100_rl_s1_r10k_dm004p0 vn_op0_n100_rl_s1_r10k_dm004p0 0 sky130_fd_pr__nfet_01v8 L=0.15 W=1 nf=1 ad=0.29 as=0.29 pd=2.58 ps=2.58 mult=1 m=1
XMN2_op0_n100_rl_s1_r10k_dm004p0 ref_op0_n100_rl_s1_r10k_dm004p0 rbl_op0_n100_rl_s1_r10k_dm004p0 vn_op0_n100_rl_s1_r10k_dm004p0 0 sky130_fd_pr__nfet_01v8 L=0.15 W=1 nf=1 ad=0.29 as=0.29 pd=2.58 ps=2.58 mult=1 m=1
XMP1_op0_n100_rl_s1_r10k_dm004p0 rbl_op0_n100_rl_s1_r10k_dm004p0 ref_op0_n100_rl_s1_r10k_dm004p0 vp_op0_n100_rl_s1_r10k_dm004p0 vdd sky130_fd_pr__pfet_01v8 L=0.15 W=2 nf=1 ad=0.58 as=0.58 pd=4.58 ps=4.58 mult=1 m=1
XMP2_op0_n100_rl_s1_r10k_dm004p0 ref_op0_n100_rl_s1_r10k_dm004p0 rbl_op0_n100_rl_s1_r10k_dm004p0 vp_op0_n100_rl_s1_r10k_dm004p0 vdd sky130_fd_pr__pfet_01v8 L=0.15 W=2 nf=1 ad=0.58 as=0.58 pd=4.58 ps=4.58 mult=1 m=1
XMNF_op0_n100_rl_s1_r10k_dm004p0 vn_op0_n100_rl_s1_r10k_dm004p0 en_op0_n100_rl_s1_r10k_dm004p0 0 0 sky130_fd_pr__nfet_01v8 L=0.15 W=2 nf=1 ad=0.58 as=0.58 pd=4.58 ps=4.58 mult=1 m=1
XMPH_op0_n100_rl_s1_r10k_dm004p0 vp_op0_n100_rl_s1_r10k_dm004p0 enb_op0_n100_rl_s1_r10k_dm004p0 vdd vdd sky130_fd_pr__pfet_01v8 L=0.15 W=4 nf=1 ad=1.16 as=1.16 pd=8.58 ps=8.58 mult=1 m=1
bd_op0_n100_rl_s1_r10k_dm004p0 d_op0_n100_rl_s1_r10k_dm004p0 0 v=v(rbl_op0_n100_rl_s1_r10k_dm004p0)-v(ref_op0_n100_rl_s1_r10k_dm004p0)

* ---- instance 264: op0_0000_rl_s1_r10k_dm004p0 (variant rl_s1_r10k_dm004p0; probe dec 11.9 ns, release 34 ns, meas 36 ns) ----
vctl_op0_0000_rl_s1_r10k_dm004p0 ctl_op0_0000_rl_s1_r10k_dm004p0 0 pwl(0.0000e+00 {VDD} 2.0000e-09 {VDD} 2.1000e-09 0)
* RWL driver model (EXPERIMENTAL): slew 1 ns, series R 10000 ohm; cell pin = rwls_op0_0000_rl_s1_r10k_dm004p0
vrs_op0_0000_rl_s1_r10k_dm004p0 rwlsrc_op0_0000_rl_s1_r10k_dm004p0 0 pwl(0.0000e+00 {VDD} 2.0000e-09 {VDD} 3.0000e-09 0 2.8000e-08 0 2.9000e-08 {VDD})
rdrv_op0_0000_rl_s1_r10k_dm004p0 rwlsrc_op0_0000_rl_s1_r10k_dm004p0 rwls_op0_0000_rl_s1_r10k_dm004p0 10000
ven_op0_0000_rl_s1_r10k_dm004p0 en_op0_0000_rl_s1_r10k_dm004p0 0 pwl(0.0000e+00 0 1.1000e-08 0 1.1100e-08 {VDD} 3.4000e-08 {VDD} 3.4100e-08 0)
venb_op0_0000_rl_s1_r10k_dm004p0 enb_op0_0000_rl_s1_r10k_dm004p0 0 pwl(0.0000e+00 {VDD} 1.1000e-08 {VDD} 1.1100e-08 0 3.4000e-08 0 3.4100e-08 {VDD})
vww_op0_0000_rl_s1_r10k_dm004p0 wwl_op0_0000_rl_s1_r10k_dm004p0 0 pwl(0.0000e+00 0 1.2000e-08 0 1.2100e-08 {VDD} 3.2000e-08 {VDD} 3.2100e-08 0)
vwc_op0_0000_rl_s1_r10k_dm004p0 wbc_op0_0000_rl_s1_r10k_dm004p0 0 pwl(0.0000e+00 0 1.2000e-08 0 1.2100e-08 {VDD} 3.4000e-08 {VDD} 3.4100e-08 0)
swb_op0_0000_rl_s1_r10k_dm004p0 ref_op0_0000_rl_s1_r10k_dm004p0 wbl_op0_0000_rl_s1_r10k_dm004p0 wbc_op0_0000_rl_s1_r10k_dm004p0 0 swwbl
cwbl_op0_0000_rl_s1_r10k_dm004p0 wbl_op0_0000_rl_s1_r10k_dm004p0 0 {C_WBL}
spa_op0_0000_rl_s1_r10k_dm004p0 prea rbl_op0_0000_rl_s1_r10k_dm004p0 ctl_op0_0000_rl_s1_r10k_dm004p0 0 swpre
spr_op0_0000_rl_s1_r10k_dm004p0 pref ref_op0_0000_rl_s1_r10k_dm004p0 ctl_op0_0000_rl_s1_r10k_dm004p0 0 swpre
crbl_op0_0000_rl_s1_r10k_dm004p0 rbl_op0_0000_rl_s1_r10k_dm004p0 0 {C_RBL}
cref_op0_0000_rl_s1_r10k_dm004p0 ref_op0_0000_rl_s1_r10k_dm004p0 0 {C_RBL}   $ ASSUMPTION: ideal matched dummy load
XMWR_op0_0000_rl_s1_r10k_dm004p0_0 sn_op0_0000_rl_s1_r10k_dm004p0_0 wwl_op0_0000_rl_s1_r10k_dm004p0 wbl_op0_0000_rl_s1_r10k_dm004p0 0 sky130_fd_pr__nfet_01v8 L=0.15 W=0.42 nf=1 ad=0.1218 as=0.1218 pd=1.42 ps=1.42 nrd=0.69047619047619  nrs=0.69047619047619 sa=0 sb=0 sd=0 mult=1 m=1
XMRD_op0_0000_rl_s1_r10k_dm004p0_0 rbl_op0_0000_rl_s1_r10k_dm004p0 sn_op0_0000_rl_s1_r10k_dm004p0_0 rwls_op0_0000_rl_s1_r10k_dm004p0 0 sky130_fd_pr__nfet_01v8 L=0.15 W=0.42 nf=1 ad=0.1218 as=0.1218 pd=1.42 ps=1.42 nrd=0.69047619047619  nrs=0.69047619047619 sa=0 sb=0 sd=0 mult=1 m=1
csn_op0_0000_rl_s1_r10k_dm004p0_0 sn_op0_0000_rl_s1_r10k_dm004p0_0 0 {C_SN}
XMWR_op0_0000_rl_s1_r10k_dm004p0_1 sn_op0_0000_rl_s1_r10k_dm004p0_1 wwl_des wbl_op0_0000_rl_s1_r10k_dm004p0 0 sky130_fd_pr__nfet_01v8 L=0.15 W=0.42 nf=1 ad=0.1218 as=0.1218 pd=1.42 ps=1.42 nrd=0.69047619047619  nrs=0.69047619047619 sa=0 sb=0 sd=0 mult=1 m=1
XMRD_op0_0000_rl_s1_r10k_dm004p0_1 rbl_op0_0000_rl_s1_r10k_dm004p0 sn_op0_0000_rl_s1_r10k_dm004p0_1 rwl_des 0 sky130_fd_pr__nfet_01v8 L=0.15 W=0.42 nf=1 ad=0.1218 as=0.1218 pd=1.42 ps=1.42 nrd=0.69047619047619  nrs=0.69047619047619 sa=0 sb=0 sd=0 mult=1 m=1
csn_op0_0000_rl_s1_r10k_dm004p0_1 sn_op0_0000_rl_s1_r10k_dm004p0_1 0 {C_SN}
XMWR_op0_0000_rl_s1_r10k_dm004p0_2 sn_op0_0000_rl_s1_r10k_dm004p0_2 wwl_des wbl_op0_0000_rl_s1_r10k_dm004p0 0 sky130_fd_pr__nfet_01v8 L=0.15 W=0.42 nf=1 ad=0.1218 as=0.1218 pd=1.42 ps=1.42 nrd=0.69047619047619  nrs=0.69047619047619 sa=0 sb=0 sd=0 mult=1 m=1
XMRD_op0_0000_rl_s1_r10k_dm004p0_2 rbl_op0_0000_rl_s1_r10k_dm004p0 sn_op0_0000_rl_s1_r10k_dm004p0_2 rwl_des 0 sky130_fd_pr__nfet_01v8 L=0.15 W=0.42 nf=1 ad=0.1218 as=0.1218 pd=1.42 ps=1.42 nrd=0.69047619047619  nrs=0.69047619047619 sa=0 sb=0 sd=0 mult=1 m=1
csn_op0_0000_rl_s1_r10k_dm004p0_2 sn_op0_0000_rl_s1_r10k_dm004p0_2 0 {C_SN}
XMWR_op0_0000_rl_s1_r10k_dm004p0_3 sn_op0_0000_rl_s1_r10k_dm004p0_3 wwl_des wbl_op0_0000_rl_s1_r10k_dm004p0 0 sky130_fd_pr__nfet_01v8 L=0.15 W=0.42 nf=1 ad=0.1218 as=0.1218 pd=1.42 ps=1.42 nrd=0.69047619047619  nrs=0.69047619047619 sa=0 sb=0 sd=0 mult=1 m=1
XMRD_op0_0000_rl_s1_r10k_dm004p0_3 rbl_op0_0000_rl_s1_r10k_dm004p0 sn_op0_0000_rl_s1_r10k_dm004p0_3 rwl_des 0 sky130_fd_pr__nfet_01v8 L=0.15 W=0.42 nf=1 ad=0.1218 as=0.1218 pd=1.42 ps=1.42 nrd=0.69047619047619  nrs=0.69047619047619 sa=0 sb=0 sd=0 mult=1 m=1
csn_op0_0000_rl_s1_r10k_dm004p0_3 sn_op0_0000_rl_s1_r10k_dm004p0_3 0 {C_SN}
XMN1_op0_0000_rl_s1_r10k_dm004p0 rbl_op0_0000_rl_s1_r10k_dm004p0 ref_op0_0000_rl_s1_r10k_dm004p0 vn_op0_0000_rl_s1_r10k_dm004p0 0 sky130_fd_pr__nfet_01v8 L=0.15 W=1 nf=1 ad=0.29 as=0.29 pd=2.58 ps=2.58 mult=1 m=1
XMN2_op0_0000_rl_s1_r10k_dm004p0 ref_op0_0000_rl_s1_r10k_dm004p0 rbl_op0_0000_rl_s1_r10k_dm004p0 vn_op0_0000_rl_s1_r10k_dm004p0 0 sky130_fd_pr__nfet_01v8 L=0.15 W=1 nf=1 ad=0.29 as=0.29 pd=2.58 ps=2.58 mult=1 m=1
XMP1_op0_0000_rl_s1_r10k_dm004p0 rbl_op0_0000_rl_s1_r10k_dm004p0 ref_op0_0000_rl_s1_r10k_dm004p0 vp_op0_0000_rl_s1_r10k_dm004p0 vdd sky130_fd_pr__pfet_01v8 L=0.15 W=2 nf=1 ad=0.58 as=0.58 pd=4.58 ps=4.58 mult=1 m=1
XMP2_op0_0000_rl_s1_r10k_dm004p0 ref_op0_0000_rl_s1_r10k_dm004p0 rbl_op0_0000_rl_s1_r10k_dm004p0 vp_op0_0000_rl_s1_r10k_dm004p0 vdd sky130_fd_pr__pfet_01v8 L=0.15 W=2 nf=1 ad=0.58 as=0.58 pd=4.58 ps=4.58 mult=1 m=1
XMNF_op0_0000_rl_s1_r10k_dm004p0 vn_op0_0000_rl_s1_r10k_dm004p0 en_op0_0000_rl_s1_r10k_dm004p0 0 0 sky130_fd_pr__nfet_01v8 L=0.15 W=2 nf=1 ad=0.58 as=0.58 pd=4.58 ps=4.58 mult=1 m=1
XMPH_op0_0000_rl_s1_r10k_dm004p0 vp_op0_0000_rl_s1_r10k_dm004p0 enb_op0_0000_rl_s1_r10k_dm004p0 vdd vdd sky130_fd_pr__pfet_01v8 L=0.15 W=4 nf=1 ad=1.16 as=1.16 pd=8.58 ps=8.58 mult=1 m=1
bd_op0_0000_rl_s1_r10k_dm004p0 d_op0_0000_rl_s1_r10k_dm004p0 0 v=v(rbl_op0_0000_rl_s1_r10k_dm004p0)-v(ref_op0_0000_rl_s1_r10k_dm004p0)

* ---- instance 265: op1_0900_rl_s1_r10k_dm002p0 (variant rl_s1_r10k_dm002p0; probe dec 11.9 ns, release 34 ns, meas 36 ns) ----
vctl_op1_0900_rl_s1_r10k_dm002p0 ctl_op1_0900_rl_s1_r10k_dm002p0 0 pwl(0.0000e+00 {VDD} 2.0000e-09 {VDD} 2.1000e-09 0)
* RWL driver model (EXPERIMENTAL): slew 1 ns, series R 10000 ohm; cell pin = rwls_op1_0900_rl_s1_r10k_dm002p0
vrs_op1_0900_rl_s1_r10k_dm002p0 rwlsrc_op1_0900_rl_s1_r10k_dm002p0 0 pwl(0.0000e+00 {VDD} 2.0000e-09 {VDD} 3.0000e-09 0 3.0000e-08 0 3.1000e-08 {VDD})
rdrv_op1_0900_rl_s1_r10k_dm002p0 rwlsrc_op1_0900_rl_s1_r10k_dm002p0 rwls_op1_0900_rl_s1_r10k_dm002p0 10000
ven_op1_0900_rl_s1_r10k_dm002p0 en_op1_0900_rl_s1_r10k_dm002p0 0 pwl(0.0000e+00 0 1.1000e-08 0 1.1100e-08 {VDD} 3.4000e-08 {VDD} 3.4100e-08 0)
venb_op1_0900_rl_s1_r10k_dm002p0 enb_op1_0900_rl_s1_r10k_dm002p0 0 pwl(0.0000e+00 {VDD} 1.1000e-08 {VDD} 1.1100e-08 0 3.4000e-08 0 3.4100e-08 {VDD})
vww_op1_0900_rl_s1_r10k_dm002p0 wwl_op1_0900_rl_s1_r10k_dm002p0 0 pwl(0.0000e+00 0 1.2000e-08 0 1.2100e-08 {VDD} 3.2000e-08 {VDD} 3.2100e-08 0)
vwc_op1_0900_rl_s1_r10k_dm002p0 wbc_op1_0900_rl_s1_r10k_dm002p0 0 pwl(0.0000e+00 0 1.2000e-08 0 1.2100e-08 {VDD} 3.4000e-08 {VDD} 3.4100e-08 0)
swb_op1_0900_rl_s1_r10k_dm002p0 ref_op1_0900_rl_s1_r10k_dm002p0 wbl_op1_0900_rl_s1_r10k_dm002p0 wbc_op1_0900_rl_s1_r10k_dm002p0 0 swwbl
cwbl_op1_0900_rl_s1_r10k_dm002p0 wbl_op1_0900_rl_s1_r10k_dm002p0 0 {C_WBL}
spa_op1_0900_rl_s1_r10k_dm002p0 prea rbl_op1_0900_rl_s1_r10k_dm002p0 ctl_op1_0900_rl_s1_r10k_dm002p0 0 swpre
spr_op1_0900_rl_s1_r10k_dm002p0 pref ref_op1_0900_rl_s1_r10k_dm002p0 ctl_op1_0900_rl_s1_r10k_dm002p0 0 swpre
crbl_op1_0900_rl_s1_r10k_dm002p0 rbl_op1_0900_rl_s1_r10k_dm002p0 0 {C_RBL}
cref_op1_0900_rl_s1_r10k_dm002p0 ref_op1_0900_rl_s1_r10k_dm002p0 0 {C_RBL}   $ ASSUMPTION: ideal matched dummy load
XMWR_op1_0900_rl_s1_r10k_dm002p0_0 sn_op1_0900_rl_s1_r10k_dm002p0_0 wwl_op1_0900_rl_s1_r10k_dm002p0 wbl_op1_0900_rl_s1_r10k_dm002p0 0 sky130_fd_pr__nfet_01v8 L=0.15 W=0.42 nf=1 ad=0.1218 as=0.1218 pd=1.42 ps=1.42 nrd=0.69047619047619  nrs=0.69047619047619 sa=0 sb=0 sd=0 mult=1 m=1
XMRD_op1_0900_rl_s1_r10k_dm002p0_0 rbl_op1_0900_rl_s1_r10k_dm002p0 sn_op1_0900_rl_s1_r10k_dm002p0_0 rwls_op1_0900_rl_s1_r10k_dm002p0 0 sky130_fd_pr__nfet_01v8 L=0.15 W=0.42 nf=1 ad=0.1218 as=0.1218 pd=1.42 ps=1.42 nrd=0.69047619047619  nrs=0.69047619047619 sa=0 sb=0 sd=0 mult=1 m=1
csn_op1_0900_rl_s1_r10k_dm002p0_0 sn_op1_0900_rl_s1_r10k_dm002p0_0 0 {C_SN}
XMWR_op1_0900_rl_s1_r10k_dm002p0_1 sn_op1_0900_rl_s1_r10k_dm002p0_1 wwl_des wbl_op1_0900_rl_s1_r10k_dm002p0 0 sky130_fd_pr__nfet_01v8 L=0.15 W=0.42 nf=1 ad=0.1218 as=0.1218 pd=1.42 ps=1.42 nrd=0.69047619047619  nrs=0.69047619047619 sa=0 sb=0 sd=0 mult=1 m=1
XMRD_op1_0900_rl_s1_r10k_dm002p0_1 rbl_op1_0900_rl_s1_r10k_dm002p0 sn_op1_0900_rl_s1_r10k_dm002p0_1 rwl_des 0 sky130_fd_pr__nfet_01v8 L=0.15 W=0.42 nf=1 ad=0.1218 as=0.1218 pd=1.42 ps=1.42 nrd=0.69047619047619  nrs=0.69047619047619 sa=0 sb=0 sd=0 mult=1 m=1
csn_op1_0900_rl_s1_r10k_dm002p0_1 sn_op1_0900_rl_s1_r10k_dm002p0_1 0 {C_SN}
XMWR_op1_0900_rl_s1_r10k_dm002p0_2 sn_op1_0900_rl_s1_r10k_dm002p0_2 wwl_des wbl_op1_0900_rl_s1_r10k_dm002p0 0 sky130_fd_pr__nfet_01v8 L=0.15 W=0.42 nf=1 ad=0.1218 as=0.1218 pd=1.42 ps=1.42 nrd=0.69047619047619  nrs=0.69047619047619 sa=0 sb=0 sd=0 mult=1 m=1
XMRD_op1_0900_rl_s1_r10k_dm002p0_2 rbl_op1_0900_rl_s1_r10k_dm002p0 sn_op1_0900_rl_s1_r10k_dm002p0_2 rwl_des 0 sky130_fd_pr__nfet_01v8 L=0.15 W=0.42 nf=1 ad=0.1218 as=0.1218 pd=1.42 ps=1.42 nrd=0.69047619047619  nrs=0.69047619047619 sa=0 sb=0 sd=0 mult=1 m=1
csn_op1_0900_rl_s1_r10k_dm002p0_2 sn_op1_0900_rl_s1_r10k_dm002p0_2 0 {C_SN}
XMWR_op1_0900_rl_s1_r10k_dm002p0_3 sn_op1_0900_rl_s1_r10k_dm002p0_3 wwl_des wbl_op1_0900_rl_s1_r10k_dm002p0 0 sky130_fd_pr__nfet_01v8 L=0.15 W=0.42 nf=1 ad=0.1218 as=0.1218 pd=1.42 ps=1.42 nrd=0.69047619047619  nrs=0.69047619047619 sa=0 sb=0 sd=0 mult=1 m=1
XMRD_op1_0900_rl_s1_r10k_dm002p0_3 rbl_op1_0900_rl_s1_r10k_dm002p0 sn_op1_0900_rl_s1_r10k_dm002p0_3 rwl_des 0 sky130_fd_pr__nfet_01v8 L=0.15 W=0.42 nf=1 ad=0.1218 as=0.1218 pd=1.42 ps=1.42 nrd=0.69047619047619  nrs=0.69047619047619 sa=0 sb=0 sd=0 mult=1 m=1
csn_op1_0900_rl_s1_r10k_dm002p0_3 sn_op1_0900_rl_s1_r10k_dm002p0_3 0 {C_SN}
XMN1_op1_0900_rl_s1_r10k_dm002p0 rbl_op1_0900_rl_s1_r10k_dm002p0 ref_op1_0900_rl_s1_r10k_dm002p0 vn_op1_0900_rl_s1_r10k_dm002p0 0 sky130_fd_pr__nfet_01v8 L=0.15 W=1 nf=1 ad=0.29 as=0.29 pd=2.58 ps=2.58 mult=1 m=1
XMN2_op1_0900_rl_s1_r10k_dm002p0 ref_op1_0900_rl_s1_r10k_dm002p0 rbl_op1_0900_rl_s1_r10k_dm002p0 vn_op1_0900_rl_s1_r10k_dm002p0 0 sky130_fd_pr__nfet_01v8 L=0.15 W=1 nf=1 ad=0.29 as=0.29 pd=2.58 ps=2.58 mult=1 m=1
XMP1_op1_0900_rl_s1_r10k_dm002p0 rbl_op1_0900_rl_s1_r10k_dm002p0 ref_op1_0900_rl_s1_r10k_dm002p0 vp_op1_0900_rl_s1_r10k_dm002p0 vdd sky130_fd_pr__pfet_01v8 L=0.15 W=2 nf=1 ad=0.58 as=0.58 pd=4.58 ps=4.58 mult=1 m=1
XMP2_op1_0900_rl_s1_r10k_dm002p0 ref_op1_0900_rl_s1_r10k_dm002p0 rbl_op1_0900_rl_s1_r10k_dm002p0 vp_op1_0900_rl_s1_r10k_dm002p0 vdd sky130_fd_pr__pfet_01v8 L=0.15 W=2 nf=1 ad=0.58 as=0.58 pd=4.58 ps=4.58 mult=1 m=1
XMNF_op1_0900_rl_s1_r10k_dm002p0 vn_op1_0900_rl_s1_r10k_dm002p0 en_op1_0900_rl_s1_r10k_dm002p0 0 0 sky130_fd_pr__nfet_01v8 L=0.15 W=2 nf=1 ad=0.58 as=0.58 pd=4.58 ps=4.58 mult=1 m=1
XMPH_op1_0900_rl_s1_r10k_dm002p0 vp_op1_0900_rl_s1_r10k_dm002p0 enb_op1_0900_rl_s1_r10k_dm002p0 vdd vdd sky130_fd_pr__pfet_01v8 L=0.15 W=4 nf=1 ad=1.16 as=1.16 pd=8.58 ps=8.58 mult=1 m=1
bd_op1_0900_rl_s1_r10k_dm002p0 d_op1_0900_rl_s1_r10k_dm002p0 0 v=v(rbl_op1_0900_rl_s1_r10k_dm002p0)-v(ref_op1_0900_rl_s1_r10k_dm002p0)

* ---- instance 266: op1_1000_rl_s1_r10k_dm002p0 (variant rl_s1_r10k_dm002p0; probe dec 11.9 ns, release 34 ns, meas 36 ns) ----
vctl_op1_1000_rl_s1_r10k_dm002p0 ctl_op1_1000_rl_s1_r10k_dm002p0 0 pwl(0.0000e+00 {VDD} 2.0000e-09 {VDD} 2.1000e-09 0)
* RWL driver model (EXPERIMENTAL): slew 1 ns, series R 10000 ohm; cell pin = rwls_op1_1000_rl_s1_r10k_dm002p0
vrs_op1_1000_rl_s1_r10k_dm002p0 rwlsrc_op1_1000_rl_s1_r10k_dm002p0 0 pwl(0.0000e+00 {VDD} 2.0000e-09 {VDD} 3.0000e-09 0 3.0000e-08 0 3.1000e-08 {VDD})
rdrv_op1_1000_rl_s1_r10k_dm002p0 rwlsrc_op1_1000_rl_s1_r10k_dm002p0 rwls_op1_1000_rl_s1_r10k_dm002p0 10000
ven_op1_1000_rl_s1_r10k_dm002p0 en_op1_1000_rl_s1_r10k_dm002p0 0 pwl(0.0000e+00 0 1.1000e-08 0 1.1100e-08 {VDD} 3.4000e-08 {VDD} 3.4100e-08 0)
venb_op1_1000_rl_s1_r10k_dm002p0 enb_op1_1000_rl_s1_r10k_dm002p0 0 pwl(0.0000e+00 {VDD} 1.1000e-08 {VDD} 1.1100e-08 0 3.4000e-08 0 3.4100e-08 {VDD})
vww_op1_1000_rl_s1_r10k_dm002p0 wwl_op1_1000_rl_s1_r10k_dm002p0 0 pwl(0.0000e+00 0 1.2000e-08 0 1.2100e-08 {VDD} 3.2000e-08 {VDD} 3.2100e-08 0)
vwc_op1_1000_rl_s1_r10k_dm002p0 wbc_op1_1000_rl_s1_r10k_dm002p0 0 pwl(0.0000e+00 0 1.2000e-08 0 1.2100e-08 {VDD} 3.4000e-08 {VDD} 3.4100e-08 0)
swb_op1_1000_rl_s1_r10k_dm002p0 ref_op1_1000_rl_s1_r10k_dm002p0 wbl_op1_1000_rl_s1_r10k_dm002p0 wbc_op1_1000_rl_s1_r10k_dm002p0 0 swwbl
cwbl_op1_1000_rl_s1_r10k_dm002p0 wbl_op1_1000_rl_s1_r10k_dm002p0 0 {C_WBL}
spa_op1_1000_rl_s1_r10k_dm002p0 prea rbl_op1_1000_rl_s1_r10k_dm002p0 ctl_op1_1000_rl_s1_r10k_dm002p0 0 swpre
spr_op1_1000_rl_s1_r10k_dm002p0 pref ref_op1_1000_rl_s1_r10k_dm002p0 ctl_op1_1000_rl_s1_r10k_dm002p0 0 swpre
crbl_op1_1000_rl_s1_r10k_dm002p0 rbl_op1_1000_rl_s1_r10k_dm002p0 0 {C_RBL}
cref_op1_1000_rl_s1_r10k_dm002p0 ref_op1_1000_rl_s1_r10k_dm002p0 0 {C_RBL}   $ ASSUMPTION: ideal matched dummy load
XMWR_op1_1000_rl_s1_r10k_dm002p0_0 sn_op1_1000_rl_s1_r10k_dm002p0_0 wwl_op1_1000_rl_s1_r10k_dm002p0 wbl_op1_1000_rl_s1_r10k_dm002p0 0 sky130_fd_pr__nfet_01v8 L=0.15 W=0.42 nf=1 ad=0.1218 as=0.1218 pd=1.42 ps=1.42 nrd=0.69047619047619  nrs=0.69047619047619 sa=0 sb=0 sd=0 mult=1 m=1
XMRD_op1_1000_rl_s1_r10k_dm002p0_0 rbl_op1_1000_rl_s1_r10k_dm002p0 sn_op1_1000_rl_s1_r10k_dm002p0_0 rwls_op1_1000_rl_s1_r10k_dm002p0 0 sky130_fd_pr__nfet_01v8 L=0.15 W=0.42 nf=1 ad=0.1218 as=0.1218 pd=1.42 ps=1.42 nrd=0.69047619047619  nrs=0.69047619047619 sa=0 sb=0 sd=0 mult=1 m=1
csn_op1_1000_rl_s1_r10k_dm002p0_0 sn_op1_1000_rl_s1_r10k_dm002p0_0 0 {C_SN}
XMWR_op1_1000_rl_s1_r10k_dm002p0_1 sn_op1_1000_rl_s1_r10k_dm002p0_1 wwl_des wbl_op1_1000_rl_s1_r10k_dm002p0 0 sky130_fd_pr__nfet_01v8 L=0.15 W=0.42 nf=1 ad=0.1218 as=0.1218 pd=1.42 ps=1.42 nrd=0.69047619047619  nrs=0.69047619047619 sa=0 sb=0 sd=0 mult=1 m=1
XMRD_op1_1000_rl_s1_r10k_dm002p0_1 rbl_op1_1000_rl_s1_r10k_dm002p0 sn_op1_1000_rl_s1_r10k_dm002p0_1 rwl_des 0 sky130_fd_pr__nfet_01v8 L=0.15 W=0.42 nf=1 ad=0.1218 as=0.1218 pd=1.42 ps=1.42 nrd=0.69047619047619  nrs=0.69047619047619 sa=0 sb=0 sd=0 mult=1 m=1
csn_op1_1000_rl_s1_r10k_dm002p0_1 sn_op1_1000_rl_s1_r10k_dm002p0_1 0 {C_SN}
XMWR_op1_1000_rl_s1_r10k_dm002p0_2 sn_op1_1000_rl_s1_r10k_dm002p0_2 wwl_des wbl_op1_1000_rl_s1_r10k_dm002p0 0 sky130_fd_pr__nfet_01v8 L=0.15 W=0.42 nf=1 ad=0.1218 as=0.1218 pd=1.42 ps=1.42 nrd=0.69047619047619  nrs=0.69047619047619 sa=0 sb=0 sd=0 mult=1 m=1
XMRD_op1_1000_rl_s1_r10k_dm002p0_2 rbl_op1_1000_rl_s1_r10k_dm002p0 sn_op1_1000_rl_s1_r10k_dm002p0_2 rwl_des 0 sky130_fd_pr__nfet_01v8 L=0.15 W=0.42 nf=1 ad=0.1218 as=0.1218 pd=1.42 ps=1.42 nrd=0.69047619047619  nrs=0.69047619047619 sa=0 sb=0 sd=0 mult=1 m=1
csn_op1_1000_rl_s1_r10k_dm002p0_2 sn_op1_1000_rl_s1_r10k_dm002p0_2 0 {C_SN}
XMWR_op1_1000_rl_s1_r10k_dm002p0_3 sn_op1_1000_rl_s1_r10k_dm002p0_3 wwl_des wbl_op1_1000_rl_s1_r10k_dm002p0 0 sky130_fd_pr__nfet_01v8 L=0.15 W=0.42 nf=1 ad=0.1218 as=0.1218 pd=1.42 ps=1.42 nrd=0.69047619047619  nrs=0.69047619047619 sa=0 sb=0 sd=0 mult=1 m=1
XMRD_op1_1000_rl_s1_r10k_dm002p0_3 rbl_op1_1000_rl_s1_r10k_dm002p0 sn_op1_1000_rl_s1_r10k_dm002p0_3 rwl_des 0 sky130_fd_pr__nfet_01v8 L=0.15 W=0.42 nf=1 ad=0.1218 as=0.1218 pd=1.42 ps=1.42 nrd=0.69047619047619  nrs=0.69047619047619 sa=0 sb=0 sd=0 mult=1 m=1
csn_op1_1000_rl_s1_r10k_dm002p0_3 sn_op1_1000_rl_s1_r10k_dm002p0_3 0 {C_SN}
XMN1_op1_1000_rl_s1_r10k_dm002p0 rbl_op1_1000_rl_s1_r10k_dm002p0 ref_op1_1000_rl_s1_r10k_dm002p0 vn_op1_1000_rl_s1_r10k_dm002p0 0 sky130_fd_pr__nfet_01v8 L=0.15 W=1 nf=1 ad=0.29 as=0.29 pd=2.58 ps=2.58 mult=1 m=1
XMN2_op1_1000_rl_s1_r10k_dm002p0 ref_op1_1000_rl_s1_r10k_dm002p0 rbl_op1_1000_rl_s1_r10k_dm002p0 vn_op1_1000_rl_s1_r10k_dm002p0 0 sky130_fd_pr__nfet_01v8 L=0.15 W=1 nf=1 ad=0.29 as=0.29 pd=2.58 ps=2.58 mult=1 m=1
XMP1_op1_1000_rl_s1_r10k_dm002p0 rbl_op1_1000_rl_s1_r10k_dm002p0 ref_op1_1000_rl_s1_r10k_dm002p0 vp_op1_1000_rl_s1_r10k_dm002p0 vdd sky130_fd_pr__pfet_01v8 L=0.15 W=2 nf=1 ad=0.58 as=0.58 pd=4.58 ps=4.58 mult=1 m=1
XMP2_op1_1000_rl_s1_r10k_dm002p0 ref_op1_1000_rl_s1_r10k_dm002p0 rbl_op1_1000_rl_s1_r10k_dm002p0 vp_op1_1000_rl_s1_r10k_dm002p0 vdd sky130_fd_pr__pfet_01v8 L=0.15 W=2 nf=1 ad=0.58 as=0.58 pd=4.58 ps=4.58 mult=1 m=1
XMNF_op1_1000_rl_s1_r10k_dm002p0 vn_op1_1000_rl_s1_r10k_dm002p0 en_op1_1000_rl_s1_r10k_dm002p0 0 0 sky130_fd_pr__nfet_01v8 L=0.15 W=2 nf=1 ad=0.58 as=0.58 pd=4.58 ps=4.58 mult=1 m=1
XMPH_op1_1000_rl_s1_r10k_dm002p0 vp_op1_1000_rl_s1_r10k_dm002p0 enb_op1_1000_rl_s1_r10k_dm002p0 vdd vdd sky130_fd_pr__pfet_01v8 L=0.15 W=4 nf=1 ad=1.16 as=1.16 pd=8.58 ps=8.58 mult=1 m=1
bd_op1_1000_rl_s1_r10k_dm002p0 d_op1_1000_rl_s1_r10k_dm002p0 0 v=v(rbl_op1_1000_rl_s1_r10k_dm002p0)-v(ref_op1_1000_rl_s1_r10k_dm002p0)

* ---- instance 267: op0_n100_rl_s1_r10k_dm002p0 (variant rl_s1_r10k_dm002p0; probe dec 11.9 ns, release 34 ns, meas 36 ns) ----
vctl_op0_n100_rl_s1_r10k_dm002p0 ctl_op0_n100_rl_s1_r10k_dm002p0 0 pwl(0.0000e+00 {VDD} 2.0000e-09 {VDD} 2.1000e-09 0)
* RWL driver model (EXPERIMENTAL): slew 1 ns, series R 10000 ohm; cell pin = rwls_op0_n100_rl_s1_r10k_dm002p0
vrs_op0_n100_rl_s1_r10k_dm002p0 rwlsrc_op0_n100_rl_s1_r10k_dm002p0 0 pwl(0.0000e+00 {VDD} 2.0000e-09 {VDD} 3.0000e-09 0 3.0000e-08 0 3.1000e-08 {VDD})
rdrv_op0_n100_rl_s1_r10k_dm002p0 rwlsrc_op0_n100_rl_s1_r10k_dm002p0 rwls_op0_n100_rl_s1_r10k_dm002p0 10000
ven_op0_n100_rl_s1_r10k_dm002p0 en_op0_n100_rl_s1_r10k_dm002p0 0 pwl(0.0000e+00 0 1.1000e-08 0 1.1100e-08 {VDD} 3.4000e-08 {VDD} 3.4100e-08 0)
venb_op0_n100_rl_s1_r10k_dm002p0 enb_op0_n100_rl_s1_r10k_dm002p0 0 pwl(0.0000e+00 {VDD} 1.1000e-08 {VDD} 1.1100e-08 0 3.4000e-08 0 3.4100e-08 {VDD})
vww_op0_n100_rl_s1_r10k_dm002p0 wwl_op0_n100_rl_s1_r10k_dm002p0 0 pwl(0.0000e+00 0 1.2000e-08 0 1.2100e-08 {VDD} 3.2000e-08 {VDD} 3.2100e-08 0)
vwc_op0_n100_rl_s1_r10k_dm002p0 wbc_op0_n100_rl_s1_r10k_dm002p0 0 pwl(0.0000e+00 0 1.2000e-08 0 1.2100e-08 {VDD} 3.4000e-08 {VDD} 3.4100e-08 0)
swb_op0_n100_rl_s1_r10k_dm002p0 ref_op0_n100_rl_s1_r10k_dm002p0 wbl_op0_n100_rl_s1_r10k_dm002p0 wbc_op0_n100_rl_s1_r10k_dm002p0 0 swwbl
cwbl_op0_n100_rl_s1_r10k_dm002p0 wbl_op0_n100_rl_s1_r10k_dm002p0 0 {C_WBL}
spa_op0_n100_rl_s1_r10k_dm002p0 prea rbl_op0_n100_rl_s1_r10k_dm002p0 ctl_op0_n100_rl_s1_r10k_dm002p0 0 swpre
spr_op0_n100_rl_s1_r10k_dm002p0 pref ref_op0_n100_rl_s1_r10k_dm002p0 ctl_op0_n100_rl_s1_r10k_dm002p0 0 swpre
crbl_op0_n100_rl_s1_r10k_dm002p0 rbl_op0_n100_rl_s1_r10k_dm002p0 0 {C_RBL}
cref_op0_n100_rl_s1_r10k_dm002p0 ref_op0_n100_rl_s1_r10k_dm002p0 0 {C_RBL}   $ ASSUMPTION: ideal matched dummy load
XMWR_op0_n100_rl_s1_r10k_dm002p0_0 sn_op0_n100_rl_s1_r10k_dm002p0_0 wwl_op0_n100_rl_s1_r10k_dm002p0 wbl_op0_n100_rl_s1_r10k_dm002p0 0 sky130_fd_pr__nfet_01v8 L=0.15 W=0.42 nf=1 ad=0.1218 as=0.1218 pd=1.42 ps=1.42 nrd=0.69047619047619  nrs=0.69047619047619 sa=0 sb=0 sd=0 mult=1 m=1
XMRD_op0_n100_rl_s1_r10k_dm002p0_0 rbl_op0_n100_rl_s1_r10k_dm002p0 sn_op0_n100_rl_s1_r10k_dm002p0_0 rwls_op0_n100_rl_s1_r10k_dm002p0 0 sky130_fd_pr__nfet_01v8 L=0.15 W=0.42 nf=1 ad=0.1218 as=0.1218 pd=1.42 ps=1.42 nrd=0.69047619047619  nrs=0.69047619047619 sa=0 sb=0 sd=0 mult=1 m=1
csn_op0_n100_rl_s1_r10k_dm002p0_0 sn_op0_n100_rl_s1_r10k_dm002p0_0 0 {C_SN}
XMWR_op0_n100_rl_s1_r10k_dm002p0_1 sn_op0_n100_rl_s1_r10k_dm002p0_1 wwl_des wbl_op0_n100_rl_s1_r10k_dm002p0 0 sky130_fd_pr__nfet_01v8 L=0.15 W=0.42 nf=1 ad=0.1218 as=0.1218 pd=1.42 ps=1.42 nrd=0.69047619047619  nrs=0.69047619047619 sa=0 sb=0 sd=0 mult=1 m=1
XMRD_op0_n100_rl_s1_r10k_dm002p0_1 rbl_op0_n100_rl_s1_r10k_dm002p0 sn_op0_n100_rl_s1_r10k_dm002p0_1 rwl_des 0 sky130_fd_pr__nfet_01v8 L=0.15 W=0.42 nf=1 ad=0.1218 as=0.1218 pd=1.42 ps=1.42 nrd=0.69047619047619  nrs=0.69047619047619 sa=0 sb=0 sd=0 mult=1 m=1
csn_op0_n100_rl_s1_r10k_dm002p0_1 sn_op0_n100_rl_s1_r10k_dm002p0_1 0 {C_SN}
XMWR_op0_n100_rl_s1_r10k_dm002p0_2 sn_op0_n100_rl_s1_r10k_dm002p0_2 wwl_des wbl_op0_n100_rl_s1_r10k_dm002p0 0 sky130_fd_pr__nfet_01v8 L=0.15 W=0.42 nf=1 ad=0.1218 as=0.1218 pd=1.42 ps=1.42 nrd=0.69047619047619  nrs=0.69047619047619 sa=0 sb=0 sd=0 mult=1 m=1
XMRD_op0_n100_rl_s1_r10k_dm002p0_2 rbl_op0_n100_rl_s1_r10k_dm002p0 sn_op0_n100_rl_s1_r10k_dm002p0_2 rwl_des 0 sky130_fd_pr__nfet_01v8 L=0.15 W=0.42 nf=1 ad=0.1218 as=0.1218 pd=1.42 ps=1.42 nrd=0.69047619047619  nrs=0.69047619047619 sa=0 sb=0 sd=0 mult=1 m=1
csn_op0_n100_rl_s1_r10k_dm002p0_2 sn_op0_n100_rl_s1_r10k_dm002p0_2 0 {C_SN}
XMWR_op0_n100_rl_s1_r10k_dm002p0_3 sn_op0_n100_rl_s1_r10k_dm002p0_3 wwl_des wbl_op0_n100_rl_s1_r10k_dm002p0 0 sky130_fd_pr__nfet_01v8 L=0.15 W=0.42 nf=1 ad=0.1218 as=0.1218 pd=1.42 ps=1.42 nrd=0.69047619047619  nrs=0.69047619047619 sa=0 sb=0 sd=0 mult=1 m=1
XMRD_op0_n100_rl_s1_r10k_dm002p0_3 rbl_op0_n100_rl_s1_r10k_dm002p0 sn_op0_n100_rl_s1_r10k_dm002p0_3 rwl_des 0 sky130_fd_pr__nfet_01v8 L=0.15 W=0.42 nf=1 ad=0.1218 as=0.1218 pd=1.42 ps=1.42 nrd=0.69047619047619  nrs=0.69047619047619 sa=0 sb=0 sd=0 mult=1 m=1
csn_op0_n100_rl_s1_r10k_dm002p0_3 sn_op0_n100_rl_s1_r10k_dm002p0_3 0 {C_SN}
XMN1_op0_n100_rl_s1_r10k_dm002p0 rbl_op0_n100_rl_s1_r10k_dm002p0 ref_op0_n100_rl_s1_r10k_dm002p0 vn_op0_n100_rl_s1_r10k_dm002p0 0 sky130_fd_pr__nfet_01v8 L=0.15 W=1 nf=1 ad=0.29 as=0.29 pd=2.58 ps=2.58 mult=1 m=1
XMN2_op0_n100_rl_s1_r10k_dm002p0 ref_op0_n100_rl_s1_r10k_dm002p0 rbl_op0_n100_rl_s1_r10k_dm002p0 vn_op0_n100_rl_s1_r10k_dm002p0 0 sky130_fd_pr__nfet_01v8 L=0.15 W=1 nf=1 ad=0.29 as=0.29 pd=2.58 ps=2.58 mult=1 m=1
XMP1_op0_n100_rl_s1_r10k_dm002p0 rbl_op0_n100_rl_s1_r10k_dm002p0 ref_op0_n100_rl_s1_r10k_dm002p0 vp_op0_n100_rl_s1_r10k_dm002p0 vdd sky130_fd_pr__pfet_01v8 L=0.15 W=2 nf=1 ad=0.58 as=0.58 pd=4.58 ps=4.58 mult=1 m=1
XMP2_op0_n100_rl_s1_r10k_dm002p0 ref_op0_n100_rl_s1_r10k_dm002p0 rbl_op0_n100_rl_s1_r10k_dm002p0 vp_op0_n100_rl_s1_r10k_dm002p0 vdd sky130_fd_pr__pfet_01v8 L=0.15 W=2 nf=1 ad=0.58 as=0.58 pd=4.58 ps=4.58 mult=1 m=1
XMNF_op0_n100_rl_s1_r10k_dm002p0 vn_op0_n100_rl_s1_r10k_dm002p0 en_op0_n100_rl_s1_r10k_dm002p0 0 0 sky130_fd_pr__nfet_01v8 L=0.15 W=2 nf=1 ad=0.58 as=0.58 pd=4.58 ps=4.58 mult=1 m=1
XMPH_op0_n100_rl_s1_r10k_dm002p0 vp_op0_n100_rl_s1_r10k_dm002p0 enb_op0_n100_rl_s1_r10k_dm002p0 vdd vdd sky130_fd_pr__pfet_01v8 L=0.15 W=4 nf=1 ad=1.16 as=1.16 pd=8.58 ps=8.58 mult=1 m=1
bd_op0_n100_rl_s1_r10k_dm002p0 d_op0_n100_rl_s1_r10k_dm002p0 0 v=v(rbl_op0_n100_rl_s1_r10k_dm002p0)-v(ref_op0_n100_rl_s1_r10k_dm002p0)

* ---- instance 268: op0_0000_rl_s1_r10k_dm002p0 (variant rl_s1_r10k_dm002p0; probe dec 11.9 ns, release 34 ns, meas 36 ns) ----
vctl_op0_0000_rl_s1_r10k_dm002p0 ctl_op0_0000_rl_s1_r10k_dm002p0 0 pwl(0.0000e+00 {VDD} 2.0000e-09 {VDD} 2.1000e-09 0)
* RWL driver model (EXPERIMENTAL): slew 1 ns, series R 10000 ohm; cell pin = rwls_op0_0000_rl_s1_r10k_dm002p0
vrs_op0_0000_rl_s1_r10k_dm002p0 rwlsrc_op0_0000_rl_s1_r10k_dm002p0 0 pwl(0.0000e+00 {VDD} 2.0000e-09 {VDD} 3.0000e-09 0 3.0000e-08 0 3.1000e-08 {VDD})
rdrv_op0_0000_rl_s1_r10k_dm002p0 rwlsrc_op0_0000_rl_s1_r10k_dm002p0 rwls_op0_0000_rl_s1_r10k_dm002p0 10000
ven_op0_0000_rl_s1_r10k_dm002p0 en_op0_0000_rl_s1_r10k_dm002p0 0 pwl(0.0000e+00 0 1.1000e-08 0 1.1100e-08 {VDD} 3.4000e-08 {VDD} 3.4100e-08 0)
venb_op0_0000_rl_s1_r10k_dm002p0 enb_op0_0000_rl_s1_r10k_dm002p0 0 pwl(0.0000e+00 {VDD} 1.1000e-08 {VDD} 1.1100e-08 0 3.4000e-08 0 3.4100e-08 {VDD})
vww_op0_0000_rl_s1_r10k_dm002p0 wwl_op0_0000_rl_s1_r10k_dm002p0 0 pwl(0.0000e+00 0 1.2000e-08 0 1.2100e-08 {VDD} 3.2000e-08 {VDD} 3.2100e-08 0)
vwc_op0_0000_rl_s1_r10k_dm002p0 wbc_op0_0000_rl_s1_r10k_dm002p0 0 pwl(0.0000e+00 0 1.2000e-08 0 1.2100e-08 {VDD} 3.4000e-08 {VDD} 3.4100e-08 0)
swb_op0_0000_rl_s1_r10k_dm002p0 ref_op0_0000_rl_s1_r10k_dm002p0 wbl_op0_0000_rl_s1_r10k_dm002p0 wbc_op0_0000_rl_s1_r10k_dm002p0 0 swwbl
cwbl_op0_0000_rl_s1_r10k_dm002p0 wbl_op0_0000_rl_s1_r10k_dm002p0 0 {C_WBL}
spa_op0_0000_rl_s1_r10k_dm002p0 prea rbl_op0_0000_rl_s1_r10k_dm002p0 ctl_op0_0000_rl_s1_r10k_dm002p0 0 swpre
spr_op0_0000_rl_s1_r10k_dm002p0 pref ref_op0_0000_rl_s1_r10k_dm002p0 ctl_op0_0000_rl_s1_r10k_dm002p0 0 swpre
crbl_op0_0000_rl_s1_r10k_dm002p0 rbl_op0_0000_rl_s1_r10k_dm002p0 0 {C_RBL}
cref_op0_0000_rl_s1_r10k_dm002p0 ref_op0_0000_rl_s1_r10k_dm002p0 0 {C_RBL}   $ ASSUMPTION: ideal matched dummy load
XMWR_op0_0000_rl_s1_r10k_dm002p0_0 sn_op0_0000_rl_s1_r10k_dm002p0_0 wwl_op0_0000_rl_s1_r10k_dm002p0 wbl_op0_0000_rl_s1_r10k_dm002p0 0 sky130_fd_pr__nfet_01v8 L=0.15 W=0.42 nf=1 ad=0.1218 as=0.1218 pd=1.42 ps=1.42 nrd=0.69047619047619  nrs=0.69047619047619 sa=0 sb=0 sd=0 mult=1 m=1
XMRD_op0_0000_rl_s1_r10k_dm002p0_0 rbl_op0_0000_rl_s1_r10k_dm002p0 sn_op0_0000_rl_s1_r10k_dm002p0_0 rwls_op0_0000_rl_s1_r10k_dm002p0 0 sky130_fd_pr__nfet_01v8 L=0.15 W=0.42 nf=1 ad=0.1218 as=0.1218 pd=1.42 ps=1.42 nrd=0.69047619047619  nrs=0.69047619047619 sa=0 sb=0 sd=0 mult=1 m=1
csn_op0_0000_rl_s1_r10k_dm002p0_0 sn_op0_0000_rl_s1_r10k_dm002p0_0 0 {C_SN}
XMWR_op0_0000_rl_s1_r10k_dm002p0_1 sn_op0_0000_rl_s1_r10k_dm002p0_1 wwl_des wbl_op0_0000_rl_s1_r10k_dm002p0 0 sky130_fd_pr__nfet_01v8 L=0.15 W=0.42 nf=1 ad=0.1218 as=0.1218 pd=1.42 ps=1.42 nrd=0.69047619047619  nrs=0.69047619047619 sa=0 sb=0 sd=0 mult=1 m=1
XMRD_op0_0000_rl_s1_r10k_dm002p0_1 rbl_op0_0000_rl_s1_r10k_dm002p0 sn_op0_0000_rl_s1_r10k_dm002p0_1 rwl_des 0 sky130_fd_pr__nfet_01v8 L=0.15 W=0.42 nf=1 ad=0.1218 as=0.1218 pd=1.42 ps=1.42 nrd=0.69047619047619  nrs=0.69047619047619 sa=0 sb=0 sd=0 mult=1 m=1
csn_op0_0000_rl_s1_r10k_dm002p0_1 sn_op0_0000_rl_s1_r10k_dm002p0_1 0 {C_SN}
XMWR_op0_0000_rl_s1_r10k_dm002p0_2 sn_op0_0000_rl_s1_r10k_dm002p0_2 wwl_des wbl_op0_0000_rl_s1_r10k_dm002p0 0 sky130_fd_pr__nfet_01v8 L=0.15 W=0.42 nf=1 ad=0.1218 as=0.1218 pd=1.42 ps=1.42 nrd=0.69047619047619  nrs=0.69047619047619 sa=0 sb=0 sd=0 mult=1 m=1
XMRD_op0_0000_rl_s1_r10k_dm002p0_2 rbl_op0_0000_rl_s1_r10k_dm002p0 sn_op0_0000_rl_s1_r10k_dm002p0_2 rwl_des 0 sky130_fd_pr__nfet_01v8 L=0.15 W=0.42 nf=1 ad=0.1218 as=0.1218 pd=1.42 ps=1.42 nrd=0.69047619047619  nrs=0.69047619047619 sa=0 sb=0 sd=0 mult=1 m=1
csn_op0_0000_rl_s1_r10k_dm002p0_2 sn_op0_0000_rl_s1_r10k_dm002p0_2 0 {C_SN}
XMWR_op0_0000_rl_s1_r10k_dm002p0_3 sn_op0_0000_rl_s1_r10k_dm002p0_3 wwl_des wbl_op0_0000_rl_s1_r10k_dm002p0 0 sky130_fd_pr__nfet_01v8 L=0.15 W=0.42 nf=1 ad=0.1218 as=0.1218 pd=1.42 ps=1.42 nrd=0.69047619047619  nrs=0.69047619047619 sa=0 sb=0 sd=0 mult=1 m=1
XMRD_op0_0000_rl_s1_r10k_dm002p0_3 rbl_op0_0000_rl_s1_r10k_dm002p0 sn_op0_0000_rl_s1_r10k_dm002p0_3 rwl_des 0 sky130_fd_pr__nfet_01v8 L=0.15 W=0.42 nf=1 ad=0.1218 as=0.1218 pd=1.42 ps=1.42 nrd=0.69047619047619  nrs=0.69047619047619 sa=0 sb=0 sd=0 mult=1 m=1
csn_op0_0000_rl_s1_r10k_dm002p0_3 sn_op0_0000_rl_s1_r10k_dm002p0_3 0 {C_SN}
XMN1_op0_0000_rl_s1_r10k_dm002p0 rbl_op0_0000_rl_s1_r10k_dm002p0 ref_op0_0000_rl_s1_r10k_dm002p0 vn_op0_0000_rl_s1_r10k_dm002p0 0 sky130_fd_pr__nfet_01v8 L=0.15 W=1 nf=1 ad=0.29 as=0.29 pd=2.58 ps=2.58 mult=1 m=1
XMN2_op0_0000_rl_s1_r10k_dm002p0 ref_op0_0000_rl_s1_r10k_dm002p0 rbl_op0_0000_rl_s1_r10k_dm002p0 vn_op0_0000_rl_s1_r10k_dm002p0 0 sky130_fd_pr__nfet_01v8 L=0.15 W=1 nf=1 ad=0.29 as=0.29 pd=2.58 ps=2.58 mult=1 m=1
XMP1_op0_0000_rl_s1_r10k_dm002p0 rbl_op0_0000_rl_s1_r10k_dm002p0 ref_op0_0000_rl_s1_r10k_dm002p0 vp_op0_0000_rl_s1_r10k_dm002p0 vdd sky130_fd_pr__pfet_01v8 L=0.15 W=2 nf=1 ad=0.58 as=0.58 pd=4.58 ps=4.58 mult=1 m=1
XMP2_op0_0000_rl_s1_r10k_dm002p0 ref_op0_0000_rl_s1_r10k_dm002p0 rbl_op0_0000_rl_s1_r10k_dm002p0 vp_op0_0000_rl_s1_r10k_dm002p0 vdd sky130_fd_pr__pfet_01v8 L=0.15 W=2 nf=1 ad=0.58 as=0.58 pd=4.58 ps=4.58 mult=1 m=1
XMNF_op0_0000_rl_s1_r10k_dm002p0 vn_op0_0000_rl_s1_r10k_dm002p0 en_op0_0000_rl_s1_r10k_dm002p0 0 0 sky130_fd_pr__nfet_01v8 L=0.15 W=2 nf=1 ad=0.58 as=0.58 pd=4.58 ps=4.58 mult=1 m=1
XMPH_op0_0000_rl_s1_r10k_dm002p0 vp_op0_0000_rl_s1_r10k_dm002p0 enb_op0_0000_rl_s1_r10k_dm002p0 vdd vdd sky130_fd_pr__pfet_01v8 L=0.15 W=4 nf=1 ad=1.16 as=1.16 pd=8.58 ps=8.58 mult=1 m=1
bd_op0_0000_rl_s1_r10k_dm002p0 d_op0_0000_rl_s1_r10k_dm002p0 0 v=v(rbl_op0_0000_rl_s1_r10k_dm002p0)-v(ref_op0_0000_rl_s1_r10k_dm002p0)

* ---- instance 269: op1_0900_rl_s1_r10k_dp000p0 (variant rl_s1_r10k_dp000p0; probe dec 11.9 ns, release 34 ns, meas 36 ns) ----
vctl_op1_0900_rl_s1_r10k_dp000p0 ctl_op1_0900_rl_s1_r10k_dp000p0 0 pwl(0.0000e+00 {VDD} 2.0000e-09 {VDD} 2.1000e-09 0)
* RWL driver model (EXPERIMENTAL): slew 1 ns, series R 10000 ohm; cell pin = rwls_op1_0900_rl_s1_r10k_dp000p0
vrs_op1_0900_rl_s1_r10k_dp000p0 rwlsrc_op1_0900_rl_s1_r10k_dp000p0 0 pwl(0.0000e+00 {VDD} 2.0000e-09 {VDD} 3.0000e-09 0 3.2000e-08 0 3.3000e-08 {VDD})
rdrv_op1_0900_rl_s1_r10k_dp000p0 rwlsrc_op1_0900_rl_s1_r10k_dp000p0 rwls_op1_0900_rl_s1_r10k_dp000p0 10000
ven_op1_0900_rl_s1_r10k_dp000p0 en_op1_0900_rl_s1_r10k_dp000p0 0 pwl(0.0000e+00 0 1.1000e-08 0 1.1100e-08 {VDD} 3.4000e-08 {VDD} 3.4100e-08 0)
venb_op1_0900_rl_s1_r10k_dp000p0 enb_op1_0900_rl_s1_r10k_dp000p0 0 pwl(0.0000e+00 {VDD} 1.1000e-08 {VDD} 1.1100e-08 0 3.4000e-08 0 3.4100e-08 {VDD})
vww_op1_0900_rl_s1_r10k_dp000p0 wwl_op1_0900_rl_s1_r10k_dp000p0 0 pwl(0.0000e+00 0 1.2000e-08 0 1.2100e-08 {VDD} 3.2000e-08 {VDD} 3.2100e-08 0)
vwc_op1_0900_rl_s1_r10k_dp000p0 wbc_op1_0900_rl_s1_r10k_dp000p0 0 pwl(0.0000e+00 0 1.2000e-08 0 1.2100e-08 {VDD} 3.4000e-08 {VDD} 3.4100e-08 0)
swb_op1_0900_rl_s1_r10k_dp000p0 ref_op1_0900_rl_s1_r10k_dp000p0 wbl_op1_0900_rl_s1_r10k_dp000p0 wbc_op1_0900_rl_s1_r10k_dp000p0 0 swwbl
cwbl_op1_0900_rl_s1_r10k_dp000p0 wbl_op1_0900_rl_s1_r10k_dp000p0 0 {C_WBL}
spa_op1_0900_rl_s1_r10k_dp000p0 prea rbl_op1_0900_rl_s1_r10k_dp000p0 ctl_op1_0900_rl_s1_r10k_dp000p0 0 swpre
spr_op1_0900_rl_s1_r10k_dp000p0 pref ref_op1_0900_rl_s1_r10k_dp000p0 ctl_op1_0900_rl_s1_r10k_dp000p0 0 swpre
crbl_op1_0900_rl_s1_r10k_dp000p0 rbl_op1_0900_rl_s1_r10k_dp000p0 0 {C_RBL}
cref_op1_0900_rl_s1_r10k_dp000p0 ref_op1_0900_rl_s1_r10k_dp000p0 0 {C_RBL}   $ ASSUMPTION: ideal matched dummy load
XMWR_op1_0900_rl_s1_r10k_dp000p0_0 sn_op1_0900_rl_s1_r10k_dp000p0_0 wwl_op1_0900_rl_s1_r10k_dp000p0 wbl_op1_0900_rl_s1_r10k_dp000p0 0 sky130_fd_pr__nfet_01v8 L=0.15 W=0.42 nf=1 ad=0.1218 as=0.1218 pd=1.42 ps=1.42 nrd=0.69047619047619  nrs=0.69047619047619 sa=0 sb=0 sd=0 mult=1 m=1
XMRD_op1_0900_rl_s1_r10k_dp000p0_0 rbl_op1_0900_rl_s1_r10k_dp000p0 sn_op1_0900_rl_s1_r10k_dp000p0_0 rwls_op1_0900_rl_s1_r10k_dp000p0 0 sky130_fd_pr__nfet_01v8 L=0.15 W=0.42 nf=1 ad=0.1218 as=0.1218 pd=1.42 ps=1.42 nrd=0.69047619047619  nrs=0.69047619047619 sa=0 sb=0 sd=0 mult=1 m=1
csn_op1_0900_rl_s1_r10k_dp000p0_0 sn_op1_0900_rl_s1_r10k_dp000p0_0 0 {C_SN}
XMWR_op1_0900_rl_s1_r10k_dp000p0_1 sn_op1_0900_rl_s1_r10k_dp000p0_1 wwl_des wbl_op1_0900_rl_s1_r10k_dp000p0 0 sky130_fd_pr__nfet_01v8 L=0.15 W=0.42 nf=1 ad=0.1218 as=0.1218 pd=1.42 ps=1.42 nrd=0.69047619047619  nrs=0.69047619047619 sa=0 sb=0 sd=0 mult=1 m=1
XMRD_op1_0900_rl_s1_r10k_dp000p0_1 rbl_op1_0900_rl_s1_r10k_dp000p0 sn_op1_0900_rl_s1_r10k_dp000p0_1 rwl_des 0 sky130_fd_pr__nfet_01v8 L=0.15 W=0.42 nf=1 ad=0.1218 as=0.1218 pd=1.42 ps=1.42 nrd=0.69047619047619  nrs=0.69047619047619 sa=0 sb=0 sd=0 mult=1 m=1
csn_op1_0900_rl_s1_r10k_dp000p0_1 sn_op1_0900_rl_s1_r10k_dp000p0_1 0 {C_SN}
XMWR_op1_0900_rl_s1_r10k_dp000p0_2 sn_op1_0900_rl_s1_r10k_dp000p0_2 wwl_des wbl_op1_0900_rl_s1_r10k_dp000p0 0 sky130_fd_pr__nfet_01v8 L=0.15 W=0.42 nf=1 ad=0.1218 as=0.1218 pd=1.42 ps=1.42 nrd=0.69047619047619  nrs=0.69047619047619 sa=0 sb=0 sd=0 mult=1 m=1
XMRD_op1_0900_rl_s1_r10k_dp000p0_2 rbl_op1_0900_rl_s1_r10k_dp000p0 sn_op1_0900_rl_s1_r10k_dp000p0_2 rwl_des 0 sky130_fd_pr__nfet_01v8 L=0.15 W=0.42 nf=1 ad=0.1218 as=0.1218 pd=1.42 ps=1.42 nrd=0.69047619047619  nrs=0.69047619047619 sa=0 sb=0 sd=0 mult=1 m=1
csn_op1_0900_rl_s1_r10k_dp000p0_2 sn_op1_0900_rl_s1_r10k_dp000p0_2 0 {C_SN}
XMWR_op1_0900_rl_s1_r10k_dp000p0_3 sn_op1_0900_rl_s1_r10k_dp000p0_3 wwl_des wbl_op1_0900_rl_s1_r10k_dp000p0 0 sky130_fd_pr__nfet_01v8 L=0.15 W=0.42 nf=1 ad=0.1218 as=0.1218 pd=1.42 ps=1.42 nrd=0.69047619047619  nrs=0.69047619047619 sa=0 sb=0 sd=0 mult=1 m=1
XMRD_op1_0900_rl_s1_r10k_dp000p0_3 rbl_op1_0900_rl_s1_r10k_dp000p0 sn_op1_0900_rl_s1_r10k_dp000p0_3 rwl_des 0 sky130_fd_pr__nfet_01v8 L=0.15 W=0.42 nf=1 ad=0.1218 as=0.1218 pd=1.42 ps=1.42 nrd=0.69047619047619  nrs=0.69047619047619 sa=0 sb=0 sd=0 mult=1 m=1
csn_op1_0900_rl_s1_r10k_dp000p0_3 sn_op1_0900_rl_s1_r10k_dp000p0_3 0 {C_SN}
XMN1_op1_0900_rl_s1_r10k_dp000p0 rbl_op1_0900_rl_s1_r10k_dp000p0 ref_op1_0900_rl_s1_r10k_dp000p0 vn_op1_0900_rl_s1_r10k_dp000p0 0 sky130_fd_pr__nfet_01v8 L=0.15 W=1 nf=1 ad=0.29 as=0.29 pd=2.58 ps=2.58 mult=1 m=1
XMN2_op1_0900_rl_s1_r10k_dp000p0 ref_op1_0900_rl_s1_r10k_dp000p0 rbl_op1_0900_rl_s1_r10k_dp000p0 vn_op1_0900_rl_s1_r10k_dp000p0 0 sky130_fd_pr__nfet_01v8 L=0.15 W=1 nf=1 ad=0.29 as=0.29 pd=2.58 ps=2.58 mult=1 m=1
XMP1_op1_0900_rl_s1_r10k_dp000p0 rbl_op1_0900_rl_s1_r10k_dp000p0 ref_op1_0900_rl_s1_r10k_dp000p0 vp_op1_0900_rl_s1_r10k_dp000p0 vdd sky130_fd_pr__pfet_01v8 L=0.15 W=2 nf=1 ad=0.58 as=0.58 pd=4.58 ps=4.58 mult=1 m=1
XMP2_op1_0900_rl_s1_r10k_dp000p0 ref_op1_0900_rl_s1_r10k_dp000p0 rbl_op1_0900_rl_s1_r10k_dp000p0 vp_op1_0900_rl_s1_r10k_dp000p0 vdd sky130_fd_pr__pfet_01v8 L=0.15 W=2 nf=1 ad=0.58 as=0.58 pd=4.58 ps=4.58 mult=1 m=1
XMNF_op1_0900_rl_s1_r10k_dp000p0 vn_op1_0900_rl_s1_r10k_dp000p0 en_op1_0900_rl_s1_r10k_dp000p0 0 0 sky130_fd_pr__nfet_01v8 L=0.15 W=2 nf=1 ad=0.58 as=0.58 pd=4.58 ps=4.58 mult=1 m=1
XMPH_op1_0900_rl_s1_r10k_dp000p0 vp_op1_0900_rl_s1_r10k_dp000p0 enb_op1_0900_rl_s1_r10k_dp000p0 vdd vdd sky130_fd_pr__pfet_01v8 L=0.15 W=4 nf=1 ad=1.16 as=1.16 pd=8.58 ps=8.58 mult=1 m=1
bd_op1_0900_rl_s1_r10k_dp000p0 d_op1_0900_rl_s1_r10k_dp000p0 0 v=v(rbl_op1_0900_rl_s1_r10k_dp000p0)-v(ref_op1_0900_rl_s1_r10k_dp000p0)

* ---- instance 270: op1_1000_rl_s1_r10k_dp000p0 (variant rl_s1_r10k_dp000p0; probe dec 11.9 ns, release 34 ns, meas 36 ns) ----
vctl_op1_1000_rl_s1_r10k_dp000p0 ctl_op1_1000_rl_s1_r10k_dp000p0 0 pwl(0.0000e+00 {VDD} 2.0000e-09 {VDD} 2.1000e-09 0)
* RWL driver model (EXPERIMENTAL): slew 1 ns, series R 10000 ohm; cell pin = rwls_op1_1000_rl_s1_r10k_dp000p0
vrs_op1_1000_rl_s1_r10k_dp000p0 rwlsrc_op1_1000_rl_s1_r10k_dp000p0 0 pwl(0.0000e+00 {VDD} 2.0000e-09 {VDD} 3.0000e-09 0 3.2000e-08 0 3.3000e-08 {VDD})
rdrv_op1_1000_rl_s1_r10k_dp000p0 rwlsrc_op1_1000_rl_s1_r10k_dp000p0 rwls_op1_1000_rl_s1_r10k_dp000p0 10000
ven_op1_1000_rl_s1_r10k_dp000p0 en_op1_1000_rl_s1_r10k_dp000p0 0 pwl(0.0000e+00 0 1.1000e-08 0 1.1100e-08 {VDD} 3.4000e-08 {VDD} 3.4100e-08 0)
venb_op1_1000_rl_s1_r10k_dp000p0 enb_op1_1000_rl_s1_r10k_dp000p0 0 pwl(0.0000e+00 {VDD} 1.1000e-08 {VDD} 1.1100e-08 0 3.4000e-08 0 3.4100e-08 {VDD})
vww_op1_1000_rl_s1_r10k_dp000p0 wwl_op1_1000_rl_s1_r10k_dp000p0 0 pwl(0.0000e+00 0 1.2000e-08 0 1.2100e-08 {VDD} 3.2000e-08 {VDD} 3.2100e-08 0)
vwc_op1_1000_rl_s1_r10k_dp000p0 wbc_op1_1000_rl_s1_r10k_dp000p0 0 pwl(0.0000e+00 0 1.2000e-08 0 1.2100e-08 {VDD} 3.4000e-08 {VDD} 3.4100e-08 0)
swb_op1_1000_rl_s1_r10k_dp000p0 ref_op1_1000_rl_s1_r10k_dp000p0 wbl_op1_1000_rl_s1_r10k_dp000p0 wbc_op1_1000_rl_s1_r10k_dp000p0 0 swwbl
cwbl_op1_1000_rl_s1_r10k_dp000p0 wbl_op1_1000_rl_s1_r10k_dp000p0 0 {C_WBL}
spa_op1_1000_rl_s1_r10k_dp000p0 prea rbl_op1_1000_rl_s1_r10k_dp000p0 ctl_op1_1000_rl_s1_r10k_dp000p0 0 swpre
spr_op1_1000_rl_s1_r10k_dp000p0 pref ref_op1_1000_rl_s1_r10k_dp000p0 ctl_op1_1000_rl_s1_r10k_dp000p0 0 swpre
crbl_op1_1000_rl_s1_r10k_dp000p0 rbl_op1_1000_rl_s1_r10k_dp000p0 0 {C_RBL}
cref_op1_1000_rl_s1_r10k_dp000p0 ref_op1_1000_rl_s1_r10k_dp000p0 0 {C_RBL}   $ ASSUMPTION: ideal matched dummy load
XMWR_op1_1000_rl_s1_r10k_dp000p0_0 sn_op1_1000_rl_s1_r10k_dp000p0_0 wwl_op1_1000_rl_s1_r10k_dp000p0 wbl_op1_1000_rl_s1_r10k_dp000p0 0 sky130_fd_pr__nfet_01v8 L=0.15 W=0.42 nf=1 ad=0.1218 as=0.1218 pd=1.42 ps=1.42 nrd=0.69047619047619  nrs=0.69047619047619 sa=0 sb=0 sd=0 mult=1 m=1
XMRD_op1_1000_rl_s1_r10k_dp000p0_0 rbl_op1_1000_rl_s1_r10k_dp000p0 sn_op1_1000_rl_s1_r10k_dp000p0_0 rwls_op1_1000_rl_s1_r10k_dp000p0 0 sky130_fd_pr__nfet_01v8 L=0.15 W=0.42 nf=1 ad=0.1218 as=0.1218 pd=1.42 ps=1.42 nrd=0.69047619047619  nrs=0.69047619047619 sa=0 sb=0 sd=0 mult=1 m=1
csn_op1_1000_rl_s1_r10k_dp000p0_0 sn_op1_1000_rl_s1_r10k_dp000p0_0 0 {C_SN}
XMWR_op1_1000_rl_s1_r10k_dp000p0_1 sn_op1_1000_rl_s1_r10k_dp000p0_1 wwl_des wbl_op1_1000_rl_s1_r10k_dp000p0 0 sky130_fd_pr__nfet_01v8 L=0.15 W=0.42 nf=1 ad=0.1218 as=0.1218 pd=1.42 ps=1.42 nrd=0.69047619047619  nrs=0.69047619047619 sa=0 sb=0 sd=0 mult=1 m=1
XMRD_op1_1000_rl_s1_r10k_dp000p0_1 rbl_op1_1000_rl_s1_r10k_dp000p0 sn_op1_1000_rl_s1_r10k_dp000p0_1 rwl_des 0 sky130_fd_pr__nfet_01v8 L=0.15 W=0.42 nf=1 ad=0.1218 as=0.1218 pd=1.42 ps=1.42 nrd=0.69047619047619  nrs=0.69047619047619 sa=0 sb=0 sd=0 mult=1 m=1
csn_op1_1000_rl_s1_r10k_dp000p0_1 sn_op1_1000_rl_s1_r10k_dp000p0_1 0 {C_SN}
XMWR_op1_1000_rl_s1_r10k_dp000p0_2 sn_op1_1000_rl_s1_r10k_dp000p0_2 wwl_des wbl_op1_1000_rl_s1_r10k_dp000p0 0 sky130_fd_pr__nfet_01v8 L=0.15 W=0.42 nf=1 ad=0.1218 as=0.1218 pd=1.42 ps=1.42 nrd=0.69047619047619  nrs=0.69047619047619 sa=0 sb=0 sd=0 mult=1 m=1
XMRD_op1_1000_rl_s1_r10k_dp000p0_2 rbl_op1_1000_rl_s1_r10k_dp000p0 sn_op1_1000_rl_s1_r10k_dp000p0_2 rwl_des 0 sky130_fd_pr__nfet_01v8 L=0.15 W=0.42 nf=1 ad=0.1218 as=0.1218 pd=1.42 ps=1.42 nrd=0.69047619047619  nrs=0.69047619047619 sa=0 sb=0 sd=0 mult=1 m=1
csn_op1_1000_rl_s1_r10k_dp000p0_2 sn_op1_1000_rl_s1_r10k_dp000p0_2 0 {C_SN}
XMWR_op1_1000_rl_s1_r10k_dp000p0_3 sn_op1_1000_rl_s1_r10k_dp000p0_3 wwl_des wbl_op1_1000_rl_s1_r10k_dp000p0 0 sky130_fd_pr__nfet_01v8 L=0.15 W=0.42 nf=1 ad=0.1218 as=0.1218 pd=1.42 ps=1.42 nrd=0.69047619047619  nrs=0.69047619047619 sa=0 sb=0 sd=0 mult=1 m=1
XMRD_op1_1000_rl_s1_r10k_dp000p0_3 rbl_op1_1000_rl_s1_r10k_dp000p0 sn_op1_1000_rl_s1_r10k_dp000p0_3 rwl_des 0 sky130_fd_pr__nfet_01v8 L=0.15 W=0.42 nf=1 ad=0.1218 as=0.1218 pd=1.42 ps=1.42 nrd=0.69047619047619  nrs=0.69047619047619 sa=0 sb=0 sd=0 mult=1 m=1
csn_op1_1000_rl_s1_r10k_dp000p0_3 sn_op1_1000_rl_s1_r10k_dp000p0_3 0 {C_SN}
XMN1_op1_1000_rl_s1_r10k_dp000p0 rbl_op1_1000_rl_s1_r10k_dp000p0 ref_op1_1000_rl_s1_r10k_dp000p0 vn_op1_1000_rl_s1_r10k_dp000p0 0 sky130_fd_pr__nfet_01v8 L=0.15 W=1 nf=1 ad=0.29 as=0.29 pd=2.58 ps=2.58 mult=1 m=1
XMN2_op1_1000_rl_s1_r10k_dp000p0 ref_op1_1000_rl_s1_r10k_dp000p0 rbl_op1_1000_rl_s1_r10k_dp000p0 vn_op1_1000_rl_s1_r10k_dp000p0 0 sky130_fd_pr__nfet_01v8 L=0.15 W=1 nf=1 ad=0.29 as=0.29 pd=2.58 ps=2.58 mult=1 m=1
XMP1_op1_1000_rl_s1_r10k_dp000p0 rbl_op1_1000_rl_s1_r10k_dp000p0 ref_op1_1000_rl_s1_r10k_dp000p0 vp_op1_1000_rl_s1_r10k_dp000p0 vdd sky130_fd_pr__pfet_01v8 L=0.15 W=2 nf=1 ad=0.58 as=0.58 pd=4.58 ps=4.58 mult=1 m=1
XMP2_op1_1000_rl_s1_r10k_dp000p0 ref_op1_1000_rl_s1_r10k_dp000p0 rbl_op1_1000_rl_s1_r10k_dp000p0 vp_op1_1000_rl_s1_r10k_dp000p0 vdd sky130_fd_pr__pfet_01v8 L=0.15 W=2 nf=1 ad=0.58 as=0.58 pd=4.58 ps=4.58 mult=1 m=1
XMNF_op1_1000_rl_s1_r10k_dp000p0 vn_op1_1000_rl_s1_r10k_dp000p0 en_op1_1000_rl_s1_r10k_dp000p0 0 0 sky130_fd_pr__nfet_01v8 L=0.15 W=2 nf=1 ad=0.58 as=0.58 pd=4.58 ps=4.58 mult=1 m=1
XMPH_op1_1000_rl_s1_r10k_dp000p0 vp_op1_1000_rl_s1_r10k_dp000p0 enb_op1_1000_rl_s1_r10k_dp000p0 vdd vdd sky130_fd_pr__pfet_01v8 L=0.15 W=4 nf=1 ad=1.16 as=1.16 pd=8.58 ps=8.58 mult=1 m=1
bd_op1_1000_rl_s1_r10k_dp000p0 d_op1_1000_rl_s1_r10k_dp000p0 0 v=v(rbl_op1_1000_rl_s1_r10k_dp000p0)-v(ref_op1_1000_rl_s1_r10k_dp000p0)

* ---- instance 271: op0_n100_rl_s1_r10k_dp000p0 (variant rl_s1_r10k_dp000p0; probe dec 11.9 ns, release 34 ns, meas 36 ns) ----
vctl_op0_n100_rl_s1_r10k_dp000p0 ctl_op0_n100_rl_s1_r10k_dp000p0 0 pwl(0.0000e+00 {VDD} 2.0000e-09 {VDD} 2.1000e-09 0)
* RWL driver model (EXPERIMENTAL): slew 1 ns, series R 10000 ohm; cell pin = rwls_op0_n100_rl_s1_r10k_dp000p0
vrs_op0_n100_rl_s1_r10k_dp000p0 rwlsrc_op0_n100_rl_s1_r10k_dp000p0 0 pwl(0.0000e+00 {VDD} 2.0000e-09 {VDD} 3.0000e-09 0 3.2000e-08 0 3.3000e-08 {VDD})
rdrv_op0_n100_rl_s1_r10k_dp000p0 rwlsrc_op0_n100_rl_s1_r10k_dp000p0 rwls_op0_n100_rl_s1_r10k_dp000p0 10000
ven_op0_n100_rl_s1_r10k_dp000p0 en_op0_n100_rl_s1_r10k_dp000p0 0 pwl(0.0000e+00 0 1.1000e-08 0 1.1100e-08 {VDD} 3.4000e-08 {VDD} 3.4100e-08 0)
venb_op0_n100_rl_s1_r10k_dp000p0 enb_op0_n100_rl_s1_r10k_dp000p0 0 pwl(0.0000e+00 {VDD} 1.1000e-08 {VDD} 1.1100e-08 0 3.4000e-08 0 3.4100e-08 {VDD})
vww_op0_n100_rl_s1_r10k_dp000p0 wwl_op0_n100_rl_s1_r10k_dp000p0 0 pwl(0.0000e+00 0 1.2000e-08 0 1.2100e-08 {VDD} 3.2000e-08 {VDD} 3.2100e-08 0)
vwc_op0_n100_rl_s1_r10k_dp000p0 wbc_op0_n100_rl_s1_r10k_dp000p0 0 pwl(0.0000e+00 0 1.2000e-08 0 1.2100e-08 {VDD} 3.4000e-08 {VDD} 3.4100e-08 0)
swb_op0_n100_rl_s1_r10k_dp000p0 ref_op0_n100_rl_s1_r10k_dp000p0 wbl_op0_n100_rl_s1_r10k_dp000p0 wbc_op0_n100_rl_s1_r10k_dp000p0 0 swwbl
cwbl_op0_n100_rl_s1_r10k_dp000p0 wbl_op0_n100_rl_s1_r10k_dp000p0 0 {C_WBL}
spa_op0_n100_rl_s1_r10k_dp000p0 prea rbl_op0_n100_rl_s1_r10k_dp000p0 ctl_op0_n100_rl_s1_r10k_dp000p0 0 swpre
spr_op0_n100_rl_s1_r10k_dp000p0 pref ref_op0_n100_rl_s1_r10k_dp000p0 ctl_op0_n100_rl_s1_r10k_dp000p0 0 swpre
crbl_op0_n100_rl_s1_r10k_dp000p0 rbl_op0_n100_rl_s1_r10k_dp000p0 0 {C_RBL}
cref_op0_n100_rl_s1_r10k_dp000p0 ref_op0_n100_rl_s1_r10k_dp000p0 0 {C_RBL}   $ ASSUMPTION: ideal matched dummy load
XMWR_op0_n100_rl_s1_r10k_dp000p0_0 sn_op0_n100_rl_s1_r10k_dp000p0_0 wwl_op0_n100_rl_s1_r10k_dp000p0 wbl_op0_n100_rl_s1_r10k_dp000p0 0 sky130_fd_pr__nfet_01v8 L=0.15 W=0.42 nf=1 ad=0.1218 as=0.1218 pd=1.42 ps=1.42 nrd=0.69047619047619  nrs=0.69047619047619 sa=0 sb=0 sd=0 mult=1 m=1
XMRD_op0_n100_rl_s1_r10k_dp000p0_0 rbl_op0_n100_rl_s1_r10k_dp000p0 sn_op0_n100_rl_s1_r10k_dp000p0_0 rwls_op0_n100_rl_s1_r10k_dp000p0 0 sky130_fd_pr__nfet_01v8 L=0.15 W=0.42 nf=1 ad=0.1218 as=0.1218 pd=1.42 ps=1.42 nrd=0.69047619047619  nrs=0.69047619047619 sa=0 sb=0 sd=0 mult=1 m=1
csn_op0_n100_rl_s1_r10k_dp000p0_0 sn_op0_n100_rl_s1_r10k_dp000p0_0 0 {C_SN}
XMWR_op0_n100_rl_s1_r10k_dp000p0_1 sn_op0_n100_rl_s1_r10k_dp000p0_1 wwl_des wbl_op0_n100_rl_s1_r10k_dp000p0 0 sky130_fd_pr__nfet_01v8 L=0.15 W=0.42 nf=1 ad=0.1218 as=0.1218 pd=1.42 ps=1.42 nrd=0.69047619047619  nrs=0.69047619047619 sa=0 sb=0 sd=0 mult=1 m=1
XMRD_op0_n100_rl_s1_r10k_dp000p0_1 rbl_op0_n100_rl_s1_r10k_dp000p0 sn_op0_n100_rl_s1_r10k_dp000p0_1 rwl_des 0 sky130_fd_pr__nfet_01v8 L=0.15 W=0.42 nf=1 ad=0.1218 as=0.1218 pd=1.42 ps=1.42 nrd=0.69047619047619  nrs=0.69047619047619 sa=0 sb=0 sd=0 mult=1 m=1
csn_op0_n100_rl_s1_r10k_dp000p0_1 sn_op0_n100_rl_s1_r10k_dp000p0_1 0 {C_SN}
XMWR_op0_n100_rl_s1_r10k_dp000p0_2 sn_op0_n100_rl_s1_r10k_dp000p0_2 wwl_des wbl_op0_n100_rl_s1_r10k_dp000p0 0 sky130_fd_pr__nfet_01v8 L=0.15 W=0.42 nf=1 ad=0.1218 as=0.1218 pd=1.42 ps=1.42 nrd=0.69047619047619  nrs=0.69047619047619 sa=0 sb=0 sd=0 mult=1 m=1
XMRD_op0_n100_rl_s1_r10k_dp000p0_2 rbl_op0_n100_rl_s1_r10k_dp000p0 sn_op0_n100_rl_s1_r10k_dp000p0_2 rwl_des 0 sky130_fd_pr__nfet_01v8 L=0.15 W=0.42 nf=1 ad=0.1218 as=0.1218 pd=1.42 ps=1.42 nrd=0.69047619047619  nrs=0.69047619047619 sa=0 sb=0 sd=0 mult=1 m=1
csn_op0_n100_rl_s1_r10k_dp000p0_2 sn_op0_n100_rl_s1_r10k_dp000p0_2 0 {C_SN}
XMWR_op0_n100_rl_s1_r10k_dp000p0_3 sn_op0_n100_rl_s1_r10k_dp000p0_3 wwl_des wbl_op0_n100_rl_s1_r10k_dp000p0 0 sky130_fd_pr__nfet_01v8 L=0.15 W=0.42 nf=1 ad=0.1218 as=0.1218 pd=1.42 ps=1.42 nrd=0.69047619047619  nrs=0.69047619047619 sa=0 sb=0 sd=0 mult=1 m=1
XMRD_op0_n100_rl_s1_r10k_dp000p0_3 rbl_op0_n100_rl_s1_r10k_dp000p0 sn_op0_n100_rl_s1_r10k_dp000p0_3 rwl_des 0 sky130_fd_pr__nfet_01v8 L=0.15 W=0.42 nf=1 ad=0.1218 as=0.1218 pd=1.42 ps=1.42 nrd=0.69047619047619  nrs=0.69047619047619 sa=0 sb=0 sd=0 mult=1 m=1
csn_op0_n100_rl_s1_r10k_dp000p0_3 sn_op0_n100_rl_s1_r10k_dp000p0_3 0 {C_SN}
XMN1_op0_n100_rl_s1_r10k_dp000p0 rbl_op0_n100_rl_s1_r10k_dp000p0 ref_op0_n100_rl_s1_r10k_dp000p0 vn_op0_n100_rl_s1_r10k_dp000p0 0 sky130_fd_pr__nfet_01v8 L=0.15 W=1 nf=1 ad=0.29 as=0.29 pd=2.58 ps=2.58 mult=1 m=1
XMN2_op0_n100_rl_s1_r10k_dp000p0 ref_op0_n100_rl_s1_r10k_dp000p0 rbl_op0_n100_rl_s1_r10k_dp000p0 vn_op0_n100_rl_s1_r10k_dp000p0 0 sky130_fd_pr__nfet_01v8 L=0.15 W=1 nf=1 ad=0.29 as=0.29 pd=2.58 ps=2.58 mult=1 m=1
XMP1_op0_n100_rl_s1_r10k_dp000p0 rbl_op0_n100_rl_s1_r10k_dp000p0 ref_op0_n100_rl_s1_r10k_dp000p0 vp_op0_n100_rl_s1_r10k_dp000p0 vdd sky130_fd_pr__pfet_01v8 L=0.15 W=2 nf=1 ad=0.58 as=0.58 pd=4.58 ps=4.58 mult=1 m=1
XMP2_op0_n100_rl_s1_r10k_dp000p0 ref_op0_n100_rl_s1_r10k_dp000p0 rbl_op0_n100_rl_s1_r10k_dp000p0 vp_op0_n100_rl_s1_r10k_dp000p0 vdd sky130_fd_pr__pfet_01v8 L=0.15 W=2 nf=1 ad=0.58 as=0.58 pd=4.58 ps=4.58 mult=1 m=1
XMNF_op0_n100_rl_s1_r10k_dp000p0 vn_op0_n100_rl_s1_r10k_dp000p0 en_op0_n100_rl_s1_r10k_dp000p0 0 0 sky130_fd_pr__nfet_01v8 L=0.15 W=2 nf=1 ad=0.58 as=0.58 pd=4.58 ps=4.58 mult=1 m=1
XMPH_op0_n100_rl_s1_r10k_dp000p0 vp_op0_n100_rl_s1_r10k_dp000p0 enb_op0_n100_rl_s1_r10k_dp000p0 vdd vdd sky130_fd_pr__pfet_01v8 L=0.15 W=4 nf=1 ad=1.16 as=1.16 pd=8.58 ps=8.58 mult=1 m=1
bd_op0_n100_rl_s1_r10k_dp000p0 d_op0_n100_rl_s1_r10k_dp000p0 0 v=v(rbl_op0_n100_rl_s1_r10k_dp000p0)-v(ref_op0_n100_rl_s1_r10k_dp000p0)

* ---- instance 272: op0_0000_rl_s1_r10k_dp000p0 (variant rl_s1_r10k_dp000p0; probe dec 11.9 ns, release 34 ns, meas 36 ns) ----
vctl_op0_0000_rl_s1_r10k_dp000p0 ctl_op0_0000_rl_s1_r10k_dp000p0 0 pwl(0.0000e+00 {VDD} 2.0000e-09 {VDD} 2.1000e-09 0)
* RWL driver model (EXPERIMENTAL): slew 1 ns, series R 10000 ohm; cell pin = rwls_op0_0000_rl_s1_r10k_dp000p0
vrs_op0_0000_rl_s1_r10k_dp000p0 rwlsrc_op0_0000_rl_s1_r10k_dp000p0 0 pwl(0.0000e+00 {VDD} 2.0000e-09 {VDD} 3.0000e-09 0 3.2000e-08 0 3.3000e-08 {VDD})
rdrv_op0_0000_rl_s1_r10k_dp000p0 rwlsrc_op0_0000_rl_s1_r10k_dp000p0 rwls_op0_0000_rl_s1_r10k_dp000p0 10000
ven_op0_0000_rl_s1_r10k_dp000p0 en_op0_0000_rl_s1_r10k_dp000p0 0 pwl(0.0000e+00 0 1.1000e-08 0 1.1100e-08 {VDD} 3.4000e-08 {VDD} 3.4100e-08 0)
venb_op0_0000_rl_s1_r10k_dp000p0 enb_op0_0000_rl_s1_r10k_dp000p0 0 pwl(0.0000e+00 {VDD} 1.1000e-08 {VDD} 1.1100e-08 0 3.4000e-08 0 3.4100e-08 {VDD})
vww_op0_0000_rl_s1_r10k_dp000p0 wwl_op0_0000_rl_s1_r10k_dp000p0 0 pwl(0.0000e+00 0 1.2000e-08 0 1.2100e-08 {VDD} 3.2000e-08 {VDD} 3.2100e-08 0)
vwc_op0_0000_rl_s1_r10k_dp000p0 wbc_op0_0000_rl_s1_r10k_dp000p0 0 pwl(0.0000e+00 0 1.2000e-08 0 1.2100e-08 {VDD} 3.4000e-08 {VDD} 3.4100e-08 0)
swb_op0_0000_rl_s1_r10k_dp000p0 ref_op0_0000_rl_s1_r10k_dp000p0 wbl_op0_0000_rl_s1_r10k_dp000p0 wbc_op0_0000_rl_s1_r10k_dp000p0 0 swwbl
cwbl_op0_0000_rl_s1_r10k_dp000p0 wbl_op0_0000_rl_s1_r10k_dp000p0 0 {C_WBL}
spa_op0_0000_rl_s1_r10k_dp000p0 prea rbl_op0_0000_rl_s1_r10k_dp000p0 ctl_op0_0000_rl_s1_r10k_dp000p0 0 swpre
spr_op0_0000_rl_s1_r10k_dp000p0 pref ref_op0_0000_rl_s1_r10k_dp000p0 ctl_op0_0000_rl_s1_r10k_dp000p0 0 swpre
crbl_op0_0000_rl_s1_r10k_dp000p0 rbl_op0_0000_rl_s1_r10k_dp000p0 0 {C_RBL}
cref_op0_0000_rl_s1_r10k_dp000p0 ref_op0_0000_rl_s1_r10k_dp000p0 0 {C_RBL}   $ ASSUMPTION: ideal matched dummy load
XMWR_op0_0000_rl_s1_r10k_dp000p0_0 sn_op0_0000_rl_s1_r10k_dp000p0_0 wwl_op0_0000_rl_s1_r10k_dp000p0 wbl_op0_0000_rl_s1_r10k_dp000p0 0 sky130_fd_pr__nfet_01v8 L=0.15 W=0.42 nf=1 ad=0.1218 as=0.1218 pd=1.42 ps=1.42 nrd=0.69047619047619  nrs=0.69047619047619 sa=0 sb=0 sd=0 mult=1 m=1
XMRD_op0_0000_rl_s1_r10k_dp000p0_0 rbl_op0_0000_rl_s1_r10k_dp000p0 sn_op0_0000_rl_s1_r10k_dp000p0_0 rwls_op0_0000_rl_s1_r10k_dp000p0 0 sky130_fd_pr__nfet_01v8 L=0.15 W=0.42 nf=1 ad=0.1218 as=0.1218 pd=1.42 ps=1.42 nrd=0.69047619047619  nrs=0.69047619047619 sa=0 sb=0 sd=0 mult=1 m=1
csn_op0_0000_rl_s1_r10k_dp000p0_0 sn_op0_0000_rl_s1_r10k_dp000p0_0 0 {C_SN}
XMWR_op0_0000_rl_s1_r10k_dp000p0_1 sn_op0_0000_rl_s1_r10k_dp000p0_1 wwl_des wbl_op0_0000_rl_s1_r10k_dp000p0 0 sky130_fd_pr__nfet_01v8 L=0.15 W=0.42 nf=1 ad=0.1218 as=0.1218 pd=1.42 ps=1.42 nrd=0.69047619047619  nrs=0.69047619047619 sa=0 sb=0 sd=0 mult=1 m=1
XMRD_op0_0000_rl_s1_r10k_dp000p0_1 rbl_op0_0000_rl_s1_r10k_dp000p0 sn_op0_0000_rl_s1_r10k_dp000p0_1 rwl_des 0 sky130_fd_pr__nfet_01v8 L=0.15 W=0.42 nf=1 ad=0.1218 as=0.1218 pd=1.42 ps=1.42 nrd=0.69047619047619  nrs=0.69047619047619 sa=0 sb=0 sd=0 mult=1 m=1
csn_op0_0000_rl_s1_r10k_dp000p0_1 sn_op0_0000_rl_s1_r10k_dp000p0_1 0 {C_SN}
XMWR_op0_0000_rl_s1_r10k_dp000p0_2 sn_op0_0000_rl_s1_r10k_dp000p0_2 wwl_des wbl_op0_0000_rl_s1_r10k_dp000p0 0 sky130_fd_pr__nfet_01v8 L=0.15 W=0.42 nf=1 ad=0.1218 as=0.1218 pd=1.42 ps=1.42 nrd=0.69047619047619  nrs=0.69047619047619 sa=0 sb=0 sd=0 mult=1 m=1
XMRD_op0_0000_rl_s1_r10k_dp000p0_2 rbl_op0_0000_rl_s1_r10k_dp000p0 sn_op0_0000_rl_s1_r10k_dp000p0_2 rwl_des 0 sky130_fd_pr__nfet_01v8 L=0.15 W=0.42 nf=1 ad=0.1218 as=0.1218 pd=1.42 ps=1.42 nrd=0.69047619047619  nrs=0.69047619047619 sa=0 sb=0 sd=0 mult=1 m=1
csn_op0_0000_rl_s1_r10k_dp000p0_2 sn_op0_0000_rl_s1_r10k_dp000p0_2 0 {C_SN}
XMWR_op0_0000_rl_s1_r10k_dp000p0_3 sn_op0_0000_rl_s1_r10k_dp000p0_3 wwl_des wbl_op0_0000_rl_s1_r10k_dp000p0 0 sky130_fd_pr__nfet_01v8 L=0.15 W=0.42 nf=1 ad=0.1218 as=0.1218 pd=1.42 ps=1.42 nrd=0.69047619047619  nrs=0.69047619047619 sa=0 sb=0 sd=0 mult=1 m=1
XMRD_op0_0000_rl_s1_r10k_dp000p0_3 rbl_op0_0000_rl_s1_r10k_dp000p0 sn_op0_0000_rl_s1_r10k_dp000p0_3 rwl_des 0 sky130_fd_pr__nfet_01v8 L=0.15 W=0.42 nf=1 ad=0.1218 as=0.1218 pd=1.42 ps=1.42 nrd=0.69047619047619  nrs=0.69047619047619 sa=0 sb=0 sd=0 mult=1 m=1
csn_op0_0000_rl_s1_r10k_dp000p0_3 sn_op0_0000_rl_s1_r10k_dp000p0_3 0 {C_SN}
XMN1_op0_0000_rl_s1_r10k_dp000p0 rbl_op0_0000_rl_s1_r10k_dp000p0 ref_op0_0000_rl_s1_r10k_dp000p0 vn_op0_0000_rl_s1_r10k_dp000p0 0 sky130_fd_pr__nfet_01v8 L=0.15 W=1 nf=1 ad=0.29 as=0.29 pd=2.58 ps=2.58 mult=1 m=1
XMN2_op0_0000_rl_s1_r10k_dp000p0 ref_op0_0000_rl_s1_r10k_dp000p0 rbl_op0_0000_rl_s1_r10k_dp000p0 vn_op0_0000_rl_s1_r10k_dp000p0 0 sky130_fd_pr__nfet_01v8 L=0.15 W=1 nf=1 ad=0.29 as=0.29 pd=2.58 ps=2.58 mult=1 m=1
XMP1_op0_0000_rl_s1_r10k_dp000p0 rbl_op0_0000_rl_s1_r10k_dp000p0 ref_op0_0000_rl_s1_r10k_dp000p0 vp_op0_0000_rl_s1_r10k_dp000p0 vdd sky130_fd_pr__pfet_01v8 L=0.15 W=2 nf=1 ad=0.58 as=0.58 pd=4.58 ps=4.58 mult=1 m=1
XMP2_op0_0000_rl_s1_r10k_dp000p0 ref_op0_0000_rl_s1_r10k_dp000p0 rbl_op0_0000_rl_s1_r10k_dp000p0 vp_op0_0000_rl_s1_r10k_dp000p0 vdd sky130_fd_pr__pfet_01v8 L=0.15 W=2 nf=1 ad=0.58 as=0.58 pd=4.58 ps=4.58 mult=1 m=1
XMNF_op0_0000_rl_s1_r10k_dp000p0 vn_op0_0000_rl_s1_r10k_dp000p0 en_op0_0000_rl_s1_r10k_dp000p0 0 0 sky130_fd_pr__nfet_01v8 L=0.15 W=2 nf=1 ad=0.58 as=0.58 pd=4.58 ps=4.58 mult=1 m=1
XMPH_op0_0000_rl_s1_r10k_dp000p0 vp_op0_0000_rl_s1_r10k_dp000p0 enb_op0_0000_rl_s1_r10k_dp000p0 vdd vdd sky130_fd_pr__pfet_01v8 L=0.15 W=4 nf=1 ad=1.16 as=1.16 pd=8.58 ps=8.58 mult=1 m=1
bd_op0_0000_rl_s1_r10k_dp000p0 d_op0_0000_rl_s1_r10k_dp000p0 0 v=v(rbl_op0_0000_rl_s1_r10k_dp000p0)-v(ref_op0_0000_rl_s1_r10k_dp000p0)

* ---- instance 273: op1_0900_rl_s1_r10k_dp001p0 (variant rl_s1_r10k_dp001p0; probe dec 11.9 ns, release 34 ns, meas 36 ns) ----
vctl_op1_0900_rl_s1_r10k_dp001p0 ctl_op1_0900_rl_s1_r10k_dp001p0 0 pwl(0.0000e+00 {VDD} 2.0000e-09 {VDD} 2.1000e-09 0)
* RWL driver model (EXPERIMENTAL): slew 1 ns, series R 10000 ohm; cell pin = rwls_op1_0900_rl_s1_r10k_dp001p0
vrs_op1_0900_rl_s1_r10k_dp001p0 rwlsrc_op1_0900_rl_s1_r10k_dp001p0 0 pwl(0.0000e+00 {VDD} 2.0000e-09 {VDD} 3.0000e-09 0 3.3000e-08 0 3.4000e-08 {VDD})
rdrv_op1_0900_rl_s1_r10k_dp001p0 rwlsrc_op1_0900_rl_s1_r10k_dp001p0 rwls_op1_0900_rl_s1_r10k_dp001p0 10000
ven_op1_0900_rl_s1_r10k_dp001p0 en_op1_0900_rl_s1_r10k_dp001p0 0 pwl(0.0000e+00 0 1.1000e-08 0 1.1100e-08 {VDD} 3.4000e-08 {VDD} 3.4100e-08 0)
venb_op1_0900_rl_s1_r10k_dp001p0 enb_op1_0900_rl_s1_r10k_dp001p0 0 pwl(0.0000e+00 {VDD} 1.1000e-08 {VDD} 1.1100e-08 0 3.4000e-08 0 3.4100e-08 {VDD})
vww_op1_0900_rl_s1_r10k_dp001p0 wwl_op1_0900_rl_s1_r10k_dp001p0 0 pwl(0.0000e+00 0 1.2000e-08 0 1.2100e-08 {VDD} 3.2000e-08 {VDD} 3.2100e-08 0)
vwc_op1_0900_rl_s1_r10k_dp001p0 wbc_op1_0900_rl_s1_r10k_dp001p0 0 pwl(0.0000e+00 0 1.2000e-08 0 1.2100e-08 {VDD} 3.4000e-08 {VDD} 3.4100e-08 0)
swb_op1_0900_rl_s1_r10k_dp001p0 ref_op1_0900_rl_s1_r10k_dp001p0 wbl_op1_0900_rl_s1_r10k_dp001p0 wbc_op1_0900_rl_s1_r10k_dp001p0 0 swwbl
cwbl_op1_0900_rl_s1_r10k_dp001p0 wbl_op1_0900_rl_s1_r10k_dp001p0 0 {C_WBL}
spa_op1_0900_rl_s1_r10k_dp001p0 prea rbl_op1_0900_rl_s1_r10k_dp001p0 ctl_op1_0900_rl_s1_r10k_dp001p0 0 swpre
spr_op1_0900_rl_s1_r10k_dp001p0 pref ref_op1_0900_rl_s1_r10k_dp001p0 ctl_op1_0900_rl_s1_r10k_dp001p0 0 swpre
crbl_op1_0900_rl_s1_r10k_dp001p0 rbl_op1_0900_rl_s1_r10k_dp001p0 0 {C_RBL}
cref_op1_0900_rl_s1_r10k_dp001p0 ref_op1_0900_rl_s1_r10k_dp001p0 0 {C_RBL}   $ ASSUMPTION: ideal matched dummy load
XMWR_op1_0900_rl_s1_r10k_dp001p0_0 sn_op1_0900_rl_s1_r10k_dp001p0_0 wwl_op1_0900_rl_s1_r10k_dp001p0 wbl_op1_0900_rl_s1_r10k_dp001p0 0 sky130_fd_pr__nfet_01v8 L=0.15 W=0.42 nf=1 ad=0.1218 as=0.1218 pd=1.42 ps=1.42 nrd=0.69047619047619  nrs=0.69047619047619 sa=0 sb=0 sd=0 mult=1 m=1
XMRD_op1_0900_rl_s1_r10k_dp001p0_0 rbl_op1_0900_rl_s1_r10k_dp001p0 sn_op1_0900_rl_s1_r10k_dp001p0_0 rwls_op1_0900_rl_s1_r10k_dp001p0 0 sky130_fd_pr__nfet_01v8 L=0.15 W=0.42 nf=1 ad=0.1218 as=0.1218 pd=1.42 ps=1.42 nrd=0.69047619047619  nrs=0.69047619047619 sa=0 sb=0 sd=0 mult=1 m=1
csn_op1_0900_rl_s1_r10k_dp001p0_0 sn_op1_0900_rl_s1_r10k_dp001p0_0 0 {C_SN}
XMWR_op1_0900_rl_s1_r10k_dp001p0_1 sn_op1_0900_rl_s1_r10k_dp001p0_1 wwl_des wbl_op1_0900_rl_s1_r10k_dp001p0 0 sky130_fd_pr__nfet_01v8 L=0.15 W=0.42 nf=1 ad=0.1218 as=0.1218 pd=1.42 ps=1.42 nrd=0.69047619047619  nrs=0.69047619047619 sa=0 sb=0 sd=0 mult=1 m=1
XMRD_op1_0900_rl_s1_r10k_dp001p0_1 rbl_op1_0900_rl_s1_r10k_dp001p0 sn_op1_0900_rl_s1_r10k_dp001p0_1 rwl_des 0 sky130_fd_pr__nfet_01v8 L=0.15 W=0.42 nf=1 ad=0.1218 as=0.1218 pd=1.42 ps=1.42 nrd=0.69047619047619  nrs=0.69047619047619 sa=0 sb=0 sd=0 mult=1 m=1
csn_op1_0900_rl_s1_r10k_dp001p0_1 sn_op1_0900_rl_s1_r10k_dp001p0_1 0 {C_SN}
XMWR_op1_0900_rl_s1_r10k_dp001p0_2 sn_op1_0900_rl_s1_r10k_dp001p0_2 wwl_des wbl_op1_0900_rl_s1_r10k_dp001p0 0 sky130_fd_pr__nfet_01v8 L=0.15 W=0.42 nf=1 ad=0.1218 as=0.1218 pd=1.42 ps=1.42 nrd=0.69047619047619  nrs=0.69047619047619 sa=0 sb=0 sd=0 mult=1 m=1
XMRD_op1_0900_rl_s1_r10k_dp001p0_2 rbl_op1_0900_rl_s1_r10k_dp001p0 sn_op1_0900_rl_s1_r10k_dp001p0_2 rwl_des 0 sky130_fd_pr__nfet_01v8 L=0.15 W=0.42 nf=1 ad=0.1218 as=0.1218 pd=1.42 ps=1.42 nrd=0.69047619047619  nrs=0.69047619047619 sa=0 sb=0 sd=0 mult=1 m=1
csn_op1_0900_rl_s1_r10k_dp001p0_2 sn_op1_0900_rl_s1_r10k_dp001p0_2 0 {C_SN}
XMWR_op1_0900_rl_s1_r10k_dp001p0_3 sn_op1_0900_rl_s1_r10k_dp001p0_3 wwl_des wbl_op1_0900_rl_s1_r10k_dp001p0 0 sky130_fd_pr__nfet_01v8 L=0.15 W=0.42 nf=1 ad=0.1218 as=0.1218 pd=1.42 ps=1.42 nrd=0.69047619047619  nrs=0.69047619047619 sa=0 sb=0 sd=0 mult=1 m=1
XMRD_op1_0900_rl_s1_r10k_dp001p0_3 rbl_op1_0900_rl_s1_r10k_dp001p0 sn_op1_0900_rl_s1_r10k_dp001p0_3 rwl_des 0 sky130_fd_pr__nfet_01v8 L=0.15 W=0.42 nf=1 ad=0.1218 as=0.1218 pd=1.42 ps=1.42 nrd=0.69047619047619  nrs=0.69047619047619 sa=0 sb=0 sd=0 mult=1 m=1
csn_op1_0900_rl_s1_r10k_dp001p0_3 sn_op1_0900_rl_s1_r10k_dp001p0_3 0 {C_SN}
XMN1_op1_0900_rl_s1_r10k_dp001p0 rbl_op1_0900_rl_s1_r10k_dp001p0 ref_op1_0900_rl_s1_r10k_dp001p0 vn_op1_0900_rl_s1_r10k_dp001p0 0 sky130_fd_pr__nfet_01v8 L=0.15 W=1 nf=1 ad=0.29 as=0.29 pd=2.58 ps=2.58 mult=1 m=1
XMN2_op1_0900_rl_s1_r10k_dp001p0 ref_op1_0900_rl_s1_r10k_dp001p0 rbl_op1_0900_rl_s1_r10k_dp001p0 vn_op1_0900_rl_s1_r10k_dp001p0 0 sky130_fd_pr__nfet_01v8 L=0.15 W=1 nf=1 ad=0.29 as=0.29 pd=2.58 ps=2.58 mult=1 m=1
XMP1_op1_0900_rl_s1_r10k_dp001p0 rbl_op1_0900_rl_s1_r10k_dp001p0 ref_op1_0900_rl_s1_r10k_dp001p0 vp_op1_0900_rl_s1_r10k_dp001p0 vdd sky130_fd_pr__pfet_01v8 L=0.15 W=2 nf=1 ad=0.58 as=0.58 pd=4.58 ps=4.58 mult=1 m=1
XMP2_op1_0900_rl_s1_r10k_dp001p0 ref_op1_0900_rl_s1_r10k_dp001p0 rbl_op1_0900_rl_s1_r10k_dp001p0 vp_op1_0900_rl_s1_r10k_dp001p0 vdd sky130_fd_pr__pfet_01v8 L=0.15 W=2 nf=1 ad=0.58 as=0.58 pd=4.58 ps=4.58 mult=1 m=1
XMNF_op1_0900_rl_s1_r10k_dp001p0 vn_op1_0900_rl_s1_r10k_dp001p0 en_op1_0900_rl_s1_r10k_dp001p0 0 0 sky130_fd_pr__nfet_01v8 L=0.15 W=2 nf=1 ad=0.58 as=0.58 pd=4.58 ps=4.58 mult=1 m=1
XMPH_op1_0900_rl_s1_r10k_dp001p0 vp_op1_0900_rl_s1_r10k_dp001p0 enb_op1_0900_rl_s1_r10k_dp001p0 vdd vdd sky130_fd_pr__pfet_01v8 L=0.15 W=4 nf=1 ad=1.16 as=1.16 pd=8.58 ps=8.58 mult=1 m=1
bd_op1_0900_rl_s1_r10k_dp001p0 d_op1_0900_rl_s1_r10k_dp001p0 0 v=v(rbl_op1_0900_rl_s1_r10k_dp001p0)-v(ref_op1_0900_rl_s1_r10k_dp001p0)

* ---- instance 274: op1_1000_rl_s1_r10k_dp001p0 (variant rl_s1_r10k_dp001p0; probe dec 11.9 ns, release 34 ns, meas 36 ns) ----
vctl_op1_1000_rl_s1_r10k_dp001p0 ctl_op1_1000_rl_s1_r10k_dp001p0 0 pwl(0.0000e+00 {VDD} 2.0000e-09 {VDD} 2.1000e-09 0)
* RWL driver model (EXPERIMENTAL): slew 1 ns, series R 10000 ohm; cell pin = rwls_op1_1000_rl_s1_r10k_dp001p0
vrs_op1_1000_rl_s1_r10k_dp001p0 rwlsrc_op1_1000_rl_s1_r10k_dp001p0 0 pwl(0.0000e+00 {VDD} 2.0000e-09 {VDD} 3.0000e-09 0 3.3000e-08 0 3.4000e-08 {VDD})
rdrv_op1_1000_rl_s1_r10k_dp001p0 rwlsrc_op1_1000_rl_s1_r10k_dp001p0 rwls_op1_1000_rl_s1_r10k_dp001p0 10000
ven_op1_1000_rl_s1_r10k_dp001p0 en_op1_1000_rl_s1_r10k_dp001p0 0 pwl(0.0000e+00 0 1.1000e-08 0 1.1100e-08 {VDD} 3.4000e-08 {VDD} 3.4100e-08 0)
venb_op1_1000_rl_s1_r10k_dp001p0 enb_op1_1000_rl_s1_r10k_dp001p0 0 pwl(0.0000e+00 {VDD} 1.1000e-08 {VDD} 1.1100e-08 0 3.4000e-08 0 3.4100e-08 {VDD})
vww_op1_1000_rl_s1_r10k_dp001p0 wwl_op1_1000_rl_s1_r10k_dp001p0 0 pwl(0.0000e+00 0 1.2000e-08 0 1.2100e-08 {VDD} 3.2000e-08 {VDD} 3.2100e-08 0)
vwc_op1_1000_rl_s1_r10k_dp001p0 wbc_op1_1000_rl_s1_r10k_dp001p0 0 pwl(0.0000e+00 0 1.2000e-08 0 1.2100e-08 {VDD} 3.4000e-08 {VDD} 3.4100e-08 0)
swb_op1_1000_rl_s1_r10k_dp001p0 ref_op1_1000_rl_s1_r10k_dp001p0 wbl_op1_1000_rl_s1_r10k_dp001p0 wbc_op1_1000_rl_s1_r10k_dp001p0 0 swwbl
cwbl_op1_1000_rl_s1_r10k_dp001p0 wbl_op1_1000_rl_s1_r10k_dp001p0 0 {C_WBL}
spa_op1_1000_rl_s1_r10k_dp001p0 prea rbl_op1_1000_rl_s1_r10k_dp001p0 ctl_op1_1000_rl_s1_r10k_dp001p0 0 swpre
spr_op1_1000_rl_s1_r10k_dp001p0 pref ref_op1_1000_rl_s1_r10k_dp001p0 ctl_op1_1000_rl_s1_r10k_dp001p0 0 swpre
crbl_op1_1000_rl_s1_r10k_dp001p0 rbl_op1_1000_rl_s1_r10k_dp001p0 0 {C_RBL}
cref_op1_1000_rl_s1_r10k_dp001p0 ref_op1_1000_rl_s1_r10k_dp001p0 0 {C_RBL}   $ ASSUMPTION: ideal matched dummy load
XMWR_op1_1000_rl_s1_r10k_dp001p0_0 sn_op1_1000_rl_s1_r10k_dp001p0_0 wwl_op1_1000_rl_s1_r10k_dp001p0 wbl_op1_1000_rl_s1_r10k_dp001p0 0 sky130_fd_pr__nfet_01v8 L=0.15 W=0.42 nf=1 ad=0.1218 as=0.1218 pd=1.42 ps=1.42 nrd=0.69047619047619  nrs=0.69047619047619 sa=0 sb=0 sd=0 mult=1 m=1
XMRD_op1_1000_rl_s1_r10k_dp001p0_0 rbl_op1_1000_rl_s1_r10k_dp001p0 sn_op1_1000_rl_s1_r10k_dp001p0_0 rwls_op1_1000_rl_s1_r10k_dp001p0 0 sky130_fd_pr__nfet_01v8 L=0.15 W=0.42 nf=1 ad=0.1218 as=0.1218 pd=1.42 ps=1.42 nrd=0.69047619047619  nrs=0.69047619047619 sa=0 sb=0 sd=0 mult=1 m=1
csn_op1_1000_rl_s1_r10k_dp001p0_0 sn_op1_1000_rl_s1_r10k_dp001p0_0 0 {C_SN}
XMWR_op1_1000_rl_s1_r10k_dp001p0_1 sn_op1_1000_rl_s1_r10k_dp001p0_1 wwl_des wbl_op1_1000_rl_s1_r10k_dp001p0 0 sky130_fd_pr__nfet_01v8 L=0.15 W=0.42 nf=1 ad=0.1218 as=0.1218 pd=1.42 ps=1.42 nrd=0.69047619047619  nrs=0.69047619047619 sa=0 sb=0 sd=0 mult=1 m=1
XMRD_op1_1000_rl_s1_r10k_dp001p0_1 rbl_op1_1000_rl_s1_r10k_dp001p0 sn_op1_1000_rl_s1_r10k_dp001p0_1 rwl_des 0 sky130_fd_pr__nfet_01v8 L=0.15 W=0.42 nf=1 ad=0.1218 as=0.1218 pd=1.42 ps=1.42 nrd=0.69047619047619  nrs=0.69047619047619 sa=0 sb=0 sd=0 mult=1 m=1
csn_op1_1000_rl_s1_r10k_dp001p0_1 sn_op1_1000_rl_s1_r10k_dp001p0_1 0 {C_SN}
XMWR_op1_1000_rl_s1_r10k_dp001p0_2 sn_op1_1000_rl_s1_r10k_dp001p0_2 wwl_des wbl_op1_1000_rl_s1_r10k_dp001p0 0 sky130_fd_pr__nfet_01v8 L=0.15 W=0.42 nf=1 ad=0.1218 as=0.1218 pd=1.42 ps=1.42 nrd=0.69047619047619  nrs=0.69047619047619 sa=0 sb=0 sd=0 mult=1 m=1
XMRD_op1_1000_rl_s1_r10k_dp001p0_2 rbl_op1_1000_rl_s1_r10k_dp001p0 sn_op1_1000_rl_s1_r10k_dp001p0_2 rwl_des 0 sky130_fd_pr__nfet_01v8 L=0.15 W=0.42 nf=1 ad=0.1218 as=0.1218 pd=1.42 ps=1.42 nrd=0.69047619047619  nrs=0.69047619047619 sa=0 sb=0 sd=0 mult=1 m=1
csn_op1_1000_rl_s1_r10k_dp001p0_2 sn_op1_1000_rl_s1_r10k_dp001p0_2 0 {C_SN}
XMWR_op1_1000_rl_s1_r10k_dp001p0_3 sn_op1_1000_rl_s1_r10k_dp001p0_3 wwl_des wbl_op1_1000_rl_s1_r10k_dp001p0 0 sky130_fd_pr__nfet_01v8 L=0.15 W=0.42 nf=1 ad=0.1218 as=0.1218 pd=1.42 ps=1.42 nrd=0.69047619047619  nrs=0.69047619047619 sa=0 sb=0 sd=0 mult=1 m=1
XMRD_op1_1000_rl_s1_r10k_dp001p0_3 rbl_op1_1000_rl_s1_r10k_dp001p0 sn_op1_1000_rl_s1_r10k_dp001p0_3 rwl_des 0 sky130_fd_pr__nfet_01v8 L=0.15 W=0.42 nf=1 ad=0.1218 as=0.1218 pd=1.42 ps=1.42 nrd=0.69047619047619  nrs=0.69047619047619 sa=0 sb=0 sd=0 mult=1 m=1
csn_op1_1000_rl_s1_r10k_dp001p0_3 sn_op1_1000_rl_s1_r10k_dp001p0_3 0 {C_SN}
XMN1_op1_1000_rl_s1_r10k_dp001p0 rbl_op1_1000_rl_s1_r10k_dp001p0 ref_op1_1000_rl_s1_r10k_dp001p0 vn_op1_1000_rl_s1_r10k_dp001p0 0 sky130_fd_pr__nfet_01v8 L=0.15 W=1 nf=1 ad=0.29 as=0.29 pd=2.58 ps=2.58 mult=1 m=1
XMN2_op1_1000_rl_s1_r10k_dp001p0 ref_op1_1000_rl_s1_r10k_dp001p0 rbl_op1_1000_rl_s1_r10k_dp001p0 vn_op1_1000_rl_s1_r10k_dp001p0 0 sky130_fd_pr__nfet_01v8 L=0.15 W=1 nf=1 ad=0.29 as=0.29 pd=2.58 ps=2.58 mult=1 m=1
XMP1_op1_1000_rl_s1_r10k_dp001p0 rbl_op1_1000_rl_s1_r10k_dp001p0 ref_op1_1000_rl_s1_r10k_dp001p0 vp_op1_1000_rl_s1_r10k_dp001p0 vdd sky130_fd_pr__pfet_01v8 L=0.15 W=2 nf=1 ad=0.58 as=0.58 pd=4.58 ps=4.58 mult=1 m=1
XMP2_op1_1000_rl_s1_r10k_dp001p0 ref_op1_1000_rl_s1_r10k_dp001p0 rbl_op1_1000_rl_s1_r10k_dp001p0 vp_op1_1000_rl_s1_r10k_dp001p0 vdd sky130_fd_pr__pfet_01v8 L=0.15 W=2 nf=1 ad=0.58 as=0.58 pd=4.58 ps=4.58 mult=1 m=1
XMNF_op1_1000_rl_s1_r10k_dp001p0 vn_op1_1000_rl_s1_r10k_dp001p0 en_op1_1000_rl_s1_r10k_dp001p0 0 0 sky130_fd_pr__nfet_01v8 L=0.15 W=2 nf=1 ad=0.58 as=0.58 pd=4.58 ps=4.58 mult=1 m=1
XMPH_op1_1000_rl_s1_r10k_dp001p0 vp_op1_1000_rl_s1_r10k_dp001p0 enb_op1_1000_rl_s1_r10k_dp001p0 vdd vdd sky130_fd_pr__pfet_01v8 L=0.15 W=4 nf=1 ad=1.16 as=1.16 pd=8.58 ps=8.58 mult=1 m=1
bd_op1_1000_rl_s1_r10k_dp001p0 d_op1_1000_rl_s1_r10k_dp001p0 0 v=v(rbl_op1_1000_rl_s1_r10k_dp001p0)-v(ref_op1_1000_rl_s1_r10k_dp001p0)

* ---- instance 275: op0_n100_rl_s1_r10k_dp001p0 (variant rl_s1_r10k_dp001p0; probe dec 11.9 ns, release 34 ns, meas 36 ns) ----
vctl_op0_n100_rl_s1_r10k_dp001p0 ctl_op0_n100_rl_s1_r10k_dp001p0 0 pwl(0.0000e+00 {VDD} 2.0000e-09 {VDD} 2.1000e-09 0)
* RWL driver model (EXPERIMENTAL): slew 1 ns, series R 10000 ohm; cell pin = rwls_op0_n100_rl_s1_r10k_dp001p0
vrs_op0_n100_rl_s1_r10k_dp001p0 rwlsrc_op0_n100_rl_s1_r10k_dp001p0 0 pwl(0.0000e+00 {VDD} 2.0000e-09 {VDD} 3.0000e-09 0 3.3000e-08 0 3.4000e-08 {VDD})
rdrv_op0_n100_rl_s1_r10k_dp001p0 rwlsrc_op0_n100_rl_s1_r10k_dp001p0 rwls_op0_n100_rl_s1_r10k_dp001p0 10000
ven_op0_n100_rl_s1_r10k_dp001p0 en_op0_n100_rl_s1_r10k_dp001p0 0 pwl(0.0000e+00 0 1.1000e-08 0 1.1100e-08 {VDD} 3.4000e-08 {VDD} 3.4100e-08 0)
venb_op0_n100_rl_s1_r10k_dp001p0 enb_op0_n100_rl_s1_r10k_dp001p0 0 pwl(0.0000e+00 {VDD} 1.1000e-08 {VDD} 1.1100e-08 0 3.4000e-08 0 3.4100e-08 {VDD})
vww_op0_n100_rl_s1_r10k_dp001p0 wwl_op0_n100_rl_s1_r10k_dp001p0 0 pwl(0.0000e+00 0 1.2000e-08 0 1.2100e-08 {VDD} 3.2000e-08 {VDD} 3.2100e-08 0)
vwc_op0_n100_rl_s1_r10k_dp001p0 wbc_op0_n100_rl_s1_r10k_dp001p0 0 pwl(0.0000e+00 0 1.2000e-08 0 1.2100e-08 {VDD} 3.4000e-08 {VDD} 3.4100e-08 0)
swb_op0_n100_rl_s1_r10k_dp001p0 ref_op0_n100_rl_s1_r10k_dp001p0 wbl_op0_n100_rl_s1_r10k_dp001p0 wbc_op0_n100_rl_s1_r10k_dp001p0 0 swwbl
cwbl_op0_n100_rl_s1_r10k_dp001p0 wbl_op0_n100_rl_s1_r10k_dp001p0 0 {C_WBL}
spa_op0_n100_rl_s1_r10k_dp001p0 prea rbl_op0_n100_rl_s1_r10k_dp001p0 ctl_op0_n100_rl_s1_r10k_dp001p0 0 swpre
spr_op0_n100_rl_s1_r10k_dp001p0 pref ref_op0_n100_rl_s1_r10k_dp001p0 ctl_op0_n100_rl_s1_r10k_dp001p0 0 swpre
crbl_op0_n100_rl_s1_r10k_dp001p0 rbl_op0_n100_rl_s1_r10k_dp001p0 0 {C_RBL}
cref_op0_n100_rl_s1_r10k_dp001p0 ref_op0_n100_rl_s1_r10k_dp001p0 0 {C_RBL}   $ ASSUMPTION: ideal matched dummy load
XMWR_op0_n100_rl_s1_r10k_dp001p0_0 sn_op0_n100_rl_s1_r10k_dp001p0_0 wwl_op0_n100_rl_s1_r10k_dp001p0 wbl_op0_n100_rl_s1_r10k_dp001p0 0 sky130_fd_pr__nfet_01v8 L=0.15 W=0.42 nf=1 ad=0.1218 as=0.1218 pd=1.42 ps=1.42 nrd=0.69047619047619  nrs=0.69047619047619 sa=0 sb=0 sd=0 mult=1 m=1
XMRD_op0_n100_rl_s1_r10k_dp001p0_0 rbl_op0_n100_rl_s1_r10k_dp001p0 sn_op0_n100_rl_s1_r10k_dp001p0_0 rwls_op0_n100_rl_s1_r10k_dp001p0 0 sky130_fd_pr__nfet_01v8 L=0.15 W=0.42 nf=1 ad=0.1218 as=0.1218 pd=1.42 ps=1.42 nrd=0.69047619047619  nrs=0.69047619047619 sa=0 sb=0 sd=0 mult=1 m=1
csn_op0_n100_rl_s1_r10k_dp001p0_0 sn_op0_n100_rl_s1_r10k_dp001p0_0 0 {C_SN}
XMWR_op0_n100_rl_s1_r10k_dp001p0_1 sn_op0_n100_rl_s1_r10k_dp001p0_1 wwl_des wbl_op0_n100_rl_s1_r10k_dp001p0 0 sky130_fd_pr__nfet_01v8 L=0.15 W=0.42 nf=1 ad=0.1218 as=0.1218 pd=1.42 ps=1.42 nrd=0.69047619047619  nrs=0.69047619047619 sa=0 sb=0 sd=0 mult=1 m=1
XMRD_op0_n100_rl_s1_r10k_dp001p0_1 rbl_op0_n100_rl_s1_r10k_dp001p0 sn_op0_n100_rl_s1_r10k_dp001p0_1 rwl_des 0 sky130_fd_pr__nfet_01v8 L=0.15 W=0.42 nf=1 ad=0.1218 as=0.1218 pd=1.42 ps=1.42 nrd=0.69047619047619  nrs=0.69047619047619 sa=0 sb=0 sd=0 mult=1 m=1
csn_op0_n100_rl_s1_r10k_dp001p0_1 sn_op0_n100_rl_s1_r10k_dp001p0_1 0 {C_SN}
XMWR_op0_n100_rl_s1_r10k_dp001p0_2 sn_op0_n100_rl_s1_r10k_dp001p0_2 wwl_des wbl_op0_n100_rl_s1_r10k_dp001p0 0 sky130_fd_pr__nfet_01v8 L=0.15 W=0.42 nf=1 ad=0.1218 as=0.1218 pd=1.42 ps=1.42 nrd=0.69047619047619  nrs=0.69047619047619 sa=0 sb=0 sd=0 mult=1 m=1
XMRD_op0_n100_rl_s1_r10k_dp001p0_2 rbl_op0_n100_rl_s1_r10k_dp001p0 sn_op0_n100_rl_s1_r10k_dp001p0_2 rwl_des 0 sky130_fd_pr__nfet_01v8 L=0.15 W=0.42 nf=1 ad=0.1218 as=0.1218 pd=1.42 ps=1.42 nrd=0.69047619047619  nrs=0.69047619047619 sa=0 sb=0 sd=0 mult=1 m=1
csn_op0_n100_rl_s1_r10k_dp001p0_2 sn_op0_n100_rl_s1_r10k_dp001p0_2 0 {C_SN}
XMWR_op0_n100_rl_s1_r10k_dp001p0_3 sn_op0_n100_rl_s1_r10k_dp001p0_3 wwl_des wbl_op0_n100_rl_s1_r10k_dp001p0 0 sky130_fd_pr__nfet_01v8 L=0.15 W=0.42 nf=1 ad=0.1218 as=0.1218 pd=1.42 ps=1.42 nrd=0.69047619047619  nrs=0.69047619047619 sa=0 sb=0 sd=0 mult=1 m=1
XMRD_op0_n100_rl_s1_r10k_dp001p0_3 rbl_op0_n100_rl_s1_r10k_dp001p0 sn_op0_n100_rl_s1_r10k_dp001p0_3 rwl_des 0 sky130_fd_pr__nfet_01v8 L=0.15 W=0.42 nf=1 ad=0.1218 as=0.1218 pd=1.42 ps=1.42 nrd=0.69047619047619  nrs=0.69047619047619 sa=0 sb=0 sd=0 mult=1 m=1
csn_op0_n100_rl_s1_r10k_dp001p0_3 sn_op0_n100_rl_s1_r10k_dp001p0_3 0 {C_SN}
XMN1_op0_n100_rl_s1_r10k_dp001p0 rbl_op0_n100_rl_s1_r10k_dp001p0 ref_op0_n100_rl_s1_r10k_dp001p0 vn_op0_n100_rl_s1_r10k_dp001p0 0 sky130_fd_pr__nfet_01v8 L=0.15 W=1 nf=1 ad=0.29 as=0.29 pd=2.58 ps=2.58 mult=1 m=1
XMN2_op0_n100_rl_s1_r10k_dp001p0 ref_op0_n100_rl_s1_r10k_dp001p0 rbl_op0_n100_rl_s1_r10k_dp001p0 vn_op0_n100_rl_s1_r10k_dp001p0 0 sky130_fd_pr__nfet_01v8 L=0.15 W=1 nf=1 ad=0.29 as=0.29 pd=2.58 ps=2.58 mult=1 m=1
XMP1_op0_n100_rl_s1_r10k_dp001p0 rbl_op0_n100_rl_s1_r10k_dp001p0 ref_op0_n100_rl_s1_r10k_dp001p0 vp_op0_n100_rl_s1_r10k_dp001p0 vdd sky130_fd_pr__pfet_01v8 L=0.15 W=2 nf=1 ad=0.58 as=0.58 pd=4.58 ps=4.58 mult=1 m=1
XMP2_op0_n100_rl_s1_r10k_dp001p0 ref_op0_n100_rl_s1_r10k_dp001p0 rbl_op0_n100_rl_s1_r10k_dp001p0 vp_op0_n100_rl_s1_r10k_dp001p0 vdd sky130_fd_pr__pfet_01v8 L=0.15 W=2 nf=1 ad=0.58 as=0.58 pd=4.58 ps=4.58 mult=1 m=1
XMNF_op0_n100_rl_s1_r10k_dp001p0 vn_op0_n100_rl_s1_r10k_dp001p0 en_op0_n100_rl_s1_r10k_dp001p0 0 0 sky130_fd_pr__nfet_01v8 L=0.15 W=2 nf=1 ad=0.58 as=0.58 pd=4.58 ps=4.58 mult=1 m=1
XMPH_op0_n100_rl_s1_r10k_dp001p0 vp_op0_n100_rl_s1_r10k_dp001p0 enb_op0_n100_rl_s1_r10k_dp001p0 vdd vdd sky130_fd_pr__pfet_01v8 L=0.15 W=4 nf=1 ad=1.16 as=1.16 pd=8.58 ps=8.58 mult=1 m=1
bd_op0_n100_rl_s1_r10k_dp001p0 d_op0_n100_rl_s1_r10k_dp001p0 0 v=v(rbl_op0_n100_rl_s1_r10k_dp001p0)-v(ref_op0_n100_rl_s1_r10k_dp001p0)

* ---- instance 276: op0_0000_rl_s1_r10k_dp001p0 (variant rl_s1_r10k_dp001p0; probe dec 11.9 ns, release 34 ns, meas 36 ns) ----
vctl_op0_0000_rl_s1_r10k_dp001p0 ctl_op0_0000_rl_s1_r10k_dp001p0 0 pwl(0.0000e+00 {VDD} 2.0000e-09 {VDD} 2.1000e-09 0)
* RWL driver model (EXPERIMENTAL): slew 1 ns, series R 10000 ohm; cell pin = rwls_op0_0000_rl_s1_r10k_dp001p0
vrs_op0_0000_rl_s1_r10k_dp001p0 rwlsrc_op0_0000_rl_s1_r10k_dp001p0 0 pwl(0.0000e+00 {VDD} 2.0000e-09 {VDD} 3.0000e-09 0 3.3000e-08 0 3.4000e-08 {VDD})
rdrv_op0_0000_rl_s1_r10k_dp001p0 rwlsrc_op0_0000_rl_s1_r10k_dp001p0 rwls_op0_0000_rl_s1_r10k_dp001p0 10000
ven_op0_0000_rl_s1_r10k_dp001p0 en_op0_0000_rl_s1_r10k_dp001p0 0 pwl(0.0000e+00 0 1.1000e-08 0 1.1100e-08 {VDD} 3.4000e-08 {VDD} 3.4100e-08 0)
venb_op0_0000_rl_s1_r10k_dp001p0 enb_op0_0000_rl_s1_r10k_dp001p0 0 pwl(0.0000e+00 {VDD} 1.1000e-08 {VDD} 1.1100e-08 0 3.4000e-08 0 3.4100e-08 {VDD})
vww_op0_0000_rl_s1_r10k_dp001p0 wwl_op0_0000_rl_s1_r10k_dp001p0 0 pwl(0.0000e+00 0 1.2000e-08 0 1.2100e-08 {VDD} 3.2000e-08 {VDD} 3.2100e-08 0)
vwc_op0_0000_rl_s1_r10k_dp001p0 wbc_op0_0000_rl_s1_r10k_dp001p0 0 pwl(0.0000e+00 0 1.2000e-08 0 1.2100e-08 {VDD} 3.4000e-08 {VDD} 3.4100e-08 0)
swb_op0_0000_rl_s1_r10k_dp001p0 ref_op0_0000_rl_s1_r10k_dp001p0 wbl_op0_0000_rl_s1_r10k_dp001p0 wbc_op0_0000_rl_s1_r10k_dp001p0 0 swwbl
cwbl_op0_0000_rl_s1_r10k_dp001p0 wbl_op0_0000_rl_s1_r10k_dp001p0 0 {C_WBL}
spa_op0_0000_rl_s1_r10k_dp001p0 prea rbl_op0_0000_rl_s1_r10k_dp001p0 ctl_op0_0000_rl_s1_r10k_dp001p0 0 swpre
spr_op0_0000_rl_s1_r10k_dp001p0 pref ref_op0_0000_rl_s1_r10k_dp001p0 ctl_op0_0000_rl_s1_r10k_dp001p0 0 swpre
crbl_op0_0000_rl_s1_r10k_dp001p0 rbl_op0_0000_rl_s1_r10k_dp001p0 0 {C_RBL}
cref_op0_0000_rl_s1_r10k_dp001p0 ref_op0_0000_rl_s1_r10k_dp001p0 0 {C_RBL}   $ ASSUMPTION: ideal matched dummy load
XMWR_op0_0000_rl_s1_r10k_dp001p0_0 sn_op0_0000_rl_s1_r10k_dp001p0_0 wwl_op0_0000_rl_s1_r10k_dp001p0 wbl_op0_0000_rl_s1_r10k_dp001p0 0 sky130_fd_pr__nfet_01v8 L=0.15 W=0.42 nf=1 ad=0.1218 as=0.1218 pd=1.42 ps=1.42 nrd=0.69047619047619  nrs=0.69047619047619 sa=0 sb=0 sd=0 mult=1 m=1
XMRD_op0_0000_rl_s1_r10k_dp001p0_0 rbl_op0_0000_rl_s1_r10k_dp001p0 sn_op0_0000_rl_s1_r10k_dp001p0_0 rwls_op0_0000_rl_s1_r10k_dp001p0 0 sky130_fd_pr__nfet_01v8 L=0.15 W=0.42 nf=1 ad=0.1218 as=0.1218 pd=1.42 ps=1.42 nrd=0.69047619047619  nrs=0.69047619047619 sa=0 sb=0 sd=0 mult=1 m=1
csn_op0_0000_rl_s1_r10k_dp001p0_0 sn_op0_0000_rl_s1_r10k_dp001p0_0 0 {C_SN}
XMWR_op0_0000_rl_s1_r10k_dp001p0_1 sn_op0_0000_rl_s1_r10k_dp001p0_1 wwl_des wbl_op0_0000_rl_s1_r10k_dp001p0 0 sky130_fd_pr__nfet_01v8 L=0.15 W=0.42 nf=1 ad=0.1218 as=0.1218 pd=1.42 ps=1.42 nrd=0.69047619047619  nrs=0.69047619047619 sa=0 sb=0 sd=0 mult=1 m=1
XMRD_op0_0000_rl_s1_r10k_dp001p0_1 rbl_op0_0000_rl_s1_r10k_dp001p0 sn_op0_0000_rl_s1_r10k_dp001p0_1 rwl_des 0 sky130_fd_pr__nfet_01v8 L=0.15 W=0.42 nf=1 ad=0.1218 as=0.1218 pd=1.42 ps=1.42 nrd=0.69047619047619  nrs=0.69047619047619 sa=0 sb=0 sd=0 mult=1 m=1
csn_op0_0000_rl_s1_r10k_dp001p0_1 sn_op0_0000_rl_s1_r10k_dp001p0_1 0 {C_SN}
XMWR_op0_0000_rl_s1_r10k_dp001p0_2 sn_op0_0000_rl_s1_r10k_dp001p0_2 wwl_des wbl_op0_0000_rl_s1_r10k_dp001p0 0 sky130_fd_pr__nfet_01v8 L=0.15 W=0.42 nf=1 ad=0.1218 as=0.1218 pd=1.42 ps=1.42 nrd=0.69047619047619  nrs=0.69047619047619 sa=0 sb=0 sd=0 mult=1 m=1
XMRD_op0_0000_rl_s1_r10k_dp001p0_2 rbl_op0_0000_rl_s1_r10k_dp001p0 sn_op0_0000_rl_s1_r10k_dp001p0_2 rwl_des 0 sky130_fd_pr__nfet_01v8 L=0.15 W=0.42 nf=1 ad=0.1218 as=0.1218 pd=1.42 ps=1.42 nrd=0.69047619047619  nrs=0.69047619047619 sa=0 sb=0 sd=0 mult=1 m=1
csn_op0_0000_rl_s1_r10k_dp001p0_2 sn_op0_0000_rl_s1_r10k_dp001p0_2 0 {C_SN}
XMWR_op0_0000_rl_s1_r10k_dp001p0_3 sn_op0_0000_rl_s1_r10k_dp001p0_3 wwl_des wbl_op0_0000_rl_s1_r10k_dp001p0 0 sky130_fd_pr__nfet_01v8 L=0.15 W=0.42 nf=1 ad=0.1218 as=0.1218 pd=1.42 ps=1.42 nrd=0.69047619047619  nrs=0.69047619047619 sa=0 sb=0 sd=0 mult=1 m=1
XMRD_op0_0000_rl_s1_r10k_dp001p0_3 rbl_op0_0000_rl_s1_r10k_dp001p0 sn_op0_0000_rl_s1_r10k_dp001p0_3 rwl_des 0 sky130_fd_pr__nfet_01v8 L=0.15 W=0.42 nf=1 ad=0.1218 as=0.1218 pd=1.42 ps=1.42 nrd=0.69047619047619  nrs=0.69047619047619 sa=0 sb=0 sd=0 mult=1 m=1
csn_op0_0000_rl_s1_r10k_dp001p0_3 sn_op0_0000_rl_s1_r10k_dp001p0_3 0 {C_SN}
XMN1_op0_0000_rl_s1_r10k_dp001p0 rbl_op0_0000_rl_s1_r10k_dp001p0 ref_op0_0000_rl_s1_r10k_dp001p0 vn_op0_0000_rl_s1_r10k_dp001p0 0 sky130_fd_pr__nfet_01v8 L=0.15 W=1 nf=1 ad=0.29 as=0.29 pd=2.58 ps=2.58 mult=1 m=1
XMN2_op0_0000_rl_s1_r10k_dp001p0 ref_op0_0000_rl_s1_r10k_dp001p0 rbl_op0_0000_rl_s1_r10k_dp001p0 vn_op0_0000_rl_s1_r10k_dp001p0 0 sky130_fd_pr__nfet_01v8 L=0.15 W=1 nf=1 ad=0.29 as=0.29 pd=2.58 ps=2.58 mult=1 m=1
XMP1_op0_0000_rl_s1_r10k_dp001p0 rbl_op0_0000_rl_s1_r10k_dp001p0 ref_op0_0000_rl_s1_r10k_dp001p0 vp_op0_0000_rl_s1_r10k_dp001p0 vdd sky130_fd_pr__pfet_01v8 L=0.15 W=2 nf=1 ad=0.58 as=0.58 pd=4.58 ps=4.58 mult=1 m=1
XMP2_op0_0000_rl_s1_r10k_dp001p0 ref_op0_0000_rl_s1_r10k_dp001p0 rbl_op0_0000_rl_s1_r10k_dp001p0 vp_op0_0000_rl_s1_r10k_dp001p0 vdd sky130_fd_pr__pfet_01v8 L=0.15 W=2 nf=1 ad=0.58 as=0.58 pd=4.58 ps=4.58 mult=1 m=1
XMNF_op0_0000_rl_s1_r10k_dp001p0 vn_op0_0000_rl_s1_r10k_dp001p0 en_op0_0000_rl_s1_r10k_dp001p0 0 0 sky130_fd_pr__nfet_01v8 L=0.15 W=2 nf=1 ad=0.58 as=0.58 pd=4.58 ps=4.58 mult=1 m=1
XMPH_op0_0000_rl_s1_r10k_dp001p0 vp_op0_0000_rl_s1_r10k_dp001p0 enb_op0_0000_rl_s1_r10k_dp001p0 vdd vdd sky130_fd_pr__pfet_01v8 L=0.15 W=4 nf=1 ad=1.16 as=1.16 pd=8.58 ps=8.58 mult=1 m=1
bd_op0_0000_rl_s1_r10k_dp001p0 d_op0_0000_rl_s1_r10k_dp001p0 0 v=v(rbl_op0_0000_rl_s1_r10k_dp001p0)-v(ref_op0_0000_rl_s1_r10k_dp001p0)

* ---- instance 277: op1_0900_rl_s1_r10k_dp002p0 (variant rl_s1_r10k_dp002p0; probe dec 11.9 ns, release 34 ns, meas 36 ns) ----
vctl_op1_0900_rl_s1_r10k_dp002p0 ctl_op1_0900_rl_s1_r10k_dp002p0 0 pwl(0.0000e+00 {VDD} 2.0000e-09 {VDD} 2.1000e-09 0)
* RWL driver model (EXPERIMENTAL): slew 1 ns, series R 10000 ohm; cell pin = rwls_op1_0900_rl_s1_r10k_dp002p0
vrs_op1_0900_rl_s1_r10k_dp002p0 rwlsrc_op1_0900_rl_s1_r10k_dp002p0 0 pwl(0.0000e+00 {VDD} 2.0000e-09 {VDD} 3.0000e-09 0 3.4000e-08 0 3.5000e-08 {VDD})
rdrv_op1_0900_rl_s1_r10k_dp002p0 rwlsrc_op1_0900_rl_s1_r10k_dp002p0 rwls_op1_0900_rl_s1_r10k_dp002p0 10000
ven_op1_0900_rl_s1_r10k_dp002p0 en_op1_0900_rl_s1_r10k_dp002p0 0 pwl(0.0000e+00 0 1.1000e-08 0 1.1100e-08 {VDD} 3.4000e-08 {VDD} 3.4100e-08 0)
venb_op1_0900_rl_s1_r10k_dp002p0 enb_op1_0900_rl_s1_r10k_dp002p0 0 pwl(0.0000e+00 {VDD} 1.1000e-08 {VDD} 1.1100e-08 0 3.4000e-08 0 3.4100e-08 {VDD})
vww_op1_0900_rl_s1_r10k_dp002p0 wwl_op1_0900_rl_s1_r10k_dp002p0 0 pwl(0.0000e+00 0 1.2000e-08 0 1.2100e-08 {VDD} 3.2000e-08 {VDD} 3.2100e-08 0)
vwc_op1_0900_rl_s1_r10k_dp002p0 wbc_op1_0900_rl_s1_r10k_dp002p0 0 pwl(0.0000e+00 0 1.2000e-08 0 1.2100e-08 {VDD} 3.4000e-08 {VDD} 3.4100e-08 0)
swb_op1_0900_rl_s1_r10k_dp002p0 ref_op1_0900_rl_s1_r10k_dp002p0 wbl_op1_0900_rl_s1_r10k_dp002p0 wbc_op1_0900_rl_s1_r10k_dp002p0 0 swwbl
cwbl_op1_0900_rl_s1_r10k_dp002p0 wbl_op1_0900_rl_s1_r10k_dp002p0 0 {C_WBL}
spa_op1_0900_rl_s1_r10k_dp002p0 prea rbl_op1_0900_rl_s1_r10k_dp002p0 ctl_op1_0900_rl_s1_r10k_dp002p0 0 swpre
spr_op1_0900_rl_s1_r10k_dp002p0 pref ref_op1_0900_rl_s1_r10k_dp002p0 ctl_op1_0900_rl_s1_r10k_dp002p0 0 swpre
crbl_op1_0900_rl_s1_r10k_dp002p0 rbl_op1_0900_rl_s1_r10k_dp002p0 0 {C_RBL}
cref_op1_0900_rl_s1_r10k_dp002p0 ref_op1_0900_rl_s1_r10k_dp002p0 0 {C_RBL}   $ ASSUMPTION: ideal matched dummy load
XMWR_op1_0900_rl_s1_r10k_dp002p0_0 sn_op1_0900_rl_s1_r10k_dp002p0_0 wwl_op1_0900_rl_s1_r10k_dp002p0 wbl_op1_0900_rl_s1_r10k_dp002p0 0 sky130_fd_pr__nfet_01v8 L=0.15 W=0.42 nf=1 ad=0.1218 as=0.1218 pd=1.42 ps=1.42 nrd=0.69047619047619  nrs=0.69047619047619 sa=0 sb=0 sd=0 mult=1 m=1
XMRD_op1_0900_rl_s1_r10k_dp002p0_0 rbl_op1_0900_rl_s1_r10k_dp002p0 sn_op1_0900_rl_s1_r10k_dp002p0_0 rwls_op1_0900_rl_s1_r10k_dp002p0 0 sky130_fd_pr__nfet_01v8 L=0.15 W=0.42 nf=1 ad=0.1218 as=0.1218 pd=1.42 ps=1.42 nrd=0.69047619047619  nrs=0.69047619047619 sa=0 sb=0 sd=0 mult=1 m=1
csn_op1_0900_rl_s1_r10k_dp002p0_0 sn_op1_0900_rl_s1_r10k_dp002p0_0 0 {C_SN}
XMWR_op1_0900_rl_s1_r10k_dp002p0_1 sn_op1_0900_rl_s1_r10k_dp002p0_1 wwl_des wbl_op1_0900_rl_s1_r10k_dp002p0 0 sky130_fd_pr__nfet_01v8 L=0.15 W=0.42 nf=1 ad=0.1218 as=0.1218 pd=1.42 ps=1.42 nrd=0.69047619047619  nrs=0.69047619047619 sa=0 sb=0 sd=0 mult=1 m=1
XMRD_op1_0900_rl_s1_r10k_dp002p0_1 rbl_op1_0900_rl_s1_r10k_dp002p0 sn_op1_0900_rl_s1_r10k_dp002p0_1 rwl_des 0 sky130_fd_pr__nfet_01v8 L=0.15 W=0.42 nf=1 ad=0.1218 as=0.1218 pd=1.42 ps=1.42 nrd=0.69047619047619  nrs=0.69047619047619 sa=0 sb=0 sd=0 mult=1 m=1
csn_op1_0900_rl_s1_r10k_dp002p0_1 sn_op1_0900_rl_s1_r10k_dp002p0_1 0 {C_SN}
XMWR_op1_0900_rl_s1_r10k_dp002p0_2 sn_op1_0900_rl_s1_r10k_dp002p0_2 wwl_des wbl_op1_0900_rl_s1_r10k_dp002p0 0 sky130_fd_pr__nfet_01v8 L=0.15 W=0.42 nf=1 ad=0.1218 as=0.1218 pd=1.42 ps=1.42 nrd=0.69047619047619  nrs=0.69047619047619 sa=0 sb=0 sd=0 mult=1 m=1
XMRD_op1_0900_rl_s1_r10k_dp002p0_2 rbl_op1_0900_rl_s1_r10k_dp002p0 sn_op1_0900_rl_s1_r10k_dp002p0_2 rwl_des 0 sky130_fd_pr__nfet_01v8 L=0.15 W=0.42 nf=1 ad=0.1218 as=0.1218 pd=1.42 ps=1.42 nrd=0.69047619047619  nrs=0.69047619047619 sa=0 sb=0 sd=0 mult=1 m=1
csn_op1_0900_rl_s1_r10k_dp002p0_2 sn_op1_0900_rl_s1_r10k_dp002p0_2 0 {C_SN}
XMWR_op1_0900_rl_s1_r10k_dp002p0_3 sn_op1_0900_rl_s1_r10k_dp002p0_3 wwl_des wbl_op1_0900_rl_s1_r10k_dp002p0 0 sky130_fd_pr__nfet_01v8 L=0.15 W=0.42 nf=1 ad=0.1218 as=0.1218 pd=1.42 ps=1.42 nrd=0.69047619047619  nrs=0.69047619047619 sa=0 sb=0 sd=0 mult=1 m=1
XMRD_op1_0900_rl_s1_r10k_dp002p0_3 rbl_op1_0900_rl_s1_r10k_dp002p0 sn_op1_0900_rl_s1_r10k_dp002p0_3 rwl_des 0 sky130_fd_pr__nfet_01v8 L=0.15 W=0.42 nf=1 ad=0.1218 as=0.1218 pd=1.42 ps=1.42 nrd=0.69047619047619  nrs=0.69047619047619 sa=0 sb=0 sd=0 mult=1 m=1
csn_op1_0900_rl_s1_r10k_dp002p0_3 sn_op1_0900_rl_s1_r10k_dp002p0_3 0 {C_SN}
XMN1_op1_0900_rl_s1_r10k_dp002p0 rbl_op1_0900_rl_s1_r10k_dp002p0 ref_op1_0900_rl_s1_r10k_dp002p0 vn_op1_0900_rl_s1_r10k_dp002p0 0 sky130_fd_pr__nfet_01v8 L=0.15 W=1 nf=1 ad=0.29 as=0.29 pd=2.58 ps=2.58 mult=1 m=1
XMN2_op1_0900_rl_s1_r10k_dp002p0 ref_op1_0900_rl_s1_r10k_dp002p0 rbl_op1_0900_rl_s1_r10k_dp002p0 vn_op1_0900_rl_s1_r10k_dp002p0 0 sky130_fd_pr__nfet_01v8 L=0.15 W=1 nf=1 ad=0.29 as=0.29 pd=2.58 ps=2.58 mult=1 m=1
XMP1_op1_0900_rl_s1_r10k_dp002p0 rbl_op1_0900_rl_s1_r10k_dp002p0 ref_op1_0900_rl_s1_r10k_dp002p0 vp_op1_0900_rl_s1_r10k_dp002p0 vdd sky130_fd_pr__pfet_01v8 L=0.15 W=2 nf=1 ad=0.58 as=0.58 pd=4.58 ps=4.58 mult=1 m=1
XMP2_op1_0900_rl_s1_r10k_dp002p0 ref_op1_0900_rl_s1_r10k_dp002p0 rbl_op1_0900_rl_s1_r10k_dp002p0 vp_op1_0900_rl_s1_r10k_dp002p0 vdd sky130_fd_pr__pfet_01v8 L=0.15 W=2 nf=1 ad=0.58 as=0.58 pd=4.58 ps=4.58 mult=1 m=1
XMNF_op1_0900_rl_s1_r10k_dp002p0 vn_op1_0900_rl_s1_r10k_dp002p0 en_op1_0900_rl_s1_r10k_dp002p0 0 0 sky130_fd_pr__nfet_01v8 L=0.15 W=2 nf=1 ad=0.58 as=0.58 pd=4.58 ps=4.58 mult=1 m=1
XMPH_op1_0900_rl_s1_r10k_dp002p0 vp_op1_0900_rl_s1_r10k_dp002p0 enb_op1_0900_rl_s1_r10k_dp002p0 vdd vdd sky130_fd_pr__pfet_01v8 L=0.15 W=4 nf=1 ad=1.16 as=1.16 pd=8.58 ps=8.58 mult=1 m=1
bd_op1_0900_rl_s1_r10k_dp002p0 d_op1_0900_rl_s1_r10k_dp002p0 0 v=v(rbl_op1_0900_rl_s1_r10k_dp002p0)-v(ref_op1_0900_rl_s1_r10k_dp002p0)

* ---- instance 278: op1_1000_rl_s1_r10k_dp002p0 (variant rl_s1_r10k_dp002p0; probe dec 11.9 ns, release 34 ns, meas 36 ns) ----
vctl_op1_1000_rl_s1_r10k_dp002p0 ctl_op1_1000_rl_s1_r10k_dp002p0 0 pwl(0.0000e+00 {VDD} 2.0000e-09 {VDD} 2.1000e-09 0)
* RWL driver model (EXPERIMENTAL): slew 1 ns, series R 10000 ohm; cell pin = rwls_op1_1000_rl_s1_r10k_dp002p0
vrs_op1_1000_rl_s1_r10k_dp002p0 rwlsrc_op1_1000_rl_s1_r10k_dp002p0 0 pwl(0.0000e+00 {VDD} 2.0000e-09 {VDD} 3.0000e-09 0 3.4000e-08 0 3.5000e-08 {VDD})
rdrv_op1_1000_rl_s1_r10k_dp002p0 rwlsrc_op1_1000_rl_s1_r10k_dp002p0 rwls_op1_1000_rl_s1_r10k_dp002p0 10000
ven_op1_1000_rl_s1_r10k_dp002p0 en_op1_1000_rl_s1_r10k_dp002p0 0 pwl(0.0000e+00 0 1.1000e-08 0 1.1100e-08 {VDD} 3.4000e-08 {VDD} 3.4100e-08 0)
venb_op1_1000_rl_s1_r10k_dp002p0 enb_op1_1000_rl_s1_r10k_dp002p0 0 pwl(0.0000e+00 {VDD} 1.1000e-08 {VDD} 1.1100e-08 0 3.4000e-08 0 3.4100e-08 {VDD})
vww_op1_1000_rl_s1_r10k_dp002p0 wwl_op1_1000_rl_s1_r10k_dp002p0 0 pwl(0.0000e+00 0 1.2000e-08 0 1.2100e-08 {VDD} 3.2000e-08 {VDD} 3.2100e-08 0)
vwc_op1_1000_rl_s1_r10k_dp002p0 wbc_op1_1000_rl_s1_r10k_dp002p0 0 pwl(0.0000e+00 0 1.2000e-08 0 1.2100e-08 {VDD} 3.4000e-08 {VDD} 3.4100e-08 0)
swb_op1_1000_rl_s1_r10k_dp002p0 ref_op1_1000_rl_s1_r10k_dp002p0 wbl_op1_1000_rl_s1_r10k_dp002p0 wbc_op1_1000_rl_s1_r10k_dp002p0 0 swwbl
cwbl_op1_1000_rl_s1_r10k_dp002p0 wbl_op1_1000_rl_s1_r10k_dp002p0 0 {C_WBL}
spa_op1_1000_rl_s1_r10k_dp002p0 prea rbl_op1_1000_rl_s1_r10k_dp002p0 ctl_op1_1000_rl_s1_r10k_dp002p0 0 swpre
spr_op1_1000_rl_s1_r10k_dp002p0 pref ref_op1_1000_rl_s1_r10k_dp002p0 ctl_op1_1000_rl_s1_r10k_dp002p0 0 swpre
crbl_op1_1000_rl_s1_r10k_dp002p0 rbl_op1_1000_rl_s1_r10k_dp002p0 0 {C_RBL}
cref_op1_1000_rl_s1_r10k_dp002p0 ref_op1_1000_rl_s1_r10k_dp002p0 0 {C_RBL}   $ ASSUMPTION: ideal matched dummy load
XMWR_op1_1000_rl_s1_r10k_dp002p0_0 sn_op1_1000_rl_s1_r10k_dp002p0_0 wwl_op1_1000_rl_s1_r10k_dp002p0 wbl_op1_1000_rl_s1_r10k_dp002p0 0 sky130_fd_pr__nfet_01v8 L=0.15 W=0.42 nf=1 ad=0.1218 as=0.1218 pd=1.42 ps=1.42 nrd=0.69047619047619  nrs=0.69047619047619 sa=0 sb=0 sd=0 mult=1 m=1
XMRD_op1_1000_rl_s1_r10k_dp002p0_0 rbl_op1_1000_rl_s1_r10k_dp002p0 sn_op1_1000_rl_s1_r10k_dp002p0_0 rwls_op1_1000_rl_s1_r10k_dp002p0 0 sky130_fd_pr__nfet_01v8 L=0.15 W=0.42 nf=1 ad=0.1218 as=0.1218 pd=1.42 ps=1.42 nrd=0.69047619047619  nrs=0.69047619047619 sa=0 sb=0 sd=0 mult=1 m=1
csn_op1_1000_rl_s1_r10k_dp002p0_0 sn_op1_1000_rl_s1_r10k_dp002p0_0 0 {C_SN}
XMWR_op1_1000_rl_s1_r10k_dp002p0_1 sn_op1_1000_rl_s1_r10k_dp002p0_1 wwl_des wbl_op1_1000_rl_s1_r10k_dp002p0 0 sky130_fd_pr__nfet_01v8 L=0.15 W=0.42 nf=1 ad=0.1218 as=0.1218 pd=1.42 ps=1.42 nrd=0.69047619047619  nrs=0.69047619047619 sa=0 sb=0 sd=0 mult=1 m=1
XMRD_op1_1000_rl_s1_r10k_dp002p0_1 rbl_op1_1000_rl_s1_r10k_dp002p0 sn_op1_1000_rl_s1_r10k_dp002p0_1 rwl_des 0 sky130_fd_pr__nfet_01v8 L=0.15 W=0.42 nf=1 ad=0.1218 as=0.1218 pd=1.42 ps=1.42 nrd=0.69047619047619  nrs=0.69047619047619 sa=0 sb=0 sd=0 mult=1 m=1
csn_op1_1000_rl_s1_r10k_dp002p0_1 sn_op1_1000_rl_s1_r10k_dp002p0_1 0 {C_SN}
XMWR_op1_1000_rl_s1_r10k_dp002p0_2 sn_op1_1000_rl_s1_r10k_dp002p0_2 wwl_des wbl_op1_1000_rl_s1_r10k_dp002p0 0 sky130_fd_pr__nfet_01v8 L=0.15 W=0.42 nf=1 ad=0.1218 as=0.1218 pd=1.42 ps=1.42 nrd=0.69047619047619  nrs=0.69047619047619 sa=0 sb=0 sd=0 mult=1 m=1
XMRD_op1_1000_rl_s1_r10k_dp002p0_2 rbl_op1_1000_rl_s1_r10k_dp002p0 sn_op1_1000_rl_s1_r10k_dp002p0_2 rwl_des 0 sky130_fd_pr__nfet_01v8 L=0.15 W=0.42 nf=1 ad=0.1218 as=0.1218 pd=1.42 ps=1.42 nrd=0.69047619047619  nrs=0.69047619047619 sa=0 sb=0 sd=0 mult=1 m=1
csn_op1_1000_rl_s1_r10k_dp002p0_2 sn_op1_1000_rl_s1_r10k_dp002p0_2 0 {C_SN}
XMWR_op1_1000_rl_s1_r10k_dp002p0_3 sn_op1_1000_rl_s1_r10k_dp002p0_3 wwl_des wbl_op1_1000_rl_s1_r10k_dp002p0 0 sky130_fd_pr__nfet_01v8 L=0.15 W=0.42 nf=1 ad=0.1218 as=0.1218 pd=1.42 ps=1.42 nrd=0.69047619047619  nrs=0.69047619047619 sa=0 sb=0 sd=0 mult=1 m=1
XMRD_op1_1000_rl_s1_r10k_dp002p0_3 rbl_op1_1000_rl_s1_r10k_dp002p0 sn_op1_1000_rl_s1_r10k_dp002p0_3 rwl_des 0 sky130_fd_pr__nfet_01v8 L=0.15 W=0.42 nf=1 ad=0.1218 as=0.1218 pd=1.42 ps=1.42 nrd=0.69047619047619  nrs=0.69047619047619 sa=0 sb=0 sd=0 mult=1 m=1
csn_op1_1000_rl_s1_r10k_dp002p0_3 sn_op1_1000_rl_s1_r10k_dp002p0_3 0 {C_SN}
XMN1_op1_1000_rl_s1_r10k_dp002p0 rbl_op1_1000_rl_s1_r10k_dp002p0 ref_op1_1000_rl_s1_r10k_dp002p0 vn_op1_1000_rl_s1_r10k_dp002p0 0 sky130_fd_pr__nfet_01v8 L=0.15 W=1 nf=1 ad=0.29 as=0.29 pd=2.58 ps=2.58 mult=1 m=1
XMN2_op1_1000_rl_s1_r10k_dp002p0 ref_op1_1000_rl_s1_r10k_dp002p0 rbl_op1_1000_rl_s1_r10k_dp002p0 vn_op1_1000_rl_s1_r10k_dp002p0 0 sky130_fd_pr__nfet_01v8 L=0.15 W=1 nf=1 ad=0.29 as=0.29 pd=2.58 ps=2.58 mult=1 m=1
XMP1_op1_1000_rl_s1_r10k_dp002p0 rbl_op1_1000_rl_s1_r10k_dp002p0 ref_op1_1000_rl_s1_r10k_dp002p0 vp_op1_1000_rl_s1_r10k_dp002p0 vdd sky130_fd_pr__pfet_01v8 L=0.15 W=2 nf=1 ad=0.58 as=0.58 pd=4.58 ps=4.58 mult=1 m=1
XMP2_op1_1000_rl_s1_r10k_dp002p0 ref_op1_1000_rl_s1_r10k_dp002p0 rbl_op1_1000_rl_s1_r10k_dp002p0 vp_op1_1000_rl_s1_r10k_dp002p0 vdd sky130_fd_pr__pfet_01v8 L=0.15 W=2 nf=1 ad=0.58 as=0.58 pd=4.58 ps=4.58 mult=1 m=1
XMNF_op1_1000_rl_s1_r10k_dp002p0 vn_op1_1000_rl_s1_r10k_dp002p0 en_op1_1000_rl_s1_r10k_dp002p0 0 0 sky130_fd_pr__nfet_01v8 L=0.15 W=2 nf=1 ad=0.58 as=0.58 pd=4.58 ps=4.58 mult=1 m=1
XMPH_op1_1000_rl_s1_r10k_dp002p0 vp_op1_1000_rl_s1_r10k_dp002p0 enb_op1_1000_rl_s1_r10k_dp002p0 vdd vdd sky130_fd_pr__pfet_01v8 L=0.15 W=4 nf=1 ad=1.16 as=1.16 pd=8.58 ps=8.58 mult=1 m=1
bd_op1_1000_rl_s1_r10k_dp002p0 d_op1_1000_rl_s1_r10k_dp002p0 0 v=v(rbl_op1_1000_rl_s1_r10k_dp002p0)-v(ref_op1_1000_rl_s1_r10k_dp002p0)

* ---- instance 279: op0_n100_rl_s1_r10k_dp002p0 (variant rl_s1_r10k_dp002p0; probe dec 11.9 ns, release 34 ns, meas 36 ns) ----
vctl_op0_n100_rl_s1_r10k_dp002p0 ctl_op0_n100_rl_s1_r10k_dp002p0 0 pwl(0.0000e+00 {VDD} 2.0000e-09 {VDD} 2.1000e-09 0)
* RWL driver model (EXPERIMENTAL): slew 1 ns, series R 10000 ohm; cell pin = rwls_op0_n100_rl_s1_r10k_dp002p0
vrs_op0_n100_rl_s1_r10k_dp002p0 rwlsrc_op0_n100_rl_s1_r10k_dp002p0 0 pwl(0.0000e+00 {VDD} 2.0000e-09 {VDD} 3.0000e-09 0 3.4000e-08 0 3.5000e-08 {VDD})
rdrv_op0_n100_rl_s1_r10k_dp002p0 rwlsrc_op0_n100_rl_s1_r10k_dp002p0 rwls_op0_n100_rl_s1_r10k_dp002p0 10000
ven_op0_n100_rl_s1_r10k_dp002p0 en_op0_n100_rl_s1_r10k_dp002p0 0 pwl(0.0000e+00 0 1.1000e-08 0 1.1100e-08 {VDD} 3.4000e-08 {VDD} 3.4100e-08 0)
venb_op0_n100_rl_s1_r10k_dp002p0 enb_op0_n100_rl_s1_r10k_dp002p0 0 pwl(0.0000e+00 {VDD} 1.1000e-08 {VDD} 1.1100e-08 0 3.4000e-08 0 3.4100e-08 {VDD})
vww_op0_n100_rl_s1_r10k_dp002p0 wwl_op0_n100_rl_s1_r10k_dp002p0 0 pwl(0.0000e+00 0 1.2000e-08 0 1.2100e-08 {VDD} 3.2000e-08 {VDD} 3.2100e-08 0)
vwc_op0_n100_rl_s1_r10k_dp002p0 wbc_op0_n100_rl_s1_r10k_dp002p0 0 pwl(0.0000e+00 0 1.2000e-08 0 1.2100e-08 {VDD} 3.4000e-08 {VDD} 3.4100e-08 0)
swb_op0_n100_rl_s1_r10k_dp002p0 ref_op0_n100_rl_s1_r10k_dp002p0 wbl_op0_n100_rl_s1_r10k_dp002p0 wbc_op0_n100_rl_s1_r10k_dp002p0 0 swwbl
cwbl_op0_n100_rl_s1_r10k_dp002p0 wbl_op0_n100_rl_s1_r10k_dp002p0 0 {C_WBL}
spa_op0_n100_rl_s1_r10k_dp002p0 prea rbl_op0_n100_rl_s1_r10k_dp002p0 ctl_op0_n100_rl_s1_r10k_dp002p0 0 swpre
spr_op0_n100_rl_s1_r10k_dp002p0 pref ref_op0_n100_rl_s1_r10k_dp002p0 ctl_op0_n100_rl_s1_r10k_dp002p0 0 swpre
crbl_op0_n100_rl_s1_r10k_dp002p0 rbl_op0_n100_rl_s1_r10k_dp002p0 0 {C_RBL}
cref_op0_n100_rl_s1_r10k_dp002p0 ref_op0_n100_rl_s1_r10k_dp002p0 0 {C_RBL}   $ ASSUMPTION: ideal matched dummy load
XMWR_op0_n100_rl_s1_r10k_dp002p0_0 sn_op0_n100_rl_s1_r10k_dp002p0_0 wwl_op0_n100_rl_s1_r10k_dp002p0 wbl_op0_n100_rl_s1_r10k_dp002p0 0 sky130_fd_pr__nfet_01v8 L=0.15 W=0.42 nf=1 ad=0.1218 as=0.1218 pd=1.42 ps=1.42 nrd=0.69047619047619  nrs=0.69047619047619 sa=0 sb=0 sd=0 mult=1 m=1
XMRD_op0_n100_rl_s1_r10k_dp002p0_0 rbl_op0_n100_rl_s1_r10k_dp002p0 sn_op0_n100_rl_s1_r10k_dp002p0_0 rwls_op0_n100_rl_s1_r10k_dp002p0 0 sky130_fd_pr__nfet_01v8 L=0.15 W=0.42 nf=1 ad=0.1218 as=0.1218 pd=1.42 ps=1.42 nrd=0.69047619047619  nrs=0.69047619047619 sa=0 sb=0 sd=0 mult=1 m=1
csn_op0_n100_rl_s1_r10k_dp002p0_0 sn_op0_n100_rl_s1_r10k_dp002p0_0 0 {C_SN}
XMWR_op0_n100_rl_s1_r10k_dp002p0_1 sn_op0_n100_rl_s1_r10k_dp002p0_1 wwl_des wbl_op0_n100_rl_s1_r10k_dp002p0 0 sky130_fd_pr__nfet_01v8 L=0.15 W=0.42 nf=1 ad=0.1218 as=0.1218 pd=1.42 ps=1.42 nrd=0.69047619047619  nrs=0.69047619047619 sa=0 sb=0 sd=0 mult=1 m=1
XMRD_op0_n100_rl_s1_r10k_dp002p0_1 rbl_op0_n100_rl_s1_r10k_dp002p0 sn_op0_n100_rl_s1_r10k_dp002p0_1 rwl_des 0 sky130_fd_pr__nfet_01v8 L=0.15 W=0.42 nf=1 ad=0.1218 as=0.1218 pd=1.42 ps=1.42 nrd=0.69047619047619  nrs=0.69047619047619 sa=0 sb=0 sd=0 mult=1 m=1
csn_op0_n100_rl_s1_r10k_dp002p0_1 sn_op0_n100_rl_s1_r10k_dp002p0_1 0 {C_SN}
XMWR_op0_n100_rl_s1_r10k_dp002p0_2 sn_op0_n100_rl_s1_r10k_dp002p0_2 wwl_des wbl_op0_n100_rl_s1_r10k_dp002p0 0 sky130_fd_pr__nfet_01v8 L=0.15 W=0.42 nf=1 ad=0.1218 as=0.1218 pd=1.42 ps=1.42 nrd=0.69047619047619  nrs=0.69047619047619 sa=0 sb=0 sd=0 mult=1 m=1
XMRD_op0_n100_rl_s1_r10k_dp002p0_2 rbl_op0_n100_rl_s1_r10k_dp002p0 sn_op0_n100_rl_s1_r10k_dp002p0_2 rwl_des 0 sky130_fd_pr__nfet_01v8 L=0.15 W=0.42 nf=1 ad=0.1218 as=0.1218 pd=1.42 ps=1.42 nrd=0.69047619047619  nrs=0.69047619047619 sa=0 sb=0 sd=0 mult=1 m=1
csn_op0_n100_rl_s1_r10k_dp002p0_2 sn_op0_n100_rl_s1_r10k_dp002p0_2 0 {C_SN}
XMWR_op0_n100_rl_s1_r10k_dp002p0_3 sn_op0_n100_rl_s1_r10k_dp002p0_3 wwl_des wbl_op0_n100_rl_s1_r10k_dp002p0 0 sky130_fd_pr__nfet_01v8 L=0.15 W=0.42 nf=1 ad=0.1218 as=0.1218 pd=1.42 ps=1.42 nrd=0.69047619047619  nrs=0.69047619047619 sa=0 sb=0 sd=0 mult=1 m=1
XMRD_op0_n100_rl_s1_r10k_dp002p0_3 rbl_op0_n100_rl_s1_r10k_dp002p0 sn_op0_n100_rl_s1_r10k_dp002p0_3 rwl_des 0 sky130_fd_pr__nfet_01v8 L=0.15 W=0.42 nf=1 ad=0.1218 as=0.1218 pd=1.42 ps=1.42 nrd=0.69047619047619  nrs=0.69047619047619 sa=0 sb=0 sd=0 mult=1 m=1
csn_op0_n100_rl_s1_r10k_dp002p0_3 sn_op0_n100_rl_s1_r10k_dp002p0_3 0 {C_SN}
XMN1_op0_n100_rl_s1_r10k_dp002p0 rbl_op0_n100_rl_s1_r10k_dp002p0 ref_op0_n100_rl_s1_r10k_dp002p0 vn_op0_n100_rl_s1_r10k_dp002p0 0 sky130_fd_pr__nfet_01v8 L=0.15 W=1 nf=1 ad=0.29 as=0.29 pd=2.58 ps=2.58 mult=1 m=1
XMN2_op0_n100_rl_s1_r10k_dp002p0 ref_op0_n100_rl_s1_r10k_dp002p0 rbl_op0_n100_rl_s1_r10k_dp002p0 vn_op0_n100_rl_s1_r10k_dp002p0 0 sky130_fd_pr__nfet_01v8 L=0.15 W=1 nf=1 ad=0.29 as=0.29 pd=2.58 ps=2.58 mult=1 m=1
XMP1_op0_n100_rl_s1_r10k_dp002p0 rbl_op0_n100_rl_s1_r10k_dp002p0 ref_op0_n100_rl_s1_r10k_dp002p0 vp_op0_n100_rl_s1_r10k_dp002p0 vdd sky130_fd_pr__pfet_01v8 L=0.15 W=2 nf=1 ad=0.58 as=0.58 pd=4.58 ps=4.58 mult=1 m=1
XMP2_op0_n100_rl_s1_r10k_dp002p0 ref_op0_n100_rl_s1_r10k_dp002p0 rbl_op0_n100_rl_s1_r10k_dp002p0 vp_op0_n100_rl_s1_r10k_dp002p0 vdd sky130_fd_pr__pfet_01v8 L=0.15 W=2 nf=1 ad=0.58 as=0.58 pd=4.58 ps=4.58 mult=1 m=1
XMNF_op0_n100_rl_s1_r10k_dp002p0 vn_op0_n100_rl_s1_r10k_dp002p0 en_op0_n100_rl_s1_r10k_dp002p0 0 0 sky130_fd_pr__nfet_01v8 L=0.15 W=2 nf=1 ad=0.58 as=0.58 pd=4.58 ps=4.58 mult=1 m=1
XMPH_op0_n100_rl_s1_r10k_dp002p0 vp_op0_n100_rl_s1_r10k_dp002p0 enb_op0_n100_rl_s1_r10k_dp002p0 vdd vdd sky130_fd_pr__pfet_01v8 L=0.15 W=4 nf=1 ad=1.16 as=1.16 pd=8.58 ps=8.58 mult=1 m=1
bd_op0_n100_rl_s1_r10k_dp002p0 d_op0_n100_rl_s1_r10k_dp002p0 0 v=v(rbl_op0_n100_rl_s1_r10k_dp002p0)-v(ref_op0_n100_rl_s1_r10k_dp002p0)

* ---- instance 280: op0_0000_rl_s1_r10k_dp002p0 (variant rl_s1_r10k_dp002p0; probe dec 11.9 ns, release 34 ns, meas 36 ns) ----
vctl_op0_0000_rl_s1_r10k_dp002p0 ctl_op0_0000_rl_s1_r10k_dp002p0 0 pwl(0.0000e+00 {VDD} 2.0000e-09 {VDD} 2.1000e-09 0)
* RWL driver model (EXPERIMENTAL): slew 1 ns, series R 10000 ohm; cell pin = rwls_op0_0000_rl_s1_r10k_dp002p0
vrs_op0_0000_rl_s1_r10k_dp002p0 rwlsrc_op0_0000_rl_s1_r10k_dp002p0 0 pwl(0.0000e+00 {VDD} 2.0000e-09 {VDD} 3.0000e-09 0 3.4000e-08 0 3.5000e-08 {VDD})
rdrv_op0_0000_rl_s1_r10k_dp002p0 rwlsrc_op0_0000_rl_s1_r10k_dp002p0 rwls_op0_0000_rl_s1_r10k_dp002p0 10000
ven_op0_0000_rl_s1_r10k_dp002p0 en_op0_0000_rl_s1_r10k_dp002p0 0 pwl(0.0000e+00 0 1.1000e-08 0 1.1100e-08 {VDD} 3.4000e-08 {VDD} 3.4100e-08 0)
venb_op0_0000_rl_s1_r10k_dp002p0 enb_op0_0000_rl_s1_r10k_dp002p0 0 pwl(0.0000e+00 {VDD} 1.1000e-08 {VDD} 1.1100e-08 0 3.4000e-08 0 3.4100e-08 {VDD})
vww_op0_0000_rl_s1_r10k_dp002p0 wwl_op0_0000_rl_s1_r10k_dp002p0 0 pwl(0.0000e+00 0 1.2000e-08 0 1.2100e-08 {VDD} 3.2000e-08 {VDD} 3.2100e-08 0)
vwc_op0_0000_rl_s1_r10k_dp002p0 wbc_op0_0000_rl_s1_r10k_dp002p0 0 pwl(0.0000e+00 0 1.2000e-08 0 1.2100e-08 {VDD} 3.4000e-08 {VDD} 3.4100e-08 0)
swb_op0_0000_rl_s1_r10k_dp002p0 ref_op0_0000_rl_s1_r10k_dp002p0 wbl_op0_0000_rl_s1_r10k_dp002p0 wbc_op0_0000_rl_s1_r10k_dp002p0 0 swwbl
cwbl_op0_0000_rl_s1_r10k_dp002p0 wbl_op0_0000_rl_s1_r10k_dp002p0 0 {C_WBL}
spa_op0_0000_rl_s1_r10k_dp002p0 prea rbl_op0_0000_rl_s1_r10k_dp002p0 ctl_op0_0000_rl_s1_r10k_dp002p0 0 swpre
spr_op0_0000_rl_s1_r10k_dp002p0 pref ref_op0_0000_rl_s1_r10k_dp002p0 ctl_op0_0000_rl_s1_r10k_dp002p0 0 swpre
crbl_op0_0000_rl_s1_r10k_dp002p0 rbl_op0_0000_rl_s1_r10k_dp002p0 0 {C_RBL}
cref_op0_0000_rl_s1_r10k_dp002p0 ref_op0_0000_rl_s1_r10k_dp002p0 0 {C_RBL}   $ ASSUMPTION: ideal matched dummy load
XMWR_op0_0000_rl_s1_r10k_dp002p0_0 sn_op0_0000_rl_s1_r10k_dp002p0_0 wwl_op0_0000_rl_s1_r10k_dp002p0 wbl_op0_0000_rl_s1_r10k_dp002p0 0 sky130_fd_pr__nfet_01v8 L=0.15 W=0.42 nf=1 ad=0.1218 as=0.1218 pd=1.42 ps=1.42 nrd=0.69047619047619  nrs=0.69047619047619 sa=0 sb=0 sd=0 mult=1 m=1
XMRD_op0_0000_rl_s1_r10k_dp002p0_0 rbl_op0_0000_rl_s1_r10k_dp002p0 sn_op0_0000_rl_s1_r10k_dp002p0_0 rwls_op0_0000_rl_s1_r10k_dp002p0 0 sky130_fd_pr__nfet_01v8 L=0.15 W=0.42 nf=1 ad=0.1218 as=0.1218 pd=1.42 ps=1.42 nrd=0.69047619047619  nrs=0.69047619047619 sa=0 sb=0 sd=0 mult=1 m=1
csn_op0_0000_rl_s1_r10k_dp002p0_0 sn_op0_0000_rl_s1_r10k_dp002p0_0 0 {C_SN}
XMWR_op0_0000_rl_s1_r10k_dp002p0_1 sn_op0_0000_rl_s1_r10k_dp002p0_1 wwl_des wbl_op0_0000_rl_s1_r10k_dp002p0 0 sky130_fd_pr__nfet_01v8 L=0.15 W=0.42 nf=1 ad=0.1218 as=0.1218 pd=1.42 ps=1.42 nrd=0.69047619047619  nrs=0.69047619047619 sa=0 sb=0 sd=0 mult=1 m=1
XMRD_op0_0000_rl_s1_r10k_dp002p0_1 rbl_op0_0000_rl_s1_r10k_dp002p0 sn_op0_0000_rl_s1_r10k_dp002p0_1 rwl_des 0 sky130_fd_pr__nfet_01v8 L=0.15 W=0.42 nf=1 ad=0.1218 as=0.1218 pd=1.42 ps=1.42 nrd=0.69047619047619  nrs=0.69047619047619 sa=0 sb=0 sd=0 mult=1 m=1
csn_op0_0000_rl_s1_r10k_dp002p0_1 sn_op0_0000_rl_s1_r10k_dp002p0_1 0 {C_SN}
XMWR_op0_0000_rl_s1_r10k_dp002p0_2 sn_op0_0000_rl_s1_r10k_dp002p0_2 wwl_des wbl_op0_0000_rl_s1_r10k_dp002p0 0 sky130_fd_pr__nfet_01v8 L=0.15 W=0.42 nf=1 ad=0.1218 as=0.1218 pd=1.42 ps=1.42 nrd=0.69047619047619  nrs=0.69047619047619 sa=0 sb=0 sd=0 mult=1 m=1
XMRD_op0_0000_rl_s1_r10k_dp002p0_2 rbl_op0_0000_rl_s1_r10k_dp002p0 sn_op0_0000_rl_s1_r10k_dp002p0_2 rwl_des 0 sky130_fd_pr__nfet_01v8 L=0.15 W=0.42 nf=1 ad=0.1218 as=0.1218 pd=1.42 ps=1.42 nrd=0.69047619047619  nrs=0.69047619047619 sa=0 sb=0 sd=0 mult=1 m=1
csn_op0_0000_rl_s1_r10k_dp002p0_2 sn_op0_0000_rl_s1_r10k_dp002p0_2 0 {C_SN}
XMWR_op0_0000_rl_s1_r10k_dp002p0_3 sn_op0_0000_rl_s1_r10k_dp002p0_3 wwl_des wbl_op0_0000_rl_s1_r10k_dp002p0 0 sky130_fd_pr__nfet_01v8 L=0.15 W=0.42 nf=1 ad=0.1218 as=0.1218 pd=1.42 ps=1.42 nrd=0.69047619047619  nrs=0.69047619047619 sa=0 sb=0 sd=0 mult=1 m=1
XMRD_op0_0000_rl_s1_r10k_dp002p0_3 rbl_op0_0000_rl_s1_r10k_dp002p0 sn_op0_0000_rl_s1_r10k_dp002p0_3 rwl_des 0 sky130_fd_pr__nfet_01v8 L=0.15 W=0.42 nf=1 ad=0.1218 as=0.1218 pd=1.42 ps=1.42 nrd=0.69047619047619  nrs=0.69047619047619 sa=0 sb=0 sd=0 mult=1 m=1
csn_op0_0000_rl_s1_r10k_dp002p0_3 sn_op0_0000_rl_s1_r10k_dp002p0_3 0 {C_SN}
XMN1_op0_0000_rl_s1_r10k_dp002p0 rbl_op0_0000_rl_s1_r10k_dp002p0 ref_op0_0000_rl_s1_r10k_dp002p0 vn_op0_0000_rl_s1_r10k_dp002p0 0 sky130_fd_pr__nfet_01v8 L=0.15 W=1 nf=1 ad=0.29 as=0.29 pd=2.58 ps=2.58 mult=1 m=1
XMN2_op0_0000_rl_s1_r10k_dp002p0 ref_op0_0000_rl_s1_r10k_dp002p0 rbl_op0_0000_rl_s1_r10k_dp002p0 vn_op0_0000_rl_s1_r10k_dp002p0 0 sky130_fd_pr__nfet_01v8 L=0.15 W=1 nf=1 ad=0.29 as=0.29 pd=2.58 ps=2.58 mult=1 m=1
XMP1_op0_0000_rl_s1_r10k_dp002p0 rbl_op0_0000_rl_s1_r10k_dp002p0 ref_op0_0000_rl_s1_r10k_dp002p0 vp_op0_0000_rl_s1_r10k_dp002p0 vdd sky130_fd_pr__pfet_01v8 L=0.15 W=2 nf=1 ad=0.58 as=0.58 pd=4.58 ps=4.58 mult=1 m=1
XMP2_op0_0000_rl_s1_r10k_dp002p0 ref_op0_0000_rl_s1_r10k_dp002p0 rbl_op0_0000_rl_s1_r10k_dp002p0 vp_op0_0000_rl_s1_r10k_dp002p0 vdd sky130_fd_pr__pfet_01v8 L=0.15 W=2 nf=1 ad=0.58 as=0.58 pd=4.58 ps=4.58 mult=1 m=1
XMNF_op0_0000_rl_s1_r10k_dp002p0 vn_op0_0000_rl_s1_r10k_dp002p0 en_op0_0000_rl_s1_r10k_dp002p0 0 0 sky130_fd_pr__nfet_01v8 L=0.15 W=2 nf=1 ad=0.58 as=0.58 pd=4.58 ps=4.58 mult=1 m=1
XMPH_op0_0000_rl_s1_r10k_dp002p0 vp_op0_0000_rl_s1_r10k_dp002p0 enb_op0_0000_rl_s1_r10k_dp002p0 vdd vdd sky130_fd_pr__pfet_01v8 L=0.15 W=4 nf=1 ad=1.16 as=1.16 pd=8.58 ps=8.58 mult=1 m=1
bd_op0_0000_rl_s1_r10k_dp002p0 d_op0_0000_rl_s1_r10k_dp002p0 0 v=v(rbl_op0_0000_rl_s1_r10k_dp002p0)-v(ref_op0_0000_rl_s1_r10k_dp002p0)

* ---- instance 281: op1_0900_rl_s1_r10k_dp003p0 (variant rl_s1_r10k_dp003p0; probe dec 11.9 ns, release 35 ns, meas 36 ns) ----
vctl_op1_0900_rl_s1_r10k_dp003p0 ctl_op1_0900_rl_s1_r10k_dp003p0 0 pwl(0.0000e+00 {VDD} 2.0000e-09 {VDD} 2.1000e-09 0)
* RWL driver model (EXPERIMENTAL): slew 1 ns, series R 10000 ohm; cell pin = rwls_op1_0900_rl_s1_r10k_dp003p0
vrs_op1_0900_rl_s1_r10k_dp003p0 rwlsrc_op1_0900_rl_s1_r10k_dp003p0 0 pwl(0.0000e+00 {VDD} 2.0000e-09 {VDD} 3.0000e-09 0 3.5000e-08 0 3.6000e-08 {VDD})
rdrv_op1_0900_rl_s1_r10k_dp003p0 rwlsrc_op1_0900_rl_s1_r10k_dp003p0 rwls_op1_0900_rl_s1_r10k_dp003p0 10000
ven_op1_0900_rl_s1_r10k_dp003p0 en_op1_0900_rl_s1_r10k_dp003p0 0 pwl(0.0000e+00 0 1.1000e-08 0 1.1100e-08 {VDD} 3.4000e-08 {VDD} 3.4100e-08 0)
venb_op1_0900_rl_s1_r10k_dp003p0 enb_op1_0900_rl_s1_r10k_dp003p0 0 pwl(0.0000e+00 {VDD} 1.1000e-08 {VDD} 1.1100e-08 0 3.4000e-08 0 3.4100e-08 {VDD})
vww_op1_0900_rl_s1_r10k_dp003p0 wwl_op1_0900_rl_s1_r10k_dp003p0 0 pwl(0.0000e+00 0 1.2000e-08 0 1.2100e-08 {VDD} 3.2000e-08 {VDD} 3.2100e-08 0)
vwc_op1_0900_rl_s1_r10k_dp003p0 wbc_op1_0900_rl_s1_r10k_dp003p0 0 pwl(0.0000e+00 0 1.2000e-08 0 1.2100e-08 {VDD} 3.4000e-08 {VDD} 3.4100e-08 0)
swb_op1_0900_rl_s1_r10k_dp003p0 ref_op1_0900_rl_s1_r10k_dp003p0 wbl_op1_0900_rl_s1_r10k_dp003p0 wbc_op1_0900_rl_s1_r10k_dp003p0 0 swwbl
cwbl_op1_0900_rl_s1_r10k_dp003p0 wbl_op1_0900_rl_s1_r10k_dp003p0 0 {C_WBL}
spa_op1_0900_rl_s1_r10k_dp003p0 prea rbl_op1_0900_rl_s1_r10k_dp003p0 ctl_op1_0900_rl_s1_r10k_dp003p0 0 swpre
spr_op1_0900_rl_s1_r10k_dp003p0 pref ref_op1_0900_rl_s1_r10k_dp003p0 ctl_op1_0900_rl_s1_r10k_dp003p0 0 swpre
crbl_op1_0900_rl_s1_r10k_dp003p0 rbl_op1_0900_rl_s1_r10k_dp003p0 0 {C_RBL}
cref_op1_0900_rl_s1_r10k_dp003p0 ref_op1_0900_rl_s1_r10k_dp003p0 0 {C_RBL}   $ ASSUMPTION: ideal matched dummy load
XMWR_op1_0900_rl_s1_r10k_dp003p0_0 sn_op1_0900_rl_s1_r10k_dp003p0_0 wwl_op1_0900_rl_s1_r10k_dp003p0 wbl_op1_0900_rl_s1_r10k_dp003p0 0 sky130_fd_pr__nfet_01v8 L=0.15 W=0.42 nf=1 ad=0.1218 as=0.1218 pd=1.42 ps=1.42 nrd=0.69047619047619  nrs=0.69047619047619 sa=0 sb=0 sd=0 mult=1 m=1
XMRD_op1_0900_rl_s1_r10k_dp003p0_0 rbl_op1_0900_rl_s1_r10k_dp003p0 sn_op1_0900_rl_s1_r10k_dp003p0_0 rwls_op1_0900_rl_s1_r10k_dp003p0 0 sky130_fd_pr__nfet_01v8 L=0.15 W=0.42 nf=1 ad=0.1218 as=0.1218 pd=1.42 ps=1.42 nrd=0.69047619047619  nrs=0.69047619047619 sa=0 sb=0 sd=0 mult=1 m=1
csn_op1_0900_rl_s1_r10k_dp003p0_0 sn_op1_0900_rl_s1_r10k_dp003p0_0 0 {C_SN}
XMWR_op1_0900_rl_s1_r10k_dp003p0_1 sn_op1_0900_rl_s1_r10k_dp003p0_1 wwl_des wbl_op1_0900_rl_s1_r10k_dp003p0 0 sky130_fd_pr__nfet_01v8 L=0.15 W=0.42 nf=1 ad=0.1218 as=0.1218 pd=1.42 ps=1.42 nrd=0.69047619047619  nrs=0.69047619047619 sa=0 sb=0 sd=0 mult=1 m=1
XMRD_op1_0900_rl_s1_r10k_dp003p0_1 rbl_op1_0900_rl_s1_r10k_dp003p0 sn_op1_0900_rl_s1_r10k_dp003p0_1 rwl_des 0 sky130_fd_pr__nfet_01v8 L=0.15 W=0.42 nf=1 ad=0.1218 as=0.1218 pd=1.42 ps=1.42 nrd=0.69047619047619  nrs=0.69047619047619 sa=0 sb=0 sd=0 mult=1 m=1
csn_op1_0900_rl_s1_r10k_dp003p0_1 sn_op1_0900_rl_s1_r10k_dp003p0_1 0 {C_SN}
XMWR_op1_0900_rl_s1_r10k_dp003p0_2 sn_op1_0900_rl_s1_r10k_dp003p0_2 wwl_des wbl_op1_0900_rl_s1_r10k_dp003p0 0 sky130_fd_pr__nfet_01v8 L=0.15 W=0.42 nf=1 ad=0.1218 as=0.1218 pd=1.42 ps=1.42 nrd=0.69047619047619  nrs=0.69047619047619 sa=0 sb=0 sd=0 mult=1 m=1
XMRD_op1_0900_rl_s1_r10k_dp003p0_2 rbl_op1_0900_rl_s1_r10k_dp003p0 sn_op1_0900_rl_s1_r10k_dp003p0_2 rwl_des 0 sky130_fd_pr__nfet_01v8 L=0.15 W=0.42 nf=1 ad=0.1218 as=0.1218 pd=1.42 ps=1.42 nrd=0.69047619047619  nrs=0.69047619047619 sa=0 sb=0 sd=0 mult=1 m=1
csn_op1_0900_rl_s1_r10k_dp003p0_2 sn_op1_0900_rl_s1_r10k_dp003p0_2 0 {C_SN}
XMWR_op1_0900_rl_s1_r10k_dp003p0_3 sn_op1_0900_rl_s1_r10k_dp003p0_3 wwl_des wbl_op1_0900_rl_s1_r10k_dp003p0 0 sky130_fd_pr__nfet_01v8 L=0.15 W=0.42 nf=1 ad=0.1218 as=0.1218 pd=1.42 ps=1.42 nrd=0.69047619047619  nrs=0.69047619047619 sa=0 sb=0 sd=0 mult=1 m=1
XMRD_op1_0900_rl_s1_r10k_dp003p0_3 rbl_op1_0900_rl_s1_r10k_dp003p0 sn_op1_0900_rl_s1_r10k_dp003p0_3 rwl_des 0 sky130_fd_pr__nfet_01v8 L=0.15 W=0.42 nf=1 ad=0.1218 as=0.1218 pd=1.42 ps=1.42 nrd=0.69047619047619  nrs=0.69047619047619 sa=0 sb=0 sd=0 mult=1 m=1
csn_op1_0900_rl_s1_r10k_dp003p0_3 sn_op1_0900_rl_s1_r10k_dp003p0_3 0 {C_SN}
XMN1_op1_0900_rl_s1_r10k_dp003p0 rbl_op1_0900_rl_s1_r10k_dp003p0 ref_op1_0900_rl_s1_r10k_dp003p0 vn_op1_0900_rl_s1_r10k_dp003p0 0 sky130_fd_pr__nfet_01v8 L=0.15 W=1 nf=1 ad=0.29 as=0.29 pd=2.58 ps=2.58 mult=1 m=1
XMN2_op1_0900_rl_s1_r10k_dp003p0 ref_op1_0900_rl_s1_r10k_dp003p0 rbl_op1_0900_rl_s1_r10k_dp003p0 vn_op1_0900_rl_s1_r10k_dp003p0 0 sky130_fd_pr__nfet_01v8 L=0.15 W=1 nf=1 ad=0.29 as=0.29 pd=2.58 ps=2.58 mult=1 m=1
XMP1_op1_0900_rl_s1_r10k_dp003p0 rbl_op1_0900_rl_s1_r10k_dp003p0 ref_op1_0900_rl_s1_r10k_dp003p0 vp_op1_0900_rl_s1_r10k_dp003p0 vdd sky130_fd_pr__pfet_01v8 L=0.15 W=2 nf=1 ad=0.58 as=0.58 pd=4.58 ps=4.58 mult=1 m=1
XMP2_op1_0900_rl_s1_r10k_dp003p0 ref_op1_0900_rl_s1_r10k_dp003p0 rbl_op1_0900_rl_s1_r10k_dp003p0 vp_op1_0900_rl_s1_r10k_dp003p0 vdd sky130_fd_pr__pfet_01v8 L=0.15 W=2 nf=1 ad=0.58 as=0.58 pd=4.58 ps=4.58 mult=1 m=1
XMNF_op1_0900_rl_s1_r10k_dp003p0 vn_op1_0900_rl_s1_r10k_dp003p0 en_op1_0900_rl_s1_r10k_dp003p0 0 0 sky130_fd_pr__nfet_01v8 L=0.15 W=2 nf=1 ad=0.58 as=0.58 pd=4.58 ps=4.58 mult=1 m=1
XMPH_op1_0900_rl_s1_r10k_dp003p0 vp_op1_0900_rl_s1_r10k_dp003p0 enb_op1_0900_rl_s1_r10k_dp003p0 vdd vdd sky130_fd_pr__pfet_01v8 L=0.15 W=4 nf=1 ad=1.16 as=1.16 pd=8.58 ps=8.58 mult=1 m=1
bd_op1_0900_rl_s1_r10k_dp003p0 d_op1_0900_rl_s1_r10k_dp003p0 0 v=v(rbl_op1_0900_rl_s1_r10k_dp003p0)-v(ref_op1_0900_rl_s1_r10k_dp003p0)

* ---- instance 282: op1_1000_rl_s1_r10k_dp003p0 (variant rl_s1_r10k_dp003p0; probe dec 11.9 ns, release 35 ns, meas 36 ns) ----
vctl_op1_1000_rl_s1_r10k_dp003p0 ctl_op1_1000_rl_s1_r10k_dp003p0 0 pwl(0.0000e+00 {VDD} 2.0000e-09 {VDD} 2.1000e-09 0)
* RWL driver model (EXPERIMENTAL): slew 1 ns, series R 10000 ohm; cell pin = rwls_op1_1000_rl_s1_r10k_dp003p0
vrs_op1_1000_rl_s1_r10k_dp003p0 rwlsrc_op1_1000_rl_s1_r10k_dp003p0 0 pwl(0.0000e+00 {VDD} 2.0000e-09 {VDD} 3.0000e-09 0 3.5000e-08 0 3.6000e-08 {VDD})
rdrv_op1_1000_rl_s1_r10k_dp003p0 rwlsrc_op1_1000_rl_s1_r10k_dp003p0 rwls_op1_1000_rl_s1_r10k_dp003p0 10000
ven_op1_1000_rl_s1_r10k_dp003p0 en_op1_1000_rl_s1_r10k_dp003p0 0 pwl(0.0000e+00 0 1.1000e-08 0 1.1100e-08 {VDD} 3.4000e-08 {VDD} 3.4100e-08 0)
venb_op1_1000_rl_s1_r10k_dp003p0 enb_op1_1000_rl_s1_r10k_dp003p0 0 pwl(0.0000e+00 {VDD} 1.1000e-08 {VDD} 1.1100e-08 0 3.4000e-08 0 3.4100e-08 {VDD})
vww_op1_1000_rl_s1_r10k_dp003p0 wwl_op1_1000_rl_s1_r10k_dp003p0 0 pwl(0.0000e+00 0 1.2000e-08 0 1.2100e-08 {VDD} 3.2000e-08 {VDD} 3.2100e-08 0)
vwc_op1_1000_rl_s1_r10k_dp003p0 wbc_op1_1000_rl_s1_r10k_dp003p0 0 pwl(0.0000e+00 0 1.2000e-08 0 1.2100e-08 {VDD} 3.4000e-08 {VDD} 3.4100e-08 0)
swb_op1_1000_rl_s1_r10k_dp003p0 ref_op1_1000_rl_s1_r10k_dp003p0 wbl_op1_1000_rl_s1_r10k_dp003p0 wbc_op1_1000_rl_s1_r10k_dp003p0 0 swwbl
cwbl_op1_1000_rl_s1_r10k_dp003p0 wbl_op1_1000_rl_s1_r10k_dp003p0 0 {C_WBL}
spa_op1_1000_rl_s1_r10k_dp003p0 prea rbl_op1_1000_rl_s1_r10k_dp003p0 ctl_op1_1000_rl_s1_r10k_dp003p0 0 swpre
spr_op1_1000_rl_s1_r10k_dp003p0 pref ref_op1_1000_rl_s1_r10k_dp003p0 ctl_op1_1000_rl_s1_r10k_dp003p0 0 swpre
crbl_op1_1000_rl_s1_r10k_dp003p0 rbl_op1_1000_rl_s1_r10k_dp003p0 0 {C_RBL}
cref_op1_1000_rl_s1_r10k_dp003p0 ref_op1_1000_rl_s1_r10k_dp003p0 0 {C_RBL}   $ ASSUMPTION: ideal matched dummy load
XMWR_op1_1000_rl_s1_r10k_dp003p0_0 sn_op1_1000_rl_s1_r10k_dp003p0_0 wwl_op1_1000_rl_s1_r10k_dp003p0 wbl_op1_1000_rl_s1_r10k_dp003p0 0 sky130_fd_pr__nfet_01v8 L=0.15 W=0.42 nf=1 ad=0.1218 as=0.1218 pd=1.42 ps=1.42 nrd=0.69047619047619  nrs=0.69047619047619 sa=0 sb=0 sd=0 mult=1 m=1
XMRD_op1_1000_rl_s1_r10k_dp003p0_0 rbl_op1_1000_rl_s1_r10k_dp003p0 sn_op1_1000_rl_s1_r10k_dp003p0_0 rwls_op1_1000_rl_s1_r10k_dp003p0 0 sky130_fd_pr__nfet_01v8 L=0.15 W=0.42 nf=1 ad=0.1218 as=0.1218 pd=1.42 ps=1.42 nrd=0.69047619047619  nrs=0.69047619047619 sa=0 sb=0 sd=0 mult=1 m=1
csn_op1_1000_rl_s1_r10k_dp003p0_0 sn_op1_1000_rl_s1_r10k_dp003p0_0 0 {C_SN}
XMWR_op1_1000_rl_s1_r10k_dp003p0_1 sn_op1_1000_rl_s1_r10k_dp003p0_1 wwl_des wbl_op1_1000_rl_s1_r10k_dp003p0 0 sky130_fd_pr__nfet_01v8 L=0.15 W=0.42 nf=1 ad=0.1218 as=0.1218 pd=1.42 ps=1.42 nrd=0.69047619047619  nrs=0.69047619047619 sa=0 sb=0 sd=0 mult=1 m=1
XMRD_op1_1000_rl_s1_r10k_dp003p0_1 rbl_op1_1000_rl_s1_r10k_dp003p0 sn_op1_1000_rl_s1_r10k_dp003p0_1 rwl_des 0 sky130_fd_pr__nfet_01v8 L=0.15 W=0.42 nf=1 ad=0.1218 as=0.1218 pd=1.42 ps=1.42 nrd=0.69047619047619  nrs=0.69047619047619 sa=0 sb=0 sd=0 mult=1 m=1
csn_op1_1000_rl_s1_r10k_dp003p0_1 sn_op1_1000_rl_s1_r10k_dp003p0_1 0 {C_SN}
XMWR_op1_1000_rl_s1_r10k_dp003p0_2 sn_op1_1000_rl_s1_r10k_dp003p0_2 wwl_des wbl_op1_1000_rl_s1_r10k_dp003p0 0 sky130_fd_pr__nfet_01v8 L=0.15 W=0.42 nf=1 ad=0.1218 as=0.1218 pd=1.42 ps=1.42 nrd=0.69047619047619  nrs=0.69047619047619 sa=0 sb=0 sd=0 mult=1 m=1
XMRD_op1_1000_rl_s1_r10k_dp003p0_2 rbl_op1_1000_rl_s1_r10k_dp003p0 sn_op1_1000_rl_s1_r10k_dp003p0_2 rwl_des 0 sky130_fd_pr__nfet_01v8 L=0.15 W=0.42 nf=1 ad=0.1218 as=0.1218 pd=1.42 ps=1.42 nrd=0.69047619047619  nrs=0.69047619047619 sa=0 sb=0 sd=0 mult=1 m=1
csn_op1_1000_rl_s1_r10k_dp003p0_2 sn_op1_1000_rl_s1_r10k_dp003p0_2 0 {C_SN}
XMWR_op1_1000_rl_s1_r10k_dp003p0_3 sn_op1_1000_rl_s1_r10k_dp003p0_3 wwl_des wbl_op1_1000_rl_s1_r10k_dp003p0 0 sky130_fd_pr__nfet_01v8 L=0.15 W=0.42 nf=1 ad=0.1218 as=0.1218 pd=1.42 ps=1.42 nrd=0.69047619047619  nrs=0.69047619047619 sa=0 sb=0 sd=0 mult=1 m=1
XMRD_op1_1000_rl_s1_r10k_dp003p0_3 rbl_op1_1000_rl_s1_r10k_dp003p0 sn_op1_1000_rl_s1_r10k_dp003p0_3 rwl_des 0 sky130_fd_pr__nfet_01v8 L=0.15 W=0.42 nf=1 ad=0.1218 as=0.1218 pd=1.42 ps=1.42 nrd=0.69047619047619  nrs=0.69047619047619 sa=0 sb=0 sd=0 mult=1 m=1
csn_op1_1000_rl_s1_r10k_dp003p0_3 sn_op1_1000_rl_s1_r10k_dp003p0_3 0 {C_SN}
XMN1_op1_1000_rl_s1_r10k_dp003p0 rbl_op1_1000_rl_s1_r10k_dp003p0 ref_op1_1000_rl_s1_r10k_dp003p0 vn_op1_1000_rl_s1_r10k_dp003p0 0 sky130_fd_pr__nfet_01v8 L=0.15 W=1 nf=1 ad=0.29 as=0.29 pd=2.58 ps=2.58 mult=1 m=1
XMN2_op1_1000_rl_s1_r10k_dp003p0 ref_op1_1000_rl_s1_r10k_dp003p0 rbl_op1_1000_rl_s1_r10k_dp003p0 vn_op1_1000_rl_s1_r10k_dp003p0 0 sky130_fd_pr__nfet_01v8 L=0.15 W=1 nf=1 ad=0.29 as=0.29 pd=2.58 ps=2.58 mult=1 m=1
XMP1_op1_1000_rl_s1_r10k_dp003p0 rbl_op1_1000_rl_s1_r10k_dp003p0 ref_op1_1000_rl_s1_r10k_dp003p0 vp_op1_1000_rl_s1_r10k_dp003p0 vdd sky130_fd_pr__pfet_01v8 L=0.15 W=2 nf=1 ad=0.58 as=0.58 pd=4.58 ps=4.58 mult=1 m=1
XMP2_op1_1000_rl_s1_r10k_dp003p0 ref_op1_1000_rl_s1_r10k_dp003p0 rbl_op1_1000_rl_s1_r10k_dp003p0 vp_op1_1000_rl_s1_r10k_dp003p0 vdd sky130_fd_pr__pfet_01v8 L=0.15 W=2 nf=1 ad=0.58 as=0.58 pd=4.58 ps=4.58 mult=1 m=1
XMNF_op1_1000_rl_s1_r10k_dp003p0 vn_op1_1000_rl_s1_r10k_dp003p0 en_op1_1000_rl_s1_r10k_dp003p0 0 0 sky130_fd_pr__nfet_01v8 L=0.15 W=2 nf=1 ad=0.58 as=0.58 pd=4.58 ps=4.58 mult=1 m=1
XMPH_op1_1000_rl_s1_r10k_dp003p0 vp_op1_1000_rl_s1_r10k_dp003p0 enb_op1_1000_rl_s1_r10k_dp003p0 vdd vdd sky130_fd_pr__pfet_01v8 L=0.15 W=4 nf=1 ad=1.16 as=1.16 pd=8.58 ps=8.58 mult=1 m=1
bd_op1_1000_rl_s1_r10k_dp003p0 d_op1_1000_rl_s1_r10k_dp003p0 0 v=v(rbl_op1_1000_rl_s1_r10k_dp003p0)-v(ref_op1_1000_rl_s1_r10k_dp003p0)

* ---- instance 283: op0_n100_rl_s1_r10k_dp003p0 (variant rl_s1_r10k_dp003p0; probe dec 11.9 ns, release 35 ns, meas 36 ns) ----
vctl_op0_n100_rl_s1_r10k_dp003p0 ctl_op0_n100_rl_s1_r10k_dp003p0 0 pwl(0.0000e+00 {VDD} 2.0000e-09 {VDD} 2.1000e-09 0)
* RWL driver model (EXPERIMENTAL): slew 1 ns, series R 10000 ohm; cell pin = rwls_op0_n100_rl_s1_r10k_dp003p0
vrs_op0_n100_rl_s1_r10k_dp003p0 rwlsrc_op0_n100_rl_s1_r10k_dp003p0 0 pwl(0.0000e+00 {VDD} 2.0000e-09 {VDD} 3.0000e-09 0 3.5000e-08 0 3.6000e-08 {VDD})
rdrv_op0_n100_rl_s1_r10k_dp003p0 rwlsrc_op0_n100_rl_s1_r10k_dp003p0 rwls_op0_n100_rl_s1_r10k_dp003p0 10000
ven_op0_n100_rl_s1_r10k_dp003p0 en_op0_n100_rl_s1_r10k_dp003p0 0 pwl(0.0000e+00 0 1.1000e-08 0 1.1100e-08 {VDD} 3.4000e-08 {VDD} 3.4100e-08 0)
venb_op0_n100_rl_s1_r10k_dp003p0 enb_op0_n100_rl_s1_r10k_dp003p0 0 pwl(0.0000e+00 {VDD} 1.1000e-08 {VDD} 1.1100e-08 0 3.4000e-08 0 3.4100e-08 {VDD})
vww_op0_n100_rl_s1_r10k_dp003p0 wwl_op0_n100_rl_s1_r10k_dp003p0 0 pwl(0.0000e+00 0 1.2000e-08 0 1.2100e-08 {VDD} 3.2000e-08 {VDD} 3.2100e-08 0)
vwc_op0_n100_rl_s1_r10k_dp003p0 wbc_op0_n100_rl_s1_r10k_dp003p0 0 pwl(0.0000e+00 0 1.2000e-08 0 1.2100e-08 {VDD} 3.4000e-08 {VDD} 3.4100e-08 0)
swb_op0_n100_rl_s1_r10k_dp003p0 ref_op0_n100_rl_s1_r10k_dp003p0 wbl_op0_n100_rl_s1_r10k_dp003p0 wbc_op0_n100_rl_s1_r10k_dp003p0 0 swwbl
cwbl_op0_n100_rl_s1_r10k_dp003p0 wbl_op0_n100_rl_s1_r10k_dp003p0 0 {C_WBL}
spa_op0_n100_rl_s1_r10k_dp003p0 prea rbl_op0_n100_rl_s1_r10k_dp003p0 ctl_op0_n100_rl_s1_r10k_dp003p0 0 swpre
spr_op0_n100_rl_s1_r10k_dp003p0 pref ref_op0_n100_rl_s1_r10k_dp003p0 ctl_op0_n100_rl_s1_r10k_dp003p0 0 swpre
crbl_op0_n100_rl_s1_r10k_dp003p0 rbl_op0_n100_rl_s1_r10k_dp003p0 0 {C_RBL}
cref_op0_n100_rl_s1_r10k_dp003p0 ref_op0_n100_rl_s1_r10k_dp003p0 0 {C_RBL}   $ ASSUMPTION: ideal matched dummy load
XMWR_op0_n100_rl_s1_r10k_dp003p0_0 sn_op0_n100_rl_s1_r10k_dp003p0_0 wwl_op0_n100_rl_s1_r10k_dp003p0 wbl_op0_n100_rl_s1_r10k_dp003p0 0 sky130_fd_pr__nfet_01v8 L=0.15 W=0.42 nf=1 ad=0.1218 as=0.1218 pd=1.42 ps=1.42 nrd=0.69047619047619  nrs=0.69047619047619 sa=0 sb=0 sd=0 mult=1 m=1
XMRD_op0_n100_rl_s1_r10k_dp003p0_0 rbl_op0_n100_rl_s1_r10k_dp003p0 sn_op0_n100_rl_s1_r10k_dp003p0_0 rwls_op0_n100_rl_s1_r10k_dp003p0 0 sky130_fd_pr__nfet_01v8 L=0.15 W=0.42 nf=1 ad=0.1218 as=0.1218 pd=1.42 ps=1.42 nrd=0.69047619047619  nrs=0.69047619047619 sa=0 sb=0 sd=0 mult=1 m=1
csn_op0_n100_rl_s1_r10k_dp003p0_0 sn_op0_n100_rl_s1_r10k_dp003p0_0 0 {C_SN}
XMWR_op0_n100_rl_s1_r10k_dp003p0_1 sn_op0_n100_rl_s1_r10k_dp003p0_1 wwl_des wbl_op0_n100_rl_s1_r10k_dp003p0 0 sky130_fd_pr__nfet_01v8 L=0.15 W=0.42 nf=1 ad=0.1218 as=0.1218 pd=1.42 ps=1.42 nrd=0.69047619047619  nrs=0.69047619047619 sa=0 sb=0 sd=0 mult=1 m=1
XMRD_op0_n100_rl_s1_r10k_dp003p0_1 rbl_op0_n100_rl_s1_r10k_dp003p0 sn_op0_n100_rl_s1_r10k_dp003p0_1 rwl_des 0 sky130_fd_pr__nfet_01v8 L=0.15 W=0.42 nf=1 ad=0.1218 as=0.1218 pd=1.42 ps=1.42 nrd=0.69047619047619  nrs=0.69047619047619 sa=0 sb=0 sd=0 mult=1 m=1
csn_op0_n100_rl_s1_r10k_dp003p0_1 sn_op0_n100_rl_s1_r10k_dp003p0_1 0 {C_SN}
XMWR_op0_n100_rl_s1_r10k_dp003p0_2 sn_op0_n100_rl_s1_r10k_dp003p0_2 wwl_des wbl_op0_n100_rl_s1_r10k_dp003p0 0 sky130_fd_pr__nfet_01v8 L=0.15 W=0.42 nf=1 ad=0.1218 as=0.1218 pd=1.42 ps=1.42 nrd=0.69047619047619  nrs=0.69047619047619 sa=0 sb=0 sd=0 mult=1 m=1
XMRD_op0_n100_rl_s1_r10k_dp003p0_2 rbl_op0_n100_rl_s1_r10k_dp003p0 sn_op0_n100_rl_s1_r10k_dp003p0_2 rwl_des 0 sky130_fd_pr__nfet_01v8 L=0.15 W=0.42 nf=1 ad=0.1218 as=0.1218 pd=1.42 ps=1.42 nrd=0.69047619047619  nrs=0.69047619047619 sa=0 sb=0 sd=0 mult=1 m=1
csn_op0_n100_rl_s1_r10k_dp003p0_2 sn_op0_n100_rl_s1_r10k_dp003p0_2 0 {C_SN}
XMWR_op0_n100_rl_s1_r10k_dp003p0_3 sn_op0_n100_rl_s1_r10k_dp003p0_3 wwl_des wbl_op0_n100_rl_s1_r10k_dp003p0 0 sky130_fd_pr__nfet_01v8 L=0.15 W=0.42 nf=1 ad=0.1218 as=0.1218 pd=1.42 ps=1.42 nrd=0.69047619047619  nrs=0.69047619047619 sa=0 sb=0 sd=0 mult=1 m=1
XMRD_op0_n100_rl_s1_r10k_dp003p0_3 rbl_op0_n100_rl_s1_r10k_dp003p0 sn_op0_n100_rl_s1_r10k_dp003p0_3 rwl_des 0 sky130_fd_pr__nfet_01v8 L=0.15 W=0.42 nf=1 ad=0.1218 as=0.1218 pd=1.42 ps=1.42 nrd=0.69047619047619  nrs=0.69047619047619 sa=0 sb=0 sd=0 mult=1 m=1
csn_op0_n100_rl_s1_r10k_dp003p0_3 sn_op0_n100_rl_s1_r10k_dp003p0_3 0 {C_SN}
XMN1_op0_n100_rl_s1_r10k_dp003p0 rbl_op0_n100_rl_s1_r10k_dp003p0 ref_op0_n100_rl_s1_r10k_dp003p0 vn_op0_n100_rl_s1_r10k_dp003p0 0 sky130_fd_pr__nfet_01v8 L=0.15 W=1 nf=1 ad=0.29 as=0.29 pd=2.58 ps=2.58 mult=1 m=1
XMN2_op0_n100_rl_s1_r10k_dp003p0 ref_op0_n100_rl_s1_r10k_dp003p0 rbl_op0_n100_rl_s1_r10k_dp003p0 vn_op0_n100_rl_s1_r10k_dp003p0 0 sky130_fd_pr__nfet_01v8 L=0.15 W=1 nf=1 ad=0.29 as=0.29 pd=2.58 ps=2.58 mult=1 m=1
XMP1_op0_n100_rl_s1_r10k_dp003p0 rbl_op0_n100_rl_s1_r10k_dp003p0 ref_op0_n100_rl_s1_r10k_dp003p0 vp_op0_n100_rl_s1_r10k_dp003p0 vdd sky130_fd_pr__pfet_01v8 L=0.15 W=2 nf=1 ad=0.58 as=0.58 pd=4.58 ps=4.58 mult=1 m=1
XMP2_op0_n100_rl_s1_r10k_dp003p0 ref_op0_n100_rl_s1_r10k_dp003p0 rbl_op0_n100_rl_s1_r10k_dp003p0 vp_op0_n100_rl_s1_r10k_dp003p0 vdd sky130_fd_pr__pfet_01v8 L=0.15 W=2 nf=1 ad=0.58 as=0.58 pd=4.58 ps=4.58 mult=1 m=1
XMNF_op0_n100_rl_s1_r10k_dp003p0 vn_op0_n100_rl_s1_r10k_dp003p0 en_op0_n100_rl_s1_r10k_dp003p0 0 0 sky130_fd_pr__nfet_01v8 L=0.15 W=2 nf=1 ad=0.58 as=0.58 pd=4.58 ps=4.58 mult=1 m=1
XMPH_op0_n100_rl_s1_r10k_dp003p0 vp_op0_n100_rl_s1_r10k_dp003p0 enb_op0_n100_rl_s1_r10k_dp003p0 vdd vdd sky130_fd_pr__pfet_01v8 L=0.15 W=4 nf=1 ad=1.16 as=1.16 pd=8.58 ps=8.58 mult=1 m=1
bd_op0_n100_rl_s1_r10k_dp003p0 d_op0_n100_rl_s1_r10k_dp003p0 0 v=v(rbl_op0_n100_rl_s1_r10k_dp003p0)-v(ref_op0_n100_rl_s1_r10k_dp003p0)

* ---- instance 284: op0_0000_rl_s1_r10k_dp003p0 (variant rl_s1_r10k_dp003p0; probe dec 11.9 ns, release 35 ns, meas 36 ns) ----
vctl_op0_0000_rl_s1_r10k_dp003p0 ctl_op0_0000_rl_s1_r10k_dp003p0 0 pwl(0.0000e+00 {VDD} 2.0000e-09 {VDD} 2.1000e-09 0)
* RWL driver model (EXPERIMENTAL): slew 1 ns, series R 10000 ohm; cell pin = rwls_op0_0000_rl_s1_r10k_dp003p0
vrs_op0_0000_rl_s1_r10k_dp003p0 rwlsrc_op0_0000_rl_s1_r10k_dp003p0 0 pwl(0.0000e+00 {VDD} 2.0000e-09 {VDD} 3.0000e-09 0 3.5000e-08 0 3.6000e-08 {VDD})
rdrv_op0_0000_rl_s1_r10k_dp003p0 rwlsrc_op0_0000_rl_s1_r10k_dp003p0 rwls_op0_0000_rl_s1_r10k_dp003p0 10000
ven_op0_0000_rl_s1_r10k_dp003p0 en_op0_0000_rl_s1_r10k_dp003p0 0 pwl(0.0000e+00 0 1.1000e-08 0 1.1100e-08 {VDD} 3.4000e-08 {VDD} 3.4100e-08 0)
venb_op0_0000_rl_s1_r10k_dp003p0 enb_op0_0000_rl_s1_r10k_dp003p0 0 pwl(0.0000e+00 {VDD} 1.1000e-08 {VDD} 1.1100e-08 0 3.4000e-08 0 3.4100e-08 {VDD})
vww_op0_0000_rl_s1_r10k_dp003p0 wwl_op0_0000_rl_s1_r10k_dp003p0 0 pwl(0.0000e+00 0 1.2000e-08 0 1.2100e-08 {VDD} 3.2000e-08 {VDD} 3.2100e-08 0)
vwc_op0_0000_rl_s1_r10k_dp003p0 wbc_op0_0000_rl_s1_r10k_dp003p0 0 pwl(0.0000e+00 0 1.2000e-08 0 1.2100e-08 {VDD} 3.4000e-08 {VDD} 3.4100e-08 0)
swb_op0_0000_rl_s1_r10k_dp003p0 ref_op0_0000_rl_s1_r10k_dp003p0 wbl_op0_0000_rl_s1_r10k_dp003p0 wbc_op0_0000_rl_s1_r10k_dp003p0 0 swwbl
cwbl_op0_0000_rl_s1_r10k_dp003p0 wbl_op0_0000_rl_s1_r10k_dp003p0 0 {C_WBL}
spa_op0_0000_rl_s1_r10k_dp003p0 prea rbl_op0_0000_rl_s1_r10k_dp003p0 ctl_op0_0000_rl_s1_r10k_dp003p0 0 swpre
spr_op0_0000_rl_s1_r10k_dp003p0 pref ref_op0_0000_rl_s1_r10k_dp003p0 ctl_op0_0000_rl_s1_r10k_dp003p0 0 swpre
crbl_op0_0000_rl_s1_r10k_dp003p0 rbl_op0_0000_rl_s1_r10k_dp003p0 0 {C_RBL}
cref_op0_0000_rl_s1_r10k_dp003p0 ref_op0_0000_rl_s1_r10k_dp003p0 0 {C_RBL}   $ ASSUMPTION: ideal matched dummy load
XMWR_op0_0000_rl_s1_r10k_dp003p0_0 sn_op0_0000_rl_s1_r10k_dp003p0_0 wwl_op0_0000_rl_s1_r10k_dp003p0 wbl_op0_0000_rl_s1_r10k_dp003p0 0 sky130_fd_pr__nfet_01v8 L=0.15 W=0.42 nf=1 ad=0.1218 as=0.1218 pd=1.42 ps=1.42 nrd=0.69047619047619  nrs=0.69047619047619 sa=0 sb=0 sd=0 mult=1 m=1
XMRD_op0_0000_rl_s1_r10k_dp003p0_0 rbl_op0_0000_rl_s1_r10k_dp003p0 sn_op0_0000_rl_s1_r10k_dp003p0_0 rwls_op0_0000_rl_s1_r10k_dp003p0 0 sky130_fd_pr__nfet_01v8 L=0.15 W=0.42 nf=1 ad=0.1218 as=0.1218 pd=1.42 ps=1.42 nrd=0.69047619047619  nrs=0.69047619047619 sa=0 sb=0 sd=0 mult=1 m=1
csn_op0_0000_rl_s1_r10k_dp003p0_0 sn_op0_0000_rl_s1_r10k_dp003p0_0 0 {C_SN}
XMWR_op0_0000_rl_s1_r10k_dp003p0_1 sn_op0_0000_rl_s1_r10k_dp003p0_1 wwl_des wbl_op0_0000_rl_s1_r10k_dp003p0 0 sky130_fd_pr__nfet_01v8 L=0.15 W=0.42 nf=1 ad=0.1218 as=0.1218 pd=1.42 ps=1.42 nrd=0.69047619047619  nrs=0.69047619047619 sa=0 sb=0 sd=0 mult=1 m=1
XMRD_op0_0000_rl_s1_r10k_dp003p0_1 rbl_op0_0000_rl_s1_r10k_dp003p0 sn_op0_0000_rl_s1_r10k_dp003p0_1 rwl_des 0 sky130_fd_pr__nfet_01v8 L=0.15 W=0.42 nf=1 ad=0.1218 as=0.1218 pd=1.42 ps=1.42 nrd=0.69047619047619  nrs=0.69047619047619 sa=0 sb=0 sd=0 mult=1 m=1
csn_op0_0000_rl_s1_r10k_dp003p0_1 sn_op0_0000_rl_s1_r10k_dp003p0_1 0 {C_SN}
XMWR_op0_0000_rl_s1_r10k_dp003p0_2 sn_op0_0000_rl_s1_r10k_dp003p0_2 wwl_des wbl_op0_0000_rl_s1_r10k_dp003p0 0 sky130_fd_pr__nfet_01v8 L=0.15 W=0.42 nf=1 ad=0.1218 as=0.1218 pd=1.42 ps=1.42 nrd=0.69047619047619  nrs=0.69047619047619 sa=0 sb=0 sd=0 mult=1 m=1
XMRD_op0_0000_rl_s1_r10k_dp003p0_2 rbl_op0_0000_rl_s1_r10k_dp003p0 sn_op0_0000_rl_s1_r10k_dp003p0_2 rwl_des 0 sky130_fd_pr__nfet_01v8 L=0.15 W=0.42 nf=1 ad=0.1218 as=0.1218 pd=1.42 ps=1.42 nrd=0.69047619047619  nrs=0.69047619047619 sa=0 sb=0 sd=0 mult=1 m=1
csn_op0_0000_rl_s1_r10k_dp003p0_2 sn_op0_0000_rl_s1_r10k_dp003p0_2 0 {C_SN}
XMWR_op0_0000_rl_s1_r10k_dp003p0_3 sn_op0_0000_rl_s1_r10k_dp003p0_3 wwl_des wbl_op0_0000_rl_s1_r10k_dp003p0 0 sky130_fd_pr__nfet_01v8 L=0.15 W=0.42 nf=1 ad=0.1218 as=0.1218 pd=1.42 ps=1.42 nrd=0.69047619047619  nrs=0.69047619047619 sa=0 sb=0 sd=0 mult=1 m=1
XMRD_op0_0000_rl_s1_r10k_dp003p0_3 rbl_op0_0000_rl_s1_r10k_dp003p0 sn_op0_0000_rl_s1_r10k_dp003p0_3 rwl_des 0 sky130_fd_pr__nfet_01v8 L=0.15 W=0.42 nf=1 ad=0.1218 as=0.1218 pd=1.42 ps=1.42 nrd=0.69047619047619  nrs=0.69047619047619 sa=0 sb=0 sd=0 mult=1 m=1
csn_op0_0000_rl_s1_r10k_dp003p0_3 sn_op0_0000_rl_s1_r10k_dp003p0_3 0 {C_SN}
XMN1_op0_0000_rl_s1_r10k_dp003p0 rbl_op0_0000_rl_s1_r10k_dp003p0 ref_op0_0000_rl_s1_r10k_dp003p0 vn_op0_0000_rl_s1_r10k_dp003p0 0 sky130_fd_pr__nfet_01v8 L=0.15 W=1 nf=1 ad=0.29 as=0.29 pd=2.58 ps=2.58 mult=1 m=1
XMN2_op0_0000_rl_s1_r10k_dp003p0 ref_op0_0000_rl_s1_r10k_dp003p0 rbl_op0_0000_rl_s1_r10k_dp003p0 vn_op0_0000_rl_s1_r10k_dp003p0 0 sky130_fd_pr__nfet_01v8 L=0.15 W=1 nf=1 ad=0.29 as=0.29 pd=2.58 ps=2.58 mult=1 m=1
XMP1_op0_0000_rl_s1_r10k_dp003p0 rbl_op0_0000_rl_s1_r10k_dp003p0 ref_op0_0000_rl_s1_r10k_dp003p0 vp_op0_0000_rl_s1_r10k_dp003p0 vdd sky130_fd_pr__pfet_01v8 L=0.15 W=2 nf=1 ad=0.58 as=0.58 pd=4.58 ps=4.58 mult=1 m=1
XMP2_op0_0000_rl_s1_r10k_dp003p0 ref_op0_0000_rl_s1_r10k_dp003p0 rbl_op0_0000_rl_s1_r10k_dp003p0 vp_op0_0000_rl_s1_r10k_dp003p0 vdd sky130_fd_pr__pfet_01v8 L=0.15 W=2 nf=1 ad=0.58 as=0.58 pd=4.58 ps=4.58 mult=1 m=1
XMNF_op0_0000_rl_s1_r10k_dp003p0 vn_op0_0000_rl_s1_r10k_dp003p0 en_op0_0000_rl_s1_r10k_dp003p0 0 0 sky130_fd_pr__nfet_01v8 L=0.15 W=2 nf=1 ad=0.58 as=0.58 pd=4.58 ps=4.58 mult=1 m=1
XMPH_op0_0000_rl_s1_r10k_dp003p0 vp_op0_0000_rl_s1_r10k_dp003p0 enb_op0_0000_rl_s1_r10k_dp003p0 vdd vdd sky130_fd_pr__pfet_01v8 L=0.15 W=4 nf=1 ad=1.16 as=1.16 pd=8.58 ps=8.58 mult=1 m=1
bd_op0_0000_rl_s1_r10k_dp003p0 d_op0_0000_rl_s1_r10k_dp003p0 0 v=v(rbl_op0_0000_rl_s1_r10k_dp003p0)-v(ref_op0_0000_rl_s1_r10k_dp003p0)

* ---- instance 285: op1_0900_rl_s2_r100k_dm016p0 (variant rl_s2_r100k_dm016p0; probe dec 11.9 ns, release 34 ns, meas 36 ns) ----
vctl_op1_0900_rl_s2_r100k_dm016p0 ctl_op1_0900_rl_s2_r100k_dm016p0 0 pwl(0.0000e+00 {VDD} 2.0000e-09 {VDD} 2.1000e-09 0)
* RWL driver model (EXPERIMENTAL): slew 2 ns, series R 100000 ohm; cell pin = rwls_op1_0900_rl_s2_r100k_dm016p0
vrs_op1_0900_rl_s2_r100k_dm016p0 rwlsrc_op1_0900_rl_s2_r100k_dm016p0 0 pwl(0.0000e+00 {VDD} 2.0000e-09 {VDD} 4.0000e-09 0 1.6000e-08 0 1.8000e-08 {VDD})
rdrv_op1_0900_rl_s2_r100k_dm016p0 rwlsrc_op1_0900_rl_s2_r100k_dm016p0 rwls_op1_0900_rl_s2_r100k_dm016p0 100000
ven_op1_0900_rl_s2_r100k_dm016p0 en_op1_0900_rl_s2_r100k_dm016p0 0 pwl(0.0000e+00 0 1.1000e-08 0 1.1100e-08 {VDD} 3.4000e-08 {VDD} 3.4100e-08 0)
venb_op1_0900_rl_s2_r100k_dm016p0 enb_op1_0900_rl_s2_r100k_dm016p0 0 pwl(0.0000e+00 {VDD} 1.1000e-08 {VDD} 1.1100e-08 0 3.4000e-08 0 3.4100e-08 {VDD})
vww_op1_0900_rl_s2_r100k_dm016p0 wwl_op1_0900_rl_s2_r100k_dm016p0 0 pwl(0.0000e+00 0 1.2000e-08 0 1.2100e-08 {VDD} 3.2000e-08 {VDD} 3.2100e-08 0)
vwc_op1_0900_rl_s2_r100k_dm016p0 wbc_op1_0900_rl_s2_r100k_dm016p0 0 pwl(0.0000e+00 0 1.2000e-08 0 1.2100e-08 {VDD} 3.4000e-08 {VDD} 3.4100e-08 0)
swb_op1_0900_rl_s2_r100k_dm016p0 ref_op1_0900_rl_s2_r100k_dm016p0 wbl_op1_0900_rl_s2_r100k_dm016p0 wbc_op1_0900_rl_s2_r100k_dm016p0 0 swwbl
cwbl_op1_0900_rl_s2_r100k_dm016p0 wbl_op1_0900_rl_s2_r100k_dm016p0 0 {C_WBL}
spa_op1_0900_rl_s2_r100k_dm016p0 prea rbl_op1_0900_rl_s2_r100k_dm016p0 ctl_op1_0900_rl_s2_r100k_dm016p0 0 swpre
spr_op1_0900_rl_s2_r100k_dm016p0 pref ref_op1_0900_rl_s2_r100k_dm016p0 ctl_op1_0900_rl_s2_r100k_dm016p0 0 swpre
crbl_op1_0900_rl_s2_r100k_dm016p0 rbl_op1_0900_rl_s2_r100k_dm016p0 0 {C_RBL}
cref_op1_0900_rl_s2_r100k_dm016p0 ref_op1_0900_rl_s2_r100k_dm016p0 0 {C_RBL}   $ ASSUMPTION: ideal matched dummy load
XMWR_op1_0900_rl_s2_r100k_dm016p0_0 sn_op1_0900_rl_s2_r100k_dm016p0_0 wwl_op1_0900_rl_s2_r100k_dm016p0 wbl_op1_0900_rl_s2_r100k_dm016p0 0 sky130_fd_pr__nfet_01v8 L=0.15 W=0.42 nf=1 ad=0.1218 as=0.1218 pd=1.42 ps=1.42 nrd=0.69047619047619  nrs=0.69047619047619 sa=0 sb=0 sd=0 mult=1 m=1
XMRD_op1_0900_rl_s2_r100k_dm016p0_0 rbl_op1_0900_rl_s2_r100k_dm016p0 sn_op1_0900_rl_s2_r100k_dm016p0_0 rwls_op1_0900_rl_s2_r100k_dm016p0 0 sky130_fd_pr__nfet_01v8 L=0.15 W=0.42 nf=1 ad=0.1218 as=0.1218 pd=1.42 ps=1.42 nrd=0.69047619047619  nrs=0.69047619047619 sa=0 sb=0 sd=0 mult=1 m=1
csn_op1_0900_rl_s2_r100k_dm016p0_0 sn_op1_0900_rl_s2_r100k_dm016p0_0 0 {C_SN}
XMWR_op1_0900_rl_s2_r100k_dm016p0_1 sn_op1_0900_rl_s2_r100k_dm016p0_1 wwl_des wbl_op1_0900_rl_s2_r100k_dm016p0 0 sky130_fd_pr__nfet_01v8 L=0.15 W=0.42 nf=1 ad=0.1218 as=0.1218 pd=1.42 ps=1.42 nrd=0.69047619047619  nrs=0.69047619047619 sa=0 sb=0 sd=0 mult=1 m=1
XMRD_op1_0900_rl_s2_r100k_dm016p0_1 rbl_op1_0900_rl_s2_r100k_dm016p0 sn_op1_0900_rl_s2_r100k_dm016p0_1 rwl_des 0 sky130_fd_pr__nfet_01v8 L=0.15 W=0.42 nf=1 ad=0.1218 as=0.1218 pd=1.42 ps=1.42 nrd=0.69047619047619  nrs=0.69047619047619 sa=0 sb=0 sd=0 mult=1 m=1
csn_op1_0900_rl_s2_r100k_dm016p0_1 sn_op1_0900_rl_s2_r100k_dm016p0_1 0 {C_SN}
XMWR_op1_0900_rl_s2_r100k_dm016p0_2 sn_op1_0900_rl_s2_r100k_dm016p0_2 wwl_des wbl_op1_0900_rl_s2_r100k_dm016p0 0 sky130_fd_pr__nfet_01v8 L=0.15 W=0.42 nf=1 ad=0.1218 as=0.1218 pd=1.42 ps=1.42 nrd=0.69047619047619  nrs=0.69047619047619 sa=0 sb=0 sd=0 mult=1 m=1
XMRD_op1_0900_rl_s2_r100k_dm016p0_2 rbl_op1_0900_rl_s2_r100k_dm016p0 sn_op1_0900_rl_s2_r100k_dm016p0_2 rwl_des 0 sky130_fd_pr__nfet_01v8 L=0.15 W=0.42 nf=1 ad=0.1218 as=0.1218 pd=1.42 ps=1.42 nrd=0.69047619047619  nrs=0.69047619047619 sa=0 sb=0 sd=0 mult=1 m=1
csn_op1_0900_rl_s2_r100k_dm016p0_2 sn_op1_0900_rl_s2_r100k_dm016p0_2 0 {C_SN}
XMWR_op1_0900_rl_s2_r100k_dm016p0_3 sn_op1_0900_rl_s2_r100k_dm016p0_3 wwl_des wbl_op1_0900_rl_s2_r100k_dm016p0 0 sky130_fd_pr__nfet_01v8 L=0.15 W=0.42 nf=1 ad=0.1218 as=0.1218 pd=1.42 ps=1.42 nrd=0.69047619047619  nrs=0.69047619047619 sa=0 sb=0 sd=0 mult=1 m=1
XMRD_op1_0900_rl_s2_r100k_dm016p0_3 rbl_op1_0900_rl_s2_r100k_dm016p0 sn_op1_0900_rl_s2_r100k_dm016p0_3 rwl_des 0 sky130_fd_pr__nfet_01v8 L=0.15 W=0.42 nf=1 ad=0.1218 as=0.1218 pd=1.42 ps=1.42 nrd=0.69047619047619  nrs=0.69047619047619 sa=0 sb=0 sd=0 mult=1 m=1
csn_op1_0900_rl_s2_r100k_dm016p0_3 sn_op1_0900_rl_s2_r100k_dm016p0_3 0 {C_SN}
XMN1_op1_0900_rl_s2_r100k_dm016p0 rbl_op1_0900_rl_s2_r100k_dm016p0 ref_op1_0900_rl_s2_r100k_dm016p0 vn_op1_0900_rl_s2_r100k_dm016p0 0 sky130_fd_pr__nfet_01v8 L=0.15 W=1 nf=1 ad=0.29 as=0.29 pd=2.58 ps=2.58 mult=1 m=1
XMN2_op1_0900_rl_s2_r100k_dm016p0 ref_op1_0900_rl_s2_r100k_dm016p0 rbl_op1_0900_rl_s2_r100k_dm016p0 vn_op1_0900_rl_s2_r100k_dm016p0 0 sky130_fd_pr__nfet_01v8 L=0.15 W=1 nf=1 ad=0.29 as=0.29 pd=2.58 ps=2.58 mult=1 m=1
XMP1_op1_0900_rl_s2_r100k_dm016p0 rbl_op1_0900_rl_s2_r100k_dm016p0 ref_op1_0900_rl_s2_r100k_dm016p0 vp_op1_0900_rl_s2_r100k_dm016p0 vdd sky130_fd_pr__pfet_01v8 L=0.15 W=2 nf=1 ad=0.58 as=0.58 pd=4.58 ps=4.58 mult=1 m=1
XMP2_op1_0900_rl_s2_r100k_dm016p0 ref_op1_0900_rl_s2_r100k_dm016p0 rbl_op1_0900_rl_s2_r100k_dm016p0 vp_op1_0900_rl_s2_r100k_dm016p0 vdd sky130_fd_pr__pfet_01v8 L=0.15 W=2 nf=1 ad=0.58 as=0.58 pd=4.58 ps=4.58 mult=1 m=1
XMNF_op1_0900_rl_s2_r100k_dm016p0 vn_op1_0900_rl_s2_r100k_dm016p0 en_op1_0900_rl_s2_r100k_dm016p0 0 0 sky130_fd_pr__nfet_01v8 L=0.15 W=2 nf=1 ad=0.58 as=0.58 pd=4.58 ps=4.58 mult=1 m=1
XMPH_op1_0900_rl_s2_r100k_dm016p0 vp_op1_0900_rl_s2_r100k_dm016p0 enb_op1_0900_rl_s2_r100k_dm016p0 vdd vdd sky130_fd_pr__pfet_01v8 L=0.15 W=4 nf=1 ad=1.16 as=1.16 pd=8.58 ps=8.58 mult=1 m=1
bd_op1_0900_rl_s2_r100k_dm016p0 d_op1_0900_rl_s2_r100k_dm016p0 0 v=v(rbl_op1_0900_rl_s2_r100k_dm016p0)-v(ref_op1_0900_rl_s2_r100k_dm016p0)

* ---- instance 286: op1_1000_rl_s2_r100k_dm016p0 (variant rl_s2_r100k_dm016p0; probe dec 11.9 ns, release 34 ns, meas 36 ns) ----
vctl_op1_1000_rl_s2_r100k_dm016p0 ctl_op1_1000_rl_s2_r100k_dm016p0 0 pwl(0.0000e+00 {VDD} 2.0000e-09 {VDD} 2.1000e-09 0)
* RWL driver model (EXPERIMENTAL): slew 2 ns, series R 100000 ohm; cell pin = rwls_op1_1000_rl_s2_r100k_dm016p0
vrs_op1_1000_rl_s2_r100k_dm016p0 rwlsrc_op1_1000_rl_s2_r100k_dm016p0 0 pwl(0.0000e+00 {VDD} 2.0000e-09 {VDD} 4.0000e-09 0 1.6000e-08 0 1.8000e-08 {VDD})
rdrv_op1_1000_rl_s2_r100k_dm016p0 rwlsrc_op1_1000_rl_s2_r100k_dm016p0 rwls_op1_1000_rl_s2_r100k_dm016p0 100000
ven_op1_1000_rl_s2_r100k_dm016p0 en_op1_1000_rl_s2_r100k_dm016p0 0 pwl(0.0000e+00 0 1.1000e-08 0 1.1100e-08 {VDD} 3.4000e-08 {VDD} 3.4100e-08 0)
venb_op1_1000_rl_s2_r100k_dm016p0 enb_op1_1000_rl_s2_r100k_dm016p0 0 pwl(0.0000e+00 {VDD} 1.1000e-08 {VDD} 1.1100e-08 0 3.4000e-08 0 3.4100e-08 {VDD})
vww_op1_1000_rl_s2_r100k_dm016p0 wwl_op1_1000_rl_s2_r100k_dm016p0 0 pwl(0.0000e+00 0 1.2000e-08 0 1.2100e-08 {VDD} 3.2000e-08 {VDD} 3.2100e-08 0)
vwc_op1_1000_rl_s2_r100k_dm016p0 wbc_op1_1000_rl_s2_r100k_dm016p0 0 pwl(0.0000e+00 0 1.2000e-08 0 1.2100e-08 {VDD} 3.4000e-08 {VDD} 3.4100e-08 0)
swb_op1_1000_rl_s2_r100k_dm016p0 ref_op1_1000_rl_s2_r100k_dm016p0 wbl_op1_1000_rl_s2_r100k_dm016p0 wbc_op1_1000_rl_s2_r100k_dm016p0 0 swwbl
cwbl_op1_1000_rl_s2_r100k_dm016p0 wbl_op1_1000_rl_s2_r100k_dm016p0 0 {C_WBL}
spa_op1_1000_rl_s2_r100k_dm016p0 prea rbl_op1_1000_rl_s2_r100k_dm016p0 ctl_op1_1000_rl_s2_r100k_dm016p0 0 swpre
spr_op1_1000_rl_s2_r100k_dm016p0 pref ref_op1_1000_rl_s2_r100k_dm016p0 ctl_op1_1000_rl_s2_r100k_dm016p0 0 swpre
crbl_op1_1000_rl_s2_r100k_dm016p0 rbl_op1_1000_rl_s2_r100k_dm016p0 0 {C_RBL}
cref_op1_1000_rl_s2_r100k_dm016p0 ref_op1_1000_rl_s2_r100k_dm016p0 0 {C_RBL}   $ ASSUMPTION: ideal matched dummy load
XMWR_op1_1000_rl_s2_r100k_dm016p0_0 sn_op1_1000_rl_s2_r100k_dm016p0_0 wwl_op1_1000_rl_s2_r100k_dm016p0 wbl_op1_1000_rl_s2_r100k_dm016p0 0 sky130_fd_pr__nfet_01v8 L=0.15 W=0.42 nf=1 ad=0.1218 as=0.1218 pd=1.42 ps=1.42 nrd=0.69047619047619  nrs=0.69047619047619 sa=0 sb=0 sd=0 mult=1 m=1
XMRD_op1_1000_rl_s2_r100k_dm016p0_0 rbl_op1_1000_rl_s2_r100k_dm016p0 sn_op1_1000_rl_s2_r100k_dm016p0_0 rwls_op1_1000_rl_s2_r100k_dm016p0 0 sky130_fd_pr__nfet_01v8 L=0.15 W=0.42 nf=1 ad=0.1218 as=0.1218 pd=1.42 ps=1.42 nrd=0.69047619047619  nrs=0.69047619047619 sa=0 sb=0 sd=0 mult=1 m=1
csn_op1_1000_rl_s2_r100k_dm016p0_0 sn_op1_1000_rl_s2_r100k_dm016p0_0 0 {C_SN}
XMWR_op1_1000_rl_s2_r100k_dm016p0_1 sn_op1_1000_rl_s2_r100k_dm016p0_1 wwl_des wbl_op1_1000_rl_s2_r100k_dm016p0 0 sky130_fd_pr__nfet_01v8 L=0.15 W=0.42 nf=1 ad=0.1218 as=0.1218 pd=1.42 ps=1.42 nrd=0.69047619047619  nrs=0.69047619047619 sa=0 sb=0 sd=0 mult=1 m=1
XMRD_op1_1000_rl_s2_r100k_dm016p0_1 rbl_op1_1000_rl_s2_r100k_dm016p0 sn_op1_1000_rl_s2_r100k_dm016p0_1 rwl_des 0 sky130_fd_pr__nfet_01v8 L=0.15 W=0.42 nf=1 ad=0.1218 as=0.1218 pd=1.42 ps=1.42 nrd=0.69047619047619  nrs=0.69047619047619 sa=0 sb=0 sd=0 mult=1 m=1
csn_op1_1000_rl_s2_r100k_dm016p0_1 sn_op1_1000_rl_s2_r100k_dm016p0_1 0 {C_SN}
XMWR_op1_1000_rl_s2_r100k_dm016p0_2 sn_op1_1000_rl_s2_r100k_dm016p0_2 wwl_des wbl_op1_1000_rl_s2_r100k_dm016p0 0 sky130_fd_pr__nfet_01v8 L=0.15 W=0.42 nf=1 ad=0.1218 as=0.1218 pd=1.42 ps=1.42 nrd=0.69047619047619  nrs=0.69047619047619 sa=0 sb=0 sd=0 mult=1 m=1
XMRD_op1_1000_rl_s2_r100k_dm016p0_2 rbl_op1_1000_rl_s2_r100k_dm016p0 sn_op1_1000_rl_s2_r100k_dm016p0_2 rwl_des 0 sky130_fd_pr__nfet_01v8 L=0.15 W=0.42 nf=1 ad=0.1218 as=0.1218 pd=1.42 ps=1.42 nrd=0.69047619047619  nrs=0.69047619047619 sa=0 sb=0 sd=0 mult=1 m=1
csn_op1_1000_rl_s2_r100k_dm016p0_2 sn_op1_1000_rl_s2_r100k_dm016p0_2 0 {C_SN}
XMWR_op1_1000_rl_s2_r100k_dm016p0_3 sn_op1_1000_rl_s2_r100k_dm016p0_3 wwl_des wbl_op1_1000_rl_s2_r100k_dm016p0 0 sky130_fd_pr__nfet_01v8 L=0.15 W=0.42 nf=1 ad=0.1218 as=0.1218 pd=1.42 ps=1.42 nrd=0.69047619047619  nrs=0.69047619047619 sa=0 sb=0 sd=0 mult=1 m=1
XMRD_op1_1000_rl_s2_r100k_dm016p0_3 rbl_op1_1000_rl_s2_r100k_dm016p0 sn_op1_1000_rl_s2_r100k_dm016p0_3 rwl_des 0 sky130_fd_pr__nfet_01v8 L=0.15 W=0.42 nf=1 ad=0.1218 as=0.1218 pd=1.42 ps=1.42 nrd=0.69047619047619  nrs=0.69047619047619 sa=0 sb=0 sd=0 mult=1 m=1
csn_op1_1000_rl_s2_r100k_dm016p0_3 sn_op1_1000_rl_s2_r100k_dm016p0_3 0 {C_SN}
XMN1_op1_1000_rl_s2_r100k_dm016p0 rbl_op1_1000_rl_s2_r100k_dm016p0 ref_op1_1000_rl_s2_r100k_dm016p0 vn_op1_1000_rl_s2_r100k_dm016p0 0 sky130_fd_pr__nfet_01v8 L=0.15 W=1 nf=1 ad=0.29 as=0.29 pd=2.58 ps=2.58 mult=1 m=1
XMN2_op1_1000_rl_s2_r100k_dm016p0 ref_op1_1000_rl_s2_r100k_dm016p0 rbl_op1_1000_rl_s2_r100k_dm016p0 vn_op1_1000_rl_s2_r100k_dm016p0 0 sky130_fd_pr__nfet_01v8 L=0.15 W=1 nf=1 ad=0.29 as=0.29 pd=2.58 ps=2.58 mult=1 m=1
XMP1_op1_1000_rl_s2_r100k_dm016p0 rbl_op1_1000_rl_s2_r100k_dm016p0 ref_op1_1000_rl_s2_r100k_dm016p0 vp_op1_1000_rl_s2_r100k_dm016p0 vdd sky130_fd_pr__pfet_01v8 L=0.15 W=2 nf=1 ad=0.58 as=0.58 pd=4.58 ps=4.58 mult=1 m=1
XMP2_op1_1000_rl_s2_r100k_dm016p0 ref_op1_1000_rl_s2_r100k_dm016p0 rbl_op1_1000_rl_s2_r100k_dm016p0 vp_op1_1000_rl_s2_r100k_dm016p0 vdd sky130_fd_pr__pfet_01v8 L=0.15 W=2 nf=1 ad=0.58 as=0.58 pd=4.58 ps=4.58 mult=1 m=1
XMNF_op1_1000_rl_s2_r100k_dm016p0 vn_op1_1000_rl_s2_r100k_dm016p0 en_op1_1000_rl_s2_r100k_dm016p0 0 0 sky130_fd_pr__nfet_01v8 L=0.15 W=2 nf=1 ad=0.58 as=0.58 pd=4.58 ps=4.58 mult=1 m=1
XMPH_op1_1000_rl_s2_r100k_dm016p0 vp_op1_1000_rl_s2_r100k_dm016p0 enb_op1_1000_rl_s2_r100k_dm016p0 vdd vdd sky130_fd_pr__pfet_01v8 L=0.15 W=4 nf=1 ad=1.16 as=1.16 pd=8.58 ps=8.58 mult=1 m=1
bd_op1_1000_rl_s2_r100k_dm016p0 d_op1_1000_rl_s2_r100k_dm016p0 0 v=v(rbl_op1_1000_rl_s2_r100k_dm016p0)-v(ref_op1_1000_rl_s2_r100k_dm016p0)

* ---- instance 287: op0_n100_rl_s2_r100k_dm016p0 (variant rl_s2_r100k_dm016p0; probe dec 11.9 ns, release 34 ns, meas 36 ns) ----
vctl_op0_n100_rl_s2_r100k_dm016p0 ctl_op0_n100_rl_s2_r100k_dm016p0 0 pwl(0.0000e+00 {VDD} 2.0000e-09 {VDD} 2.1000e-09 0)
* RWL driver model (EXPERIMENTAL): slew 2 ns, series R 100000 ohm; cell pin = rwls_op0_n100_rl_s2_r100k_dm016p0
vrs_op0_n100_rl_s2_r100k_dm016p0 rwlsrc_op0_n100_rl_s2_r100k_dm016p0 0 pwl(0.0000e+00 {VDD} 2.0000e-09 {VDD} 4.0000e-09 0 1.6000e-08 0 1.8000e-08 {VDD})
rdrv_op0_n100_rl_s2_r100k_dm016p0 rwlsrc_op0_n100_rl_s2_r100k_dm016p0 rwls_op0_n100_rl_s2_r100k_dm016p0 100000
ven_op0_n100_rl_s2_r100k_dm016p0 en_op0_n100_rl_s2_r100k_dm016p0 0 pwl(0.0000e+00 0 1.1000e-08 0 1.1100e-08 {VDD} 3.4000e-08 {VDD} 3.4100e-08 0)
venb_op0_n100_rl_s2_r100k_dm016p0 enb_op0_n100_rl_s2_r100k_dm016p0 0 pwl(0.0000e+00 {VDD} 1.1000e-08 {VDD} 1.1100e-08 0 3.4000e-08 0 3.4100e-08 {VDD})
vww_op0_n100_rl_s2_r100k_dm016p0 wwl_op0_n100_rl_s2_r100k_dm016p0 0 pwl(0.0000e+00 0 1.2000e-08 0 1.2100e-08 {VDD} 3.2000e-08 {VDD} 3.2100e-08 0)
vwc_op0_n100_rl_s2_r100k_dm016p0 wbc_op0_n100_rl_s2_r100k_dm016p0 0 pwl(0.0000e+00 0 1.2000e-08 0 1.2100e-08 {VDD} 3.4000e-08 {VDD} 3.4100e-08 0)
swb_op0_n100_rl_s2_r100k_dm016p0 ref_op0_n100_rl_s2_r100k_dm016p0 wbl_op0_n100_rl_s2_r100k_dm016p0 wbc_op0_n100_rl_s2_r100k_dm016p0 0 swwbl
cwbl_op0_n100_rl_s2_r100k_dm016p0 wbl_op0_n100_rl_s2_r100k_dm016p0 0 {C_WBL}
spa_op0_n100_rl_s2_r100k_dm016p0 prea rbl_op0_n100_rl_s2_r100k_dm016p0 ctl_op0_n100_rl_s2_r100k_dm016p0 0 swpre
spr_op0_n100_rl_s2_r100k_dm016p0 pref ref_op0_n100_rl_s2_r100k_dm016p0 ctl_op0_n100_rl_s2_r100k_dm016p0 0 swpre
crbl_op0_n100_rl_s2_r100k_dm016p0 rbl_op0_n100_rl_s2_r100k_dm016p0 0 {C_RBL}
cref_op0_n100_rl_s2_r100k_dm016p0 ref_op0_n100_rl_s2_r100k_dm016p0 0 {C_RBL}   $ ASSUMPTION: ideal matched dummy load
XMWR_op0_n100_rl_s2_r100k_dm016p0_0 sn_op0_n100_rl_s2_r100k_dm016p0_0 wwl_op0_n100_rl_s2_r100k_dm016p0 wbl_op0_n100_rl_s2_r100k_dm016p0 0 sky130_fd_pr__nfet_01v8 L=0.15 W=0.42 nf=1 ad=0.1218 as=0.1218 pd=1.42 ps=1.42 nrd=0.69047619047619  nrs=0.69047619047619 sa=0 sb=0 sd=0 mult=1 m=1
XMRD_op0_n100_rl_s2_r100k_dm016p0_0 rbl_op0_n100_rl_s2_r100k_dm016p0 sn_op0_n100_rl_s2_r100k_dm016p0_0 rwls_op0_n100_rl_s2_r100k_dm016p0 0 sky130_fd_pr__nfet_01v8 L=0.15 W=0.42 nf=1 ad=0.1218 as=0.1218 pd=1.42 ps=1.42 nrd=0.69047619047619  nrs=0.69047619047619 sa=0 sb=0 sd=0 mult=1 m=1
csn_op0_n100_rl_s2_r100k_dm016p0_0 sn_op0_n100_rl_s2_r100k_dm016p0_0 0 {C_SN}
XMWR_op0_n100_rl_s2_r100k_dm016p0_1 sn_op0_n100_rl_s2_r100k_dm016p0_1 wwl_des wbl_op0_n100_rl_s2_r100k_dm016p0 0 sky130_fd_pr__nfet_01v8 L=0.15 W=0.42 nf=1 ad=0.1218 as=0.1218 pd=1.42 ps=1.42 nrd=0.69047619047619  nrs=0.69047619047619 sa=0 sb=0 sd=0 mult=1 m=1
XMRD_op0_n100_rl_s2_r100k_dm016p0_1 rbl_op0_n100_rl_s2_r100k_dm016p0 sn_op0_n100_rl_s2_r100k_dm016p0_1 rwl_des 0 sky130_fd_pr__nfet_01v8 L=0.15 W=0.42 nf=1 ad=0.1218 as=0.1218 pd=1.42 ps=1.42 nrd=0.69047619047619  nrs=0.69047619047619 sa=0 sb=0 sd=0 mult=1 m=1
csn_op0_n100_rl_s2_r100k_dm016p0_1 sn_op0_n100_rl_s2_r100k_dm016p0_1 0 {C_SN}
XMWR_op0_n100_rl_s2_r100k_dm016p0_2 sn_op0_n100_rl_s2_r100k_dm016p0_2 wwl_des wbl_op0_n100_rl_s2_r100k_dm016p0 0 sky130_fd_pr__nfet_01v8 L=0.15 W=0.42 nf=1 ad=0.1218 as=0.1218 pd=1.42 ps=1.42 nrd=0.69047619047619  nrs=0.69047619047619 sa=0 sb=0 sd=0 mult=1 m=1
XMRD_op0_n100_rl_s2_r100k_dm016p0_2 rbl_op0_n100_rl_s2_r100k_dm016p0 sn_op0_n100_rl_s2_r100k_dm016p0_2 rwl_des 0 sky130_fd_pr__nfet_01v8 L=0.15 W=0.42 nf=1 ad=0.1218 as=0.1218 pd=1.42 ps=1.42 nrd=0.69047619047619  nrs=0.69047619047619 sa=0 sb=0 sd=0 mult=1 m=1
csn_op0_n100_rl_s2_r100k_dm016p0_2 sn_op0_n100_rl_s2_r100k_dm016p0_2 0 {C_SN}
XMWR_op0_n100_rl_s2_r100k_dm016p0_3 sn_op0_n100_rl_s2_r100k_dm016p0_3 wwl_des wbl_op0_n100_rl_s2_r100k_dm016p0 0 sky130_fd_pr__nfet_01v8 L=0.15 W=0.42 nf=1 ad=0.1218 as=0.1218 pd=1.42 ps=1.42 nrd=0.69047619047619  nrs=0.69047619047619 sa=0 sb=0 sd=0 mult=1 m=1
XMRD_op0_n100_rl_s2_r100k_dm016p0_3 rbl_op0_n100_rl_s2_r100k_dm016p0 sn_op0_n100_rl_s2_r100k_dm016p0_3 rwl_des 0 sky130_fd_pr__nfet_01v8 L=0.15 W=0.42 nf=1 ad=0.1218 as=0.1218 pd=1.42 ps=1.42 nrd=0.69047619047619  nrs=0.69047619047619 sa=0 sb=0 sd=0 mult=1 m=1
csn_op0_n100_rl_s2_r100k_dm016p0_3 sn_op0_n100_rl_s2_r100k_dm016p0_3 0 {C_SN}
XMN1_op0_n100_rl_s2_r100k_dm016p0 rbl_op0_n100_rl_s2_r100k_dm016p0 ref_op0_n100_rl_s2_r100k_dm016p0 vn_op0_n100_rl_s2_r100k_dm016p0 0 sky130_fd_pr__nfet_01v8 L=0.15 W=1 nf=1 ad=0.29 as=0.29 pd=2.58 ps=2.58 mult=1 m=1
XMN2_op0_n100_rl_s2_r100k_dm016p0 ref_op0_n100_rl_s2_r100k_dm016p0 rbl_op0_n100_rl_s2_r100k_dm016p0 vn_op0_n100_rl_s2_r100k_dm016p0 0 sky130_fd_pr__nfet_01v8 L=0.15 W=1 nf=1 ad=0.29 as=0.29 pd=2.58 ps=2.58 mult=1 m=1
XMP1_op0_n100_rl_s2_r100k_dm016p0 rbl_op0_n100_rl_s2_r100k_dm016p0 ref_op0_n100_rl_s2_r100k_dm016p0 vp_op0_n100_rl_s2_r100k_dm016p0 vdd sky130_fd_pr__pfet_01v8 L=0.15 W=2 nf=1 ad=0.58 as=0.58 pd=4.58 ps=4.58 mult=1 m=1
XMP2_op0_n100_rl_s2_r100k_dm016p0 ref_op0_n100_rl_s2_r100k_dm016p0 rbl_op0_n100_rl_s2_r100k_dm016p0 vp_op0_n100_rl_s2_r100k_dm016p0 vdd sky130_fd_pr__pfet_01v8 L=0.15 W=2 nf=1 ad=0.58 as=0.58 pd=4.58 ps=4.58 mult=1 m=1
XMNF_op0_n100_rl_s2_r100k_dm016p0 vn_op0_n100_rl_s2_r100k_dm016p0 en_op0_n100_rl_s2_r100k_dm016p0 0 0 sky130_fd_pr__nfet_01v8 L=0.15 W=2 nf=1 ad=0.58 as=0.58 pd=4.58 ps=4.58 mult=1 m=1
XMPH_op0_n100_rl_s2_r100k_dm016p0 vp_op0_n100_rl_s2_r100k_dm016p0 enb_op0_n100_rl_s2_r100k_dm016p0 vdd vdd sky130_fd_pr__pfet_01v8 L=0.15 W=4 nf=1 ad=1.16 as=1.16 pd=8.58 ps=8.58 mult=1 m=1
bd_op0_n100_rl_s2_r100k_dm016p0 d_op0_n100_rl_s2_r100k_dm016p0 0 v=v(rbl_op0_n100_rl_s2_r100k_dm016p0)-v(ref_op0_n100_rl_s2_r100k_dm016p0)

* ---- instance 288: op0_0000_rl_s2_r100k_dm016p0 (variant rl_s2_r100k_dm016p0; probe dec 11.9 ns, release 34 ns, meas 36 ns) ----
vctl_op0_0000_rl_s2_r100k_dm016p0 ctl_op0_0000_rl_s2_r100k_dm016p0 0 pwl(0.0000e+00 {VDD} 2.0000e-09 {VDD} 2.1000e-09 0)
* RWL driver model (EXPERIMENTAL): slew 2 ns, series R 100000 ohm; cell pin = rwls_op0_0000_rl_s2_r100k_dm016p0
vrs_op0_0000_rl_s2_r100k_dm016p0 rwlsrc_op0_0000_rl_s2_r100k_dm016p0 0 pwl(0.0000e+00 {VDD} 2.0000e-09 {VDD} 4.0000e-09 0 1.6000e-08 0 1.8000e-08 {VDD})
rdrv_op0_0000_rl_s2_r100k_dm016p0 rwlsrc_op0_0000_rl_s2_r100k_dm016p0 rwls_op0_0000_rl_s2_r100k_dm016p0 100000
ven_op0_0000_rl_s2_r100k_dm016p0 en_op0_0000_rl_s2_r100k_dm016p0 0 pwl(0.0000e+00 0 1.1000e-08 0 1.1100e-08 {VDD} 3.4000e-08 {VDD} 3.4100e-08 0)
venb_op0_0000_rl_s2_r100k_dm016p0 enb_op0_0000_rl_s2_r100k_dm016p0 0 pwl(0.0000e+00 {VDD} 1.1000e-08 {VDD} 1.1100e-08 0 3.4000e-08 0 3.4100e-08 {VDD})
vww_op0_0000_rl_s2_r100k_dm016p0 wwl_op0_0000_rl_s2_r100k_dm016p0 0 pwl(0.0000e+00 0 1.2000e-08 0 1.2100e-08 {VDD} 3.2000e-08 {VDD} 3.2100e-08 0)
vwc_op0_0000_rl_s2_r100k_dm016p0 wbc_op0_0000_rl_s2_r100k_dm016p0 0 pwl(0.0000e+00 0 1.2000e-08 0 1.2100e-08 {VDD} 3.4000e-08 {VDD} 3.4100e-08 0)
swb_op0_0000_rl_s2_r100k_dm016p0 ref_op0_0000_rl_s2_r100k_dm016p0 wbl_op0_0000_rl_s2_r100k_dm016p0 wbc_op0_0000_rl_s2_r100k_dm016p0 0 swwbl
cwbl_op0_0000_rl_s2_r100k_dm016p0 wbl_op0_0000_rl_s2_r100k_dm016p0 0 {C_WBL}
spa_op0_0000_rl_s2_r100k_dm016p0 prea rbl_op0_0000_rl_s2_r100k_dm016p0 ctl_op0_0000_rl_s2_r100k_dm016p0 0 swpre
spr_op0_0000_rl_s2_r100k_dm016p0 pref ref_op0_0000_rl_s2_r100k_dm016p0 ctl_op0_0000_rl_s2_r100k_dm016p0 0 swpre
crbl_op0_0000_rl_s2_r100k_dm016p0 rbl_op0_0000_rl_s2_r100k_dm016p0 0 {C_RBL}
cref_op0_0000_rl_s2_r100k_dm016p0 ref_op0_0000_rl_s2_r100k_dm016p0 0 {C_RBL}   $ ASSUMPTION: ideal matched dummy load
XMWR_op0_0000_rl_s2_r100k_dm016p0_0 sn_op0_0000_rl_s2_r100k_dm016p0_0 wwl_op0_0000_rl_s2_r100k_dm016p0 wbl_op0_0000_rl_s2_r100k_dm016p0 0 sky130_fd_pr__nfet_01v8 L=0.15 W=0.42 nf=1 ad=0.1218 as=0.1218 pd=1.42 ps=1.42 nrd=0.69047619047619  nrs=0.69047619047619 sa=0 sb=0 sd=0 mult=1 m=1
XMRD_op0_0000_rl_s2_r100k_dm016p0_0 rbl_op0_0000_rl_s2_r100k_dm016p0 sn_op0_0000_rl_s2_r100k_dm016p0_0 rwls_op0_0000_rl_s2_r100k_dm016p0 0 sky130_fd_pr__nfet_01v8 L=0.15 W=0.42 nf=1 ad=0.1218 as=0.1218 pd=1.42 ps=1.42 nrd=0.69047619047619  nrs=0.69047619047619 sa=0 sb=0 sd=0 mult=1 m=1
csn_op0_0000_rl_s2_r100k_dm016p0_0 sn_op0_0000_rl_s2_r100k_dm016p0_0 0 {C_SN}
XMWR_op0_0000_rl_s2_r100k_dm016p0_1 sn_op0_0000_rl_s2_r100k_dm016p0_1 wwl_des wbl_op0_0000_rl_s2_r100k_dm016p0 0 sky130_fd_pr__nfet_01v8 L=0.15 W=0.42 nf=1 ad=0.1218 as=0.1218 pd=1.42 ps=1.42 nrd=0.69047619047619  nrs=0.69047619047619 sa=0 sb=0 sd=0 mult=1 m=1
XMRD_op0_0000_rl_s2_r100k_dm016p0_1 rbl_op0_0000_rl_s2_r100k_dm016p0 sn_op0_0000_rl_s2_r100k_dm016p0_1 rwl_des 0 sky130_fd_pr__nfet_01v8 L=0.15 W=0.42 nf=1 ad=0.1218 as=0.1218 pd=1.42 ps=1.42 nrd=0.69047619047619  nrs=0.69047619047619 sa=0 sb=0 sd=0 mult=1 m=1
csn_op0_0000_rl_s2_r100k_dm016p0_1 sn_op0_0000_rl_s2_r100k_dm016p0_1 0 {C_SN}
XMWR_op0_0000_rl_s2_r100k_dm016p0_2 sn_op0_0000_rl_s2_r100k_dm016p0_2 wwl_des wbl_op0_0000_rl_s2_r100k_dm016p0 0 sky130_fd_pr__nfet_01v8 L=0.15 W=0.42 nf=1 ad=0.1218 as=0.1218 pd=1.42 ps=1.42 nrd=0.69047619047619  nrs=0.69047619047619 sa=0 sb=0 sd=0 mult=1 m=1
XMRD_op0_0000_rl_s2_r100k_dm016p0_2 rbl_op0_0000_rl_s2_r100k_dm016p0 sn_op0_0000_rl_s2_r100k_dm016p0_2 rwl_des 0 sky130_fd_pr__nfet_01v8 L=0.15 W=0.42 nf=1 ad=0.1218 as=0.1218 pd=1.42 ps=1.42 nrd=0.69047619047619  nrs=0.69047619047619 sa=0 sb=0 sd=0 mult=1 m=1
csn_op0_0000_rl_s2_r100k_dm016p0_2 sn_op0_0000_rl_s2_r100k_dm016p0_2 0 {C_SN}
XMWR_op0_0000_rl_s2_r100k_dm016p0_3 sn_op0_0000_rl_s2_r100k_dm016p0_3 wwl_des wbl_op0_0000_rl_s2_r100k_dm016p0 0 sky130_fd_pr__nfet_01v8 L=0.15 W=0.42 nf=1 ad=0.1218 as=0.1218 pd=1.42 ps=1.42 nrd=0.69047619047619  nrs=0.69047619047619 sa=0 sb=0 sd=0 mult=1 m=1
XMRD_op0_0000_rl_s2_r100k_dm016p0_3 rbl_op0_0000_rl_s2_r100k_dm016p0 sn_op0_0000_rl_s2_r100k_dm016p0_3 rwl_des 0 sky130_fd_pr__nfet_01v8 L=0.15 W=0.42 nf=1 ad=0.1218 as=0.1218 pd=1.42 ps=1.42 nrd=0.69047619047619  nrs=0.69047619047619 sa=0 sb=0 sd=0 mult=1 m=1
csn_op0_0000_rl_s2_r100k_dm016p0_3 sn_op0_0000_rl_s2_r100k_dm016p0_3 0 {C_SN}
XMN1_op0_0000_rl_s2_r100k_dm016p0 rbl_op0_0000_rl_s2_r100k_dm016p0 ref_op0_0000_rl_s2_r100k_dm016p0 vn_op0_0000_rl_s2_r100k_dm016p0 0 sky130_fd_pr__nfet_01v8 L=0.15 W=1 nf=1 ad=0.29 as=0.29 pd=2.58 ps=2.58 mult=1 m=1
XMN2_op0_0000_rl_s2_r100k_dm016p0 ref_op0_0000_rl_s2_r100k_dm016p0 rbl_op0_0000_rl_s2_r100k_dm016p0 vn_op0_0000_rl_s2_r100k_dm016p0 0 sky130_fd_pr__nfet_01v8 L=0.15 W=1 nf=1 ad=0.29 as=0.29 pd=2.58 ps=2.58 mult=1 m=1
XMP1_op0_0000_rl_s2_r100k_dm016p0 rbl_op0_0000_rl_s2_r100k_dm016p0 ref_op0_0000_rl_s2_r100k_dm016p0 vp_op0_0000_rl_s2_r100k_dm016p0 vdd sky130_fd_pr__pfet_01v8 L=0.15 W=2 nf=1 ad=0.58 as=0.58 pd=4.58 ps=4.58 mult=1 m=1
XMP2_op0_0000_rl_s2_r100k_dm016p0 ref_op0_0000_rl_s2_r100k_dm016p0 rbl_op0_0000_rl_s2_r100k_dm016p0 vp_op0_0000_rl_s2_r100k_dm016p0 vdd sky130_fd_pr__pfet_01v8 L=0.15 W=2 nf=1 ad=0.58 as=0.58 pd=4.58 ps=4.58 mult=1 m=1
XMNF_op0_0000_rl_s2_r100k_dm016p0 vn_op0_0000_rl_s2_r100k_dm016p0 en_op0_0000_rl_s2_r100k_dm016p0 0 0 sky130_fd_pr__nfet_01v8 L=0.15 W=2 nf=1 ad=0.58 as=0.58 pd=4.58 ps=4.58 mult=1 m=1
XMPH_op0_0000_rl_s2_r100k_dm016p0 vp_op0_0000_rl_s2_r100k_dm016p0 enb_op0_0000_rl_s2_r100k_dm016p0 vdd vdd sky130_fd_pr__pfet_01v8 L=0.15 W=4 nf=1 ad=1.16 as=1.16 pd=8.58 ps=8.58 mult=1 m=1
bd_op0_0000_rl_s2_r100k_dm016p0 d_op0_0000_rl_s2_r100k_dm016p0 0 v=v(rbl_op0_0000_rl_s2_r100k_dm016p0)-v(ref_op0_0000_rl_s2_r100k_dm016p0)

* ---- instance 289: op1_0900_rl_s2_r100k_dm008p0 (variant rl_s2_r100k_dm008p0; probe dec 11.9 ns, release 34 ns, meas 36 ns) ----
vctl_op1_0900_rl_s2_r100k_dm008p0 ctl_op1_0900_rl_s2_r100k_dm008p0 0 pwl(0.0000e+00 {VDD} 2.0000e-09 {VDD} 2.1000e-09 0)
* RWL driver model (EXPERIMENTAL): slew 2 ns, series R 100000 ohm; cell pin = rwls_op1_0900_rl_s2_r100k_dm008p0
vrs_op1_0900_rl_s2_r100k_dm008p0 rwlsrc_op1_0900_rl_s2_r100k_dm008p0 0 pwl(0.0000e+00 {VDD} 2.0000e-09 {VDD} 4.0000e-09 0 2.4000e-08 0 2.6000e-08 {VDD})
rdrv_op1_0900_rl_s2_r100k_dm008p0 rwlsrc_op1_0900_rl_s2_r100k_dm008p0 rwls_op1_0900_rl_s2_r100k_dm008p0 100000
ven_op1_0900_rl_s2_r100k_dm008p0 en_op1_0900_rl_s2_r100k_dm008p0 0 pwl(0.0000e+00 0 1.1000e-08 0 1.1100e-08 {VDD} 3.4000e-08 {VDD} 3.4100e-08 0)
venb_op1_0900_rl_s2_r100k_dm008p0 enb_op1_0900_rl_s2_r100k_dm008p0 0 pwl(0.0000e+00 {VDD} 1.1000e-08 {VDD} 1.1100e-08 0 3.4000e-08 0 3.4100e-08 {VDD})
vww_op1_0900_rl_s2_r100k_dm008p0 wwl_op1_0900_rl_s2_r100k_dm008p0 0 pwl(0.0000e+00 0 1.2000e-08 0 1.2100e-08 {VDD} 3.2000e-08 {VDD} 3.2100e-08 0)
vwc_op1_0900_rl_s2_r100k_dm008p0 wbc_op1_0900_rl_s2_r100k_dm008p0 0 pwl(0.0000e+00 0 1.2000e-08 0 1.2100e-08 {VDD} 3.4000e-08 {VDD} 3.4100e-08 0)
swb_op1_0900_rl_s2_r100k_dm008p0 ref_op1_0900_rl_s2_r100k_dm008p0 wbl_op1_0900_rl_s2_r100k_dm008p0 wbc_op1_0900_rl_s2_r100k_dm008p0 0 swwbl
cwbl_op1_0900_rl_s2_r100k_dm008p0 wbl_op1_0900_rl_s2_r100k_dm008p0 0 {C_WBL}
spa_op1_0900_rl_s2_r100k_dm008p0 prea rbl_op1_0900_rl_s2_r100k_dm008p0 ctl_op1_0900_rl_s2_r100k_dm008p0 0 swpre
spr_op1_0900_rl_s2_r100k_dm008p0 pref ref_op1_0900_rl_s2_r100k_dm008p0 ctl_op1_0900_rl_s2_r100k_dm008p0 0 swpre
crbl_op1_0900_rl_s2_r100k_dm008p0 rbl_op1_0900_rl_s2_r100k_dm008p0 0 {C_RBL}
cref_op1_0900_rl_s2_r100k_dm008p0 ref_op1_0900_rl_s2_r100k_dm008p0 0 {C_RBL}   $ ASSUMPTION: ideal matched dummy load
XMWR_op1_0900_rl_s2_r100k_dm008p0_0 sn_op1_0900_rl_s2_r100k_dm008p0_0 wwl_op1_0900_rl_s2_r100k_dm008p0 wbl_op1_0900_rl_s2_r100k_dm008p0 0 sky130_fd_pr__nfet_01v8 L=0.15 W=0.42 nf=1 ad=0.1218 as=0.1218 pd=1.42 ps=1.42 nrd=0.69047619047619  nrs=0.69047619047619 sa=0 sb=0 sd=0 mult=1 m=1
XMRD_op1_0900_rl_s2_r100k_dm008p0_0 rbl_op1_0900_rl_s2_r100k_dm008p0 sn_op1_0900_rl_s2_r100k_dm008p0_0 rwls_op1_0900_rl_s2_r100k_dm008p0 0 sky130_fd_pr__nfet_01v8 L=0.15 W=0.42 nf=1 ad=0.1218 as=0.1218 pd=1.42 ps=1.42 nrd=0.69047619047619  nrs=0.69047619047619 sa=0 sb=0 sd=0 mult=1 m=1
csn_op1_0900_rl_s2_r100k_dm008p0_0 sn_op1_0900_rl_s2_r100k_dm008p0_0 0 {C_SN}
XMWR_op1_0900_rl_s2_r100k_dm008p0_1 sn_op1_0900_rl_s2_r100k_dm008p0_1 wwl_des wbl_op1_0900_rl_s2_r100k_dm008p0 0 sky130_fd_pr__nfet_01v8 L=0.15 W=0.42 nf=1 ad=0.1218 as=0.1218 pd=1.42 ps=1.42 nrd=0.69047619047619  nrs=0.69047619047619 sa=0 sb=0 sd=0 mult=1 m=1
XMRD_op1_0900_rl_s2_r100k_dm008p0_1 rbl_op1_0900_rl_s2_r100k_dm008p0 sn_op1_0900_rl_s2_r100k_dm008p0_1 rwl_des 0 sky130_fd_pr__nfet_01v8 L=0.15 W=0.42 nf=1 ad=0.1218 as=0.1218 pd=1.42 ps=1.42 nrd=0.69047619047619  nrs=0.69047619047619 sa=0 sb=0 sd=0 mult=1 m=1
csn_op1_0900_rl_s2_r100k_dm008p0_1 sn_op1_0900_rl_s2_r100k_dm008p0_1 0 {C_SN}
XMWR_op1_0900_rl_s2_r100k_dm008p0_2 sn_op1_0900_rl_s2_r100k_dm008p0_2 wwl_des wbl_op1_0900_rl_s2_r100k_dm008p0 0 sky130_fd_pr__nfet_01v8 L=0.15 W=0.42 nf=1 ad=0.1218 as=0.1218 pd=1.42 ps=1.42 nrd=0.69047619047619  nrs=0.69047619047619 sa=0 sb=0 sd=0 mult=1 m=1
XMRD_op1_0900_rl_s2_r100k_dm008p0_2 rbl_op1_0900_rl_s2_r100k_dm008p0 sn_op1_0900_rl_s2_r100k_dm008p0_2 rwl_des 0 sky130_fd_pr__nfet_01v8 L=0.15 W=0.42 nf=1 ad=0.1218 as=0.1218 pd=1.42 ps=1.42 nrd=0.69047619047619  nrs=0.69047619047619 sa=0 sb=0 sd=0 mult=1 m=1
csn_op1_0900_rl_s2_r100k_dm008p0_2 sn_op1_0900_rl_s2_r100k_dm008p0_2 0 {C_SN}
XMWR_op1_0900_rl_s2_r100k_dm008p0_3 sn_op1_0900_rl_s2_r100k_dm008p0_3 wwl_des wbl_op1_0900_rl_s2_r100k_dm008p0 0 sky130_fd_pr__nfet_01v8 L=0.15 W=0.42 nf=1 ad=0.1218 as=0.1218 pd=1.42 ps=1.42 nrd=0.69047619047619  nrs=0.69047619047619 sa=0 sb=0 sd=0 mult=1 m=1
XMRD_op1_0900_rl_s2_r100k_dm008p0_3 rbl_op1_0900_rl_s2_r100k_dm008p0 sn_op1_0900_rl_s2_r100k_dm008p0_3 rwl_des 0 sky130_fd_pr__nfet_01v8 L=0.15 W=0.42 nf=1 ad=0.1218 as=0.1218 pd=1.42 ps=1.42 nrd=0.69047619047619  nrs=0.69047619047619 sa=0 sb=0 sd=0 mult=1 m=1
csn_op1_0900_rl_s2_r100k_dm008p0_3 sn_op1_0900_rl_s2_r100k_dm008p0_3 0 {C_SN}
XMN1_op1_0900_rl_s2_r100k_dm008p0 rbl_op1_0900_rl_s2_r100k_dm008p0 ref_op1_0900_rl_s2_r100k_dm008p0 vn_op1_0900_rl_s2_r100k_dm008p0 0 sky130_fd_pr__nfet_01v8 L=0.15 W=1 nf=1 ad=0.29 as=0.29 pd=2.58 ps=2.58 mult=1 m=1
XMN2_op1_0900_rl_s2_r100k_dm008p0 ref_op1_0900_rl_s2_r100k_dm008p0 rbl_op1_0900_rl_s2_r100k_dm008p0 vn_op1_0900_rl_s2_r100k_dm008p0 0 sky130_fd_pr__nfet_01v8 L=0.15 W=1 nf=1 ad=0.29 as=0.29 pd=2.58 ps=2.58 mult=1 m=1
XMP1_op1_0900_rl_s2_r100k_dm008p0 rbl_op1_0900_rl_s2_r100k_dm008p0 ref_op1_0900_rl_s2_r100k_dm008p0 vp_op1_0900_rl_s2_r100k_dm008p0 vdd sky130_fd_pr__pfet_01v8 L=0.15 W=2 nf=1 ad=0.58 as=0.58 pd=4.58 ps=4.58 mult=1 m=1
XMP2_op1_0900_rl_s2_r100k_dm008p0 ref_op1_0900_rl_s2_r100k_dm008p0 rbl_op1_0900_rl_s2_r100k_dm008p0 vp_op1_0900_rl_s2_r100k_dm008p0 vdd sky130_fd_pr__pfet_01v8 L=0.15 W=2 nf=1 ad=0.58 as=0.58 pd=4.58 ps=4.58 mult=1 m=1
XMNF_op1_0900_rl_s2_r100k_dm008p0 vn_op1_0900_rl_s2_r100k_dm008p0 en_op1_0900_rl_s2_r100k_dm008p0 0 0 sky130_fd_pr__nfet_01v8 L=0.15 W=2 nf=1 ad=0.58 as=0.58 pd=4.58 ps=4.58 mult=1 m=1
XMPH_op1_0900_rl_s2_r100k_dm008p0 vp_op1_0900_rl_s2_r100k_dm008p0 enb_op1_0900_rl_s2_r100k_dm008p0 vdd vdd sky130_fd_pr__pfet_01v8 L=0.15 W=4 nf=1 ad=1.16 as=1.16 pd=8.58 ps=8.58 mult=1 m=1
bd_op1_0900_rl_s2_r100k_dm008p0 d_op1_0900_rl_s2_r100k_dm008p0 0 v=v(rbl_op1_0900_rl_s2_r100k_dm008p0)-v(ref_op1_0900_rl_s2_r100k_dm008p0)

* ---- instance 290: op1_1000_rl_s2_r100k_dm008p0 (variant rl_s2_r100k_dm008p0; probe dec 11.9 ns, release 34 ns, meas 36 ns) ----
vctl_op1_1000_rl_s2_r100k_dm008p0 ctl_op1_1000_rl_s2_r100k_dm008p0 0 pwl(0.0000e+00 {VDD} 2.0000e-09 {VDD} 2.1000e-09 0)
* RWL driver model (EXPERIMENTAL): slew 2 ns, series R 100000 ohm; cell pin = rwls_op1_1000_rl_s2_r100k_dm008p0
vrs_op1_1000_rl_s2_r100k_dm008p0 rwlsrc_op1_1000_rl_s2_r100k_dm008p0 0 pwl(0.0000e+00 {VDD} 2.0000e-09 {VDD} 4.0000e-09 0 2.4000e-08 0 2.6000e-08 {VDD})
rdrv_op1_1000_rl_s2_r100k_dm008p0 rwlsrc_op1_1000_rl_s2_r100k_dm008p0 rwls_op1_1000_rl_s2_r100k_dm008p0 100000
ven_op1_1000_rl_s2_r100k_dm008p0 en_op1_1000_rl_s2_r100k_dm008p0 0 pwl(0.0000e+00 0 1.1000e-08 0 1.1100e-08 {VDD} 3.4000e-08 {VDD} 3.4100e-08 0)
venb_op1_1000_rl_s2_r100k_dm008p0 enb_op1_1000_rl_s2_r100k_dm008p0 0 pwl(0.0000e+00 {VDD} 1.1000e-08 {VDD} 1.1100e-08 0 3.4000e-08 0 3.4100e-08 {VDD})
vww_op1_1000_rl_s2_r100k_dm008p0 wwl_op1_1000_rl_s2_r100k_dm008p0 0 pwl(0.0000e+00 0 1.2000e-08 0 1.2100e-08 {VDD} 3.2000e-08 {VDD} 3.2100e-08 0)
vwc_op1_1000_rl_s2_r100k_dm008p0 wbc_op1_1000_rl_s2_r100k_dm008p0 0 pwl(0.0000e+00 0 1.2000e-08 0 1.2100e-08 {VDD} 3.4000e-08 {VDD} 3.4100e-08 0)
swb_op1_1000_rl_s2_r100k_dm008p0 ref_op1_1000_rl_s2_r100k_dm008p0 wbl_op1_1000_rl_s2_r100k_dm008p0 wbc_op1_1000_rl_s2_r100k_dm008p0 0 swwbl
cwbl_op1_1000_rl_s2_r100k_dm008p0 wbl_op1_1000_rl_s2_r100k_dm008p0 0 {C_WBL}
spa_op1_1000_rl_s2_r100k_dm008p0 prea rbl_op1_1000_rl_s2_r100k_dm008p0 ctl_op1_1000_rl_s2_r100k_dm008p0 0 swpre
spr_op1_1000_rl_s2_r100k_dm008p0 pref ref_op1_1000_rl_s2_r100k_dm008p0 ctl_op1_1000_rl_s2_r100k_dm008p0 0 swpre
crbl_op1_1000_rl_s2_r100k_dm008p0 rbl_op1_1000_rl_s2_r100k_dm008p0 0 {C_RBL}
cref_op1_1000_rl_s2_r100k_dm008p0 ref_op1_1000_rl_s2_r100k_dm008p0 0 {C_RBL}   $ ASSUMPTION: ideal matched dummy load
XMWR_op1_1000_rl_s2_r100k_dm008p0_0 sn_op1_1000_rl_s2_r100k_dm008p0_0 wwl_op1_1000_rl_s2_r100k_dm008p0 wbl_op1_1000_rl_s2_r100k_dm008p0 0 sky130_fd_pr__nfet_01v8 L=0.15 W=0.42 nf=1 ad=0.1218 as=0.1218 pd=1.42 ps=1.42 nrd=0.69047619047619  nrs=0.69047619047619 sa=0 sb=0 sd=0 mult=1 m=1
XMRD_op1_1000_rl_s2_r100k_dm008p0_0 rbl_op1_1000_rl_s2_r100k_dm008p0 sn_op1_1000_rl_s2_r100k_dm008p0_0 rwls_op1_1000_rl_s2_r100k_dm008p0 0 sky130_fd_pr__nfet_01v8 L=0.15 W=0.42 nf=1 ad=0.1218 as=0.1218 pd=1.42 ps=1.42 nrd=0.69047619047619  nrs=0.69047619047619 sa=0 sb=0 sd=0 mult=1 m=1
csn_op1_1000_rl_s2_r100k_dm008p0_0 sn_op1_1000_rl_s2_r100k_dm008p0_0 0 {C_SN}
XMWR_op1_1000_rl_s2_r100k_dm008p0_1 sn_op1_1000_rl_s2_r100k_dm008p0_1 wwl_des wbl_op1_1000_rl_s2_r100k_dm008p0 0 sky130_fd_pr__nfet_01v8 L=0.15 W=0.42 nf=1 ad=0.1218 as=0.1218 pd=1.42 ps=1.42 nrd=0.69047619047619  nrs=0.69047619047619 sa=0 sb=0 sd=0 mult=1 m=1
XMRD_op1_1000_rl_s2_r100k_dm008p0_1 rbl_op1_1000_rl_s2_r100k_dm008p0 sn_op1_1000_rl_s2_r100k_dm008p0_1 rwl_des 0 sky130_fd_pr__nfet_01v8 L=0.15 W=0.42 nf=1 ad=0.1218 as=0.1218 pd=1.42 ps=1.42 nrd=0.69047619047619  nrs=0.69047619047619 sa=0 sb=0 sd=0 mult=1 m=1
csn_op1_1000_rl_s2_r100k_dm008p0_1 sn_op1_1000_rl_s2_r100k_dm008p0_1 0 {C_SN}
XMWR_op1_1000_rl_s2_r100k_dm008p0_2 sn_op1_1000_rl_s2_r100k_dm008p0_2 wwl_des wbl_op1_1000_rl_s2_r100k_dm008p0 0 sky130_fd_pr__nfet_01v8 L=0.15 W=0.42 nf=1 ad=0.1218 as=0.1218 pd=1.42 ps=1.42 nrd=0.69047619047619  nrs=0.69047619047619 sa=0 sb=0 sd=0 mult=1 m=1
XMRD_op1_1000_rl_s2_r100k_dm008p0_2 rbl_op1_1000_rl_s2_r100k_dm008p0 sn_op1_1000_rl_s2_r100k_dm008p0_2 rwl_des 0 sky130_fd_pr__nfet_01v8 L=0.15 W=0.42 nf=1 ad=0.1218 as=0.1218 pd=1.42 ps=1.42 nrd=0.69047619047619  nrs=0.69047619047619 sa=0 sb=0 sd=0 mult=1 m=1
csn_op1_1000_rl_s2_r100k_dm008p0_2 sn_op1_1000_rl_s2_r100k_dm008p0_2 0 {C_SN}
XMWR_op1_1000_rl_s2_r100k_dm008p0_3 sn_op1_1000_rl_s2_r100k_dm008p0_3 wwl_des wbl_op1_1000_rl_s2_r100k_dm008p0 0 sky130_fd_pr__nfet_01v8 L=0.15 W=0.42 nf=1 ad=0.1218 as=0.1218 pd=1.42 ps=1.42 nrd=0.69047619047619  nrs=0.69047619047619 sa=0 sb=0 sd=0 mult=1 m=1
XMRD_op1_1000_rl_s2_r100k_dm008p0_3 rbl_op1_1000_rl_s2_r100k_dm008p0 sn_op1_1000_rl_s2_r100k_dm008p0_3 rwl_des 0 sky130_fd_pr__nfet_01v8 L=0.15 W=0.42 nf=1 ad=0.1218 as=0.1218 pd=1.42 ps=1.42 nrd=0.69047619047619  nrs=0.69047619047619 sa=0 sb=0 sd=0 mult=1 m=1
csn_op1_1000_rl_s2_r100k_dm008p0_3 sn_op1_1000_rl_s2_r100k_dm008p0_3 0 {C_SN}
XMN1_op1_1000_rl_s2_r100k_dm008p0 rbl_op1_1000_rl_s2_r100k_dm008p0 ref_op1_1000_rl_s2_r100k_dm008p0 vn_op1_1000_rl_s2_r100k_dm008p0 0 sky130_fd_pr__nfet_01v8 L=0.15 W=1 nf=1 ad=0.29 as=0.29 pd=2.58 ps=2.58 mult=1 m=1
XMN2_op1_1000_rl_s2_r100k_dm008p0 ref_op1_1000_rl_s2_r100k_dm008p0 rbl_op1_1000_rl_s2_r100k_dm008p0 vn_op1_1000_rl_s2_r100k_dm008p0 0 sky130_fd_pr__nfet_01v8 L=0.15 W=1 nf=1 ad=0.29 as=0.29 pd=2.58 ps=2.58 mult=1 m=1
XMP1_op1_1000_rl_s2_r100k_dm008p0 rbl_op1_1000_rl_s2_r100k_dm008p0 ref_op1_1000_rl_s2_r100k_dm008p0 vp_op1_1000_rl_s2_r100k_dm008p0 vdd sky130_fd_pr__pfet_01v8 L=0.15 W=2 nf=1 ad=0.58 as=0.58 pd=4.58 ps=4.58 mult=1 m=1
XMP2_op1_1000_rl_s2_r100k_dm008p0 ref_op1_1000_rl_s2_r100k_dm008p0 rbl_op1_1000_rl_s2_r100k_dm008p0 vp_op1_1000_rl_s2_r100k_dm008p0 vdd sky130_fd_pr__pfet_01v8 L=0.15 W=2 nf=1 ad=0.58 as=0.58 pd=4.58 ps=4.58 mult=1 m=1
XMNF_op1_1000_rl_s2_r100k_dm008p0 vn_op1_1000_rl_s2_r100k_dm008p0 en_op1_1000_rl_s2_r100k_dm008p0 0 0 sky130_fd_pr__nfet_01v8 L=0.15 W=2 nf=1 ad=0.58 as=0.58 pd=4.58 ps=4.58 mult=1 m=1
XMPH_op1_1000_rl_s2_r100k_dm008p0 vp_op1_1000_rl_s2_r100k_dm008p0 enb_op1_1000_rl_s2_r100k_dm008p0 vdd vdd sky130_fd_pr__pfet_01v8 L=0.15 W=4 nf=1 ad=1.16 as=1.16 pd=8.58 ps=8.58 mult=1 m=1
bd_op1_1000_rl_s2_r100k_dm008p0 d_op1_1000_rl_s2_r100k_dm008p0 0 v=v(rbl_op1_1000_rl_s2_r100k_dm008p0)-v(ref_op1_1000_rl_s2_r100k_dm008p0)

* ---- instance 291: op0_n100_rl_s2_r100k_dm008p0 (variant rl_s2_r100k_dm008p0; probe dec 11.9 ns, release 34 ns, meas 36 ns) ----
vctl_op0_n100_rl_s2_r100k_dm008p0 ctl_op0_n100_rl_s2_r100k_dm008p0 0 pwl(0.0000e+00 {VDD} 2.0000e-09 {VDD} 2.1000e-09 0)
* RWL driver model (EXPERIMENTAL): slew 2 ns, series R 100000 ohm; cell pin = rwls_op0_n100_rl_s2_r100k_dm008p0
vrs_op0_n100_rl_s2_r100k_dm008p0 rwlsrc_op0_n100_rl_s2_r100k_dm008p0 0 pwl(0.0000e+00 {VDD} 2.0000e-09 {VDD} 4.0000e-09 0 2.4000e-08 0 2.6000e-08 {VDD})
rdrv_op0_n100_rl_s2_r100k_dm008p0 rwlsrc_op0_n100_rl_s2_r100k_dm008p0 rwls_op0_n100_rl_s2_r100k_dm008p0 100000
ven_op0_n100_rl_s2_r100k_dm008p0 en_op0_n100_rl_s2_r100k_dm008p0 0 pwl(0.0000e+00 0 1.1000e-08 0 1.1100e-08 {VDD} 3.4000e-08 {VDD} 3.4100e-08 0)
venb_op0_n100_rl_s2_r100k_dm008p0 enb_op0_n100_rl_s2_r100k_dm008p0 0 pwl(0.0000e+00 {VDD} 1.1000e-08 {VDD} 1.1100e-08 0 3.4000e-08 0 3.4100e-08 {VDD})
vww_op0_n100_rl_s2_r100k_dm008p0 wwl_op0_n100_rl_s2_r100k_dm008p0 0 pwl(0.0000e+00 0 1.2000e-08 0 1.2100e-08 {VDD} 3.2000e-08 {VDD} 3.2100e-08 0)
vwc_op0_n100_rl_s2_r100k_dm008p0 wbc_op0_n100_rl_s2_r100k_dm008p0 0 pwl(0.0000e+00 0 1.2000e-08 0 1.2100e-08 {VDD} 3.4000e-08 {VDD} 3.4100e-08 0)
swb_op0_n100_rl_s2_r100k_dm008p0 ref_op0_n100_rl_s2_r100k_dm008p0 wbl_op0_n100_rl_s2_r100k_dm008p0 wbc_op0_n100_rl_s2_r100k_dm008p0 0 swwbl
cwbl_op0_n100_rl_s2_r100k_dm008p0 wbl_op0_n100_rl_s2_r100k_dm008p0 0 {C_WBL}
spa_op0_n100_rl_s2_r100k_dm008p0 prea rbl_op0_n100_rl_s2_r100k_dm008p0 ctl_op0_n100_rl_s2_r100k_dm008p0 0 swpre
spr_op0_n100_rl_s2_r100k_dm008p0 pref ref_op0_n100_rl_s2_r100k_dm008p0 ctl_op0_n100_rl_s2_r100k_dm008p0 0 swpre
crbl_op0_n100_rl_s2_r100k_dm008p0 rbl_op0_n100_rl_s2_r100k_dm008p0 0 {C_RBL}
cref_op0_n100_rl_s2_r100k_dm008p0 ref_op0_n100_rl_s2_r100k_dm008p0 0 {C_RBL}   $ ASSUMPTION: ideal matched dummy load
XMWR_op0_n100_rl_s2_r100k_dm008p0_0 sn_op0_n100_rl_s2_r100k_dm008p0_0 wwl_op0_n100_rl_s2_r100k_dm008p0 wbl_op0_n100_rl_s2_r100k_dm008p0 0 sky130_fd_pr__nfet_01v8 L=0.15 W=0.42 nf=1 ad=0.1218 as=0.1218 pd=1.42 ps=1.42 nrd=0.69047619047619  nrs=0.69047619047619 sa=0 sb=0 sd=0 mult=1 m=1
XMRD_op0_n100_rl_s2_r100k_dm008p0_0 rbl_op0_n100_rl_s2_r100k_dm008p0 sn_op0_n100_rl_s2_r100k_dm008p0_0 rwls_op0_n100_rl_s2_r100k_dm008p0 0 sky130_fd_pr__nfet_01v8 L=0.15 W=0.42 nf=1 ad=0.1218 as=0.1218 pd=1.42 ps=1.42 nrd=0.69047619047619  nrs=0.69047619047619 sa=0 sb=0 sd=0 mult=1 m=1
csn_op0_n100_rl_s2_r100k_dm008p0_0 sn_op0_n100_rl_s2_r100k_dm008p0_0 0 {C_SN}
XMWR_op0_n100_rl_s2_r100k_dm008p0_1 sn_op0_n100_rl_s2_r100k_dm008p0_1 wwl_des wbl_op0_n100_rl_s2_r100k_dm008p0 0 sky130_fd_pr__nfet_01v8 L=0.15 W=0.42 nf=1 ad=0.1218 as=0.1218 pd=1.42 ps=1.42 nrd=0.69047619047619  nrs=0.69047619047619 sa=0 sb=0 sd=0 mult=1 m=1
XMRD_op0_n100_rl_s2_r100k_dm008p0_1 rbl_op0_n100_rl_s2_r100k_dm008p0 sn_op0_n100_rl_s2_r100k_dm008p0_1 rwl_des 0 sky130_fd_pr__nfet_01v8 L=0.15 W=0.42 nf=1 ad=0.1218 as=0.1218 pd=1.42 ps=1.42 nrd=0.69047619047619  nrs=0.69047619047619 sa=0 sb=0 sd=0 mult=1 m=1
csn_op0_n100_rl_s2_r100k_dm008p0_1 sn_op0_n100_rl_s2_r100k_dm008p0_1 0 {C_SN}
XMWR_op0_n100_rl_s2_r100k_dm008p0_2 sn_op0_n100_rl_s2_r100k_dm008p0_2 wwl_des wbl_op0_n100_rl_s2_r100k_dm008p0 0 sky130_fd_pr__nfet_01v8 L=0.15 W=0.42 nf=1 ad=0.1218 as=0.1218 pd=1.42 ps=1.42 nrd=0.69047619047619  nrs=0.69047619047619 sa=0 sb=0 sd=0 mult=1 m=1
XMRD_op0_n100_rl_s2_r100k_dm008p0_2 rbl_op0_n100_rl_s2_r100k_dm008p0 sn_op0_n100_rl_s2_r100k_dm008p0_2 rwl_des 0 sky130_fd_pr__nfet_01v8 L=0.15 W=0.42 nf=1 ad=0.1218 as=0.1218 pd=1.42 ps=1.42 nrd=0.69047619047619  nrs=0.69047619047619 sa=0 sb=0 sd=0 mult=1 m=1
csn_op0_n100_rl_s2_r100k_dm008p0_2 sn_op0_n100_rl_s2_r100k_dm008p0_2 0 {C_SN}
XMWR_op0_n100_rl_s2_r100k_dm008p0_3 sn_op0_n100_rl_s2_r100k_dm008p0_3 wwl_des wbl_op0_n100_rl_s2_r100k_dm008p0 0 sky130_fd_pr__nfet_01v8 L=0.15 W=0.42 nf=1 ad=0.1218 as=0.1218 pd=1.42 ps=1.42 nrd=0.69047619047619  nrs=0.69047619047619 sa=0 sb=0 sd=0 mult=1 m=1
XMRD_op0_n100_rl_s2_r100k_dm008p0_3 rbl_op0_n100_rl_s2_r100k_dm008p0 sn_op0_n100_rl_s2_r100k_dm008p0_3 rwl_des 0 sky130_fd_pr__nfet_01v8 L=0.15 W=0.42 nf=1 ad=0.1218 as=0.1218 pd=1.42 ps=1.42 nrd=0.69047619047619  nrs=0.69047619047619 sa=0 sb=0 sd=0 mult=1 m=1
csn_op0_n100_rl_s2_r100k_dm008p0_3 sn_op0_n100_rl_s2_r100k_dm008p0_3 0 {C_SN}
XMN1_op0_n100_rl_s2_r100k_dm008p0 rbl_op0_n100_rl_s2_r100k_dm008p0 ref_op0_n100_rl_s2_r100k_dm008p0 vn_op0_n100_rl_s2_r100k_dm008p0 0 sky130_fd_pr__nfet_01v8 L=0.15 W=1 nf=1 ad=0.29 as=0.29 pd=2.58 ps=2.58 mult=1 m=1
XMN2_op0_n100_rl_s2_r100k_dm008p0 ref_op0_n100_rl_s2_r100k_dm008p0 rbl_op0_n100_rl_s2_r100k_dm008p0 vn_op0_n100_rl_s2_r100k_dm008p0 0 sky130_fd_pr__nfet_01v8 L=0.15 W=1 nf=1 ad=0.29 as=0.29 pd=2.58 ps=2.58 mult=1 m=1
XMP1_op0_n100_rl_s2_r100k_dm008p0 rbl_op0_n100_rl_s2_r100k_dm008p0 ref_op0_n100_rl_s2_r100k_dm008p0 vp_op0_n100_rl_s2_r100k_dm008p0 vdd sky130_fd_pr__pfet_01v8 L=0.15 W=2 nf=1 ad=0.58 as=0.58 pd=4.58 ps=4.58 mult=1 m=1
XMP2_op0_n100_rl_s2_r100k_dm008p0 ref_op0_n100_rl_s2_r100k_dm008p0 rbl_op0_n100_rl_s2_r100k_dm008p0 vp_op0_n100_rl_s2_r100k_dm008p0 vdd sky130_fd_pr__pfet_01v8 L=0.15 W=2 nf=1 ad=0.58 as=0.58 pd=4.58 ps=4.58 mult=1 m=1
XMNF_op0_n100_rl_s2_r100k_dm008p0 vn_op0_n100_rl_s2_r100k_dm008p0 en_op0_n100_rl_s2_r100k_dm008p0 0 0 sky130_fd_pr__nfet_01v8 L=0.15 W=2 nf=1 ad=0.58 as=0.58 pd=4.58 ps=4.58 mult=1 m=1
XMPH_op0_n100_rl_s2_r100k_dm008p0 vp_op0_n100_rl_s2_r100k_dm008p0 enb_op0_n100_rl_s2_r100k_dm008p0 vdd vdd sky130_fd_pr__pfet_01v8 L=0.15 W=4 nf=1 ad=1.16 as=1.16 pd=8.58 ps=8.58 mult=1 m=1
bd_op0_n100_rl_s2_r100k_dm008p0 d_op0_n100_rl_s2_r100k_dm008p0 0 v=v(rbl_op0_n100_rl_s2_r100k_dm008p0)-v(ref_op0_n100_rl_s2_r100k_dm008p0)

* ---- instance 292: op0_0000_rl_s2_r100k_dm008p0 (variant rl_s2_r100k_dm008p0; probe dec 11.9 ns, release 34 ns, meas 36 ns) ----
vctl_op0_0000_rl_s2_r100k_dm008p0 ctl_op0_0000_rl_s2_r100k_dm008p0 0 pwl(0.0000e+00 {VDD} 2.0000e-09 {VDD} 2.1000e-09 0)
* RWL driver model (EXPERIMENTAL): slew 2 ns, series R 100000 ohm; cell pin = rwls_op0_0000_rl_s2_r100k_dm008p0
vrs_op0_0000_rl_s2_r100k_dm008p0 rwlsrc_op0_0000_rl_s2_r100k_dm008p0 0 pwl(0.0000e+00 {VDD} 2.0000e-09 {VDD} 4.0000e-09 0 2.4000e-08 0 2.6000e-08 {VDD})
rdrv_op0_0000_rl_s2_r100k_dm008p0 rwlsrc_op0_0000_rl_s2_r100k_dm008p0 rwls_op0_0000_rl_s2_r100k_dm008p0 100000
ven_op0_0000_rl_s2_r100k_dm008p0 en_op0_0000_rl_s2_r100k_dm008p0 0 pwl(0.0000e+00 0 1.1000e-08 0 1.1100e-08 {VDD} 3.4000e-08 {VDD} 3.4100e-08 0)
venb_op0_0000_rl_s2_r100k_dm008p0 enb_op0_0000_rl_s2_r100k_dm008p0 0 pwl(0.0000e+00 {VDD} 1.1000e-08 {VDD} 1.1100e-08 0 3.4000e-08 0 3.4100e-08 {VDD})
vww_op0_0000_rl_s2_r100k_dm008p0 wwl_op0_0000_rl_s2_r100k_dm008p0 0 pwl(0.0000e+00 0 1.2000e-08 0 1.2100e-08 {VDD} 3.2000e-08 {VDD} 3.2100e-08 0)
vwc_op0_0000_rl_s2_r100k_dm008p0 wbc_op0_0000_rl_s2_r100k_dm008p0 0 pwl(0.0000e+00 0 1.2000e-08 0 1.2100e-08 {VDD} 3.4000e-08 {VDD} 3.4100e-08 0)
swb_op0_0000_rl_s2_r100k_dm008p0 ref_op0_0000_rl_s2_r100k_dm008p0 wbl_op0_0000_rl_s2_r100k_dm008p0 wbc_op0_0000_rl_s2_r100k_dm008p0 0 swwbl
cwbl_op0_0000_rl_s2_r100k_dm008p0 wbl_op0_0000_rl_s2_r100k_dm008p0 0 {C_WBL}
spa_op0_0000_rl_s2_r100k_dm008p0 prea rbl_op0_0000_rl_s2_r100k_dm008p0 ctl_op0_0000_rl_s2_r100k_dm008p0 0 swpre
spr_op0_0000_rl_s2_r100k_dm008p0 pref ref_op0_0000_rl_s2_r100k_dm008p0 ctl_op0_0000_rl_s2_r100k_dm008p0 0 swpre
crbl_op0_0000_rl_s2_r100k_dm008p0 rbl_op0_0000_rl_s2_r100k_dm008p0 0 {C_RBL}
cref_op0_0000_rl_s2_r100k_dm008p0 ref_op0_0000_rl_s2_r100k_dm008p0 0 {C_RBL}   $ ASSUMPTION: ideal matched dummy load
XMWR_op0_0000_rl_s2_r100k_dm008p0_0 sn_op0_0000_rl_s2_r100k_dm008p0_0 wwl_op0_0000_rl_s2_r100k_dm008p0 wbl_op0_0000_rl_s2_r100k_dm008p0 0 sky130_fd_pr__nfet_01v8 L=0.15 W=0.42 nf=1 ad=0.1218 as=0.1218 pd=1.42 ps=1.42 nrd=0.69047619047619  nrs=0.69047619047619 sa=0 sb=0 sd=0 mult=1 m=1
XMRD_op0_0000_rl_s2_r100k_dm008p0_0 rbl_op0_0000_rl_s2_r100k_dm008p0 sn_op0_0000_rl_s2_r100k_dm008p0_0 rwls_op0_0000_rl_s2_r100k_dm008p0 0 sky130_fd_pr__nfet_01v8 L=0.15 W=0.42 nf=1 ad=0.1218 as=0.1218 pd=1.42 ps=1.42 nrd=0.69047619047619  nrs=0.69047619047619 sa=0 sb=0 sd=0 mult=1 m=1
csn_op0_0000_rl_s2_r100k_dm008p0_0 sn_op0_0000_rl_s2_r100k_dm008p0_0 0 {C_SN}
XMWR_op0_0000_rl_s2_r100k_dm008p0_1 sn_op0_0000_rl_s2_r100k_dm008p0_1 wwl_des wbl_op0_0000_rl_s2_r100k_dm008p0 0 sky130_fd_pr__nfet_01v8 L=0.15 W=0.42 nf=1 ad=0.1218 as=0.1218 pd=1.42 ps=1.42 nrd=0.69047619047619  nrs=0.69047619047619 sa=0 sb=0 sd=0 mult=1 m=1
XMRD_op0_0000_rl_s2_r100k_dm008p0_1 rbl_op0_0000_rl_s2_r100k_dm008p0 sn_op0_0000_rl_s2_r100k_dm008p0_1 rwl_des 0 sky130_fd_pr__nfet_01v8 L=0.15 W=0.42 nf=1 ad=0.1218 as=0.1218 pd=1.42 ps=1.42 nrd=0.69047619047619  nrs=0.69047619047619 sa=0 sb=0 sd=0 mult=1 m=1
csn_op0_0000_rl_s2_r100k_dm008p0_1 sn_op0_0000_rl_s2_r100k_dm008p0_1 0 {C_SN}
XMWR_op0_0000_rl_s2_r100k_dm008p0_2 sn_op0_0000_rl_s2_r100k_dm008p0_2 wwl_des wbl_op0_0000_rl_s2_r100k_dm008p0 0 sky130_fd_pr__nfet_01v8 L=0.15 W=0.42 nf=1 ad=0.1218 as=0.1218 pd=1.42 ps=1.42 nrd=0.69047619047619  nrs=0.69047619047619 sa=0 sb=0 sd=0 mult=1 m=1
XMRD_op0_0000_rl_s2_r100k_dm008p0_2 rbl_op0_0000_rl_s2_r100k_dm008p0 sn_op0_0000_rl_s2_r100k_dm008p0_2 rwl_des 0 sky130_fd_pr__nfet_01v8 L=0.15 W=0.42 nf=1 ad=0.1218 as=0.1218 pd=1.42 ps=1.42 nrd=0.69047619047619  nrs=0.69047619047619 sa=0 sb=0 sd=0 mult=1 m=1
csn_op0_0000_rl_s2_r100k_dm008p0_2 sn_op0_0000_rl_s2_r100k_dm008p0_2 0 {C_SN}
XMWR_op0_0000_rl_s2_r100k_dm008p0_3 sn_op0_0000_rl_s2_r100k_dm008p0_3 wwl_des wbl_op0_0000_rl_s2_r100k_dm008p0 0 sky130_fd_pr__nfet_01v8 L=0.15 W=0.42 nf=1 ad=0.1218 as=0.1218 pd=1.42 ps=1.42 nrd=0.69047619047619  nrs=0.69047619047619 sa=0 sb=0 sd=0 mult=1 m=1
XMRD_op0_0000_rl_s2_r100k_dm008p0_3 rbl_op0_0000_rl_s2_r100k_dm008p0 sn_op0_0000_rl_s2_r100k_dm008p0_3 rwl_des 0 sky130_fd_pr__nfet_01v8 L=0.15 W=0.42 nf=1 ad=0.1218 as=0.1218 pd=1.42 ps=1.42 nrd=0.69047619047619  nrs=0.69047619047619 sa=0 sb=0 sd=0 mult=1 m=1
csn_op0_0000_rl_s2_r100k_dm008p0_3 sn_op0_0000_rl_s2_r100k_dm008p0_3 0 {C_SN}
XMN1_op0_0000_rl_s2_r100k_dm008p0 rbl_op0_0000_rl_s2_r100k_dm008p0 ref_op0_0000_rl_s2_r100k_dm008p0 vn_op0_0000_rl_s2_r100k_dm008p0 0 sky130_fd_pr__nfet_01v8 L=0.15 W=1 nf=1 ad=0.29 as=0.29 pd=2.58 ps=2.58 mult=1 m=1
XMN2_op0_0000_rl_s2_r100k_dm008p0 ref_op0_0000_rl_s2_r100k_dm008p0 rbl_op0_0000_rl_s2_r100k_dm008p0 vn_op0_0000_rl_s2_r100k_dm008p0 0 sky130_fd_pr__nfet_01v8 L=0.15 W=1 nf=1 ad=0.29 as=0.29 pd=2.58 ps=2.58 mult=1 m=1
XMP1_op0_0000_rl_s2_r100k_dm008p0 rbl_op0_0000_rl_s2_r100k_dm008p0 ref_op0_0000_rl_s2_r100k_dm008p0 vp_op0_0000_rl_s2_r100k_dm008p0 vdd sky130_fd_pr__pfet_01v8 L=0.15 W=2 nf=1 ad=0.58 as=0.58 pd=4.58 ps=4.58 mult=1 m=1
XMP2_op0_0000_rl_s2_r100k_dm008p0 ref_op0_0000_rl_s2_r100k_dm008p0 rbl_op0_0000_rl_s2_r100k_dm008p0 vp_op0_0000_rl_s2_r100k_dm008p0 vdd sky130_fd_pr__pfet_01v8 L=0.15 W=2 nf=1 ad=0.58 as=0.58 pd=4.58 ps=4.58 mult=1 m=1
XMNF_op0_0000_rl_s2_r100k_dm008p0 vn_op0_0000_rl_s2_r100k_dm008p0 en_op0_0000_rl_s2_r100k_dm008p0 0 0 sky130_fd_pr__nfet_01v8 L=0.15 W=2 nf=1 ad=0.58 as=0.58 pd=4.58 ps=4.58 mult=1 m=1
XMPH_op0_0000_rl_s2_r100k_dm008p0 vp_op0_0000_rl_s2_r100k_dm008p0 enb_op0_0000_rl_s2_r100k_dm008p0 vdd vdd sky130_fd_pr__pfet_01v8 L=0.15 W=4 nf=1 ad=1.16 as=1.16 pd=8.58 ps=8.58 mult=1 m=1
bd_op0_0000_rl_s2_r100k_dm008p0 d_op0_0000_rl_s2_r100k_dm008p0 0 v=v(rbl_op0_0000_rl_s2_r100k_dm008p0)-v(ref_op0_0000_rl_s2_r100k_dm008p0)

* ---- instance 293: op1_0900_rl_s2_r100k_dm004p0 (variant rl_s2_r100k_dm004p0; probe dec 11.9 ns, release 34 ns, meas 36 ns) ----
vctl_op1_0900_rl_s2_r100k_dm004p0 ctl_op1_0900_rl_s2_r100k_dm004p0 0 pwl(0.0000e+00 {VDD} 2.0000e-09 {VDD} 2.1000e-09 0)
* RWL driver model (EXPERIMENTAL): slew 2 ns, series R 100000 ohm; cell pin = rwls_op1_0900_rl_s2_r100k_dm004p0
vrs_op1_0900_rl_s2_r100k_dm004p0 rwlsrc_op1_0900_rl_s2_r100k_dm004p0 0 pwl(0.0000e+00 {VDD} 2.0000e-09 {VDD} 4.0000e-09 0 2.8000e-08 0 3.0000e-08 {VDD})
rdrv_op1_0900_rl_s2_r100k_dm004p0 rwlsrc_op1_0900_rl_s2_r100k_dm004p0 rwls_op1_0900_rl_s2_r100k_dm004p0 100000
ven_op1_0900_rl_s2_r100k_dm004p0 en_op1_0900_rl_s2_r100k_dm004p0 0 pwl(0.0000e+00 0 1.1000e-08 0 1.1100e-08 {VDD} 3.4000e-08 {VDD} 3.4100e-08 0)
venb_op1_0900_rl_s2_r100k_dm004p0 enb_op1_0900_rl_s2_r100k_dm004p0 0 pwl(0.0000e+00 {VDD} 1.1000e-08 {VDD} 1.1100e-08 0 3.4000e-08 0 3.4100e-08 {VDD})
vww_op1_0900_rl_s2_r100k_dm004p0 wwl_op1_0900_rl_s2_r100k_dm004p0 0 pwl(0.0000e+00 0 1.2000e-08 0 1.2100e-08 {VDD} 3.2000e-08 {VDD} 3.2100e-08 0)
vwc_op1_0900_rl_s2_r100k_dm004p0 wbc_op1_0900_rl_s2_r100k_dm004p0 0 pwl(0.0000e+00 0 1.2000e-08 0 1.2100e-08 {VDD} 3.4000e-08 {VDD} 3.4100e-08 0)
swb_op1_0900_rl_s2_r100k_dm004p0 ref_op1_0900_rl_s2_r100k_dm004p0 wbl_op1_0900_rl_s2_r100k_dm004p0 wbc_op1_0900_rl_s2_r100k_dm004p0 0 swwbl
cwbl_op1_0900_rl_s2_r100k_dm004p0 wbl_op1_0900_rl_s2_r100k_dm004p0 0 {C_WBL}
spa_op1_0900_rl_s2_r100k_dm004p0 prea rbl_op1_0900_rl_s2_r100k_dm004p0 ctl_op1_0900_rl_s2_r100k_dm004p0 0 swpre
spr_op1_0900_rl_s2_r100k_dm004p0 pref ref_op1_0900_rl_s2_r100k_dm004p0 ctl_op1_0900_rl_s2_r100k_dm004p0 0 swpre
crbl_op1_0900_rl_s2_r100k_dm004p0 rbl_op1_0900_rl_s2_r100k_dm004p0 0 {C_RBL}
cref_op1_0900_rl_s2_r100k_dm004p0 ref_op1_0900_rl_s2_r100k_dm004p0 0 {C_RBL}   $ ASSUMPTION: ideal matched dummy load
XMWR_op1_0900_rl_s2_r100k_dm004p0_0 sn_op1_0900_rl_s2_r100k_dm004p0_0 wwl_op1_0900_rl_s2_r100k_dm004p0 wbl_op1_0900_rl_s2_r100k_dm004p0 0 sky130_fd_pr__nfet_01v8 L=0.15 W=0.42 nf=1 ad=0.1218 as=0.1218 pd=1.42 ps=1.42 nrd=0.69047619047619  nrs=0.69047619047619 sa=0 sb=0 sd=0 mult=1 m=1
XMRD_op1_0900_rl_s2_r100k_dm004p0_0 rbl_op1_0900_rl_s2_r100k_dm004p0 sn_op1_0900_rl_s2_r100k_dm004p0_0 rwls_op1_0900_rl_s2_r100k_dm004p0 0 sky130_fd_pr__nfet_01v8 L=0.15 W=0.42 nf=1 ad=0.1218 as=0.1218 pd=1.42 ps=1.42 nrd=0.69047619047619  nrs=0.69047619047619 sa=0 sb=0 sd=0 mult=1 m=1
csn_op1_0900_rl_s2_r100k_dm004p0_0 sn_op1_0900_rl_s2_r100k_dm004p0_0 0 {C_SN}
XMWR_op1_0900_rl_s2_r100k_dm004p0_1 sn_op1_0900_rl_s2_r100k_dm004p0_1 wwl_des wbl_op1_0900_rl_s2_r100k_dm004p0 0 sky130_fd_pr__nfet_01v8 L=0.15 W=0.42 nf=1 ad=0.1218 as=0.1218 pd=1.42 ps=1.42 nrd=0.69047619047619  nrs=0.69047619047619 sa=0 sb=0 sd=0 mult=1 m=1
XMRD_op1_0900_rl_s2_r100k_dm004p0_1 rbl_op1_0900_rl_s2_r100k_dm004p0 sn_op1_0900_rl_s2_r100k_dm004p0_1 rwl_des 0 sky130_fd_pr__nfet_01v8 L=0.15 W=0.42 nf=1 ad=0.1218 as=0.1218 pd=1.42 ps=1.42 nrd=0.69047619047619  nrs=0.69047619047619 sa=0 sb=0 sd=0 mult=1 m=1
csn_op1_0900_rl_s2_r100k_dm004p0_1 sn_op1_0900_rl_s2_r100k_dm004p0_1 0 {C_SN}
XMWR_op1_0900_rl_s2_r100k_dm004p0_2 sn_op1_0900_rl_s2_r100k_dm004p0_2 wwl_des wbl_op1_0900_rl_s2_r100k_dm004p0 0 sky130_fd_pr__nfet_01v8 L=0.15 W=0.42 nf=1 ad=0.1218 as=0.1218 pd=1.42 ps=1.42 nrd=0.69047619047619  nrs=0.69047619047619 sa=0 sb=0 sd=0 mult=1 m=1
XMRD_op1_0900_rl_s2_r100k_dm004p0_2 rbl_op1_0900_rl_s2_r100k_dm004p0 sn_op1_0900_rl_s2_r100k_dm004p0_2 rwl_des 0 sky130_fd_pr__nfet_01v8 L=0.15 W=0.42 nf=1 ad=0.1218 as=0.1218 pd=1.42 ps=1.42 nrd=0.69047619047619  nrs=0.69047619047619 sa=0 sb=0 sd=0 mult=1 m=1
csn_op1_0900_rl_s2_r100k_dm004p0_2 sn_op1_0900_rl_s2_r100k_dm004p0_2 0 {C_SN}
XMWR_op1_0900_rl_s2_r100k_dm004p0_3 sn_op1_0900_rl_s2_r100k_dm004p0_3 wwl_des wbl_op1_0900_rl_s2_r100k_dm004p0 0 sky130_fd_pr__nfet_01v8 L=0.15 W=0.42 nf=1 ad=0.1218 as=0.1218 pd=1.42 ps=1.42 nrd=0.69047619047619  nrs=0.69047619047619 sa=0 sb=0 sd=0 mult=1 m=1
XMRD_op1_0900_rl_s2_r100k_dm004p0_3 rbl_op1_0900_rl_s2_r100k_dm004p0 sn_op1_0900_rl_s2_r100k_dm004p0_3 rwl_des 0 sky130_fd_pr__nfet_01v8 L=0.15 W=0.42 nf=1 ad=0.1218 as=0.1218 pd=1.42 ps=1.42 nrd=0.69047619047619  nrs=0.69047619047619 sa=0 sb=0 sd=0 mult=1 m=1
csn_op1_0900_rl_s2_r100k_dm004p0_3 sn_op1_0900_rl_s2_r100k_dm004p0_3 0 {C_SN}
XMN1_op1_0900_rl_s2_r100k_dm004p0 rbl_op1_0900_rl_s2_r100k_dm004p0 ref_op1_0900_rl_s2_r100k_dm004p0 vn_op1_0900_rl_s2_r100k_dm004p0 0 sky130_fd_pr__nfet_01v8 L=0.15 W=1 nf=1 ad=0.29 as=0.29 pd=2.58 ps=2.58 mult=1 m=1
XMN2_op1_0900_rl_s2_r100k_dm004p0 ref_op1_0900_rl_s2_r100k_dm004p0 rbl_op1_0900_rl_s2_r100k_dm004p0 vn_op1_0900_rl_s2_r100k_dm004p0 0 sky130_fd_pr__nfet_01v8 L=0.15 W=1 nf=1 ad=0.29 as=0.29 pd=2.58 ps=2.58 mult=1 m=1
XMP1_op1_0900_rl_s2_r100k_dm004p0 rbl_op1_0900_rl_s2_r100k_dm004p0 ref_op1_0900_rl_s2_r100k_dm004p0 vp_op1_0900_rl_s2_r100k_dm004p0 vdd sky130_fd_pr__pfet_01v8 L=0.15 W=2 nf=1 ad=0.58 as=0.58 pd=4.58 ps=4.58 mult=1 m=1
XMP2_op1_0900_rl_s2_r100k_dm004p0 ref_op1_0900_rl_s2_r100k_dm004p0 rbl_op1_0900_rl_s2_r100k_dm004p0 vp_op1_0900_rl_s2_r100k_dm004p0 vdd sky130_fd_pr__pfet_01v8 L=0.15 W=2 nf=1 ad=0.58 as=0.58 pd=4.58 ps=4.58 mult=1 m=1
XMNF_op1_0900_rl_s2_r100k_dm004p0 vn_op1_0900_rl_s2_r100k_dm004p0 en_op1_0900_rl_s2_r100k_dm004p0 0 0 sky130_fd_pr__nfet_01v8 L=0.15 W=2 nf=1 ad=0.58 as=0.58 pd=4.58 ps=4.58 mult=1 m=1
XMPH_op1_0900_rl_s2_r100k_dm004p0 vp_op1_0900_rl_s2_r100k_dm004p0 enb_op1_0900_rl_s2_r100k_dm004p0 vdd vdd sky130_fd_pr__pfet_01v8 L=0.15 W=4 nf=1 ad=1.16 as=1.16 pd=8.58 ps=8.58 mult=1 m=1
bd_op1_0900_rl_s2_r100k_dm004p0 d_op1_0900_rl_s2_r100k_dm004p0 0 v=v(rbl_op1_0900_rl_s2_r100k_dm004p0)-v(ref_op1_0900_rl_s2_r100k_dm004p0)

* ---- instance 294: op1_1000_rl_s2_r100k_dm004p0 (variant rl_s2_r100k_dm004p0; probe dec 11.9 ns, release 34 ns, meas 36 ns) ----
vctl_op1_1000_rl_s2_r100k_dm004p0 ctl_op1_1000_rl_s2_r100k_dm004p0 0 pwl(0.0000e+00 {VDD} 2.0000e-09 {VDD} 2.1000e-09 0)
* RWL driver model (EXPERIMENTAL): slew 2 ns, series R 100000 ohm; cell pin = rwls_op1_1000_rl_s2_r100k_dm004p0
vrs_op1_1000_rl_s2_r100k_dm004p0 rwlsrc_op1_1000_rl_s2_r100k_dm004p0 0 pwl(0.0000e+00 {VDD} 2.0000e-09 {VDD} 4.0000e-09 0 2.8000e-08 0 3.0000e-08 {VDD})
rdrv_op1_1000_rl_s2_r100k_dm004p0 rwlsrc_op1_1000_rl_s2_r100k_dm004p0 rwls_op1_1000_rl_s2_r100k_dm004p0 100000
ven_op1_1000_rl_s2_r100k_dm004p0 en_op1_1000_rl_s2_r100k_dm004p0 0 pwl(0.0000e+00 0 1.1000e-08 0 1.1100e-08 {VDD} 3.4000e-08 {VDD} 3.4100e-08 0)
venb_op1_1000_rl_s2_r100k_dm004p0 enb_op1_1000_rl_s2_r100k_dm004p0 0 pwl(0.0000e+00 {VDD} 1.1000e-08 {VDD} 1.1100e-08 0 3.4000e-08 0 3.4100e-08 {VDD})
vww_op1_1000_rl_s2_r100k_dm004p0 wwl_op1_1000_rl_s2_r100k_dm004p0 0 pwl(0.0000e+00 0 1.2000e-08 0 1.2100e-08 {VDD} 3.2000e-08 {VDD} 3.2100e-08 0)
vwc_op1_1000_rl_s2_r100k_dm004p0 wbc_op1_1000_rl_s2_r100k_dm004p0 0 pwl(0.0000e+00 0 1.2000e-08 0 1.2100e-08 {VDD} 3.4000e-08 {VDD} 3.4100e-08 0)
swb_op1_1000_rl_s2_r100k_dm004p0 ref_op1_1000_rl_s2_r100k_dm004p0 wbl_op1_1000_rl_s2_r100k_dm004p0 wbc_op1_1000_rl_s2_r100k_dm004p0 0 swwbl
cwbl_op1_1000_rl_s2_r100k_dm004p0 wbl_op1_1000_rl_s2_r100k_dm004p0 0 {C_WBL}
spa_op1_1000_rl_s2_r100k_dm004p0 prea rbl_op1_1000_rl_s2_r100k_dm004p0 ctl_op1_1000_rl_s2_r100k_dm004p0 0 swpre
spr_op1_1000_rl_s2_r100k_dm004p0 pref ref_op1_1000_rl_s2_r100k_dm004p0 ctl_op1_1000_rl_s2_r100k_dm004p0 0 swpre
crbl_op1_1000_rl_s2_r100k_dm004p0 rbl_op1_1000_rl_s2_r100k_dm004p0 0 {C_RBL}
cref_op1_1000_rl_s2_r100k_dm004p0 ref_op1_1000_rl_s2_r100k_dm004p0 0 {C_RBL}   $ ASSUMPTION: ideal matched dummy load
XMWR_op1_1000_rl_s2_r100k_dm004p0_0 sn_op1_1000_rl_s2_r100k_dm004p0_0 wwl_op1_1000_rl_s2_r100k_dm004p0 wbl_op1_1000_rl_s2_r100k_dm004p0 0 sky130_fd_pr__nfet_01v8 L=0.15 W=0.42 nf=1 ad=0.1218 as=0.1218 pd=1.42 ps=1.42 nrd=0.69047619047619  nrs=0.69047619047619 sa=0 sb=0 sd=0 mult=1 m=1
XMRD_op1_1000_rl_s2_r100k_dm004p0_0 rbl_op1_1000_rl_s2_r100k_dm004p0 sn_op1_1000_rl_s2_r100k_dm004p0_0 rwls_op1_1000_rl_s2_r100k_dm004p0 0 sky130_fd_pr__nfet_01v8 L=0.15 W=0.42 nf=1 ad=0.1218 as=0.1218 pd=1.42 ps=1.42 nrd=0.69047619047619  nrs=0.69047619047619 sa=0 sb=0 sd=0 mult=1 m=1
csn_op1_1000_rl_s2_r100k_dm004p0_0 sn_op1_1000_rl_s2_r100k_dm004p0_0 0 {C_SN}
XMWR_op1_1000_rl_s2_r100k_dm004p0_1 sn_op1_1000_rl_s2_r100k_dm004p0_1 wwl_des wbl_op1_1000_rl_s2_r100k_dm004p0 0 sky130_fd_pr__nfet_01v8 L=0.15 W=0.42 nf=1 ad=0.1218 as=0.1218 pd=1.42 ps=1.42 nrd=0.69047619047619  nrs=0.69047619047619 sa=0 sb=0 sd=0 mult=1 m=1
XMRD_op1_1000_rl_s2_r100k_dm004p0_1 rbl_op1_1000_rl_s2_r100k_dm004p0 sn_op1_1000_rl_s2_r100k_dm004p0_1 rwl_des 0 sky130_fd_pr__nfet_01v8 L=0.15 W=0.42 nf=1 ad=0.1218 as=0.1218 pd=1.42 ps=1.42 nrd=0.69047619047619  nrs=0.69047619047619 sa=0 sb=0 sd=0 mult=1 m=1
csn_op1_1000_rl_s2_r100k_dm004p0_1 sn_op1_1000_rl_s2_r100k_dm004p0_1 0 {C_SN}
XMWR_op1_1000_rl_s2_r100k_dm004p0_2 sn_op1_1000_rl_s2_r100k_dm004p0_2 wwl_des wbl_op1_1000_rl_s2_r100k_dm004p0 0 sky130_fd_pr__nfet_01v8 L=0.15 W=0.42 nf=1 ad=0.1218 as=0.1218 pd=1.42 ps=1.42 nrd=0.69047619047619  nrs=0.69047619047619 sa=0 sb=0 sd=0 mult=1 m=1
XMRD_op1_1000_rl_s2_r100k_dm004p0_2 rbl_op1_1000_rl_s2_r100k_dm004p0 sn_op1_1000_rl_s2_r100k_dm004p0_2 rwl_des 0 sky130_fd_pr__nfet_01v8 L=0.15 W=0.42 nf=1 ad=0.1218 as=0.1218 pd=1.42 ps=1.42 nrd=0.69047619047619  nrs=0.69047619047619 sa=0 sb=0 sd=0 mult=1 m=1
csn_op1_1000_rl_s2_r100k_dm004p0_2 sn_op1_1000_rl_s2_r100k_dm004p0_2 0 {C_SN}
XMWR_op1_1000_rl_s2_r100k_dm004p0_3 sn_op1_1000_rl_s2_r100k_dm004p0_3 wwl_des wbl_op1_1000_rl_s2_r100k_dm004p0 0 sky130_fd_pr__nfet_01v8 L=0.15 W=0.42 nf=1 ad=0.1218 as=0.1218 pd=1.42 ps=1.42 nrd=0.69047619047619  nrs=0.69047619047619 sa=0 sb=0 sd=0 mult=1 m=1
XMRD_op1_1000_rl_s2_r100k_dm004p0_3 rbl_op1_1000_rl_s2_r100k_dm004p0 sn_op1_1000_rl_s2_r100k_dm004p0_3 rwl_des 0 sky130_fd_pr__nfet_01v8 L=0.15 W=0.42 nf=1 ad=0.1218 as=0.1218 pd=1.42 ps=1.42 nrd=0.69047619047619  nrs=0.69047619047619 sa=0 sb=0 sd=0 mult=1 m=1
csn_op1_1000_rl_s2_r100k_dm004p0_3 sn_op1_1000_rl_s2_r100k_dm004p0_3 0 {C_SN}
XMN1_op1_1000_rl_s2_r100k_dm004p0 rbl_op1_1000_rl_s2_r100k_dm004p0 ref_op1_1000_rl_s2_r100k_dm004p0 vn_op1_1000_rl_s2_r100k_dm004p0 0 sky130_fd_pr__nfet_01v8 L=0.15 W=1 nf=1 ad=0.29 as=0.29 pd=2.58 ps=2.58 mult=1 m=1
XMN2_op1_1000_rl_s2_r100k_dm004p0 ref_op1_1000_rl_s2_r100k_dm004p0 rbl_op1_1000_rl_s2_r100k_dm004p0 vn_op1_1000_rl_s2_r100k_dm004p0 0 sky130_fd_pr__nfet_01v8 L=0.15 W=1 nf=1 ad=0.29 as=0.29 pd=2.58 ps=2.58 mult=1 m=1
XMP1_op1_1000_rl_s2_r100k_dm004p0 rbl_op1_1000_rl_s2_r100k_dm004p0 ref_op1_1000_rl_s2_r100k_dm004p0 vp_op1_1000_rl_s2_r100k_dm004p0 vdd sky130_fd_pr__pfet_01v8 L=0.15 W=2 nf=1 ad=0.58 as=0.58 pd=4.58 ps=4.58 mult=1 m=1
XMP2_op1_1000_rl_s2_r100k_dm004p0 ref_op1_1000_rl_s2_r100k_dm004p0 rbl_op1_1000_rl_s2_r100k_dm004p0 vp_op1_1000_rl_s2_r100k_dm004p0 vdd sky130_fd_pr__pfet_01v8 L=0.15 W=2 nf=1 ad=0.58 as=0.58 pd=4.58 ps=4.58 mult=1 m=1
XMNF_op1_1000_rl_s2_r100k_dm004p0 vn_op1_1000_rl_s2_r100k_dm004p0 en_op1_1000_rl_s2_r100k_dm004p0 0 0 sky130_fd_pr__nfet_01v8 L=0.15 W=2 nf=1 ad=0.58 as=0.58 pd=4.58 ps=4.58 mult=1 m=1
XMPH_op1_1000_rl_s2_r100k_dm004p0 vp_op1_1000_rl_s2_r100k_dm004p0 enb_op1_1000_rl_s2_r100k_dm004p0 vdd vdd sky130_fd_pr__pfet_01v8 L=0.15 W=4 nf=1 ad=1.16 as=1.16 pd=8.58 ps=8.58 mult=1 m=1
bd_op1_1000_rl_s2_r100k_dm004p0 d_op1_1000_rl_s2_r100k_dm004p0 0 v=v(rbl_op1_1000_rl_s2_r100k_dm004p0)-v(ref_op1_1000_rl_s2_r100k_dm004p0)

* ---- instance 295: op0_n100_rl_s2_r100k_dm004p0 (variant rl_s2_r100k_dm004p0; probe dec 11.9 ns, release 34 ns, meas 36 ns) ----
vctl_op0_n100_rl_s2_r100k_dm004p0 ctl_op0_n100_rl_s2_r100k_dm004p0 0 pwl(0.0000e+00 {VDD} 2.0000e-09 {VDD} 2.1000e-09 0)
* RWL driver model (EXPERIMENTAL): slew 2 ns, series R 100000 ohm; cell pin = rwls_op0_n100_rl_s2_r100k_dm004p0
vrs_op0_n100_rl_s2_r100k_dm004p0 rwlsrc_op0_n100_rl_s2_r100k_dm004p0 0 pwl(0.0000e+00 {VDD} 2.0000e-09 {VDD} 4.0000e-09 0 2.8000e-08 0 3.0000e-08 {VDD})
rdrv_op0_n100_rl_s2_r100k_dm004p0 rwlsrc_op0_n100_rl_s2_r100k_dm004p0 rwls_op0_n100_rl_s2_r100k_dm004p0 100000
ven_op0_n100_rl_s2_r100k_dm004p0 en_op0_n100_rl_s2_r100k_dm004p0 0 pwl(0.0000e+00 0 1.1000e-08 0 1.1100e-08 {VDD} 3.4000e-08 {VDD} 3.4100e-08 0)
venb_op0_n100_rl_s2_r100k_dm004p0 enb_op0_n100_rl_s2_r100k_dm004p0 0 pwl(0.0000e+00 {VDD} 1.1000e-08 {VDD} 1.1100e-08 0 3.4000e-08 0 3.4100e-08 {VDD})
vww_op0_n100_rl_s2_r100k_dm004p0 wwl_op0_n100_rl_s2_r100k_dm004p0 0 pwl(0.0000e+00 0 1.2000e-08 0 1.2100e-08 {VDD} 3.2000e-08 {VDD} 3.2100e-08 0)
vwc_op0_n100_rl_s2_r100k_dm004p0 wbc_op0_n100_rl_s2_r100k_dm004p0 0 pwl(0.0000e+00 0 1.2000e-08 0 1.2100e-08 {VDD} 3.4000e-08 {VDD} 3.4100e-08 0)
swb_op0_n100_rl_s2_r100k_dm004p0 ref_op0_n100_rl_s2_r100k_dm004p0 wbl_op0_n100_rl_s2_r100k_dm004p0 wbc_op0_n100_rl_s2_r100k_dm004p0 0 swwbl
cwbl_op0_n100_rl_s2_r100k_dm004p0 wbl_op0_n100_rl_s2_r100k_dm004p0 0 {C_WBL}
spa_op0_n100_rl_s2_r100k_dm004p0 prea rbl_op0_n100_rl_s2_r100k_dm004p0 ctl_op0_n100_rl_s2_r100k_dm004p0 0 swpre
spr_op0_n100_rl_s2_r100k_dm004p0 pref ref_op0_n100_rl_s2_r100k_dm004p0 ctl_op0_n100_rl_s2_r100k_dm004p0 0 swpre
crbl_op0_n100_rl_s2_r100k_dm004p0 rbl_op0_n100_rl_s2_r100k_dm004p0 0 {C_RBL}
cref_op0_n100_rl_s2_r100k_dm004p0 ref_op0_n100_rl_s2_r100k_dm004p0 0 {C_RBL}   $ ASSUMPTION: ideal matched dummy load
XMWR_op0_n100_rl_s2_r100k_dm004p0_0 sn_op0_n100_rl_s2_r100k_dm004p0_0 wwl_op0_n100_rl_s2_r100k_dm004p0 wbl_op0_n100_rl_s2_r100k_dm004p0 0 sky130_fd_pr__nfet_01v8 L=0.15 W=0.42 nf=1 ad=0.1218 as=0.1218 pd=1.42 ps=1.42 nrd=0.69047619047619  nrs=0.69047619047619 sa=0 sb=0 sd=0 mult=1 m=1
XMRD_op0_n100_rl_s2_r100k_dm004p0_0 rbl_op0_n100_rl_s2_r100k_dm004p0 sn_op0_n100_rl_s2_r100k_dm004p0_0 rwls_op0_n100_rl_s2_r100k_dm004p0 0 sky130_fd_pr__nfet_01v8 L=0.15 W=0.42 nf=1 ad=0.1218 as=0.1218 pd=1.42 ps=1.42 nrd=0.69047619047619  nrs=0.69047619047619 sa=0 sb=0 sd=0 mult=1 m=1
csn_op0_n100_rl_s2_r100k_dm004p0_0 sn_op0_n100_rl_s2_r100k_dm004p0_0 0 {C_SN}
XMWR_op0_n100_rl_s2_r100k_dm004p0_1 sn_op0_n100_rl_s2_r100k_dm004p0_1 wwl_des wbl_op0_n100_rl_s2_r100k_dm004p0 0 sky130_fd_pr__nfet_01v8 L=0.15 W=0.42 nf=1 ad=0.1218 as=0.1218 pd=1.42 ps=1.42 nrd=0.69047619047619  nrs=0.69047619047619 sa=0 sb=0 sd=0 mult=1 m=1
XMRD_op0_n100_rl_s2_r100k_dm004p0_1 rbl_op0_n100_rl_s2_r100k_dm004p0 sn_op0_n100_rl_s2_r100k_dm004p0_1 rwl_des 0 sky130_fd_pr__nfet_01v8 L=0.15 W=0.42 nf=1 ad=0.1218 as=0.1218 pd=1.42 ps=1.42 nrd=0.69047619047619  nrs=0.69047619047619 sa=0 sb=0 sd=0 mult=1 m=1
csn_op0_n100_rl_s2_r100k_dm004p0_1 sn_op0_n100_rl_s2_r100k_dm004p0_1 0 {C_SN}
XMWR_op0_n100_rl_s2_r100k_dm004p0_2 sn_op0_n100_rl_s2_r100k_dm004p0_2 wwl_des wbl_op0_n100_rl_s2_r100k_dm004p0 0 sky130_fd_pr__nfet_01v8 L=0.15 W=0.42 nf=1 ad=0.1218 as=0.1218 pd=1.42 ps=1.42 nrd=0.69047619047619  nrs=0.69047619047619 sa=0 sb=0 sd=0 mult=1 m=1
XMRD_op0_n100_rl_s2_r100k_dm004p0_2 rbl_op0_n100_rl_s2_r100k_dm004p0 sn_op0_n100_rl_s2_r100k_dm004p0_2 rwl_des 0 sky130_fd_pr__nfet_01v8 L=0.15 W=0.42 nf=1 ad=0.1218 as=0.1218 pd=1.42 ps=1.42 nrd=0.69047619047619  nrs=0.69047619047619 sa=0 sb=0 sd=0 mult=1 m=1
csn_op0_n100_rl_s2_r100k_dm004p0_2 sn_op0_n100_rl_s2_r100k_dm004p0_2 0 {C_SN}
XMWR_op0_n100_rl_s2_r100k_dm004p0_3 sn_op0_n100_rl_s2_r100k_dm004p0_3 wwl_des wbl_op0_n100_rl_s2_r100k_dm004p0 0 sky130_fd_pr__nfet_01v8 L=0.15 W=0.42 nf=1 ad=0.1218 as=0.1218 pd=1.42 ps=1.42 nrd=0.69047619047619  nrs=0.69047619047619 sa=0 sb=0 sd=0 mult=1 m=1
XMRD_op0_n100_rl_s2_r100k_dm004p0_3 rbl_op0_n100_rl_s2_r100k_dm004p0 sn_op0_n100_rl_s2_r100k_dm004p0_3 rwl_des 0 sky130_fd_pr__nfet_01v8 L=0.15 W=0.42 nf=1 ad=0.1218 as=0.1218 pd=1.42 ps=1.42 nrd=0.69047619047619  nrs=0.69047619047619 sa=0 sb=0 sd=0 mult=1 m=1
csn_op0_n100_rl_s2_r100k_dm004p0_3 sn_op0_n100_rl_s2_r100k_dm004p0_3 0 {C_SN}
XMN1_op0_n100_rl_s2_r100k_dm004p0 rbl_op0_n100_rl_s2_r100k_dm004p0 ref_op0_n100_rl_s2_r100k_dm004p0 vn_op0_n100_rl_s2_r100k_dm004p0 0 sky130_fd_pr__nfet_01v8 L=0.15 W=1 nf=1 ad=0.29 as=0.29 pd=2.58 ps=2.58 mult=1 m=1
XMN2_op0_n100_rl_s2_r100k_dm004p0 ref_op0_n100_rl_s2_r100k_dm004p0 rbl_op0_n100_rl_s2_r100k_dm004p0 vn_op0_n100_rl_s2_r100k_dm004p0 0 sky130_fd_pr__nfet_01v8 L=0.15 W=1 nf=1 ad=0.29 as=0.29 pd=2.58 ps=2.58 mult=1 m=1
XMP1_op0_n100_rl_s2_r100k_dm004p0 rbl_op0_n100_rl_s2_r100k_dm004p0 ref_op0_n100_rl_s2_r100k_dm004p0 vp_op0_n100_rl_s2_r100k_dm004p0 vdd sky130_fd_pr__pfet_01v8 L=0.15 W=2 nf=1 ad=0.58 as=0.58 pd=4.58 ps=4.58 mult=1 m=1
XMP2_op0_n100_rl_s2_r100k_dm004p0 ref_op0_n100_rl_s2_r100k_dm004p0 rbl_op0_n100_rl_s2_r100k_dm004p0 vp_op0_n100_rl_s2_r100k_dm004p0 vdd sky130_fd_pr__pfet_01v8 L=0.15 W=2 nf=1 ad=0.58 as=0.58 pd=4.58 ps=4.58 mult=1 m=1
XMNF_op0_n100_rl_s2_r100k_dm004p0 vn_op0_n100_rl_s2_r100k_dm004p0 en_op0_n100_rl_s2_r100k_dm004p0 0 0 sky130_fd_pr__nfet_01v8 L=0.15 W=2 nf=1 ad=0.58 as=0.58 pd=4.58 ps=4.58 mult=1 m=1
XMPH_op0_n100_rl_s2_r100k_dm004p0 vp_op0_n100_rl_s2_r100k_dm004p0 enb_op0_n100_rl_s2_r100k_dm004p0 vdd vdd sky130_fd_pr__pfet_01v8 L=0.15 W=4 nf=1 ad=1.16 as=1.16 pd=8.58 ps=8.58 mult=1 m=1
bd_op0_n100_rl_s2_r100k_dm004p0 d_op0_n100_rl_s2_r100k_dm004p0 0 v=v(rbl_op0_n100_rl_s2_r100k_dm004p0)-v(ref_op0_n100_rl_s2_r100k_dm004p0)

* ---- instance 296: op0_0000_rl_s2_r100k_dm004p0 (variant rl_s2_r100k_dm004p0; probe dec 11.9 ns, release 34 ns, meas 36 ns) ----
vctl_op0_0000_rl_s2_r100k_dm004p0 ctl_op0_0000_rl_s2_r100k_dm004p0 0 pwl(0.0000e+00 {VDD} 2.0000e-09 {VDD} 2.1000e-09 0)
* RWL driver model (EXPERIMENTAL): slew 2 ns, series R 100000 ohm; cell pin = rwls_op0_0000_rl_s2_r100k_dm004p0
vrs_op0_0000_rl_s2_r100k_dm004p0 rwlsrc_op0_0000_rl_s2_r100k_dm004p0 0 pwl(0.0000e+00 {VDD} 2.0000e-09 {VDD} 4.0000e-09 0 2.8000e-08 0 3.0000e-08 {VDD})
rdrv_op0_0000_rl_s2_r100k_dm004p0 rwlsrc_op0_0000_rl_s2_r100k_dm004p0 rwls_op0_0000_rl_s2_r100k_dm004p0 100000
ven_op0_0000_rl_s2_r100k_dm004p0 en_op0_0000_rl_s2_r100k_dm004p0 0 pwl(0.0000e+00 0 1.1000e-08 0 1.1100e-08 {VDD} 3.4000e-08 {VDD} 3.4100e-08 0)
venb_op0_0000_rl_s2_r100k_dm004p0 enb_op0_0000_rl_s2_r100k_dm004p0 0 pwl(0.0000e+00 {VDD} 1.1000e-08 {VDD} 1.1100e-08 0 3.4000e-08 0 3.4100e-08 {VDD})
vww_op0_0000_rl_s2_r100k_dm004p0 wwl_op0_0000_rl_s2_r100k_dm004p0 0 pwl(0.0000e+00 0 1.2000e-08 0 1.2100e-08 {VDD} 3.2000e-08 {VDD} 3.2100e-08 0)
vwc_op0_0000_rl_s2_r100k_dm004p0 wbc_op0_0000_rl_s2_r100k_dm004p0 0 pwl(0.0000e+00 0 1.2000e-08 0 1.2100e-08 {VDD} 3.4000e-08 {VDD} 3.4100e-08 0)
swb_op0_0000_rl_s2_r100k_dm004p0 ref_op0_0000_rl_s2_r100k_dm004p0 wbl_op0_0000_rl_s2_r100k_dm004p0 wbc_op0_0000_rl_s2_r100k_dm004p0 0 swwbl
cwbl_op0_0000_rl_s2_r100k_dm004p0 wbl_op0_0000_rl_s2_r100k_dm004p0 0 {C_WBL}
spa_op0_0000_rl_s2_r100k_dm004p0 prea rbl_op0_0000_rl_s2_r100k_dm004p0 ctl_op0_0000_rl_s2_r100k_dm004p0 0 swpre
spr_op0_0000_rl_s2_r100k_dm004p0 pref ref_op0_0000_rl_s2_r100k_dm004p0 ctl_op0_0000_rl_s2_r100k_dm004p0 0 swpre
crbl_op0_0000_rl_s2_r100k_dm004p0 rbl_op0_0000_rl_s2_r100k_dm004p0 0 {C_RBL}
cref_op0_0000_rl_s2_r100k_dm004p0 ref_op0_0000_rl_s2_r100k_dm004p0 0 {C_RBL}   $ ASSUMPTION: ideal matched dummy load
XMWR_op0_0000_rl_s2_r100k_dm004p0_0 sn_op0_0000_rl_s2_r100k_dm004p0_0 wwl_op0_0000_rl_s2_r100k_dm004p0 wbl_op0_0000_rl_s2_r100k_dm004p0 0 sky130_fd_pr__nfet_01v8 L=0.15 W=0.42 nf=1 ad=0.1218 as=0.1218 pd=1.42 ps=1.42 nrd=0.69047619047619  nrs=0.69047619047619 sa=0 sb=0 sd=0 mult=1 m=1
XMRD_op0_0000_rl_s2_r100k_dm004p0_0 rbl_op0_0000_rl_s2_r100k_dm004p0 sn_op0_0000_rl_s2_r100k_dm004p0_0 rwls_op0_0000_rl_s2_r100k_dm004p0 0 sky130_fd_pr__nfet_01v8 L=0.15 W=0.42 nf=1 ad=0.1218 as=0.1218 pd=1.42 ps=1.42 nrd=0.69047619047619  nrs=0.69047619047619 sa=0 sb=0 sd=0 mult=1 m=1
csn_op0_0000_rl_s2_r100k_dm004p0_0 sn_op0_0000_rl_s2_r100k_dm004p0_0 0 {C_SN}
XMWR_op0_0000_rl_s2_r100k_dm004p0_1 sn_op0_0000_rl_s2_r100k_dm004p0_1 wwl_des wbl_op0_0000_rl_s2_r100k_dm004p0 0 sky130_fd_pr__nfet_01v8 L=0.15 W=0.42 nf=1 ad=0.1218 as=0.1218 pd=1.42 ps=1.42 nrd=0.69047619047619  nrs=0.69047619047619 sa=0 sb=0 sd=0 mult=1 m=1
XMRD_op0_0000_rl_s2_r100k_dm004p0_1 rbl_op0_0000_rl_s2_r100k_dm004p0 sn_op0_0000_rl_s2_r100k_dm004p0_1 rwl_des 0 sky130_fd_pr__nfet_01v8 L=0.15 W=0.42 nf=1 ad=0.1218 as=0.1218 pd=1.42 ps=1.42 nrd=0.69047619047619  nrs=0.69047619047619 sa=0 sb=0 sd=0 mult=1 m=1
csn_op0_0000_rl_s2_r100k_dm004p0_1 sn_op0_0000_rl_s2_r100k_dm004p0_1 0 {C_SN}
XMWR_op0_0000_rl_s2_r100k_dm004p0_2 sn_op0_0000_rl_s2_r100k_dm004p0_2 wwl_des wbl_op0_0000_rl_s2_r100k_dm004p0 0 sky130_fd_pr__nfet_01v8 L=0.15 W=0.42 nf=1 ad=0.1218 as=0.1218 pd=1.42 ps=1.42 nrd=0.69047619047619  nrs=0.69047619047619 sa=0 sb=0 sd=0 mult=1 m=1
XMRD_op0_0000_rl_s2_r100k_dm004p0_2 rbl_op0_0000_rl_s2_r100k_dm004p0 sn_op0_0000_rl_s2_r100k_dm004p0_2 rwl_des 0 sky130_fd_pr__nfet_01v8 L=0.15 W=0.42 nf=1 ad=0.1218 as=0.1218 pd=1.42 ps=1.42 nrd=0.69047619047619  nrs=0.69047619047619 sa=0 sb=0 sd=0 mult=1 m=1
csn_op0_0000_rl_s2_r100k_dm004p0_2 sn_op0_0000_rl_s2_r100k_dm004p0_2 0 {C_SN}
XMWR_op0_0000_rl_s2_r100k_dm004p0_3 sn_op0_0000_rl_s2_r100k_dm004p0_3 wwl_des wbl_op0_0000_rl_s2_r100k_dm004p0 0 sky130_fd_pr__nfet_01v8 L=0.15 W=0.42 nf=1 ad=0.1218 as=0.1218 pd=1.42 ps=1.42 nrd=0.69047619047619  nrs=0.69047619047619 sa=0 sb=0 sd=0 mult=1 m=1
XMRD_op0_0000_rl_s2_r100k_dm004p0_3 rbl_op0_0000_rl_s2_r100k_dm004p0 sn_op0_0000_rl_s2_r100k_dm004p0_3 rwl_des 0 sky130_fd_pr__nfet_01v8 L=0.15 W=0.42 nf=1 ad=0.1218 as=0.1218 pd=1.42 ps=1.42 nrd=0.69047619047619  nrs=0.69047619047619 sa=0 sb=0 sd=0 mult=1 m=1
csn_op0_0000_rl_s2_r100k_dm004p0_3 sn_op0_0000_rl_s2_r100k_dm004p0_3 0 {C_SN}
XMN1_op0_0000_rl_s2_r100k_dm004p0 rbl_op0_0000_rl_s2_r100k_dm004p0 ref_op0_0000_rl_s2_r100k_dm004p0 vn_op0_0000_rl_s2_r100k_dm004p0 0 sky130_fd_pr__nfet_01v8 L=0.15 W=1 nf=1 ad=0.29 as=0.29 pd=2.58 ps=2.58 mult=1 m=1
XMN2_op0_0000_rl_s2_r100k_dm004p0 ref_op0_0000_rl_s2_r100k_dm004p0 rbl_op0_0000_rl_s2_r100k_dm004p0 vn_op0_0000_rl_s2_r100k_dm004p0 0 sky130_fd_pr__nfet_01v8 L=0.15 W=1 nf=1 ad=0.29 as=0.29 pd=2.58 ps=2.58 mult=1 m=1
XMP1_op0_0000_rl_s2_r100k_dm004p0 rbl_op0_0000_rl_s2_r100k_dm004p0 ref_op0_0000_rl_s2_r100k_dm004p0 vp_op0_0000_rl_s2_r100k_dm004p0 vdd sky130_fd_pr__pfet_01v8 L=0.15 W=2 nf=1 ad=0.58 as=0.58 pd=4.58 ps=4.58 mult=1 m=1
XMP2_op0_0000_rl_s2_r100k_dm004p0 ref_op0_0000_rl_s2_r100k_dm004p0 rbl_op0_0000_rl_s2_r100k_dm004p0 vp_op0_0000_rl_s2_r100k_dm004p0 vdd sky130_fd_pr__pfet_01v8 L=0.15 W=2 nf=1 ad=0.58 as=0.58 pd=4.58 ps=4.58 mult=1 m=1
XMNF_op0_0000_rl_s2_r100k_dm004p0 vn_op0_0000_rl_s2_r100k_dm004p0 en_op0_0000_rl_s2_r100k_dm004p0 0 0 sky130_fd_pr__nfet_01v8 L=0.15 W=2 nf=1 ad=0.58 as=0.58 pd=4.58 ps=4.58 mult=1 m=1
XMPH_op0_0000_rl_s2_r100k_dm004p0 vp_op0_0000_rl_s2_r100k_dm004p0 enb_op0_0000_rl_s2_r100k_dm004p0 vdd vdd sky130_fd_pr__pfet_01v8 L=0.15 W=4 nf=1 ad=1.16 as=1.16 pd=8.58 ps=8.58 mult=1 m=1
bd_op0_0000_rl_s2_r100k_dm004p0 d_op0_0000_rl_s2_r100k_dm004p0 0 v=v(rbl_op0_0000_rl_s2_r100k_dm004p0)-v(ref_op0_0000_rl_s2_r100k_dm004p0)

* ---- instance 297: op1_0900_rl_s2_r100k_dm002p0 (variant rl_s2_r100k_dm002p0; probe dec 11.9 ns, release 34 ns, meas 36 ns) ----
vctl_op1_0900_rl_s2_r100k_dm002p0 ctl_op1_0900_rl_s2_r100k_dm002p0 0 pwl(0.0000e+00 {VDD} 2.0000e-09 {VDD} 2.1000e-09 0)
* RWL driver model (EXPERIMENTAL): slew 2 ns, series R 100000 ohm; cell pin = rwls_op1_0900_rl_s2_r100k_dm002p0
vrs_op1_0900_rl_s2_r100k_dm002p0 rwlsrc_op1_0900_rl_s2_r100k_dm002p0 0 pwl(0.0000e+00 {VDD} 2.0000e-09 {VDD} 4.0000e-09 0 3.0000e-08 0 3.2000e-08 {VDD})
rdrv_op1_0900_rl_s2_r100k_dm002p0 rwlsrc_op1_0900_rl_s2_r100k_dm002p0 rwls_op1_0900_rl_s2_r100k_dm002p0 100000
ven_op1_0900_rl_s2_r100k_dm002p0 en_op1_0900_rl_s2_r100k_dm002p0 0 pwl(0.0000e+00 0 1.1000e-08 0 1.1100e-08 {VDD} 3.4000e-08 {VDD} 3.4100e-08 0)
venb_op1_0900_rl_s2_r100k_dm002p0 enb_op1_0900_rl_s2_r100k_dm002p0 0 pwl(0.0000e+00 {VDD} 1.1000e-08 {VDD} 1.1100e-08 0 3.4000e-08 0 3.4100e-08 {VDD})
vww_op1_0900_rl_s2_r100k_dm002p0 wwl_op1_0900_rl_s2_r100k_dm002p0 0 pwl(0.0000e+00 0 1.2000e-08 0 1.2100e-08 {VDD} 3.2000e-08 {VDD} 3.2100e-08 0)
vwc_op1_0900_rl_s2_r100k_dm002p0 wbc_op1_0900_rl_s2_r100k_dm002p0 0 pwl(0.0000e+00 0 1.2000e-08 0 1.2100e-08 {VDD} 3.4000e-08 {VDD} 3.4100e-08 0)
swb_op1_0900_rl_s2_r100k_dm002p0 ref_op1_0900_rl_s2_r100k_dm002p0 wbl_op1_0900_rl_s2_r100k_dm002p0 wbc_op1_0900_rl_s2_r100k_dm002p0 0 swwbl
cwbl_op1_0900_rl_s2_r100k_dm002p0 wbl_op1_0900_rl_s2_r100k_dm002p0 0 {C_WBL}
spa_op1_0900_rl_s2_r100k_dm002p0 prea rbl_op1_0900_rl_s2_r100k_dm002p0 ctl_op1_0900_rl_s2_r100k_dm002p0 0 swpre
spr_op1_0900_rl_s2_r100k_dm002p0 pref ref_op1_0900_rl_s2_r100k_dm002p0 ctl_op1_0900_rl_s2_r100k_dm002p0 0 swpre
crbl_op1_0900_rl_s2_r100k_dm002p0 rbl_op1_0900_rl_s2_r100k_dm002p0 0 {C_RBL}
cref_op1_0900_rl_s2_r100k_dm002p0 ref_op1_0900_rl_s2_r100k_dm002p0 0 {C_RBL}   $ ASSUMPTION: ideal matched dummy load
XMWR_op1_0900_rl_s2_r100k_dm002p0_0 sn_op1_0900_rl_s2_r100k_dm002p0_0 wwl_op1_0900_rl_s2_r100k_dm002p0 wbl_op1_0900_rl_s2_r100k_dm002p0 0 sky130_fd_pr__nfet_01v8 L=0.15 W=0.42 nf=1 ad=0.1218 as=0.1218 pd=1.42 ps=1.42 nrd=0.69047619047619  nrs=0.69047619047619 sa=0 sb=0 sd=0 mult=1 m=1
XMRD_op1_0900_rl_s2_r100k_dm002p0_0 rbl_op1_0900_rl_s2_r100k_dm002p0 sn_op1_0900_rl_s2_r100k_dm002p0_0 rwls_op1_0900_rl_s2_r100k_dm002p0 0 sky130_fd_pr__nfet_01v8 L=0.15 W=0.42 nf=1 ad=0.1218 as=0.1218 pd=1.42 ps=1.42 nrd=0.69047619047619  nrs=0.69047619047619 sa=0 sb=0 sd=0 mult=1 m=1
csn_op1_0900_rl_s2_r100k_dm002p0_0 sn_op1_0900_rl_s2_r100k_dm002p0_0 0 {C_SN}
XMWR_op1_0900_rl_s2_r100k_dm002p0_1 sn_op1_0900_rl_s2_r100k_dm002p0_1 wwl_des wbl_op1_0900_rl_s2_r100k_dm002p0 0 sky130_fd_pr__nfet_01v8 L=0.15 W=0.42 nf=1 ad=0.1218 as=0.1218 pd=1.42 ps=1.42 nrd=0.69047619047619  nrs=0.69047619047619 sa=0 sb=0 sd=0 mult=1 m=1
XMRD_op1_0900_rl_s2_r100k_dm002p0_1 rbl_op1_0900_rl_s2_r100k_dm002p0 sn_op1_0900_rl_s2_r100k_dm002p0_1 rwl_des 0 sky130_fd_pr__nfet_01v8 L=0.15 W=0.42 nf=1 ad=0.1218 as=0.1218 pd=1.42 ps=1.42 nrd=0.69047619047619  nrs=0.69047619047619 sa=0 sb=0 sd=0 mult=1 m=1
csn_op1_0900_rl_s2_r100k_dm002p0_1 sn_op1_0900_rl_s2_r100k_dm002p0_1 0 {C_SN}
XMWR_op1_0900_rl_s2_r100k_dm002p0_2 sn_op1_0900_rl_s2_r100k_dm002p0_2 wwl_des wbl_op1_0900_rl_s2_r100k_dm002p0 0 sky130_fd_pr__nfet_01v8 L=0.15 W=0.42 nf=1 ad=0.1218 as=0.1218 pd=1.42 ps=1.42 nrd=0.69047619047619  nrs=0.69047619047619 sa=0 sb=0 sd=0 mult=1 m=1
XMRD_op1_0900_rl_s2_r100k_dm002p0_2 rbl_op1_0900_rl_s2_r100k_dm002p0 sn_op1_0900_rl_s2_r100k_dm002p0_2 rwl_des 0 sky130_fd_pr__nfet_01v8 L=0.15 W=0.42 nf=1 ad=0.1218 as=0.1218 pd=1.42 ps=1.42 nrd=0.69047619047619  nrs=0.69047619047619 sa=0 sb=0 sd=0 mult=1 m=1
csn_op1_0900_rl_s2_r100k_dm002p0_2 sn_op1_0900_rl_s2_r100k_dm002p0_2 0 {C_SN}
XMWR_op1_0900_rl_s2_r100k_dm002p0_3 sn_op1_0900_rl_s2_r100k_dm002p0_3 wwl_des wbl_op1_0900_rl_s2_r100k_dm002p0 0 sky130_fd_pr__nfet_01v8 L=0.15 W=0.42 nf=1 ad=0.1218 as=0.1218 pd=1.42 ps=1.42 nrd=0.69047619047619  nrs=0.69047619047619 sa=0 sb=0 sd=0 mult=1 m=1
XMRD_op1_0900_rl_s2_r100k_dm002p0_3 rbl_op1_0900_rl_s2_r100k_dm002p0 sn_op1_0900_rl_s2_r100k_dm002p0_3 rwl_des 0 sky130_fd_pr__nfet_01v8 L=0.15 W=0.42 nf=1 ad=0.1218 as=0.1218 pd=1.42 ps=1.42 nrd=0.69047619047619  nrs=0.69047619047619 sa=0 sb=0 sd=0 mult=1 m=1
csn_op1_0900_rl_s2_r100k_dm002p0_3 sn_op1_0900_rl_s2_r100k_dm002p0_3 0 {C_SN}
XMN1_op1_0900_rl_s2_r100k_dm002p0 rbl_op1_0900_rl_s2_r100k_dm002p0 ref_op1_0900_rl_s2_r100k_dm002p0 vn_op1_0900_rl_s2_r100k_dm002p0 0 sky130_fd_pr__nfet_01v8 L=0.15 W=1 nf=1 ad=0.29 as=0.29 pd=2.58 ps=2.58 mult=1 m=1
XMN2_op1_0900_rl_s2_r100k_dm002p0 ref_op1_0900_rl_s2_r100k_dm002p0 rbl_op1_0900_rl_s2_r100k_dm002p0 vn_op1_0900_rl_s2_r100k_dm002p0 0 sky130_fd_pr__nfet_01v8 L=0.15 W=1 nf=1 ad=0.29 as=0.29 pd=2.58 ps=2.58 mult=1 m=1
XMP1_op1_0900_rl_s2_r100k_dm002p0 rbl_op1_0900_rl_s2_r100k_dm002p0 ref_op1_0900_rl_s2_r100k_dm002p0 vp_op1_0900_rl_s2_r100k_dm002p0 vdd sky130_fd_pr__pfet_01v8 L=0.15 W=2 nf=1 ad=0.58 as=0.58 pd=4.58 ps=4.58 mult=1 m=1
XMP2_op1_0900_rl_s2_r100k_dm002p0 ref_op1_0900_rl_s2_r100k_dm002p0 rbl_op1_0900_rl_s2_r100k_dm002p0 vp_op1_0900_rl_s2_r100k_dm002p0 vdd sky130_fd_pr__pfet_01v8 L=0.15 W=2 nf=1 ad=0.58 as=0.58 pd=4.58 ps=4.58 mult=1 m=1
XMNF_op1_0900_rl_s2_r100k_dm002p0 vn_op1_0900_rl_s2_r100k_dm002p0 en_op1_0900_rl_s2_r100k_dm002p0 0 0 sky130_fd_pr__nfet_01v8 L=0.15 W=2 nf=1 ad=0.58 as=0.58 pd=4.58 ps=4.58 mult=1 m=1
XMPH_op1_0900_rl_s2_r100k_dm002p0 vp_op1_0900_rl_s2_r100k_dm002p0 enb_op1_0900_rl_s2_r100k_dm002p0 vdd vdd sky130_fd_pr__pfet_01v8 L=0.15 W=4 nf=1 ad=1.16 as=1.16 pd=8.58 ps=8.58 mult=1 m=1
bd_op1_0900_rl_s2_r100k_dm002p0 d_op1_0900_rl_s2_r100k_dm002p0 0 v=v(rbl_op1_0900_rl_s2_r100k_dm002p0)-v(ref_op1_0900_rl_s2_r100k_dm002p0)

* ---- instance 298: op1_1000_rl_s2_r100k_dm002p0 (variant rl_s2_r100k_dm002p0; probe dec 11.9 ns, release 34 ns, meas 36 ns) ----
vctl_op1_1000_rl_s2_r100k_dm002p0 ctl_op1_1000_rl_s2_r100k_dm002p0 0 pwl(0.0000e+00 {VDD} 2.0000e-09 {VDD} 2.1000e-09 0)
* RWL driver model (EXPERIMENTAL): slew 2 ns, series R 100000 ohm; cell pin = rwls_op1_1000_rl_s2_r100k_dm002p0
vrs_op1_1000_rl_s2_r100k_dm002p0 rwlsrc_op1_1000_rl_s2_r100k_dm002p0 0 pwl(0.0000e+00 {VDD} 2.0000e-09 {VDD} 4.0000e-09 0 3.0000e-08 0 3.2000e-08 {VDD})
rdrv_op1_1000_rl_s2_r100k_dm002p0 rwlsrc_op1_1000_rl_s2_r100k_dm002p0 rwls_op1_1000_rl_s2_r100k_dm002p0 100000
ven_op1_1000_rl_s2_r100k_dm002p0 en_op1_1000_rl_s2_r100k_dm002p0 0 pwl(0.0000e+00 0 1.1000e-08 0 1.1100e-08 {VDD} 3.4000e-08 {VDD} 3.4100e-08 0)
venb_op1_1000_rl_s2_r100k_dm002p0 enb_op1_1000_rl_s2_r100k_dm002p0 0 pwl(0.0000e+00 {VDD} 1.1000e-08 {VDD} 1.1100e-08 0 3.4000e-08 0 3.4100e-08 {VDD})
vww_op1_1000_rl_s2_r100k_dm002p0 wwl_op1_1000_rl_s2_r100k_dm002p0 0 pwl(0.0000e+00 0 1.2000e-08 0 1.2100e-08 {VDD} 3.2000e-08 {VDD} 3.2100e-08 0)
vwc_op1_1000_rl_s2_r100k_dm002p0 wbc_op1_1000_rl_s2_r100k_dm002p0 0 pwl(0.0000e+00 0 1.2000e-08 0 1.2100e-08 {VDD} 3.4000e-08 {VDD} 3.4100e-08 0)
swb_op1_1000_rl_s2_r100k_dm002p0 ref_op1_1000_rl_s2_r100k_dm002p0 wbl_op1_1000_rl_s2_r100k_dm002p0 wbc_op1_1000_rl_s2_r100k_dm002p0 0 swwbl
cwbl_op1_1000_rl_s2_r100k_dm002p0 wbl_op1_1000_rl_s2_r100k_dm002p0 0 {C_WBL}
spa_op1_1000_rl_s2_r100k_dm002p0 prea rbl_op1_1000_rl_s2_r100k_dm002p0 ctl_op1_1000_rl_s2_r100k_dm002p0 0 swpre
spr_op1_1000_rl_s2_r100k_dm002p0 pref ref_op1_1000_rl_s2_r100k_dm002p0 ctl_op1_1000_rl_s2_r100k_dm002p0 0 swpre
crbl_op1_1000_rl_s2_r100k_dm002p0 rbl_op1_1000_rl_s2_r100k_dm002p0 0 {C_RBL}
cref_op1_1000_rl_s2_r100k_dm002p0 ref_op1_1000_rl_s2_r100k_dm002p0 0 {C_RBL}   $ ASSUMPTION: ideal matched dummy load
XMWR_op1_1000_rl_s2_r100k_dm002p0_0 sn_op1_1000_rl_s2_r100k_dm002p0_0 wwl_op1_1000_rl_s2_r100k_dm002p0 wbl_op1_1000_rl_s2_r100k_dm002p0 0 sky130_fd_pr__nfet_01v8 L=0.15 W=0.42 nf=1 ad=0.1218 as=0.1218 pd=1.42 ps=1.42 nrd=0.69047619047619  nrs=0.69047619047619 sa=0 sb=0 sd=0 mult=1 m=1
XMRD_op1_1000_rl_s2_r100k_dm002p0_0 rbl_op1_1000_rl_s2_r100k_dm002p0 sn_op1_1000_rl_s2_r100k_dm002p0_0 rwls_op1_1000_rl_s2_r100k_dm002p0 0 sky130_fd_pr__nfet_01v8 L=0.15 W=0.42 nf=1 ad=0.1218 as=0.1218 pd=1.42 ps=1.42 nrd=0.69047619047619  nrs=0.69047619047619 sa=0 sb=0 sd=0 mult=1 m=1
csn_op1_1000_rl_s2_r100k_dm002p0_0 sn_op1_1000_rl_s2_r100k_dm002p0_0 0 {C_SN}
XMWR_op1_1000_rl_s2_r100k_dm002p0_1 sn_op1_1000_rl_s2_r100k_dm002p0_1 wwl_des wbl_op1_1000_rl_s2_r100k_dm002p0 0 sky130_fd_pr__nfet_01v8 L=0.15 W=0.42 nf=1 ad=0.1218 as=0.1218 pd=1.42 ps=1.42 nrd=0.69047619047619  nrs=0.69047619047619 sa=0 sb=0 sd=0 mult=1 m=1
XMRD_op1_1000_rl_s2_r100k_dm002p0_1 rbl_op1_1000_rl_s2_r100k_dm002p0 sn_op1_1000_rl_s2_r100k_dm002p0_1 rwl_des 0 sky130_fd_pr__nfet_01v8 L=0.15 W=0.42 nf=1 ad=0.1218 as=0.1218 pd=1.42 ps=1.42 nrd=0.69047619047619  nrs=0.69047619047619 sa=0 sb=0 sd=0 mult=1 m=1
csn_op1_1000_rl_s2_r100k_dm002p0_1 sn_op1_1000_rl_s2_r100k_dm002p0_1 0 {C_SN}
XMWR_op1_1000_rl_s2_r100k_dm002p0_2 sn_op1_1000_rl_s2_r100k_dm002p0_2 wwl_des wbl_op1_1000_rl_s2_r100k_dm002p0 0 sky130_fd_pr__nfet_01v8 L=0.15 W=0.42 nf=1 ad=0.1218 as=0.1218 pd=1.42 ps=1.42 nrd=0.69047619047619  nrs=0.69047619047619 sa=0 sb=0 sd=0 mult=1 m=1
XMRD_op1_1000_rl_s2_r100k_dm002p0_2 rbl_op1_1000_rl_s2_r100k_dm002p0 sn_op1_1000_rl_s2_r100k_dm002p0_2 rwl_des 0 sky130_fd_pr__nfet_01v8 L=0.15 W=0.42 nf=1 ad=0.1218 as=0.1218 pd=1.42 ps=1.42 nrd=0.69047619047619  nrs=0.69047619047619 sa=0 sb=0 sd=0 mult=1 m=1
csn_op1_1000_rl_s2_r100k_dm002p0_2 sn_op1_1000_rl_s2_r100k_dm002p0_2 0 {C_SN}
XMWR_op1_1000_rl_s2_r100k_dm002p0_3 sn_op1_1000_rl_s2_r100k_dm002p0_3 wwl_des wbl_op1_1000_rl_s2_r100k_dm002p0 0 sky130_fd_pr__nfet_01v8 L=0.15 W=0.42 nf=1 ad=0.1218 as=0.1218 pd=1.42 ps=1.42 nrd=0.69047619047619  nrs=0.69047619047619 sa=0 sb=0 sd=0 mult=1 m=1
XMRD_op1_1000_rl_s2_r100k_dm002p0_3 rbl_op1_1000_rl_s2_r100k_dm002p0 sn_op1_1000_rl_s2_r100k_dm002p0_3 rwl_des 0 sky130_fd_pr__nfet_01v8 L=0.15 W=0.42 nf=1 ad=0.1218 as=0.1218 pd=1.42 ps=1.42 nrd=0.69047619047619  nrs=0.69047619047619 sa=0 sb=0 sd=0 mult=1 m=1
csn_op1_1000_rl_s2_r100k_dm002p0_3 sn_op1_1000_rl_s2_r100k_dm002p0_3 0 {C_SN}
XMN1_op1_1000_rl_s2_r100k_dm002p0 rbl_op1_1000_rl_s2_r100k_dm002p0 ref_op1_1000_rl_s2_r100k_dm002p0 vn_op1_1000_rl_s2_r100k_dm002p0 0 sky130_fd_pr__nfet_01v8 L=0.15 W=1 nf=1 ad=0.29 as=0.29 pd=2.58 ps=2.58 mult=1 m=1
XMN2_op1_1000_rl_s2_r100k_dm002p0 ref_op1_1000_rl_s2_r100k_dm002p0 rbl_op1_1000_rl_s2_r100k_dm002p0 vn_op1_1000_rl_s2_r100k_dm002p0 0 sky130_fd_pr__nfet_01v8 L=0.15 W=1 nf=1 ad=0.29 as=0.29 pd=2.58 ps=2.58 mult=1 m=1
XMP1_op1_1000_rl_s2_r100k_dm002p0 rbl_op1_1000_rl_s2_r100k_dm002p0 ref_op1_1000_rl_s2_r100k_dm002p0 vp_op1_1000_rl_s2_r100k_dm002p0 vdd sky130_fd_pr__pfet_01v8 L=0.15 W=2 nf=1 ad=0.58 as=0.58 pd=4.58 ps=4.58 mult=1 m=1
XMP2_op1_1000_rl_s2_r100k_dm002p0 ref_op1_1000_rl_s2_r100k_dm002p0 rbl_op1_1000_rl_s2_r100k_dm002p0 vp_op1_1000_rl_s2_r100k_dm002p0 vdd sky130_fd_pr__pfet_01v8 L=0.15 W=2 nf=1 ad=0.58 as=0.58 pd=4.58 ps=4.58 mult=1 m=1
XMNF_op1_1000_rl_s2_r100k_dm002p0 vn_op1_1000_rl_s2_r100k_dm002p0 en_op1_1000_rl_s2_r100k_dm002p0 0 0 sky130_fd_pr__nfet_01v8 L=0.15 W=2 nf=1 ad=0.58 as=0.58 pd=4.58 ps=4.58 mult=1 m=1
XMPH_op1_1000_rl_s2_r100k_dm002p0 vp_op1_1000_rl_s2_r100k_dm002p0 enb_op1_1000_rl_s2_r100k_dm002p0 vdd vdd sky130_fd_pr__pfet_01v8 L=0.15 W=4 nf=1 ad=1.16 as=1.16 pd=8.58 ps=8.58 mult=1 m=1
bd_op1_1000_rl_s2_r100k_dm002p0 d_op1_1000_rl_s2_r100k_dm002p0 0 v=v(rbl_op1_1000_rl_s2_r100k_dm002p0)-v(ref_op1_1000_rl_s2_r100k_dm002p0)

* ---- instance 299: op0_n100_rl_s2_r100k_dm002p0 (variant rl_s2_r100k_dm002p0; probe dec 11.9 ns, release 34 ns, meas 36 ns) ----
vctl_op0_n100_rl_s2_r100k_dm002p0 ctl_op0_n100_rl_s2_r100k_dm002p0 0 pwl(0.0000e+00 {VDD} 2.0000e-09 {VDD} 2.1000e-09 0)
* RWL driver model (EXPERIMENTAL): slew 2 ns, series R 100000 ohm; cell pin = rwls_op0_n100_rl_s2_r100k_dm002p0
vrs_op0_n100_rl_s2_r100k_dm002p0 rwlsrc_op0_n100_rl_s2_r100k_dm002p0 0 pwl(0.0000e+00 {VDD} 2.0000e-09 {VDD} 4.0000e-09 0 3.0000e-08 0 3.2000e-08 {VDD})
rdrv_op0_n100_rl_s2_r100k_dm002p0 rwlsrc_op0_n100_rl_s2_r100k_dm002p0 rwls_op0_n100_rl_s2_r100k_dm002p0 100000
ven_op0_n100_rl_s2_r100k_dm002p0 en_op0_n100_rl_s2_r100k_dm002p0 0 pwl(0.0000e+00 0 1.1000e-08 0 1.1100e-08 {VDD} 3.4000e-08 {VDD} 3.4100e-08 0)
venb_op0_n100_rl_s2_r100k_dm002p0 enb_op0_n100_rl_s2_r100k_dm002p0 0 pwl(0.0000e+00 {VDD} 1.1000e-08 {VDD} 1.1100e-08 0 3.4000e-08 0 3.4100e-08 {VDD})
vww_op0_n100_rl_s2_r100k_dm002p0 wwl_op0_n100_rl_s2_r100k_dm002p0 0 pwl(0.0000e+00 0 1.2000e-08 0 1.2100e-08 {VDD} 3.2000e-08 {VDD} 3.2100e-08 0)
vwc_op0_n100_rl_s2_r100k_dm002p0 wbc_op0_n100_rl_s2_r100k_dm002p0 0 pwl(0.0000e+00 0 1.2000e-08 0 1.2100e-08 {VDD} 3.4000e-08 {VDD} 3.4100e-08 0)
swb_op0_n100_rl_s2_r100k_dm002p0 ref_op0_n100_rl_s2_r100k_dm002p0 wbl_op0_n100_rl_s2_r100k_dm002p0 wbc_op0_n100_rl_s2_r100k_dm002p0 0 swwbl
cwbl_op0_n100_rl_s2_r100k_dm002p0 wbl_op0_n100_rl_s2_r100k_dm002p0 0 {C_WBL}
spa_op0_n100_rl_s2_r100k_dm002p0 prea rbl_op0_n100_rl_s2_r100k_dm002p0 ctl_op0_n100_rl_s2_r100k_dm002p0 0 swpre
spr_op0_n100_rl_s2_r100k_dm002p0 pref ref_op0_n100_rl_s2_r100k_dm002p0 ctl_op0_n100_rl_s2_r100k_dm002p0 0 swpre
crbl_op0_n100_rl_s2_r100k_dm002p0 rbl_op0_n100_rl_s2_r100k_dm002p0 0 {C_RBL}
cref_op0_n100_rl_s2_r100k_dm002p0 ref_op0_n100_rl_s2_r100k_dm002p0 0 {C_RBL}   $ ASSUMPTION: ideal matched dummy load
XMWR_op0_n100_rl_s2_r100k_dm002p0_0 sn_op0_n100_rl_s2_r100k_dm002p0_0 wwl_op0_n100_rl_s2_r100k_dm002p0 wbl_op0_n100_rl_s2_r100k_dm002p0 0 sky130_fd_pr__nfet_01v8 L=0.15 W=0.42 nf=1 ad=0.1218 as=0.1218 pd=1.42 ps=1.42 nrd=0.69047619047619  nrs=0.69047619047619 sa=0 sb=0 sd=0 mult=1 m=1
XMRD_op0_n100_rl_s2_r100k_dm002p0_0 rbl_op0_n100_rl_s2_r100k_dm002p0 sn_op0_n100_rl_s2_r100k_dm002p0_0 rwls_op0_n100_rl_s2_r100k_dm002p0 0 sky130_fd_pr__nfet_01v8 L=0.15 W=0.42 nf=1 ad=0.1218 as=0.1218 pd=1.42 ps=1.42 nrd=0.69047619047619  nrs=0.69047619047619 sa=0 sb=0 sd=0 mult=1 m=1
csn_op0_n100_rl_s2_r100k_dm002p0_0 sn_op0_n100_rl_s2_r100k_dm002p0_0 0 {C_SN}
XMWR_op0_n100_rl_s2_r100k_dm002p0_1 sn_op0_n100_rl_s2_r100k_dm002p0_1 wwl_des wbl_op0_n100_rl_s2_r100k_dm002p0 0 sky130_fd_pr__nfet_01v8 L=0.15 W=0.42 nf=1 ad=0.1218 as=0.1218 pd=1.42 ps=1.42 nrd=0.69047619047619  nrs=0.69047619047619 sa=0 sb=0 sd=0 mult=1 m=1
XMRD_op0_n100_rl_s2_r100k_dm002p0_1 rbl_op0_n100_rl_s2_r100k_dm002p0 sn_op0_n100_rl_s2_r100k_dm002p0_1 rwl_des 0 sky130_fd_pr__nfet_01v8 L=0.15 W=0.42 nf=1 ad=0.1218 as=0.1218 pd=1.42 ps=1.42 nrd=0.69047619047619  nrs=0.69047619047619 sa=0 sb=0 sd=0 mult=1 m=1
csn_op0_n100_rl_s2_r100k_dm002p0_1 sn_op0_n100_rl_s2_r100k_dm002p0_1 0 {C_SN}
XMWR_op0_n100_rl_s2_r100k_dm002p0_2 sn_op0_n100_rl_s2_r100k_dm002p0_2 wwl_des wbl_op0_n100_rl_s2_r100k_dm002p0 0 sky130_fd_pr__nfet_01v8 L=0.15 W=0.42 nf=1 ad=0.1218 as=0.1218 pd=1.42 ps=1.42 nrd=0.69047619047619  nrs=0.69047619047619 sa=0 sb=0 sd=0 mult=1 m=1
XMRD_op0_n100_rl_s2_r100k_dm002p0_2 rbl_op0_n100_rl_s2_r100k_dm002p0 sn_op0_n100_rl_s2_r100k_dm002p0_2 rwl_des 0 sky130_fd_pr__nfet_01v8 L=0.15 W=0.42 nf=1 ad=0.1218 as=0.1218 pd=1.42 ps=1.42 nrd=0.69047619047619  nrs=0.69047619047619 sa=0 sb=0 sd=0 mult=1 m=1
csn_op0_n100_rl_s2_r100k_dm002p0_2 sn_op0_n100_rl_s2_r100k_dm002p0_2 0 {C_SN}
XMWR_op0_n100_rl_s2_r100k_dm002p0_3 sn_op0_n100_rl_s2_r100k_dm002p0_3 wwl_des wbl_op0_n100_rl_s2_r100k_dm002p0 0 sky130_fd_pr__nfet_01v8 L=0.15 W=0.42 nf=1 ad=0.1218 as=0.1218 pd=1.42 ps=1.42 nrd=0.69047619047619  nrs=0.69047619047619 sa=0 sb=0 sd=0 mult=1 m=1
XMRD_op0_n100_rl_s2_r100k_dm002p0_3 rbl_op0_n100_rl_s2_r100k_dm002p0 sn_op0_n100_rl_s2_r100k_dm002p0_3 rwl_des 0 sky130_fd_pr__nfet_01v8 L=0.15 W=0.42 nf=1 ad=0.1218 as=0.1218 pd=1.42 ps=1.42 nrd=0.69047619047619  nrs=0.69047619047619 sa=0 sb=0 sd=0 mult=1 m=1
csn_op0_n100_rl_s2_r100k_dm002p0_3 sn_op0_n100_rl_s2_r100k_dm002p0_3 0 {C_SN}
XMN1_op0_n100_rl_s2_r100k_dm002p0 rbl_op0_n100_rl_s2_r100k_dm002p0 ref_op0_n100_rl_s2_r100k_dm002p0 vn_op0_n100_rl_s2_r100k_dm002p0 0 sky130_fd_pr__nfet_01v8 L=0.15 W=1 nf=1 ad=0.29 as=0.29 pd=2.58 ps=2.58 mult=1 m=1
XMN2_op0_n100_rl_s2_r100k_dm002p0 ref_op0_n100_rl_s2_r100k_dm002p0 rbl_op0_n100_rl_s2_r100k_dm002p0 vn_op0_n100_rl_s2_r100k_dm002p0 0 sky130_fd_pr__nfet_01v8 L=0.15 W=1 nf=1 ad=0.29 as=0.29 pd=2.58 ps=2.58 mult=1 m=1
XMP1_op0_n100_rl_s2_r100k_dm002p0 rbl_op0_n100_rl_s2_r100k_dm002p0 ref_op0_n100_rl_s2_r100k_dm002p0 vp_op0_n100_rl_s2_r100k_dm002p0 vdd sky130_fd_pr__pfet_01v8 L=0.15 W=2 nf=1 ad=0.58 as=0.58 pd=4.58 ps=4.58 mult=1 m=1
XMP2_op0_n100_rl_s2_r100k_dm002p0 ref_op0_n100_rl_s2_r100k_dm002p0 rbl_op0_n100_rl_s2_r100k_dm002p0 vp_op0_n100_rl_s2_r100k_dm002p0 vdd sky130_fd_pr__pfet_01v8 L=0.15 W=2 nf=1 ad=0.58 as=0.58 pd=4.58 ps=4.58 mult=1 m=1
XMNF_op0_n100_rl_s2_r100k_dm002p0 vn_op0_n100_rl_s2_r100k_dm002p0 en_op0_n100_rl_s2_r100k_dm002p0 0 0 sky130_fd_pr__nfet_01v8 L=0.15 W=2 nf=1 ad=0.58 as=0.58 pd=4.58 ps=4.58 mult=1 m=1
XMPH_op0_n100_rl_s2_r100k_dm002p0 vp_op0_n100_rl_s2_r100k_dm002p0 enb_op0_n100_rl_s2_r100k_dm002p0 vdd vdd sky130_fd_pr__pfet_01v8 L=0.15 W=4 nf=1 ad=1.16 as=1.16 pd=8.58 ps=8.58 mult=1 m=1
bd_op0_n100_rl_s2_r100k_dm002p0 d_op0_n100_rl_s2_r100k_dm002p0 0 v=v(rbl_op0_n100_rl_s2_r100k_dm002p0)-v(ref_op0_n100_rl_s2_r100k_dm002p0)

* ---- instance 300: op0_0000_rl_s2_r100k_dm002p0 (variant rl_s2_r100k_dm002p0; probe dec 11.9 ns, release 34 ns, meas 36 ns) ----
vctl_op0_0000_rl_s2_r100k_dm002p0 ctl_op0_0000_rl_s2_r100k_dm002p0 0 pwl(0.0000e+00 {VDD} 2.0000e-09 {VDD} 2.1000e-09 0)
* RWL driver model (EXPERIMENTAL): slew 2 ns, series R 100000 ohm; cell pin = rwls_op0_0000_rl_s2_r100k_dm002p0
vrs_op0_0000_rl_s2_r100k_dm002p0 rwlsrc_op0_0000_rl_s2_r100k_dm002p0 0 pwl(0.0000e+00 {VDD} 2.0000e-09 {VDD} 4.0000e-09 0 3.0000e-08 0 3.2000e-08 {VDD})
rdrv_op0_0000_rl_s2_r100k_dm002p0 rwlsrc_op0_0000_rl_s2_r100k_dm002p0 rwls_op0_0000_rl_s2_r100k_dm002p0 100000
ven_op0_0000_rl_s2_r100k_dm002p0 en_op0_0000_rl_s2_r100k_dm002p0 0 pwl(0.0000e+00 0 1.1000e-08 0 1.1100e-08 {VDD} 3.4000e-08 {VDD} 3.4100e-08 0)
venb_op0_0000_rl_s2_r100k_dm002p0 enb_op0_0000_rl_s2_r100k_dm002p0 0 pwl(0.0000e+00 {VDD} 1.1000e-08 {VDD} 1.1100e-08 0 3.4000e-08 0 3.4100e-08 {VDD})
vww_op0_0000_rl_s2_r100k_dm002p0 wwl_op0_0000_rl_s2_r100k_dm002p0 0 pwl(0.0000e+00 0 1.2000e-08 0 1.2100e-08 {VDD} 3.2000e-08 {VDD} 3.2100e-08 0)
vwc_op0_0000_rl_s2_r100k_dm002p0 wbc_op0_0000_rl_s2_r100k_dm002p0 0 pwl(0.0000e+00 0 1.2000e-08 0 1.2100e-08 {VDD} 3.4000e-08 {VDD} 3.4100e-08 0)
swb_op0_0000_rl_s2_r100k_dm002p0 ref_op0_0000_rl_s2_r100k_dm002p0 wbl_op0_0000_rl_s2_r100k_dm002p0 wbc_op0_0000_rl_s2_r100k_dm002p0 0 swwbl
cwbl_op0_0000_rl_s2_r100k_dm002p0 wbl_op0_0000_rl_s2_r100k_dm002p0 0 {C_WBL}
spa_op0_0000_rl_s2_r100k_dm002p0 prea rbl_op0_0000_rl_s2_r100k_dm002p0 ctl_op0_0000_rl_s2_r100k_dm002p0 0 swpre
spr_op0_0000_rl_s2_r100k_dm002p0 pref ref_op0_0000_rl_s2_r100k_dm002p0 ctl_op0_0000_rl_s2_r100k_dm002p0 0 swpre
crbl_op0_0000_rl_s2_r100k_dm002p0 rbl_op0_0000_rl_s2_r100k_dm002p0 0 {C_RBL}
cref_op0_0000_rl_s2_r100k_dm002p0 ref_op0_0000_rl_s2_r100k_dm002p0 0 {C_RBL}   $ ASSUMPTION: ideal matched dummy load
XMWR_op0_0000_rl_s2_r100k_dm002p0_0 sn_op0_0000_rl_s2_r100k_dm002p0_0 wwl_op0_0000_rl_s2_r100k_dm002p0 wbl_op0_0000_rl_s2_r100k_dm002p0 0 sky130_fd_pr__nfet_01v8 L=0.15 W=0.42 nf=1 ad=0.1218 as=0.1218 pd=1.42 ps=1.42 nrd=0.69047619047619  nrs=0.69047619047619 sa=0 sb=0 sd=0 mult=1 m=1
XMRD_op0_0000_rl_s2_r100k_dm002p0_0 rbl_op0_0000_rl_s2_r100k_dm002p0 sn_op0_0000_rl_s2_r100k_dm002p0_0 rwls_op0_0000_rl_s2_r100k_dm002p0 0 sky130_fd_pr__nfet_01v8 L=0.15 W=0.42 nf=1 ad=0.1218 as=0.1218 pd=1.42 ps=1.42 nrd=0.69047619047619  nrs=0.69047619047619 sa=0 sb=0 sd=0 mult=1 m=1
csn_op0_0000_rl_s2_r100k_dm002p0_0 sn_op0_0000_rl_s2_r100k_dm002p0_0 0 {C_SN}
XMWR_op0_0000_rl_s2_r100k_dm002p0_1 sn_op0_0000_rl_s2_r100k_dm002p0_1 wwl_des wbl_op0_0000_rl_s2_r100k_dm002p0 0 sky130_fd_pr__nfet_01v8 L=0.15 W=0.42 nf=1 ad=0.1218 as=0.1218 pd=1.42 ps=1.42 nrd=0.69047619047619  nrs=0.69047619047619 sa=0 sb=0 sd=0 mult=1 m=1
XMRD_op0_0000_rl_s2_r100k_dm002p0_1 rbl_op0_0000_rl_s2_r100k_dm002p0 sn_op0_0000_rl_s2_r100k_dm002p0_1 rwl_des 0 sky130_fd_pr__nfet_01v8 L=0.15 W=0.42 nf=1 ad=0.1218 as=0.1218 pd=1.42 ps=1.42 nrd=0.69047619047619  nrs=0.69047619047619 sa=0 sb=0 sd=0 mult=1 m=1
csn_op0_0000_rl_s2_r100k_dm002p0_1 sn_op0_0000_rl_s2_r100k_dm002p0_1 0 {C_SN}
XMWR_op0_0000_rl_s2_r100k_dm002p0_2 sn_op0_0000_rl_s2_r100k_dm002p0_2 wwl_des wbl_op0_0000_rl_s2_r100k_dm002p0 0 sky130_fd_pr__nfet_01v8 L=0.15 W=0.42 nf=1 ad=0.1218 as=0.1218 pd=1.42 ps=1.42 nrd=0.69047619047619  nrs=0.69047619047619 sa=0 sb=0 sd=0 mult=1 m=1
XMRD_op0_0000_rl_s2_r100k_dm002p0_2 rbl_op0_0000_rl_s2_r100k_dm002p0 sn_op0_0000_rl_s2_r100k_dm002p0_2 rwl_des 0 sky130_fd_pr__nfet_01v8 L=0.15 W=0.42 nf=1 ad=0.1218 as=0.1218 pd=1.42 ps=1.42 nrd=0.69047619047619  nrs=0.69047619047619 sa=0 sb=0 sd=0 mult=1 m=1
csn_op0_0000_rl_s2_r100k_dm002p0_2 sn_op0_0000_rl_s2_r100k_dm002p0_2 0 {C_SN}
XMWR_op0_0000_rl_s2_r100k_dm002p0_3 sn_op0_0000_rl_s2_r100k_dm002p0_3 wwl_des wbl_op0_0000_rl_s2_r100k_dm002p0 0 sky130_fd_pr__nfet_01v8 L=0.15 W=0.42 nf=1 ad=0.1218 as=0.1218 pd=1.42 ps=1.42 nrd=0.69047619047619  nrs=0.69047619047619 sa=0 sb=0 sd=0 mult=1 m=1
XMRD_op0_0000_rl_s2_r100k_dm002p0_3 rbl_op0_0000_rl_s2_r100k_dm002p0 sn_op0_0000_rl_s2_r100k_dm002p0_3 rwl_des 0 sky130_fd_pr__nfet_01v8 L=0.15 W=0.42 nf=1 ad=0.1218 as=0.1218 pd=1.42 ps=1.42 nrd=0.69047619047619  nrs=0.69047619047619 sa=0 sb=0 sd=0 mult=1 m=1
csn_op0_0000_rl_s2_r100k_dm002p0_3 sn_op0_0000_rl_s2_r100k_dm002p0_3 0 {C_SN}
XMN1_op0_0000_rl_s2_r100k_dm002p0 rbl_op0_0000_rl_s2_r100k_dm002p0 ref_op0_0000_rl_s2_r100k_dm002p0 vn_op0_0000_rl_s2_r100k_dm002p0 0 sky130_fd_pr__nfet_01v8 L=0.15 W=1 nf=1 ad=0.29 as=0.29 pd=2.58 ps=2.58 mult=1 m=1
XMN2_op0_0000_rl_s2_r100k_dm002p0 ref_op0_0000_rl_s2_r100k_dm002p0 rbl_op0_0000_rl_s2_r100k_dm002p0 vn_op0_0000_rl_s2_r100k_dm002p0 0 sky130_fd_pr__nfet_01v8 L=0.15 W=1 nf=1 ad=0.29 as=0.29 pd=2.58 ps=2.58 mult=1 m=1
XMP1_op0_0000_rl_s2_r100k_dm002p0 rbl_op0_0000_rl_s2_r100k_dm002p0 ref_op0_0000_rl_s2_r100k_dm002p0 vp_op0_0000_rl_s2_r100k_dm002p0 vdd sky130_fd_pr__pfet_01v8 L=0.15 W=2 nf=1 ad=0.58 as=0.58 pd=4.58 ps=4.58 mult=1 m=1
XMP2_op0_0000_rl_s2_r100k_dm002p0 ref_op0_0000_rl_s2_r100k_dm002p0 rbl_op0_0000_rl_s2_r100k_dm002p0 vp_op0_0000_rl_s2_r100k_dm002p0 vdd sky130_fd_pr__pfet_01v8 L=0.15 W=2 nf=1 ad=0.58 as=0.58 pd=4.58 ps=4.58 mult=1 m=1
XMNF_op0_0000_rl_s2_r100k_dm002p0 vn_op0_0000_rl_s2_r100k_dm002p0 en_op0_0000_rl_s2_r100k_dm002p0 0 0 sky130_fd_pr__nfet_01v8 L=0.15 W=2 nf=1 ad=0.58 as=0.58 pd=4.58 ps=4.58 mult=1 m=1
XMPH_op0_0000_rl_s2_r100k_dm002p0 vp_op0_0000_rl_s2_r100k_dm002p0 enb_op0_0000_rl_s2_r100k_dm002p0 vdd vdd sky130_fd_pr__pfet_01v8 L=0.15 W=4 nf=1 ad=1.16 as=1.16 pd=8.58 ps=8.58 mult=1 m=1
bd_op0_0000_rl_s2_r100k_dm002p0 d_op0_0000_rl_s2_r100k_dm002p0 0 v=v(rbl_op0_0000_rl_s2_r100k_dm002p0)-v(ref_op0_0000_rl_s2_r100k_dm002p0)

* ---- instance 301: op1_0900_rl_s2_r100k_dp000p0 (variant rl_s2_r100k_dp000p0; probe dec 11.9 ns, release 34 ns, meas 36 ns) ----
vctl_op1_0900_rl_s2_r100k_dp000p0 ctl_op1_0900_rl_s2_r100k_dp000p0 0 pwl(0.0000e+00 {VDD} 2.0000e-09 {VDD} 2.1000e-09 0)
* RWL driver model (EXPERIMENTAL): slew 2 ns, series R 100000 ohm; cell pin = rwls_op1_0900_rl_s2_r100k_dp000p0
vrs_op1_0900_rl_s2_r100k_dp000p0 rwlsrc_op1_0900_rl_s2_r100k_dp000p0 0 pwl(0.0000e+00 {VDD} 2.0000e-09 {VDD} 4.0000e-09 0 3.2000e-08 0 3.4000e-08 {VDD})
rdrv_op1_0900_rl_s2_r100k_dp000p0 rwlsrc_op1_0900_rl_s2_r100k_dp000p0 rwls_op1_0900_rl_s2_r100k_dp000p0 100000
ven_op1_0900_rl_s2_r100k_dp000p0 en_op1_0900_rl_s2_r100k_dp000p0 0 pwl(0.0000e+00 0 1.1000e-08 0 1.1100e-08 {VDD} 3.4000e-08 {VDD} 3.4100e-08 0)
venb_op1_0900_rl_s2_r100k_dp000p0 enb_op1_0900_rl_s2_r100k_dp000p0 0 pwl(0.0000e+00 {VDD} 1.1000e-08 {VDD} 1.1100e-08 0 3.4000e-08 0 3.4100e-08 {VDD})
vww_op1_0900_rl_s2_r100k_dp000p0 wwl_op1_0900_rl_s2_r100k_dp000p0 0 pwl(0.0000e+00 0 1.2000e-08 0 1.2100e-08 {VDD} 3.2000e-08 {VDD} 3.2100e-08 0)
vwc_op1_0900_rl_s2_r100k_dp000p0 wbc_op1_0900_rl_s2_r100k_dp000p0 0 pwl(0.0000e+00 0 1.2000e-08 0 1.2100e-08 {VDD} 3.4000e-08 {VDD} 3.4100e-08 0)
swb_op1_0900_rl_s2_r100k_dp000p0 ref_op1_0900_rl_s2_r100k_dp000p0 wbl_op1_0900_rl_s2_r100k_dp000p0 wbc_op1_0900_rl_s2_r100k_dp000p0 0 swwbl
cwbl_op1_0900_rl_s2_r100k_dp000p0 wbl_op1_0900_rl_s2_r100k_dp000p0 0 {C_WBL}
spa_op1_0900_rl_s2_r100k_dp000p0 prea rbl_op1_0900_rl_s2_r100k_dp000p0 ctl_op1_0900_rl_s2_r100k_dp000p0 0 swpre
spr_op1_0900_rl_s2_r100k_dp000p0 pref ref_op1_0900_rl_s2_r100k_dp000p0 ctl_op1_0900_rl_s2_r100k_dp000p0 0 swpre
crbl_op1_0900_rl_s2_r100k_dp000p0 rbl_op1_0900_rl_s2_r100k_dp000p0 0 {C_RBL}
cref_op1_0900_rl_s2_r100k_dp000p0 ref_op1_0900_rl_s2_r100k_dp000p0 0 {C_RBL}   $ ASSUMPTION: ideal matched dummy load
XMWR_op1_0900_rl_s2_r100k_dp000p0_0 sn_op1_0900_rl_s2_r100k_dp000p0_0 wwl_op1_0900_rl_s2_r100k_dp000p0 wbl_op1_0900_rl_s2_r100k_dp000p0 0 sky130_fd_pr__nfet_01v8 L=0.15 W=0.42 nf=1 ad=0.1218 as=0.1218 pd=1.42 ps=1.42 nrd=0.69047619047619  nrs=0.69047619047619 sa=0 sb=0 sd=0 mult=1 m=1
XMRD_op1_0900_rl_s2_r100k_dp000p0_0 rbl_op1_0900_rl_s2_r100k_dp000p0 sn_op1_0900_rl_s2_r100k_dp000p0_0 rwls_op1_0900_rl_s2_r100k_dp000p0 0 sky130_fd_pr__nfet_01v8 L=0.15 W=0.42 nf=1 ad=0.1218 as=0.1218 pd=1.42 ps=1.42 nrd=0.69047619047619  nrs=0.69047619047619 sa=0 sb=0 sd=0 mult=1 m=1
csn_op1_0900_rl_s2_r100k_dp000p0_0 sn_op1_0900_rl_s2_r100k_dp000p0_0 0 {C_SN}
XMWR_op1_0900_rl_s2_r100k_dp000p0_1 sn_op1_0900_rl_s2_r100k_dp000p0_1 wwl_des wbl_op1_0900_rl_s2_r100k_dp000p0 0 sky130_fd_pr__nfet_01v8 L=0.15 W=0.42 nf=1 ad=0.1218 as=0.1218 pd=1.42 ps=1.42 nrd=0.69047619047619  nrs=0.69047619047619 sa=0 sb=0 sd=0 mult=1 m=1
XMRD_op1_0900_rl_s2_r100k_dp000p0_1 rbl_op1_0900_rl_s2_r100k_dp000p0 sn_op1_0900_rl_s2_r100k_dp000p0_1 rwl_des 0 sky130_fd_pr__nfet_01v8 L=0.15 W=0.42 nf=1 ad=0.1218 as=0.1218 pd=1.42 ps=1.42 nrd=0.69047619047619  nrs=0.69047619047619 sa=0 sb=0 sd=0 mult=1 m=1
csn_op1_0900_rl_s2_r100k_dp000p0_1 sn_op1_0900_rl_s2_r100k_dp000p0_1 0 {C_SN}
XMWR_op1_0900_rl_s2_r100k_dp000p0_2 sn_op1_0900_rl_s2_r100k_dp000p0_2 wwl_des wbl_op1_0900_rl_s2_r100k_dp000p0 0 sky130_fd_pr__nfet_01v8 L=0.15 W=0.42 nf=1 ad=0.1218 as=0.1218 pd=1.42 ps=1.42 nrd=0.69047619047619  nrs=0.69047619047619 sa=0 sb=0 sd=0 mult=1 m=1
XMRD_op1_0900_rl_s2_r100k_dp000p0_2 rbl_op1_0900_rl_s2_r100k_dp000p0 sn_op1_0900_rl_s2_r100k_dp000p0_2 rwl_des 0 sky130_fd_pr__nfet_01v8 L=0.15 W=0.42 nf=1 ad=0.1218 as=0.1218 pd=1.42 ps=1.42 nrd=0.69047619047619  nrs=0.69047619047619 sa=0 sb=0 sd=0 mult=1 m=1
csn_op1_0900_rl_s2_r100k_dp000p0_2 sn_op1_0900_rl_s2_r100k_dp000p0_2 0 {C_SN}
XMWR_op1_0900_rl_s2_r100k_dp000p0_3 sn_op1_0900_rl_s2_r100k_dp000p0_3 wwl_des wbl_op1_0900_rl_s2_r100k_dp000p0 0 sky130_fd_pr__nfet_01v8 L=0.15 W=0.42 nf=1 ad=0.1218 as=0.1218 pd=1.42 ps=1.42 nrd=0.69047619047619  nrs=0.69047619047619 sa=0 sb=0 sd=0 mult=1 m=1
XMRD_op1_0900_rl_s2_r100k_dp000p0_3 rbl_op1_0900_rl_s2_r100k_dp000p0 sn_op1_0900_rl_s2_r100k_dp000p0_3 rwl_des 0 sky130_fd_pr__nfet_01v8 L=0.15 W=0.42 nf=1 ad=0.1218 as=0.1218 pd=1.42 ps=1.42 nrd=0.69047619047619  nrs=0.69047619047619 sa=0 sb=0 sd=0 mult=1 m=1
csn_op1_0900_rl_s2_r100k_dp000p0_3 sn_op1_0900_rl_s2_r100k_dp000p0_3 0 {C_SN}
XMN1_op1_0900_rl_s2_r100k_dp000p0 rbl_op1_0900_rl_s2_r100k_dp000p0 ref_op1_0900_rl_s2_r100k_dp000p0 vn_op1_0900_rl_s2_r100k_dp000p0 0 sky130_fd_pr__nfet_01v8 L=0.15 W=1 nf=1 ad=0.29 as=0.29 pd=2.58 ps=2.58 mult=1 m=1
XMN2_op1_0900_rl_s2_r100k_dp000p0 ref_op1_0900_rl_s2_r100k_dp000p0 rbl_op1_0900_rl_s2_r100k_dp000p0 vn_op1_0900_rl_s2_r100k_dp000p0 0 sky130_fd_pr__nfet_01v8 L=0.15 W=1 nf=1 ad=0.29 as=0.29 pd=2.58 ps=2.58 mult=1 m=1
XMP1_op1_0900_rl_s2_r100k_dp000p0 rbl_op1_0900_rl_s2_r100k_dp000p0 ref_op1_0900_rl_s2_r100k_dp000p0 vp_op1_0900_rl_s2_r100k_dp000p0 vdd sky130_fd_pr__pfet_01v8 L=0.15 W=2 nf=1 ad=0.58 as=0.58 pd=4.58 ps=4.58 mult=1 m=1
XMP2_op1_0900_rl_s2_r100k_dp000p0 ref_op1_0900_rl_s2_r100k_dp000p0 rbl_op1_0900_rl_s2_r100k_dp000p0 vp_op1_0900_rl_s2_r100k_dp000p0 vdd sky130_fd_pr__pfet_01v8 L=0.15 W=2 nf=1 ad=0.58 as=0.58 pd=4.58 ps=4.58 mult=1 m=1
XMNF_op1_0900_rl_s2_r100k_dp000p0 vn_op1_0900_rl_s2_r100k_dp000p0 en_op1_0900_rl_s2_r100k_dp000p0 0 0 sky130_fd_pr__nfet_01v8 L=0.15 W=2 nf=1 ad=0.58 as=0.58 pd=4.58 ps=4.58 mult=1 m=1
XMPH_op1_0900_rl_s2_r100k_dp000p0 vp_op1_0900_rl_s2_r100k_dp000p0 enb_op1_0900_rl_s2_r100k_dp000p0 vdd vdd sky130_fd_pr__pfet_01v8 L=0.15 W=4 nf=1 ad=1.16 as=1.16 pd=8.58 ps=8.58 mult=1 m=1
bd_op1_0900_rl_s2_r100k_dp000p0 d_op1_0900_rl_s2_r100k_dp000p0 0 v=v(rbl_op1_0900_rl_s2_r100k_dp000p0)-v(ref_op1_0900_rl_s2_r100k_dp000p0)

* ---- instance 302: op1_1000_rl_s2_r100k_dp000p0 (variant rl_s2_r100k_dp000p0; probe dec 11.9 ns, release 34 ns, meas 36 ns) ----
vctl_op1_1000_rl_s2_r100k_dp000p0 ctl_op1_1000_rl_s2_r100k_dp000p0 0 pwl(0.0000e+00 {VDD} 2.0000e-09 {VDD} 2.1000e-09 0)
* RWL driver model (EXPERIMENTAL): slew 2 ns, series R 100000 ohm; cell pin = rwls_op1_1000_rl_s2_r100k_dp000p0
vrs_op1_1000_rl_s2_r100k_dp000p0 rwlsrc_op1_1000_rl_s2_r100k_dp000p0 0 pwl(0.0000e+00 {VDD} 2.0000e-09 {VDD} 4.0000e-09 0 3.2000e-08 0 3.4000e-08 {VDD})
rdrv_op1_1000_rl_s2_r100k_dp000p0 rwlsrc_op1_1000_rl_s2_r100k_dp000p0 rwls_op1_1000_rl_s2_r100k_dp000p0 100000
ven_op1_1000_rl_s2_r100k_dp000p0 en_op1_1000_rl_s2_r100k_dp000p0 0 pwl(0.0000e+00 0 1.1000e-08 0 1.1100e-08 {VDD} 3.4000e-08 {VDD} 3.4100e-08 0)
venb_op1_1000_rl_s2_r100k_dp000p0 enb_op1_1000_rl_s2_r100k_dp000p0 0 pwl(0.0000e+00 {VDD} 1.1000e-08 {VDD} 1.1100e-08 0 3.4000e-08 0 3.4100e-08 {VDD})
vww_op1_1000_rl_s2_r100k_dp000p0 wwl_op1_1000_rl_s2_r100k_dp000p0 0 pwl(0.0000e+00 0 1.2000e-08 0 1.2100e-08 {VDD} 3.2000e-08 {VDD} 3.2100e-08 0)
vwc_op1_1000_rl_s2_r100k_dp000p0 wbc_op1_1000_rl_s2_r100k_dp000p0 0 pwl(0.0000e+00 0 1.2000e-08 0 1.2100e-08 {VDD} 3.4000e-08 {VDD} 3.4100e-08 0)
swb_op1_1000_rl_s2_r100k_dp000p0 ref_op1_1000_rl_s2_r100k_dp000p0 wbl_op1_1000_rl_s2_r100k_dp000p0 wbc_op1_1000_rl_s2_r100k_dp000p0 0 swwbl
cwbl_op1_1000_rl_s2_r100k_dp000p0 wbl_op1_1000_rl_s2_r100k_dp000p0 0 {C_WBL}
spa_op1_1000_rl_s2_r100k_dp000p0 prea rbl_op1_1000_rl_s2_r100k_dp000p0 ctl_op1_1000_rl_s2_r100k_dp000p0 0 swpre
spr_op1_1000_rl_s2_r100k_dp000p0 pref ref_op1_1000_rl_s2_r100k_dp000p0 ctl_op1_1000_rl_s2_r100k_dp000p0 0 swpre
crbl_op1_1000_rl_s2_r100k_dp000p0 rbl_op1_1000_rl_s2_r100k_dp000p0 0 {C_RBL}
cref_op1_1000_rl_s2_r100k_dp000p0 ref_op1_1000_rl_s2_r100k_dp000p0 0 {C_RBL}   $ ASSUMPTION: ideal matched dummy load
XMWR_op1_1000_rl_s2_r100k_dp000p0_0 sn_op1_1000_rl_s2_r100k_dp000p0_0 wwl_op1_1000_rl_s2_r100k_dp000p0 wbl_op1_1000_rl_s2_r100k_dp000p0 0 sky130_fd_pr__nfet_01v8 L=0.15 W=0.42 nf=1 ad=0.1218 as=0.1218 pd=1.42 ps=1.42 nrd=0.69047619047619  nrs=0.69047619047619 sa=0 sb=0 sd=0 mult=1 m=1
XMRD_op1_1000_rl_s2_r100k_dp000p0_0 rbl_op1_1000_rl_s2_r100k_dp000p0 sn_op1_1000_rl_s2_r100k_dp000p0_0 rwls_op1_1000_rl_s2_r100k_dp000p0 0 sky130_fd_pr__nfet_01v8 L=0.15 W=0.42 nf=1 ad=0.1218 as=0.1218 pd=1.42 ps=1.42 nrd=0.69047619047619  nrs=0.69047619047619 sa=0 sb=0 sd=0 mult=1 m=1
csn_op1_1000_rl_s2_r100k_dp000p0_0 sn_op1_1000_rl_s2_r100k_dp000p0_0 0 {C_SN}
XMWR_op1_1000_rl_s2_r100k_dp000p0_1 sn_op1_1000_rl_s2_r100k_dp000p0_1 wwl_des wbl_op1_1000_rl_s2_r100k_dp000p0 0 sky130_fd_pr__nfet_01v8 L=0.15 W=0.42 nf=1 ad=0.1218 as=0.1218 pd=1.42 ps=1.42 nrd=0.69047619047619  nrs=0.69047619047619 sa=0 sb=0 sd=0 mult=1 m=1
XMRD_op1_1000_rl_s2_r100k_dp000p0_1 rbl_op1_1000_rl_s2_r100k_dp000p0 sn_op1_1000_rl_s2_r100k_dp000p0_1 rwl_des 0 sky130_fd_pr__nfet_01v8 L=0.15 W=0.42 nf=1 ad=0.1218 as=0.1218 pd=1.42 ps=1.42 nrd=0.69047619047619  nrs=0.69047619047619 sa=0 sb=0 sd=0 mult=1 m=1
csn_op1_1000_rl_s2_r100k_dp000p0_1 sn_op1_1000_rl_s2_r100k_dp000p0_1 0 {C_SN}
XMWR_op1_1000_rl_s2_r100k_dp000p0_2 sn_op1_1000_rl_s2_r100k_dp000p0_2 wwl_des wbl_op1_1000_rl_s2_r100k_dp000p0 0 sky130_fd_pr__nfet_01v8 L=0.15 W=0.42 nf=1 ad=0.1218 as=0.1218 pd=1.42 ps=1.42 nrd=0.69047619047619  nrs=0.69047619047619 sa=0 sb=0 sd=0 mult=1 m=1
XMRD_op1_1000_rl_s2_r100k_dp000p0_2 rbl_op1_1000_rl_s2_r100k_dp000p0 sn_op1_1000_rl_s2_r100k_dp000p0_2 rwl_des 0 sky130_fd_pr__nfet_01v8 L=0.15 W=0.42 nf=1 ad=0.1218 as=0.1218 pd=1.42 ps=1.42 nrd=0.69047619047619  nrs=0.69047619047619 sa=0 sb=0 sd=0 mult=1 m=1
csn_op1_1000_rl_s2_r100k_dp000p0_2 sn_op1_1000_rl_s2_r100k_dp000p0_2 0 {C_SN}
XMWR_op1_1000_rl_s2_r100k_dp000p0_3 sn_op1_1000_rl_s2_r100k_dp000p0_3 wwl_des wbl_op1_1000_rl_s2_r100k_dp000p0 0 sky130_fd_pr__nfet_01v8 L=0.15 W=0.42 nf=1 ad=0.1218 as=0.1218 pd=1.42 ps=1.42 nrd=0.69047619047619  nrs=0.69047619047619 sa=0 sb=0 sd=0 mult=1 m=1
XMRD_op1_1000_rl_s2_r100k_dp000p0_3 rbl_op1_1000_rl_s2_r100k_dp000p0 sn_op1_1000_rl_s2_r100k_dp000p0_3 rwl_des 0 sky130_fd_pr__nfet_01v8 L=0.15 W=0.42 nf=1 ad=0.1218 as=0.1218 pd=1.42 ps=1.42 nrd=0.69047619047619  nrs=0.69047619047619 sa=0 sb=0 sd=0 mult=1 m=1
csn_op1_1000_rl_s2_r100k_dp000p0_3 sn_op1_1000_rl_s2_r100k_dp000p0_3 0 {C_SN}
XMN1_op1_1000_rl_s2_r100k_dp000p0 rbl_op1_1000_rl_s2_r100k_dp000p0 ref_op1_1000_rl_s2_r100k_dp000p0 vn_op1_1000_rl_s2_r100k_dp000p0 0 sky130_fd_pr__nfet_01v8 L=0.15 W=1 nf=1 ad=0.29 as=0.29 pd=2.58 ps=2.58 mult=1 m=1
XMN2_op1_1000_rl_s2_r100k_dp000p0 ref_op1_1000_rl_s2_r100k_dp000p0 rbl_op1_1000_rl_s2_r100k_dp000p0 vn_op1_1000_rl_s2_r100k_dp000p0 0 sky130_fd_pr__nfet_01v8 L=0.15 W=1 nf=1 ad=0.29 as=0.29 pd=2.58 ps=2.58 mult=1 m=1
XMP1_op1_1000_rl_s2_r100k_dp000p0 rbl_op1_1000_rl_s2_r100k_dp000p0 ref_op1_1000_rl_s2_r100k_dp000p0 vp_op1_1000_rl_s2_r100k_dp000p0 vdd sky130_fd_pr__pfet_01v8 L=0.15 W=2 nf=1 ad=0.58 as=0.58 pd=4.58 ps=4.58 mult=1 m=1
XMP2_op1_1000_rl_s2_r100k_dp000p0 ref_op1_1000_rl_s2_r100k_dp000p0 rbl_op1_1000_rl_s2_r100k_dp000p0 vp_op1_1000_rl_s2_r100k_dp000p0 vdd sky130_fd_pr__pfet_01v8 L=0.15 W=2 nf=1 ad=0.58 as=0.58 pd=4.58 ps=4.58 mult=1 m=1
XMNF_op1_1000_rl_s2_r100k_dp000p0 vn_op1_1000_rl_s2_r100k_dp000p0 en_op1_1000_rl_s2_r100k_dp000p0 0 0 sky130_fd_pr__nfet_01v8 L=0.15 W=2 nf=1 ad=0.58 as=0.58 pd=4.58 ps=4.58 mult=1 m=1
XMPH_op1_1000_rl_s2_r100k_dp000p0 vp_op1_1000_rl_s2_r100k_dp000p0 enb_op1_1000_rl_s2_r100k_dp000p0 vdd vdd sky130_fd_pr__pfet_01v8 L=0.15 W=4 nf=1 ad=1.16 as=1.16 pd=8.58 ps=8.58 mult=1 m=1
bd_op1_1000_rl_s2_r100k_dp000p0 d_op1_1000_rl_s2_r100k_dp000p0 0 v=v(rbl_op1_1000_rl_s2_r100k_dp000p0)-v(ref_op1_1000_rl_s2_r100k_dp000p0)

* ---- instance 303: op0_n100_rl_s2_r100k_dp000p0 (variant rl_s2_r100k_dp000p0; probe dec 11.9 ns, release 34 ns, meas 36 ns) ----
vctl_op0_n100_rl_s2_r100k_dp000p0 ctl_op0_n100_rl_s2_r100k_dp000p0 0 pwl(0.0000e+00 {VDD} 2.0000e-09 {VDD} 2.1000e-09 0)
* RWL driver model (EXPERIMENTAL): slew 2 ns, series R 100000 ohm; cell pin = rwls_op0_n100_rl_s2_r100k_dp000p0
vrs_op0_n100_rl_s2_r100k_dp000p0 rwlsrc_op0_n100_rl_s2_r100k_dp000p0 0 pwl(0.0000e+00 {VDD} 2.0000e-09 {VDD} 4.0000e-09 0 3.2000e-08 0 3.4000e-08 {VDD})
rdrv_op0_n100_rl_s2_r100k_dp000p0 rwlsrc_op0_n100_rl_s2_r100k_dp000p0 rwls_op0_n100_rl_s2_r100k_dp000p0 100000
ven_op0_n100_rl_s2_r100k_dp000p0 en_op0_n100_rl_s2_r100k_dp000p0 0 pwl(0.0000e+00 0 1.1000e-08 0 1.1100e-08 {VDD} 3.4000e-08 {VDD} 3.4100e-08 0)
venb_op0_n100_rl_s2_r100k_dp000p0 enb_op0_n100_rl_s2_r100k_dp000p0 0 pwl(0.0000e+00 {VDD} 1.1000e-08 {VDD} 1.1100e-08 0 3.4000e-08 0 3.4100e-08 {VDD})
vww_op0_n100_rl_s2_r100k_dp000p0 wwl_op0_n100_rl_s2_r100k_dp000p0 0 pwl(0.0000e+00 0 1.2000e-08 0 1.2100e-08 {VDD} 3.2000e-08 {VDD} 3.2100e-08 0)
vwc_op0_n100_rl_s2_r100k_dp000p0 wbc_op0_n100_rl_s2_r100k_dp000p0 0 pwl(0.0000e+00 0 1.2000e-08 0 1.2100e-08 {VDD} 3.4000e-08 {VDD} 3.4100e-08 0)
swb_op0_n100_rl_s2_r100k_dp000p0 ref_op0_n100_rl_s2_r100k_dp000p0 wbl_op0_n100_rl_s2_r100k_dp000p0 wbc_op0_n100_rl_s2_r100k_dp000p0 0 swwbl
cwbl_op0_n100_rl_s2_r100k_dp000p0 wbl_op0_n100_rl_s2_r100k_dp000p0 0 {C_WBL}
spa_op0_n100_rl_s2_r100k_dp000p0 prea rbl_op0_n100_rl_s2_r100k_dp000p0 ctl_op0_n100_rl_s2_r100k_dp000p0 0 swpre
spr_op0_n100_rl_s2_r100k_dp000p0 pref ref_op0_n100_rl_s2_r100k_dp000p0 ctl_op0_n100_rl_s2_r100k_dp000p0 0 swpre
crbl_op0_n100_rl_s2_r100k_dp000p0 rbl_op0_n100_rl_s2_r100k_dp000p0 0 {C_RBL}
cref_op0_n100_rl_s2_r100k_dp000p0 ref_op0_n100_rl_s2_r100k_dp000p0 0 {C_RBL}   $ ASSUMPTION: ideal matched dummy load
XMWR_op0_n100_rl_s2_r100k_dp000p0_0 sn_op0_n100_rl_s2_r100k_dp000p0_0 wwl_op0_n100_rl_s2_r100k_dp000p0 wbl_op0_n100_rl_s2_r100k_dp000p0 0 sky130_fd_pr__nfet_01v8 L=0.15 W=0.42 nf=1 ad=0.1218 as=0.1218 pd=1.42 ps=1.42 nrd=0.69047619047619  nrs=0.69047619047619 sa=0 sb=0 sd=0 mult=1 m=1
XMRD_op0_n100_rl_s2_r100k_dp000p0_0 rbl_op0_n100_rl_s2_r100k_dp000p0 sn_op0_n100_rl_s2_r100k_dp000p0_0 rwls_op0_n100_rl_s2_r100k_dp000p0 0 sky130_fd_pr__nfet_01v8 L=0.15 W=0.42 nf=1 ad=0.1218 as=0.1218 pd=1.42 ps=1.42 nrd=0.69047619047619  nrs=0.69047619047619 sa=0 sb=0 sd=0 mult=1 m=1
csn_op0_n100_rl_s2_r100k_dp000p0_0 sn_op0_n100_rl_s2_r100k_dp000p0_0 0 {C_SN}
XMWR_op0_n100_rl_s2_r100k_dp000p0_1 sn_op0_n100_rl_s2_r100k_dp000p0_1 wwl_des wbl_op0_n100_rl_s2_r100k_dp000p0 0 sky130_fd_pr__nfet_01v8 L=0.15 W=0.42 nf=1 ad=0.1218 as=0.1218 pd=1.42 ps=1.42 nrd=0.69047619047619  nrs=0.69047619047619 sa=0 sb=0 sd=0 mult=1 m=1
XMRD_op0_n100_rl_s2_r100k_dp000p0_1 rbl_op0_n100_rl_s2_r100k_dp000p0 sn_op0_n100_rl_s2_r100k_dp000p0_1 rwl_des 0 sky130_fd_pr__nfet_01v8 L=0.15 W=0.42 nf=1 ad=0.1218 as=0.1218 pd=1.42 ps=1.42 nrd=0.69047619047619  nrs=0.69047619047619 sa=0 sb=0 sd=0 mult=1 m=1
csn_op0_n100_rl_s2_r100k_dp000p0_1 sn_op0_n100_rl_s2_r100k_dp000p0_1 0 {C_SN}
XMWR_op0_n100_rl_s2_r100k_dp000p0_2 sn_op0_n100_rl_s2_r100k_dp000p0_2 wwl_des wbl_op0_n100_rl_s2_r100k_dp000p0 0 sky130_fd_pr__nfet_01v8 L=0.15 W=0.42 nf=1 ad=0.1218 as=0.1218 pd=1.42 ps=1.42 nrd=0.69047619047619  nrs=0.69047619047619 sa=0 sb=0 sd=0 mult=1 m=1
XMRD_op0_n100_rl_s2_r100k_dp000p0_2 rbl_op0_n100_rl_s2_r100k_dp000p0 sn_op0_n100_rl_s2_r100k_dp000p0_2 rwl_des 0 sky130_fd_pr__nfet_01v8 L=0.15 W=0.42 nf=1 ad=0.1218 as=0.1218 pd=1.42 ps=1.42 nrd=0.69047619047619  nrs=0.69047619047619 sa=0 sb=0 sd=0 mult=1 m=1
csn_op0_n100_rl_s2_r100k_dp000p0_2 sn_op0_n100_rl_s2_r100k_dp000p0_2 0 {C_SN}
XMWR_op0_n100_rl_s2_r100k_dp000p0_3 sn_op0_n100_rl_s2_r100k_dp000p0_3 wwl_des wbl_op0_n100_rl_s2_r100k_dp000p0 0 sky130_fd_pr__nfet_01v8 L=0.15 W=0.42 nf=1 ad=0.1218 as=0.1218 pd=1.42 ps=1.42 nrd=0.69047619047619  nrs=0.69047619047619 sa=0 sb=0 sd=0 mult=1 m=1
XMRD_op0_n100_rl_s2_r100k_dp000p0_3 rbl_op0_n100_rl_s2_r100k_dp000p0 sn_op0_n100_rl_s2_r100k_dp000p0_3 rwl_des 0 sky130_fd_pr__nfet_01v8 L=0.15 W=0.42 nf=1 ad=0.1218 as=0.1218 pd=1.42 ps=1.42 nrd=0.69047619047619  nrs=0.69047619047619 sa=0 sb=0 sd=0 mult=1 m=1
csn_op0_n100_rl_s2_r100k_dp000p0_3 sn_op0_n100_rl_s2_r100k_dp000p0_3 0 {C_SN}
XMN1_op0_n100_rl_s2_r100k_dp000p0 rbl_op0_n100_rl_s2_r100k_dp000p0 ref_op0_n100_rl_s2_r100k_dp000p0 vn_op0_n100_rl_s2_r100k_dp000p0 0 sky130_fd_pr__nfet_01v8 L=0.15 W=1 nf=1 ad=0.29 as=0.29 pd=2.58 ps=2.58 mult=1 m=1
XMN2_op0_n100_rl_s2_r100k_dp000p0 ref_op0_n100_rl_s2_r100k_dp000p0 rbl_op0_n100_rl_s2_r100k_dp000p0 vn_op0_n100_rl_s2_r100k_dp000p0 0 sky130_fd_pr__nfet_01v8 L=0.15 W=1 nf=1 ad=0.29 as=0.29 pd=2.58 ps=2.58 mult=1 m=1
XMP1_op0_n100_rl_s2_r100k_dp000p0 rbl_op0_n100_rl_s2_r100k_dp000p0 ref_op0_n100_rl_s2_r100k_dp000p0 vp_op0_n100_rl_s2_r100k_dp000p0 vdd sky130_fd_pr__pfet_01v8 L=0.15 W=2 nf=1 ad=0.58 as=0.58 pd=4.58 ps=4.58 mult=1 m=1
XMP2_op0_n100_rl_s2_r100k_dp000p0 ref_op0_n100_rl_s2_r100k_dp000p0 rbl_op0_n100_rl_s2_r100k_dp000p0 vp_op0_n100_rl_s2_r100k_dp000p0 vdd sky130_fd_pr__pfet_01v8 L=0.15 W=2 nf=1 ad=0.58 as=0.58 pd=4.58 ps=4.58 mult=1 m=1
XMNF_op0_n100_rl_s2_r100k_dp000p0 vn_op0_n100_rl_s2_r100k_dp000p0 en_op0_n100_rl_s2_r100k_dp000p0 0 0 sky130_fd_pr__nfet_01v8 L=0.15 W=2 nf=1 ad=0.58 as=0.58 pd=4.58 ps=4.58 mult=1 m=1
XMPH_op0_n100_rl_s2_r100k_dp000p0 vp_op0_n100_rl_s2_r100k_dp000p0 enb_op0_n100_rl_s2_r100k_dp000p0 vdd vdd sky130_fd_pr__pfet_01v8 L=0.15 W=4 nf=1 ad=1.16 as=1.16 pd=8.58 ps=8.58 mult=1 m=1
bd_op0_n100_rl_s2_r100k_dp000p0 d_op0_n100_rl_s2_r100k_dp000p0 0 v=v(rbl_op0_n100_rl_s2_r100k_dp000p0)-v(ref_op0_n100_rl_s2_r100k_dp000p0)

* ---- instance 304: op0_0000_rl_s2_r100k_dp000p0 (variant rl_s2_r100k_dp000p0; probe dec 11.9 ns, release 34 ns, meas 36 ns) ----
vctl_op0_0000_rl_s2_r100k_dp000p0 ctl_op0_0000_rl_s2_r100k_dp000p0 0 pwl(0.0000e+00 {VDD} 2.0000e-09 {VDD} 2.1000e-09 0)
* RWL driver model (EXPERIMENTAL): slew 2 ns, series R 100000 ohm; cell pin = rwls_op0_0000_rl_s2_r100k_dp000p0
vrs_op0_0000_rl_s2_r100k_dp000p0 rwlsrc_op0_0000_rl_s2_r100k_dp000p0 0 pwl(0.0000e+00 {VDD} 2.0000e-09 {VDD} 4.0000e-09 0 3.2000e-08 0 3.4000e-08 {VDD})
rdrv_op0_0000_rl_s2_r100k_dp000p0 rwlsrc_op0_0000_rl_s2_r100k_dp000p0 rwls_op0_0000_rl_s2_r100k_dp000p0 100000
ven_op0_0000_rl_s2_r100k_dp000p0 en_op0_0000_rl_s2_r100k_dp000p0 0 pwl(0.0000e+00 0 1.1000e-08 0 1.1100e-08 {VDD} 3.4000e-08 {VDD} 3.4100e-08 0)
venb_op0_0000_rl_s2_r100k_dp000p0 enb_op0_0000_rl_s2_r100k_dp000p0 0 pwl(0.0000e+00 {VDD} 1.1000e-08 {VDD} 1.1100e-08 0 3.4000e-08 0 3.4100e-08 {VDD})
vww_op0_0000_rl_s2_r100k_dp000p0 wwl_op0_0000_rl_s2_r100k_dp000p0 0 pwl(0.0000e+00 0 1.2000e-08 0 1.2100e-08 {VDD} 3.2000e-08 {VDD} 3.2100e-08 0)
vwc_op0_0000_rl_s2_r100k_dp000p0 wbc_op0_0000_rl_s2_r100k_dp000p0 0 pwl(0.0000e+00 0 1.2000e-08 0 1.2100e-08 {VDD} 3.4000e-08 {VDD} 3.4100e-08 0)
swb_op0_0000_rl_s2_r100k_dp000p0 ref_op0_0000_rl_s2_r100k_dp000p0 wbl_op0_0000_rl_s2_r100k_dp000p0 wbc_op0_0000_rl_s2_r100k_dp000p0 0 swwbl
cwbl_op0_0000_rl_s2_r100k_dp000p0 wbl_op0_0000_rl_s2_r100k_dp000p0 0 {C_WBL}
spa_op0_0000_rl_s2_r100k_dp000p0 prea rbl_op0_0000_rl_s2_r100k_dp000p0 ctl_op0_0000_rl_s2_r100k_dp000p0 0 swpre
spr_op0_0000_rl_s2_r100k_dp000p0 pref ref_op0_0000_rl_s2_r100k_dp000p0 ctl_op0_0000_rl_s2_r100k_dp000p0 0 swpre
crbl_op0_0000_rl_s2_r100k_dp000p0 rbl_op0_0000_rl_s2_r100k_dp000p0 0 {C_RBL}
cref_op0_0000_rl_s2_r100k_dp000p0 ref_op0_0000_rl_s2_r100k_dp000p0 0 {C_RBL}   $ ASSUMPTION: ideal matched dummy load
XMWR_op0_0000_rl_s2_r100k_dp000p0_0 sn_op0_0000_rl_s2_r100k_dp000p0_0 wwl_op0_0000_rl_s2_r100k_dp000p0 wbl_op0_0000_rl_s2_r100k_dp000p0 0 sky130_fd_pr__nfet_01v8 L=0.15 W=0.42 nf=1 ad=0.1218 as=0.1218 pd=1.42 ps=1.42 nrd=0.69047619047619  nrs=0.69047619047619 sa=0 sb=0 sd=0 mult=1 m=1
XMRD_op0_0000_rl_s2_r100k_dp000p0_0 rbl_op0_0000_rl_s2_r100k_dp000p0 sn_op0_0000_rl_s2_r100k_dp000p0_0 rwls_op0_0000_rl_s2_r100k_dp000p0 0 sky130_fd_pr__nfet_01v8 L=0.15 W=0.42 nf=1 ad=0.1218 as=0.1218 pd=1.42 ps=1.42 nrd=0.69047619047619  nrs=0.69047619047619 sa=0 sb=0 sd=0 mult=1 m=1
csn_op0_0000_rl_s2_r100k_dp000p0_0 sn_op0_0000_rl_s2_r100k_dp000p0_0 0 {C_SN}
XMWR_op0_0000_rl_s2_r100k_dp000p0_1 sn_op0_0000_rl_s2_r100k_dp000p0_1 wwl_des wbl_op0_0000_rl_s2_r100k_dp000p0 0 sky130_fd_pr__nfet_01v8 L=0.15 W=0.42 nf=1 ad=0.1218 as=0.1218 pd=1.42 ps=1.42 nrd=0.69047619047619  nrs=0.69047619047619 sa=0 sb=0 sd=0 mult=1 m=1
XMRD_op0_0000_rl_s2_r100k_dp000p0_1 rbl_op0_0000_rl_s2_r100k_dp000p0 sn_op0_0000_rl_s2_r100k_dp000p0_1 rwl_des 0 sky130_fd_pr__nfet_01v8 L=0.15 W=0.42 nf=1 ad=0.1218 as=0.1218 pd=1.42 ps=1.42 nrd=0.69047619047619  nrs=0.69047619047619 sa=0 sb=0 sd=0 mult=1 m=1
csn_op0_0000_rl_s2_r100k_dp000p0_1 sn_op0_0000_rl_s2_r100k_dp000p0_1 0 {C_SN}
XMWR_op0_0000_rl_s2_r100k_dp000p0_2 sn_op0_0000_rl_s2_r100k_dp000p0_2 wwl_des wbl_op0_0000_rl_s2_r100k_dp000p0 0 sky130_fd_pr__nfet_01v8 L=0.15 W=0.42 nf=1 ad=0.1218 as=0.1218 pd=1.42 ps=1.42 nrd=0.69047619047619  nrs=0.69047619047619 sa=0 sb=0 sd=0 mult=1 m=1
XMRD_op0_0000_rl_s2_r100k_dp000p0_2 rbl_op0_0000_rl_s2_r100k_dp000p0 sn_op0_0000_rl_s2_r100k_dp000p0_2 rwl_des 0 sky130_fd_pr__nfet_01v8 L=0.15 W=0.42 nf=1 ad=0.1218 as=0.1218 pd=1.42 ps=1.42 nrd=0.69047619047619  nrs=0.69047619047619 sa=0 sb=0 sd=0 mult=1 m=1
csn_op0_0000_rl_s2_r100k_dp000p0_2 sn_op0_0000_rl_s2_r100k_dp000p0_2 0 {C_SN}
XMWR_op0_0000_rl_s2_r100k_dp000p0_3 sn_op0_0000_rl_s2_r100k_dp000p0_3 wwl_des wbl_op0_0000_rl_s2_r100k_dp000p0 0 sky130_fd_pr__nfet_01v8 L=0.15 W=0.42 nf=1 ad=0.1218 as=0.1218 pd=1.42 ps=1.42 nrd=0.69047619047619  nrs=0.69047619047619 sa=0 sb=0 sd=0 mult=1 m=1
XMRD_op0_0000_rl_s2_r100k_dp000p0_3 rbl_op0_0000_rl_s2_r100k_dp000p0 sn_op0_0000_rl_s2_r100k_dp000p0_3 rwl_des 0 sky130_fd_pr__nfet_01v8 L=0.15 W=0.42 nf=1 ad=0.1218 as=0.1218 pd=1.42 ps=1.42 nrd=0.69047619047619  nrs=0.69047619047619 sa=0 sb=0 sd=0 mult=1 m=1
csn_op0_0000_rl_s2_r100k_dp000p0_3 sn_op0_0000_rl_s2_r100k_dp000p0_3 0 {C_SN}
XMN1_op0_0000_rl_s2_r100k_dp000p0 rbl_op0_0000_rl_s2_r100k_dp000p0 ref_op0_0000_rl_s2_r100k_dp000p0 vn_op0_0000_rl_s2_r100k_dp000p0 0 sky130_fd_pr__nfet_01v8 L=0.15 W=1 nf=1 ad=0.29 as=0.29 pd=2.58 ps=2.58 mult=1 m=1
XMN2_op0_0000_rl_s2_r100k_dp000p0 ref_op0_0000_rl_s2_r100k_dp000p0 rbl_op0_0000_rl_s2_r100k_dp000p0 vn_op0_0000_rl_s2_r100k_dp000p0 0 sky130_fd_pr__nfet_01v8 L=0.15 W=1 nf=1 ad=0.29 as=0.29 pd=2.58 ps=2.58 mult=1 m=1
XMP1_op0_0000_rl_s2_r100k_dp000p0 rbl_op0_0000_rl_s2_r100k_dp000p0 ref_op0_0000_rl_s2_r100k_dp000p0 vp_op0_0000_rl_s2_r100k_dp000p0 vdd sky130_fd_pr__pfet_01v8 L=0.15 W=2 nf=1 ad=0.58 as=0.58 pd=4.58 ps=4.58 mult=1 m=1
XMP2_op0_0000_rl_s2_r100k_dp000p0 ref_op0_0000_rl_s2_r100k_dp000p0 rbl_op0_0000_rl_s2_r100k_dp000p0 vp_op0_0000_rl_s2_r100k_dp000p0 vdd sky130_fd_pr__pfet_01v8 L=0.15 W=2 nf=1 ad=0.58 as=0.58 pd=4.58 ps=4.58 mult=1 m=1
XMNF_op0_0000_rl_s2_r100k_dp000p0 vn_op0_0000_rl_s2_r100k_dp000p0 en_op0_0000_rl_s2_r100k_dp000p0 0 0 sky130_fd_pr__nfet_01v8 L=0.15 W=2 nf=1 ad=0.58 as=0.58 pd=4.58 ps=4.58 mult=1 m=1
XMPH_op0_0000_rl_s2_r100k_dp000p0 vp_op0_0000_rl_s2_r100k_dp000p0 enb_op0_0000_rl_s2_r100k_dp000p0 vdd vdd sky130_fd_pr__pfet_01v8 L=0.15 W=4 nf=1 ad=1.16 as=1.16 pd=8.58 ps=8.58 mult=1 m=1
bd_op0_0000_rl_s2_r100k_dp000p0 d_op0_0000_rl_s2_r100k_dp000p0 0 v=v(rbl_op0_0000_rl_s2_r100k_dp000p0)-v(ref_op0_0000_rl_s2_r100k_dp000p0)

* ---- instance 305: op1_0900_rl_s2_r100k_dp001p0 (variant rl_s2_r100k_dp001p0; probe dec 11.9 ns, release 34 ns, meas 36 ns) ----
vctl_op1_0900_rl_s2_r100k_dp001p0 ctl_op1_0900_rl_s2_r100k_dp001p0 0 pwl(0.0000e+00 {VDD} 2.0000e-09 {VDD} 2.1000e-09 0)
* RWL driver model (EXPERIMENTAL): slew 2 ns, series R 100000 ohm; cell pin = rwls_op1_0900_rl_s2_r100k_dp001p0
vrs_op1_0900_rl_s2_r100k_dp001p0 rwlsrc_op1_0900_rl_s2_r100k_dp001p0 0 pwl(0.0000e+00 {VDD} 2.0000e-09 {VDD} 4.0000e-09 0 3.3000e-08 0 3.5000e-08 {VDD})
rdrv_op1_0900_rl_s2_r100k_dp001p0 rwlsrc_op1_0900_rl_s2_r100k_dp001p0 rwls_op1_0900_rl_s2_r100k_dp001p0 100000
ven_op1_0900_rl_s2_r100k_dp001p0 en_op1_0900_rl_s2_r100k_dp001p0 0 pwl(0.0000e+00 0 1.1000e-08 0 1.1100e-08 {VDD} 3.4000e-08 {VDD} 3.4100e-08 0)
venb_op1_0900_rl_s2_r100k_dp001p0 enb_op1_0900_rl_s2_r100k_dp001p0 0 pwl(0.0000e+00 {VDD} 1.1000e-08 {VDD} 1.1100e-08 0 3.4000e-08 0 3.4100e-08 {VDD})
vww_op1_0900_rl_s2_r100k_dp001p0 wwl_op1_0900_rl_s2_r100k_dp001p0 0 pwl(0.0000e+00 0 1.2000e-08 0 1.2100e-08 {VDD} 3.2000e-08 {VDD} 3.2100e-08 0)
vwc_op1_0900_rl_s2_r100k_dp001p0 wbc_op1_0900_rl_s2_r100k_dp001p0 0 pwl(0.0000e+00 0 1.2000e-08 0 1.2100e-08 {VDD} 3.4000e-08 {VDD} 3.4100e-08 0)
swb_op1_0900_rl_s2_r100k_dp001p0 ref_op1_0900_rl_s2_r100k_dp001p0 wbl_op1_0900_rl_s2_r100k_dp001p0 wbc_op1_0900_rl_s2_r100k_dp001p0 0 swwbl
cwbl_op1_0900_rl_s2_r100k_dp001p0 wbl_op1_0900_rl_s2_r100k_dp001p0 0 {C_WBL}
spa_op1_0900_rl_s2_r100k_dp001p0 prea rbl_op1_0900_rl_s2_r100k_dp001p0 ctl_op1_0900_rl_s2_r100k_dp001p0 0 swpre
spr_op1_0900_rl_s2_r100k_dp001p0 pref ref_op1_0900_rl_s2_r100k_dp001p0 ctl_op1_0900_rl_s2_r100k_dp001p0 0 swpre
crbl_op1_0900_rl_s2_r100k_dp001p0 rbl_op1_0900_rl_s2_r100k_dp001p0 0 {C_RBL}
cref_op1_0900_rl_s2_r100k_dp001p0 ref_op1_0900_rl_s2_r100k_dp001p0 0 {C_RBL}   $ ASSUMPTION: ideal matched dummy load
XMWR_op1_0900_rl_s2_r100k_dp001p0_0 sn_op1_0900_rl_s2_r100k_dp001p0_0 wwl_op1_0900_rl_s2_r100k_dp001p0 wbl_op1_0900_rl_s2_r100k_dp001p0 0 sky130_fd_pr__nfet_01v8 L=0.15 W=0.42 nf=1 ad=0.1218 as=0.1218 pd=1.42 ps=1.42 nrd=0.69047619047619  nrs=0.69047619047619 sa=0 sb=0 sd=0 mult=1 m=1
XMRD_op1_0900_rl_s2_r100k_dp001p0_0 rbl_op1_0900_rl_s2_r100k_dp001p0 sn_op1_0900_rl_s2_r100k_dp001p0_0 rwls_op1_0900_rl_s2_r100k_dp001p0 0 sky130_fd_pr__nfet_01v8 L=0.15 W=0.42 nf=1 ad=0.1218 as=0.1218 pd=1.42 ps=1.42 nrd=0.69047619047619  nrs=0.69047619047619 sa=0 sb=0 sd=0 mult=1 m=1
csn_op1_0900_rl_s2_r100k_dp001p0_0 sn_op1_0900_rl_s2_r100k_dp001p0_0 0 {C_SN}
XMWR_op1_0900_rl_s2_r100k_dp001p0_1 sn_op1_0900_rl_s2_r100k_dp001p0_1 wwl_des wbl_op1_0900_rl_s2_r100k_dp001p0 0 sky130_fd_pr__nfet_01v8 L=0.15 W=0.42 nf=1 ad=0.1218 as=0.1218 pd=1.42 ps=1.42 nrd=0.69047619047619  nrs=0.69047619047619 sa=0 sb=0 sd=0 mult=1 m=1
XMRD_op1_0900_rl_s2_r100k_dp001p0_1 rbl_op1_0900_rl_s2_r100k_dp001p0 sn_op1_0900_rl_s2_r100k_dp001p0_1 rwl_des 0 sky130_fd_pr__nfet_01v8 L=0.15 W=0.42 nf=1 ad=0.1218 as=0.1218 pd=1.42 ps=1.42 nrd=0.69047619047619  nrs=0.69047619047619 sa=0 sb=0 sd=0 mult=1 m=1
csn_op1_0900_rl_s2_r100k_dp001p0_1 sn_op1_0900_rl_s2_r100k_dp001p0_1 0 {C_SN}
XMWR_op1_0900_rl_s2_r100k_dp001p0_2 sn_op1_0900_rl_s2_r100k_dp001p0_2 wwl_des wbl_op1_0900_rl_s2_r100k_dp001p0 0 sky130_fd_pr__nfet_01v8 L=0.15 W=0.42 nf=1 ad=0.1218 as=0.1218 pd=1.42 ps=1.42 nrd=0.69047619047619  nrs=0.69047619047619 sa=0 sb=0 sd=0 mult=1 m=1
XMRD_op1_0900_rl_s2_r100k_dp001p0_2 rbl_op1_0900_rl_s2_r100k_dp001p0 sn_op1_0900_rl_s2_r100k_dp001p0_2 rwl_des 0 sky130_fd_pr__nfet_01v8 L=0.15 W=0.42 nf=1 ad=0.1218 as=0.1218 pd=1.42 ps=1.42 nrd=0.69047619047619  nrs=0.69047619047619 sa=0 sb=0 sd=0 mult=1 m=1
csn_op1_0900_rl_s2_r100k_dp001p0_2 sn_op1_0900_rl_s2_r100k_dp001p0_2 0 {C_SN}
XMWR_op1_0900_rl_s2_r100k_dp001p0_3 sn_op1_0900_rl_s2_r100k_dp001p0_3 wwl_des wbl_op1_0900_rl_s2_r100k_dp001p0 0 sky130_fd_pr__nfet_01v8 L=0.15 W=0.42 nf=1 ad=0.1218 as=0.1218 pd=1.42 ps=1.42 nrd=0.69047619047619  nrs=0.69047619047619 sa=0 sb=0 sd=0 mult=1 m=1
XMRD_op1_0900_rl_s2_r100k_dp001p0_3 rbl_op1_0900_rl_s2_r100k_dp001p0 sn_op1_0900_rl_s2_r100k_dp001p0_3 rwl_des 0 sky130_fd_pr__nfet_01v8 L=0.15 W=0.42 nf=1 ad=0.1218 as=0.1218 pd=1.42 ps=1.42 nrd=0.69047619047619  nrs=0.69047619047619 sa=0 sb=0 sd=0 mult=1 m=1
csn_op1_0900_rl_s2_r100k_dp001p0_3 sn_op1_0900_rl_s2_r100k_dp001p0_3 0 {C_SN}
XMN1_op1_0900_rl_s2_r100k_dp001p0 rbl_op1_0900_rl_s2_r100k_dp001p0 ref_op1_0900_rl_s2_r100k_dp001p0 vn_op1_0900_rl_s2_r100k_dp001p0 0 sky130_fd_pr__nfet_01v8 L=0.15 W=1 nf=1 ad=0.29 as=0.29 pd=2.58 ps=2.58 mult=1 m=1
XMN2_op1_0900_rl_s2_r100k_dp001p0 ref_op1_0900_rl_s2_r100k_dp001p0 rbl_op1_0900_rl_s2_r100k_dp001p0 vn_op1_0900_rl_s2_r100k_dp001p0 0 sky130_fd_pr__nfet_01v8 L=0.15 W=1 nf=1 ad=0.29 as=0.29 pd=2.58 ps=2.58 mult=1 m=1
XMP1_op1_0900_rl_s2_r100k_dp001p0 rbl_op1_0900_rl_s2_r100k_dp001p0 ref_op1_0900_rl_s2_r100k_dp001p0 vp_op1_0900_rl_s2_r100k_dp001p0 vdd sky130_fd_pr__pfet_01v8 L=0.15 W=2 nf=1 ad=0.58 as=0.58 pd=4.58 ps=4.58 mult=1 m=1
XMP2_op1_0900_rl_s2_r100k_dp001p0 ref_op1_0900_rl_s2_r100k_dp001p0 rbl_op1_0900_rl_s2_r100k_dp001p0 vp_op1_0900_rl_s2_r100k_dp001p0 vdd sky130_fd_pr__pfet_01v8 L=0.15 W=2 nf=1 ad=0.58 as=0.58 pd=4.58 ps=4.58 mult=1 m=1
XMNF_op1_0900_rl_s2_r100k_dp001p0 vn_op1_0900_rl_s2_r100k_dp001p0 en_op1_0900_rl_s2_r100k_dp001p0 0 0 sky130_fd_pr__nfet_01v8 L=0.15 W=2 nf=1 ad=0.58 as=0.58 pd=4.58 ps=4.58 mult=1 m=1
XMPH_op1_0900_rl_s2_r100k_dp001p0 vp_op1_0900_rl_s2_r100k_dp001p0 enb_op1_0900_rl_s2_r100k_dp001p0 vdd vdd sky130_fd_pr__pfet_01v8 L=0.15 W=4 nf=1 ad=1.16 as=1.16 pd=8.58 ps=8.58 mult=1 m=1
bd_op1_0900_rl_s2_r100k_dp001p0 d_op1_0900_rl_s2_r100k_dp001p0 0 v=v(rbl_op1_0900_rl_s2_r100k_dp001p0)-v(ref_op1_0900_rl_s2_r100k_dp001p0)

* ---- instance 306: op1_1000_rl_s2_r100k_dp001p0 (variant rl_s2_r100k_dp001p0; probe dec 11.9 ns, release 34 ns, meas 36 ns) ----
vctl_op1_1000_rl_s2_r100k_dp001p0 ctl_op1_1000_rl_s2_r100k_dp001p0 0 pwl(0.0000e+00 {VDD} 2.0000e-09 {VDD} 2.1000e-09 0)
* RWL driver model (EXPERIMENTAL): slew 2 ns, series R 100000 ohm; cell pin = rwls_op1_1000_rl_s2_r100k_dp001p0
vrs_op1_1000_rl_s2_r100k_dp001p0 rwlsrc_op1_1000_rl_s2_r100k_dp001p0 0 pwl(0.0000e+00 {VDD} 2.0000e-09 {VDD} 4.0000e-09 0 3.3000e-08 0 3.5000e-08 {VDD})
rdrv_op1_1000_rl_s2_r100k_dp001p0 rwlsrc_op1_1000_rl_s2_r100k_dp001p0 rwls_op1_1000_rl_s2_r100k_dp001p0 100000
ven_op1_1000_rl_s2_r100k_dp001p0 en_op1_1000_rl_s2_r100k_dp001p0 0 pwl(0.0000e+00 0 1.1000e-08 0 1.1100e-08 {VDD} 3.4000e-08 {VDD} 3.4100e-08 0)
venb_op1_1000_rl_s2_r100k_dp001p0 enb_op1_1000_rl_s2_r100k_dp001p0 0 pwl(0.0000e+00 {VDD} 1.1000e-08 {VDD} 1.1100e-08 0 3.4000e-08 0 3.4100e-08 {VDD})
vww_op1_1000_rl_s2_r100k_dp001p0 wwl_op1_1000_rl_s2_r100k_dp001p0 0 pwl(0.0000e+00 0 1.2000e-08 0 1.2100e-08 {VDD} 3.2000e-08 {VDD} 3.2100e-08 0)
vwc_op1_1000_rl_s2_r100k_dp001p0 wbc_op1_1000_rl_s2_r100k_dp001p0 0 pwl(0.0000e+00 0 1.2000e-08 0 1.2100e-08 {VDD} 3.4000e-08 {VDD} 3.4100e-08 0)
swb_op1_1000_rl_s2_r100k_dp001p0 ref_op1_1000_rl_s2_r100k_dp001p0 wbl_op1_1000_rl_s2_r100k_dp001p0 wbc_op1_1000_rl_s2_r100k_dp001p0 0 swwbl
cwbl_op1_1000_rl_s2_r100k_dp001p0 wbl_op1_1000_rl_s2_r100k_dp001p0 0 {C_WBL}
spa_op1_1000_rl_s2_r100k_dp001p0 prea rbl_op1_1000_rl_s2_r100k_dp001p0 ctl_op1_1000_rl_s2_r100k_dp001p0 0 swpre
spr_op1_1000_rl_s2_r100k_dp001p0 pref ref_op1_1000_rl_s2_r100k_dp001p0 ctl_op1_1000_rl_s2_r100k_dp001p0 0 swpre
crbl_op1_1000_rl_s2_r100k_dp001p0 rbl_op1_1000_rl_s2_r100k_dp001p0 0 {C_RBL}
cref_op1_1000_rl_s2_r100k_dp001p0 ref_op1_1000_rl_s2_r100k_dp001p0 0 {C_RBL}   $ ASSUMPTION: ideal matched dummy load
XMWR_op1_1000_rl_s2_r100k_dp001p0_0 sn_op1_1000_rl_s2_r100k_dp001p0_0 wwl_op1_1000_rl_s2_r100k_dp001p0 wbl_op1_1000_rl_s2_r100k_dp001p0 0 sky130_fd_pr__nfet_01v8 L=0.15 W=0.42 nf=1 ad=0.1218 as=0.1218 pd=1.42 ps=1.42 nrd=0.69047619047619  nrs=0.69047619047619 sa=0 sb=0 sd=0 mult=1 m=1
XMRD_op1_1000_rl_s2_r100k_dp001p0_0 rbl_op1_1000_rl_s2_r100k_dp001p0 sn_op1_1000_rl_s2_r100k_dp001p0_0 rwls_op1_1000_rl_s2_r100k_dp001p0 0 sky130_fd_pr__nfet_01v8 L=0.15 W=0.42 nf=1 ad=0.1218 as=0.1218 pd=1.42 ps=1.42 nrd=0.69047619047619  nrs=0.69047619047619 sa=0 sb=0 sd=0 mult=1 m=1
csn_op1_1000_rl_s2_r100k_dp001p0_0 sn_op1_1000_rl_s2_r100k_dp001p0_0 0 {C_SN}
XMWR_op1_1000_rl_s2_r100k_dp001p0_1 sn_op1_1000_rl_s2_r100k_dp001p0_1 wwl_des wbl_op1_1000_rl_s2_r100k_dp001p0 0 sky130_fd_pr__nfet_01v8 L=0.15 W=0.42 nf=1 ad=0.1218 as=0.1218 pd=1.42 ps=1.42 nrd=0.69047619047619  nrs=0.69047619047619 sa=0 sb=0 sd=0 mult=1 m=1
XMRD_op1_1000_rl_s2_r100k_dp001p0_1 rbl_op1_1000_rl_s2_r100k_dp001p0 sn_op1_1000_rl_s2_r100k_dp001p0_1 rwl_des 0 sky130_fd_pr__nfet_01v8 L=0.15 W=0.42 nf=1 ad=0.1218 as=0.1218 pd=1.42 ps=1.42 nrd=0.69047619047619  nrs=0.69047619047619 sa=0 sb=0 sd=0 mult=1 m=1
csn_op1_1000_rl_s2_r100k_dp001p0_1 sn_op1_1000_rl_s2_r100k_dp001p0_1 0 {C_SN}
XMWR_op1_1000_rl_s2_r100k_dp001p0_2 sn_op1_1000_rl_s2_r100k_dp001p0_2 wwl_des wbl_op1_1000_rl_s2_r100k_dp001p0 0 sky130_fd_pr__nfet_01v8 L=0.15 W=0.42 nf=1 ad=0.1218 as=0.1218 pd=1.42 ps=1.42 nrd=0.69047619047619  nrs=0.69047619047619 sa=0 sb=0 sd=0 mult=1 m=1
XMRD_op1_1000_rl_s2_r100k_dp001p0_2 rbl_op1_1000_rl_s2_r100k_dp001p0 sn_op1_1000_rl_s2_r100k_dp001p0_2 rwl_des 0 sky130_fd_pr__nfet_01v8 L=0.15 W=0.42 nf=1 ad=0.1218 as=0.1218 pd=1.42 ps=1.42 nrd=0.69047619047619  nrs=0.69047619047619 sa=0 sb=0 sd=0 mult=1 m=1
csn_op1_1000_rl_s2_r100k_dp001p0_2 sn_op1_1000_rl_s2_r100k_dp001p0_2 0 {C_SN}
XMWR_op1_1000_rl_s2_r100k_dp001p0_3 sn_op1_1000_rl_s2_r100k_dp001p0_3 wwl_des wbl_op1_1000_rl_s2_r100k_dp001p0 0 sky130_fd_pr__nfet_01v8 L=0.15 W=0.42 nf=1 ad=0.1218 as=0.1218 pd=1.42 ps=1.42 nrd=0.69047619047619  nrs=0.69047619047619 sa=0 sb=0 sd=0 mult=1 m=1
XMRD_op1_1000_rl_s2_r100k_dp001p0_3 rbl_op1_1000_rl_s2_r100k_dp001p0 sn_op1_1000_rl_s2_r100k_dp001p0_3 rwl_des 0 sky130_fd_pr__nfet_01v8 L=0.15 W=0.42 nf=1 ad=0.1218 as=0.1218 pd=1.42 ps=1.42 nrd=0.69047619047619  nrs=0.69047619047619 sa=0 sb=0 sd=0 mult=1 m=1
csn_op1_1000_rl_s2_r100k_dp001p0_3 sn_op1_1000_rl_s2_r100k_dp001p0_3 0 {C_SN}
XMN1_op1_1000_rl_s2_r100k_dp001p0 rbl_op1_1000_rl_s2_r100k_dp001p0 ref_op1_1000_rl_s2_r100k_dp001p0 vn_op1_1000_rl_s2_r100k_dp001p0 0 sky130_fd_pr__nfet_01v8 L=0.15 W=1 nf=1 ad=0.29 as=0.29 pd=2.58 ps=2.58 mult=1 m=1
XMN2_op1_1000_rl_s2_r100k_dp001p0 ref_op1_1000_rl_s2_r100k_dp001p0 rbl_op1_1000_rl_s2_r100k_dp001p0 vn_op1_1000_rl_s2_r100k_dp001p0 0 sky130_fd_pr__nfet_01v8 L=0.15 W=1 nf=1 ad=0.29 as=0.29 pd=2.58 ps=2.58 mult=1 m=1
XMP1_op1_1000_rl_s2_r100k_dp001p0 rbl_op1_1000_rl_s2_r100k_dp001p0 ref_op1_1000_rl_s2_r100k_dp001p0 vp_op1_1000_rl_s2_r100k_dp001p0 vdd sky130_fd_pr__pfet_01v8 L=0.15 W=2 nf=1 ad=0.58 as=0.58 pd=4.58 ps=4.58 mult=1 m=1
XMP2_op1_1000_rl_s2_r100k_dp001p0 ref_op1_1000_rl_s2_r100k_dp001p0 rbl_op1_1000_rl_s2_r100k_dp001p0 vp_op1_1000_rl_s2_r100k_dp001p0 vdd sky130_fd_pr__pfet_01v8 L=0.15 W=2 nf=1 ad=0.58 as=0.58 pd=4.58 ps=4.58 mult=1 m=1
XMNF_op1_1000_rl_s2_r100k_dp001p0 vn_op1_1000_rl_s2_r100k_dp001p0 en_op1_1000_rl_s2_r100k_dp001p0 0 0 sky130_fd_pr__nfet_01v8 L=0.15 W=2 nf=1 ad=0.58 as=0.58 pd=4.58 ps=4.58 mult=1 m=1
XMPH_op1_1000_rl_s2_r100k_dp001p0 vp_op1_1000_rl_s2_r100k_dp001p0 enb_op1_1000_rl_s2_r100k_dp001p0 vdd vdd sky130_fd_pr__pfet_01v8 L=0.15 W=4 nf=1 ad=1.16 as=1.16 pd=8.58 ps=8.58 mult=1 m=1
bd_op1_1000_rl_s2_r100k_dp001p0 d_op1_1000_rl_s2_r100k_dp001p0 0 v=v(rbl_op1_1000_rl_s2_r100k_dp001p0)-v(ref_op1_1000_rl_s2_r100k_dp001p0)

* ---- instance 307: op0_n100_rl_s2_r100k_dp001p0 (variant rl_s2_r100k_dp001p0; probe dec 11.9 ns, release 34 ns, meas 36 ns) ----
vctl_op0_n100_rl_s2_r100k_dp001p0 ctl_op0_n100_rl_s2_r100k_dp001p0 0 pwl(0.0000e+00 {VDD} 2.0000e-09 {VDD} 2.1000e-09 0)
* RWL driver model (EXPERIMENTAL): slew 2 ns, series R 100000 ohm; cell pin = rwls_op0_n100_rl_s2_r100k_dp001p0
vrs_op0_n100_rl_s2_r100k_dp001p0 rwlsrc_op0_n100_rl_s2_r100k_dp001p0 0 pwl(0.0000e+00 {VDD} 2.0000e-09 {VDD} 4.0000e-09 0 3.3000e-08 0 3.5000e-08 {VDD})
rdrv_op0_n100_rl_s2_r100k_dp001p0 rwlsrc_op0_n100_rl_s2_r100k_dp001p0 rwls_op0_n100_rl_s2_r100k_dp001p0 100000
ven_op0_n100_rl_s2_r100k_dp001p0 en_op0_n100_rl_s2_r100k_dp001p0 0 pwl(0.0000e+00 0 1.1000e-08 0 1.1100e-08 {VDD} 3.4000e-08 {VDD} 3.4100e-08 0)
venb_op0_n100_rl_s2_r100k_dp001p0 enb_op0_n100_rl_s2_r100k_dp001p0 0 pwl(0.0000e+00 {VDD} 1.1000e-08 {VDD} 1.1100e-08 0 3.4000e-08 0 3.4100e-08 {VDD})
vww_op0_n100_rl_s2_r100k_dp001p0 wwl_op0_n100_rl_s2_r100k_dp001p0 0 pwl(0.0000e+00 0 1.2000e-08 0 1.2100e-08 {VDD} 3.2000e-08 {VDD} 3.2100e-08 0)
vwc_op0_n100_rl_s2_r100k_dp001p0 wbc_op0_n100_rl_s2_r100k_dp001p0 0 pwl(0.0000e+00 0 1.2000e-08 0 1.2100e-08 {VDD} 3.4000e-08 {VDD} 3.4100e-08 0)
swb_op0_n100_rl_s2_r100k_dp001p0 ref_op0_n100_rl_s2_r100k_dp001p0 wbl_op0_n100_rl_s2_r100k_dp001p0 wbc_op0_n100_rl_s2_r100k_dp001p0 0 swwbl
cwbl_op0_n100_rl_s2_r100k_dp001p0 wbl_op0_n100_rl_s2_r100k_dp001p0 0 {C_WBL}
spa_op0_n100_rl_s2_r100k_dp001p0 prea rbl_op0_n100_rl_s2_r100k_dp001p0 ctl_op0_n100_rl_s2_r100k_dp001p0 0 swpre
spr_op0_n100_rl_s2_r100k_dp001p0 pref ref_op0_n100_rl_s2_r100k_dp001p0 ctl_op0_n100_rl_s2_r100k_dp001p0 0 swpre
crbl_op0_n100_rl_s2_r100k_dp001p0 rbl_op0_n100_rl_s2_r100k_dp001p0 0 {C_RBL}
cref_op0_n100_rl_s2_r100k_dp001p0 ref_op0_n100_rl_s2_r100k_dp001p0 0 {C_RBL}   $ ASSUMPTION: ideal matched dummy load
XMWR_op0_n100_rl_s2_r100k_dp001p0_0 sn_op0_n100_rl_s2_r100k_dp001p0_0 wwl_op0_n100_rl_s2_r100k_dp001p0 wbl_op0_n100_rl_s2_r100k_dp001p0 0 sky130_fd_pr__nfet_01v8 L=0.15 W=0.42 nf=1 ad=0.1218 as=0.1218 pd=1.42 ps=1.42 nrd=0.69047619047619  nrs=0.69047619047619 sa=0 sb=0 sd=0 mult=1 m=1
XMRD_op0_n100_rl_s2_r100k_dp001p0_0 rbl_op0_n100_rl_s2_r100k_dp001p0 sn_op0_n100_rl_s2_r100k_dp001p0_0 rwls_op0_n100_rl_s2_r100k_dp001p0 0 sky130_fd_pr__nfet_01v8 L=0.15 W=0.42 nf=1 ad=0.1218 as=0.1218 pd=1.42 ps=1.42 nrd=0.69047619047619  nrs=0.69047619047619 sa=0 sb=0 sd=0 mult=1 m=1
csn_op0_n100_rl_s2_r100k_dp001p0_0 sn_op0_n100_rl_s2_r100k_dp001p0_0 0 {C_SN}
XMWR_op0_n100_rl_s2_r100k_dp001p0_1 sn_op0_n100_rl_s2_r100k_dp001p0_1 wwl_des wbl_op0_n100_rl_s2_r100k_dp001p0 0 sky130_fd_pr__nfet_01v8 L=0.15 W=0.42 nf=1 ad=0.1218 as=0.1218 pd=1.42 ps=1.42 nrd=0.69047619047619  nrs=0.69047619047619 sa=0 sb=0 sd=0 mult=1 m=1
XMRD_op0_n100_rl_s2_r100k_dp001p0_1 rbl_op0_n100_rl_s2_r100k_dp001p0 sn_op0_n100_rl_s2_r100k_dp001p0_1 rwl_des 0 sky130_fd_pr__nfet_01v8 L=0.15 W=0.42 nf=1 ad=0.1218 as=0.1218 pd=1.42 ps=1.42 nrd=0.69047619047619  nrs=0.69047619047619 sa=0 sb=0 sd=0 mult=1 m=1
csn_op0_n100_rl_s2_r100k_dp001p0_1 sn_op0_n100_rl_s2_r100k_dp001p0_1 0 {C_SN}
XMWR_op0_n100_rl_s2_r100k_dp001p0_2 sn_op0_n100_rl_s2_r100k_dp001p0_2 wwl_des wbl_op0_n100_rl_s2_r100k_dp001p0 0 sky130_fd_pr__nfet_01v8 L=0.15 W=0.42 nf=1 ad=0.1218 as=0.1218 pd=1.42 ps=1.42 nrd=0.69047619047619  nrs=0.69047619047619 sa=0 sb=0 sd=0 mult=1 m=1
XMRD_op0_n100_rl_s2_r100k_dp001p0_2 rbl_op0_n100_rl_s2_r100k_dp001p0 sn_op0_n100_rl_s2_r100k_dp001p0_2 rwl_des 0 sky130_fd_pr__nfet_01v8 L=0.15 W=0.42 nf=1 ad=0.1218 as=0.1218 pd=1.42 ps=1.42 nrd=0.69047619047619  nrs=0.69047619047619 sa=0 sb=0 sd=0 mult=1 m=1
csn_op0_n100_rl_s2_r100k_dp001p0_2 sn_op0_n100_rl_s2_r100k_dp001p0_2 0 {C_SN}
XMWR_op0_n100_rl_s2_r100k_dp001p0_3 sn_op0_n100_rl_s2_r100k_dp001p0_3 wwl_des wbl_op0_n100_rl_s2_r100k_dp001p0 0 sky130_fd_pr__nfet_01v8 L=0.15 W=0.42 nf=1 ad=0.1218 as=0.1218 pd=1.42 ps=1.42 nrd=0.69047619047619  nrs=0.69047619047619 sa=0 sb=0 sd=0 mult=1 m=1
XMRD_op0_n100_rl_s2_r100k_dp001p0_3 rbl_op0_n100_rl_s2_r100k_dp001p0 sn_op0_n100_rl_s2_r100k_dp001p0_3 rwl_des 0 sky130_fd_pr__nfet_01v8 L=0.15 W=0.42 nf=1 ad=0.1218 as=0.1218 pd=1.42 ps=1.42 nrd=0.69047619047619  nrs=0.69047619047619 sa=0 sb=0 sd=0 mult=1 m=1
csn_op0_n100_rl_s2_r100k_dp001p0_3 sn_op0_n100_rl_s2_r100k_dp001p0_3 0 {C_SN}
XMN1_op0_n100_rl_s2_r100k_dp001p0 rbl_op0_n100_rl_s2_r100k_dp001p0 ref_op0_n100_rl_s2_r100k_dp001p0 vn_op0_n100_rl_s2_r100k_dp001p0 0 sky130_fd_pr__nfet_01v8 L=0.15 W=1 nf=1 ad=0.29 as=0.29 pd=2.58 ps=2.58 mult=1 m=1
XMN2_op0_n100_rl_s2_r100k_dp001p0 ref_op0_n100_rl_s2_r100k_dp001p0 rbl_op0_n100_rl_s2_r100k_dp001p0 vn_op0_n100_rl_s2_r100k_dp001p0 0 sky130_fd_pr__nfet_01v8 L=0.15 W=1 nf=1 ad=0.29 as=0.29 pd=2.58 ps=2.58 mult=1 m=1
XMP1_op0_n100_rl_s2_r100k_dp001p0 rbl_op0_n100_rl_s2_r100k_dp001p0 ref_op0_n100_rl_s2_r100k_dp001p0 vp_op0_n100_rl_s2_r100k_dp001p0 vdd sky130_fd_pr__pfet_01v8 L=0.15 W=2 nf=1 ad=0.58 as=0.58 pd=4.58 ps=4.58 mult=1 m=1
XMP2_op0_n100_rl_s2_r100k_dp001p0 ref_op0_n100_rl_s2_r100k_dp001p0 rbl_op0_n100_rl_s2_r100k_dp001p0 vp_op0_n100_rl_s2_r100k_dp001p0 vdd sky130_fd_pr__pfet_01v8 L=0.15 W=2 nf=1 ad=0.58 as=0.58 pd=4.58 ps=4.58 mult=1 m=1
XMNF_op0_n100_rl_s2_r100k_dp001p0 vn_op0_n100_rl_s2_r100k_dp001p0 en_op0_n100_rl_s2_r100k_dp001p0 0 0 sky130_fd_pr__nfet_01v8 L=0.15 W=2 nf=1 ad=0.58 as=0.58 pd=4.58 ps=4.58 mult=1 m=1
XMPH_op0_n100_rl_s2_r100k_dp001p0 vp_op0_n100_rl_s2_r100k_dp001p0 enb_op0_n100_rl_s2_r100k_dp001p0 vdd vdd sky130_fd_pr__pfet_01v8 L=0.15 W=4 nf=1 ad=1.16 as=1.16 pd=8.58 ps=8.58 mult=1 m=1
bd_op0_n100_rl_s2_r100k_dp001p0 d_op0_n100_rl_s2_r100k_dp001p0 0 v=v(rbl_op0_n100_rl_s2_r100k_dp001p0)-v(ref_op0_n100_rl_s2_r100k_dp001p0)

* ---- instance 308: op0_0000_rl_s2_r100k_dp001p0 (variant rl_s2_r100k_dp001p0; probe dec 11.9 ns, release 34 ns, meas 36 ns) ----
vctl_op0_0000_rl_s2_r100k_dp001p0 ctl_op0_0000_rl_s2_r100k_dp001p0 0 pwl(0.0000e+00 {VDD} 2.0000e-09 {VDD} 2.1000e-09 0)
* RWL driver model (EXPERIMENTAL): slew 2 ns, series R 100000 ohm; cell pin = rwls_op0_0000_rl_s2_r100k_dp001p0
vrs_op0_0000_rl_s2_r100k_dp001p0 rwlsrc_op0_0000_rl_s2_r100k_dp001p0 0 pwl(0.0000e+00 {VDD} 2.0000e-09 {VDD} 4.0000e-09 0 3.3000e-08 0 3.5000e-08 {VDD})
rdrv_op0_0000_rl_s2_r100k_dp001p0 rwlsrc_op0_0000_rl_s2_r100k_dp001p0 rwls_op0_0000_rl_s2_r100k_dp001p0 100000
ven_op0_0000_rl_s2_r100k_dp001p0 en_op0_0000_rl_s2_r100k_dp001p0 0 pwl(0.0000e+00 0 1.1000e-08 0 1.1100e-08 {VDD} 3.4000e-08 {VDD} 3.4100e-08 0)
venb_op0_0000_rl_s2_r100k_dp001p0 enb_op0_0000_rl_s2_r100k_dp001p0 0 pwl(0.0000e+00 {VDD} 1.1000e-08 {VDD} 1.1100e-08 0 3.4000e-08 0 3.4100e-08 {VDD})
vww_op0_0000_rl_s2_r100k_dp001p0 wwl_op0_0000_rl_s2_r100k_dp001p0 0 pwl(0.0000e+00 0 1.2000e-08 0 1.2100e-08 {VDD} 3.2000e-08 {VDD} 3.2100e-08 0)
vwc_op0_0000_rl_s2_r100k_dp001p0 wbc_op0_0000_rl_s2_r100k_dp001p0 0 pwl(0.0000e+00 0 1.2000e-08 0 1.2100e-08 {VDD} 3.4000e-08 {VDD} 3.4100e-08 0)
swb_op0_0000_rl_s2_r100k_dp001p0 ref_op0_0000_rl_s2_r100k_dp001p0 wbl_op0_0000_rl_s2_r100k_dp001p0 wbc_op0_0000_rl_s2_r100k_dp001p0 0 swwbl
cwbl_op0_0000_rl_s2_r100k_dp001p0 wbl_op0_0000_rl_s2_r100k_dp001p0 0 {C_WBL}
spa_op0_0000_rl_s2_r100k_dp001p0 prea rbl_op0_0000_rl_s2_r100k_dp001p0 ctl_op0_0000_rl_s2_r100k_dp001p0 0 swpre
spr_op0_0000_rl_s2_r100k_dp001p0 pref ref_op0_0000_rl_s2_r100k_dp001p0 ctl_op0_0000_rl_s2_r100k_dp001p0 0 swpre
crbl_op0_0000_rl_s2_r100k_dp001p0 rbl_op0_0000_rl_s2_r100k_dp001p0 0 {C_RBL}
cref_op0_0000_rl_s2_r100k_dp001p0 ref_op0_0000_rl_s2_r100k_dp001p0 0 {C_RBL}   $ ASSUMPTION: ideal matched dummy load
XMWR_op0_0000_rl_s2_r100k_dp001p0_0 sn_op0_0000_rl_s2_r100k_dp001p0_0 wwl_op0_0000_rl_s2_r100k_dp001p0 wbl_op0_0000_rl_s2_r100k_dp001p0 0 sky130_fd_pr__nfet_01v8 L=0.15 W=0.42 nf=1 ad=0.1218 as=0.1218 pd=1.42 ps=1.42 nrd=0.69047619047619  nrs=0.69047619047619 sa=0 sb=0 sd=0 mult=1 m=1
XMRD_op0_0000_rl_s2_r100k_dp001p0_0 rbl_op0_0000_rl_s2_r100k_dp001p0 sn_op0_0000_rl_s2_r100k_dp001p0_0 rwls_op0_0000_rl_s2_r100k_dp001p0 0 sky130_fd_pr__nfet_01v8 L=0.15 W=0.42 nf=1 ad=0.1218 as=0.1218 pd=1.42 ps=1.42 nrd=0.69047619047619  nrs=0.69047619047619 sa=0 sb=0 sd=0 mult=1 m=1
csn_op0_0000_rl_s2_r100k_dp001p0_0 sn_op0_0000_rl_s2_r100k_dp001p0_0 0 {C_SN}
XMWR_op0_0000_rl_s2_r100k_dp001p0_1 sn_op0_0000_rl_s2_r100k_dp001p0_1 wwl_des wbl_op0_0000_rl_s2_r100k_dp001p0 0 sky130_fd_pr__nfet_01v8 L=0.15 W=0.42 nf=1 ad=0.1218 as=0.1218 pd=1.42 ps=1.42 nrd=0.69047619047619  nrs=0.69047619047619 sa=0 sb=0 sd=0 mult=1 m=1
XMRD_op0_0000_rl_s2_r100k_dp001p0_1 rbl_op0_0000_rl_s2_r100k_dp001p0 sn_op0_0000_rl_s2_r100k_dp001p0_1 rwl_des 0 sky130_fd_pr__nfet_01v8 L=0.15 W=0.42 nf=1 ad=0.1218 as=0.1218 pd=1.42 ps=1.42 nrd=0.69047619047619  nrs=0.69047619047619 sa=0 sb=0 sd=0 mult=1 m=1
csn_op0_0000_rl_s2_r100k_dp001p0_1 sn_op0_0000_rl_s2_r100k_dp001p0_1 0 {C_SN}
XMWR_op0_0000_rl_s2_r100k_dp001p0_2 sn_op0_0000_rl_s2_r100k_dp001p0_2 wwl_des wbl_op0_0000_rl_s2_r100k_dp001p0 0 sky130_fd_pr__nfet_01v8 L=0.15 W=0.42 nf=1 ad=0.1218 as=0.1218 pd=1.42 ps=1.42 nrd=0.69047619047619  nrs=0.69047619047619 sa=0 sb=0 sd=0 mult=1 m=1
XMRD_op0_0000_rl_s2_r100k_dp001p0_2 rbl_op0_0000_rl_s2_r100k_dp001p0 sn_op0_0000_rl_s2_r100k_dp001p0_2 rwl_des 0 sky130_fd_pr__nfet_01v8 L=0.15 W=0.42 nf=1 ad=0.1218 as=0.1218 pd=1.42 ps=1.42 nrd=0.69047619047619  nrs=0.69047619047619 sa=0 sb=0 sd=0 mult=1 m=1
csn_op0_0000_rl_s2_r100k_dp001p0_2 sn_op0_0000_rl_s2_r100k_dp001p0_2 0 {C_SN}
XMWR_op0_0000_rl_s2_r100k_dp001p0_3 sn_op0_0000_rl_s2_r100k_dp001p0_3 wwl_des wbl_op0_0000_rl_s2_r100k_dp001p0 0 sky130_fd_pr__nfet_01v8 L=0.15 W=0.42 nf=1 ad=0.1218 as=0.1218 pd=1.42 ps=1.42 nrd=0.69047619047619  nrs=0.69047619047619 sa=0 sb=0 sd=0 mult=1 m=1
XMRD_op0_0000_rl_s2_r100k_dp001p0_3 rbl_op0_0000_rl_s2_r100k_dp001p0 sn_op0_0000_rl_s2_r100k_dp001p0_3 rwl_des 0 sky130_fd_pr__nfet_01v8 L=0.15 W=0.42 nf=1 ad=0.1218 as=0.1218 pd=1.42 ps=1.42 nrd=0.69047619047619  nrs=0.69047619047619 sa=0 sb=0 sd=0 mult=1 m=1
csn_op0_0000_rl_s2_r100k_dp001p0_3 sn_op0_0000_rl_s2_r100k_dp001p0_3 0 {C_SN}
XMN1_op0_0000_rl_s2_r100k_dp001p0 rbl_op0_0000_rl_s2_r100k_dp001p0 ref_op0_0000_rl_s2_r100k_dp001p0 vn_op0_0000_rl_s2_r100k_dp001p0 0 sky130_fd_pr__nfet_01v8 L=0.15 W=1 nf=1 ad=0.29 as=0.29 pd=2.58 ps=2.58 mult=1 m=1
XMN2_op0_0000_rl_s2_r100k_dp001p0 ref_op0_0000_rl_s2_r100k_dp001p0 rbl_op0_0000_rl_s2_r100k_dp001p0 vn_op0_0000_rl_s2_r100k_dp001p0 0 sky130_fd_pr__nfet_01v8 L=0.15 W=1 nf=1 ad=0.29 as=0.29 pd=2.58 ps=2.58 mult=1 m=1
XMP1_op0_0000_rl_s2_r100k_dp001p0 rbl_op0_0000_rl_s2_r100k_dp001p0 ref_op0_0000_rl_s2_r100k_dp001p0 vp_op0_0000_rl_s2_r100k_dp001p0 vdd sky130_fd_pr__pfet_01v8 L=0.15 W=2 nf=1 ad=0.58 as=0.58 pd=4.58 ps=4.58 mult=1 m=1
XMP2_op0_0000_rl_s2_r100k_dp001p0 ref_op0_0000_rl_s2_r100k_dp001p0 rbl_op0_0000_rl_s2_r100k_dp001p0 vp_op0_0000_rl_s2_r100k_dp001p0 vdd sky130_fd_pr__pfet_01v8 L=0.15 W=2 nf=1 ad=0.58 as=0.58 pd=4.58 ps=4.58 mult=1 m=1
XMNF_op0_0000_rl_s2_r100k_dp001p0 vn_op0_0000_rl_s2_r100k_dp001p0 en_op0_0000_rl_s2_r100k_dp001p0 0 0 sky130_fd_pr__nfet_01v8 L=0.15 W=2 nf=1 ad=0.58 as=0.58 pd=4.58 ps=4.58 mult=1 m=1
XMPH_op0_0000_rl_s2_r100k_dp001p0 vp_op0_0000_rl_s2_r100k_dp001p0 enb_op0_0000_rl_s2_r100k_dp001p0 vdd vdd sky130_fd_pr__pfet_01v8 L=0.15 W=4 nf=1 ad=1.16 as=1.16 pd=8.58 ps=8.58 mult=1 m=1
bd_op0_0000_rl_s2_r100k_dp001p0 d_op0_0000_rl_s2_r100k_dp001p0 0 v=v(rbl_op0_0000_rl_s2_r100k_dp001p0)-v(ref_op0_0000_rl_s2_r100k_dp001p0)

* ---- instance 309: op1_0900_rl_s2_r100k_dp002p0 (variant rl_s2_r100k_dp002p0; probe dec 11.9 ns, release 34 ns, meas 36 ns) ----
vctl_op1_0900_rl_s2_r100k_dp002p0 ctl_op1_0900_rl_s2_r100k_dp002p0 0 pwl(0.0000e+00 {VDD} 2.0000e-09 {VDD} 2.1000e-09 0)
* RWL driver model (EXPERIMENTAL): slew 2 ns, series R 100000 ohm; cell pin = rwls_op1_0900_rl_s2_r100k_dp002p0
vrs_op1_0900_rl_s2_r100k_dp002p0 rwlsrc_op1_0900_rl_s2_r100k_dp002p0 0 pwl(0.0000e+00 {VDD} 2.0000e-09 {VDD} 4.0000e-09 0 3.4000e-08 0 3.6000e-08 {VDD})
rdrv_op1_0900_rl_s2_r100k_dp002p0 rwlsrc_op1_0900_rl_s2_r100k_dp002p0 rwls_op1_0900_rl_s2_r100k_dp002p0 100000
ven_op1_0900_rl_s2_r100k_dp002p0 en_op1_0900_rl_s2_r100k_dp002p0 0 pwl(0.0000e+00 0 1.1000e-08 0 1.1100e-08 {VDD} 3.4000e-08 {VDD} 3.4100e-08 0)
venb_op1_0900_rl_s2_r100k_dp002p0 enb_op1_0900_rl_s2_r100k_dp002p0 0 pwl(0.0000e+00 {VDD} 1.1000e-08 {VDD} 1.1100e-08 0 3.4000e-08 0 3.4100e-08 {VDD})
vww_op1_0900_rl_s2_r100k_dp002p0 wwl_op1_0900_rl_s2_r100k_dp002p0 0 pwl(0.0000e+00 0 1.2000e-08 0 1.2100e-08 {VDD} 3.2000e-08 {VDD} 3.2100e-08 0)
vwc_op1_0900_rl_s2_r100k_dp002p0 wbc_op1_0900_rl_s2_r100k_dp002p0 0 pwl(0.0000e+00 0 1.2000e-08 0 1.2100e-08 {VDD} 3.4000e-08 {VDD} 3.4100e-08 0)
swb_op1_0900_rl_s2_r100k_dp002p0 ref_op1_0900_rl_s2_r100k_dp002p0 wbl_op1_0900_rl_s2_r100k_dp002p0 wbc_op1_0900_rl_s2_r100k_dp002p0 0 swwbl
cwbl_op1_0900_rl_s2_r100k_dp002p0 wbl_op1_0900_rl_s2_r100k_dp002p0 0 {C_WBL}
spa_op1_0900_rl_s2_r100k_dp002p0 prea rbl_op1_0900_rl_s2_r100k_dp002p0 ctl_op1_0900_rl_s2_r100k_dp002p0 0 swpre
spr_op1_0900_rl_s2_r100k_dp002p0 pref ref_op1_0900_rl_s2_r100k_dp002p0 ctl_op1_0900_rl_s2_r100k_dp002p0 0 swpre
crbl_op1_0900_rl_s2_r100k_dp002p0 rbl_op1_0900_rl_s2_r100k_dp002p0 0 {C_RBL}
cref_op1_0900_rl_s2_r100k_dp002p0 ref_op1_0900_rl_s2_r100k_dp002p0 0 {C_RBL}   $ ASSUMPTION: ideal matched dummy load
XMWR_op1_0900_rl_s2_r100k_dp002p0_0 sn_op1_0900_rl_s2_r100k_dp002p0_0 wwl_op1_0900_rl_s2_r100k_dp002p0 wbl_op1_0900_rl_s2_r100k_dp002p0 0 sky130_fd_pr__nfet_01v8 L=0.15 W=0.42 nf=1 ad=0.1218 as=0.1218 pd=1.42 ps=1.42 nrd=0.69047619047619  nrs=0.69047619047619 sa=0 sb=0 sd=0 mult=1 m=1
XMRD_op1_0900_rl_s2_r100k_dp002p0_0 rbl_op1_0900_rl_s2_r100k_dp002p0 sn_op1_0900_rl_s2_r100k_dp002p0_0 rwls_op1_0900_rl_s2_r100k_dp002p0 0 sky130_fd_pr__nfet_01v8 L=0.15 W=0.42 nf=1 ad=0.1218 as=0.1218 pd=1.42 ps=1.42 nrd=0.69047619047619  nrs=0.69047619047619 sa=0 sb=0 sd=0 mult=1 m=1
csn_op1_0900_rl_s2_r100k_dp002p0_0 sn_op1_0900_rl_s2_r100k_dp002p0_0 0 {C_SN}
XMWR_op1_0900_rl_s2_r100k_dp002p0_1 sn_op1_0900_rl_s2_r100k_dp002p0_1 wwl_des wbl_op1_0900_rl_s2_r100k_dp002p0 0 sky130_fd_pr__nfet_01v8 L=0.15 W=0.42 nf=1 ad=0.1218 as=0.1218 pd=1.42 ps=1.42 nrd=0.69047619047619  nrs=0.69047619047619 sa=0 sb=0 sd=0 mult=1 m=1
XMRD_op1_0900_rl_s2_r100k_dp002p0_1 rbl_op1_0900_rl_s2_r100k_dp002p0 sn_op1_0900_rl_s2_r100k_dp002p0_1 rwl_des 0 sky130_fd_pr__nfet_01v8 L=0.15 W=0.42 nf=1 ad=0.1218 as=0.1218 pd=1.42 ps=1.42 nrd=0.69047619047619  nrs=0.69047619047619 sa=0 sb=0 sd=0 mult=1 m=1
csn_op1_0900_rl_s2_r100k_dp002p0_1 sn_op1_0900_rl_s2_r100k_dp002p0_1 0 {C_SN}
XMWR_op1_0900_rl_s2_r100k_dp002p0_2 sn_op1_0900_rl_s2_r100k_dp002p0_2 wwl_des wbl_op1_0900_rl_s2_r100k_dp002p0 0 sky130_fd_pr__nfet_01v8 L=0.15 W=0.42 nf=1 ad=0.1218 as=0.1218 pd=1.42 ps=1.42 nrd=0.69047619047619  nrs=0.69047619047619 sa=0 sb=0 sd=0 mult=1 m=1
XMRD_op1_0900_rl_s2_r100k_dp002p0_2 rbl_op1_0900_rl_s2_r100k_dp002p0 sn_op1_0900_rl_s2_r100k_dp002p0_2 rwl_des 0 sky130_fd_pr__nfet_01v8 L=0.15 W=0.42 nf=1 ad=0.1218 as=0.1218 pd=1.42 ps=1.42 nrd=0.69047619047619  nrs=0.69047619047619 sa=0 sb=0 sd=0 mult=1 m=1
csn_op1_0900_rl_s2_r100k_dp002p0_2 sn_op1_0900_rl_s2_r100k_dp002p0_2 0 {C_SN}
XMWR_op1_0900_rl_s2_r100k_dp002p0_3 sn_op1_0900_rl_s2_r100k_dp002p0_3 wwl_des wbl_op1_0900_rl_s2_r100k_dp002p0 0 sky130_fd_pr__nfet_01v8 L=0.15 W=0.42 nf=1 ad=0.1218 as=0.1218 pd=1.42 ps=1.42 nrd=0.69047619047619  nrs=0.69047619047619 sa=0 sb=0 sd=0 mult=1 m=1
XMRD_op1_0900_rl_s2_r100k_dp002p0_3 rbl_op1_0900_rl_s2_r100k_dp002p0 sn_op1_0900_rl_s2_r100k_dp002p0_3 rwl_des 0 sky130_fd_pr__nfet_01v8 L=0.15 W=0.42 nf=1 ad=0.1218 as=0.1218 pd=1.42 ps=1.42 nrd=0.69047619047619  nrs=0.69047619047619 sa=0 sb=0 sd=0 mult=1 m=1
csn_op1_0900_rl_s2_r100k_dp002p0_3 sn_op1_0900_rl_s2_r100k_dp002p0_3 0 {C_SN}
XMN1_op1_0900_rl_s2_r100k_dp002p0 rbl_op1_0900_rl_s2_r100k_dp002p0 ref_op1_0900_rl_s2_r100k_dp002p0 vn_op1_0900_rl_s2_r100k_dp002p0 0 sky130_fd_pr__nfet_01v8 L=0.15 W=1 nf=1 ad=0.29 as=0.29 pd=2.58 ps=2.58 mult=1 m=1
XMN2_op1_0900_rl_s2_r100k_dp002p0 ref_op1_0900_rl_s2_r100k_dp002p0 rbl_op1_0900_rl_s2_r100k_dp002p0 vn_op1_0900_rl_s2_r100k_dp002p0 0 sky130_fd_pr__nfet_01v8 L=0.15 W=1 nf=1 ad=0.29 as=0.29 pd=2.58 ps=2.58 mult=1 m=1
XMP1_op1_0900_rl_s2_r100k_dp002p0 rbl_op1_0900_rl_s2_r100k_dp002p0 ref_op1_0900_rl_s2_r100k_dp002p0 vp_op1_0900_rl_s2_r100k_dp002p0 vdd sky130_fd_pr__pfet_01v8 L=0.15 W=2 nf=1 ad=0.58 as=0.58 pd=4.58 ps=4.58 mult=1 m=1
XMP2_op1_0900_rl_s2_r100k_dp002p0 ref_op1_0900_rl_s2_r100k_dp002p0 rbl_op1_0900_rl_s2_r100k_dp002p0 vp_op1_0900_rl_s2_r100k_dp002p0 vdd sky130_fd_pr__pfet_01v8 L=0.15 W=2 nf=1 ad=0.58 as=0.58 pd=4.58 ps=4.58 mult=1 m=1
XMNF_op1_0900_rl_s2_r100k_dp002p0 vn_op1_0900_rl_s2_r100k_dp002p0 en_op1_0900_rl_s2_r100k_dp002p0 0 0 sky130_fd_pr__nfet_01v8 L=0.15 W=2 nf=1 ad=0.58 as=0.58 pd=4.58 ps=4.58 mult=1 m=1
XMPH_op1_0900_rl_s2_r100k_dp002p0 vp_op1_0900_rl_s2_r100k_dp002p0 enb_op1_0900_rl_s2_r100k_dp002p0 vdd vdd sky130_fd_pr__pfet_01v8 L=0.15 W=4 nf=1 ad=1.16 as=1.16 pd=8.58 ps=8.58 mult=1 m=1
bd_op1_0900_rl_s2_r100k_dp002p0 d_op1_0900_rl_s2_r100k_dp002p0 0 v=v(rbl_op1_0900_rl_s2_r100k_dp002p0)-v(ref_op1_0900_rl_s2_r100k_dp002p0)

* ---- instance 310: op1_1000_rl_s2_r100k_dp002p0 (variant rl_s2_r100k_dp002p0; probe dec 11.9 ns, release 34 ns, meas 36 ns) ----
vctl_op1_1000_rl_s2_r100k_dp002p0 ctl_op1_1000_rl_s2_r100k_dp002p0 0 pwl(0.0000e+00 {VDD} 2.0000e-09 {VDD} 2.1000e-09 0)
* RWL driver model (EXPERIMENTAL): slew 2 ns, series R 100000 ohm; cell pin = rwls_op1_1000_rl_s2_r100k_dp002p0
vrs_op1_1000_rl_s2_r100k_dp002p0 rwlsrc_op1_1000_rl_s2_r100k_dp002p0 0 pwl(0.0000e+00 {VDD} 2.0000e-09 {VDD} 4.0000e-09 0 3.4000e-08 0 3.6000e-08 {VDD})
rdrv_op1_1000_rl_s2_r100k_dp002p0 rwlsrc_op1_1000_rl_s2_r100k_dp002p0 rwls_op1_1000_rl_s2_r100k_dp002p0 100000
ven_op1_1000_rl_s2_r100k_dp002p0 en_op1_1000_rl_s2_r100k_dp002p0 0 pwl(0.0000e+00 0 1.1000e-08 0 1.1100e-08 {VDD} 3.4000e-08 {VDD} 3.4100e-08 0)
venb_op1_1000_rl_s2_r100k_dp002p0 enb_op1_1000_rl_s2_r100k_dp002p0 0 pwl(0.0000e+00 {VDD} 1.1000e-08 {VDD} 1.1100e-08 0 3.4000e-08 0 3.4100e-08 {VDD})
vww_op1_1000_rl_s2_r100k_dp002p0 wwl_op1_1000_rl_s2_r100k_dp002p0 0 pwl(0.0000e+00 0 1.2000e-08 0 1.2100e-08 {VDD} 3.2000e-08 {VDD} 3.2100e-08 0)
vwc_op1_1000_rl_s2_r100k_dp002p0 wbc_op1_1000_rl_s2_r100k_dp002p0 0 pwl(0.0000e+00 0 1.2000e-08 0 1.2100e-08 {VDD} 3.4000e-08 {VDD} 3.4100e-08 0)
swb_op1_1000_rl_s2_r100k_dp002p0 ref_op1_1000_rl_s2_r100k_dp002p0 wbl_op1_1000_rl_s2_r100k_dp002p0 wbc_op1_1000_rl_s2_r100k_dp002p0 0 swwbl
cwbl_op1_1000_rl_s2_r100k_dp002p0 wbl_op1_1000_rl_s2_r100k_dp002p0 0 {C_WBL}
spa_op1_1000_rl_s2_r100k_dp002p0 prea rbl_op1_1000_rl_s2_r100k_dp002p0 ctl_op1_1000_rl_s2_r100k_dp002p0 0 swpre
spr_op1_1000_rl_s2_r100k_dp002p0 pref ref_op1_1000_rl_s2_r100k_dp002p0 ctl_op1_1000_rl_s2_r100k_dp002p0 0 swpre
crbl_op1_1000_rl_s2_r100k_dp002p0 rbl_op1_1000_rl_s2_r100k_dp002p0 0 {C_RBL}
cref_op1_1000_rl_s2_r100k_dp002p0 ref_op1_1000_rl_s2_r100k_dp002p0 0 {C_RBL}   $ ASSUMPTION: ideal matched dummy load
XMWR_op1_1000_rl_s2_r100k_dp002p0_0 sn_op1_1000_rl_s2_r100k_dp002p0_0 wwl_op1_1000_rl_s2_r100k_dp002p0 wbl_op1_1000_rl_s2_r100k_dp002p0 0 sky130_fd_pr__nfet_01v8 L=0.15 W=0.42 nf=1 ad=0.1218 as=0.1218 pd=1.42 ps=1.42 nrd=0.69047619047619  nrs=0.69047619047619 sa=0 sb=0 sd=0 mult=1 m=1
XMRD_op1_1000_rl_s2_r100k_dp002p0_0 rbl_op1_1000_rl_s2_r100k_dp002p0 sn_op1_1000_rl_s2_r100k_dp002p0_0 rwls_op1_1000_rl_s2_r100k_dp002p0 0 sky130_fd_pr__nfet_01v8 L=0.15 W=0.42 nf=1 ad=0.1218 as=0.1218 pd=1.42 ps=1.42 nrd=0.69047619047619  nrs=0.69047619047619 sa=0 sb=0 sd=0 mult=1 m=1
csn_op1_1000_rl_s2_r100k_dp002p0_0 sn_op1_1000_rl_s2_r100k_dp002p0_0 0 {C_SN}
XMWR_op1_1000_rl_s2_r100k_dp002p0_1 sn_op1_1000_rl_s2_r100k_dp002p0_1 wwl_des wbl_op1_1000_rl_s2_r100k_dp002p0 0 sky130_fd_pr__nfet_01v8 L=0.15 W=0.42 nf=1 ad=0.1218 as=0.1218 pd=1.42 ps=1.42 nrd=0.69047619047619  nrs=0.69047619047619 sa=0 sb=0 sd=0 mult=1 m=1
XMRD_op1_1000_rl_s2_r100k_dp002p0_1 rbl_op1_1000_rl_s2_r100k_dp002p0 sn_op1_1000_rl_s2_r100k_dp002p0_1 rwl_des 0 sky130_fd_pr__nfet_01v8 L=0.15 W=0.42 nf=1 ad=0.1218 as=0.1218 pd=1.42 ps=1.42 nrd=0.69047619047619  nrs=0.69047619047619 sa=0 sb=0 sd=0 mult=1 m=1
csn_op1_1000_rl_s2_r100k_dp002p0_1 sn_op1_1000_rl_s2_r100k_dp002p0_1 0 {C_SN}
XMWR_op1_1000_rl_s2_r100k_dp002p0_2 sn_op1_1000_rl_s2_r100k_dp002p0_2 wwl_des wbl_op1_1000_rl_s2_r100k_dp002p0 0 sky130_fd_pr__nfet_01v8 L=0.15 W=0.42 nf=1 ad=0.1218 as=0.1218 pd=1.42 ps=1.42 nrd=0.69047619047619  nrs=0.69047619047619 sa=0 sb=0 sd=0 mult=1 m=1
XMRD_op1_1000_rl_s2_r100k_dp002p0_2 rbl_op1_1000_rl_s2_r100k_dp002p0 sn_op1_1000_rl_s2_r100k_dp002p0_2 rwl_des 0 sky130_fd_pr__nfet_01v8 L=0.15 W=0.42 nf=1 ad=0.1218 as=0.1218 pd=1.42 ps=1.42 nrd=0.69047619047619  nrs=0.69047619047619 sa=0 sb=0 sd=0 mult=1 m=1
csn_op1_1000_rl_s2_r100k_dp002p0_2 sn_op1_1000_rl_s2_r100k_dp002p0_2 0 {C_SN}
XMWR_op1_1000_rl_s2_r100k_dp002p0_3 sn_op1_1000_rl_s2_r100k_dp002p0_3 wwl_des wbl_op1_1000_rl_s2_r100k_dp002p0 0 sky130_fd_pr__nfet_01v8 L=0.15 W=0.42 nf=1 ad=0.1218 as=0.1218 pd=1.42 ps=1.42 nrd=0.69047619047619  nrs=0.69047619047619 sa=0 sb=0 sd=0 mult=1 m=1
XMRD_op1_1000_rl_s2_r100k_dp002p0_3 rbl_op1_1000_rl_s2_r100k_dp002p0 sn_op1_1000_rl_s2_r100k_dp002p0_3 rwl_des 0 sky130_fd_pr__nfet_01v8 L=0.15 W=0.42 nf=1 ad=0.1218 as=0.1218 pd=1.42 ps=1.42 nrd=0.69047619047619  nrs=0.69047619047619 sa=0 sb=0 sd=0 mult=1 m=1
csn_op1_1000_rl_s2_r100k_dp002p0_3 sn_op1_1000_rl_s2_r100k_dp002p0_3 0 {C_SN}
XMN1_op1_1000_rl_s2_r100k_dp002p0 rbl_op1_1000_rl_s2_r100k_dp002p0 ref_op1_1000_rl_s2_r100k_dp002p0 vn_op1_1000_rl_s2_r100k_dp002p0 0 sky130_fd_pr__nfet_01v8 L=0.15 W=1 nf=1 ad=0.29 as=0.29 pd=2.58 ps=2.58 mult=1 m=1
XMN2_op1_1000_rl_s2_r100k_dp002p0 ref_op1_1000_rl_s2_r100k_dp002p0 rbl_op1_1000_rl_s2_r100k_dp002p0 vn_op1_1000_rl_s2_r100k_dp002p0 0 sky130_fd_pr__nfet_01v8 L=0.15 W=1 nf=1 ad=0.29 as=0.29 pd=2.58 ps=2.58 mult=1 m=1
XMP1_op1_1000_rl_s2_r100k_dp002p0 rbl_op1_1000_rl_s2_r100k_dp002p0 ref_op1_1000_rl_s2_r100k_dp002p0 vp_op1_1000_rl_s2_r100k_dp002p0 vdd sky130_fd_pr__pfet_01v8 L=0.15 W=2 nf=1 ad=0.58 as=0.58 pd=4.58 ps=4.58 mult=1 m=1
XMP2_op1_1000_rl_s2_r100k_dp002p0 ref_op1_1000_rl_s2_r100k_dp002p0 rbl_op1_1000_rl_s2_r100k_dp002p0 vp_op1_1000_rl_s2_r100k_dp002p0 vdd sky130_fd_pr__pfet_01v8 L=0.15 W=2 nf=1 ad=0.58 as=0.58 pd=4.58 ps=4.58 mult=1 m=1
XMNF_op1_1000_rl_s2_r100k_dp002p0 vn_op1_1000_rl_s2_r100k_dp002p0 en_op1_1000_rl_s2_r100k_dp002p0 0 0 sky130_fd_pr__nfet_01v8 L=0.15 W=2 nf=1 ad=0.58 as=0.58 pd=4.58 ps=4.58 mult=1 m=1
XMPH_op1_1000_rl_s2_r100k_dp002p0 vp_op1_1000_rl_s2_r100k_dp002p0 enb_op1_1000_rl_s2_r100k_dp002p0 vdd vdd sky130_fd_pr__pfet_01v8 L=0.15 W=4 nf=1 ad=1.16 as=1.16 pd=8.58 ps=8.58 mult=1 m=1
bd_op1_1000_rl_s2_r100k_dp002p0 d_op1_1000_rl_s2_r100k_dp002p0 0 v=v(rbl_op1_1000_rl_s2_r100k_dp002p0)-v(ref_op1_1000_rl_s2_r100k_dp002p0)

* ---- instance 311: op0_n100_rl_s2_r100k_dp002p0 (variant rl_s2_r100k_dp002p0; probe dec 11.9 ns, release 34 ns, meas 36 ns) ----
vctl_op0_n100_rl_s2_r100k_dp002p0 ctl_op0_n100_rl_s2_r100k_dp002p0 0 pwl(0.0000e+00 {VDD} 2.0000e-09 {VDD} 2.1000e-09 0)
* RWL driver model (EXPERIMENTAL): slew 2 ns, series R 100000 ohm; cell pin = rwls_op0_n100_rl_s2_r100k_dp002p0
vrs_op0_n100_rl_s2_r100k_dp002p0 rwlsrc_op0_n100_rl_s2_r100k_dp002p0 0 pwl(0.0000e+00 {VDD} 2.0000e-09 {VDD} 4.0000e-09 0 3.4000e-08 0 3.6000e-08 {VDD})
rdrv_op0_n100_rl_s2_r100k_dp002p0 rwlsrc_op0_n100_rl_s2_r100k_dp002p0 rwls_op0_n100_rl_s2_r100k_dp002p0 100000
ven_op0_n100_rl_s2_r100k_dp002p0 en_op0_n100_rl_s2_r100k_dp002p0 0 pwl(0.0000e+00 0 1.1000e-08 0 1.1100e-08 {VDD} 3.4000e-08 {VDD} 3.4100e-08 0)
venb_op0_n100_rl_s2_r100k_dp002p0 enb_op0_n100_rl_s2_r100k_dp002p0 0 pwl(0.0000e+00 {VDD} 1.1000e-08 {VDD} 1.1100e-08 0 3.4000e-08 0 3.4100e-08 {VDD})
vww_op0_n100_rl_s2_r100k_dp002p0 wwl_op0_n100_rl_s2_r100k_dp002p0 0 pwl(0.0000e+00 0 1.2000e-08 0 1.2100e-08 {VDD} 3.2000e-08 {VDD} 3.2100e-08 0)
vwc_op0_n100_rl_s2_r100k_dp002p0 wbc_op0_n100_rl_s2_r100k_dp002p0 0 pwl(0.0000e+00 0 1.2000e-08 0 1.2100e-08 {VDD} 3.4000e-08 {VDD} 3.4100e-08 0)
swb_op0_n100_rl_s2_r100k_dp002p0 ref_op0_n100_rl_s2_r100k_dp002p0 wbl_op0_n100_rl_s2_r100k_dp002p0 wbc_op0_n100_rl_s2_r100k_dp002p0 0 swwbl
cwbl_op0_n100_rl_s2_r100k_dp002p0 wbl_op0_n100_rl_s2_r100k_dp002p0 0 {C_WBL}
spa_op0_n100_rl_s2_r100k_dp002p0 prea rbl_op0_n100_rl_s2_r100k_dp002p0 ctl_op0_n100_rl_s2_r100k_dp002p0 0 swpre
spr_op0_n100_rl_s2_r100k_dp002p0 pref ref_op0_n100_rl_s2_r100k_dp002p0 ctl_op0_n100_rl_s2_r100k_dp002p0 0 swpre
crbl_op0_n100_rl_s2_r100k_dp002p0 rbl_op0_n100_rl_s2_r100k_dp002p0 0 {C_RBL}
cref_op0_n100_rl_s2_r100k_dp002p0 ref_op0_n100_rl_s2_r100k_dp002p0 0 {C_RBL}   $ ASSUMPTION: ideal matched dummy load
XMWR_op0_n100_rl_s2_r100k_dp002p0_0 sn_op0_n100_rl_s2_r100k_dp002p0_0 wwl_op0_n100_rl_s2_r100k_dp002p0 wbl_op0_n100_rl_s2_r100k_dp002p0 0 sky130_fd_pr__nfet_01v8 L=0.15 W=0.42 nf=1 ad=0.1218 as=0.1218 pd=1.42 ps=1.42 nrd=0.69047619047619  nrs=0.69047619047619 sa=0 sb=0 sd=0 mult=1 m=1
XMRD_op0_n100_rl_s2_r100k_dp002p0_0 rbl_op0_n100_rl_s2_r100k_dp002p0 sn_op0_n100_rl_s2_r100k_dp002p0_0 rwls_op0_n100_rl_s2_r100k_dp002p0 0 sky130_fd_pr__nfet_01v8 L=0.15 W=0.42 nf=1 ad=0.1218 as=0.1218 pd=1.42 ps=1.42 nrd=0.69047619047619  nrs=0.69047619047619 sa=0 sb=0 sd=0 mult=1 m=1
csn_op0_n100_rl_s2_r100k_dp002p0_0 sn_op0_n100_rl_s2_r100k_dp002p0_0 0 {C_SN}
XMWR_op0_n100_rl_s2_r100k_dp002p0_1 sn_op0_n100_rl_s2_r100k_dp002p0_1 wwl_des wbl_op0_n100_rl_s2_r100k_dp002p0 0 sky130_fd_pr__nfet_01v8 L=0.15 W=0.42 nf=1 ad=0.1218 as=0.1218 pd=1.42 ps=1.42 nrd=0.69047619047619  nrs=0.69047619047619 sa=0 sb=0 sd=0 mult=1 m=1
XMRD_op0_n100_rl_s2_r100k_dp002p0_1 rbl_op0_n100_rl_s2_r100k_dp002p0 sn_op0_n100_rl_s2_r100k_dp002p0_1 rwl_des 0 sky130_fd_pr__nfet_01v8 L=0.15 W=0.42 nf=1 ad=0.1218 as=0.1218 pd=1.42 ps=1.42 nrd=0.69047619047619  nrs=0.69047619047619 sa=0 sb=0 sd=0 mult=1 m=1
csn_op0_n100_rl_s2_r100k_dp002p0_1 sn_op0_n100_rl_s2_r100k_dp002p0_1 0 {C_SN}
XMWR_op0_n100_rl_s2_r100k_dp002p0_2 sn_op0_n100_rl_s2_r100k_dp002p0_2 wwl_des wbl_op0_n100_rl_s2_r100k_dp002p0 0 sky130_fd_pr__nfet_01v8 L=0.15 W=0.42 nf=1 ad=0.1218 as=0.1218 pd=1.42 ps=1.42 nrd=0.69047619047619  nrs=0.69047619047619 sa=0 sb=0 sd=0 mult=1 m=1
XMRD_op0_n100_rl_s2_r100k_dp002p0_2 rbl_op0_n100_rl_s2_r100k_dp002p0 sn_op0_n100_rl_s2_r100k_dp002p0_2 rwl_des 0 sky130_fd_pr__nfet_01v8 L=0.15 W=0.42 nf=1 ad=0.1218 as=0.1218 pd=1.42 ps=1.42 nrd=0.69047619047619  nrs=0.69047619047619 sa=0 sb=0 sd=0 mult=1 m=1
csn_op0_n100_rl_s2_r100k_dp002p0_2 sn_op0_n100_rl_s2_r100k_dp002p0_2 0 {C_SN}
XMWR_op0_n100_rl_s2_r100k_dp002p0_3 sn_op0_n100_rl_s2_r100k_dp002p0_3 wwl_des wbl_op0_n100_rl_s2_r100k_dp002p0 0 sky130_fd_pr__nfet_01v8 L=0.15 W=0.42 nf=1 ad=0.1218 as=0.1218 pd=1.42 ps=1.42 nrd=0.69047619047619  nrs=0.69047619047619 sa=0 sb=0 sd=0 mult=1 m=1
XMRD_op0_n100_rl_s2_r100k_dp002p0_3 rbl_op0_n100_rl_s2_r100k_dp002p0 sn_op0_n100_rl_s2_r100k_dp002p0_3 rwl_des 0 sky130_fd_pr__nfet_01v8 L=0.15 W=0.42 nf=1 ad=0.1218 as=0.1218 pd=1.42 ps=1.42 nrd=0.69047619047619  nrs=0.69047619047619 sa=0 sb=0 sd=0 mult=1 m=1
csn_op0_n100_rl_s2_r100k_dp002p0_3 sn_op0_n100_rl_s2_r100k_dp002p0_3 0 {C_SN}
XMN1_op0_n100_rl_s2_r100k_dp002p0 rbl_op0_n100_rl_s2_r100k_dp002p0 ref_op0_n100_rl_s2_r100k_dp002p0 vn_op0_n100_rl_s2_r100k_dp002p0 0 sky130_fd_pr__nfet_01v8 L=0.15 W=1 nf=1 ad=0.29 as=0.29 pd=2.58 ps=2.58 mult=1 m=1
XMN2_op0_n100_rl_s2_r100k_dp002p0 ref_op0_n100_rl_s2_r100k_dp002p0 rbl_op0_n100_rl_s2_r100k_dp002p0 vn_op0_n100_rl_s2_r100k_dp002p0 0 sky130_fd_pr__nfet_01v8 L=0.15 W=1 nf=1 ad=0.29 as=0.29 pd=2.58 ps=2.58 mult=1 m=1
XMP1_op0_n100_rl_s2_r100k_dp002p0 rbl_op0_n100_rl_s2_r100k_dp002p0 ref_op0_n100_rl_s2_r100k_dp002p0 vp_op0_n100_rl_s2_r100k_dp002p0 vdd sky130_fd_pr__pfet_01v8 L=0.15 W=2 nf=1 ad=0.58 as=0.58 pd=4.58 ps=4.58 mult=1 m=1
XMP2_op0_n100_rl_s2_r100k_dp002p0 ref_op0_n100_rl_s2_r100k_dp002p0 rbl_op0_n100_rl_s2_r100k_dp002p0 vp_op0_n100_rl_s2_r100k_dp002p0 vdd sky130_fd_pr__pfet_01v8 L=0.15 W=2 nf=1 ad=0.58 as=0.58 pd=4.58 ps=4.58 mult=1 m=1
XMNF_op0_n100_rl_s2_r100k_dp002p0 vn_op0_n100_rl_s2_r100k_dp002p0 en_op0_n100_rl_s2_r100k_dp002p0 0 0 sky130_fd_pr__nfet_01v8 L=0.15 W=2 nf=1 ad=0.58 as=0.58 pd=4.58 ps=4.58 mult=1 m=1
XMPH_op0_n100_rl_s2_r100k_dp002p0 vp_op0_n100_rl_s2_r100k_dp002p0 enb_op0_n100_rl_s2_r100k_dp002p0 vdd vdd sky130_fd_pr__pfet_01v8 L=0.15 W=4 nf=1 ad=1.16 as=1.16 pd=8.58 ps=8.58 mult=1 m=1
bd_op0_n100_rl_s2_r100k_dp002p0 d_op0_n100_rl_s2_r100k_dp002p0 0 v=v(rbl_op0_n100_rl_s2_r100k_dp002p0)-v(ref_op0_n100_rl_s2_r100k_dp002p0)

* ---- instance 312: op0_0000_rl_s2_r100k_dp002p0 (variant rl_s2_r100k_dp002p0; probe dec 11.9 ns, release 34 ns, meas 36 ns) ----
vctl_op0_0000_rl_s2_r100k_dp002p0 ctl_op0_0000_rl_s2_r100k_dp002p0 0 pwl(0.0000e+00 {VDD} 2.0000e-09 {VDD} 2.1000e-09 0)
* RWL driver model (EXPERIMENTAL): slew 2 ns, series R 100000 ohm; cell pin = rwls_op0_0000_rl_s2_r100k_dp002p0
vrs_op0_0000_rl_s2_r100k_dp002p0 rwlsrc_op0_0000_rl_s2_r100k_dp002p0 0 pwl(0.0000e+00 {VDD} 2.0000e-09 {VDD} 4.0000e-09 0 3.4000e-08 0 3.6000e-08 {VDD})
rdrv_op0_0000_rl_s2_r100k_dp002p0 rwlsrc_op0_0000_rl_s2_r100k_dp002p0 rwls_op0_0000_rl_s2_r100k_dp002p0 100000
ven_op0_0000_rl_s2_r100k_dp002p0 en_op0_0000_rl_s2_r100k_dp002p0 0 pwl(0.0000e+00 0 1.1000e-08 0 1.1100e-08 {VDD} 3.4000e-08 {VDD} 3.4100e-08 0)
venb_op0_0000_rl_s2_r100k_dp002p0 enb_op0_0000_rl_s2_r100k_dp002p0 0 pwl(0.0000e+00 {VDD} 1.1000e-08 {VDD} 1.1100e-08 0 3.4000e-08 0 3.4100e-08 {VDD})
vww_op0_0000_rl_s2_r100k_dp002p0 wwl_op0_0000_rl_s2_r100k_dp002p0 0 pwl(0.0000e+00 0 1.2000e-08 0 1.2100e-08 {VDD} 3.2000e-08 {VDD} 3.2100e-08 0)
vwc_op0_0000_rl_s2_r100k_dp002p0 wbc_op0_0000_rl_s2_r100k_dp002p0 0 pwl(0.0000e+00 0 1.2000e-08 0 1.2100e-08 {VDD} 3.4000e-08 {VDD} 3.4100e-08 0)
swb_op0_0000_rl_s2_r100k_dp002p0 ref_op0_0000_rl_s2_r100k_dp002p0 wbl_op0_0000_rl_s2_r100k_dp002p0 wbc_op0_0000_rl_s2_r100k_dp002p0 0 swwbl
cwbl_op0_0000_rl_s2_r100k_dp002p0 wbl_op0_0000_rl_s2_r100k_dp002p0 0 {C_WBL}
spa_op0_0000_rl_s2_r100k_dp002p0 prea rbl_op0_0000_rl_s2_r100k_dp002p0 ctl_op0_0000_rl_s2_r100k_dp002p0 0 swpre
spr_op0_0000_rl_s2_r100k_dp002p0 pref ref_op0_0000_rl_s2_r100k_dp002p0 ctl_op0_0000_rl_s2_r100k_dp002p0 0 swpre
crbl_op0_0000_rl_s2_r100k_dp002p0 rbl_op0_0000_rl_s2_r100k_dp002p0 0 {C_RBL}
cref_op0_0000_rl_s2_r100k_dp002p0 ref_op0_0000_rl_s2_r100k_dp002p0 0 {C_RBL}   $ ASSUMPTION: ideal matched dummy load
XMWR_op0_0000_rl_s2_r100k_dp002p0_0 sn_op0_0000_rl_s2_r100k_dp002p0_0 wwl_op0_0000_rl_s2_r100k_dp002p0 wbl_op0_0000_rl_s2_r100k_dp002p0 0 sky130_fd_pr__nfet_01v8 L=0.15 W=0.42 nf=1 ad=0.1218 as=0.1218 pd=1.42 ps=1.42 nrd=0.69047619047619  nrs=0.69047619047619 sa=0 sb=0 sd=0 mult=1 m=1
XMRD_op0_0000_rl_s2_r100k_dp002p0_0 rbl_op0_0000_rl_s2_r100k_dp002p0 sn_op0_0000_rl_s2_r100k_dp002p0_0 rwls_op0_0000_rl_s2_r100k_dp002p0 0 sky130_fd_pr__nfet_01v8 L=0.15 W=0.42 nf=1 ad=0.1218 as=0.1218 pd=1.42 ps=1.42 nrd=0.69047619047619  nrs=0.69047619047619 sa=0 sb=0 sd=0 mult=1 m=1
csn_op0_0000_rl_s2_r100k_dp002p0_0 sn_op0_0000_rl_s2_r100k_dp002p0_0 0 {C_SN}
XMWR_op0_0000_rl_s2_r100k_dp002p0_1 sn_op0_0000_rl_s2_r100k_dp002p0_1 wwl_des wbl_op0_0000_rl_s2_r100k_dp002p0 0 sky130_fd_pr__nfet_01v8 L=0.15 W=0.42 nf=1 ad=0.1218 as=0.1218 pd=1.42 ps=1.42 nrd=0.69047619047619  nrs=0.69047619047619 sa=0 sb=0 sd=0 mult=1 m=1
XMRD_op0_0000_rl_s2_r100k_dp002p0_1 rbl_op0_0000_rl_s2_r100k_dp002p0 sn_op0_0000_rl_s2_r100k_dp002p0_1 rwl_des 0 sky130_fd_pr__nfet_01v8 L=0.15 W=0.42 nf=1 ad=0.1218 as=0.1218 pd=1.42 ps=1.42 nrd=0.69047619047619  nrs=0.69047619047619 sa=0 sb=0 sd=0 mult=1 m=1
csn_op0_0000_rl_s2_r100k_dp002p0_1 sn_op0_0000_rl_s2_r100k_dp002p0_1 0 {C_SN}
XMWR_op0_0000_rl_s2_r100k_dp002p0_2 sn_op0_0000_rl_s2_r100k_dp002p0_2 wwl_des wbl_op0_0000_rl_s2_r100k_dp002p0 0 sky130_fd_pr__nfet_01v8 L=0.15 W=0.42 nf=1 ad=0.1218 as=0.1218 pd=1.42 ps=1.42 nrd=0.69047619047619  nrs=0.69047619047619 sa=0 sb=0 sd=0 mult=1 m=1
XMRD_op0_0000_rl_s2_r100k_dp002p0_2 rbl_op0_0000_rl_s2_r100k_dp002p0 sn_op0_0000_rl_s2_r100k_dp002p0_2 rwl_des 0 sky130_fd_pr__nfet_01v8 L=0.15 W=0.42 nf=1 ad=0.1218 as=0.1218 pd=1.42 ps=1.42 nrd=0.69047619047619  nrs=0.69047619047619 sa=0 sb=0 sd=0 mult=1 m=1
csn_op0_0000_rl_s2_r100k_dp002p0_2 sn_op0_0000_rl_s2_r100k_dp002p0_2 0 {C_SN}
XMWR_op0_0000_rl_s2_r100k_dp002p0_3 sn_op0_0000_rl_s2_r100k_dp002p0_3 wwl_des wbl_op0_0000_rl_s2_r100k_dp002p0 0 sky130_fd_pr__nfet_01v8 L=0.15 W=0.42 nf=1 ad=0.1218 as=0.1218 pd=1.42 ps=1.42 nrd=0.69047619047619  nrs=0.69047619047619 sa=0 sb=0 sd=0 mult=1 m=1
XMRD_op0_0000_rl_s2_r100k_dp002p0_3 rbl_op0_0000_rl_s2_r100k_dp002p0 sn_op0_0000_rl_s2_r100k_dp002p0_3 rwl_des 0 sky130_fd_pr__nfet_01v8 L=0.15 W=0.42 nf=1 ad=0.1218 as=0.1218 pd=1.42 ps=1.42 nrd=0.69047619047619  nrs=0.69047619047619 sa=0 sb=0 sd=0 mult=1 m=1
csn_op0_0000_rl_s2_r100k_dp002p0_3 sn_op0_0000_rl_s2_r100k_dp002p0_3 0 {C_SN}
XMN1_op0_0000_rl_s2_r100k_dp002p0 rbl_op0_0000_rl_s2_r100k_dp002p0 ref_op0_0000_rl_s2_r100k_dp002p0 vn_op0_0000_rl_s2_r100k_dp002p0 0 sky130_fd_pr__nfet_01v8 L=0.15 W=1 nf=1 ad=0.29 as=0.29 pd=2.58 ps=2.58 mult=1 m=1
XMN2_op0_0000_rl_s2_r100k_dp002p0 ref_op0_0000_rl_s2_r100k_dp002p0 rbl_op0_0000_rl_s2_r100k_dp002p0 vn_op0_0000_rl_s2_r100k_dp002p0 0 sky130_fd_pr__nfet_01v8 L=0.15 W=1 nf=1 ad=0.29 as=0.29 pd=2.58 ps=2.58 mult=1 m=1
XMP1_op0_0000_rl_s2_r100k_dp002p0 rbl_op0_0000_rl_s2_r100k_dp002p0 ref_op0_0000_rl_s2_r100k_dp002p0 vp_op0_0000_rl_s2_r100k_dp002p0 vdd sky130_fd_pr__pfet_01v8 L=0.15 W=2 nf=1 ad=0.58 as=0.58 pd=4.58 ps=4.58 mult=1 m=1
XMP2_op0_0000_rl_s2_r100k_dp002p0 ref_op0_0000_rl_s2_r100k_dp002p0 rbl_op0_0000_rl_s2_r100k_dp002p0 vp_op0_0000_rl_s2_r100k_dp002p0 vdd sky130_fd_pr__pfet_01v8 L=0.15 W=2 nf=1 ad=0.58 as=0.58 pd=4.58 ps=4.58 mult=1 m=1
XMNF_op0_0000_rl_s2_r100k_dp002p0 vn_op0_0000_rl_s2_r100k_dp002p0 en_op0_0000_rl_s2_r100k_dp002p0 0 0 sky130_fd_pr__nfet_01v8 L=0.15 W=2 nf=1 ad=0.58 as=0.58 pd=4.58 ps=4.58 mult=1 m=1
XMPH_op0_0000_rl_s2_r100k_dp002p0 vp_op0_0000_rl_s2_r100k_dp002p0 enb_op0_0000_rl_s2_r100k_dp002p0 vdd vdd sky130_fd_pr__pfet_01v8 L=0.15 W=4 nf=1 ad=1.16 as=1.16 pd=8.58 ps=8.58 mult=1 m=1
bd_op0_0000_rl_s2_r100k_dp002p0 d_op0_0000_rl_s2_r100k_dp002p0 0 v=v(rbl_op0_0000_rl_s2_r100k_dp002p0)-v(ref_op0_0000_rl_s2_r100k_dp002p0)

* ---- instance 313: op1_0900_rl_s2_r100k_dp003p0 (variant rl_s2_r100k_dp003p0; probe dec 11.9 ns, release 35 ns, meas 36 ns) ----
vctl_op1_0900_rl_s2_r100k_dp003p0 ctl_op1_0900_rl_s2_r100k_dp003p0 0 pwl(0.0000e+00 {VDD} 2.0000e-09 {VDD} 2.1000e-09 0)
* RWL driver model (EXPERIMENTAL): slew 2 ns, series R 100000 ohm; cell pin = rwls_op1_0900_rl_s2_r100k_dp003p0
vrs_op1_0900_rl_s2_r100k_dp003p0 rwlsrc_op1_0900_rl_s2_r100k_dp003p0 0 pwl(0.0000e+00 {VDD} 2.0000e-09 {VDD} 4.0000e-09 0 3.5000e-08 0 3.7000e-08 {VDD})
rdrv_op1_0900_rl_s2_r100k_dp003p0 rwlsrc_op1_0900_rl_s2_r100k_dp003p0 rwls_op1_0900_rl_s2_r100k_dp003p0 100000
ven_op1_0900_rl_s2_r100k_dp003p0 en_op1_0900_rl_s2_r100k_dp003p0 0 pwl(0.0000e+00 0 1.1000e-08 0 1.1100e-08 {VDD} 3.4000e-08 {VDD} 3.4100e-08 0)
venb_op1_0900_rl_s2_r100k_dp003p0 enb_op1_0900_rl_s2_r100k_dp003p0 0 pwl(0.0000e+00 {VDD} 1.1000e-08 {VDD} 1.1100e-08 0 3.4000e-08 0 3.4100e-08 {VDD})
vww_op1_0900_rl_s2_r100k_dp003p0 wwl_op1_0900_rl_s2_r100k_dp003p0 0 pwl(0.0000e+00 0 1.2000e-08 0 1.2100e-08 {VDD} 3.2000e-08 {VDD} 3.2100e-08 0)
vwc_op1_0900_rl_s2_r100k_dp003p0 wbc_op1_0900_rl_s2_r100k_dp003p0 0 pwl(0.0000e+00 0 1.2000e-08 0 1.2100e-08 {VDD} 3.4000e-08 {VDD} 3.4100e-08 0)
swb_op1_0900_rl_s2_r100k_dp003p0 ref_op1_0900_rl_s2_r100k_dp003p0 wbl_op1_0900_rl_s2_r100k_dp003p0 wbc_op1_0900_rl_s2_r100k_dp003p0 0 swwbl
cwbl_op1_0900_rl_s2_r100k_dp003p0 wbl_op1_0900_rl_s2_r100k_dp003p0 0 {C_WBL}
spa_op1_0900_rl_s2_r100k_dp003p0 prea rbl_op1_0900_rl_s2_r100k_dp003p0 ctl_op1_0900_rl_s2_r100k_dp003p0 0 swpre
spr_op1_0900_rl_s2_r100k_dp003p0 pref ref_op1_0900_rl_s2_r100k_dp003p0 ctl_op1_0900_rl_s2_r100k_dp003p0 0 swpre
crbl_op1_0900_rl_s2_r100k_dp003p0 rbl_op1_0900_rl_s2_r100k_dp003p0 0 {C_RBL}
cref_op1_0900_rl_s2_r100k_dp003p0 ref_op1_0900_rl_s2_r100k_dp003p0 0 {C_RBL}   $ ASSUMPTION: ideal matched dummy load
XMWR_op1_0900_rl_s2_r100k_dp003p0_0 sn_op1_0900_rl_s2_r100k_dp003p0_0 wwl_op1_0900_rl_s2_r100k_dp003p0 wbl_op1_0900_rl_s2_r100k_dp003p0 0 sky130_fd_pr__nfet_01v8 L=0.15 W=0.42 nf=1 ad=0.1218 as=0.1218 pd=1.42 ps=1.42 nrd=0.69047619047619  nrs=0.69047619047619 sa=0 sb=0 sd=0 mult=1 m=1
XMRD_op1_0900_rl_s2_r100k_dp003p0_0 rbl_op1_0900_rl_s2_r100k_dp003p0 sn_op1_0900_rl_s2_r100k_dp003p0_0 rwls_op1_0900_rl_s2_r100k_dp003p0 0 sky130_fd_pr__nfet_01v8 L=0.15 W=0.42 nf=1 ad=0.1218 as=0.1218 pd=1.42 ps=1.42 nrd=0.69047619047619  nrs=0.69047619047619 sa=0 sb=0 sd=0 mult=1 m=1
csn_op1_0900_rl_s2_r100k_dp003p0_0 sn_op1_0900_rl_s2_r100k_dp003p0_0 0 {C_SN}
XMWR_op1_0900_rl_s2_r100k_dp003p0_1 sn_op1_0900_rl_s2_r100k_dp003p0_1 wwl_des wbl_op1_0900_rl_s2_r100k_dp003p0 0 sky130_fd_pr__nfet_01v8 L=0.15 W=0.42 nf=1 ad=0.1218 as=0.1218 pd=1.42 ps=1.42 nrd=0.69047619047619  nrs=0.69047619047619 sa=0 sb=0 sd=0 mult=1 m=1
XMRD_op1_0900_rl_s2_r100k_dp003p0_1 rbl_op1_0900_rl_s2_r100k_dp003p0 sn_op1_0900_rl_s2_r100k_dp003p0_1 rwl_des 0 sky130_fd_pr__nfet_01v8 L=0.15 W=0.42 nf=1 ad=0.1218 as=0.1218 pd=1.42 ps=1.42 nrd=0.69047619047619  nrs=0.69047619047619 sa=0 sb=0 sd=0 mult=1 m=1
csn_op1_0900_rl_s2_r100k_dp003p0_1 sn_op1_0900_rl_s2_r100k_dp003p0_1 0 {C_SN}
XMWR_op1_0900_rl_s2_r100k_dp003p0_2 sn_op1_0900_rl_s2_r100k_dp003p0_2 wwl_des wbl_op1_0900_rl_s2_r100k_dp003p0 0 sky130_fd_pr__nfet_01v8 L=0.15 W=0.42 nf=1 ad=0.1218 as=0.1218 pd=1.42 ps=1.42 nrd=0.69047619047619  nrs=0.69047619047619 sa=0 sb=0 sd=0 mult=1 m=1
XMRD_op1_0900_rl_s2_r100k_dp003p0_2 rbl_op1_0900_rl_s2_r100k_dp003p0 sn_op1_0900_rl_s2_r100k_dp003p0_2 rwl_des 0 sky130_fd_pr__nfet_01v8 L=0.15 W=0.42 nf=1 ad=0.1218 as=0.1218 pd=1.42 ps=1.42 nrd=0.69047619047619  nrs=0.69047619047619 sa=0 sb=0 sd=0 mult=1 m=1
csn_op1_0900_rl_s2_r100k_dp003p0_2 sn_op1_0900_rl_s2_r100k_dp003p0_2 0 {C_SN}
XMWR_op1_0900_rl_s2_r100k_dp003p0_3 sn_op1_0900_rl_s2_r100k_dp003p0_3 wwl_des wbl_op1_0900_rl_s2_r100k_dp003p0 0 sky130_fd_pr__nfet_01v8 L=0.15 W=0.42 nf=1 ad=0.1218 as=0.1218 pd=1.42 ps=1.42 nrd=0.69047619047619  nrs=0.69047619047619 sa=0 sb=0 sd=0 mult=1 m=1
XMRD_op1_0900_rl_s2_r100k_dp003p0_3 rbl_op1_0900_rl_s2_r100k_dp003p0 sn_op1_0900_rl_s2_r100k_dp003p0_3 rwl_des 0 sky130_fd_pr__nfet_01v8 L=0.15 W=0.42 nf=1 ad=0.1218 as=0.1218 pd=1.42 ps=1.42 nrd=0.69047619047619  nrs=0.69047619047619 sa=0 sb=0 sd=0 mult=1 m=1
csn_op1_0900_rl_s2_r100k_dp003p0_3 sn_op1_0900_rl_s2_r100k_dp003p0_3 0 {C_SN}
XMN1_op1_0900_rl_s2_r100k_dp003p0 rbl_op1_0900_rl_s2_r100k_dp003p0 ref_op1_0900_rl_s2_r100k_dp003p0 vn_op1_0900_rl_s2_r100k_dp003p0 0 sky130_fd_pr__nfet_01v8 L=0.15 W=1 nf=1 ad=0.29 as=0.29 pd=2.58 ps=2.58 mult=1 m=1
XMN2_op1_0900_rl_s2_r100k_dp003p0 ref_op1_0900_rl_s2_r100k_dp003p0 rbl_op1_0900_rl_s2_r100k_dp003p0 vn_op1_0900_rl_s2_r100k_dp003p0 0 sky130_fd_pr__nfet_01v8 L=0.15 W=1 nf=1 ad=0.29 as=0.29 pd=2.58 ps=2.58 mult=1 m=1
XMP1_op1_0900_rl_s2_r100k_dp003p0 rbl_op1_0900_rl_s2_r100k_dp003p0 ref_op1_0900_rl_s2_r100k_dp003p0 vp_op1_0900_rl_s2_r100k_dp003p0 vdd sky130_fd_pr__pfet_01v8 L=0.15 W=2 nf=1 ad=0.58 as=0.58 pd=4.58 ps=4.58 mult=1 m=1
XMP2_op1_0900_rl_s2_r100k_dp003p0 ref_op1_0900_rl_s2_r100k_dp003p0 rbl_op1_0900_rl_s2_r100k_dp003p0 vp_op1_0900_rl_s2_r100k_dp003p0 vdd sky130_fd_pr__pfet_01v8 L=0.15 W=2 nf=1 ad=0.58 as=0.58 pd=4.58 ps=4.58 mult=1 m=1
XMNF_op1_0900_rl_s2_r100k_dp003p0 vn_op1_0900_rl_s2_r100k_dp003p0 en_op1_0900_rl_s2_r100k_dp003p0 0 0 sky130_fd_pr__nfet_01v8 L=0.15 W=2 nf=1 ad=0.58 as=0.58 pd=4.58 ps=4.58 mult=1 m=1
XMPH_op1_0900_rl_s2_r100k_dp003p0 vp_op1_0900_rl_s2_r100k_dp003p0 enb_op1_0900_rl_s2_r100k_dp003p0 vdd vdd sky130_fd_pr__pfet_01v8 L=0.15 W=4 nf=1 ad=1.16 as=1.16 pd=8.58 ps=8.58 mult=1 m=1
bd_op1_0900_rl_s2_r100k_dp003p0 d_op1_0900_rl_s2_r100k_dp003p0 0 v=v(rbl_op1_0900_rl_s2_r100k_dp003p0)-v(ref_op1_0900_rl_s2_r100k_dp003p0)

* ---- instance 314: op1_1000_rl_s2_r100k_dp003p0 (variant rl_s2_r100k_dp003p0; probe dec 11.9 ns, release 35 ns, meas 36 ns) ----
vctl_op1_1000_rl_s2_r100k_dp003p0 ctl_op1_1000_rl_s2_r100k_dp003p0 0 pwl(0.0000e+00 {VDD} 2.0000e-09 {VDD} 2.1000e-09 0)
* RWL driver model (EXPERIMENTAL): slew 2 ns, series R 100000 ohm; cell pin = rwls_op1_1000_rl_s2_r100k_dp003p0
vrs_op1_1000_rl_s2_r100k_dp003p0 rwlsrc_op1_1000_rl_s2_r100k_dp003p0 0 pwl(0.0000e+00 {VDD} 2.0000e-09 {VDD} 4.0000e-09 0 3.5000e-08 0 3.7000e-08 {VDD})
rdrv_op1_1000_rl_s2_r100k_dp003p0 rwlsrc_op1_1000_rl_s2_r100k_dp003p0 rwls_op1_1000_rl_s2_r100k_dp003p0 100000
ven_op1_1000_rl_s2_r100k_dp003p0 en_op1_1000_rl_s2_r100k_dp003p0 0 pwl(0.0000e+00 0 1.1000e-08 0 1.1100e-08 {VDD} 3.4000e-08 {VDD} 3.4100e-08 0)
venb_op1_1000_rl_s2_r100k_dp003p0 enb_op1_1000_rl_s2_r100k_dp003p0 0 pwl(0.0000e+00 {VDD} 1.1000e-08 {VDD} 1.1100e-08 0 3.4000e-08 0 3.4100e-08 {VDD})
vww_op1_1000_rl_s2_r100k_dp003p0 wwl_op1_1000_rl_s2_r100k_dp003p0 0 pwl(0.0000e+00 0 1.2000e-08 0 1.2100e-08 {VDD} 3.2000e-08 {VDD} 3.2100e-08 0)
vwc_op1_1000_rl_s2_r100k_dp003p0 wbc_op1_1000_rl_s2_r100k_dp003p0 0 pwl(0.0000e+00 0 1.2000e-08 0 1.2100e-08 {VDD} 3.4000e-08 {VDD} 3.4100e-08 0)
swb_op1_1000_rl_s2_r100k_dp003p0 ref_op1_1000_rl_s2_r100k_dp003p0 wbl_op1_1000_rl_s2_r100k_dp003p0 wbc_op1_1000_rl_s2_r100k_dp003p0 0 swwbl
cwbl_op1_1000_rl_s2_r100k_dp003p0 wbl_op1_1000_rl_s2_r100k_dp003p0 0 {C_WBL}
spa_op1_1000_rl_s2_r100k_dp003p0 prea rbl_op1_1000_rl_s2_r100k_dp003p0 ctl_op1_1000_rl_s2_r100k_dp003p0 0 swpre
spr_op1_1000_rl_s2_r100k_dp003p0 pref ref_op1_1000_rl_s2_r100k_dp003p0 ctl_op1_1000_rl_s2_r100k_dp003p0 0 swpre
crbl_op1_1000_rl_s2_r100k_dp003p0 rbl_op1_1000_rl_s2_r100k_dp003p0 0 {C_RBL}
cref_op1_1000_rl_s2_r100k_dp003p0 ref_op1_1000_rl_s2_r100k_dp003p0 0 {C_RBL}   $ ASSUMPTION: ideal matched dummy load
XMWR_op1_1000_rl_s2_r100k_dp003p0_0 sn_op1_1000_rl_s2_r100k_dp003p0_0 wwl_op1_1000_rl_s2_r100k_dp003p0 wbl_op1_1000_rl_s2_r100k_dp003p0 0 sky130_fd_pr__nfet_01v8 L=0.15 W=0.42 nf=1 ad=0.1218 as=0.1218 pd=1.42 ps=1.42 nrd=0.69047619047619  nrs=0.69047619047619 sa=0 sb=0 sd=0 mult=1 m=1
XMRD_op1_1000_rl_s2_r100k_dp003p0_0 rbl_op1_1000_rl_s2_r100k_dp003p0 sn_op1_1000_rl_s2_r100k_dp003p0_0 rwls_op1_1000_rl_s2_r100k_dp003p0 0 sky130_fd_pr__nfet_01v8 L=0.15 W=0.42 nf=1 ad=0.1218 as=0.1218 pd=1.42 ps=1.42 nrd=0.69047619047619  nrs=0.69047619047619 sa=0 sb=0 sd=0 mult=1 m=1
csn_op1_1000_rl_s2_r100k_dp003p0_0 sn_op1_1000_rl_s2_r100k_dp003p0_0 0 {C_SN}
XMWR_op1_1000_rl_s2_r100k_dp003p0_1 sn_op1_1000_rl_s2_r100k_dp003p0_1 wwl_des wbl_op1_1000_rl_s2_r100k_dp003p0 0 sky130_fd_pr__nfet_01v8 L=0.15 W=0.42 nf=1 ad=0.1218 as=0.1218 pd=1.42 ps=1.42 nrd=0.69047619047619  nrs=0.69047619047619 sa=0 sb=0 sd=0 mult=1 m=1
XMRD_op1_1000_rl_s2_r100k_dp003p0_1 rbl_op1_1000_rl_s2_r100k_dp003p0 sn_op1_1000_rl_s2_r100k_dp003p0_1 rwl_des 0 sky130_fd_pr__nfet_01v8 L=0.15 W=0.42 nf=1 ad=0.1218 as=0.1218 pd=1.42 ps=1.42 nrd=0.69047619047619  nrs=0.69047619047619 sa=0 sb=0 sd=0 mult=1 m=1
csn_op1_1000_rl_s2_r100k_dp003p0_1 sn_op1_1000_rl_s2_r100k_dp003p0_1 0 {C_SN}
XMWR_op1_1000_rl_s2_r100k_dp003p0_2 sn_op1_1000_rl_s2_r100k_dp003p0_2 wwl_des wbl_op1_1000_rl_s2_r100k_dp003p0 0 sky130_fd_pr__nfet_01v8 L=0.15 W=0.42 nf=1 ad=0.1218 as=0.1218 pd=1.42 ps=1.42 nrd=0.69047619047619  nrs=0.69047619047619 sa=0 sb=0 sd=0 mult=1 m=1
XMRD_op1_1000_rl_s2_r100k_dp003p0_2 rbl_op1_1000_rl_s2_r100k_dp003p0 sn_op1_1000_rl_s2_r100k_dp003p0_2 rwl_des 0 sky130_fd_pr__nfet_01v8 L=0.15 W=0.42 nf=1 ad=0.1218 as=0.1218 pd=1.42 ps=1.42 nrd=0.69047619047619  nrs=0.69047619047619 sa=0 sb=0 sd=0 mult=1 m=1
csn_op1_1000_rl_s2_r100k_dp003p0_2 sn_op1_1000_rl_s2_r100k_dp003p0_2 0 {C_SN}
XMWR_op1_1000_rl_s2_r100k_dp003p0_3 sn_op1_1000_rl_s2_r100k_dp003p0_3 wwl_des wbl_op1_1000_rl_s2_r100k_dp003p0 0 sky130_fd_pr__nfet_01v8 L=0.15 W=0.42 nf=1 ad=0.1218 as=0.1218 pd=1.42 ps=1.42 nrd=0.69047619047619  nrs=0.69047619047619 sa=0 sb=0 sd=0 mult=1 m=1
XMRD_op1_1000_rl_s2_r100k_dp003p0_3 rbl_op1_1000_rl_s2_r100k_dp003p0 sn_op1_1000_rl_s2_r100k_dp003p0_3 rwl_des 0 sky130_fd_pr__nfet_01v8 L=0.15 W=0.42 nf=1 ad=0.1218 as=0.1218 pd=1.42 ps=1.42 nrd=0.69047619047619  nrs=0.69047619047619 sa=0 sb=0 sd=0 mult=1 m=1
csn_op1_1000_rl_s2_r100k_dp003p0_3 sn_op1_1000_rl_s2_r100k_dp003p0_3 0 {C_SN}
XMN1_op1_1000_rl_s2_r100k_dp003p0 rbl_op1_1000_rl_s2_r100k_dp003p0 ref_op1_1000_rl_s2_r100k_dp003p0 vn_op1_1000_rl_s2_r100k_dp003p0 0 sky130_fd_pr__nfet_01v8 L=0.15 W=1 nf=1 ad=0.29 as=0.29 pd=2.58 ps=2.58 mult=1 m=1
XMN2_op1_1000_rl_s2_r100k_dp003p0 ref_op1_1000_rl_s2_r100k_dp003p0 rbl_op1_1000_rl_s2_r100k_dp003p0 vn_op1_1000_rl_s2_r100k_dp003p0 0 sky130_fd_pr__nfet_01v8 L=0.15 W=1 nf=1 ad=0.29 as=0.29 pd=2.58 ps=2.58 mult=1 m=1
XMP1_op1_1000_rl_s2_r100k_dp003p0 rbl_op1_1000_rl_s2_r100k_dp003p0 ref_op1_1000_rl_s2_r100k_dp003p0 vp_op1_1000_rl_s2_r100k_dp003p0 vdd sky130_fd_pr__pfet_01v8 L=0.15 W=2 nf=1 ad=0.58 as=0.58 pd=4.58 ps=4.58 mult=1 m=1
XMP2_op1_1000_rl_s2_r100k_dp003p0 ref_op1_1000_rl_s2_r100k_dp003p0 rbl_op1_1000_rl_s2_r100k_dp003p0 vp_op1_1000_rl_s2_r100k_dp003p0 vdd sky130_fd_pr__pfet_01v8 L=0.15 W=2 nf=1 ad=0.58 as=0.58 pd=4.58 ps=4.58 mult=1 m=1
XMNF_op1_1000_rl_s2_r100k_dp003p0 vn_op1_1000_rl_s2_r100k_dp003p0 en_op1_1000_rl_s2_r100k_dp003p0 0 0 sky130_fd_pr__nfet_01v8 L=0.15 W=2 nf=1 ad=0.58 as=0.58 pd=4.58 ps=4.58 mult=1 m=1
XMPH_op1_1000_rl_s2_r100k_dp003p0 vp_op1_1000_rl_s2_r100k_dp003p0 enb_op1_1000_rl_s2_r100k_dp003p0 vdd vdd sky130_fd_pr__pfet_01v8 L=0.15 W=4 nf=1 ad=1.16 as=1.16 pd=8.58 ps=8.58 mult=1 m=1
bd_op1_1000_rl_s2_r100k_dp003p0 d_op1_1000_rl_s2_r100k_dp003p0 0 v=v(rbl_op1_1000_rl_s2_r100k_dp003p0)-v(ref_op1_1000_rl_s2_r100k_dp003p0)

* ---- instance 315: op0_n100_rl_s2_r100k_dp003p0 (variant rl_s2_r100k_dp003p0; probe dec 11.9 ns, release 35 ns, meas 36 ns) ----
vctl_op0_n100_rl_s2_r100k_dp003p0 ctl_op0_n100_rl_s2_r100k_dp003p0 0 pwl(0.0000e+00 {VDD} 2.0000e-09 {VDD} 2.1000e-09 0)
* RWL driver model (EXPERIMENTAL): slew 2 ns, series R 100000 ohm; cell pin = rwls_op0_n100_rl_s2_r100k_dp003p0
vrs_op0_n100_rl_s2_r100k_dp003p0 rwlsrc_op0_n100_rl_s2_r100k_dp003p0 0 pwl(0.0000e+00 {VDD} 2.0000e-09 {VDD} 4.0000e-09 0 3.5000e-08 0 3.7000e-08 {VDD})
rdrv_op0_n100_rl_s2_r100k_dp003p0 rwlsrc_op0_n100_rl_s2_r100k_dp003p0 rwls_op0_n100_rl_s2_r100k_dp003p0 100000
ven_op0_n100_rl_s2_r100k_dp003p0 en_op0_n100_rl_s2_r100k_dp003p0 0 pwl(0.0000e+00 0 1.1000e-08 0 1.1100e-08 {VDD} 3.4000e-08 {VDD} 3.4100e-08 0)
venb_op0_n100_rl_s2_r100k_dp003p0 enb_op0_n100_rl_s2_r100k_dp003p0 0 pwl(0.0000e+00 {VDD} 1.1000e-08 {VDD} 1.1100e-08 0 3.4000e-08 0 3.4100e-08 {VDD})
vww_op0_n100_rl_s2_r100k_dp003p0 wwl_op0_n100_rl_s2_r100k_dp003p0 0 pwl(0.0000e+00 0 1.2000e-08 0 1.2100e-08 {VDD} 3.2000e-08 {VDD} 3.2100e-08 0)
vwc_op0_n100_rl_s2_r100k_dp003p0 wbc_op0_n100_rl_s2_r100k_dp003p0 0 pwl(0.0000e+00 0 1.2000e-08 0 1.2100e-08 {VDD} 3.4000e-08 {VDD} 3.4100e-08 0)
swb_op0_n100_rl_s2_r100k_dp003p0 ref_op0_n100_rl_s2_r100k_dp003p0 wbl_op0_n100_rl_s2_r100k_dp003p0 wbc_op0_n100_rl_s2_r100k_dp003p0 0 swwbl
cwbl_op0_n100_rl_s2_r100k_dp003p0 wbl_op0_n100_rl_s2_r100k_dp003p0 0 {C_WBL}
spa_op0_n100_rl_s2_r100k_dp003p0 prea rbl_op0_n100_rl_s2_r100k_dp003p0 ctl_op0_n100_rl_s2_r100k_dp003p0 0 swpre
spr_op0_n100_rl_s2_r100k_dp003p0 pref ref_op0_n100_rl_s2_r100k_dp003p0 ctl_op0_n100_rl_s2_r100k_dp003p0 0 swpre
crbl_op0_n100_rl_s2_r100k_dp003p0 rbl_op0_n100_rl_s2_r100k_dp003p0 0 {C_RBL}
cref_op0_n100_rl_s2_r100k_dp003p0 ref_op0_n100_rl_s2_r100k_dp003p0 0 {C_RBL}   $ ASSUMPTION: ideal matched dummy load
XMWR_op0_n100_rl_s2_r100k_dp003p0_0 sn_op0_n100_rl_s2_r100k_dp003p0_0 wwl_op0_n100_rl_s2_r100k_dp003p0 wbl_op0_n100_rl_s2_r100k_dp003p0 0 sky130_fd_pr__nfet_01v8 L=0.15 W=0.42 nf=1 ad=0.1218 as=0.1218 pd=1.42 ps=1.42 nrd=0.69047619047619  nrs=0.69047619047619 sa=0 sb=0 sd=0 mult=1 m=1
XMRD_op0_n100_rl_s2_r100k_dp003p0_0 rbl_op0_n100_rl_s2_r100k_dp003p0 sn_op0_n100_rl_s2_r100k_dp003p0_0 rwls_op0_n100_rl_s2_r100k_dp003p0 0 sky130_fd_pr__nfet_01v8 L=0.15 W=0.42 nf=1 ad=0.1218 as=0.1218 pd=1.42 ps=1.42 nrd=0.69047619047619  nrs=0.69047619047619 sa=0 sb=0 sd=0 mult=1 m=1
csn_op0_n100_rl_s2_r100k_dp003p0_0 sn_op0_n100_rl_s2_r100k_dp003p0_0 0 {C_SN}
XMWR_op0_n100_rl_s2_r100k_dp003p0_1 sn_op0_n100_rl_s2_r100k_dp003p0_1 wwl_des wbl_op0_n100_rl_s2_r100k_dp003p0 0 sky130_fd_pr__nfet_01v8 L=0.15 W=0.42 nf=1 ad=0.1218 as=0.1218 pd=1.42 ps=1.42 nrd=0.69047619047619  nrs=0.69047619047619 sa=0 sb=0 sd=0 mult=1 m=1
XMRD_op0_n100_rl_s2_r100k_dp003p0_1 rbl_op0_n100_rl_s2_r100k_dp003p0 sn_op0_n100_rl_s2_r100k_dp003p0_1 rwl_des 0 sky130_fd_pr__nfet_01v8 L=0.15 W=0.42 nf=1 ad=0.1218 as=0.1218 pd=1.42 ps=1.42 nrd=0.69047619047619  nrs=0.69047619047619 sa=0 sb=0 sd=0 mult=1 m=1
csn_op0_n100_rl_s2_r100k_dp003p0_1 sn_op0_n100_rl_s2_r100k_dp003p0_1 0 {C_SN}
XMWR_op0_n100_rl_s2_r100k_dp003p0_2 sn_op0_n100_rl_s2_r100k_dp003p0_2 wwl_des wbl_op0_n100_rl_s2_r100k_dp003p0 0 sky130_fd_pr__nfet_01v8 L=0.15 W=0.42 nf=1 ad=0.1218 as=0.1218 pd=1.42 ps=1.42 nrd=0.69047619047619  nrs=0.69047619047619 sa=0 sb=0 sd=0 mult=1 m=1
XMRD_op0_n100_rl_s2_r100k_dp003p0_2 rbl_op0_n100_rl_s2_r100k_dp003p0 sn_op0_n100_rl_s2_r100k_dp003p0_2 rwl_des 0 sky130_fd_pr__nfet_01v8 L=0.15 W=0.42 nf=1 ad=0.1218 as=0.1218 pd=1.42 ps=1.42 nrd=0.69047619047619  nrs=0.69047619047619 sa=0 sb=0 sd=0 mult=1 m=1
csn_op0_n100_rl_s2_r100k_dp003p0_2 sn_op0_n100_rl_s2_r100k_dp003p0_2 0 {C_SN}
XMWR_op0_n100_rl_s2_r100k_dp003p0_3 sn_op0_n100_rl_s2_r100k_dp003p0_3 wwl_des wbl_op0_n100_rl_s2_r100k_dp003p0 0 sky130_fd_pr__nfet_01v8 L=0.15 W=0.42 nf=1 ad=0.1218 as=0.1218 pd=1.42 ps=1.42 nrd=0.69047619047619  nrs=0.69047619047619 sa=0 sb=0 sd=0 mult=1 m=1
XMRD_op0_n100_rl_s2_r100k_dp003p0_3 rbl_op0_n100_rl_s2_r100k_dp003p0 sn_op0_n100_rl_s2_r100k_dp003p0_3 rwl_des 0 sky130_fd_pr__nfet_01v8 L=0.15 W=0.42 nf=1 ad=0.1218 as=0.1218 pd=1.42 ps=1.42 nrd=0.69047619047619  nrs=0.69047619047619 sa=0 sb=0 sd=0 mult=1 m=1
csn_op0_n100_rl_s2_r100k_dp003p0_3 sn_op0_n100_rl_s2_r100k_dp003p0_3 0 {C_SN}
XMN1_op0_n100_rl_s2_r100k_dp003p0 rbl_op0_n100_rl_s2_r100k_dp003p0 ref_op0_n100_rl_s2_r100k_dp003p0 vn_op0_n100_rl_s2_r100k_dp003p0 0 sky130_fd_pr__nfet_01v8 L=0.15 W=1 nf=1 ad=0.29 as=0.29 pd=2.58 ps=2.58 mult=1 m=1
XMN2_op0_n100_rl_s2_r100k_dp003p0 ref_op0_n100_rl_s2_r100k_dp003p0 rbl_op0_n100_rl_s2_r100k_dp003p0 vn_op0_n100_rl_s2_r100k_dp003p0 0 sky130_fd_pr__nfet_01v8 L=0.15 W=1 nf=1 ad=0.29 as=0.29 pd=2.58 ps=2.58 mult=1 m=1
XMP1_op0_n100_rl_s2_r100k_dp003p0 rbl_op0_n100_rl_s2_r100k_dp003p0 ref_op0_n100_rl_s2_r100k_dp003p0 vp_op0_n100_rl_s2_r100k_dp003p0 vdd sky130_fd_pr__pfet_01v8 L=0.15 W=2 nf=1 ad=0.58 as=0.58 pd=4.58 ps=4.58 mult=1 m=1
XMP2_op0_n100_rl_s2_r100k_dp003p0 ref_op0_n100_rl_s2_r100k_dp003p0 rbl_op0_n100_rl_s2_r100k_dp003p0 vp_op0_n100_rl_s2_r100k_dp003p0 vdd sky130_fd_pr__pfet_01v8 L=0.15 W=2 nf=1 ad=0.58 as=0.58 pd=4.58 ps=4.58 mult=1 m=1
XMNF_op0_n100_rl_s2_r100k_dp003p0 vn_op0_n100_rl_s2_r100k_dp003p0 en_op0_n100_rl_s2_r100k_dp003p0 0 0 sky130_fd_pr__nfet_01v8 L=0.15 W=2 nf=1 ad=0.58 as=0.58 pd=4.58 ps=4.58 mult=1 m=1
XMPH_op0_n100_rl_s2_r100k_dp003p0 vp_op0_n100_rl_s2_r100k_dp003p0 enb_op0_n100_rl_s2_r100k_dp003p0 vdd vdd sky130_fd_pr__pfet_01v8 L=0.15 W=4 nf=1 ad=1.16 as=1.16 pd=8.58 ps=8.58 mult=1 m=1
bd_op0_n100_rl_s2_r100k_dp003p0 d_op0_n100_rl_s2_r100k_dp003p0 0 v=v(rbl_op0_n100_rl_s2_r100k_dp003p0)-v(ref_op0_n100_rl_s2_r100k_dp003p0)

* ---- instance 316: op0_0000_rl_s2_r100k_dp003p0 (variant rl_s2_r100k_dp003p0; probe dec 11.9 ns, release 35 ns, meas 36 ns) ----
vctl_op0_0000_rl_s2_r100k_dp003p0 ctl_op0_0000_rl_s2_r100k_dp003p0 0 pwl(0.0000e+00 {VDD} 2.0000e-09 {VDD} 2.1000e-09 0)
* RWL driver model (EXPERIMENTAL): slew 2 ns, series R 100000 ohm; cell pin = rwls_op0_0000_rl_s2_r100k_dp003p0
vrs_op0_0000_rl_s2_r100k_dp003p0 rwlsrc_op0_0000_rl_s2_r100k_dp003p0 0 pwl(0.0000e+00 {VDD} 2.0000e-09 {VDD} 4.0000e-09 0 3.5000e-08 0 3.7000e-08 {VDD})
rdrv_op0_0000_rl_s2_r100k_dp003p0 rwlsrc_op0_0000_rl_s2_r100k_dp003p0 rwls_op0_0000_rl_s2_r100k_dp003p0 100000
ven_op0_0000_rl_s2_r100k_dp003p0 en_op0_0000_rl_s2_r100k_dp003p0 0 pwl(0.0000e+00 0 1.1000e-08 0 1.1100e-08 {VDD} 3.4000e-08 {VDD} 3.4100e-08 0)
venb_op0_0000_rl_s2_r100k_dp003p0 enb_op0_0000_rl_s2_r100k_dp003p0 0 pwl(0.0000e+00 {VDD} 1.1000e-08 {VDD} 1.1100e-08 0 3.4000e-08 0 3.4100e-08 {VDD})
vww_op0_0000_rl_s2_r100k_dp003p0 wwl_op0_0000_rl_s2_r100k_dp003p0 0 pwl(0.0000e+00 0 1.2000e-08 0 1.2100e-08 {VDD} 3.2000e-08 {VDD} 3.2100e-08 0)
vwc_op0_0000_rl_s2_r100k_dp003p0 wbc_op0_0000_rl_s2_r100k_dp003p0 0 pwl(0.0000e+00 0 1.2000e-08 0 1.2100e-08 {VDD} 3.4000e-08 {VDD} 3.4100e-08 0)
swb_op0_0000_rl_s2_r100k_dp003p0 ref_op0_0000_rl_s2_r100k_dp003p0 wbl_op0_0000_rl_s2_r100k_dp003p0 wbc_op0_0000_rl_s2_r100k_dp003p0 0 swwbl
cwbl_op0_0000_rl_s2_r100k_dp003p0 wbl_op0_0000_rl_s2_r100k_dp003p0 0 {C_WBL}
spa_op0_0000_rl_s2_r100k_dp003p0 prea rbl_op0_0000_rl_s2_r100k_dp003p0 ctl_op0_0000_rl_s2_r100k_dp003p0 0 swpre
spr_op0_0000_rl_s2_r100k_dp003p0 pref ref_op0_0000_rl_s2_r100k_dp003p0 ctl_op0_0000_rl_s2_r100k_dp003p0 0 swpre
crbl_op0_0000_rl_s2_r100k_dp003p0 rbl_op0_0000_rl_s2_r100k_dp003p0 0 {C_RBL}
cref_op0_0000_rl_s2_r100k_dp003p0 ref_op0_0000_rl_s2_r100k_dp003p0 0 {C_RBL}   $ ASSUMPTION: ideal matched dummy load
XMWR_op0_0000_rl_s2_r100k_dp003p0_0 sn_op0_0000_rl_s2_r100k_dp003p0_0 wwl_op0_0000_rl_s2_r100k_dp003p0 wbl_op0_0000_rl_s2_r100k_dp003p0 0 sky130_fd_pr__nfet_01v8 L=0.15 W=0.42 nf=1 ad=0.1218 as=0.1218 pd=1.42 ps=1.42 nrd=0.69047619047619  nrs=0.69047619047619 sa=0 sb=0 sd=0 mult=1 m=1
XMRD_op0_0000_rl_s2_r100k_dp003p0_0 rbl_op0_0000_rl_s2_r100k_dp003p0 sn_op0_0000_rl_s2_r100k_dp003p0_0 rwls_op0_0000_rl_s2_r100k_dp003p0 0 sky130_fd_pr__nfet_01v8 L=0.15 W=0.42 nf=1 ad=0.1218 as=0.1218 pd=1.42 ps=1.42 nrd=0.69047619047619  nrs=0.69047619047619 sa=0 sb=0 sd=0 mult=1 m=1
csn_op0_0000_rl_s2_r100k_dp003p0_0 sn_op0_0000_rl_s2_r100k_dp003p0_0 0 {C_SN}
XMWR_op0_0000_rl_s2_r100k_dp003p0_1 sn_op0_0000_rl_s2_r100k_dp003p0_1 wwl_des wbl_op0_0000_rl_s2_r100k_dp003p0 0 sky130_fd_pr__nfet_01v8 L=0.15 W=0.42 nf=1 ad=0.1218 as=0.1218 pd=1.42 ps=1.42 nrd=0.69047619047619  nrs=0.69047619047619 sa=0 sb=0 sd=0 mult=1 m=1
XMRD_op0_0000_rl_s2_r100k_dp003p0_1 rbl_op0_0000_rl_s2_r100k_dp003p0 sn_op0_0000_rl_s2_r100k_dp003p0_1 rwl_des 0 sky130_fd_pr__nfet_01v8 L=0.15 W=0.42 nf=1 ad=0.1218 as=0.1218 pd=1.42 ps=1.42 nrd=0.69047619047619  nrs=0.69047619047619 sa=0 sb=0 sd=0 mult=1 m=1
csn_op0_0000_rl_s2_r100k_dp003p0_1 sn_op0_0000_rl_s2_r100k_dp003p0_1 0 {C_SN}
XMWR_op0_0000_rl_s2_r100k_dp003p0_2 sn_op0_0000_rl_s2_r100k_dp003p0_2 wwl_des wbl_op0_0000_rl_s2_r100k_dp003p0 0 sky130_fd_pr__nfet_01v8 L=0.15 W=0.42 nf=1 ad=0.1218 as=0.1218 pd=1.42 ps=1.42 nrd=0.69047619047619  nrs=0.69047619047619 sa=0 sb=0 sd=0 mult=1 m=1
XMRD_op0_0000_rl_s2_r100k_dp003p0_2 rbl_op0_0000_rl_s2_r100k_dp003p0 sn_op0_0000_rl_s2_r100k_dp003p0_2 rwl_des 0 sky130_fd_pr__nfet_01v8 L=0.15 W=0.42 nf=1 ad=0.1218 as=0.1218 pd=1.42 ps=1.42 nrd=0.69047619047619  nrs=0.69047619047619 sa=0 sb=0 sd=0 mult=1 m=1
csn_op0_0000_rl_s2_r100k_dp003p0_2 sn_op0_0000_rl_s2_r100k_dp003p0_2 0 {C_SN}
XMWR_op0_0000_rl_s2_r100k_dp003p0_3 sn_op0_0000_rl_s2_r100k_dp003p0_3 wwl_des wbl_op0_0000_rl_s2_r100k_dp003p0 0 sky130_fd_pr__nfet_01v8 L=0.15 W=0.42 nf=1 ad=0.1218 as=0.1218 pd=1.42 ps=1.42 nrd=0.69047619047619  nrs=0.69047619047619 sa=0 sb=0 sd=0 mult=1 m=1
XMRD_op0_0000_rl_s2_r100k_dp003p0_3 rbl_op0_0000_rl_s2_r100k_dp003p0 sn_op0_0000_rl_s2_r100k_dp003p0_3 rwl_des 0 sky130_fd_pr__nfet_01v8 L=0.15 W=0.42 nf=1 ad=0.1218 as=0.1218 pd=1.42 ps=1.42 nrd=0.69047619047619  nrs=0.69047619047619 sa=0 sb=0 sd=0 mult=1 m=1
csn_op0_0000_rl_s2_r100k_dp003p0_3 sn_op0_0000_rl_s2_r100k_dp003p0_3 0 {C_SN}
XMN1_op0_0000_rl_s2_r100k_dp003p0 rbl_op0_0000_rl_s2_r100k_dp003p0 ref_op0_0000_rl_s2_r100k_dp003p0 vn_op0_0000_rl_s2_r100k_dp003p0 0 sky130_fd_pr__nfet_01v8 L=0.15 W=1 nf=1 ad=0.29 as=0.29 pd=2.58 ps=2.58 mult=1 m=1
XMN2_op0_0000_rl_s2_r100k_dp003p0 ref_op0_0000_rl_s2_r100k_dp003p0 rbl_op0_0000_rl_s2_r100k_dp003p0 vn_op0_0000_rl_s2_r100k_dp003p0 0 sky130_fd_pr__nfet_01v8 L=0.15 W=1 nf=1 ad=0.29 as=0.29 pd=2.58 ps=2.58 mult=1 m=1
XMP1_op0_0000_rl_s2_r100k_dp003p0 rbl_op0_0000_rl_s2_r100k_dp003p0 ref_op0_0000_rl_s2_r100k_dp003p0 vp_op0_0000_rl_s2_r100k_dp003p0 vdd sky130_fd_pr__pfet_01v8 L=0.15 W=2 nf=1 ad=0.58 as=0.58 pd=4.58 ps=4.58 mult=1 m=1
XMP2_op0_0000_rl_s2_r100k_dp003p0 ref_op0_0000_rl_s2_r100k_dp003p0 rbl_op0_0000_rl_s2_r100k_dp003p0 vp_op0_0000_rl_s2_r100k_dp003p0 vdd sky130_fd_pr__pfet_01v8 L=0.15 W=2 nf=1 ad=0.58 as=0.58 pd=4.58 ps=4.58 mult=1 m=1
XMNF_op0_0000_rl_s2_r100k_dp003p0 vn_op0_0000_rl_s2_r100k_dp003p0 en_op0_0000_rl_s2_r100k_dp003p0 0 0 sky130_fd_pr__nfet_01v8 L=0.15 W=2 nf=1 ad=0.58 as=0.58 pd=4.58 ps=4.58 mult=1 m=1
XMPH_op0_0000_rl_s2_r100k_dp003p0 vp_op0_0000_rl_s2_r100k_dp003p0 enb_op0_0000_rl_s2_r100k_dp003p0 vdd vdd sky130_fd_pr__pfet_01v8 L=0.15 W=4 nf=1 ad=1.16 as=1.16 pd=8.58 ps=8.58 mult=1 m=1
bd_op0_0000_rl_s2_r100k_dp003p0 d_op0_0000_rl_s2_r100k_dp003p0 0 v=v(rbl_op0_0000_rl_s2_r100k_dp003p0)-v(ref_op0_0000_rl_s2_r100k_dp003p0)

* ---- instance 317: op1_0900_an_s0p1_r0_ic (variant an_s0p1_r0_ic; probe dec 14.9 ns, release 37 ns, meas 39 ns) ----
vctl_op1_0900_an_s0p1_r0_ic ctl_op1_0900_an_s0p1_r0_ic 0 pwl(0.0000e+00 {VDD} 2.0000e-09 {VDD} 2.1000e-09 0)
* RWL driver model (EXPERIMENTAL): slew 0.1 ns, series R 0 ohm; cell pin = rwls_op1_0900_an_s0p1_r0_ic
vrs_op1_0900_an_s0p1_r0_ic rwls_op1_0900_an_s0p1_r0_ic 0 pwl(0.0000e+00 {VDD} 4.0000e-09 {VDD} 4.1000e-09 0 3.7000e-08 0 3.7100e-08 {VDD})
ven_op1_0900_an_s0p1_r0_ic en_op1_0900_an_s0p1_r0_ic 0 pwl(0.0000e+00 0 1.4000e-08 0 1.4100e-08 {VDD} 3.7000e-08 {VDD} 3.7100e-08 0)
venb_op1_0900_an_s0p1_r0_ic enb_op1_0900_an_s0p1_r0_ic 0 pwl(0.0000e+00 {VDD} 1.4000e-08 {VDD} 1.4100e-08 0 3.7000e-08 0 3.7100e-08 {VDD})
vww_op1_0900_an_s0p1_r0_ic wwl_op1_0900_an_s0p1_r0_ic 0 pwl(0.0000e+00 0 1.5000e-08 0 1.5100e-08 {VDD} 3.5000e-08 {VDD} 3.5100e-08 0)
vwc_op1_0900_an_s0p1_r0_ic wbc_op1_0900_an_s0p1_r0_ic 0 pwl(0.0000e+00 0 1.5000e-08 0 1.5100e-08 {VDD} 3.7000e-08 {VDD} 3.7100e-08 0)
swb_op1_0900_an_s0p1_r0_ic ref_op1_0900_an_s0p1_r0_ic wbl_op1_0900_an_s0p1_r0_ic wbc_op1_0900_an_s0p1_r0_ic 0 swwbl
cwbl_op1_0900_an_s0p1_r0_ic wbl_op1_0900_an_s0p1_r0_ic 0 {C_WBL}
spa_op1_0900_an_s0p1_r0_ic prea rbl_op1_0900_an_s0p1_r0_ic ctl_op1_0900_an_s0p1_r0_ic 0 swpre
spr_op1_0900_an_s0p1_r0_ic pref ref_op1_0900_an_s0p1_r0_ic ctl_op1_0900_an_s0p1_r0_ic 0 swpre
crbl_op1_0900_an_s0p1_r0_ic rbl_op1_0900_an_s0p1_r0_ic 0 {C_RBL}
cref_op1_0900_an_s0p1_r0_ic ref_op1_0900_an_s0p1_r0_ic 0 {C_RBL}   $ ASSUMPTION: ideal matched dummy load
XMWR_op1_0900_an_s0p1_r0_ic_0 sn_op1_0900_an_s0p1_r0_ic_0 wwl_op1_0900_an_s0p1_r0_ic wbl_op1_0900_an_s0p1_r0_ic 0 sky130_fd_pr__nfet_01v8 L=0.15 W=0.42 nf=1 ad=0.1218 as=0.1218 pd=1.42 ps=1.42 nrd=0.69047619047619  nrs=0.69047619047619 sa=0 sb=0 sd=0 mult=1 m=1
XMRD_op1_0900_an_s0p1_r0_ic_0 rbl_op1_0900_an_s0p1_r0_ic sn_op1_0900_an_s0p1_r0_ic_0 rwls_op1_0900_an_s0p1_r0_ic 0 sky130_fd_pr__nfet_01v8 L=0.15 W=0.42 nf=1 ad=0.1218 as=0.1218 pd=1.42 ps=1.42 nrd=0.69047619047619  nrs=0.69047619047619 sa=0 sb=0 sd=0 mult=1 m=1
csn_op1_0900_an_s0p1_r0_ic_0 sn_op1_0900_an_s0p1_r0_ic_0 0 {C_SN}
XMWR_op1_0900_an_s0p1_r0_ic_1 sn_op1_0900_an_s0p1_r0_ic_1 wwl_des wbl_op1_0900_an_s0p1_r0_ic 0 sky130_fd_pr__nfet_01v8 L=0.15 W=0.42 nf=1 ad=0.1218 as=0.1218 pd=1.42 ps=1.42 nrd=0.69047619047619  nrs=0.69047619047619 sa=0 sb=0 sd=0 mult=1 m=1
XMRD_op1_0900_an_s0p1_r0_ic_1 rbl_op1_0900_an_s0p1_r0_ic sn_op1_0900_an_s0p1_r0_ic_1 rwl_des 0 sky130_fd_pr__nfet_01v8 L=0.15 W=0.42 nf=1 ad=0.1218 as=0.1218 pd=1.42 ps=1.42 nrd=0.69047619047619  nrs=0.69047619047619 sa=0 sb=0 sd=0 mult=1 m=1
csn_op1_0900_an_s0p1_r0_ic_1 sn_op1_0900_an_s0p1_r0_ic_1 0 {C_SN}
XMWR_op1_0900_an_s0p1_r0_ic_2 sn_op1_0900_an_s0p1_r0_ic_2 wwl_des wbl_op1_0900_an_s0p1_r0_ic 0 sky130_fd_pr__nfet_01v8 L=0.15 W=0.42 nf=1 ad=0.1218 as=0.1218 pd=1.42 ps=1.42 nrd=0.69047619047619  nrs=0.69047619047619 sa=0 sb=0 sd=0 mult=1 m=1
XMRD_op1_0900_an_s0p1_r0_ic_2 rbl_op1_0900_an_s0p1_r0_ic sn_op1_0900_an_s0p1_r0_ic_2 rwl_des 0 sky130_fd_pr__nfet_01v8 L=0.15 W=0.42 nf=1 ad=0.1218 as=0.1218 pd=1.42 ps=1.42 nrd=0.69047619047619  nrs=0.69047619047619 sa=0 sb=0 sd=0 mult=1 m=1
csn_op1_0900_an_s0p1_r0_ic_2 sn_op1_0900_an_s0p1_r0_ic_2 0 {C_SN}
XMWR_op1_0900_an_s0p1_r0_ic_3 sn_op1_0900_an_s0p1_r0_ic_3 wwl_des wbl_op1_0900_an_s0p1_r0_ic 0 sky130_fd_pr__nfet_01v8 L=0.15 W=0.42 nf=1 ad=0.1218 as=0.1218 pd=1.42 ps=1.42 nrd=0.69047619047619  nrs=0.69047619047619 sa=0 sb=0 sd=0 mult=1 m=1
XMRD_op1_0900_an_s0p1_r0_ic_3 rbl_op1_0900_an_s0p1_r0_ic sn_op1_0900_an_s0p1_r0_ic_3 rwl_des 0 sky130_fd_pr__nfet_01v8 L=0.15 W=0.42 nf=1 ad=0.1218 as=0.1218 pd=1.42 ps=1.42 nrd=0.69047619047619  nrs=0.69047619047619 sa=0 sb=0 sd=0 mult=1 m=1
csn_op1_0900_an_s0p1_r0_ic_3 sn_op1_0900_an_s0p1_r0_ic_3 0 {C_SN}
XMN1_op1_0900_an_s0p1_r0_ic rbl_op1_0900_an_s0p1_r0_ic ref_op1_0900_an_s0p1_r0_ic vn_op1_0900_an_s0p1_r0_ic 0 sky130_fd_pr__nfet_01v8 L=0.15 W=1 nf=1 ad=0.29 as=0.29 pd=2.58 ps=2.58 mult=1 m=1
XMN2_op1_0900_an_s0p1_r0_ic ref_op1_0900_an_s0p1_r0_ic rbl_op1_0900_an_s0p1_r0_ic vn_op1_0900_an_s0p1_r0_ic 0 sky130_fd_pr__nfet_01v8 L=0.15 W=1 nf=1 ad=0.29 as=0.29 pd=2.58 ps=2.58 mult=1 m=1
XMP1_op1_0900_an_s0p1_r0_ic rbl_op1_0900_an_s0p1_r0_ic ref_op1_0900_an_s0p1_r0_ic vp_op1_0900_an_s0p1_r0_ic vdd sky130_fd_pr__pfet_01v8 L=0.15 W=2 nf=1 ad=0.58 as=0.58 pd=4.58 ps=4.58 mult=1 m=1
XMP2_op1_0900_an_s0p1_r0_ic ref_op1_0900_an_s0p1_r0_ic rbl_op1_0900_an_s0p1_r0_ic vp_op1_0900_an_s0p1_r0_ic vdd sky130_fd_pr__pfet_01v8 L=0.15 W=2 nf=1 ad=0.58 as=0.58 pd=4.58 ps=4.58 mult=1 m=1
XMNF_op1_0900_an_s0p1_r0_ic vn_op1_0900_an_s0p1_r0_ic en_op1_0900_an_s0p1_r0_ic 0 0 sky130_fd_pr__nfet_01v8 L=0.15 W=2 nf=1 ad=0.58 as=0.58 pd=4.58 ps=4.58 mult=1 m=1
XMPH_op1_0900_an_s0p1_r0_ic vp_op1_0900_an_s0p1_r0_ic enb_op1_0900_an_s0p1_r0_ic vdd vdd sky130_fd_pr__pfet_01v8 L=0.15 W=4 nf=1 ad=1.16 as=1.16 pd=8.58 ps=8.58 mult=1 m=1
bd_op1_0900_an_s0p1_r0_ic d_op1_0900_an_s0p1_r0_ic 0 v=v(rbl_op1_0900_an_s0p1_r0_ic)-v(ref_op1_0900_an_s0p1_r0_ic)

* ---- instance 318: op1_1000_an_s0p1_r0_ic (variant an_s0p1_r0_ic; probe dec 14.9 ns, release 37 ns, meas 39 ns) ----
vctl_op1_1000_an_s0p1_r0_ic ctl_op1_1000_an_s0p1_r0_ic 0 pwl(0.0000e+00 {VDD} 2.0000e-09 {VDD} 2.1000e-09 0)
* RWL driver model (EXPERIMENTAL): slew 0.1 ns, series R 0 ohm; cell pin = rwls_op1_1000_an_s0p1_r0_ic
vrs_op1_1000_an_s0p1_r0_ic rwls_op1_1000_an_s0p1_r0_ic 0 pwl(0.0000e+00 {VDD} 4.0000e-09 {VDD} 4.1000e-09 0 3.7000e-08 0 3.7100e-08 {VDD})
ven_op1_1000_an_s0p1_r0_ic en_op1_1000_an_s0p1_r0_ic 0 pwl(0.0000e+00 0 1.4000e-08 0 1.4100e-08 {VDD} 3.7000e-08 {VDD} 3.7100e-08 0)
venb_op1_1000_an_s0p1_r0_ic enb_op1_1000_an_s0p1_r0_ic 0 pwl(0.0000e+00 {VDD} 1.4000e-08 {VDD} 1.4100e-08 0 3.7000e-08 0 3.7100e-08 {VDD})
vww_op1_1000_an_s0p1_r0_ic wwl_op1_1000_an_s0p1_r0_ic 0 pwl(0.0000e+00 0 1.5000e-08 0 1.5100e-08 {VDD} 3.5000e-08 {VDD} 3.5100e-08 0)
vwc_op1_1000_an_s0p1_r0_ic wbc_op1_1000_an_s0p1_r0_ic 0 pwl(0.0000e+00 0 1.5000e-08 0 1.5100e-08 {VDD} 3.7000e-08 {VDD} 3.7100e-08 0)
swb_op1_1000_an_s0p1_r0_ic ref_op1_1000_an_s0p1_r0_ic wbl_op1_1000_an_s0p1_r0_ic wbc_op1_1000_an_s0p1_r0_ic 0 swwbl
cwbl_op1_1000_an_s0p1_r0_ic wbl_op1_1000_an_s0p1_r0_ic 0 {C_WBL}
spa_op1_1000_an_s0p1_r0_ic prea rbl_op1_1000_an_s0p1_r0_ic ctl_op1_1000_an_s0p1_r0_ic 0 swpre
spr_op1_1000_an_s0p1_r0_ic pref ref_op1_1000_an_s0p1_r0_ic ctl_op1_1000_an_s0p1_r0_ic 0 swpre
crbl_op1_1000_an_s0p1_r0_ic rbl_op1_1000_an_s0p1_r0_ic 0 {C_RBL}
cref_op1_1000_an_s0p1_r0_ic ref_op1_1000_an_s0p1_r0_ic 0 {C_RBL}   $ ASSUMPTION: ideal matched dummy load
XMWR_op1_1000_an_s0p1_r0_ic_0 sn_op1_1000_an_s0p1_r0_ic_0 wwl_op1_1000_an_s0p1_r0_ic wbl_op1_1000_an_s0p1_r0_ic 0 sky130_fd_pr__nfet_01v8 L=0.15 W=0.42 nf=1 ad=0.1218 as=0.1218 pd=1.42 ps=1.42 nrd=0.69047619047619  nrs=0.69047619047619 sa=0 sb=0 sd=0 mult=1 m=1
XMRD_op1_1000_an_s0p1_r0_ic_0 rbl_op1_1000_an_s0p1_r0_ic sn_op1_1000_an_s0p1_r0_ic_0 rwls_op1_1000_an_s0p1_r0_ic 0 sky130_fd_pr__nfet_01v8 L=0.15 W=0.42 nf=1 ad=0.1218 as=0.1218 pd=1.42 ps=1.42 nrd=0.69047619047619  nrs=0.69047619047619 sa=0 sb=0 sd=0 mult=1 m=1
csn_op1_1000_an_s0p1_r0_ic_0 sn_op1_1000_an_s0p1_r0_ic_0 0 {C_SN}
XMWR_op1_1000_an_s0p1_r0_ic_1 sn_op1_1000_an_s0p1_r0_ic_1 wwl_des wbl_op1_1000_an_s0p1_r0_ic 0 sky130_fd_pr__nfet_01v8 L=0.15 W=0.42 nf=1 ad=0.1218 as=0.1218 pd=1.42 ps=1.42 nrd=0.69047619047619  nrs=0.69047619047619 sa=0 sb=0 sd=0 mult=1 m=1
XMRD_op1_1000_an_s0p1_r0_ic_1 rbl_op1_1000_an_s0p1_r0_ic sn_op1_1000_an_s0p1_r0_ic_1 rwl_des 0 sky130_fd_pr__nfet_01v8 L=0.15 W=0.42 nf=1 ad=0.1218 as=0.1218 pd=1.42 ps=1.42 nrd=0.69047619047619  nrs=0.69047619047619 sa=0 sb=0 sd=0 mult=1 m=1
csn_op1_1000_an_s0p1_r0_ic_1 sn_op1_1000_an_s0p1_r0_ic_1 0 {C_SN}
XMWR_op1_1000_an_s0p1_r0_ic_2 sn_op1_1000_an_s0p1_r0_ic_2 wwl_des wbl_op1_1000_an_s0p1_r0_ic 0 sky130_fd_pr__nfet_01v8 L=0.15 W=0.42 nf=1 ad=0.1218 as=0.1218 pd=1.42 ps=1.42 nrd=0.69047619047619  nrs=0.69047619047619 sa=0 sb=0 sd=0 mult=1 m=1
XMRD_op1_1000_an_s0p1_r0_ic_2 rbl_op1_1000_an_s0p1_r0_ic sn_op1_1000_an_s0p1_r0_ic_2 rwl_des 0 sky130_fd_pr__nfet_01v8 L=0.15 W=0.42 nf=1 ad=0.1218 as=0.1218 pd=1.42 ps=1.42 nrd=0.69047619047619  nrs=0.69047619047619 sa=0 sb=0 sd=0 mult=1 m=1
csn_op1_1000_an_s0p1_r0_ic_2 sn_op1_1000_an_s0p1_r0_ic_2 0 {C_SN}
XMWR_op1_1000_an_s0p1_r0_ic_3 sn_op1_1000_an_s0p1_r0_ic_3 wwl_des wbl_op1_1000_an_s0p1_r0_ic 0 sky130_fd_pr__nfet_01v8 L=0.15 W=0.42 nf=1 ad=0.1218 as=0.1218 pd=1.42 ps=1.42 nrd=0.69047619047619  nrs=0.69047619047619 sa=0 sb=0 sd=0 mult=1 m=1
XMRD_op1_1000_an_s0p1_r0_ic_3 rbl_op1_1000_an_s0p1_r0_ic sn_op1_1000_an_s0p1_r0_ic_3 rwl_des 0 sky130_fd_pr__nfet_01v8 L=0.15 W=0.42 nf=1 ad=0.1218 as=0.1218 pd=1.42 ps=1.42 nrd=0.69047619047619  nrs=0.69047619047619 sa=0 sb=0 sd=0 mult=1 m=1
csn_op1_1000_an_s0p1_r0_ic_3 sn_op1_1000_an_s0p1_r0_ic_3 0 {C_SN}
XMN1_op1_1000_an_s0p1_r0_ic rbl_op1_1000_an_s0p1_r0_ic ref_op1_1000_an_s0p1_r0_ic vn_op1_1000_an_s0p1_r0_ic 0 sky130_fd_pr__nfet_01v8 L=0.15 W=1 nf=1 ad=0.29 as=0.29 pd=2.58 ps=2.58 mult=1 m=1
XMN2_op1_1000_an_s0p1_r0_ic ref_op1_1000_an_s0p1_r0_ic rbl_op1_1000_an_s0p1_r0_ic vn_op1_1000_an_s0p1_r0_ic 0 sky130_fd_pr__nfet_01v8 L=0.15 W=1 nf=1 ad=0.29 as=0.29 pd=2.58 ps=2.58 mult=1 m=1
XMP1_op1_1000_an_s0p1_r0_ic rbl_op1_1000_an_s0p1_r0_ic ref_op1_1000_an_s0p1_r0_ic vp_op1_1000_an_s0p1_r0_ic vdd sky130_fd_pr__pfet_01v8 L=0.15 W=2 nf=1 ad=0.58 as=0.58 pd=4.58 ps=4.58 mult=1 m=1
XMP2_op1_1000_an_s0p1_r0_ic ref_op1_1000_an_s0p1_r0_ic rbl_op1_1000_an_s0p1_r0_ic vp_op1_1000_an_s0p1_r0_ic vdd sky130_fd_pr__pfet_01v8 L=0.15 W=2 nf=1 ad=0.58 as=0.58 pd=4.58 ps=4.58 mult=1 m=1
XMNF_op1_1000_an_s0p1_r0_ic vn_op1_1000_an_s0p1_r0_ic en_op1_1000_an_s0p1_r0_ic 0 0 sky130_fd_pr__nfet_01v8 L=0.15 W=2 nf=1 ad=0.58 as=0.58 pd=4.58 ps=4.58 mult=1 m=1
XMPH_op1_1000_an_s0p1_r0_ic vp_op1_1000_an_s0p1_r0_ic enb_op1_1000_an_s0p1_r0_ic vdd vdd sky130_fd_pr__pfet_01v8 L=0.15 W=4 nf=1 ad=1.16 as=1.16 pd=8.58 ps=8.58 mult=1 m=1
bd_op1_1000_an_s0p1_r0_ic d_op1_1000_an_s0p1_r0_ic 0 v=v(rbl_op1_1000_an_s0p1_r0_ic)-v(ref_op1_1000_an_s0p1_r0_ic)

* ---- instance 319: op0_n100_an_s0p1_r0_ic (variant an_s0p1_r0_ic; probe dec 14.9 ns, release 37 ns, meas 39 ns) ----
vctl_op0_n100_an_s0p1_r0_ic ctl_op0_n100_an_s0p1_r0_ic 0 pwl(0.0000e+00 {VDD} 2.0000e-09 {VDD} 2.1000e-09 0)
* RWL driver model (EXPERIMENTAL): slew 0.1 ns, series R 0 ohm; cell pin = rwls_op0_n100_an_s0p1_r0_ic
vrs_op0_n100_an_s0p1_r0_ic rwls_op0_n100_an_s0p1_r0_ic 0 pwl(0.0000e+00 {VDD} 4.0000e-09 {VDD} 4.1000e-09 0 3.7000e-08 0 3.7100e-08 {VDD})
ven_op0_n100_an_s0p1_r0_ic en_op0_n100_an_s0p1_r0_ic 0 pwl(0.0000e+00 0 1.4000e-08 0 1.4100e-08 {VDD} 3.7000e-08 {VDD} 3.7100e-08 0)
venb_op0_n100_an_s0p1_r0_ic enb_op0_n100_an_s0p1_r0_ic 0 pwl(0.0000e+00 {VDD} 1.4000e-08 {VDD} 1.4100e-08 0 3.7000e-08 0 3.7100e-08 {VDD})
vww_op0_n100_an_s0p1_r0_ic wwl_op0_n100_an_s0p1_r0_ic 0 pwl(0.0000e+00 0 1.5000e-08 0 1.5100e-08 {VDD} 3.5000e-08 {VDD} 3.5100e-08 0)
vwc_op0_n100_an_s0p1_r0_ic wbc_op0_n100_an_s0p1_r0_ic 0 pwl(0.0000e+00 0 1.5000e-08 0 1.5100e-08 {VDD} 3.7000e-08 {VDD} 3.7100e-08 0)
swb_op0_n100_an_s0p1_r0_ic ref_op0_n100_an_s0p1_r0_ic wbl_op0_n100_an_s0p1_r0_ic wbc_op0_n100_an_s0p1_r0_ic 0 swwbl
cwbl_op0_n100_an_s0p1_r0_ic wbl_op0_n100_an_s0p1_r0_ic 0 {C_WBL}
spa_op0_n100_an_s0p1_r0_ic prea rbl_op0_n100_an_s0p1_r0_ic ctl_op0_n100_an_s0p1_r0_ic 0 swpre
spr_op0_n100_an_s0p1_r0_ic pref ref_op0_n100_an_s0p1_r0_ic ctl_op0_n100_an_s0p1_r0_ic 0 swpre
crbl_op0_n100_an_s0p1_r0_ic rbl_op0_n100_an_s0p1_r0_ic 0 {C_RBL}
cref_op0_n100_an_s0p1_r0_ic ref_op0_n100_an_s0p1_r0_ic 0 {C_RBL}   $ ASSUMPTION: ideal matched dummy load
XMWR_op0_n100_an_s0p1_r0_ic_0 sn_op0_n100_an_s0p1_r0_ic_0 wwl_op0_n100_an_s0p1_r0_ic wbl_op0_n100_an_s0p1_r0_ic 0 sky130_fd_pr__nfet_01v8 L=0.15 W=0.42 nf=1 ad=0.1218 as=0.1218 pd=1.42 ps=1.42 nrd=0.69047619047619  nrs=0.69047619047619 sa=0 sb=0 sd=0 mult=1 m=1
XMRD_op0_n100_an_s0p1_r0_ic_0 rbl_op0_n100_an_s0p1_r0_ic sn_op0_n100_an_s0p1_r0_ic_0 rwls_op0_n100_an_s0p1_r0_ic 0 sky130_fd_pr__nfet_01v8 L=0.15 W=0.42 nf=1 ad=0.1218 as=0.1218 pd=1.42 ps=1.42 nrd=0.69047619047619  nrs=0.69047619047619 sa=0 sb=0 sd=0 mult=1 m=1
csn_op0_n100_an_s0p1_r0_ic_0 sn_op0_n100_an_s0p1_r0_ic_0 0 {C_SN}
XMWR_op0_n100_an_s0p1_r0_ic_1 sn_op0_n100_an_s0p1_r0_ic_1 wwl_des wbl_op0_n100_an_s0p1_r0_ic 0 sky130_fd_pr__nfet_01v8 L=0.15 W=0.42 nf=1 ad=0.1218 as=0.1218 pd=1.42 ps=1.42 nrd=0.69047619047619  nrs=0.69047619047619 sa=0 sb=0 sd=0 mult=1 m=1
XMRD_op0_n100_an_s0p1_r0_ic_1 rbl_op0_n100_an_s0p1_r0_ic sn_op0_n100_an_s0p1_r0_ic_1 rwl_des 0 sky130_fd_pr__nfet_01v8 L=0.15 W=0.42 nf=1 ad=0.1218 as=0.1218 pd=1.42 ps=1.42 nrd=0.69047619047619  nrs=0.69047619047619 sa=0 sb=0 sd=0 mult=1 m=1
csn_op0_n100_an_s0p1_r0_ic_1 sn_op0_n100_an_s0p1_r0_ic_1 0 {C_SN}
XMWR_op0_n100_an_s0p1_r0_ic_2 sn_op0_n100_an_s0p1_r0_ic_2 wwl_des wbl_op0_n100_an_s0p1_r0_ic 0 sky130_fd_pr__nfet_01v8 L=0.15 W=0.42 nf=1 ad=0.1218 as=0.1218 pd=1.42 ps=1.42 nrd=0.69047619047619  nrs=0.69047619047619 sa=0 sb=0 sd=0 mult=1 m=1
XMRD_op0_n100_an_s0p1_r0_ic_2 rbl_op0_n100_an_s0p1_r0_ic sn_op0_n100_an_s0p1_r0_ic_2 rwl_des 0 sky130_fd_pr__nfet_01v8 L=0.15 W=0.42 nf=1 ad=0.1218 as=0.1218 pd=1.42 ps=1.42 nrd=0.69047619047619  nrs=0.69047619047619 sa=0 sb=0 sd=0 mult=1 m=1
csn_op0_n100_an_s0p1_r0_ic_2 sn_op0_n100_an_s0p1_r0_ic_2 0 {C_SN}
XMWR_op0_n100_an_s0p1_r0_ic_3 sn_op0_n100_an_s0p1_r0_ic_3 wwl_des wbl_op0_n100_an_s0p1_r0_ic 0 sky130_fd_pr__nfet_01v8 L=0.15 W=0.42 nf=1 ad=0.1218 as=0.1218 pd=1.42 ps=1.42 nrd=0.69047619047619  nrs=0.69047619047619 sa=0 sb=0 sd=0 mult=1 m=1
XMRD_op0_n100_an_s0p1_r0_ic_3 rbl_op0_n100_an_s0p1_r0_ic sn_op0_n100_an_s0p1_r0_ic_3 rwl_des 0 sky130_fd_pr__nfet_01v8 L=0.15 W=0.42 nf=1 ad=0.1218 as=0.1218 pd=1.42 ps=1.42 nrd=0.69047619047619  nrs=0.69047619047619 sa=0 sb=0 sd=0 mult=1 m=1
csn_op0_n100_an_s0p1_r0_ic_3 sn_op0_n100_an_s0p1_r0_ic_3 0 {C_SN}
XMN1_op0_n100_an_s0p1_r0_ic rbl_op0_n100_an_s0p1_r0_ic ref_op0_n100_an_s0p1_r0_ic vn_op0_n100_an_s0p1_r0_ic 0 sky130_fd_pr__nfet_01v8 L=0.15 W=1 nf=1 ad=0.29 as=0.29 pd=2.58 ps=2.58 mult=1 m=1
XMN2_op0_n100_an_s0p1_r0_ic ref_op0_n100_an_s0p1_r0_ic rbl_op0_n100_an_s0p1_r0_ic vn_op0_n100_an_s0p1_r0_ic 0 sky130_fd_pr__nfet_01v8 L=0.15 W=1 nf=1 ad=0.29 as=0.29 pd=2.58 ps=2.58 mult=1 m=1
XMP1_op0_n100_an_s0p1_r0_ic rbl_op0_n100_an_s0p1_r0_ic ref_op0_n100_an_s0p1_r0_ic vp_op0_n100_an_s0p1_r0_ic vdd sky130_fd_pr__pfet_01v8 L=0.15 W=2 nf=1 ad=0.58 as=0.58 pd=4.58 ps=4.58 mult=1 m=1
XMP2_op0_n100_an_s0p1_r0_ic ref_op0_n100_an_s0p1_r0_ic rbl_op0_n100_an_s0p1_r0_ic vp_op0_n100_an_s0p1_r0_ic vdd sky130_fd_pr__pfet_01v8 L=0.15 W=2 nf=1 ad=0.58 as=0.58 pd=4.58 ps=4.58 mult=1 m=1
XMNF_op0_n100_an_s0p1_r0_ic vn_op0_n100_an_s0p1_r0_ic en_op0_n100_an_s0p1_r0_ic 0 0 sky130_fd_pr__nfet_01v8 L=0.15 W=2 nf=1 ad=0.58 as=0.58 pd=4.58 ps=4.58 mult=1 m=1
XMPH_op0_n100_an_s0p1_r0_ic vp_op0_n100_an_s0p1_r0_ic enb_op0_n100_an_s0p1_r0_ic vdd vdd sky130_fd_pr__pfet_01v8 L=0.15 W=4 nf=1 ad=1.16 as=1.16 pd=8.58 ps=8.58 mult=1 m=1
bd_op0_n100_an_s0p1_r0_ic d_op0_n100_an_s0p1_r0_ic 0 v=v(rbl_op0_n100_an_s0p1_r0_ic)-v(ref_op0_n100_an_s0p1_r0_ic)

* ---- instance 320: op0_0000_an_s0p1_r0_ic (variant an_s0p1_r0_ic; probe dec 14.9 ns, release 37 ns, meas 39 ns) ----
vctl_op0_0000_an_s0p1_r0_ic ctl_op0_0000_an_s0p1_r0_ic 0 pwl(0.0000e+00 {VDD} 2.0000e-09 {VDD} 2.1000e-09 0)
* RWL driver model (EXPERIMENTAL): slew 0.1 ns, series R 0 ohm; cell pin = rwls_op0_0000_an_s0p1_r0_ic
vrs_op0_0000_an_s0p1_r0_ic rwls_op0_0000_an_s0p1_r0_ic 0 pwl(0.0000e+00 {VDD} 4.0000e-09 {VDD} 4.1000e-09 0 3.7000e-08 0 3.7100e-08 {VDD})
ven_op0_0000_an_s0p1_r0_ic en_op0_0000_an_s0p1_r0_ic 0 pwl(0.0000e+00 0 1.4000e-08 0 1.4100e-08 {VDD} 3.7000e-08 {VDD} 3.7100e-08 0)
venb_op0_0000_an_s0p1_r0_ic enb_op0_0000_an_s0p1_r0_ic 0 pwl(0.0000e+00 {VDD} 1.4000e-08 {VDD} 1.4100e-08 0 3.7000e-08 0 3.7100e-08 {VDD})
vww_op0_0000_an_s0p1_r0_ic wwl_op0_0000_an_s0p1_r0_ic 0 pwl(0.0000e+00 0 1.5000e-08 0 1.5100e-08 {VDD} 3.5000e-08 {VDD} 3.5100e-08 0)
vwc_op0_0000_an_s0p1_r0_ic wbc_op0_0000_an_s0p1_r0_ic 0 pwl(0.0000e+00 0 1.5000e-08 0 1.5100e-08 {VDD} 3.7000e-08 {VDD} 3.7100e-08 0)
swb_op0_0000_an_s0p1_r0_ic ref_op0_0000_an_s0p1_r0_ic wbl_op0_0000_an_s0p1_r0_ic wbc_op0_0000_an_s0p1_r0_ic 0 swwbl
cwbl_op0_0000_an_s0p1_r0_ic wbl_op0_0000_an_s0p1_r0_ic 0 {C_WBL}
spa_op0_0000_an_s0p1_r0_ic prea rbl_op0_0000_an_s0p1_r0_ic ctl_op0_0000_an_s0p1_r0_ic 0 swpre
spr_op0_0000_an_s0p1_r0_ic pref ref_op0_0000_an_s0p1_r0_ic ctl_op0_0000_an_s0p1_r0_ic 0 swpre
crbl_op0_0000_an_s0p1_r0_ic rbl_op0_0000_an_s0p1_r0_ic 0 {C_RBL}
cref_op0_0000_an_s0p1_r0_ic ref_op0_0000_an_s0p1_r0_ic 0 {C_RBL}   $ ASSUMPTION: ideal matched dummy load
XMWR_op0_0000_an_s0p1_r0_ic_0 sn_op0_0000_an_s0p1_r0_ic_0 wwl_op0_0000_an_s0p1_r0_ic wbl_op0_0000_an_s0p1_r0_ic 0 sky130_fd_pr__nfet_01v8 L=0.15 W=0.42 nf=1 ad=0.1218 as=0.1218 pd=1.42 ps=1.42 nrd=0.69047619047619  nrs=0.69047619047619 sa=0 sb=0 sd=0 mult=1 m=1
XMRD_op0_0000_an_s0p1_r0_ic_0 rbl_op0_0000_an_s0p1_r0_ic sn_op0_0000_an_s0p1_r0_ic_0 rwls_op0_0000_an_s0p1_r0_ic 0 sky130_fd_pr__nfet_01v8 L=0.15 W=0.42 nf=1 ad=0.1218 as=0.1218 pd=1.42 ps=1.42 nrd=0.69047619047619  nrs=0.69047619047619 sa=0 sb=0 sd=0 mult=1 m=1
csn_op0_0000_an_s0p1_r0_ic_0 sn_op0_0000_an_s0p1_r0_ic_0 0 {C_SN}
XMWR_op0_0000_an_s0p1_r0_ic_1 sn_op0_0000_an_s0p1_r0_ic_1 wwl_des wbl_op0_0000_an_s0p1_r0_ic 0 sky130_fd_pr__nfet_01v8 L=0.15 W=0.42 nf=1 ad=0.1218 as=0.1218 pd=1.42 ps=1.42 nrd=0.69047619047619  nrs=0.69047619047619 sa=0 sb=0 sd=0 mult=1 m=1
XMRD_op0_0000_an_s0p1_r0_ic_1 rbl_op0_0000_an_s0p1_r0_ic sn_op0_0000_an_s0p1_r0_ic_1 rwl_des 0 sky130_fd_pr__nfet_01v8 L=0.15 W=0.42 nf=1 ad=0.1218 as=0.1218 pd=1.42 ps=1.42 nrd=0.69047619047619  nrs=0.69047619047619 sa=0 sb=0 sd=0 mult=1 m=1
csn_op0_0000_an_s0p1_r0_ic_1 sn_op0_0000_an_s0p1_r0_ic_1 0 {C_SN}
XMWR_op0_0000_an_s0p1_r0_ic_2 sn_op0_0000_an_s0p1_r0_ic_2 wwl_des wbl_op0_0000_an_s0p1_r0_ic 0 sky130_fd_pr__nfet_01v8 L=0.15 W=0.42 nf=1 ad=0.1218 as=0.1218 pd=1.42 ps=1.42 nrd=0.69047619047619  nrs=0.69047619047619 sa=0 sb=0 sd=0 mult=1 m=1
XMRD_op0_0000_an_s0p1_r0_ic_2 rbl_op0_0000_an_s0p1_r0_ic sn_op0_0000_an_s0p1_r0_ic_2 rwl_des 0 sky130_fd_pr__nfet_01v8 L=0.15 W=0.42 nf=1 ad=0.1218 as=0.1218 pd=1.42 ps=1.42 nrd=0.69047619047619  nrs=0.69047619047619 sa=0 sb=0 sd=0 mult=1 m=1
csn_op0_0000_an_s0p1_r0_ic_2 sn_op0_0000_an_s0p1_r0_ic_2 0 {C_SN}
XMWR_op0_0000_an_s0p1_r0_ic_3 sn_op0_0000_an_s0p1_r0_ic_3 wwl_des wbl_op0_0000_an_s0p1_r0_ic 0 sky130_fd_pr__nfet_01v8 L=0.15 W=0.42 nf=1 ad=0.1218 as=0.1218 pd=1.42 ps=1.42 nrd=0.69047619047619  nrs=0.69047619047619 sa=0 sb=0 sd=0 mult=1 m=1
XMRD_op0_0000_an_s0p1_r0_ic_3 rbl_op0_0000_an_s0p1_r0_ic sn_op0_0000_an_s0p1_r0_ic_3 rwl_des 0 sky130_fd_pr__nfet_01v8 L=0.15 W=0.42 nf=1 ad=0.1218 as=0.1218 pd=1.42 ps=1.42 nrd=0.69047619047619  nrs=0.69047619047619 sa=0 sb=0 sd=0 mult=1 m=1
csn_op0_0000_an_s0p1_r0_ic_3 sn_op0_0000_an_s0p1_r0_ic_3 0 {C_SN}
XMN1_op0_0000_an_s0p1_r0_ic rbl_op0_0000_an_s0p1_r0_ic ref_op0_0000_an_s0p1_r0_ic vn_op0_0000_an_s0p1_r0_ic 0 sky130_fd_pr__nfet_01v8 L=0.15 W=1 nf=1 ad=0.29 as=0.29 pd=2.58 ps=2.58 mult=1 m=1
XMN2_op0_0000_an_s0p1_r0_ic ref_op0_0000_an_s0p1_r0_ic rbl_op0_0000_an_s0p1_r0_ic vn_op0_0000_an_s0p1_r0_ic 0 sky130_fd_pr__nfet_01v8 L=0.15 W=1 nf=1 ad=0.29 as=0.29 pd=2.58 ps=2.58 mult=1 m=1
XMP1_op0_0000_an_s0p1_r0_ic rbl_op0_0000_an_s0p1_r0_ic ref_op0_0000_an_s0p1_r0_ic vp_op0_0000_an_s0p1_r0_ic vdd sky130_fd_pr__pfet_01v8 L=0.15 W=2 nf=1 ad=0.58 as=0.58 pd=4.58 ps=4.58 mult=1 m=1
XMP2_op0_0000_an_s0p1_r0_ic ref_op0_0000_an_s0p1_r0_ic rbl_op0_0000_an_s0p1_r0_ic vp_op0_0000_an_s0p1_r0_ic vdd sky130_fd_pr__pfet_01v8 L=0.15 W=2 nf=1 ad=0.58 as=0.58 pd=4.58 ps=4.58 mult=1 m=1
XMNF_op0_0000_an_s0p1_r0_ic vn_op0_0000_an_s0p1_r0_ic en_op0_0000_an_s0p1_r0_ic 0 0 sky130_fd_pr__nfet_01v8 L=0.15 W=2 nf=1 ad=0.58 as=0.58 pd=4.58 ps=4.58 mult=1 m=1
XMPH_op0_0000_an_s0p1_r0_ic vp_op0_0000_an_s0p1_r0_ic enb_op0_0000_an_s0p1_r0_ic vdd vdd sky130_fd_pr__pfet_01v8 L=0.15 W=4 nf=1 ad=1.16 as=1.16 pd=8.58 ps=8.58 mult=1 m=1
bd_op0_0000_an_s0p1_r0_ic d_op0_0000_an_s0p1_r0_ic 0 v=v(rbl_op0_0000_an_s0p1_r0_ic)-v(ref_op0_0000_an_s0p1_r0_ic)

* ---- instance 321: op1_0900_rh_s0p1_r0_ic (variant rh_s0p1_r0_ic; probe dec 11.9 ns, release 34 ns, meas 36 ns) ----
vctl_op1_0900_rh_s0p1_r0_ic ctl_op1_0900_rh_s0p1_r0_ic 0 pwl(0.0000e+00 {VDD} 2.0000e-09 {VDD} 2.1000e-09 0)
* RWL driver model (EXPERIMENTAL): slew 0.1 ns, series R 0 ohm; cell pin = rwls_op1_0900_rh_s0p1_r0_ic
vrs_op1_0900_rh_s0p1_r0_ic rwls_op1_0900_rh_s0p1_r0_ic 0 pwl(0.0000e+00 {VDD} 2.0000e-09 {VDD} 2.1000e-09 0 1.2000e-08 0 1.2100e-08 {VDD})
ven_op1_0900_rh_s0p1_r0_ic en_op1_0900_rh_s0p1_r0_ic 0 pwl(0.0000e+00 0 1.1000e-08 0 1.1100e-08 {VDD} 3.4000e-08 {VDD} 3.4100e-08 0)
venb_op1_0900_rh_s0p1_r0_ic enb_op1_0900_rh_s0p1_r0_ic 0 pwl(0.0000e+00 {VDD} 1.1000e-08 {VDD} 1.1100e-08 0 3.4000e-08 0 3.4100e-08 {VDD})
vww_op1_0900_rh_s0p1_r0_ic wwl_op1_0900_rh_s0p1_r0_ic 0 pwl(0.0000e+00 0 1.2000e-08 0 1.2100e-08 {VDD} 3.2000e-08 {VDD} 3.2100e-08 0)
vwc_op1_0900_rh_s0p1_r0_ic wbc_op1_0900_rh_s0p1_r0_ic 0 pwl(0.0000e+00 0 1.2000e-08 0 1.2100e-08 {VDD} 3.4000e-08 {VDD} 3.4100e-08 0)
swb_op1_0900_rh_s0p1_r0_ic ref_op1_0900_rh_s0p1_r0_ic wbl_op1_0900_rh_s0p1_r0_ic wbc_op1_0900_rh_s0p1_r0_ic 0 swwbl
cwbl_op1_0900_rh_s0p1_r0_ic wbl_op1_0900_rh_s0p1_r0_ic 0 {C_WBL}
spa_op1_0900_rh_s0p1_r0_ic prea rbl_op1_0900_rh_s0p1_r0_ic ctl_op1_0900_rh_s0p1_r0_ic 0 swpre
spr_op1_0900_rh_s0p1_r0_ic pref ref_op1_0900_rh_s0p1_r0_ic ctl_op1_0900_rh_s0p1_r0_ic 0 swpre
crbl_op1_0900_rh_s0p1_r0_ic rbl_op1_0900_rh_s0p1_r0_ic 0 {C_RBL}
cref_op1_0900_rh_s0p1_r0_ic ref_op1_0900_rh_s0p1_r0_ic 0 {C_RBL}   $ ASSUMPTION: ideal matched dummy load
XMWR_op1_0900_rh_s0p1_r0_ic_0 sn_op1_0900_rh_s0p1_r0_ic_0 wwl_op1_0900_rh_s0p1_r0_ic wbl_op1_0900_rh_s0p1_r0_ic 0 sky130_fd_pr__nfet_01v8 L=0.15 W=0.42 nf=1 ad=0.1218 as=0.1218 pd=1.42 ps=1.42 nrd=0.69047619047619  nrs=0.69047619047619 sa=0 sb=0 sd=0 mult=1 m=1
XMRD_op1_0900_rh_s0p1_r0_ic_0 rbl_op1_0900_rh_s0p1_r0_ic sn_op1_0900_rh_s0p1_r0_ic_0 rwls_op1_0900_rh_s0p1_r0_ic 0 sky130_fd_pr__nfet_01v8 L=0.15 W=0.42 nf=1 ad=0.1218 as=0.1218 pd=1.42 ps=1.42 nrd=0.69047619047619  nrs=0.69047619047619 sa=0 sb=0 sd=0 mult=1 m=1
csn_op1_0900_rh_s0p1_r0_ic_0 sn_op1_0900_rh_s0p1_r0_ic_0 0 {C_SN}
XMWR_op1_0900_rh_s0p1_r0_ic_1 sn_op1_0900_rh_s0p1_r0_ic_1 wwl_des wbl_op1_0900_rh_s0p1_r0_ic 0 sky130_fd_pr__nfet_01v8 L=0.15 W=0.42 nf=1 ad=0.1218 as=0.1218 pd=1.42 ps=1.42 nrd=0.69047619047619  nrs=0.69047619047619 sa=0 sb=0 sd=0 mult=1 m=1
XMRD_op1_0900_rh_s0p1_r0_ic_1 rbl_op1_0900_rh_s0p1_r0_ic sn_op1_0900_rh_s0p1_r0_ic_1 rwl_des 0 sky130_fd_pr__nfet_01v8 L=0.15 W=0.42 nf=1 ad=0.1218 as=0.1218 pd=1.42 ps=1.42 nrd=0.69047619047619  nrs=0.69047619047619 sa=0 sb=0 sd=0 mult=1 m=1
csn_op1_0900_rh_s0p1_r0_ic_1 sn_op1_0900_rh_s0p1_r0_ic_1 0 {C_SN}
XMWR_op1_0900_rh_s0p1_r0_ic_2 sn_op1_0900_rh_s0p1_r0_ic_2 wwl_des wbl_op1_0900_rh_s0p1_r0_ic 0 sky130_fd_pr__nfet_01v8 L=0.15 W=0.42 nf=1 ad=0.1218 as=0.1218 pd=1.42 ps=1.42 nrd=0.69047619047619  nrs=0.69047619047619 sa=0 sb=0 sd=0 mult=1 m=1
XMRD_op1_0900_rh_s0p1_r0_ic_2 rbl_op1_0900_rh_s0p1_r0_ic sn_op1_0900_rh_s0p1_r0_ic_2 rwl_des 0 sky130_fd_pr__nfet_01v8 L=0.15 W=0.42 nf=1 ad=0.1218 as=0.1218 pd=1.42 ps=1.42 nrd=0.69047619047619  nrs=0.69047619047619 sa=0 sb=0 sd=0 mult=1 m=1
csn_op1_0900_rh_s0p1_r0_ic_2 sn_op1_0900_rh_s0p1_r0_ic_2 0 {C_SN}
XMWR_op1_0900_rh_s0p1_r0_ic_3 sn_op1_0900_rh_s0p1_r0_ic_3 wwl_des wbl_op1_0900_rh_s0p1_r0_ic 0 sky130_fd_pr__nfet_01v8 L=0.15 W=0.42 nf=1 ad=0.1218 as=0.1218 pd=1.42 ps=1.42 nrd=0.69047619047619  nrs=0.69047619047619 sa=0 sb=0 sd=0 mult=1 m=1
XMRD_op1_0900_rh_s0p1_r0_ic_3 rbl_op1_0900_rh_s0p1_r0_ic sn_op1_0900_rh_s0p1_r0_ic_3 rwl_des 0 sky130_fd_pr__nfet_01v8 L=0.15 W=0.42 nf=1 ad=0.1218 as=0.1218 pd=1.42 ps=1.42 nrd=0.69047619047619  nrs=0.69047619047619 sa=0 sb=0 sd=0 mult=1 m=1
csn_op1_0900_rh_s0p1_r0_ic_3 sn_op1_0900_rh_s0p1_r0_ic_3 0 {C_SN}
XMN1_op1_0900_rh_s0p1_r0_ic rbl_op1_0900_rh_s0p1_r0_ic ref_op1_0900_rh_s0p1_r0_ic vn_op1_0900_rh_s0p1_r0_ic 0 sky130_fd_pr__nfet_01v8 L=0.15 W=1 nf=1 ad=0.29 as=0.29 pd=2.58 ps=2.58 mult=1 m=1
XMN2_op1_0900_rh_s0p1_r0_ic ref_op1_0900_rh_s0p1_r0_ic rbl_op1_0900_rh_s0p1_r0_ic vn_op1_0900_rh_s0p1_r0_ic 0 sky130_fd_pr__nfet_01v8 L=0.15 W=1 nf=1 ad=0.29 as=0.29 pd=2.58 ps=2.58 mult=1 m=1
XMP1_op1_0900_rh_s0p1_r0_ic rbl_op1_0900_rh_s0p1_r0_ic ref_op1_0900_rh_s0p1_r0_ic vp_op1_0900_rh_s0p1_r0_ic vdd sky130_fd_pr__pfet_01v8 L=0.15 W=2 nf=1 ad=0.58 as=0.58 pd=4.58 ps=4.58 mult=1 m=1
XMP2_op1_0900_rh_s0p1_r0_ic ref_op1_0900_rh_s0p1_r0_ic rbl_op1_0900_rh_s0p1_r0_ic vp_op1_0900_rh_s0p1_r0_ic vdd sky130_fd_pr__pfet_01v8 L=0.15 W=2 nf=1 ad=0.58 as=0.58 pd=4.58 ps=4.58 mult=1 m=1
XMNF_op1_0900_rh_s0p1_r0_ic vn_op1_0900_rh_s0p1_r0_ic en_op1_0900_rh_s0p1_r0_ic 0 0 sky130_fd_pr__nfet_01v8 L=0.15 W=2 nf=1 ad=0.58 as=0.58 pd=4.58 ps=4.58 mult=1 m=1
XMPH_op1_0900_rh_s0p1_r0_ic vp_op1_0900_rh_s0p1_r0_ic enb_op1_0900_rh_s0p1_r0_ic vdd vdd sky130_fd_pr__pfet_01v8 L=0.15 W=4 nf=1 ad=1.16 as=1.16 pd=8.58 ps=8.58 mult=1 m=1
bd_op1_0900_rh_s0p1_r0_ic d_op1_0900_rh_s0p1_r0_ic 0 v=v(rbl_op1_0900_rh_s0p1_r0_ic)-v(ref_op1_0900_rh_s0p1_r0_ic)

* ---- instance 322: op1_1000_rh_s0p1_r0_ic (variant rh_s0p1_r0_ic; probe dec 11.9 ns, release 34 ns, meas 36 ns) ----
vctl_op1_1000_rh_s0p1_r0_ic ctl_op1_1000_rh_s0p1_r0_ic 0 pwl(0.0000e+00 {VDD} 2.0000e-09 {VDD} 2.1000e-09 0)
* RWL driver model (EXPERIMENTAL): slew 0.1 ns, series R 0 ohm; cell pin = rwls_op1_1000_rh_s0p1_r0_ic
vrs_op1_1000_rh_s0p1_r0_ic rwls_op1_1000_rh_s0p1_r0_ic 0 pwl(0.0000e+00 {VDD} 2.0000e-09 {VDD} 2.1000e-09 0 1.2000e-08 0 1.2100e-08 {VDD})
ven_op1_1000_rh_s0p1_r0_ic en_op1_1000_rh_s0p1_r0_ic 0 pwl(0.0000e+00 0 1.1000e-08 0 1.1100e-08 {VDD} 3.4000e-08 {VDD} 3.4100e-08 0)
venb_op1_1000_rh_s0p1_r0_ic enb_op1_1000_rh_s0p1_r0_ic 0 pwl(0.0000e+00 {VDD} 1.1000e-08 {VDD} 1.1100e-08 0 3.4000e-08 0 3.4100e-08 {VDD})
vww_op1_1000_rh_s0p1_r0_ic wwl_op1_1000_rh_s0p1_r0_ic 0 pwl(0.0000e+00 0 1.2000e-08 0 1.2100e-08 {VDD} 3.2000e-08 {VDD} 3.2100e-08 0)
vwc_op1_1000_rh_s0p1_r0_ic wbc_op1_1000_rh_s0p1_r0_ic 0 pwl(0.0000e+00 0 1.2000e-08 0 1.2100e-08 {VDD} 3.4000e-08 {VDD} 3.4100e-08 0)
swb_op1_1000_rh_s0p1_r0_ic ref_op1_1000_rh_s0p1_r0_ic wbl_op1_1000_rh_s0p1_r0_ic wbc_op1_1000_rh_s0p1_r0_ic 0 swwbl
cwbl_op1_1000_rh_s0p1_r0_ic wbl_op1_1000_rh_s0p1_r0_ic 0 {C_WBL}
spa_op1_1000_rh_s0p1_r0_ic prea rbl_op1_1000_rh_s0p1_r0_ic ctl_op1_1000_rh_s0p1_r0_ic 0 swpre
spr_op1_1000_rh_s0p1_r0_ic pref ref_op1_1000_rh_s0p1_r0_ic ctl_op1_1000_rh_s0p1_r0_ic 0 swpre
crbl_op1_1000_rh_s0p1_r0_ic rbl_op1_1000_rh_s0p1_r0_ic 0 {C_RBL}
cref_op1_1000_rh_s0p1_r0_ic ref_op1_1000_rh_s0p1_r0_ic 0 {C_RBL}   $ ASSUMPTION: ideal matched dummy load
XMWR_op1_1000_rh_s0p1_r0_ic_0 sn_op1_1000_rh_s0p1_r0_ic_0 wwl_op1_1000_rh_s0p1_r0_ic wbl_op1_1000_rh_s0p1_r0_ic 0 sky130_fd_pr__nfet_01v8 L=0.15 W=0.42 nf=1 ad=0.1218 as=0.1218 pd=1.42 ps=1.42 nrd=0.69047619047619  nrs=0.69047619047619 sa=0 sb=0 sd=0 mult=1 m=1
XMRD_op1_1000_rh_s0p1_r0_ic_0 rbl_op1_1000_rh_s0p1_r0_ic sn_op1_1000_rh_s0p1_r0_ic_0 rwls_op1_1000_rh_s0p1_r0_ic 0 sky130_fd_pr__nfet_01v8 L=0.15 W=0.42 nf=1 ad=0.1218 as=0.1218 pd=1.42 ps=1.42 nrd=0.69047619047619  nrs=0.69047619047619 sa=0 sb=0 sd=0 mult=1 m=1
csn_op1_1000_rh_s0p1_r0_ic_0 sn_op1_1000_rh_s0p1_r0_ic_0 0 {C_SN}
XMWR_op1_1000_rh_s0p1_r0_ic_1 sn_op1_1000_rh_s0p1_r0_ic_1 wwl_des wbl_op1_1000_rh_s0p1_r0_ic 0 sky130_fd_pr__nfet_01v8 L=0.15 W=0.42 nf=1 ad=0.1218 as=0.1218 pd=1.42 ps=1.42 nrd=0.69047619047619  nrs=0.69047619047619 sa=0 sb=0 sd=0 mult=1 m=1
XMRD_op1_1000_rh_s0p1_r0_ic_1 rbl_op1_1000_rh_s0p1_r0_ic sn_op1_1000_rh_s0p1_r0_ic_1 rwl_des 0 sky130_fd_pr__nfet_01v8 L=0.15 W=0.42 nf=1 ad=0.1218 as=0.1218 pd=1.42 ps=1.42 nrd=0.69047619047619  nrs=0.69047619047619 sa=0 sb=0 sd=0 mult=1 m=1
csn_op1_1000_rh_s0p1_r0_ic_1 sn_op1_1000_rh_s0p1_r0_ic_1 0 {C_SN}
XMWR_op1_1000_rh_s0p1_r0_ic_2 sn_op1_1000_rh_s0p1_r0_ic_2 wwl_des wbl_op1_1000_rh_s0p1_r0_ic 0 sky130_fd_pr__nfet_01v8 L=0.15 W=0.42 nf=1 ad=0.1218 as=0.1218 pd=1.42 ps=1.42 nrd=0.69047619047619  nrs=0.69047619047619 sa=0 sb=0 sd=0 mult=1 m=1
XMRD_op1_1000_rh_s0p1_r0_ic_2 rbl_op1_1000_rh_s0p1_r0_ic sn_op1_1000_rh_s0p1_r0_ic_2 rwl_des 0 sky130_fd_pr__nfet_01v8 L=0.15 W=0.42 nf=1 ad=0.1218 as=0.1218 pd=1.42 ps=1.42 nrd=0.69047619047619  nrs=0.69047619047619 sa=0 sb=0 sd=0 mult=1 m=1
csn_op1_1000_rh_s0p1_r0_ic_2 sn_op1_1000_rh_s0p1_r0_ic_2 0 {C_SN}
XMWR_op1_1000_rh_s0p1_r0_ic_3 sn_op1_1000_rh_s0p1_r0_ic_3 wwl_des wbl_op1_1000_rh_s0p1_r0_ic 0 sky130_fd_pr__nfet_01v8 L=0.15 W=0.42 nf=1 ad=0.1218 as=0.1218 pd=1.42 ps=1.42 nrd=0.69047619047619  nrs=0.69047619047619 sa=0 sb=0 sd=0 mult=1 m=1
XMRD_op1_1000_rh_s0p1_r0_ic_3 rbl_op1_1000_rh_s0p1_r0_ic sn_op1_1000_rh_s0p1_r0_ic_3 rwl_des 0 sky130_fd_pr__nfet_01v8 L=0.15 W=0.42 nf=1 ad=0.1218 as=0.1218 pd=1.42 ps=1.42 nrd=0.69047619047619  nrs=0.69047619047619 sa=0 sb=0 sd=0 mult=1 m=1
csn_op1_1000_rh_s0p1_r0_ic_3 sn_op1_1000_rh_s0p1_r0_ic_3 0 {C_SN}
XMN1_op1_1000_rh_s0p1_r0_ic rbl_op1_1000_rh_s0p1_r0_ic ref_op1_1000_rh_s0p1_r0_ic vn_op1_1000_rh_s0p1_r0_ic 0 sky130_fd_pr__nfet_01v8 L=0.15 W=1 nf=1 ad=0.29 as=0.29 pd=2.58 ps=2.58 mult=1 m=1
XMN2_op1_1000_rh_s0p1_r0_ic ref_op1_1000_rh_s0p1_r0_ic rbl_op1_1000_rh_s0p1_r0_ic vn_op1_1000_rh_s0p1_r0_ic 0 sky130_fd_pr__nfet_01v8 L=0.15 W=1 nf=1 ad=0.29 as=0.29 pd=2.58 ps=2.58 mult=1 m=1
XMP1_op1_1000_rh_s0p1_r0_ic rbl_op1_1000_rh_s0p1_r0_ic ref_op1_1000_rh_s0p1_r0_ic vp_op1_1000_rh_s0p1_r0_ic vdd sky130_fd_pr__pfet_01v8 L=0.15 W=2 nf=1 ad=0.58 as=0.58 pd=4.58 ps=4.58 mult=1 m=1
XMP2_op1_1000_rh_s0p1_r0_ic ref_op1_1000_rh_s0p1_r0_ic rbl_op1_1000_rh_s0p1_r0_ic vp_op1_1000_rh_s0p1_r0_ic vdd sky130_fd_pr__pfet_01v8 L=0.15 W=2 nf=1 ad=0.58 as=0.58 pd=4.58 ps=4.58 mult=1 m=1
XMNF_op1_1000_rh_s0p1_r0_ic vn_op1_1000_rh_s0p1_r0_ic en_op1_1000_rh_s0p1_r0_ic 0 0 sky130_fd_pr__nfet_01v8 L=0.15 W=2 nf=1 ad=0.58 as=0.58 pd=4.58 ps=4.58 mult=1 m=1
XMPH_op1_1000_rh_s0p1_r0_ic vp_op1_1000_rh_s0p1_r0_ic enb_op1_1000_rh_s0p1_r0_ic vdd vdd sky130_fd_pr__pfet_01v8 L=0.15 W=4 nf=1 ad=1.16 as=1.16 pd=8.58 ps=8.58 mult=1 m=1
bd_op1_1000_rh_s0p1_r0_ic d_op1_1000_rh_s0p1_r0_ic 0 v=v(rbl_op1_1000_rh_s0p1_r0_ic)-v(ref_op1_1000_rh_s0p1_r0_ic)

* ---- instance 323: op0_n100_rh_s0p1_r0_ic (variant rh_s0p1_r0_ic; probe dec 11.9 ns, release 34 ns, meas 36 ns) ----
vctl_op0_n100_rh_s0p1_r0_ic ctl_op0_n100_rh_s0p1_r0_ic 0 pwl(0.0000e+00 {VDD} 2.0000e-09 {VDD} 2.1000e-09 0)
* RWL driver model (EXPERIMENTAL): slew 0.1 ns, series R 0 ohm; cell pin = rwls_op0_n100_rh_s0p1_r0_ic
vrs_op0_n100_rh_s0p1_r0_ic rwls_op0_n100_rh_s0p1_r0_ic 0 pwl(0.0000e+00 {VDD} 2.0000e-09 {VDD} 2.1000e-09 0 1.2000e-08 0 1.2100e-08 {VDD})
ven_op0_n100_rh_s0p1_r0_ic en_op0_n100_rh_s0p1_r0_ic 0 pwl(0.0000e+00 0 1.1000e-08 0 1.1100e-08 {VDD} 3.4000e-08 {VDD} 3.4100e-08 0)
venb_op0_n100_rh_s0p1_r0_ic enb_op0_n100_rh_s0p1_r0_ic 0 pwl(0.0000e+00 {VDD} 1.1000e-08 {VDD} 1.1100e-08 0 3.4000e-08 0 3.4100e-08 {VDD})
vww_op0_n100_rh_s0p1_r0_ic wwl_op0_n100_rh_s0p1_r0_ic 0 pwl(0.0000e+00 0 1.2000e-08 0 1.2100e-08 {VDD} 3.2000e-08 {VDD} 3.2100e-08 0)
vwc_op0_n100_rh_s0p1_r0_ic wbc_op0_n100_rh_s0p1_r0_ic 0 pwl(0.0000e+00 0 1.2000e-08 0 1.2100e-08 {VDD} 3.4000e-08 {VDD} 3.4100e-08 0)
swb_op0_n100_rh_s0p1_r0_ic ref_op0_n100_rh_s0p1_r0_ic wbl_op0_n100_rh_s0p1_r0_ic wbc_op0_n100_rh_s0p1_r0_ic 0 swwbl
cwbl_op0_n100_rh_s0p1_r0_ic wbl_op0_n100_rh_s0p1_r0_ic 0 {C_WBL}
spa_op0_n100_rh_s0p1_r0_ic prea rbl_op0_n100_rh_s0p1_r0_ic ctl_op0_n100_rh_s0p1_r0_ic 0 swpre
spr_op0_n100_rh_s0p1_r0_ic pref ref_op0_n100_rh_s0p1_r0_ic ctl_op0_n100_rh_s0p1_r0_ic 0 swpre
crbl_op0_n100_rh_s0p1_r0_ic rbl_op0_n100_rh_s0p1_r0_ic 0 {C_RBL}
cref_op0_n100_rh_s0p1_r0_ic ref_op0_n100_rh_s0p1_r0_ic 0 {C_RBL}   $ ASSUMPTION: ideal matched dummy load
XMWR_op0_n100_rh_s0p1_r0_ic_0 sn_op0_n100_rh_s0p1_r0_ic_0 wwl_op0_n100_rh_s0p1_r0_ic wbl_op0_n100_rh_s0p1_r0_ic 0 sky130_fd_pr__nfet_01v8 L=0.15 W=0.42 nf=1 ad=0.1218 as=0.1218 pd=1.42 ps=1.42 nrd=0.69047619047619  nrs=0.69047619047619 sa=0 sb=0 sd=0 mult=1 m=1
XMRD_op0_n100_rh_s0p1_r0_ic_0 rbl_op0_n100_rh_s0p1_r0_ic sn_op0_n100_rh_s0p1_r0_ic_0 rwls_op0_n100_rh_s0p1_r0_ic 0 sky130_fd_pr__nfet_01v8 L=0.15 W=0.42 nf=1 ad=0.1218 as=0.1218 pd=1.42 ps=1.42 nrd=0.69047619047619  nrs=0.69047619047619 sa=0 sb=0 sd=0 mult=1 m=1
csn_op0_n100_rh_s0p1_r0_ic_0 sn_op0_n100_rh_s0p1_r0_ic_0 0 {C_SN}
XMWR_op0_n100_rh_s0p1_r0_ic_1 sn_op0_n100_rh_s0p1_r0_ic_1 wwl_des wbl_op0_n100_rh_s0p1_r0_ic 0 sky130_fd_pr__nfet_01v8 L=0.15 W=0.42 nf=1 ad=0.1218 as=0.1218 pd=1.42 ps=1.42 nrd=0.69047619047619  nrs=0.69047619047619 sa=0 sb=0 sd=0 mult=1 m=1
XMRD_op0_n100_rh_s0p1_r0_ic_1 rbl_op0_n100_rh_s0p1_r0_ic sn_op0_n100_rh_s0p1_r0_ic_1 rwl_des 0 sky130_fd_pr__nfet_01v8 L=0.15 W=0.42 nf=1 ad=0.1218 as=0.1218 pd=1.42 ps=1.42 nrd=0.69047619047619  nrs=0.69047619047619 sa=0 sb=0 sd=0 mult=1 m=1
csn_op0_n100_rh_s0p1_r0_ic_1 sn_op0_n100_rh_s0p1_r0_ic_1 0 {C_SN}
XMWR_op0_n100_rh_s0p1_r0_ic_2 sn_op0_n100_rh_s0p1_r0_ic_2 wwl_des wbl_op0_n100_rh_s0p1_r0_ic 0 sky130_fd_pr__nfet_01v8 L=0.15 W=0.42 nf=1 ad=0.1218 as=0.1218 pd=1.42 ps=1.42 nrd=0.69047619047619  nrs=0.69047619047619 sa=0 sb=0 sd=0 mult=1 m=1
XMRD_op0_n100_rh_s0p1_r0_ic_2 rbl_op0_n100_rh_s0p1_r0_ic sn_op0_n100_rh_s0p1_r0_ic_2 rwl_des 0 sky130_fd_pr__nfet_01v8 L=0.15 W=0.42 nf=1 ad=0.1218 as=0.1218 pd=1.42 ps=1.42 nrd=0.69047619047619  nrs=0.69047619047619 sa=0 sb=0 sd=0 mult=1 m=1
csn_op0_n100_rh_s0p1_r0_ic_2 sn_op0_n100_rh_s0p1_r0_ic_2 0 {C_SN}
XMWR_op0_n100_rh_s0p1_r0_ic_3 sn_op0_n100_rh_s0p1_r0_ic_3 wwl_des wbl_op0_n100_rh_s0p1_r0_ic 0 sky130_fd_pr__nfet_01v8 L=0.15 W=0.42 nf=1 ad=0.1218 as=0.1218 pd=1.42 ps=1.42 nrd=0.69047619047619  nrs=0.69047619047619 sa=0 sb=0 sd=0 mult=1 m=1
XMRD_op0_n100_rh_s0p1_r0_ic_3 rbl_op0_n100_rh_s0p1_r0_ic sn_op0_n100_rh_s0p1_r0_ic_3 rwl_des 0 sky130_fd_pr__nfet_01v8 L=0.15 W=0.42 nf=1 ad=0.1218 as=0.1218 pd=1.42 ps=1.42 nrd=0.69047619047619  nrs=0.69047619047619 sa=0 sb=0 sd=0 mult=1 m=1
csn_op0_n100_rh_s0p1_r0_ic_3 sn_op0_n100_rh_s0p1_r0_ic_3 0 {C_SN}
XMN1_op0_n100_rh_s0p1_r0_ic rbl_op0_n100_rh_s0p1_r0_ic ref_op0_n100_rh_s0p1_r0_ic vn_op0_n100_rh_s0p1_r0_ic 0 sky130_fd_pr__nfet_01v8 L=0.15 W=1 nf=1 ad=0.29 as=0.29 pd=2.58 ps=2.58 mult=1 m=1
XMN2_op0_n100_rh_s0p1_r0_ic ref_op0_n100_rh_s0p1_r0_ic rbl_op0_n100_rh_s0p1_r0_ic vn_op0_n100_rh_s0p1_r0_ic 0 sky130_fd_pr__nfet_01v8 L=0.15 W=1 nf=1 ad=0.29 as=0.29 pd=2.58 ps=2.58 mult=1 m=1
XMP1_op0_n100_rh_s0p1_r0_ic rbl_op0_n100_rh_s0p1_r0_ic ref_op0_n100_rh_s0p1_r0_ic vp_op0_n100_rh_s0p1_r0_ic vdd sky130_fd_pr__pfet_01v8 L=0.15 W=2 nf=1 ad=0.58 as=0.58 pd=4.58 ps=4.58 mult=1 m=1
XMP2_op0_n100_rh_s0p1_r0_ic ref_op0_n100_rh_s0p1_r0_ic rbl_op0_n100_rh_s0p1_r0_ic vp_op0_n100_rh_s0p1_r0_ic vdd sky130_fd_pr__pfet_01v8 L=0.15 W=2 nf=1 ad=0.58 as=0.58 pd=4.58 ps=4.58 mult=1 m=1
XMNF_op0_n100_rh_s0p1_r0_ic vn_op0_n100_rh_s0p1_r0_ic en_op0_n100_rh_s0p1_r0_ic 0 0 sky130_fd_pr__nfet_01v8 L=0.15 W=2 nf=1 ad=0.58 as=0.58 pd=4.58 ps=4.58 mult=1 m=1
XMPH_op0_n100_rh_s0p1_r0_ic vp_op0_n100_rh_s0p1_r0_ic enb_op0_n100_rh_s0p1_r0_ic vdd vdd sky130_fd_pr__pfet_01v8 L=0.15 W=4 nf=1 ad=1.16 as=1.16 pd=8.58 ps=8.58 mult=1 m=1
bd_op0_n100_rh_s0p1_r0_ic d_op0_n100_rh_s0p1_r0_ic 0 v=v(rbl_op0_n100_rh_s0p1_r0_ic)-v(ref_op0_n100_rh_s0p1_r0_ic)

* ---- instance 324: op0_0000_rh_s0p1_r0_ic (variant rh_s0p1_r0_ic; probe dec 11.9 ns, release 34 ns, meas 36 ns) ----
vctl_op0_0000_rh_s0p1_r0_ic ctl_op0_0000_rh_s0p1_r0_ic 0 pwl(0.0000e+00 {VDD} 2.0000e-09 {VDD} 2.1000e-09 0)
* RWL driver model (EXPERIMENTAL): slew 0.1 ns, series R 0 ohm; cell pin = rwls_op0_0000_rh_s0p1_r0_ic
vrs_op0_0000_rh_s0p1_r0_ic rwls_op0_0000_rh_s0p1_r0_ic 0 pwl(0.0000e+00 {VDD} 2.0000e-09 {VDD} 2.1000e-09 0 1.2000e-08 0 1.2100e-08 {VDD})
ven_op0_0000_rh_s0p1_r0_ic en_op0_0000_rh_s0p1_r0_ic 0 pwl(0.0000e+00 0 1.1000e-08 0 1.1100e-08 {VDD} 3.4000e-08 {VDD} 3.4100e-08 0)
venb_op0_0000_rh_s0p1_r0_ic enb_op0_0000_rh_s0p1_r0_ic 0 pwl(0.0000e+00 {VDD} 1.1000e-08 {VDD} 1.1100e-08 0 3.4000e-08 0 3.4100e-08 {VDD})
vww_op0_0000_rh_s0p1_r0_ic wwl_op0_0000_rh_s0p1_r0_ic 0 pwl(0.0000e+00 0 1.2000e-08 0 1.2100e-08 {VDD} 3.2000e-08 {VDD} 3.2100e-08 0)
vwc_op0_0000_rh_s0p1_r0_ic wbc_op0_0000_rh_s0p1_r0_ic 0 pwl(0.0000e+00 0 1.2000e-08 0 1.2100e-08 {VDD} 3.4000e-08 {VDD} 3.4100e-08 0)
swb_op0_0000_rh_s0p1_r0_ic ref_op0_0000_rh_s0p1_r0_ic wbl_op0_0000_rh_s0p1_r0_ic wbc_op0_0000_rh_s0p1_r0_ic 0 swwbl
cwbl_op0_0000_rh_s0p1_r0_ic wbl_op0_0000_rh_s0p1_r0_ic 0 {C_WBL}
spa_op0_0000_rh_s0p1_r0_ic prea rbl_op0_0000_rh_s0p1_r0_ic ctl_op0_0000_rh_s0p1_r0_ic 0 swpre
spr_op0_0000_rh_s0p1_r0_ic pref ref_op0_0000_rh_s0p1_r0_ic ctl_op0_0000_rh_s0p1_r0_ic 0 swpre
crbl_op0_0000_rh_s0p1_r0_ic rbl_op0_0000_rh_s0p1_r0_ic 0 {C_RBL}
cref_op0_0000_rh_s0p1_r0_ic ref_op0_0000_rh_s0p1_r0_ic 0 {C_RBL}   $ ASSUMPTION: ideal matched dummy load
XMWR_op0_0000_rh_s0p1_r0_ic_0 sn_op0_0000_rh_s0p1_r0_ic_0 wwl_op0_0000_rh_s0p1_r0_ic wbl_op0_0000_rh_s0p1_r0_ic 0 sky130_fd_pr__nfet_01v8 L=0.15 W=0.42 nf=1 ad=0.1218 as=0.1218 pd=1.42 ps=1.42 nrd=0.69047619047619  nrs=0.69047619047619 sa=0 sb=0 sd=0 mult=1 m=1
XMRD_op0_0000_rh_s0p1_r0_ic_0 rbl_op0_0000_rh_s0p1_r0_ic sn_op0_0000_rh_s0p1_r0_ic_0 rwls_op0_0000_rh_s0p1_r0_ic 0 sky130_fd_pr__nfet_01v8 L=0.15 W=0.42 nf=1 ad=0.1218 as=0.1218 pd=1.42 ps=1.42 nrd=0.69047619047619  nrs=0.69047619047619 sa=0 sb=0 sd=0 mult=1 m=1
csn_op0_0000_rh_s0p1_r0_ic_0 sn_op0_0000_rh_s0p1_r0_ic_0 0 {C_SN}
XMWR_op0_0000_rh_s0p1_r0_ic_1 sn_op0_0000_rh_s0p1_r0_ic_1 wwl_des wbl_op0_0000_rh_s0p1_r0_ic 0 sky130_fd_pr__nfet_01v8 L=0.15 W=0.42 nf=1 ad=0.1218 as=0.1218 pd=1.42 ps=1.42 nrd=0.69047619047619  nrs=0.69047619047619 sa=0 sb=0 sd=0 mult=1 m=1
XMRD_op0_0000_rh_s0p1_r0_ic_1 rbl_op0_0000_rh_s0p1_r0_ic sn_op0_0000_rh_s0p1_r0_ic_1 rwl_des 0 sky130_fd_pr__nfet_01v8 L=0.15 W=0.42 nf=1 ad=0.1218 as=0.1218 pd=1.42 ps=1.42 nrd=0.69047619047619  nrs=0.69047619047619 sa=0 sb=0 sd=0 mult=1 m=1
csn_op0_0000_rh_s0p1_r0_ic_1 sn_op0_0000_rh_s0p1_r0_ic_1 0 {C_SN}
XMWR_op0_0000_rh_s0p1_r0_ic_2 sn_op0_0000_rh_s0p1_r0_ic_2 wwl_des wbl_op0_0000_rh_s0p1_r0_ic 0 sky130_fd_pr__nfet_01v8 L=0.15 W=0.42 nf=1 ad=0.1218 as=0.1218 pd=1.42 ps=1.42 nrd=0.69047619047619  nrs=0.69047619047619 sa=0 sb=0 sd=0 mult=1 m=1
XMRD_op0_0000_rh_s0p1_r0_ic_2 rbl_op0_0000_rh_s0p1_r0_ic sn_op0_0000_rh_s0p1_r0_ic_2 rwl_des 0 sky130_fd_pr__nfet_01v8 L=0.15 W=0.42 nf=1 ad=0.1218 as=0.1218 pd=1.42 ps=1.42 nrd=0.69047619047619  nrs=0.69047619047619 sa=0 sb=0 sd=0 mult=1 m=1
csn_op0_0000_rh_s0p1_r0_ic_2 sn_op0_0000_rh_s0p1_r0_ic_2 0 {C_SN}
XMWR_op0_0000_rh_s0p1_r0_ic_3 sn_op0_0000_rh_s0p1_r0_ic_3 wwl_des wbl_op0_0000_rh_s0p1_r0_ic 0 sky130_fd_pr__nfet_01v8 L=0.15 W=0.42 nf=1 ad=0.1218 as=0.1218 pd=1.42 ps=1.42 nrd=0.69047619047619  nrs=0.69047619047619 sa=0 sb=0 sd=0 mult=1 m=1
XMRD_op0_0000_rh_s0p1_r0_ic_3 rbl_op0_0000_rh_s0p1_r0_ic sn_op0_0000_rh_s0p1_r0_ic_3 rwl_des 0 sky130_fd_pr__nfet_01v8 L=0.15 W=0.42 nf=1 ad=0.1218 as=0.1218 pd=1.42 ps=1.42 nrd=0.69047619047619  nrs=0.69047619047619 sa=0 sb=0 sd=0 mult=1 m=1
csn_op0_0000_rh_s0p1_r0_ic_3 sn_op0_0000_rh_s0p1_r0_ic_3 0 {C_SN}
XMN1_op0_0000_rh_s0p1_r0_ic rbl_op0_0000_rh_s0p1_r0_ic ref_op0_0000_rh_s0p1_r0_ic vn_op0_0000_rh_s0p1_r0_ic 0 sky130_fd_pr__nfet_01v8 L=0.15 W=1 nf=1 ad=0.29 as=0.29 pd=2.58 ps=2.58 mult=1 m=1
XMN2_op0_0000_rh_s0p1_r0_ic ref_op0_0000_rh_s0p1_r0_ic rbl_op0_0000_rh_s0p1_r0_ic vn_op0_0000_rh_s0p1_r0_ic 0 sky130_fd_pr__nfet_01v8 L=0.15 W=1 nf=1 ad=0.29 as=0.29 pd=2.58 ps=2.58 mult=1 m=1
XMP1_op0_0000_rh_s0p1_r0_ic rbl_op0_0000_rh_s0p1_r0_ic ref_op0_0000_rh_s0p1_r0_ic vp_op0_0000_rh_s0p1_r0_ic vdd sky130_fd_pr__pfet_01v8 L=0.15 W=2 nf=1 ad=0.58 as=0.58 pd=4.58 ps=4.58 mult=1 m=1
XMP2_op0_0000_rh_s0p1_r0_ic ref_op0_0000_rh_s0p1_r0_ic rbl_op0_0000_rh_s0p1_r0_ic vp_op0_0000_rh_s0p1_r0_ic vdd sky130_fd_pr__pfet_01v8 L=0.15 W=2 nf=1 ad=0.58 as=0.58 pd=4.58 ps=4.58 mult=1 m=1
XMNF_op0_0000_rh_s0p1_r0_ic vn_op0_0000_rh_s0p1_r0_ic en_op0_0000_rh_s0p1_r0_ic 0 0 sky130_fd_pr__nfet_01v8 L=0.15 W=2 nf=1 ad=0.58 as=0.58 pd=4.58 ps=4.58 mult=1 m=1
XMPH_op0_0000_rh_s0p1_r0_ic vp_op0_0000_rh_s0p1_r0_ic enb_op0_0000_rh_s0p1_r0_ic vdd vdd sky130_fd_pr__pfet_01v8 L=0.15 W=4 nf=1 ad=1.16 as=1.16 pd=8.58 ps=8.58 mult=1 m=1
bd_op0_0000_rh_s0p1_r0_ic d_op0_0000_rh_s0p1_r0_ic 0 v=v(rbl_op0_0000_rh_s0p1_r0_ic)-v(ref_op0_0000_rh_s0p1_r0_ic)

* ---- instance 325: op1_0900_rl_s0p1_r0_ic (variant rl_s0p1_r0_ic; probe dec 11.9 ns, release 34 ns, meas 36 ns) ----
vctl_op1_0900_rl_s0p1_r0_ic ctl_op1_0900_rl_s0p1_r0_ic 0 pwl(0.0000e+00 {VDD} 2.0000e-09 {VDD} 2.1000e-09 0)
* RWL driver model (EXPERIMENTAL): slew 0.1 ns, series R 0 ohm; cell pin = rwls_op1_0900_rl_s0p1_r0_ic
vrs_op1_0900_rl_s0p1_r0_ic rwls_op1_0900_rl_s0p1_r0_ic 0 pwl(0.0000e+00 {VDD} 2.0000e-09 {VDD} 2.1000e-09 0 3.4000e-08 0 3.4100e-08 {VDD})
ven_op1_0900_rl_s0p1_r0_ic en_op1_0900_rl_s0p1_r0_ic 0 pwl(0.0000e+00 0 1.1000e-08 0 1.1100e-08 {VDD} 3.4000e-08 {VDD} 3.4100e-08 0)
venb_op1_0900_rl_s0p1_r0_ic enb_op1_0900_rl_s0p1_r0_ic 0 pwl(0.0000e+00 {VDD} 1.1000e-08 {VDD} 1.1100e-08 0 3.4000e-08 0 3.4100e-08 {VDD})
vww_op1_0900_rl_s0p1_r0_ic wwl_op1_0900_rl_s0p1_r0_ic 0 pwl(0.0000e+00 0 1.2000e-08 0 1.2100e-08 {VDD} 3.2000e-08 {VDD} 3.2100e-08 0)
vwc_op1_0900_rl_s0p1_r0_ic wbc_op1_0900_rl_s0p1_r0_ic 0 pwl(0.0000e+00 0 1.2000e-08 0 1.2100e-08 {VDD} 3.4000e-08 {VDD} 3.4100e-08 0)
swb_op1_0900_rl_s0p1_r0_ic ref_op1_0900_rl_s0p1_r0_ic wbl_op1_0900_rl_s0p1_r0_ic wbc_op1_0900_rl_s0p1_r0_ic 0 swwbl
cwbl_op1_0900_rl_s0p1_r0_ic wbl_op1_0900_rl_s0p1_r0_ic 0 {C_WBL}
spa_op1_0900_rl_s0p1_r0_ic prea rbl_op1_0900_rl_s0p1_r0_ic ctl_op1_0900_rl_s0p1_r0_ic 0 swpre
spr_op1_0900_rl_s0p1_r0_ic pref ref_op1_0900_rl_s0p1_r0_ic ctl_op1_0900_rl_s0p1_r0_ic 0 swpre
crbl_op1_0900_rl_s0p1_r0_ic rbl_op1_0900_rl_s0p1_r0_ic 0 {C_RBL}
cref_op1_0900_rl_s0p1_r0_ic ref_op1_0900_rl_s0p1_r0_ic 0 {C_RBL}   $ ASSUMPTION: ideal matched dummy load
XMWR_op1_0900_rl_s0p1_r0_ic_0 sn_op1_0900_rl_s0p1_r0_ic_0 wwl_op1_0900_rl_s0p1_r0_ic wbl_op1_0900_rl_s0p1_r0_ic 0 sky130_fd_pr__nfet_01v8 L=0.15 W=0.42 nf=1 ad=0.1218 as=0.1218 pd=1.42 ps=1.42 nrd=0.69047619047619  nrs=0.69047619047619 sa=0 sb=0 sd=0 mult=1 m=1
XMRD_op1_0900_rl_s0p1_r0_ic_0 rbl_op1_0900_rl_s0p1_r0_ic sn_op1_0900_rl_s0p1_r0_ic_0 rwls_op1_0900_rl_s0p1_r0_ic 0 sky130_fd_pr__nfet_01v8 L=0.15 W=0.42 nf=1 ad=0.1218 as=0.1218 pd=1.42 ps=1.42 nrd=0.69047619047619  nrs=0.69047619047619 sa=0 sb=0 sd=0 mult=1 m=1
csn_op1_0900_rl_s0p1_r0_ic_0 sn_op1_0900_rl_s0p1_r0_ic_0 0 {C_SN}
XMWR_op1_0900_rl_s0p1_r0_ic_1 sn_op1_0900_rl_s0p1_r0_ic_1 wwl_des wbl_op1_0900_rl_s0p1_r0_ic 0 sky130_fd_pr__nfet_01v8 L=0.15 W=0.42 nf=1 ad=0.1218 as=0.1218 pd=1.42 ps=1.42 nrd=0.69047619047619  nrs=0.69047619047619 sa=0 sb=0 sd=0 mult=1 m=1
XMRD_op1_0900_rl_s0p1_r0_ic_1 rbl_op1_0900_rl_s0p1_r0_ic sn_op1_0900_rl_s0p1_r0_ic_1 rwl_des 0 sky130_fd_pr__nfet_01v8 L=0.15 W=0.42 nf=1 ad=0.1218 as=0.1218 pd=1.42 ps=1.42 nrd=0.69047619047619  nrs=0.69047619047619 sa=0 sb=0 sd=0 mult=1 m=1
csn_op1_0900_rl_s0p1_r0_ic_1 sn_op1_0900_rl_s0p1_r0_ic_1 0 {C_SN}
XMWR_op1_0900_rl_s0p1_r0_ic_2 sn_op1_0900_rl_s0p1_r0_ic_2 wwl_des wbl_op1_0900_rl_s0p1_r0_ic 0 sky130_fd_pr__nfet_01v8 L=0.15 W=0.42 nf=1 ad=0.1218 as=0.1218 pd=1.42 ps=1.42 nrd=0.69047619047619  nrs=0.69047619047619 sa=0 sb=0 sd=0 mult=1 m=1
XMRD_op1_0900_rl_s0p1_r0_ic_2 rbl_op1_0900_rl_s0p1_r0_ic sn_op1_0900_rl_s0p1_r0_ic_2 rwl_des 0 sky130_fd_pr__nfet_01v8 L=0.15 W=0.42 nf=1 ad=0.1218 as=0.1218 pd=1.42 ps=1.42 nrd=0.69047619047619  nrs=0.69047619047619 sa=0 sb=0 sd=0 mult=1 m=1
csn_op1_0900_rl_s0p1_r0_ic_2 sn_op1_0900_rl_s0p1_r0_ic_2 0 {C_SN}
XMWR_op1_0900_rl_s0p1_r0_ic_3 sn_op1_0900_rl_s0p1_r0_ic_3 wwl_des wbl_op1_0900_rl_s0p1_r0_ic 0 sky130_fd_pr__nfet_01v8 L=0.15 W=0.42 nf=1 ad=0.1218 as=0.1218 pd=1.42 ps=1.42 nrd=0.69047619047619  nrs=0.69047619047619 sa=0 sb=0 sd=0 mult=1 m=1
XMRD_op1_0900_rl_s0p1_r0_ic_3 rbl_op1_0900_rl_s0p1_r0_ic sn_op1_0900_rl_s0p1_r0_ic_3 rwl_des 0 sky130_fd_pr__nfet_01v8 L=0.15 W=0.42 nf=1 ad=0.1218 as=0.1218 pd=1.42 ps=1.42 nrd=0.69047619047619  nrs=0.69047619047619 sa=0 sb=0 sd=0 mult=1 m=1
csn_op1_0900_rl_s0p1_r0_ic_3 sn_op1_0900_rl_s0p1_r0_ic_3 0 {C_SN}
XMN1_op1_0900_rl_s0p1_r0_ic rbl_op1_0900_rl_s0p1_r0_ic ref_op1_0900_rl_s0p1_r0_ic vn_op1_0900_rl_s0p1_r0_ic 0 sky130_fd_pr__nfet_01v8 L=0.15 W=1 nf=1 ad=0.29 as=0.29 pd=2.58 ps=2.58 mult=1 m=1
XMN2_op1_0900_rl_s0p1_r0_ic ref_op1_0900_rl_s0p1_r0_ic rbl_op1_0900_rl_s0p1_r0_ic vn_op1_0900_rl_s0p1_r0_ic 0 sky130_fd_pr__nfet_01v8 L=0.15 W=1 nf=1 ad=0.29 as=0.29 pd=2.58 ps=2.58 mult=1 m=1
XMP1_op1_0900_rl_s0p1_r0_ic rbl_op1_0900_rl_s0p1_r0_ic ref_op1_0900_rl_s0p1_r0_ic vp_op1_0900_rl_s0p1_r0_ic vdd sky130_fd_pr__pfet_01v8 L=0.15 W=2 nf=1 ad=0.58 as=0.58 pd=4.58 ps=4.58 mult=1 m=1
XMP2_op1_0900_rl_s0p1_r0_ic ref_op1_0900_rl_s0p1_r0_ic rbl_op1_0900_rl_s0p1_r0_ic vp_op1_0900_rl_s0p1_r0_ic vdd sky130_fd_pr__pfet_01v8 L=0.15 W=2 nf=1 ad=0.58 as=0.58 pd=4.58 ps=4.58 mult=1 m=1
XMNF_op1_0900_rl_s0p1_r0_ic vn_op1_0900_rl_s0p1_r0_ic en_op1_0900_rl_s0p1_r0_ic 0 0 sky130_fd_pr__nfet_01v8 L=0.15 W=2 nf=1 ad=0.58 as=0.58 pd=4.58 ps=4.58 mult=1 m=1
XMPH_op1_0900_rl_s0p1_r0_ic vp_op1_0900_rl_s0p1_r0_ic enb_op1_0900_rl_s0p1_r0_ic vdd vdd sky130_fd_pr__pfet_01v8 L=0.15 W=4 nf=1 ad=1.16 as=1.16 pd=8.58 ps=8.58 mult=1 m=1
bd_op1_0900_rl_s0p1_r0_ic d_op1_0900_rl_s0p1_r0_ic 0 v=v(rbl_op1_0900_rl_s0p1_r0_ic)-v(ref_op1_0900_rl_s0p1_r0_ic)

* ---- instance 326: op1_1000_rl_s0p1_r0_ic (variant rl_s0p1_r0_ic; probe dec 11.9 ns, release 34 ns, meas 36 ns) ----
vctl_op1_1000_rl_s0p1_r0_ic ctl_op1_1000_rl_s0p1_r0_ic 0 pwl(0.0000e+00 {VDD} 2.0000e-09 {VDD} 2.1000e-09 0)
* RWL driver model (EXPERIMENTAL): slew 0.1 ns, series R 0 ohm; cell pin = rwls_op1_1000_rl_s0p1_r0_ic
vrs_op1_1000_rl_s0p1_r0_ic rwls_op1_1000_rl_s0p1_r0_ic 0 pwl(0.0000e+00 {VDD} 2.0000e-09 {VDD} 2.1000e-09 0 3.4000e-08 0 3.4100e-08 {VDD})
ven_op1_1000_rl_s0p1_r0_ic en_op1_1000_rl_s0p1_r0_ic 0 pwl(0.0000e+00 0 1.1000e-08 0 1.1100e-08 {VDD} 3.4000e-08 {VDD} 3.4100e-08 0)
venb_op1_1000_rl_s0p1_r0_ic enb_op1_1000_rl_s0p1_r0_ic 0 pwl(0.0000e+00 {VDD} 1.1000e-08 {VDD} 1.1100e-08 0 3.4000e-08 0 3.4100e-08 {VDD})
vww_op1_1000_rl_s0p1_r0_ic wwl_op1_1000_rl_s0p1_r0_ic 0 pwl(0.0000e+00 0 1.2000e-08 0 1.2100e-08 {VDD} 3.2000e-08 {VDD} 3.2100e-08 0)
vwc_op1_1000_rl_s0p1_r0_ic wbc_op1_1000_rl_s0p1_r0_ic 0 pwl(0.0000e+00 0 1.2000e-08 0 1.2100e-08 {VDD} 3.4000e-08 {VDD} 3.4100e-08 0)
swb_op1_1000_rl_s0p1_r0_ic ref_op1_1000_rl_s0p1_r0_ic wbl_op1_1000_rl_s0p1_r0_ic wbc_op1_1000_rl_s0p1_r0_ic 0 swwbl
cwbl_op1_1000_rl_s0p1_r0_ic wbl_op1_1000_rl_s0p1_r0_ic 0 {C_WBL}
spa_op1_1000_rl_s0p1_r0_ic prea rbl_op1_1000_rl_s0p1_r0_ic ctl_op1_1000_rl_s0p1_r0_ic 0 swpre
spr_op1_1000_rl_s0p1_r0_ic pref ref_op1_1000_rl_s0p1_r0_ic ctl_op1_1000_rl_s0p1_r0_ic 0 swpre
crbl_op1_1000_rl_s0p1_r0_ic rbl_op1_1000_rl_s0p1_r0_ic 0 {C_RBL}
cref_op1_1000_rl_s0p1_r0_ic ref_op1_1000_rl_s0p1_r0_ic 0 {C_RBL}   $ ASSUMPTION: ideal matched dummy load
XMWR_op1_1000_rl_s0p1_r0_ic_0 sn_op1_1000_rl_s0p1_r0_ic_0 wwl_op1_1000_rl_s0p1_r0_ic wbl_op1_1000_rl_s0p1_r0_ic 0 sky130_fd_pr__nfet_01v8 L=0.15 W=0.42 nf=1 ad=0.1218 as=0.1218 pd=1.42 ps=1.42 nrd=0.69047619047619  nrs=0.69047619047619 sa=0 sb=0 sd=0 mult=1 m=1
XMRD_op1_1000_rl_s0p1_r0_ic_0 rbl_op1_1000_rl_s0p1_r0_ic sn_op1_1000_rl_s0p1_r0_ic_0 rwls_op1_1000_rl_s0p1_r0_ic 0 sky130_fd_pr__nfet_01v8 L=0.15 W=0.42 nf=1 ad=0.1218 as=0.1218 pd=1.42 ps=1.42 nrd=0.69047619047619  nrs=0.69047619047619 sa=0 sb=0 sd=0 mult=1 m=1
csn_op1_1000_rl_s0p1_r0_ic_0 sn_op1_1000_rl_s0p1_r0_ic_0 0 {C_SN}
XMWR_op1_1000_rl_s0p1_r0_ic_1 sn_op1_1000_rl_s0p1_r0_ic_1 wwl_des wbl_op1_1000_rl_s0p1_r0_ic 0 sky130_fd_pr__nfet_01v8 L=0.15 W=0.42 nf=1 ad=0.1218 as=0.1218 pd=1.42 ps=1.42 nrd=0.69047619047619  nrs=0.69047619047619 sa=0 sb=0 sd=0 mult=1 m=1
XMRD_op1_1000_rl_s0p1_r0_ic_1 rbl_op1_1000_rl_s0p1_r0_ic sn_op1_1000_rl_s0p1_r0_ic_1 rwl_des 0 sky130_fd_pr__nfet_01v8 L=0.15 W=0.42 nf=1 ad=0.1218 as=0.1218 pd=1.42 ps=1.42 nrd=0.69047619047619  nrs=0.69047619047619 sa=0 sb=0 sd=0 mult=1 m=1
csn_op1_1000_rl_s0p1_r0_ic_1 sn_op1_1000_rl_s0p1_r0_ic_1 0 {C_SN}
XMWR_op1_1000_rl_s0p1_r0_ic_2 sn_op1_1000_rl_s0p1_r0_ic_2 wwl_des wbl_op1_1000_rl_s0p1_r0_ic 0 sky130_fd_pr__nfet_01v8 L=0.15 W=0.42 nf=1 ad=0.1218 as=0.1218 pd=1.42 ps=1.42 nrd=0.69047619047619  nrs=0.69047619047619 sa=0 sb=0 sd=0 mult=1 m=1
XMRD_op1_1000_rl_s0p1_r0_ic_2 rbl_op1_1000_rl_s0p1_r0_ic sn_op1_1000_rl_s0p1_r0_ic_2 rwl_des 0 sky130_fd_pr__nfet_01v8 L=0.15 W=0.42 nf=1 ad=0.1218 as=0.1218 pd=1.42 ps=1.42 nrd=0.69047619047619  nrs=0.69047619047619 sa=0 sb=0 sd=0 mult=1 m=1
csn_op1_1000_rl_s0p1_r0_ic_2 sn_op1_1000_rl_s0p1_r0_ic_2 0 {C_SN}
XMWR_op1_1000_rl_s0p1_r0_ic_3 sn_op1_1000_rl_s0p1_r0_ic_3 wwl_des wbl_op1_1000_rl_s0p1_r0_ic 0 sky130_fd_pr__nfet_01v8 L=0.15 W=0.42 nf=1 ad=0.1218 as=0.1218 pd=1.42 ps=1.42 nrd=0.69047619047619  nrs=0.69047619047619 sa=0 sb=0 sd=0 mult=1 m=1
XMRD_op1_1000_rl_s0p1_r0_ic_3 rbl_op1_1000_rl_s0p1_r0_ic sn_op1_1000_rl_s0p1_r0_ic_3 rwl_des 0 sky130_fd_pr__nfet_01v8 L=0.15 W=0.42 nf=1 ad=0.1218 as=0.1218 pd=1.42 ps=1.42 nrd=0.69047619047619  nrs=0.69047619047619 sa=0 sb=0 sd=0 mult=1 m=1
csn_op1_1000_rl_s0p1_r0_ic_3 sn_op1_1000_rl_s0p1_r0_ic_3 0 {C_SN}
XMN1_op1_1000_rl_s0p1_r0_ic rbl_op1_1000_rl_s0p1_r0_ic ref_op1_1000_rl_s0p1_r0_ic vn_op1_1000_rl_s0p1_r0_ic 0 sky130_fd_pr__nfet_01v8 L=0.15 W=1 nf=1 ad=0.29 as=0.29 pd=2.58 ps=2.58 mult=1 m=1
XMN2_op1_1000_rl_s0p1_r0_ic ref_op1_1000_rl_s0p1_r0_ic rbl_op1_1000_rl_s0p1_r0_ic vn_op1_1000_rl_s0p1_r0_ic 0 sky130_fd_pr__nfet_01v8 L=0.15 W=1 nf=1 ad=0.29 as=0.29 pd=2.58 ps=2.58 mult=1 m=1
XMP1_op1_1000_rl_s0p1_r0_ic rbl_op1_1000_rl_s0p1_r0_ic ref_op1_1000_rl_s0p1_r0_ic vp_op1_1000_rl_s0p1_r0_ic vdd sky130_fd_pr__pfet_01v8 L=0.15 W=2 nf=1 ad=0.58 as=0.58 pd=4.58 ps=4.58 mult=1 m=1
XMP2_op1_1000_rl_s0p1_r0_ic ref_op1_1000_rl_s0p1_r0_ic rbl_op1_1000_rl_s0p1_r0_ic vp_op1_1000_rl_s0p1_r0_ic vdd sky130_fd_pr__pfet_01v8 L=0.15 W=2 nf=1 ad=0.58 as=0.58 pd=4.58 ps=4.58 mult=1 m=1
XMNF_op1_1000_rl_s0p1_r0_ic vn_op1_1000_rl_s0p1_r0_ic en_op1_1000_rl_s0p1_r0_ic 0 0 sky130_fd_pr__nfet_01v8 L=0.15 W=2 nf=1 ad=0.58 as=0.58 pd=4.58 ps=4.58 mult=1 m=1
XMPH_op1_1000_rl_s0p1_r0_ic vp_op1_1000_rl_s0p1_r0_ic enb_op1_1000_rl_s0p1_r0_ic vdd vdd sky130_fd_pr__pfet_01v8 L=0.15 W=4 nf=1 ad=1.16 as=1.16 pd=8.58 ps=8.58 mult=1 m=1
bd_op1_1000_rl_s0p1_r0_ic d_op1_1000_rl_s0p1_r0_ic 0 v=v(rbl_op1_1000_rl_s0p1_r0_ic)-v(ref_op1_1000_rl_s0p1_r0_ic)

* ---- instance 327: op0_n100_rl_s0p1_r0_ic (variant rl_s0p1_r0_ic; probe dec 11.9 ns, release 34 ns, meas 36 ns) ----
vctl_op0_n100_rl_s0p1_r0_ic ctl_op0_n100_rl_s0p1_r0_ic 0 pwl(0.0000e+00 {VDD} 2.0000e-09 {VDD} 2.1000e-09 0)
* RWL driver model (EXPERIMENTAL): slew 0.1 ns, series R 0 ohm; cell pin = rwls_op0_n100_rl_s0p1_r0_ic
vrs_op0_n100_rl_s0p1_r0_ic rwls_op0_n100_rl_s0p1_r0_ic 0 pwl(0.0000e+00 {VDD} 2.0000e-09 {VDD} 2.1000e-09 0 3.4000e-08 0 3.4100e-08 {VDD})
ven_op0_n100_rl_s0p1_r0_ic en_op0_n100_rl_s0p1_r0_ic 0 pwl(0.0000e+00 0 1.1000e-08 0 1.1100e-08 {VDD} 3.4000e-08 {VDD} 3.4100e-08 0)
venb_op0_n100_rl_s0p1_r0_ic enb_op0_n100_rl_s0p1_r0_ic 0 pwl(0.0000e+00 {VDD} 1.1000e-08 {VDD} 1.1100e-08 0 3.4000e-08 0 3.4100e-08 {VDD})
vww_op0_n100_rl_s0p1_r0_ic wwl_op0_n100_rl_s0p1_r0_ic 0 pwl(0.0000e+00 0 1.2000e-08 0 1.2100e-08 {VDD} 3.2000e-08 {VDD} 3.2100e-08 0)
vwc_op0_n100_rl_s0p1_r0_ic wbc_op0_n100_rl_s0p1_r0_ic 0 pwl(0.0000e+00 0 1.2000e-08 0 1.2100e-08 {VDD} 3.4000e-08 {VDD} 3.4100e-08 0)
swb_op0_n100_rl_s0p1_r0_ic ref_op0_n100_rl_s0p1_r0_ic wbl_op0_n100_rl_s0p1_r0_ic wbc_op0_n100_rl_s0p1_r0_ic 0 swwbl
cwbl_op0_n100_rl_s0p1_r0_ic wbl_op0_n100_rl_s0p1_r0_ic 0 {C_WBL}
spa_op0_n100_rl_s0p1_r0_ic prea rbl_op0_n100_rl_s0p1_r0_ic ctl_op0_n100_rl_s0p1_r0_ic 0 swpre
spr_op0_n100_rl_s0p1_r0_ic pref ref_op0_n100_rl_s0p1_r0_ic ctl_op0_n100_rl_s0p1_r0_ic 0 swpre
crbl_op0_n100_rl_s0p1_r0_ic rbl_op0_n100_rl_s0p1_r0_ic 0 {C_RBL}
cref_op0_n100_rl_s0p1_r0_ic ref_op0_n100_rl_s0p1_r0_ic 0 {C_RBL}   $ ASSUMPTION: ideal matched dummy load
XMWR_op0_n100_rl_s0p1_r0_ic_0 sn_op0_n100_rl_s0p1_r0_ic_0 wwl_op0_n100_rl_s0p1_r0_ic wbl_op0_n100_rl_s0p1_r0_ic 0 sky130_fd_pr__nfet_01v8 L=0.15 W=0.42 nf=1 ad=0.1218 as=0.1218 pd=1.42 ps=1.42 nrd=0.69047619047619  nrs=0.69047619047619 sa=0 sb=0 sd=0 mult=1 m=1
XMRD_op0_n100_rl_s0p1_r0_ic_0 rbl_op0_n100_rl_s0p1_r0_ic sn_op0_n100_rl_s0p1_r0_ic_0 rwls_op0_n100_rl_s0p1_r0_ic 0 sky130_fd_pr__nfet_01v8 L=0.15 W=0.42 nf=1 ad=0.1218 as=0.1218 pd=1.42 ps=1.42 nrd=0.69047619047619  nrs=0.69047619047619 sa=0 sb=0 sd=0 mult=1 m=1
csn_op0_n100_rl_s0p1_r0_ic_0 sn_op0_n100_rl_s0p1_r0_ic_0 0 {C_SN}
XMWR_op0_n100_rl_s0p1_r0_ic_1 sn_op0_n100_rl_s0p1_r0_ic_1 wwl_des wbl_op0_n100_rl_s0p1_r0_ic 0 sky130_fd_pr__nfet_01v8 L=0.15 W=0.42 nf=1 ad=0.1218 as=0.1218 pd=1.42 ps=1.42 nrd=0.69047619047619  nrs=0.69047619047619 sa=0 sb=0 sd=0 mult=1 m=1
XMRD_op0_n100_rl_s0p1_r0_ic_1 rbl_op0_n100_rl_s0p1_r0_ic sn_op0_n100_rl_s0p1_r0_ic_1 rwl_des 0 sky130_fd_pr__nfet_01v8 L=0.15 W=0.42 nf=1 ad=0.1218 as=0.1218 pd=1.42 ps=1.42 nrd=0.69047619047619  nrs=0.69047619047619 sa=0 sb=0 sd=0 mult=1 m=1
csn_op0_n100_rl_s0p1_r0_ic_1 sn_op0_n100_rl_s0p1_r0_ic_1 0 {C_SN}
XMWR_op0_n100_rl_s0p1_r0_ic_2 sn_op0_n100_rl_s0p1_r0_ic_2 wwl_des wbl_op0_n100_rl_s0p1_r0_ic 0 sky130_fd_pr__nfet_01v8 L=0.15 W=0.42 nf=1 ad=0.1218 as=0.1218 pd=1.42 ps=1.42 nrd=0.69047619047619  nrs=0.69047619047619 sa=0 sb=0 sd=0 mult=1 m=1
XMRD_op0_n100_rl_s0p1_r0_ic_2 rbl_op0_n100_rl_s0p1_r0_ic sn_op0_n100_rl_s0p1_r0_ic_2 rwl_des 0 sky130_fd_pr__nfet_01v8 L=0.15 W=0.42 nf=1 ad=0.1218 as=0.1218 pd=1.42 ps=1.42 nrd=0.69047619047619  nrs=0.69047619047619 sa=0 sb=0 sd=0 mult=1 m=1
csn_op0_n100_rl_s0p1_r0_ic_2 sn_op0_n100_rl_s0p1_r0_ic_2 0 {C_SN}
XMWR_op0_n100_rl_s0p1_r0_ic_3 sn_op0_n100_rl_s0p1_r0_ic_3 wwl_des wbl_op0_n100_rl_s0p1_r0_ic 0 sky130_fd_pr__nfet_01v8 L=0.15 W=0.42 nf=1 ad=0.1218 as=0.1218 pd=1.42 ps=1.42 nrd=0.69047619047619  nrs=0.69047619047619 sa=0 sb=0 sd=0 mult=1 m=1
XMRD_op0_n100_rl_s0p1_r0_ic_3 rbl_op0_n100_rl_s0p1_r0_ic sn_op0_n100_rl_s0p1_r0_ic_3 rwl_des 0 sky130_fd_pr__nfet_01v8 L=0.15 W=0.42 nf=1 ad=0.1218 as=0.1218 pd=1.42 ps=1.42 nrd=0.69047619047619  nrs=0.69047619047619 sa=0 sb=0 sd=0 mult=1 m=1
csn_op0_n100_rl_s0p1_r0_ic_3 sn_op0_n100_rl_s0p1_r0_ic_3 0 {C_SN}
XMN1_op0_n100_rl_s0p1_r0_ic rbl_op0_n100_rl_s0p1_r0_ic ref_op0_n100_rl_s0p1_r0_ic vn_op0_n100_rl_s0p1_r0_ic 0 sky130_fd_pr__nfet_01v8 L=0.15 W=1 nf=1 ad=0.29 as=0.29 pd=2.58 ps=2.58 mult=1 m=1
XMN2_op0_n100_rl_s0p1_r0_ic ref_op0_n100_rl_s0p1_r0_ic rbl_op0_n100_rl_s0p1_r0_ic vn_op0_n100_rl_s0p1_r0_ic 0 sky130_fd_pr__nfet_01v8 L=0.15 W=1 nf=1 ad=0.29 as=0.29 pd=2.58 ps=2.58 mult=1 m=1
XMP1_op0_n100_rl_s0p1_r0_ic rbl_op0_n100_rl_s0p1_r0_ic ref_op0_n100_rl_s0p1_r0_ic vp_op0_n100_rl_s0p1_r0_ic vdd sky130_fd_pr__pfet_01v8 L=0.15 W=2 nf=1 ad=0.58 as=0.58 pd=4.58 ps=4.58 mult=1 m=1
XMP2_op0_n100_rl_s0p1_r0_ic ref_op0_n100_rl_s0p1_r0_ic rbl_op0_n100_rl_s0p1_r0_ic vp_op0_n100_rl_s0p1_r0_ic vdd sky130_fd_pr__pfet_01v8 L=0.15 W=2 nf=1 ad=0.58 as=0.58 pd=4.58 ps=4.58 mult=1 m=1
XMNF_op0_n100_rl_s0p1_r0_ic vn_op0_n100_rl_s0p1_r0_ic en_op0_n100_rl_s0p1_r0_ic 0 0 sky130_fd_pr__nfet_01v8 L=0.15 W=2 nf=1 ad=0.58 as=0.58 pd=4.58 ps=4.58 mult=1 m=1
XMPH_op0_n100_rl_s0p1_r0_ic vp_op0_n100_rl_s0p1_r0_ic enb_op0_n100_rl_s0p1_r0_ic vdd vdd sky130_fd_pr__pfet_01v8 L=0.15 W=4 nf=1 ad=1.16 as=1.16 pd=8.58 ps=8.58 mult=1 m=1
bd_op0_n100_rl_s0p1_r0_ic d_op0_n100_rl_s0p1_r0_ic 0 v=v(rbl_op0_n100_rl_s0p1_r0_ic)-v(ref_op0_n100_rl_s0p1_r0_ic)

* ---- instance 328: op0_0000_rl_s0p1_r0_ic (variant rl_s0p1_r0_ic; probe dec 11.9 ns, release 34 ns, meas 36 ns) ----
vctl_op0_0000_rl_s0p1_r0_ic ctl_op0_0000_rl_s0p1_r0_ic 0 pwl(0.0000e+00 {VDD} 2.0000e-09 {VDD} 2.1000e-09 0)
* RWL driver model (EXPERIMENTAL): slew 0.1 ns, series R 0 ohm; cell pin = rwls_op0_0000_rl_s0p1_r0_ic
vrs_op0_0000_rl_s0p1_r0_ic rwls_op0_0000_rl_s0p1_r0_ic 0 pwl(0.0000e+00 {VDD} 2.0000e-09 {VDD} 2.1000e-09 0 3.4000e-08 0 3.4100e-08 {VDD})
ven_op0_0000_rl_s0p1_r0_ic en_op0_0000_rl_s0p1_r0_ic 0 pwl(0.0000e+00 0 1.1000e-08 0 1.1100e-08 {VDD} 3.4000e-08 {VDD} 3.4100e-08 0)
venb_op0_0000_rl_s0p1_r0_ic enb_op0_0000_rl_s0p1_r0_ic 0 pwl(0.0000e+00 {VDD} 1.1000e-08 {VDD} 1.1100e-08 0 3.4000e-08 0 3.4100e-08 {VDD})
vww_op0_0000_rl_s0p1_r0_ic wwl_op0_0000_rl_s0p1_r0_ic 0 pwl(0.0000e+00 0 1.2000e-08 0 1.2100e-08 {VDD} 3.2000e-08 {VDD} 3.2100e-08 0)
vwc_op0_0000_rl_s0p1_r0_ic wbc_op0_0000_rl_s0p1_r0_ic 0 pwl(0.0000e+00 0 1.2000e-08 0 1.2100e-08 {VDD} 3.4000e-08 {VDD} 3.4100e-08 0)
swb_op0_0000_rl_s0p1_r0_ic ref_op0_0000_rl_s0p1_r0_ic wbl_op0_0000_rl_s0p1_r0_ic wbc_op0_0000_rl_s0p1_r0_ic 0 swwbl
cwbl_op0_0000_rl_s0p1_r0_ic wbl_op0_0000_rl_s0p1_r0_ic 0 {C_WBL}
spa_op0_0000_rl_s0p1_r0_ic prea rbl_op0_0000_rl_s0p1_r0_ic ctl_op0_0000_rl_s0p1_r0_ic 0 swpre
spr_op0_0000_rl_s0p1_r0_ic pref ref_op0_0000_rl_s0p1_r0_ic ctl_op0_0000_rl_s0p1_r0_ic 0 swpre
crbl_op0_0000_rl_s0p1_r0_ic rbl_op0_0000_rl_s0p1_r0_ic 0 {C_RBL}
cref_op0_0000_rl_s0p1_r0_ic ref_op0_0000_rl_s0p1_r0_ic 0 {C_RBL}   $ ASSUMPTION: ideal matched dummy load
XMWR_op0_0000_rl_s0p1_r0_ic_0 sn_op0_0000_rl_s0p1_r0_ic_0 wwl_op0_0000_rl_s0p1_r0_ic wbl_op0_0000_rl_s0p1_r0_ic 0 sky130_fd_pr__nfet_01v8 L=0.15 W=0.42 nf=1 ad=0.1218 as=0.1218 pd=1.42 ps=1.42 nrd=0.69047619047619  nrs=0.69047619047619 sa=0 sb=0 sd=0 mult=1 m=1
XMRD_op0_0000_rl_s0p1_r0_ic_0 rbl_op0_0000_rl_s0p1_r0_ic sn_op0_0000_rl_s0p1_r0_ic_0 rwls_op0_0000_rl_s0p1_r0_ic 0 sky130_fd_pr__nfet_01v8 L=0.15 W=0.42 nf=1 ad=0.1218 as=0.1218 pd=1.42 ps=1.42 nrd=0.69047619047619  nrs=0.69047619047619 sa=0 sb=0 sd=0 mult=1 m=1
csn_op0_0000_rl_s0p1_r0_ic_0 sn_op0_0000_rl_s0p1_r0_ic_0 0 {C_SN}
XMWR_op0_0000_rl_s0p1_r0_ic_1 sn_op0_0000_rl_s0p1_r0_ic_1 wwl_des wbl_op0_0000_rl_s0p1_r0_ic 0 sky130_fd_pr__nfet_01v8 L=0.15 W=0.42 nf=1 ad=0.1218 as=0.1218 pd=1.42 ps=1.42 nrd=0.69047619047619  nrs=0.69047619047619 sa=0 sb=0 sd=0 mult=1 m=1
XMRD_op0_0000_rl_s0p1_r0_ic_1 rbl_op0_0000_rl_s0p1_r0_ic sn_op0_0000_rl_s0p1_r0_ic_1 rwl_des 0 sky130_fd_pr__nfet_01v8 L=0.15 W=0.42 nf=1 ad=0.1218 as=0.1218 pd=1.42 ps=1.42 nrd=0.69047619047619  nrs=0.69047619047619 sa=0 sb=0 sd=0 mult=1 m=1
csn_op0_0000_rl_s0p1_r0_ic_1 sn_op0_0000_rl_s0p1_r0_ic_1 0 {C_SN}
XMWR_op0_0000_rl_s0p1_r0_ic_2 sn_op0_0000_rl_s0p1_r0_ic_2 wwl_des wbl_op0_0000_rl_s0p1_r0_ic 0 sky130_fd_pr__nfet_01v8 L=0.15 W=0.42 nf=1 ad=0.1218 as=0.1218 pd=1.42 ps=1.42 nrd=0.69047619047619  nrs=0.69047619047619 sa=0 sb=0 sd=0 mult=1 m=1
XMRD_op0_0000_rl_s0p1_r0_ic_2 rbl_op0_0000_rl_s0p1_r0_ic sn_op0_0000_rl_s0p1_r0_ic_2 rwl_des 0 sky130_fd_pr__nfet_01v8 L=0.15 W=0.42 nf=1 ad=0.1218 as=0.1218 pd=1.42 ps=1.42 nrd=0.69047619047619  nrs=0.69047619047619 sa=0 sb=0 sd=0 mult=1 m=1
csn_op0_0000_rl_s0p1_r0_ic_2 sn_op0_0000_rl_s0p1_r0_ic_2 0 {C_SN}
XMWR_op0_0000_rl_s0p1_r0_ic_3 sn_op0_0000_rl_s0p1_r0_ic_3 wwl_des wbl_op0_0000_rl_s0p1_r0_ic 0 sky130_fd_pr__nfet_01v8 L=0.15 W=0.42 nf=1 ad=0.1218 as=0.1218 pd=1.42 ps=1.42 nrd=0.69047619047619  nrs=0.69047619047619 sa=0 sb=0 sd=0 mult=1 m=1
XMRD_op0_0000_rl_s0p1_r0_ic_3 rbl_op0_0000_rl_s0p1_r0_ic sn_op0_0000_rl_s0p1_r0_ic_3 rwl_des 0 sky130_fd_pr__nfet_01v8 L=0.15 W=0.42 nf=1 ad=0.1218 as=0.1218 pd=1.42 ps=1.42 nrd=0.69047619047619  nrs=0.69047619047619 sa=0 sb=0 sd=0 mult=1 m=1
csn_op0_0000_rl_s0p1_r0_ic_3 sn_op0_0000_rl_s0p1_r0_ic_3 0 {C_SN}
XMN1_op0_0000_rl_s0p1_r0_ic rbl_op0_0000_rl_s0p1_r0_ic ref_op0_0000_rl_s0p1_r0_ic vn_op0_0000_rl_s0p1_r0_ic 0 sky130_fd_pr__nfet_01v8 L=0.15 W=1 nf=1 ad=0.29 as=0.29 pd=2.58 ps=2.58 mult=1 m=1
XMN2_op0_0000_rl_s0p1_r0_ic ref_op0_0000_rl_s0p1_r0_ic rbl_op0_0000_rl_s0p1_r0_ic vn_op0_0000_rl_s0p1_r0_ic 0 sky130_fd_pr__nfet_01v8 L=0.15 W=1 nf=1 ad=0.29 as=0.29 pd=2.58 ps=2.58 mult=1 m=1
XMP1_op0_0000_rl_s0p1_r0_ic rbl_op0_0000_rl_s0p1_r0_ic ref_op0_0000_rl_s0p1_r0_ic vp_op0_0000_rl_s0p1_r0_ic vdd sky130_fd_pr__pfet_01v8 L=0.15 W=2 nf=1 ad=0.58 as=0.58 pd=4.58 ps=4.58 mult=1 m=1
XMP2_op0_0000_rl_s0p1_r0_ic ref_op0_0000_rl_s0p1_r0_ic rbl_op0_0000_rl_s0p1_r0_ic vp_op0_0000_rl_s0p1_r0_ic vdd sky130_fd_pr__pfet_01v8 L=0.15 W=2 nf=1 ad=0.58 as=0.58 pd=4.58 ps=4.58 mult=1 m=1
XMNF_op0_0000_rl_s0p1_r0_ic vn_op0_0000_rl_s0p1_r0_ic en_op0_0000_rl_s0p1_r0_ic 0 0 sky130_fd_pr__nfet_01v8 L=0.15 W=2 nf=1 ad=0.58 as=0.58 pd=4.58 ps=4.58 mult=1 m=1
XMPH_op0_0000_rl_s0p1_r0_ic vp_op0_0000_rl_s0p1_r0_ic enb_op0_0000_rl_s0p1_r0_ic vdd vdd sky130_fd_pr__pfet_01v8 L=0.15 W=4 nf=1 ad=1.16 as=1.16 pd=8.58 ps=8.58 mult=1 m=1
bd_op0_0000_rl_s0p1_r0_ic d_op0_0000_rl_s0p1_r0_ic 0 v=v(rbl_op0_0000_rl_s0p1_r0_ic)-v(ref_op0_0000_rl_s0p1_r0_ic)

* ---- instance 329: op1_0900_rl_s0p1_r1k_ic (variant rl_s0p1_r1k_ic; probe dec 11.9 ns, release 34 ns, meas 36 ns) ----
vctl_op1_0900_rl_s0p1_r1k_ic ctl_op1_0900_rl_s0p1_r1k_ic 0 pwl(0.0000e+00 {VDD} 2.0000e-09 {VDD} 2.1000e-09 0)
* RWL driver model (EXPERIMENTAL): slew 0.1 ns, series R 1000 ohm; cell pin = rwls_op1_0900_rl_s0p1_r1k_ic
vrs_op1_0900_rl_s0p1_r1k_ic rwlsrc_op1_0900_rl_s0p1_r1k_ic 0 pwl(0.0000e+00 {VDD} 2.0000e-09 {VDD} 2.1000e-09 0 3.4000e-08 0 3.4100e-08 {VDD})
rdrv_op1_0900_rl_s0p1_r1k_ic rwlsrc_op1_0900_rl_s0p1_r1k_ic rwls_op1_0900_rl_s0p1_r1k_ic 1000
ven_op1_0900_rl_s0p1_r1k_ic en_op1_0900_rl_s0p1_r1k_ic 0 pwl(0.0000e+00 0 1.1000e-08 0 1.1100e-08 {VDD} 3.4000e-08 {VDD} 3.4100e-08 0)
venb_op1_0900_rl_s0p1_r1k_ic enb_op1_0900_rl_s0p1_r1k_ic 0 pwl(0.0000e+00 {VDD} 1.1000e-08 {VDD} 1.1100e-08 0 3.4000e-08 0 3.4100e-08 {VDD})
vww_op1_0900_rl_s0p1_r1k_ic wwl_op1_0900_rl_s0p1_r1k_ic 0 pwl(0.0000e+00 0 1.2000e-08 0 1.2100e-08 {VDD} 3.2000e-08 {VDD} 3.2100e-08 0)
vwc_op1_0900_rl_s0p1_r1k_ic wbc_op1_0900_rl_s0p1_r1k_ic 0 pwl(0.0000e+00 0 1.2000e-08 0 1.2100e-08 {VDD} 3.4000e-08 {VDD} 3.4100e-08 0)
swb_op1_0900_rl_s0p1_r1k_ic ref_op1_0900_rl_s0p1_r1k_ic wbl_op1_0900_rl_s0p1_r1k_ic wbc_op1_0900_rl_s0p1_r1k_ic 0 swwbl
cwbl_op1_0900_rl_s0p1_r1k_ic wbl_op1_0900_rl_s0p1_r1k_ic 0 {C_WBL}
spa_op1_0900_rl_s0p1_r1k_ic prea rbl_op1_0900_rl_s0p1_r1k_ic ctl_op1_0900_rl_s0p1_r1k_ic 0 swpre
spr_op1_0900_rl_s0p1_r1k_ic pref ref_op1_0900_rl_s0p1_r1k_ic ctl_op1_0900_rl_s0p1_r1k_ic 0 swpre
crbl_op1_0900_rl_s0p1_r1k_ic rbl_op1_0900_rl_s0p1_r1k_ic 0 {C_RBL}
cref_op1_0900_rl_s0p1_r1k_ic ref_op1_0900_rl_s0p1_r1k_ic 0 {C_RBL}   $ ASSUMPTION: ideal matched dummy load
XMWR_op1_0900_rl_s0p1_r1k_ic_0 sn_op1_0900_rl_s0p1_r1k_ic_0 wwl_op1_0900_rl_s0p1_r1k_ic wbl_op1_0900_rl_s0p1_r1k_ic 0 sky130_fd_pr__nfet_01v8 L=0.15 W=0.42 nf=1 ad=0.1218 as=0.1218 pd=1.42 ps=1.42 nrd=0.69047619047619  nrs=0.69047619047619 sa=0 sb=0 sd=0 mult=1 m=1
XMRD_op1_0900_rl_s0p1_r1k_ic_0 rbl_op1_0900_rl_s0p1_r1k_ic sn_op1_0900_rl_s0p1_r1k_ic_0 rwls_op1_0900_rl_s0p1_r1k_ic 0 sky130_fd_pr__nfet_01v8 L=0.15 W=0.42 nf=1 ad=0.1218 as=0.1218 pd=1.42 ps=1.42 nrd=0.69047619047619  nrs=0.69047619047619 sa=0 sb=0 sd=0 mult=1 m=1
csn_op1_0900_rl_s0p1_r1k_ic_0 sn_op1_0900_rl_s0p1_r1k_ic_0 0 {C_SN}
XMWR_op1_0900_rl_s0p1_r1k_ic_1 sn_op1_0900_rl_s0p1_r1k_ic_1 wwl_des wbl_op1_0900_rl_s0p1_r1k_ic 0 sky130_fd_pr__nfet_01v8 L=0.15 W=0.42 nf=1 ad=0.1218 as=0.1218 pd=1.42 ps=1.42 nrd=0.69047619047619  nrs=0.69047619047619 sa=0 sb=0 sd=0 mult=1 m=1
XMRD_op1_0900_rl_s0p1_r1k_ic_1 rbl_op1_0900_rl_s0p1_r1k_ic sn_op1_0900_rl_s0p1_r1k_ic_1 rwl_des 0 sky130_fd_pr__nfet_01v8 L=0.15 W=0.42 nf=1 ad=0.1218 as=0.1218 pd=1.42 ps=1.42 nrd=0.69047619047619  nrs=0.69047619047619 sa=0 sb=0 sd=0 mult=1 m=1
csn_op1_0900_rl_s0p1_r1k_ic_1 sn_op1_0900_rl_s0p1_r1k_ic_1 0 {C_SN}
XMWR_op1_0900_rl_s0p1_r1k_ic_2 sn_op1_0900_rl_s0p1_r1k_ic_2 wwl_des wbl_op1_0900_rl_s0p1_r1k_ic 0 sky130_fd_pr__nfet_01v8 L=0.15 W=0.42 nf=1 ad=0.1218 as=0.1218 pd=1.42 ps=1.42 nrd=0.69047619047619  nrs=0.69047619047619 sa=0 sb=0 sd=0 mult=1 m=1
XMRD_op1_0900_rl_s0p1_r1k_ic_2 rbl_op1_0900_rl_s0p1_r1k_ic sn_op1_0900_rl_s0p1_r1k_ic_2 rwl_des 0 sky130_fd_pr__nfet_01v8 L=0.15 W=0.42 nf=1 ad=0.1218 as=0.1218 pd=1.42 ps=1.42 nrd=0.69047619047619  nrs=0.69047619047619 sa=0 sb=0 sd=0 mult=1 m=1
csn_op1_0900_rl_s0p1_r1k_ic_2 sn_op1_0900_rl_s0p1_r1k_ic_2 0 {C_SN}
XMWR_op1_0900_rl_s0p1_r1k_ic_3 sn_op1_0900_rl_s0p1_r1k_ic_3 wwl_des wbl_op1_0900_rl_s0p1_r1k_ic 0 sky130_fd_pr__nfet_01v8 L=0.15 W=0.42 nf=1 ad=0.1218 as=0.1218 pd=1.42 ps=1.42 nrd=0.69047619047619  nrs=0.69047619047619 sa=0 sb=0 sd=0 mult=1 m=1
XMRD_op1_0900_rl_s0p1_r1k_ic_3 rbl_op1_0900_rl_s0p1_r1k_ic sn_op1_0900_rl_s0p1_r1k_ic_3 rwl_des 0 sky130_fd_pr__nfet_01v8 L=0.15 W=0.42 nf=1 ad=0.1218 as=0.1218 pd=1.42 ps=1.42 nrd=0.69047619047619  nrs=0.69047619047619 sa=0 sb=0 sd=0 mult=1 m=1
csn_op1_0900_rl_s0p1_r1k_ic_3 sn_op1_0900_rl_s0p1_r1k_ic_3 0 {C_SN}
XMN1_op1_0900_rl_s0p1_r1k_ic rbl_op1_0900_rl_s0p1_r1k_ic ref_op1_0900_rl_s0p1_r1k_ic vn_op1_0900_rl_s0p1_r1k_ic 0 sky130_fd_pr__nfet_01v8 L=0.15 W=1 nf=1 ad=0.29 as=0.29 pd=2.58 ps=2.58 mult=1 m=1
XMN2_op1_0900_rl_s0p1_r1k_ic ref_op1_0900_rl_s0p1_r1k_ic rbl_op1_0900_rl_s0p1_r1k_ic vn_op1_0900_rl_s0p1_r1k_ic 0 sky130_fd_pr__nfet_01v8 L=0.15 W=1 nf=1 ad=0.29 as=0.29 pd=2.58 ps=2.58 mult=1 m=1
XMP1_op1_0900_rl_s0p1_r1k_ic rbl_op1_0900_rl_s0p1_r1k_ic ref_op1_0900_rl_s0p1_r1k_ic vp_op1_0900_rl_s0p1_r1k_ic vdd sky130_fd_pr__pfet_01v8 L=0.15 W=2 nf=1 ad=0.58 as=0.58 pd=4.58 ps=4.58 mult=1 m=1
XMP2_op1_0900_rl_s0p1_r1k_ic ref_op1_0900_rl_s0p1_r1k_ic rbl_op1_0900_rl_s0p1_r1k_ic vp_op1_0900_rl_s0p1_r1k_ic vdd sky130_fd_pr__pfet_01v8 L=0.15 W=2 nf=1 ad=0.58 as=0.58 pd=4.58 ps=4.58 mult=1 m=1
XMNF_op1_0900_rl_s0p1_r1k_ic vn_op1_0900_rl_s0p1_r1k_ic en_op1_0900_rl_s0p1_r1k_ic 0 0 sky130_fd_pr__nfet_01v8 L=0.15 W=2 nf=1 ad=0.58 as=0.58 pd=4.58 ps=4.58 mult=1 m=1
XMPH_op1_0900_rl_s0p1_r1k_ic vp_op1_0900_rl_s0p1_r1k_ic enb_op1_0900_rl_s0p1_r1k_ic vdd vdd sky130_fd_pr__pfet_01v8 L=0.15 W=4 nf=1 ad=1.16 as=1.16 pd=8.58 ps=8.58 mult=1 m=1
bd_op1_0900_rl_s0p1_r1k_ic d_op1_0900_rl_s0p1_r1k_ic 0 v=v(rbl_op1_0900_rl_s0p1_r1k_ic)-v(ref_op1_0900_rl_s0p1_r1k_ic)

* ---- instance 330: op1_1000_rl_s0p1_r1k_ic (variant rl_s0p1_r1k_ic; probe dec 11.9 ns, release 34 ns, meas 36 ns) ----
vctl_op1_1000_rl_s0p1_r1k_ic ctl_op1_1000_rl_s0p1_r1k_ic 0 pwl(0.0000e+00 {VDD} 2.0000e-09 {VDD} 2.1000e-09 0)
* RWL driver model (EXPERIMENTAL): slew 0.1 ns, series R 1000 ohm; cell pin = rwls_op1_1000_rl_s0p1_r1k_ic
vrs_op1_1000_rl_s0p1_r1k_ic rwlsrc_op1_1000_rl_s0p1_r1k_ic 0 pwl(0.0000e+00 {VDD} 2.0000e-09 {VDD} 2.1000e-09 0 3.4000e-08 0 3.4100e-08 {VDD})
rdrv_op1_1000_rl_s0p1_r1k_ic rwlsrc_op1_1000_rl_s0p1_r1k_ic rwls_op1_1000_rl_s0p1_r1k_ic 1000
ven_op1_1000_rl_s0p1_r1k_ic en_op1_1000_rl_s0p1_r1k_ic 0 pwl(0.0000e+00 0 1.1000e-08 0 1.1100e-08 {VDD} 3.4000e-08 {VDD} 3.4100e-08 0)
venb_op1_1000_rl_s0p1_r1k_ic enb_op1_1000_rl_s0p1_r1k_ic 0 pwl(0.0000e+00 {VDD} 1.1000e-08 {VDD} 1.1100e-08 0 3.4000e-08 0 3.4100e-08 {VDD})
vww_op1_1000_rl_s0p1_r1k_ic wwl_op1_1000_rl_s0p1_r1k_ic 0 pwl(0.0000e+00 0 1.2000e-08 0 1.2100e-08 {VDD} 3.2000e-08 {VDD} 3.2100e-08 0)
vwc_op1_1000_rl_s0p1_r1k_ic wbc_op1_1000_rl_s0p1_r1k_ic 0 pwl(0.0000e+00 0 1.2000e-08 0 1.2100e-08 {VDD} 3.4000e-08 {VDD} 3.4100e-08 0)
swb_op1_1000_rl_s0p1_r1k_ic ref_op1_1000_rl_s0p1_r1k_ic wbl_op1_1000_rl_s0p1_r1k_ic wbc_op1_1000_rl_s0p1_r1k_ic 0 swwbl
cwbl_op1_1000_rl_s0p1_r1k_ic wbl_op1_1000_rl_s0p1_r1k_ic 0 {C_WBL}
spa_op1_1000_rl_s0p1_r1k_ic prea rbl_op1_1000_rl_s0p1_r1k_ic ctl_op1_1000_rl_s0p1_r1k_ic 0 swpre
spr_op1_1000_rl_s0p1_r1k_ic pref ref_op1_1000_rl_s0p1_r1k_ic ctl_op1_1000_rl_s0p1_r1k_ic 0 swpre
crbl_op1_1000_rl_s0p1_r1k_ic rbl_op1_1000_rl_s0p1_r1k_ic 0 {C_RBL}
cref_op1_1000_rl_s0p1_r1k_ic ref_op1_1000_rl_s0p1_r1k_ic 0 {C_RBL}   $ ASSUMPTION: ideal matched dummy load
XMWR_op1_1000_rl_s0p1_r1k_ic_0 sn_op1_1000_rl_s0p1_r1k_ic_0 wwl_op1_1000_rl_s0p1_r1k_ic wbl_op1_1000_rl_s0p1_r1k_ic 0 sky130_fd_pr__nfet_01v8 L=0.15 W=0.42 nf=1 ad=0.1218 as=0.1218 pd=1.42 ps=1.42 nrd=0.69047619047619  nrs=0.69047619047619 sa=0 sb=0 sd=0 mult=1 m=1
XMRD_op1_1000_rl_s0p1_r1k_ic_0 rbl_op1_1000_rl_s0p1_r1k_ic sn_op1_1000_rl_s0p1_r1k_ic_0 rwls_op1_1000_rl_s0p1_r1k_ic 0 sky130_fd_pr__nfet_01v8 L=0.15 W=0.42 nf=1 ad=0.1218 as=0.1218 pd=1.42 ps=1.42 nrd=0.69047619047619  nrs=0.69047619047619 sa=0 sb=0 sd=0 mult=1 m=1
csn_op1_1000_rl_s0p1_r1k_ic_0 sn_op1_1000_rl_s0p1_r1k_ic_0 0 {C_SN}
XMWR_op1_1000_rl_s0p1_r1k_ic_1 sn_op1_1000_rl_s0p1_r1k_ic_1 wwl_des wbl_op1_1000_rl_s0p1_r1k_ic 0 sky130_fd_pr__nfet_01v8 L=0.15 W=0.42 nf=1 ad=0.1218 as=0.1218 pd=1.42 ps=1.42 nrd=0.69047619047619  nrs=0.69047619047619 sa=0 sb=0 sd=0 mult=1 m=1
XMRD_op1_1000_rl_s0p1_r1k_ic_1 rbl_op1_1000_rl_s0p1_r1k_ic sn_op1_1000_rl_s0p1_r1k_ic_1 rwl_des 0 sky130_fd_pr__nfet_01v8 L=0.15 W=0.42 nf=1 ad=0.1218 as=0.1218 pd=1.42 ps=1.42 nrd=0.69047619047619  nrs=0.69047619047619 sa=0 sb=0 sd=0 mult=1 m=1
csn_op1_1000_rl_s0p1_r1k_ic_1 sn_op1_1000_rl_s0p1_r1k_ic_1 0 {C_SN}
XMWR_op1_1000_rl_s0p1_r1k_ic_2 sn_op1_1000_rl_s0p1_r1k_ic_2 wwl_des wbl_op1_1000_rl_s0p1_r1k_ic 0 sky130_fd_pr__nfet_01v8 L=0.15 W=0.42 nf=1 ad=0.1218 as=0.1218 pd=1.42 ps=1.42 nrd=0.69047619047619  nrs=0.69047619047619 sa=0 sb=0 sd=0 mult=1 m=1
XMRD_op1_1000_rl_s0p1_r1k_ic_2 rbl_op1_1000_rl_s0p1_r1k_ic sn_op1_1000_rl_s0p1_r1k_ic_2 rwl_des 0 sky130_fd_pr__nfet_01v8 L=0.15 W=0.42 nf=1 ad=0.1218 as=0.1218 pd=1.42 ps=1.42 nrd=0.69047619047619  nrs=0.69047619047619 sa=0 sb=0 sd=0 mult=1 m=1
csn_op1_1000_rl_s0p1_r1k_ic_2 sn_op1_1000_rl_s0p1_r1k_ic_2 0 {C_SN}
XMWR_op1_1000_rl_s0p1_r1k_ic_3 sn_op1_1000_rl_s0p1_r1k_ic_3 wwl_des wbl_op1_1000_rl_s0p1_r1k_ic 0 sky130_fd_pr__nfet_01v8 L=0.15 W=0.42 nf=1 ad=0.1218 as=0.1218 pd=1.42 ps=1.42 nrd=0.69047619047619  nrs=0.69047619047619 sa=0 sb=0 sd=0 mult=1 m=1
XMRD_op1_1000_rl_s0p1_r1k_ic_3 rbl_op1_1000_rl_s0p1_r1k_ic sn_op1_1000_rl_s0p1_r1k_ic_3 rwl_des 0 sky130_fd_pr__nfet_01v8 L=0.15 W=0.42 nf=1 ad=0.1218 as=0.1218 pd=1.42 ps=1.42 nrd=0.69047619047619  nrs=0.69047619047619 sa=0 sb=0 sd=0 mult=1 m=1
csn_op1_1000_rl_s0p1_r1k_ic_3 sn_op1_1000_rl_s0p1_r1k_ic_3 0 {C_SN}
XMN1_op1_1000_rl_s0p1_r1k_ic rbl_op1_1000_rl_s0p1_r1k_ic ref_op1_1000_rl_s0p1_r1k_ic vn_op1_1000_rl_s0p1_r1k_ic 0 sky130_fd_pr__nfet_01v8 L=0.15 W=1 nf=1 ad=0.29 as=0.29 pd=2.58 ps=2.58 mult=1 m=1
XMN2_op1_1000_rl_s0p1_r1k_ic ref_op1_1000_rl_s0p1_r1k_ic rbl_op1_1000_rl_s0p1_r1k_ic vn_op1_1000_rl_s0p1_r1k_ic 0 sky130_fd_pr__nfet_01v8 L=0.15 W=1 nf=1 ad=0.29 as=0.29 pd=2.58 ps=2.58 mult=1 m=1
XMP1_op1_1000_rl_s0p1_r1k_ic rbl_op1_1000_rl_s0p1_r1k_ic ref_op1_1000_rl_s0p1_r1k_ic vp_op1_1000_rl_s0p1_r1k_ic vdd sky130_fd_pr__pfet_01v8 L=0.15 W=2 nf=1 ad=0.58 as=0.58 pd=4.58 ps=4.58 mult=1 m=1
XMP2_op1_1000_rl_s0p1_r1k_ic ref_op1_1000_rl_s0p1_r1k_ic rbl_op1_1000_rl_s0p1_r1k_ic vp_op1_1000_rl_s0p1_r1k_ic vdd sky130_fd_pr__pfet_01v8 L=0.15 W=2 nf=1 ad=0.58 as=0.58 pd=4.58 ps=4.58 mult=1 m=1
XMNF_op1_1000_rl_s0p1_r1k_ic vn_op1_1000_rl_s0p1_r1k_ic en_op1_1000_rl_s0p1_r1k_ic 0 0 sky130_fd_pr__nfet_01v8 L=0.15 W=2 nf=1 ad=0.58 as=0.58 pd=4.58 ps=4.58 mult=1 m=1
XMPH_op1_1000_rl_s0p1_r1k_ic vp_op1_1000_rl_s0p1_r1k_ic enb_op1_1000_rl_s0p1_r1k_ic vdd vdd sky130_fd_pr__pfet_01v8 L=0.15 W=4 nf=1 ad=1.16 as=1.16 pd=8.58 ps=8.58 mult=1 m=1
bd_op1_1000_rl_s0p1_r1k_ic d_op1_1000_rl_s0p1_r1k_ic 0 v=v(rbl_op1_1000_rl_s0p1_r1k_ic)-v(ref_op1_1000_rl_s0p1_r1k_ic)

* ---- instance 331: op0_n100_rl_s0p1_r1k_ic (variant rl_s0p1_r1k_ic; probe dec 11.9 ns, release 34 ns, meas 36 ns) ----
vctl_op0_n100_rl_s0p1_r1k_ic ctl_op0_n100_rl_s0p1_r1k_ic 0 pwl(0.0000e+00 {VDD} 2.0000e-09 {VDD} 2.1000e-09 0)
* RWL driver model (EXPERIMENTAL): slew 0.1 ns, series R 1000 ohm; cell pin = rwls_op0_n100_rl_s0p1_r1k_ic
vrs_op0_n100_rl_s0p1_r1k_ic rwlsrc_op0_n100_rl_s0p1_r1k_ic 0 pwl(0.0000e+00 {VDD} 2.0000e-09 {VDD} 2.1000e-09 0 3.4000e-08 0 3.4100e-08 {VDD})
rdrv_op0_n100_rl_s0p1_r1k_ic rwlsrc_op0_n100_rl_s0p1_r1k_ic rwls_op0_n100_rl_s0p1_r1k_ic 1000
ven_op0_n100_rl_s0p1_r1k_ic en_op0_n100_rl_s0p1_r1k_ic 0 pwl(0.0000e+00 0 1.1000e-08 0 1.1100e-08 {VDD} 3.4000e-08 {VDD} 3.4100e-08 0)
venb_op0_n100_rl_s0p1_r1k_ic enb_op0_n100_rl_s0p1_r1k_ic 0 pwl(0.0000e+00 {VDD} 1.1000e-08 {VDD} 1.1100e-08 0 3.4000e-08 0 3.4100e-08 {VDD})
vww_op0_n100_rl_s0p1_r1k_ic wwl_op0_n100_rl_s0p1_r1k_ic 0 pwl(0.0000e+00 0 1.2000e-08 0 1.2100e-08 {VDD} 3.2000e-08 {VDD} 3.2100e-08 0)
vwc_op0_n100_rl_s0p1_r1k_ic wbc_op0_n100_rl_s0p1_r1k_ic 0 pwl(0.0000e+00 0 1.2000e-08 0 1.2100e-08 {VDD} 3.4000e-08 {VDD} 3.4100e-08 0)
swb_op0_n100_rl_s0p1_r1k_ic ref_op0_n100_rl_s0p1_r1k_ic wbl_op0_n100_rl_s0p1_r1k_ic wbc_op0_n100_rl_s0p1_r1k_ic 0 swwbl
cwbl_op0_n100_rl_s0p1_r1k_ic wbl_op0_n100_rl_s0p1_r1k_ic 0 {C_WBL}
spa_op0_n100_rl_s0p1_r1k_ic prea rbl_op0_n100_rl_s0p1_r1k_ic ctl_op0_n100_rl_s0p1_r1k_ic 0 swpre
spr_op0_n100_rl_s0p1_r1k_ic pref ref_op0_n100_rl_s0p1_r1k_ic ctl_op0_n100_rl_s0p1_r1k_ic 0 swpre
crbl_op0_n100_rl_s0p1_r1k_ic rbl_op0_n100_rl_s0p1_r1k_ic 0 {C_RBL}
cref_op0_n100_rl_s0p1_r1k_ic ref_op0_n100_rl_s0p1_r1k_ic 0 {C_RBL}   $ ASSUMPTION: ideal matched dummy load
XMWR_op0_n100_rl_s0p1_r1k_ic_0 sn_op0_n100_rl_s0p1_r1k_ic_0 wwl_op0_n100_rl_s0p1_r1k_ic wbl_op0_n100_rl_s0p1_r1k_ic 0 sky130_fd_pr__nfet_01v8 L=0.15 W=0.42 nf=1 ad=0.1218 as=0.1218 pd=1.42 ps=1.42 nrd=0.69047619047619  nrs=0.69047619047619 sa=0 sb=0 sd=0 mult=1 m=1
XMRD_op0_n100_rl_s0p1_r1k_ic_0 rbl_op0_n100_rl_s0p1_r1k_ic sn_op0_n100_rl_s0p1_r1k_ic_0 rwls_op0_n100_rl_s0p1_r1k_ic 0 sky130_fd_pr__nfet_01v8 L=0.15 W=0.42 nf=1 ad=0.1218 as=0.1218 pd=1.42 ps=1.42 nrd=0.69047619047619  nrs=0.69047619047619 sa=0 sb=0 sd=0 mult=1 m=1
csn_op0_n100_rl_s0p1_r1k_ic_0 sn_op0_n100_rl_s0p1_r1k_ic_0 0 {C_SN}
XMWR_op0_n100_rl_s0p1_r1k_ic_1 sn_op0_n100_rl_s0p1_r1k_ic_1 wwl_des wbl_op0_n100_rl_s0p1_r1k_ic 0 sky130_fd_pr__nfet_01v8 L=0.15 W=0.42 nf=1 ad=0.1218 as=0.1218 pd=1.42 ps=1.42 nrd=0.69047619047619  nrs=0.69047619047619 sa=0 sb=0 sd=0 mult=1 m=1
XMRD_op0_n100_rl_s0p1_r1k_ic_1 rbl_op0_n100_rl_s0p1_r1k_ic sn_op0_n100_rl_s0p1_r1k_ic_1 rwl_des 0 sky130_fd_pr__nfet_01v8 L=0.15 W=0.42 nf=1 ad=0.1218 as=0.1218 pd=1.42 ps=1.42 nrd=0.69047619047619  nrs=0.69047619047619 sa=0 sb=0 sd=0 mult=1 m=1
csn_op0_n100_rl_s0p1_r1k_ic_1 sn_op0_n100_rl_s0p1_r1k_ic_1 0 {C_SN}
XMWR_op0_n100_rl_s0p1_r1k_ic_2 sn_op0_n100_rl_s0p1_r1k_ic_2 wwl_des wbl_op0_n100_rl_s0p1_r1k_ic 0 sky130_fd_pr__nfet_01v8 L=0.15 W=0.42 nf=1 ad=0.1218 as=0.1218 pd=1.42 ps=1.42 nrd=0.69047619047619  nrs=0.69047619047619 sa=0 sb=0 sd=0 mult=1 m=1
XMRD_op0_n100_rl_s0p1_r1k_ic_2 rbl_op0_n100_rl_s0p1_r1k_ic sn_op0_n100_rl_s0p1_r1k_ic_2 rwl_des 0 sky130_fd_pr__nfet_01v8 L=0.15 W=0.42 nf=1 ad=0.1218 as=0.1218 pd=1.42 ps=1.42 nrd=0.69047619047619  nrs=0.69047619047619 sa=0 sb=0 sd=0 mult=1 m=1
csn_op0_n100_rl_s0p1_r1k_ic_2 sn_op0_n100_rl_s0p1_r1k_ic_2 0 {C_SN}
XMWR_op0_n100_rl_s0p1_r1k_ic_3 sn_op0_n100_rl_s0p1_r1k_ic_3 wwl_des wbl_op0_n100_rl_s0p1_r1k_ic 0 sky130_fd_pr__nfet_01v8 L=0.15 W=0.42 nf=1 ad=0.1218 as=0.1218 pd=1.42 ps=1.42 nrd=0.69047619047619  nrs=0.69047619047619 sa=0 sb=0 sd=0 mult=1 m=1
XMRD_op0_n100_rl_s0p1_r1k_ic_3 rbl_op0_n100_rl_s0p1_r1k_ic sn_op0_n100_rl_s0p1_r1k_ic_3 rwl_des 0 sky130_fd_pr__nfet_01v8 L=0.15 W=0.42 nf=1 ad=0.1218 as=0.1218 pd=1.42 ps=1.42 nrd=0.69047619047619  nrs=0.69047619047619 sa=0 sb=0 sd=0 mult=1 m=1
csn_op0_n100_rl_s0p1_r1k_ic_3 sn_op0_n100_rl_s0p1_r1k_ic_3 0 {C_SN}
XMN1_op0_n100_rl_s0p1_r1k_ic rbl_op0_n100_rl_s0p1_r1k_ic ref_op0_n100_rl_s0p1_r1k_ic vn_op0_n100_rl_s0p1_r1k_ic 0 sky130_fd_pr__nfet_01v8 L=0.15 W=1 nf=1 ad=0.29 as=0.29 pd=2.58 ps=2.58 mult=1 m=1
XMN2_op0_n100_rl_s0p1_r1k_ic ref_op0_n100_rl_s0p1_r1k_ic rbl_op0_n100_rl_s0p1_r1k_ic vn_op0_n100_rl_s0p1_r1k_ic 0 sky130_fd_pr__nfet_01v8 L=0.15 W=1 nf=1 ad=0.29 as=0.29 pd=2.58 ps=2.58 mult=1 m=1
XMP1_op0_n100_rl_s0p1_r1k_ic rbl_op0_n100_rl_s0p1_r1k_ic ref_op0_n100_rl_s0p1_r1k_ic vp_op0_n100_rl_s0p1_r1k_ic vdd sky130_fd_pr__pfet_01v8 L=0.15 W=2 nf=1 ad=0.58 as=0.58 pd=4.58 ps=4.58 mult=1 m=1
XMP2_op0_n100_rl_s0p1_r1k_ic ref_op0_n100_rl_s0p1_r1k_ic rbl_op0_n100_rl_s0p1_r1k_ic vp_op0_n100_rl_s0p1_r1k_ic vdd sky130_fd_pr__pfet_01v8 L=0.15 W=2 nf=1 ad=0.58 as=0.58 pd=4.58 ps=4.58 mult=1 m=1
XMNF_op0_n100_rl_s0p1_r1k_ic vn_op0_n100_rl_s0p1_r1k_ic en_op0_n100_rl_s0p1_r1k_ic 0 0 sky130_fd_pr__nfet_01v8 L=0.15 W=2 nf=1 ad=0.58 as=0.58 pd=4.58 ps=4.58 mult=1 m=1
XMPH_op0_n100_rl_s0p1_r1k_ic vp_op0_n100_rl_s0p1_r1k_ic enb_op0_n100_rl_s0p1_r1k_ic vdd vdd sky130_fd_pr__pfet_01v8 L=0.15 W=4 nf=1 ad=1.16 as=1.16 pd=8.58 ps=8.58 mult=1 m=1
bd_op0_n100_rl_s0p1_r1k_ic d_op0_n100_rl_s0p1_r1k_ic 0 v=v(rbl_op0_n100_rl_s0p1_r1k_ic)-v(ref_op0_n100_rl_s0p1_r1k_ic)

* ---- instance 332: op0_0000_rl_s0p1_r1k_ic (variant rl_s0p1_r1k_ic; probe dec 11.9 ns, release 34 ns, meas 36 ns) ----
vctl_op0_0000_rl_s0p1_r1k_ic ctl_op0_0000_rl_s0p1_r1k_ic 0 pwl(0.0000e+00 {VDD} 2.0000e-09 {VDD} 2.1000e-09 0)
* RWL driver model (EXPERIMENTAL): slew 0.1 ns, series R 1000 ohm; cell pin = rwls_op0_0000_rl_s0p1_r1k_ic
vrs_op0_0000_rl_s0p1_r1k_ic rwlsrc_op0_0000_rl_s0p1_r1k_ic 0 pwl(0.0000e+00 {VDD} 2.0000e-09 {VDD} 2.1000e-09 0 3.4000e-08 0 3.4100e-08 {VDD})
rdrv_op0_0000_rl_s0p1_r1k_ic rwlsrc_op0_0000_rl_s0p1_r1k_ic rwls_op0_0000_rl_s0p1_r1k_ic 1000
ven_op0_0000_rl_s0p1_r1k_ic en_op0_0000_rl_s0p1_r1k_ic 0 pwl(0.0000e+00 0 1.1000e-08 0 1.1100e-08 {VDD} 3.4000e-08 {VDD} 3.4100e-08 0)
venb_op0_0000_rl_s0p1_r1k_ic enb_op0_0000_rl_s0p1_r1k_ic 0 pwl(0.0000e+00 {VDD} 1.1000e-08 {VDD} 1.1100e-08 0 3.4000e-08 0 3.4100e-08 {VDD})
vww_op0_0000_rl_s0p1_r1k_ic wwl_op0_0000_rl_s0p1_r1k_ic 0 pwl(0.0000e+00 0 1.2000e-08 0 1.2100e-08 {VDD} 3.2000e-08 {VDD} 3.2100e-08 0)
vwc_op0_0000_rl_s0p1_r1k_ic wbc_op0_0000_rl_s0p1_r1k_ic 0 pwl(0.0000e+00 0 1.2000e-08 0 1.2100e-08 {VDD} 3.4000e-08 {VDD} 3.4100e-08 0)
swb_op0_0000_rl_s0p1_r1k_ic ref_op0_0000_rl_s0p1_r1k_ic wbl_op0_0000_rl_s0p1_r1k_ic wbc_op0_0000_rl_s0p1_r1k_ic 0 swwbl
cwbl_op0_0000_rl_s0p1_r1k_ic wbl_op0_0000_rl_s0p1_r1k_ic 0 {C_WBL}
spa_op0_0000_rl_s0p1_r1k_ic prea rbl_op0_0000_rl_s0p1_r1k_ic ctl_op0_0000_rl_s0p1_r1k_ic 0 swpre
spr_op0_0000_rl_s0p1_r1k_ic pref ref_op0_0000_rl_s0p1_r1k_ic ctl_op0_0000_rl_s0p1_r1k_ic 0 swpre
crbl_op0_0000_rl_s0p1_r1k_ic rbl_op0_0000_rl_s0p1_r1k_ic 0 {C_RBL}
cref_op0_0000_rl_s0p1_r1k_ic ref_op0_0000_rl_s0p1_r1k_ic 0 {C_RBL}   $ ASSUMPTION: ideal matched dummy load
XMWR_op0_0000_rl_s0p1_r1k_ic_0 sn_op0_0000_rl_s0p1_r1k_ic_0 wwl_op0_0000_rl_s0p1_r1k_ic wbl_op0_0000_rl_s0p1_r1k_ic 0 sky130_fd_pr__nfet_01v8 L=0.15 W=0.42 nf=1 ad=0.1218 as=0.1218 pd=1.42 ps=1.42 nrd=0.69047619047619  nrs=0.69047619047619 sa=0 sb=0 sd=0 mult=1 m=1
XMRD_op0_0000_rl_s0p1_r1k_ic_0 rbl_op0_0000_rl_s0p1_r1k_ic sn_op0_0000_rl_s0p1_r1k_ic_0 rwls_op0_0000_rl_s0p1_r1k_ic 0 sky130_fd_pr__nfet_01v8 L=0.15 W=0.42 nf=1 ad=0.1218 as=0.1218 pd=1.42 ps=1.42 nrd=0.69047619047619  nrs=0.69047619047619 sa=0 sb=0 sd=0 mult=1 m=1
csn_op0_0000_rl_s0p1_r1k_ic_0 sn_op0_0000_rl_s0p1_r1k_ic_0 0 {C_SN}
XMWR_op0_0000_rl_s0p1_r1k_ic_1 sn_op0_0000_rl_s0p1_r1k_ic_1 wwl_des wbl_op0_0000_rl_s0p1_r1k_ic 0 sky130_fd_pr__nfet_01v8 L=0.15 W=0.42 nf=1 ad=0.1218 as=0.1218 pd=1.42 ps=1.42 nrd=0.69047619047619  nrs=0.69047619047619 sa=0 sb=0 sd=0 mult=1 m=1
XMRD_op0_0000_rl_s0p1_r1k_ic_1 rbl_op0_0000_rl_s0p1_r1k_ic sn_op0_0000_rl_s0p1_r1k_ic_1 rwl_des 0 sky130_fd_pr__nfet_01v8 L=0.15 W=0.42 nf=1 ad=0.1218 as=0.1218 pd=1.42 ps=1.42 nrd=0.69047619047619  nrs=0.69047619047619 sa=0 sb=0 sd=0 mult=1 m=1
csn_op0_0000_rl_s0p1_r1k_ic_1 sn_op0_0000_rl_s0p1_r1k_ic_1 0 {C_SN}
XMWR_op0_0000_rl_s0p1_r1k_ic_2 sn_op0_0000_rl_s0p1_r1k_ic_2 wwl_des wbl_op0_0000_rl_s0p1_r1k_ic 0 sky130_fd_pr__nfet_01v8 L=0.15 W=0.42 nf=1 ad=0.1218 as=0.1218 pd=1.42 ps=1.42 nrd=0.69047619047619  nrs=0.69047619047619 sa=0 sb=0 sd=0 mult=1 m=1
XMRD_op0_0000_rl_s0p1_r1k_ic_2 rbl_op0_0000_rl_s0p1_r1k_ic sn_op0_0000_rl_s0p1_r1k_ic_2 rwl_des 0 sky130_fd_pr__nfet_01v8 L=0.15 W=0.42 nf=1 ad=0.1218 as=0.1218 pd=1.42 ps=1.42 nrd=0.69047619047619  nrs=0.69047619047619 sa=0 sb=0 sd=0 mult=1 m=1
csn_op0_0000_rl_s0p1_r1k_ic_2 sn_op0_0000_rl_s0p1_r1k_ic_2 0 {C_SN}
XMWR_op0_0000_rl_s0p1_r1k_ic_3 sn_op0_0000_rl_s0p1_r1k_ic_3 wwl_des wbl_op0_0000_rl_s0p1_r1k_ic 0 sky130_fd_pr__nfet_01v8 L=0.15 W=0.42 nf=1 ad=0.1218 as=0.1218 pd=1.42 ps=1.42 nrd=0.69047619047619  nrs=0.69047619047619 sa=0 sb=0 sd=0 mult=1 m=1
XMRD_op0_0000_rl_s0p1_r1k_ic_3 rbl_op0_0000_rl_s0p1_r1k_ic sn_op0_0000_rl_s0p1_r1k_ic_3 rwl_des 0 sky130_fd_pr__nfet_01v8 L=0.15 W=0.42 nf=1 ad=0.1218 as=0.1218 pd=1.42 ps=1.42 nrd=0.69047619047619  nrs=0.69047619047619 sa=0 sb=0 sd=0 mult=1 m=1
csn_op0_0000_rl_s0p1_r1k_ic_3 sn_op0_0000_rl_s0p1_r1k_ic_3 0 {C_SN}
XMN1_op0_0000_rl_s0p1_r1k_ic rbl_op0_0000_rl_s0p1_r1k_ic ref_op0_0000_rl_s0p1_r1k_ic vn_op0_0000_rl_s0p1_r1k_ic 0 sky130_fd_pr__nfet_01v8 L=0.15 W=1 nf=1 ad=0.29 as=0.29 pd=2.58 ps=2.58 mult=1 m=1
XMN2_op0_0000_rl_s0p1_r1k_ic ref_op0_0000_rl_s0p1_r1k_ic rbl_op0_0000_rl_s0p1_r1k_ic vn_op0_0000_rl_s0p1_r1k_ic 0 sky130_fd_pr__nfet_01v8 L=0.15 W=1 nf=1 ad=0.29 as=0.29 pd=2.58 ps=2.58 mult=1 m=1
XMP1_op0_0000_rl_s0p1_r1k_ic rbl_op0_0000_rl_s0p1_r1k_ic ref_op0_0000_rl_s0p1_r1k_ic vp_op0_0000_rl_s0p1_r1k_ic vdd sky130_fd_pr__pfet_01v8 L=0.15 W=2 nf=1 ad=0.58 as=0.58 pd=4.58 ps=4.58 mult=1 m=1
XMP2_op0_0000_rl_s0p1_r1k_ic ref_op0_0000_rl_s0p1_r1k_ic rbl_op0_0000_rl_s0p1_r1k_ic vp_op0_0000_rl_s0p1_r1k_ic vdd sky130_fd_pr__pfet_01v8 L=0.15 W=2 nf=1 ad=0.58 as=0.58 pd=4.58 ps=4.58 mult=1 m=1
XMNF_op0_0000_rl_s0p1_r1k_ic vn_op0_0000_rl_s0p1_r1k_ic en_op0_0000_rl_s0p1_r1k_ic 0 0 sky130_fd_pr__nfet_01v8 L=0.15 W=2 nf=1 ad=0.58 as=0.58 pd=4.58 ps=4.58 mult=1 m=1
XMPH_op0_0000_rl_s0p1_r1k_ic vp_op0_0000_rl_s0p1_r1k_ic enb_op0_0000_rl_s0p1_r1k_ic vdd vdd sky130_fd_pr__pfet_01v8 L=0.15 W=4 nf=1 ad=1.16 as=1.16 pd=8.58 ps=8.58 mult=1 m=1
bd_op0_0000_rl_s0p1_r1k_ic d_op0_0000_rl_s0p1_r1k_ic 0 v=v(rbl_op0_0000_rl_s0p1_r1k_ic)-v(ref_op0_0000_rl_s0p1_r1k_ic)

* ---- instance 333: op1_0900_rl_s0p1_r10k_ic (variant rl_s0p1_r10k_ic; probe dec 11.9 ns, release 34 ns, meas 36 ns) ----
vctl_op1_0900_rl_s0p1_r10k_ic ctl_op1_0900_rl_s0p1_r10k_ic 0 pwl(0.0000e+00 {VDD} 2.0000e-09 {VDD} 2.1000e-09 0)
* RWL driver model (EXPERIMENTAL): slew 0.1 ns, series R 10000 ohm; cell pin = rwls_op1_0900_rl_s0p1_r10k_ic
vrs_op1_0900_rl_s0p1_r10k_ic rwlsrc_op1_0900_rl_s0p1_r10k_ic 0 pwl(0.0000e+00 {VDD} 2.0000e-09 {VDD} 2.1000e-09 0 3.4000e-08 0 3.4100e-08 {VDD})
rdrv_op1_0900_rl_s0p1_r10k_ic rwlsrc_op1_0900_rl_s0p1_r10k_ic rwls_op1_0900_rl_s0p1_r10k_ic 10000
ven_op1_0900_rl_s0p1_r10k_ic en_op1_0900_rl_s0p1_r10k_ic 0 pwl(0.0000e+00 0 1.1000e-08 0 1.1100e-08 {VDD} 3.4000e-08 {VDD} 3.4100e-08 0)
venb_op1_0900_rl_s0p1_r10k_ic enb_op1_0900_rl_s0p1_r10k_ic 0 pwl(0.0000e+00 {VDD} 1.1000e-08 {VDD} 1.1100e-08 0 3.4000e-08 0 3.4100e-08 {VDD})
vww_op1_0900_rl_s0p1_r10k_ic wwl_op1_0900_rl_s0p1_r10k_ic 0 pwl(0.0000e+00 0 1.2000e-08 0 1.2100e-08 {VDD} 3.2000e-08 {VDD} 3.2100e-08 0)
vwc_op1_0900_rl_s0p1_r10k_ic wbc_op1_0900_rl_s0p1_r10k_ic 0 pwl(0.0000e+00 0 1.2000e-08 0 1.2100e-08 {VDD} 3.4000e-08 {VDD} 3.4100e-08 0)
swb_op1_0900_rl_s0p1_r10k_ic ref_op1_0900_rl_s0p1_r10k_ic wbl_op1_0900_rl_s0p1_r10k_ic wbc_op1_0900_rl_s0p1_r10k_ic 0 swwbl
cwbl_op1_0900_rl_s0p1_r10k_ic wbl_op1_0900_rl_s0p1_r10k_ic 0 {C_WBL}
spa_op1_0900_rl_s0p1_r10k_ic prea rbl_op1_0900_rl_s0p1_r10k_ic ctl_op1_0900_rl_s0p1_r10k_ic 0 swpre
spr_op1_0900_rl_s0p1_r10k_ic pref ref_op1_0900_rl_s0p1_r10k_ic ctl_op1_0900_rl_s0p1_r10k_ic 0 swpre
crbl_op1_0900_rl_s0p1_r10k_ic rbl_op1_0900_rl_s0p1_r10k_ic 0 {C_RBL}
cref_op1_0900_rl_s0p1_r10k_ic ref_op1_0900_rl_s0p1_r10k_ic 0 {C_RBL}   $ ASSUMPTION: ideal matched dummy load
XMWR_op1_0900_rl_s0p1_r10k_ic_0 sn_op1_0900_rl_s0p1_r10k_ic_0 wwl_op1_0900_rl_s0p1_r10k_ic wbl_op1_0900_rl_s0p1_r10k_ic 0 sky130_fd_pr__nfet_01v8 L=0.15 W=0.42 nf=1 ad=0.1218 as=0.1218 pd=1.42 ps=1.42 nrd=0.69047619047619  nrs=0.69047619047619 sa=0 sb=0 sd=0 mult=1 m=1
XMRD_op1_0900_rl_s0p1_r10k_ic_0 rbl_op1_0900_rl_s0p1_r10k_ic sn_op1_0900_rl_s0p1_r10k_ic_0 rwls_op1_0900_rl_s0p1_r10k_ic 0 sky130_fd_pr__nfet_01v8 L=0.15 W=0.42 nf=1 ad=0.1218 as=0.1218 pd=1.42 ps=1.42 nrd=0.69047619047619  nrs=0.69047619047619 sa=0 sb=0 sd=0 mult=1 m=1
csn_op1_0900_rl_s0p1_r10k_ic_0 sn_op1_0900_rl_s0p1_r10k_ic_0 0 {C_SN}
XMWR_op1_0900_rl_s0p1_r10k_ic_1 sn_op1_0900_rl_s0p1_r10k_ic_1 wwl_des wbl_op1_0900_rl_s0p1_r10k_ic 0 sky130_fd_pr__nfet_01v8 L=0.15 W=0.42 nf=1 ad=0.1218 as=0.1218 pd=1.42 ps=1.42 nrd=0.69047619047619  nrs=0.69047619047619 sa=0 sb=0 sd=0 mult=1 m=1
XMRD_op1_0900_rl_s0p1_r10k_ic_1 rbl_op1_0900_rl_s0p1_r10k_ic sn_op1_0900_rl_s0p1_r10k_ic_1 rwl_des 0 sky130_fd_pr__nfet_01v8 L=0.15 W=0.42 nf=1 ad=0.1218 as=0.1218 pd=1.42 ps=1.42 nrd=0.69047619047619  nrs=0.69047619047619 sa=0 sb=0 sd=0 mult=1 m=1
csn_op1_0900_rl_s0p1_r10k_ic_1 sn_op1_0900_rl_s0p1_r10k_ic_1 0 {C_SN}
XMWR_op1_0900_rl_s0p1_r10k_ic_2 sn_op1_0900_rl_s0p1_r10k_ic_2 wwl_des wbl_op1_0900_rl_s0p1_r10k_ic 0 sky130_fd_pr__nfet_01v8 L=0.15 W=0.42 nf=1 ad=0.1218 as=0.1218 pd=1.42 ps=1.42 nrd=0.69047619047619  nrs=0.69047619047619 sa=0 sb=0 sd=0 mult=1 m=1
XMRD_op1_0900_rl_s0p1_r10k_ic_2 rbl_op1_0900_rl_s0p1_r10k_ic sn_op1_0900_rl_s0p1_r10k_ic_2 rwl_des 0 sky130_fd_pr__nfet_01v8 L=0.15 W=0.42 nf=1 ad=0.1218 as=0.1218 pd=1.42 ps=1.42 nrd=0.69047619047619  nrs=0.69047619047619 sa=0 sb=0 sd=0 mult=1 m=1
csn_op1_0900_rl_s0p1_r10k_ic_2 sn_op1_0900_rl_s0p1_r10k_ic_2 0 {C_SN}
XMWR_op1_0900_rl_s0p1_r10k_ic_3 sn_op1_0900_rl_s0p1_r10k_ic_3 wwl_des wbl_op1_0900_rl_s0p1_r10k_ic 0 sky130_fd_pr__nfet_01v8 L=0.15 W=0.42 nf=1 ad=0.1218 as=0.1218 pd=1.42 ps=1.42 nrd=0.69047619047619  nrs=0.69047619047619 sa=0 sb=0 sd=0 mult=1 m=1
XMRD_op1_0900_rl_s0p1_r10k_ic_3 rbl_op1_0900_rl_s0p1_r10k_ic sn_op1_0900_rl_s0p1_r10k_ic_3 rwl_des 0 sky130_fd_pr__nfet_01v8 L=0.15 W=0.42 nf=1 ad=0.1218 as=0.1218 pd=1.42 ps=1.42 nrd=0.69047619047619  nrs=0.69047619047619 sa=0 sb=0 sd=0 mult=1 m=1
csn_op1_0900_rl_s0p1_r10k_ic_3 sn_op1_0900_rl_s0p1_r10k_ic_3 0 {C_SN}
XMN1_op1_0900_rl_s0p1_r10k_ic rbl_op1_0900_rl_s0p1_r10k_ic ref_op1_0900_rl_s0p1_r10k_ic vn_op1_0900_rl_s0p1_r10k_ic 0 sky130_fd_pr__nfet_01v8 L=0.15 W=1 nf=1 ad=0.29 as=0.29 pd=2.58 ps=2.58 mult=1 m=1
XMN2_op1_0900_rl_s0p1_r10k_ic ref_op1_0900_rl_s0p1_r10k_ic rbl_op1_0900_rl_s0p1_r10k_ic vn_op1_0900_rl_s0p1_r10k_ic 0 sky130_fd_pr__nfet_01v8 L=0.15 W=1 nf=1 ad=0.29 as=0.29 pd=2.58 ps=2.58 mult=1 m=1
XMP1_op1_0900_rl_s0p1_r10k_ic rbl_op1_0900_rl_s0p1_r10k_ic ref_op1_0900_rl_s0p1_r10k_ic vp_op1_0900_rl_s0p1_r10k_ic vdd sky130_fd_pr__pfet_01v8 L=0.15 W=2 nf=1 ad=0.58 as=0.58 pd=4.58 ps=4.58 mult=1 m=1
XMP2_op1_0900_rl_s0p1_r10k_ic ref_op1_0900_rl_s0p1_r10k_ic rbl_op1_0900_rl_s0p1_r10k_ic vp_op1_0900_rl_s0p1_r10k_ic vdd sky130_fd_pr__pfet_01v8 L=0.15 W=2 nf=1 ad=0.58 as=0.58 pd=4.58 ps=4.58 mult=1 m=1
XMNF_op1_0900_rl_s0p1_r10k_ic vn_op1_0900_rl_s0p1_r10k_ic en_op1_0900_rl_s0p1_r10k_ic 0 0 sky130_fd_pr__nfet_01v8 L=0.15 W=2 nf=1 ad=0.58 as=0.58 pd=4.58 ps=4.58 mult=1 m=1
XMPH_op1_0900_rl_s0p1_r10k_ic vp_op1_0900_rl_s0p1_r10k_ic enb_op1_0900_rl_s0p1_r10k_ic vdd vdd sky130_fd_pr__pfet_01v8 L=0.15 W=4 nf=1 ad=1.16 as=1.16 pd=8.58 ps=8.58 mult=1 m=1
bd_op1_0900_rl_s0p1_r10k_ic d_op1_0900_rl_s0p1_r10k_ic 0 v=v(rbl_op1_0900_rl_s0p1_r10k_ic)-v(ref_op1_0900_rl_s0p1_r10k_ic)

* ---- instance 334: op1_1000_rl_s0p1_r10k_ic (variant rl_s0p1_r10k_ic; probe dec 11.9 ns, release 34 ns, meas 36 ns) ----
vctl_op1_1000_rl_s0p1_r10k_ic ctl_op1_1000_rl_s0p1_r10k_ic 0 pwl(0.0000e+00 {VDD} 2.0000e-09 {VDD} 2.1000e-09 0)
* RWL driver model (EXPERIMENTAL): slew 0.1 ns, series R 10000 ohm; cell pin = rwls_op1_1000_rl_s0p1_r10k_ic
vrs_op1_1000_rl_s0p1_r10k_ic rwlsrc_op1_1000_rl_s0p1_r10k_ic 0 pwl(0.0000e+00 {VDD} 2.0000e-09 {VDD} 2.1000e-09 0 3.4000e-08 0 3.4100e-08 {VDD})
rdrv_op1_1000_rl_s0p1_r10k_ic rwlsrc_op1_1000_rl_s0p1_r10k_ic rwls_op1_1000_rl_s0p1_r10k_ic 10000
ven_op1_1000_rl_s0p1_r10k_ic en_op1_1000_rl_s0p1_r10k_ic 0 pwl(0.0000e+00 0 1.1000e-08 0 1.1100e-08 {VDD} 3.4000e-08 {VDD} 3.4100e-08 0)
venb_op1_1000_rl_s0p1_r10k_ic enb_op1_1000_rl_s0p1_r10k_ic 0 pwl(0.0000e+00 {VDD} 1.1000e-08 {VDD} 1.1100e-08 0 3.4000e-08 0 3.4100e-08 {VDD})
vww_op1_1000_rl_s0p1_r10k_ic wwl_op1_1000_rl_s0p1_r10k_ic 0 pwl(0.0000e+00 0 1.2000e-08 0 1.2100e-08 {VDD} 3.2000e-08 {VDD} 3.2100e-08 0)
vwc_op1_1000_rl_s0p1_r10k_ic wbc_op1_1000_rl_s0p1_r10k_ic 0 pwl(0.0000e+00 0 1.2000e-08 0 1.2100e-08 {VDD} 3.4000e-08 {VDD} 3.4100e-08 0)
swb_op1_1000_rl_s0p1_r10k_ic ref_op1_1000_rl_s0p1_r10k_ic wbl_op1_1000_rl_s0p1_r10k_ic wbc_op1_1000_rl_s0p1_r10k_ic 0 swwbl
cwbl_op1_1000_rl_s0p1_r10k_ic wbl_op1_1000_rl_s0p1_r10k_ic 0 {C_WBL}
spa_op1_1000_rl_s0p1_r10k_ic prea rbl_op1_1000_rl_s0p1_r10k_ic ctl_op1_1000_rl_s0p1_r10k_ic 0 swpre
spr_op1_1000_rl_s0p1_r10k_ic pref ref_op1_1000_rl_s0p1_r10k_ic ctl_op1_1000_rl_s0p1_r10k_ic 0 swpre
crbl_op1_1000_rl_s0p1_r10k_ic rbl_op1_1000_rl_s0p1_r10k_ic 0 {C_RBL}
cref_op1_1000_rl_s0p1_r10k_ic ref_op1_1000_rl_s0p1_r10k_ic 0 {C_RBL}   $ ASSUMPTION: ideal matched dummy load
XMWR_op1_1000_rl_s0p1_r10k_ic_0 sn_op1_1000_rl_s0p1_r10k_ic_0 wwl_op1_1000_rl_s0p1_r10k_ic wbl_op1_1000_rl_s0p1_r10k_ic 0 sky130_fd_pr__nfet_01v8 L=0.15 W=0.42 nf=1 ad=0.1218 as=0.1218 pd=1.42 ps=1.42 nrd=0.69047619047619  nrs=0.69047619047619 sa=0 sb=0 sd=0 mult=1 m=1
XMRD_op1_1000_rl_s0p1_r10k_ic_0 rbl_op1_1000_rl_s0p1_r10k_ic sn_op1_1000_rl_s0p1_r10k_ic_0 rwls_op1_1000_rl_s0p1_r10k_ic 0 sky130_fd_pr__nfet_01v8 L=0.15 W=0.42 nf=1 ad=0.1218 as=0.1218 pd=1.42 ps=1.42 nrd=0.69047619047619  nrs=0.69047619047619 sa=0 sb=0 sd=0 mult=1 m=1
csn_op1_1000_rl_s0p1_r10k_ic_0 sn_op1_1000_rl_s0p1_r10k_ic_0 0 {C_SN}
XMWR_op1_1000_rl_s0p1_r10k_ic_1 sn_op1_1000_rl_s0p1_r10k_ic_1 wwl_des wbl_op1_1000_rl_s0p1_r10k_ic 0 sky130_fd_pr__nfet_01v8 L=0.15 W=0.42 nf=1 ad=0.1218 as=0.1218 pd=1.42 ps=1.42 nrd=0.69047619047619  nrs=0.69047619047619 sa=0 sb=0 sd=0 mult=1 m=1
XMRD_op1_1000_rl_s0p1_r10k_ic_1 rbl_op1_1000_rl_s0p1_r10k_ic sn_op1_1000_rl_s0p1_r10k_ic_1 rwl_des 0 sky130_fd_pr__nfet_01v8 L=0.15 W=0.42 nf=1 ad=0.1218 as=0.1218 pd=1.42 ps=1.42 nrd=0.69047619047619  nrs=0.69047619047619 sa=0 sb=0 sd=0 mult=1 m=1
csn_op1_1000_rl_s0p1_r10k_ic_1 sn_op1_1000_rl_s0p1_r10k_ic_1 0 {C_SN}
XMWR_op1_1000_rl_s0p1_r10k_ic_2 sn_op1_1000_rl_s0p1_r10k_ic_2 wwl_des wbl_op1_1000_rl_s0p1_r10k_ic 0 sky130_fd_pr__nfet_01v8 L=0.15 W=0.42 nf=1 ad=0.1218 as=0.1218 pd=1.42 ps=1.42 nrd=0.69047619047619  nrs=0.69047619047619 sa=0 sb=0 sd=0 mult=1 m=1
XMRD_op1_1000_rl_s0p1_r10k_ic_2 rbl_op1_1000_rl_s0p1_r10k_ic sn_op1_1000_rl_s0p1_r10k_ic_2 rwl_des 0 sky130_fd_pr__nfet_01v8 L=0.15 W=0.42 nf=1 ad=0.1218 as=0.1218 pd=1.42 ps=1.42 nrd=0.69047619047619  nrs=0.69047619047619 sa=0 sb=0 sd=0 mult=1 m=1
csn_op1_1000_rl_s0p1_r10k_ic_2 sn_op1_1000_rl_s0p1_r10k_ic_2 0 {C_SN}
XMWR_op1_1000_rl_s0p1_r10k_ic_3 sn_op1_1000_rl_s0p1_r10k_ic_3 wwl_des wbl_op1_1000_rl_s0p1_r10k_ic 0 sky130_fd_pr__nfet_01v8 L=0.15 W=0.42 nf=1 ad=0.1218 as=0.1218 pd=1.42 ps=1.42 nrd=0.69047619047619  nrs=0.69047619047619 sa=0 sb=0 sd=0 mult=1 m=1
XMRD_op1_1000_rl_s0p1_r10k_ic_3 rbl_op1_1000_rl_s0p1_r10k_ic sn_op1_1000_rl_s0p1_r10k_ic_3 rwl_des 0 sky130_fd_pr__nfet_01v8 L=0.15 W=0.42 nf=1 ad=0.1218 as=0.1218 pd=1.42 ps=1.42 nrd=0.69047619047619  nrs=0.69047619047619 sa=0 sb=0 sd=0 mult=1 m=1
csn_op1_1000_rl_s0p1_r10k_ic_3 sn_op1_1000_rl_s0p1_r10k_ic_3 0 {C_SN}
XMN1_op1_1000_rl_s0p1_r10k_ic rbl_op1_1000_rl_s0p1_r10k_ic ref_op1_1000_rl_s0p1_r10k_ic vn_op1_1000_rl_s0p1_r10k_ic 0 sky130_fd_pr__nfet_01v8 L=0.15 W=1 nf=1 ad=0.29 as=0.29 pd=2.58 ps=2.58 mult=1 m=1
XMN2_op1_1000_rl_s0p1_r10k_ic ref_op1_1000_rl_s0p1_r10k_ic rbl_op1_1000_rl_s0p1_r10k_ic vn_op1_1000_rl_s0p1_r10k_ic 0 sky130_fd_pr__nfet_01v8 L=0.15 W=1 nf=1 ad=0.29 as=0.29 pd=2.58 ps=2.58 mult=1 m=1
XMP1_op1_1000_rl_s0p1_r10k_ic rbl_op1_1000_rl_s0p1_r10k_ic ref_op1_1000_rl_s0p1_r10k_ic vp_op1_1000_rl_s0p1_r10k_ic vdd sky130_fd_pr__pfet_01v8 L=0.15 W=2 nf=1 ad=0.58 as=0.58 pd=4.58 ps=4.58 mult=1 m=1
XMP2_op1_1000_rl_s0p1_r10k_ic ref_op1_1000_rl_s0p1_r10k_ic rbl_op1_1000_rl_s0p1_r10k_ic vp_op1_1000_rl_s0p1_r10k_ic vdd sky130_fd_pr__pfet_01v8 L=0.15 W=2 nf=1 ad=0.58 as=0.58 pd=4.58 ps=4.58 mult=1 m=1
XMNF_op1_1000_rl_s0p1_r10k_ic vn_op1_1000_rl_s0p1_r10k_ic en_op1_1000_rl_s0p1_r10k_ic 0 0 sky130_fd_pr__nfet_01v8 L=0.15 W=2 nf=1 ad=0.58 as=0.58 pd=4.58 ps=4.58 mult=1 m=1
XMPH_op1_1000_rl_s0p1_r10k_ic vp_op1_1000_rl_s0p1_r10k_ic enb_op1_1000_rl_s0p1_r10k_ic vdd vdd sky130_fd_pr__pfet_01v8 L=0.15 W=4 nf=1 ad=1.16 as=1.16 pd=8.58 ps=8.58 mult=1 m=1
bd_op1_1000_rl_s0p1_r10k_ic d_op1_1000_rl_s0p1_r10k_ic 0 v=v(rbl_op1_1000_rl_s0p1_r10k_ic)-v(ref_op1_1000_rl_s0p1_r10k_ic)

* ---- instance 335: op0_n100_rl_s0p1_r10k_ic (variant rl_s0p1_r10k_ic; probe dec 11.9 ns, release 34 ns, meas 36 ns) ----
vctl_op0_n100_rl_s0p1_r10k_ic ctl_op0_n100_rl_s0p1_r10k_ic 0 pwl(0.0000e+00 {VDD} 2.0000e-09 {VDD} 2.1000e-09 0)
* RWL driver model (EXPERIMENTAL): slew 0.1 ns, series R 10000 ohm; cell pin = rwls_op0_n100_rl_s0p1_r10k_ic
vrs_op0_n100_rl_s0p1_r10k_ic rwlsrc_op0_n100_rl_s0p1_r10k_ic 0 pwl(0.0000e+00 {VDD} 2.0000e-09 {VDD} 2.1000e-09 0 3.4000e-08 0 3.4100e-08 {VDD})
rdrv_op0_n100_rl_s0p1_r10k_ic rwlsrc_op0_n100_rl_s0p1_r10k_ic rwls_op0_n100_rl_s0p1_r10k_ic 10000
ven_op0_n100_rl_s0p1_r10k_ic en_op0_n100_rl_s0p1_r10k_ic 0 pwl(0.0000e+00 0 1.1000e-08 0 1.1100e-08 {VDD} 3.4000e-08 {VDD} 3.4100e-08 0)
venb_op0_n100_rl_s0p1_r10k_ic enb_op0_n100_rl_s0p1_r10k_ic 0 pwl(0.0000e+00 {VDD} 1.1000e-08 {VDD} 1.1100e-08 0 3.4000e-08 0 3.4100e-08 {VDD})
vww_op0_n100_rl_s0p1_r10k_ic wwl_op0_n100_rl_s0p1_r10k_ic 0 pwl(0.0000e+00 0 1.2000e-08 0 1.2100e-08 {VDD} 3.2000e-08 {VDD} 3.2100e-08 0)
vwc_op0_n100_rl_s0p1_r10k_ic wbc_op0_n100_rl_s0p1_r10k_ic 0 pwl(0.0000e+00 0 1.2000e-08 0 1.2100e-08 {VDD} 3.4000e-08 {VDD} 3.4100e-08 0)
swb_op0_n100_rl_s0p1_r10k_ic ref_op0_n100_rl_s0p1_r10k_ic wbl_op0_n100_rl_s0p1_r10k_ic wbc_op0_n100_rl_s0p1_r10k_ic 0 swwbl
cwbl_op0_n100_rl_s0p1_r10k_ic wbl_op0_n100_rl_s0p1_r10k_ic 0 {C_WBL}
spa_op0_n100_rl_s0p1_r10k_ic prea rbl_op0_n100_rl_s0p1_r10k_ic ctl_op0_n100_rl_s0p1_r10k_ic 0 swpre
spr_op0_n100_rl_s0p1_r10k_ic pref ref_op0_n100_rl_s0p1_r10k_ic ctl_op0_n100_rl_s0p1_r10k_ic 0 swpre
crbl_op0_n100_rl_s0p1_r10k_ic rbl_op0_n100_rl_s0p1_r10k_ic 0 {C_RBL}
cref_op0_n100_rl_s0p1_r10k_ic ref_op0_n100_rl_s0p1_r10k_ic 0 {C_RBL}   $ ASSUMPTION: ideal matched dummy load
XMWR_op0_n100_rl_s0p1_r10k_ic_0 sn_op0_n100_rl_s0p1_r10k_ic_0 wwl_op0_n100_rl_s0p1_r10k_ic wbl_op0_n100_rl_s0p1_r10k_ic 0 sky130_fd_pr__nfet_01v8 L=0.15 W=0.42 nf=1 ad=0.1218 as=0.1218 pd=1.42 ps=1.42 nrd=0.69047619047619  nrs=0.69047619047619 sa=0 sb=0 sd=0 mult=1 m=1
XMRD_op0_n100_rl_s0p1_r10k_ic_0 rbl_op0_n100_rl_s0p1_r10k_ic sn_op0_n100_rl_s0p1_r10k_ic_0 rwls_op0_n100_rl_s0p1_r10k_ic 0 sky130_fd_pr__nfet_01v8 L=0.15 W=0.42 nf=1 ad=0.1218 as=0.1218 pd=1.42 ps=1.42 nrd=0.69047619047619  nrs=0.69047619047619 sa=0 sb=0 sd=0 mult=1 m=1
csn_op0_n100_rl_s0p1_r10k_ic_0 sn_op0_n100_rl_s0p1_r10k_ic_0 0 {C_SN}
XMWR_op0_n100_rl_s0p1_r10k_ic_1 sn_op0_n100_rl_s0p1_r10k_ic_1 wwl_des wbl_op0_n100_rl_s0p1_r10k_ic 0 sky130_fd_pr__nfet_01v8 L=0.15 W=0.42 nf=1 ad=0.1218 as=0.1218 pd=1.42 ps=1.42 nrd=0.69047619047619  nrs=0.69047619047619 sa=0 sb=0 sd=0 mult=1 m=1
XMRD_op0_n100_rl_s0p1_r10k_ic_1 rbl_op0_n100_rl_s0p1_r10k_ic sn_op0_n100_rl_s0p1_r10k_ic_1 rwl_des 0 sky130_fd_pr__nfet_01v8 L=0.15 W=0.42 nf=1 ad=0.1218 as=0.1218 pd=1.42 ps=1.42 nrd=0.69047619047619  nrs=0.69047619047619 sa=0 sb=0 sd=0 mult=1 m=1
csn_op0_n100_rl_s0p1_r10k_ic_1 sn_op0_n100_rl_s0p1_r10k_ic_1 0 {C_SN}
XMWR_op0_n100_rl_s0p1_r10k_ic_2 sn_op0_n100_rl_s0p1_r10k_ic_2 wwl_des wbl_op0_n100_rl_s0p1_r10k_ic 0 sky130_fd_pr__nfet_01v8 L=0.15 W=0.42 nf=1 ad=0.1218 as=0.1218 pd=1.42 ps=1.42 nrd=0.69047619047619  nrs=0.69047619047619 sa=0 sb=0 sd=0 mult=1 m=1
XMRD_op0_n100_rl_s0p1_r10k_ic_2 rbl_op0_n100_rl_s0p1_r10k_ic sn_op0_n100_rl_s0p1_r10k_ic_2 rwl_des 0 sky130_fd_pr__nfet_01v8 L=0.15 W=0.42 nf=1 ad=0.1218 as=0.1218 pd=1.42 ps=1.42 nrd=0.69047619047619  nrs=0.69047619047619 sa=0 sb=0 sd=0 mult=1 m=1
csn_op0_n100_rl_s0p1_r10k_ic_2 sn_op0_n100_rl_s0p1_r10k_ic_2 0 {C_SN}
XMWR_op0_n100_rl_s0p1_r10k_ic_3 sn_op0_n100_rl_s0p1_r10k_ic_3 wwl_des wbl_op0_n100_rl_s0p1_r10k_ic 0 sky130_fd_pr__nfet_01v8 L=0.15 W=0.42 nf=1 ad=0.1218 as=0.1218 pd=1.42 ps=1.42 nrd=0.69047619047619  nrs=0.69047619047619 sa=0 sb=0 sd=0 mult=1 m=1
XMRD_op0_n100_rl_s0p1_r10k_ic_3 rbl_op0_n100_rl_s0p1_r10k_ic sn_op0_n100_rl_s0p1_r10k_ic_3 rwl_des 0 sky130_fd_pr__nfet_01v8 L=0.15 W=0.42 nf=1 ad=0.1218 as=0.1218 pd=1.42 ps=1.42 nrd=0.69047619047619  nrs=0.69047619047619 sa=0 sb=0 sd=0 mult=1 m=1
csn_op0_n100_rl_s0p1_r10k_ic_3 sn_op0_n100_rl_s0p1_r10k_ic_3 0 {C_SN}
XMN1_op0_n100_rl_s0p1_r10k_ic rbl_op0_n100_rl_s0p1_r10k_ic ref_op0_n100_rl_s0p1_r10k_ic vn_op0_n100_rl_s0p1_r10k_ic 0 sky130_fd_pr__nfet_01v8 L=0.15 W=1 nf=1 ad=0.29 as=0.29 pd=2.58 ps=2.58 mult=1 m=1
XMN2_op0_n100_rl_s0p1_r10k_ic ref_op0_n100_rl_s0p1_r10k_ic rbl_op0_n100_rl_s0p1_r10k_ic vn_op0_n100_rl_s0p1_r10k_ic 0 sky130_fd_pr__nfet_01v8 L=0.15 W=1 nf=1 ad=0.29 as=0.29 pd=2.58 ps=2.58 mult=1 m=1
XMP1_op0_n100_rl_s0p1_r10k_ic rbl_op0_n100_rl_s0p1_r10k_ic ref_op0_n100_rl_s0p1_r10k_ic vp_op0_n100_rl_s0p1_r10k_ic vdd sky130_fd_pr__pfet_01v8 L=0.15 W=2 nf=1 ad=0.58 as=0.58 pd=4.58 ps=4.58 mult=1 m=1
XMP2_op0_n100_rl_s0p1_r10k_ic ref_op0_n100_rl_s0p1_r10k_ic rbl_op0_n100_rl_s0p1_r10k_ic vp_op0_n100_rl_s0p1_r10k_ic vdd sky130_fd_pr__pfet_01v8 L=0.15 W=2 nf=1 ad=0.58 as=0.58 pd=4.58 ps=4.58 mult=1 m=1
XMNF_op0_n100_rl_s0p1_r10k_ic vn_op0_n100_rl_s0p1_r10k_ic en_op0_n100_rl_s0p1_r10k_ic 0 0 sky130_fd_pr__nfet_01v8 L=0.15 W=2 nf=1 ad=0.58 as=0.58 pd=4.58 ps=4.58 mult=1 m=1
XMPH_op0_n100_rl_s0p1_r10k_ic vp_op0_n100_rl_s0p1_r10k_ic enb_op0_n100_rl_s0p1_r10k_ic vdd vdd sky130_fd_pr__pfet_01v8 L=0.15 W=4 nf=1 ad=1.16 as=1.16 pd=8.58 ps=8.58 mult=1 m=1
bd_op0_n100_rl_s0p1_r10k_ic d_op0_n100_rl_s0p1_r10k_ic 0 v=v(rbl_op0_n100_rl_s0p1_r10k_ic)-v(ref_op0_n100_rl_s0p1_r10k_ic)

* ---- instance 336: op0_0000_rl_s0p1_r10k_ic (variant rl_s0p1_r10k_ic; probe dec 11.9 ns, release 34 ns, meas 36 ns) ----
vctl_op0_0000_rl_s0p1_r10k_ic ctl_op0_0000_rl_s0p1_r10k_ic 0 pwl(0.0000e+00 {VDD} 2.0000e-09 {VDD} 2.1000e-09 0)
* RWL driver model (EXPERIMENTAL): slew 0.1 ns, series R 10000 ohm; cell pin = rwls_op0_0000_rl_s0p1_r10k_ic
vrs_op0_0000_rl_s0p1_r10k_ic rwlsrc_op0_0000_rl_s0p1_r10k_ic 0 pwl(0.0000e+00 {VDD} 2.0000e-09 {VDD} 2.1000e-09 0 3.4000e-08 0 3.4100e-08 {VDD})
rdrv_op0_0000_rl_s0p1_r10k_ic rwlsrc_op0_0000_rl_s0p1_r10k_ic rwls_op0_0000_rl_s0p1_r10k_ic 10000
ven_op0_0000_rl_s0p1_r10k_ic en_op0_0000_rl_s0p1_r10k_ic 0 pwl(0.0000e+00 0 1.1000e-08 0 1.1100e-08 {VDD} 3.4000e-08 {VDD} 3.4100e-08 0)
venb_op0_0000_rl_s0p1_r10k_ic enb_op0_0000_rl_s0p1_r10k_ic 0 pwl(0.0000e+00 {VDD} 1.1000e-08 {VDD} 1.1100e-08 0 3.4000e-08 0 3.4100e-08 {VDD})
vww_op0_0000_rl_s0p1_r10k_ic wwl_op0_0000_rl_s0p1_r10k_ic 0 pwl(0.0000e+00 0 1.2000e-08 0 1.2100e-08 {VDD} 3.2000e-08 {VDD} 3.2100e-08 0)
vwc_op0_0000_rl_s0p1_r10k_ic wbc_op0_0000_rl_s0p1_r10k_ic 0 pwl(0.0000e+00 0 1.2000e-08 0 1.2100e-08 {VDD} 3.4000e-08 {VDD} 3.4100e-08 0)
swb_op0_0000_rl_s0p1_r10k_ic ref_op0_0000_rl_s0p1_r10k_ic wbl_op0_0000_rl_s0p1_r10k_ic wbc_op0_0000_rl_s0p1_r10k_ic 0 swwbl
cwbl_op0_0000_rl_s0p1_r10k_ic wbl_op0_0000_rl_s0p1_r10k_ic 0 {C_WBL}
spa_op0_0000_rl_s0p1_r10k_ic prea rbl_op0_0000_rl_s0p1_r10k_ic ctl_op0_0000_rl_s0p1_r10k_ic 0 swpre
spr_op0_0000_rl_s0p1_r10k_ic pref ref_op0_0000_rl_s0p1_r10k_ic ctl_op0_0000_rl_s0p1_r10k_ic 0 swpre
crbl_op0_0000_rl_s0p1_r10k_ic rbl_op0_0000_rl_s0p1_r10k_ic 0 {C_RBL}
cref_op0_0000_rl_s0p1_r10k_ic ref_op0_0000_rl_s0p1_r10k_ic 0 {C_RBL}   $ ASSUMPTION: ideal matched dummy load
XMWR_op0_0000_rl_s0p1_r10k_ic_0 sn_op0_0000_rl_s0p1_r10k_ic_0 wwl_op0_0000_rl_s0p1_r10k_ic wbl_op0_0000_rl_s0p1_r10k_ic 0 sky130_fd_pr__nfet_01v8 L=0.15 W=0.42 nf=1 ad=0.1218 as=0.1218 pd=1.42 ps=1.42 nrd=0.69047619047619  nrs=0.69047619047619 sa=0 sb=0 sd=0 mult=1 m=1
XMRD_op0_0000_rl_s0p1_r10k_ic_0 rbl_op0_0000_rl_s0p1_r10k_ic sn_op0_0000_rl_s0p1_r10k_ic_0 rwls_op0_0000_rl_s0p1_r10k_ic 0 sky130_fd_pr__nfet_01v8 L=0.15 W=0.42 nf=1 ad=0.1218 as=0.1218 pd=1.42 ps=1.42 nrd=0.69047619047619  nrs=0.69047619047619 sa=0 sb=0 sd=0 mult=1 m=1
csn_op0_0000_rl_s0p1_r10k_ic_0 sn_op0_0000_rl_s0p1_r10k_ic_0 0 {C_SN}
XMWR_op0_0000_rl_s0p1_r10k_ic_1 sn_op0_0000_rl_s0p1_r10k_ic_1 wwl_des wbl_op0_0000_rl_s0p1_r10k_ic 0 sky130_fd_pr__nfet_01v8 L=0.15 W=0.42 nf=1 ad=0.1218 as=0.1218 pd=1.42 ps=1.42 nrd=0.69047619047619  nrs=0.69047619047619 sa=0 sb=0 sd=0 mult=1 m=1
XMRD_op0_0000_rl_s0p1_r10k_ic_1 rbl_op0_0000_rl_s0p1_r10k_ic sn_op0_0000_rl_s0p1_r10k_ic_1 rwl_des 0 sky130_fd_pr__nfet_01v8 L=0.15 W=0.42 nf=1 ad=0.1218 as=0.1218 pd=1.42 ps=1.42 nrd=0.69047619047619  nrs=0.69047619047619 sa=0 sb=0 sd=0 mult=1 m=1
csn_op0_0000_rl_s0p1_r10k_ic_1 sn_op0_0000_rl_s0p1_r10k_ic_1 0 {C_SN}
XMWR_op0_0000_rl_s0p1_r10k_ic_2 sn_op0_0000_rl_s0p1_r10k_ic_2 wwl_des wbl_op0_0000_rl_s0p1_r10k_ic 0 sky130_fd_pr__nfet_01v8 L=0.15 W=0.42 nf=1 ad=0.1218 as=0.1218 pd=1.42 ps=1.42 nrd=0.69047619047619  nrs=0.69047619047619 sa=0 sb=0 sd=0 mult=1 m=1
XMRD_op0_0000_rl_s0p1_r10k_ic_2 rbl_op0_0000_rl_s0p1_r10k_ic sn_op0_0000_rl_s0p1_r10k_ic_2 rwl_des 0 sky130_fd_pr__nfet_01v8 L=0.15 W=0.42 nf=1 ad=0.1218 as=0.1218 pd=1.42 ps=1.42 nrd=0.69047619047619  nrs=0.69047619047619 sa=0 sb=0 sd=0 mult=1 m=1
csn_op0_0000_rl_s0p1_r10k_ic_2 sn_op0_0000_rl_s0p1_r10k_ic_2 0 {C_SN}
XMWR_op0_0000_rl_s0p1_r10k_ic_3 sn_op0_0000_rl_s0p1_r10k_ic_3 wwl_des wbl_op0_0000_rl_s0p1_r10k_ic 0 sky130_fd_pr__nfet_01v8 L=0.15 W=0.42 nf=1 ad=0.1218 as=0.1218 pd=1.42 ps=1.42 nrd=0.69047619047619  nrs=0.69047619047619 sa=0 sb=0 sd=0 mult=1 m=1
XMRD_op0_0000_rl_s0p1_r10k_ic_3 rbl_op0_0000_rl_s0p1_r10k_ic sn_op0_0000_rl_s0p1_r10k_ic_3 rwl_des 0 sky130_fd_pr__nfet_01v8 L=0.15 W=0.42 nf=1 ad=0.1218 as=0.1218 pd=1.42 ps=1.42 nrd=0.69047619047619  nrs=0.69047619047619 sa=0 sb=0 sd=0 mult=1 m=1
csn_op0_0000_rl_s0p1_r10k_ic_3 sn_op0_0000_rl_s0p1_r10k_ic_3 0 {C_SN}
XMN1_op0_0000_rl_s0p1_r10k_ic rbl_op0_0000_rl_s0p1_r10k_ic ref_op0_0000_rl_s0p1_r10k_ic vn_op0_0000_rl_s0p1_r10k_ic 0 sky130_fd_pr__nfet_01v8 L=0.15 W=1 nf=1 ad=0.29 as=0.29 pd=2.58 ps=2.58 mult=1 m=1
XMN2_op0_0000_rl_s0p1_r10k_ic ref_op0_0000_rl_s0p1_r10k_ic rbl_op0_0000_rl_s0p1_r10k_ic vn_op0_0000_rl_s0p1_r10k_ic 0 sky130_fd_pr__nfet_01v8 L=0.15 W=1 nf=1 ad=0.29 as=0.29 pd=2.58 ps=2.58 mult=1 m=1
XMP1_op0_0000_rl_s0p1_r10k_ic rbl_op0_0000_rl_s0p1_r10k_ic ref_op0_0000_rl_s0p1_r10k_ic vp_op0_0000_rl_s0p1_r10k_ic vdd sky130_fd_pr__pfet_01v8 L=0.15 W=2 nf=1 ad=0.58 as=0.58 pd=4.58 ps=4.58 mult=1 m=1
XMP2_op0_0000_rl_s0p1_r10k_ic ref_op0_0000_rl_s0p1_r10k_ic rbl_op0_0000_rl_s0p1_r10k_ic vp_op0_0000_rl_s0p1_r10k_ic vdd sky130_fd_pr__pfet_01v8 L=0.15 W=2 nf=1 ad=0.58 as=0.58 pd=4.58 ps=4.58 mult=1 m=1
XMNF_op0_0000_rl_s0p1_r10k_ic vn_op0_0000_rl_s0p1_r10k_ic en_op0_0000_rl_s0p1_r10k_ic 0 0 sky130_fd_pr__nfet_01v8 L=0.15 W=2 nf=1 ad=0.58 as=0.58 pd=4.58 ps=4.58 mult=1 m=1
XMPH_op0_0000_rl_s0p1_r10k_ic vp_op0_0000_rl_s0p1_r10k_ic enb_op0_0000_rl_s0p1_r10k_ic vdd vdd sky130_fd_pr__pfet_01v8 L=0.15 W=4 nf=1 ad=1.16 as=1.16 pd=8.58 ps=8.58 mult=1 m=1
bd_op0_0000_rl_s0p1_r10k_ic d_op0_0000_rl_s0p1_r10k_ic 0 v=v(rbl_op0_0000_rl_s0p1_r10k_ic)-v(ref_op0_0000_rl_s0p1_r10k_ic)

* ---- instance 337: op1_0900_nr_s0p1_r0 (variant nr_s0p1_r0; probe dec 11.9 ns, release 34 ns, meas 36 ns) ----
vctl_op1_0900_nr_s0p1_r0 ctl_op1_0900_nr_s0p1_r0 0 pwl(0.0000e+00 {VDD} 2.0000e-09 {VDD} 2.1000e-09 0)
* RWL driver model (EXPERIMENTAL): slew 0.1 ns, series R 0 ohm; cell pin = rwls_op1_0900_nr_s0p1_r0
vrs_op1_0900_nr_s0p1_r0 rwls_op1_0900_nr_s0p1_r0 0 pwl(0.0000e+00 {VDD} 2.0000e-09 {VDD} 2.1000e-09 0 1.2000e-08 0 1.2100e-08 {VDD})
ven_op1_0900_nr_s0p1_r0 en_op1_0900_nr_s0p1_r0 0 pwl(0.0000e+00 0 1.1000e-08 0 1.1100e-08 {VDD} 3.4000e-08 {VDD} 3.4100e-08 0)
venb_op1_0900_nr_s0p1_r0 enb_op1_0900_nr_s0p1_r0 0 pwl(0.0000e+00 {VDD} 1.1000e-08 {VDD} 1.1100e-08 0 3.4000e-08 0 3.4100e-08 {VDD})
vww_op1_0900_nr_s0p1_r0 wwl_op1_0900_nr_s0p1_r0 0 pwl(0.0000e+00 0)
vwc_op1_0900_nr_s0p1_r0 wbc_op1_0900_nr_s0p1_r0 0 pwl(0.0000e+00 0)
swb_op1_0900_nr_s0p1_r0 ref_op1_0900_nr_s0p1_r0 wbl_op1_0900_nr_s0p1_r0 wbc_op1_0900_nr_s0p1_r0 0 swwbl
cwbl_op1_0900_nr_s0p1_r0 wbl_op1_0900_nr_s0p1_r0 0 {C_WBL}
spa_op1_0900_nr_s0p1_r0 prea rbl_op1_0900_nr_s0p1_r0 ctl_op1_0900_nr_s0p1_r0 0 swpre
spr_op1_0900_nr_s0p1_r0 pref ref_op1_0900_nr_s0p1_r0 ctl_op1_0900_nr_s0p1_r0 0 swpre
crbl_op1_0900_nr_s0p1_r0 rbl_op1_0900_nr_s0p1_r0 0 {C_RBL}
cref_op1_0900_nr_s0p1_r0 ref_op1_0900_nr_s0p1_r0 0 {C_RBL}   $ ASSUMPTION: ideal matched dummy load
XMWR_op1_0900_nr_s0p1_r0_0 sn_op1_0900_nr_s0p1_r0_0 wwl_op1_0900_nr_s0p1_r0 wbl_op1_0900_nr_s0p1_r0 0 sky130_fd_pr__nfet_01v8 L=0.15 W=0.42 nf=1 ad=0.1218 as=0.1218 pd=1.42 ps=1.42 nrd=0.69047619047619  nrs=0.69047619047619 sa=0 sb=0 sd=0 mult=1 m=1
XMRD_op1_0900_nr_s0p1_r0_0 rbl_op1_0900_nr_s0p1_r0 sn_op1_0900_nr_s0p1_r0_0 rwls_op1_0900_nr_s0p1_r0 0 sky130_fd_pr__nfet_01v8 L=0.15 W=0.42 nf=1 ad=0.1218 as=0.1218 pd=1.42 ps=1.42 nrd=0.69047619047619  nrs=0.69047619047619 sa=0 sb=0 sd=0 mult=1 m=1
csn_op1_0900_nr_s0p1_r0_0 sn_op1_0900_nr_s0p1_r0_0 0 {C_SN}
XMWR_op1_0900_nr_s0p1_r0_1 sn_op1_0900_nr_s0p1_r0_1 wwl_des wbl_op1_0900_nr_s0p1_r0 0 sky130_fd_pr__nfet_01v8 L=0.15 W=0.42 nf=1 ad=0.1218 as=0.1218 pd=1.42 ps=1.42 nrd=0.69047619047619  nrs=0.69047619047619 sa=0 sb=0 sd=0 mult=1 m=1
XMRD_op1_0900_nr_s0p1_r0_1 rbl_op1_0900_nr_s0p1_r0 sn_op1_0900_nr_s0p1_r0_1 rwl_des 0 sky130_fd_pr__nfet_01v8 L=0.15 W=0.42 nf=1 ad=0.1218 as=0.1218 pd=1.42 ps=1.42 nrd=0.69047619047619  nrs=0.69047619047619 sa=0 sb=0 sd=0 mult=1 m=1
csn_op1_0900_nr_s0p1_r0_1 sn_op1_0900_nr_s0p1_r0_1 0 {C_SN}
XMWR_op1_0900_nr_s0p1_r0_2 sn_op1_0900_nr_s0p1_r0_2 wwl_des wbl_op1_0900_nr_s0p1_r0 0 sky130_fd_pr__nfet_01v8 L=0.15 W=0.42 nf=1 ad=0.1218 as=0.1218 pd=1.42 ps=1.42 nrd=0.69047619047619  nrs=0.69047619047619 sa=0 sb=0 sd=0 mult=1 m=1
XMRD_op1_0900_nr_s0p1_r0_2 rbl_op1_0900_nr_s0p1_r0 sn_op1_0900_nr_s0p1_r0_2 rwl_des 0 sky130_fd_pr__nfet_01v8 L=0.15 W=0.42 nf=1 ad=0.1218 as=0.1218 pd=1.42 ps=1.42 nrd=0.69047619047619  nrs=0.69047619047619 sa=0 sb=0 sd=0 mult=1 m=1
csn_op1_0900_nr_s0p1_r0_2 sn_op1_0900_nr_s0p1_r0_2 0 {C_SN}
XMWR_op1_0900_nr_s0p1_r0_3 sn_op1_0900_nr_s0p1_r0_3 wwl_des wbl_op1_0900_nr_s0p1_r0 0 sky130_fd_pr__nfet_01v8 L=0.15 W=0.42 nf=1 ad=0.1218 as=0.1218 pd=1.42 ps=1.42 nrd=0.69047619047619  nrs=0.69047619047619 sa=0 sb=0 sd=0 mult=1 m=1
XMRD_op1_0900_nr_s0p1_r0_3 rbl_op1_0900_nr_s0p1_r0 sn_op1_0900_nr_s0p1_r0_3 rwl_des 0 sky130_fd_pr__nfet_01v8 L=0.15 W=0.42 nf=1 ad=0.1218 as=0.1218 pd=1.42 ps=1.42 nrd=0.69047619047619  nrs=0.69047619047619 sa=0 sb=0 sd=0 mult=1 m=1
csn_op1_0900_nr_s0p1_r0_3 sn_op1_0900_nr_s0p1_r0_3 0 {C_SN}
XMN1_op1_0900_nr_s0p1_r0 rbl_op1_0900_nr_s0p1_r0 ref_op1_0900_nr_s0p1_r0 vn_op1_0900_nr_s0p1_r0 0 sky130_fd_pr__nfet_01v8 L=0.15 W=1 nf=1 ad=0.29 as=0.29 pd=2.58 ps=2.58 mult=1 m=1
XMN2_op1_0900_nr_s0p1_r0 ref_op1_0900_nr_s0p1_r0 rbl_op1_0900_nr_s0p1_r0 vn_op1_0900_nr_s0p1_r0 0 sky130_fd_pr__nfet_01v8 L=0.15 W=1 nf=1 ad=0.29 as=0.29 pd=2.58 ps=2.58 mult=1 m=1
XMP1_op1_0900_nr_s0p1_r0 rbl_op1_0900_nr_s0p1_r0 ref_op1_0900_nr_s0p1_r0 vp_op1_0900_nr_s0p1_r0 vdd sky130_fd_pr__pfet_01v8 L=0.15 W=2 nf=1 ad=0.58 as=0.58 pd=4.58 ps=4.58 mult=1 m=1
XMP2_op1_0900_nr_s0p1_r0 ref_op1_0900_nr_s0p1_r0 rbl_op1_0900_nr_s0p1_r0 vp_op1_0900_nr_s0p1_r0 vdd sky130_fd_pr__pfet_01v8 L=0.15 W=2 nf=1 ad=0.58 as=0.58 pd=4.58 ps=4.58 mult=1 m=1
XMNF_op1_0900_nr_s0p1_r0 vn_op1_0900_nr_s0p1_r0 en_op1_0900_nr_s0p1_r0 0 0 sky130_fd_pr__nfet_01v8 L=0.15 W=2 nf=1 ad=0.58 as=0.58 pd=4.58 ps=4.58 mult=1 m=1
XMPH_op1_0900_nr_s0p1_r0 vp_op1_0900_nr_s0p1_r0 enb_op1_0900_nr_s0p1_r0 vdd vdd sky130_fd_pr__pfet_01v8 L=0.15 W=4 nf=1 ad=1.16 as=1.16 pd=8.58 ps=8.58 mult=1 m=1
bd_op1_0900_nr_s0p1_r0 d_op1_0900_nr_s0p1_r0 0 v=v(rbl_op1_0900_nr_s0p1_r0)-v(ref_op1_0900_nr_s0p1_r0)

* ---- instance 338: op1_1000_nr_s0p1_r0 (variant nr_s0p1_r0; probe dec 11.9 ns, release 34 ns, meas 36 ns) ----
vctl_op1_1000_nr_s0p1_r0 ctl_op1_1000_nr_s0p1_r0 0 pwl(0.0000e+00 {VDD} 2.0000e-09 {VDD} 2.1000e-09 0)
* RWL driver model (EXPERIMENTAL): slew 0.1 ns, series R 0 ohm; cell pin = rwls_op1_1000_nr_s0p1_r0
vrs_op1_1000_nr_s0p1_r0 rwls_op1_1000_nr_s0p1_r0 0 pwl(0.0000e+00 {VDD} 2.0000e-09 {VDD} 2.1000e-09 0 1.2000e-08 0 1.2100e-08 {VDD})
ven_op1_1000_nr_s0p1_r0 en_op1_1000_nr_s0p1_r0 0 pwl(0.0000e+00 0 1.1000e-08 0 1.1100e-08 {VDD} 3.4000e-08 {VDD} 3.4100e-08 0)
venb_op1_1000_nr_s0p1_r0 enb_op1_1000_nr_s0p1_r0 0 pwl(0.0000e+00 {VDD} 1.1000e-08 {VDD} 1.1100e-08 0 3.4000e-08 0 3.4100e-08 {VDD})
vww_op1_1000_nr_s0p1_r0 wwl_op1_1000_nr_s0p1_r0 0 pwl(0.0000e+00 0)
vwc_op1_1000_nr_s0p1_r0 wbc_op1_1000_nr_s0p1_r0 0 pwl(0.0000e+00 0)
swb_op1_1000_nr_s0p1_r0 ref_op1_1000_nr_s0p1_r0 wbl_op1_1000_nr_s0p1_r0 wbc_op1_1000_nr_s0p1_r0 0 swwbl
cwbl_op1_1000_nr_s0p1_r0 wbl_op1_1000_nr_s0p1_r0 0 {C_WBL}
spa_op1_1000_nr_s0p1_r0 prea rbl_op1_1000_nr_s0p1_r0 ctl_op1_1000_nr_s0p1_r0 0 swpre
spr_op1_1000_nr_s0p1_r0 pref ref_op1_1000_nr_s0p1_r0 ctl_op1_1000_nr_s0p1_r0 0 swpre
crbl_op1_1000_nr_s0p1_r0 rbl_op1_1000_nr_s0p1_r0 0 {C_RBL}
cref_op1_1000_nr_s0p1_r0 ref_op1_1000_nr_s0p1_r0 0 {C_RBL}   $ ASSUMPTION: ideal matched dummy load
XMWR_op1_1000_nr_s0p1_r0_0 sn_op1_1000_nr_s0p1_r0_0 wwl_op1_1000_nr_s0p1_r0 wbl_op1_1000_nr_s0p1_r0 0 sky130_fd_pr__nfet_01v8 L=0.15 W=0.42 nf=1 ad=0.1218 as=0.1218 pd=1.42 ps=1.42 nrd=0.69047619047619  nrs=0.69047619047619 sa=0 sb=0 sd=0 mult=1 m=1
XMRD_op1_1000_nr_s0p1_r0_0 rbl_op1_1000_nr_s0p1_r0 sn_op1_1000_nr_s0p1_r0_0 rwls_op1_1000_nr_s0p1_r0 0 sky130_fd_pr__nfet_01v8 L=0.15 W=0.42 nf=1 ad=0.1218 as=0.1218 pd=1.42 ps=1.42 nrd=0.69047619047619  nrs=0.69047619047619 sa=0 sb=0 sd=0 mult=1 m=1
csn_op1_1000_nr_s0p1_r0_0 sn_op1_1000_nr_s0p1_r0_0 0 {C_SN}
XMWR_op1_1000_nr_s0p1_r0_1 sn_op1_1000_nr_s0p1_r0_1 wwl_des wbl_op1_1000_nr_s0p1_r0 0 sky130_fd_pr__nfet_01v8 L=0.15 W=0.42 nf=1 ad=0.1218 as=0.1218 pd=1.42 ps=1.42 nrd=0.69047619047619  nrs=0.69047619047619 sa=0 sb=0 sd=0 mult=1 m=1
XMRD_op1_1000_nr_s0p1_r0_1 rbl_op1_1000_nr_s0p1_r0 sn_op1_1000_nr_s0p1_r0_1 rwl_des 0 sky130_fd_pr__nfet_01v8 L=0.15 W=0.42 nf=1 ad=0.1218 as=0.1218 pd=1.42 ps=1.42 nrd=0.69047619047619  nrs=0.69047619047619 sa=0 sb=0 sd=0 mult=1 m=1
csn_op1_1000_nr_s0p1_r0_1 sn_op1_1000_nr_s0p1_r0_1 0 {C_SN}
XMWR_op1_1000_nr_s0p1_r0_2 sn_op1_1000_nr_s0p1_r0_2 wwl_des wbl_op1_1000_nr_s0p1_r0 0 sky130_fd_pr__nfet_01v8 L=0.15 W=0.42 nf=1 ad=0.1218 as=0.1218 pd=1.42 ps=1.42 nrd=0.69047619047619  nrs=0.69047619047619 sa=0 sb=0 sd=0 mult=1 m=1
XMRD_op1_1000_nr_s0p1_r0_2 rbl_op1_1000_nr_s0p1_r0 sn_op1_1000_nr_s0p1_r0_2 rwl_des 0 sky130_fd_pr__nfet_01v8 L=0.15 W=0.42 nf=1 ad=0.1218 as=0.1218 pd=1.42 ps=1.42 nrd=0.69047619047619  nrs=0.69047619047619 sa=0 sb=0 sd=0 mult=1 m=1
csn_op1_1000_nr_s0p1_r0_2 sn_op1_1000_nr_s0p1_r0_2 0 {C_SN}
XMWR_op1_1000_nr_s0p1_r0_3 sn_op1_1000_nr_s0p1_r0_3 wwl_des wbl_op1_1000_nr_s0p1_r0 0 sky130_fd_pr__nfet_01v8 L=0.15 W=0.42 nf=1 ad=0.1218 as=0.1218 pd=1.42 ps=1.42 nrd=0.69047619047619  nrs=0.69047619047619 sa=0 sb=0 sd=0 mult=1 m=1
XMRD_op1_1000_nr_s0p1_r0_3 rbl_op1_1000_nr_s0p1_r0 sn_op1_1000_nr_s0p1_r0_3 rwl_des 0 sky130_fd_pr__nfet_01v8 L=0.15 W=0.42 nf=1 ad=0.1218 as=0.1218 pd=1.42 ps=1.42 nrd=0.69047619047619  nrs=0.69047619047619 sa=0 sb=0 sd=0 mult=1 m=1
csn_op1_1000_nr_s0p1_r0_3 sn_op1_1000_nr_s0p1_r0_3 0 {C_SN}
XMN1_op1_1000_nr_s0p1_r0 rbl_op1_1000_nr_s0p1_r0 ref_op1_1000_nr_s0p1_r0 vn_op1_1000_nr_s0p1_r0 0 sky130_fd_pr__nfet_01v8 L=0.15 W=1 nf=1 ad=0.29 as=0.29 pd=2.58 ps=2.58 mult=1 m=1
XMN2_op1_1000_nr_s0p1_r0 ref_op1_1000_nr_s0p1_r0 rbl_op1_1000_nr_s0p1_r0 vn_op1_1000_nr_s0p1_r0 0 sky130_fd_pr__nfet_01v8 L=0.15 W=1 nf=1 ad=0.29 as=0.29 pd=2.58 ps=2.58 mult=1 m=1
XMP1_op1_1000_nr_s0p1_r0 rbl_op1_1000_nr_s0p1_r0 ref_op1_1000_nr_s0p1_r0 vp_op1_1000_nr_s0p1_r0 vdd sky130_fd_pr__pfet_01v8 L=0.15 W=2 nf=1 ad=0.58 as=0.58 pd=4.58 ps=4.58 mult=1 m=1
XMP2_op1_1000_nr_s0p1_r0 ref_op1_1000_nr_s0p1_r0 rbl_op1_1000_nr_s0p1_r0 vp_op1_1000_nr_s0p1_r0 vdd sky130_fd_pr__pfet_01v8 L=0.15 W=2 nf=1 ad=0.58 as=0.58 pd=4.58 ps=4.58 mult=1 m=1
XMNF_op1_1000_nr_s0p1_r0 vn_op1_1000_nr_s0p1_r0 en_op1_1000_nr_s0p1_r0 0 0 sky130_fd_pr__nfet_01v8 L=0.15 W=2 nf=1 ad=0.58 as=0.58 pd=4.58 ps=4.58 mult=1 m=1
XMPH_op1_1000_nr_s0p1_r0 vp_op1_1000_nr_s0p1_r0 enb_op1_1000_nr_s0p1_r0 vdd vdd sky130_fd_pr__pfet_01v8 L=0.15 W=4 nf=1 ad=1.16 as=1.16 pd=8.58 ps=8.58 mult=1 m=1
bd_op1_1000_nr_s0p1_r0 d_op1_1000_nr_s0p1_r0 0 v=v(rbl_op1_1000_nr_s0p1_r0)-v(ref_op1_1000_nr_s0p1_r0)

* ---- instance 339: op0_n100_nr_s0p1_r0 (variant nr_s0p1_r0; probe dec 11.9 ns, release 34 ns, meas 36 ns) ----
vctl_op0_n100_nr_s0p1_r0 ctl_op0_n100_nr_s0p1_r0 0 pwl(0.0000e+00 {VDD} 2.0000e-09 {VDD} 2.1000e-09 0)
* RWL driver model (EXPERIMENTAL): slew 0.1 ns, series R 0 ohm; cell pin = rwls_op0_n100_nr_s0p1_r0
vrs_op0_n100_nr_s0p1_r0 rwls_op0_n100_nr_s0p1_r0 0 pwl(0.0000e+00 {VDD} 2.0000e-09 {VDD} 2.1000e-09 0 1.2000e-08 0 1.2100e-08 {VDD})
ven_op0_n100_nr_s0p1_r0 en_op0_n100_nr_s0p1_r0 0 pwl(0.0000e+00 0 1.1000e-08 0 1.1100e-08 {VDD} 3.4000e-08 {VDD} 3.4100e-08 0)
venb_op0_n100_nr_s0p1_r0 enb_op0_n100_nr_s0p1_r0 0 pwl(0.0000e+00 {VDD} 1.1000e-08 {VDD} 1.1100e-08 0 3.4000e-08 0 3.4100e-08 {VDD})
vww_op0_n100_nr_s0p1_r0 wwl_op0_n100_nr_s0p1_r0 0 pwl(0.0000e+00 0)
vwc_op0_n100_nr_s0p1_r0 wbc_op0_n100_nr_s0p1_r0 0 pwl(0.0000e+00 0)
swb_op0_n100_nr_s0p1_r0 ref_op0_n100_nr_s0p1_r0 wbl_op0_n100_nr_s0p1_r0 wbc_op0_n100_nr_s0p1_r0 0 swwbl
cwbl_op0_n100_nr_s0p1_r0 wbl_op0_n100_nr_s0p1_r0 0 {C_WBL}
spa_op0_n100_nr_s0p1_r0 prea rbl_op0_n100_nr_s0p1_r0 ctl_op0_n100_nr_s0p1_r0 0 swpre
spr_op0_n100_nr_s0p1_r0 pref ref_op0_n100_nr_s0p1_r0 ctl_op0_n100_nr_s0p1_r0 0 swpre
crbl_op0_n100_nr_s0p1_r0 rbl_op0_n100_nr_s0p1_r0 0 {C_RBL}
cref_op0_n100_nr_s0p1_r0 ref_op0_n100_nr_s0p1_r0 0 {C_RBL}   $ ASSUMPTION: ideal matched dummy load
XMWR_op0_n100_nr_s0p1_r0_0 sn_op0_n100_nr_s0p1_r0_0 wwl_op0_n100_nr_s0p1_r0 wbl_op0_n100_nr_s0p1_r0 0 sky130_fd_pr__nfet_01v8 L=0.15 W=0.42 nf=1 ad=0.1218 as=0.1218 pd=1.42 ps=1.42 nrd=0.69047619047619  nrs=0.69047619047619 sa=0 sb=0 sd=0 mult=1 m=1
XMRD_op0_n100_nr_s0p1_r0_0 rbl_op0_n100_nr_s0p1_r0 sn_op0_n100_nr_s0p1_r0_0 rwls_op0_n100_nr_s0p1_r0 0 sky130_fd_pr__nfet_01v8 L=0.15 W=0.42 nf=1 ad=0.1218 as=0.1218 pd=1.42 ps=1.42 nrd=0.69047619047619  nrs=0.69047619047619 sa=0 sb=0 sd=0 mult=1 m=1
csn_op0_n100_nr_s0p1_r0_0 sn_op0_n100_nr_s0p1_r0_0 0 {C_SN}
XMWR_op0_n100_nr_s0p1_r0_1 sn_op0_n100_nr_s0p1_r0_1 wwl_des wbl_op0_n100_nr_s0p1_r0 0 sky130_fd_pr__nfet_01v8 L=0.15 W=0.42 nf=1 ad=0.1218 as=0.1218 pd=1.42 ps=1.42 nrd=0.69047619047619  nrs=0.69047619047619 sa=0 sb=0 sd=0 mult=1 m=1
XMRD_op0_n100_nr_s0p1_r0_1 rbl_op0_n100_nr_s0p1_r0 sn_op0_n100_nr_s0p1_r0_1 rwl_des 0 sky130_fd_pr__nfet_01v8 L=0.15 W=0.42 nf=1 ad=0.1218 as=0.1218 pd=1.42 ps=1.42 nrd=0.69047619047619  nrs=0.69047619047619 sa=0 sb=0 sd=0 mult=1 m=1
csn_op0_n100_nr_s0p1_r0_1 sn_op0_n100_nr_s0p1_r0_1 0 {C_SN}
XMWR_op0_n100_nr_s0p1_r0_2 sn_op0_n100_nr_s0p1_r0_2 wwl_des wbl_op0_n100_nr_s0p1_r0 0 sky130_fd_pr__nfet_01v8 L=0.15 W=0.42 nf=1 ad=0.1218 as=0.1218 pd=1.42 ps=1.42 nrd=0.69047619047619  nrs=0.69047619047619 sa=0 sb=0 sd=0 mult=1 m=1
XMRD_op0_n100_nr_s0p1_r0_2 rbl_op0_n100_nr_s0p1_r0 sn_op0_n100_nr_s0p1_r0_2 rwl_des 0 sky130_fd_pr__nfet_01v8 L=0.15 W=0.42 nf=1 ad=0.1218 as=0.1218 pd=1.42 ps=1.42 nrd=0.69047619047619  nrs=0.69047619047619 sa=0 sb=0 sd=0 mult=1 m=1
csn_op0_n100_nr_s0p1_r0_2 sn_op0_n100_nr_s0p1_r0_2 0 {C_SN}
XMWR_op0_n100_nr_s0p1_r0_3 sn_op0_n100_nr_s0p1_r0_3 wwl_des wbl_op0_n100_nr_s0p1_r0 0 sky130_fd_pr__nfet_01v8 L=0.15 W=0.42 nf=1 ad=0.1218 as=0.1218 pd=1.42 ps=1.42 nrd=0.69047619047619  nrs=0.69047619047619 sa=0 sb=0 sd=0 mult=1 m=1
XMRD_op0_n100_nr_s0p1_r0_3 rbl_op0_n100_nr_s0p1_r0 sn_op0_n100_nr_s0p1_r0_3 rwl_des 0 sky130_fd_pr__nfet_01v8 L=0.15 W=0.42 nf=1 ad=0.1218 as=0.1218 pd=1.42 ps=1.42 nrd=0.69047619047619  nrs=0.69047619047619 sa=0 sb=0 sd=0 mult=1 m=1
csn_op0_n100_nr_s0p1_r0_3 sn_op0_n100_nr_s0p1_r0_3 0 {C_SN}
XMN1_op0_n100_nr_s0p1_r0 rbl_op0_n100_nr_s0p1_r0 ref_op0_n100_nr_s0p1_r0 vn_op0_n100_nr_s0p1_r0 0 sky130_fd_pr__nfet_01v8 L=0.15 W=1 nf=1 ad=0.29 as=0.29 pd=2.58 ps=2.58 mult=1 m=1
XMN2_op0_n100_nr_s0p1_r0 ref_op0_n100_nr_s0p1_r0 rbl_op0_n100_nr_s0p1_r0 vn_op0_n100_nr_s0p1_r0 0 sky130_fd_pr__nfet_01v8 L=0.15 W=1 nf=1 ad=0.29 as=0.29 pd=2.58 ps=2.58 mult=1 m=1
XMP1_op0_n100_nr_s0p1_r0 rbl_op0_n100_nr_s0p1_r0 ref_op0_n100_nr_s0p1_r0 vp_op0_n100_nr_s0p1_r0 vdd sky130_fd_pr__pfet_01v8 L=0.15 W=2 nf=1 ad=0.58 as=0.58 pd=4.58 ps=4.58 mult=1 m=1
XMP2_op0_n100_nr_s0p1_r0 ref_op0_n100_nr_s0p1_r0 rbl_op0_n100_nr_s0p1_r0 vp_op0_n100_nr_s0p1_r0 vdd sky130_fd_pr__pfet_01v8 L=0.15 W=2 nf=1 ad=0.58 as=0.58 pd=4.58 ps=4.58 mult=1 m=1
XMNF_op0_n100_nr_s0p1_r0 vn_op0_n100_nr_s0p1_r0 en_op0_n100_nr_s0p1_r0 0 0 sky130_fd_pr__nfet_01v8 L=0.15 W=2 nf=1 ad=0.58 as=0.58 pd=4.58 ps=4.58 mult=1 m=1
XMPH_op0_n100_nr_s0p1_r0 vp_op0_n100_nr_s0p1_r0 enb_op0_n100_nr_s0p1_r0 vdd vdd sky130_fd_pr__pfet_01v8 L=0.15 W=4 nf=1 ad=1.16 as=1.16 pd=8.58 ps=8.58 mult=1 m=1
bd_op0_n100_nr_s0p1_r0 d_op0_n100_nr_s0p1_r0 0 v=v(rbl_op0_n100_nr_s0p1_r0)-v(ref_op0_n100_nr_s0p1_r0)

* ---- instance 340: op0_0000_nr_s0p1_r0 (variant nr_s0p1_r0; probe dec 11.9 ns, release 34 ns, meas 36 ns) ----
vctl_op0_0000_nr_s0p1_r0 ctl_op0_0000_nr_s0p1_r0 0 pwl(0.0000e+00 {VDD} 2.0000e-09 {VDD} 2.1000e-09 0)
* RWL driver model (EXPERIMENTAL): slew 0.1 ns, series R 0 ohm; cell pin = rwls_op0_0000_nr_s0p1_r0
vrs_op0_0000_nr_s0p1_r0 rwls_op0_0000_nr_s0p1_r0 0 pwl(0.0000e+00 {VDD} 2.0000e-09 {VDD} 2.1000e-09 0 1.2000e-08 0 1.2100e-08 {VDD})
ven_op0_0000_nr_s0p1_r0 en_op0_0000_nr_s0p1_r0 0 pwl(0.0000e+00 0 1.1000e-08 0 1.1100e-08 {VDD} 3.4000e-08 {VDD} 3.4100e-08 0)
venb_op0_0000_nr_s0p1_r0 enb_op0_0000_nr_s0p1_r0 0 pwl(0.0000e+00 {VDD} 1.1000e-08 {VDD} 1.1100e-08 0 3.4000e-08 0 3.4100e-08 {VDD})
vww_op0_0000_nr_s0p1_r0 wwl_op0_0000_nr_s0p1_r0 0 pwl(0.0000e+00 0)
vwc_op0_0000_nr_s0p1_r0 wbc_op0_0000_nr_s0p1_r0 0 pwl(0.0000e+00 0)
swb_op0_0000_nr_s0p1_r0 ref_op0_0000_nr_s0p1_r0 wbl_op0_0000_nr_s0p1_r0 wbc_op0_0000_nr_s0p1_r0 0 swwbl
cwbl_op0_0000_nr_s0p1_r0 wbl_op0_0000_nr_s0p1_r0 0 {C_WBL}
spa_op0_0000_nr_s0p1_r0 prea rbl_op0_0000_nr_s0p1_r0 ctl_op0_0000_nr_s0p1_r0 0 swpre
spr_op0_0000_nr_s0p1_r0 pref ref_op0_0000_nr_s0p1_r0 ctl_op0_0000_nr_s0p1_r0 0 swpre
crbl_op0_0000_nr_s0p1_r0 rbl_op0_0000_nr_s0p1_r0 0 {C_RBL}
cref_op0_0000_nr_s0p1_r0 ref_op0_0000_nr_s0p1_r0 0 {C_RBL}   $ ASSUMPTION: ideal matched dummy load
XMWR_op0_0000_nr_s0p1_r0_0 sn_op0_0000_nr_s0p1_r0_0 wwl_op0_0000_nr_s0p1_r0 wbl_op0_0000_nr_s0p1_r0 0 sky130_fd_pr__nfet_01v8 L=0.15 W=0.42 nf=1 ad=0.1218 as=0.1218 pd=1.42 ps=1.42 nrd=0.69047619047619  nrs=0.69047619047619 sa=0 sb=0 sd=0 mult=1 m=1
XMRD_op0_0000_nr_s0p1_r0_0 rbl_op0_0000_nr_s0p1_r0 sn_op0_0000_nr_s0p1_r0_0 rwls_op0_0000_nr_s0p1_r0 0 sky130_fd_pr__nfet_01v8 L=0.15 W=0.42 nf=1 ad=0.1218 as=0.1218 pd=1.42 ps=1.42 nrd=0.69047619047619  nrs=0.69047619047619 sa=0 sb=0 sd=0 mult=1 m=1
csn_op0_0000_nr_s0p1_r0_0 sn_op0_0000_nr_s0p1_r0_0 0 {C_SN}
XMWR_op0_0000_nr_s0p1_r0_1 sn_op0_0000_nr_s0p1_r0_1 wwl_des wbl_op0_0000_nr_s0p1_r0 0 sky130_fd_pr__nfet_01v8 L=0.15 W=0.42 nf=1 ad=0.1218 as=0.1218 pd=1.42 ps=1.42 nrd=0.69047619047619  nrs=0.69047619047619 sa=0 sb=0 sd=0 mult=1 m=1
XMRD_op0_0000_nr_s0p1_r0_1 rbl_op0_0000_nr_s0p1_r0 sn_op0_0000_nr_s0p1_r0_1 rwl_des 0 sky130_fd_pr__nfet_01v8 L=0.15 W=0.42 nf=1 ad=0.1218 as=0.1218 pd=1.42 ps=1.42 nrd=0.69047619047619  nrs=0.69047619047619 sa=0 sb=0 sd=0 mult=1 m=1
csn_op0_0000_nr_s0p1_r0_1 sn_op0_0000_nr_s0p1_r0_1 0 {C_SN}
XMWR_op0_0000_nr_s0p1_r0_2 sn_op0_0000_nr_s0p1_r0_2 wwl_des wbl_op0_0000_nr_s0p1_r0 0 sky130_fd_pr__nfet_01v8 L=0.15 W=0.42 nf=1 ad=0.1218 as=0.1218 pd=1.42 ps=1.42 nrd=0.69047619047619  nrs=0.69047619047619 sa=0 sb=0 sd=0 mult=1 m=1
XMRD_op0_0000_nr_s0p1_r0_2 rbl_op0_0000_nr_s0p1_r0 sn_op0_0000_nr_s0p1_r0_2 rwl_des 0 sky130_fd_pr__nfet_01v8 L=0.15 W=0.42 nf=1 ad=0.1218 as=0.1218 pd=1.42 ps=1.42 nrd=0.69047619047619  nrs=0.69047619047619 sa=0 sb=0 sd=0 mult=1 m=1
csn_op0_0000_nr_s0p1_r0_2 sn_op0_0000_nr_s0p1_r0_2 0 {C_SN}
XMWR_op0_0000_nr_s0p1_r0_3 sn_op0_0000_nr_s0p1_r0_3 wwl_des wbl_op0_0000_nr_s0p1_r0 0 sky130_fd_pr__nfet_01v8 L=0.15 W=0.42 nf=1 ad=0.1218 as=0.1218 pd=1.42 ps=1.42 nrd=0.69047619047619  nrs=0.69047619047619 sa=0 sb=0 sd=0 mult=1 m=1
XMRD_op0_0000_nr_s0p1_r0_3 rbl_op0_0000_nr_s0p1_r0 sn_op0_0000_nr_s0p1_r0_3 rwl_des 0 sky130_fd_pr__nfet_01v8 L=0.15 W=0.42 nf=1 ad=0.1218 as=0.1218 pd=1.42 ps=1.42 nrd=0.69047619047619  nrs=0.69047619047619 sa=0 sb=0 sd=0 mult=1 m=1
csn_op0_0000_nr_s0p1_r0_3 sn_op0_0000_nr_s0p1_r0_3 0 {C_SN}
XMN1_op0_0000_nr_s0p1_r0 rbl_op0_0000_nr_s0p1_r0 ref_op0_0000_nr_s0p1_r0 vn_op0_0000_nr_s0p1_r0 0 sky130_fd_pr__nfet_01v8 L=0.15 W=1 nf=1 ad=0.29 as=0.29 pd=2.58 ps=2.58 mult=1 m=1
XMN2_op0_0000_nr_s0p1_r0 ref_op0_0000_nr_s0p1_r0 rbl_op0_0000_nr_s0p1_r0 vn_op0_0000_nr_s0p1_r0 0 sky130_fd_pr__nfet_01v8 L=0.15 W=1 nf=1 ad=0.29 as=0.29 pd=2.58 ps=2.58 mult=1 m=1
XMP1_op0_0000_nr_s0p1_r0 rbl_op0_0000_nr_s0p1_r0 ref_op0_0000_nr_s0p1_r0 vp_op0_0000_nr_s0p1_r0 vdd sky130_fd_pr__pfet_01v8 L=0.15 W=2 nf=1 ad=0.58 as=0.58 pd=4.58 ps=4.58 mult=1 m=1
XMP2_op0_0000_nr_s0p1_r0 ref_op0_0000_nr_s0p1_r0 rbl_op0_0000_nr_s0p1_r0 vp_op0_0000_nr_s0p1_r0 vdd sky130_fd_pr__pfet_01v8 L=0.15 W=2 nf=1 ad=0.58 as=0.58 pd=4.58 ps=4.58 mult=1 m=1
XMNF_op0_0000_nr_s0p1_r0 vn_op0_0000_nr_s0p1_r0 en_op0_0000_nr_s0p1_r0 0 0 sky130_fd_pr__nfet_01v8 L=0.15 W=2 nf=1 ad=0.58 as=0.58 pd=4.58 ps=4.58 mult=1 m=1
XMPH_op0_0000_nr_s0p1_r0 vp_op0_0000_nr_s0p1_r0 enb_op0_0000_nr_s0p1_r0 vdd vdd sky130_fd_pr__pfet_01v8 L=0.15 W=4 nf=1 ad=1.16 as=1.16 pd=8.58 ps=8.58 mult=1 m=1
bd_op0_0000_nr_s0p1_r0 d_op0_0000_nr_s0p1_r0 0 v=v(rbl_op0_0000_nr_s0p1_r0)-v(ref_op0_0000_nr_s0p1_r0)

* ---- instance 341: op1_0900_nl_s0p1_r0 (variant nl_s0p1_r0; probe dec 11.9 ns, release 34 ns, meas 36 ns) ----
vctl_op1_0900_nl_s0p1_r0 ctl_op1_0900_nl_s0p1_r0 0 pwl(0.0000e+00 {VDD} 2.0000e-09 {VDD} 2.1000e-09 0)
* RWL driver model (EXPERIMENTAL): slew 0.1 ns, series R 0 ohm; cell pin = rwls_op1_0900_nl_s0p1_r0
vrs_op1_0900_nl_s0p1_r0 rwls_op1_0900_nl_s0p1_r0 0 pwl(0.0000e+00 {VDD} 2.0000e-09 {VDD} 2.1000e-09 0 3.4000e-08 0 3.4100e-08 {VDD})
ven_op1_0900_nl_s0p1_r0 en_op1_0900_nl_s0p1_r0 0 pwl(0.0000e+00 0 1.1000e-08 0 1.1100e-08 {VDD} 3.4000e-08 {VDD} 3.4100e-08 0)
venb_op1_0900_nl_s0p1_r0 enb_op1_0900_nl_s0p1_r0 0 pwl(0.0000e+00 {VDD} 1.1000e-08 {VDD} 1.1100e-08 0 3.4000e-08 0 3.4100e-08 {VDD})
vww_op1_0900_nl_s0p1_r0 wwl_op1_0900_nl_s0p1_r0 0 pwl(0.0000e+00 0)
vwc_op1_0900_nl_s0p1_r0 wbc_op1_0900_nl_s0p1_r0 0 pwl(0.0000e+00 0)
swb_op1_0900_nl_s0p1_r0 ref_op1_0900_nl_s0p1_r0 wbl_op1_0900_nl_s0p1_r0 wbc_op1_0900_nl_s0p1_r0 0 swwbl
cwbl_op1_0900_nl_s0p1_r0 wbl_op1_0900_nl_s0p1_r0 0 {C_WBL}
spa_op1_0900_nl_s0p1_r0 prea rbl_op1_0900_nl_s0p1_r0 ctl_op1_0900_nl_s0p1_r0 0 swpre
spr_op1_0900_nl_s0p1_r0 pref ref_op1_0900_nl_s0p1_r0 ctl_op1_0900_nl_s0p1_r0 0 swpre
crbl_op1_0900_nl_s0p1_r0 rbl_op1_0900_nl_s0p1_r0 0 {C_RBL}
cref_op1_0900_nl_s0p1_r0 ref_op1_0900_nl_s0p1_r0 0 {C_RBL}   $ ASSUMPTION: ideal matched dummy load
XMWR_op1_0900_nl_s0p1_r0_0 sn_op1_0900_nl_s0p1_r0_0 wwl_op1_0900_nl_s0p1_r0 wbl_op1_0900_nl_s0p1_r0 0 sky130_fd_pr__nfet_01v8 L=0.15 W=0.42 nf=1 ad=0.1218 as=0.1218 pd=1.42 ps=1.42 nrd=0.69047619047619  nrs=0.69047619047619 sa=0 sb=0 sd=0 mult=1 m=1
XMRD_op1_0900_nl_s0p1_r0_0 rbl_op1_0900_nl_s0p1_r0 sn_op1_0900_nl_s0p1_r0_0 rwls_op1_0900_nl_s0p1_r0 0 sky130_fd_pr__nfet_01v8 L=0.15 W=0.42 nf=1 ad=0.1218 as=0.1218 pd=1.42 ps=1.42 nrd=0.69047619047619  nrs=0.69047619047619 sa=0 sb=0 sd=0 mult=1 m=1
csn_op1_0900_nl_s0p1_r0_0 sn_op1_0900_nl_s0p1_r0_0 0 {C_SN}
XMWR_op1_0900_nl_s0p1_r0_1 sn_op1_0900_nl_s0p1_r0_1 wwl_des wbl_op1_0900_nl_s0p1_r0 0 sky130_fd_pr__nfet_01v8 L=0.15 W=0.42 nf=1 ad=0.1218 as=0.1218 pd=1.42 ps=1.42 nrd=0.69047619047619  nrs=0.69047619047619 sa=0 sb=0 sd=0 mult=1 m=1
XMRD_op1_0900_nl_s0p1_r0_1 rbl_op1_0900_nl_s0p1_r0 sn_op1_0900_nl_s0p1_r0_1 rwl_des 0 sky130_fd_pr__nfet_01v8 L=0.15 W=0.42 nf=1 ad=0.1218 as=0.1218 pd=1.42 ps=1.42 nrd=0.69047619047619  nrs=0.69047619047619 sa=0 sb=0 sd=0 mult=1 m=1
csn_op1_0900_nl_s0p1_r0_1 sn_op1_0900_nl_s0p1_r0_1 0 {C_SN}
XMWR_op1_0900_nl_s0p1_r0_2 sn_op1_0900_nl_s0p1_r0_2 wwl_des wbl_op1_0900_nl_s0p1_r0 0 sky130_fd_pr__nfet_01v8 L=0.15 W=0.42 nf=1 ad=0.1218 as=0.1218 pd=1.42 ps=1.42 nrd=0.69047619047619  nrs=0.69047619047619 sa=0 sb=0 sd=0 mult=1 m=1
XMRD_op1_0900_nl_s0p1_r0_2 rbl_op1_0900_nl_s0p1_r0 sn_op1_0900_nl_s0p1_r0_2 rwl_des 0 sky130_fd_pr__nfet_01v8 L=0.15 W=0.42 nf=1 ad=0.1218 as=0.1218 pd=1.42 ps=1.42 nrd=0.69047619047619  nrs=0.69047619047619 sa=0 sb=0 sd=0 mult=1 m=1
csn_op1_0900_nl_s0p1_r0_2 sn_op1_0900_nl_s0p1_r0_2 0 {C_SN}
XMWR_op1_0900_nl_s0p1_r0_3 sn_op1_0900_nl_s0p1_r0_3 wwl_des wbl_op1_0900_nl_s0p1_r0 0 sky130_fd_pr__nfet_01v8 L=0.15 W=0.42 nf=1 ad=0.1218 as=0.1218 pd=1.42 ps=1.42 nrd=0.69047619047619  nrs=0.69047619047619 sa=0 sb=0 sd=0 mult=1 m=1
XMRD_op1_0900_nl_s0p1_r0_3 rbl_op1_0900_nl_s0p1_r0 sn_op1_0900_nl_s0p1_r0_3 rwl_des 0 sky130_fd_pr__nfet_01v8 L=0.15 W=0.42 nf=1 ad=0.1218 as=0.1218 pd=1.42 ps=1.42 nrd=0.69047619047619  nrs=0.69047619047619 sa=0 sb=0 sd=0 mult=1 m=1
csn_op1_0900_nl_s0p1_r0_3 sn_op1_0900_nl_s0p1_r0_3 0 {C_SN}
XMN1_op1_0900_nl_s0p1_r0 rbl_op1_0900_nl_s0p1_r0 ref_op1_0900_nl_s0p1_r0 vn_op1_0900_nl_s0p1_r0 0 sky130_fd_pr__nfet_01v8 L=0.15 W=1 nf=1 ad=0.29 as=0.29 pd=2.58 ps=2.58 mult=1 m=1
XMN2_op1_0900_nl_s0p1_r0 ref_op1_0900_nl_s0p1_r0 rbl_op1_0900_nl_s0p1_r0 vn_op1_0900_nl_s0p1_r0 0 sky130_fd_pr__nfet_01v8 L=0.15 W=1 nf=1 ad=0.29 as=0.29 pd=2.58 ps=2.58 mult=1 m=1
XMP1_op1_0900_nl_s0p1_r0 rbl_op1_0900_nl_s0p1_r0 ref_op1_0900_nl_s0p1_r0 vp_op1_0900_nl_s0p1_r0 vdd sky130_fd_pr__pfet_01v8 L=0.15 W=2 nf=1 ad=0.58 as=0.58 pd=4.58 ps=4.58 mult=1 m=1
XMP2_op1_0900_nl_s0p1_r0 ref_op1_0900_nl_s0p1_r0 rbl_op1_0900_nl_s0p1_r0 vp_op1_0900_nl_s0p1_r0 vdd sky130_fd_pr__pfet_01v8 L=0.15 W=2 nf=1 ad=0.58 as=0.58 pd=4.58 ps=4.58 mult=1 m=1
XMNF_op1_0900_nl_s0p1_r0 vn_op1_0900_nl_s0p1_r0 en_op1_0900_nl_s0p1_r0 0 0 sky130_fd_pr__nfet_01v8 L=0.15 W=2 nf=1 ad=0.58 as=0.58 pd=4.58 ps=4.58 mult=1 m=1
XMPH_op1_0900_nl_s0p1_r0 vp_op1_0900_nl_s0p1_r0 enb_op1_0900_nl_s0p1_r0 vdd vdd sky130_fd_pr__pfet_01v8 L=0.15 W=4 nf=1 ad=1.16 as=1.16 pd=8.58 ps=8.58 mult=1 m=1
bd_op1_0900_nl_s0p1_r0 d_op1_0900_nl_s0p1_r0 0 v=v(rbl_op1_0900_nl_s0p1_r0)-v(ref_op1_0900_nl_s0p1_r0)

* ---- instance 342: op1_1000_nl_s0p1_r0 (variant nl_s0p1_r0; probe dec 11.9 ns, release 34 ns, meas 36 ns) ----
vctl_op1_1000_nl_s0p1_r0 ctl_op1_1000_nl_s0p1_r0 0 pwl(0.0000e+00 {VDD} 2.0000e-09 {VDD} 2.1000e-09 0)
* RWL driver model (EXPERIMENTAL): slew 0.1 ns, series R 0 ohm; cell pin = rwls_op1_1000_nl_s0p1_r0
vrs_op1_1000_nl_s0p1_r0 rwls_op1_1000_nl_s0p1_r0 0 pwl(0.0000e+00 {VDD} 2.0000e-09 {VDD} 2.1000e-09 0 3.4000e-08 0 3.4100e-08 {VDD})
ven_op1_1000_nl_s0p1_r0 en_op1_1000_nl_s0p1_r0 0 pwl(0.0000e+00 0 1.1000e-08 0 1.1100e-08 {VDD} 3.4000e-08 {VDD} 3.4100e-08 0)
venb_op1_1000_nl_s0p1_r0 enb_op1_1000_nl_s0p1_r0 0 pwl(0.0000e+00 {VDD} 1.1000e-08 {VDD} 1.1100e-08 0 3.4000e-08 0 3.4100e-08 {VDD})
vww_op1_1000_nl_s0p1_r0 wwl_op1_1000_nl_s0p1_r0 0 pwl(0.0000e+00 0)
vwc_op1_1000_nl_s0p1_r0 wbc_op1_1000_nl_s0p1_r0 0 pwl(0.0000e+00 0)
swb_op1_1000_nl_s0p1_r0 ref_op1_1000_nl_s0p1_r0 wbl_op1_1000_nl_s0p1_r0 wbc_op1_1000_nl_s0p1_r0 0 swwbl
cwbl_op1_1000_nl_s0p1_r0 wbl_op1_1000_nl_s0p1_r0 0 {C_WBL}
spa_op1_1000_nl_s0p1_r0 prea rbl_op1_1000_nl_s0p1_r0 ctl_op1_1000_nl_s0p1_r0 0 swpre
spr_op1_1000_nl_s0p1_r0 pref ref_op1_1000_nl_s0p1_r0 ctl_op1_1000_nl_s0p1_r0 0 swpre
crbl_op1_1000_nl_s0p1_r0 rbl_op1_1000_nl_s0p1_r0 0 {C_RBL}
cref_op1_1000_nl_s0p1_r0 ref_op1_1000_nl_s0p1_r0 0 {C_RBL}   $ ASSUMPTION: ideal matched dummy load
XMWR_op1_1000_nl_s0p1_r0_0 sn_op1_1000_nl_s0p1_r0_0 wwl_op1_1000_nl_s0p1_r0 wbl_op1_1000_nl_s0p1_r0 0 sky130_fd_pr__nfet_01v8 L=0.15 W=0.42 nf=1 ad=0.1218 as=0.1218 pd=1.42 ps=1.42 nrd=0.69047619047619  nrs=0.69047619047619 sa=0 sb=0 sd=0 mult=1 m=1
XMRD_op1_1000_nl_s0p1_r0_0 rbl_op1_1000_nl_s0p1_r0 sn_op1_1000_nl_s0p1_r0_0 rwls_op1_1000_nl_s0p1_r0 0 sky130_fd_pr__nfet_01v8 L=0.15 W=0.42 nf=1 ad=0.1218 as=0.1218 pd=1.42 ps=1.42 nrd=0.69047619047619  nrs=0.69047619047619 sa=0 sb=0 sd=0 mult=1 m=1
csn_op1_1000_nl_s0p1_r0_0 sn_op1_1000_nl_s0p1_r0_0 0 {C_SN}
XMWR_op1_1000_nl_s0p1_r0_1 sn_op1_1000_nl_s0p1_r0_1 wwl_des wbl_op1_1000_nl_s0p1_r0 0 sky130_fd_pr__nfet_01v8 L=0.15 W=0.42 nf=1 ad=0.1218 as=0.1218 pd=1.42 ps=1.42 nrd=0.69047619047619  nrs=0.69047619047619 sa=0 sb=0 sd=0 mult=1 m=1
XMRD_op1_1000_nl_s0p1_r0_1 rbl_op1_1000_nl_s0p1_r0 sn_op1_1000_nl_s0p1_r0_1 rwl_des 0 sky130_fd_pr__nfet_01v8 L=0.15 W=0.42 nf=1 ad=0.1218 as=0.1218 pd=1.42 ps=1.42 nrd=0.69047619047619  nrs=0.69047619047619 sa=0 sb=0 sd=0 mult=1 m=1
csn_op1_1000_nl_s0p1_r0_1 sn_op1_1000_nl_s0p1_r0_1 0 {C_SN}
XMWR_op1_1000_nl_s0p1_r0_2 sn_op1_1000_nl_s0p1_r0_2 wwl_des wbl_op1_1000_nl_s0p1_r0 0 sky130_fd_pr__nfet_01v8 L=0.15 W=0.42 nf=1 ad=0.1218 as=0.1218 pd=1.42 ps=1.42 nrd=0.69047619047619  nrs=0.69047619047619 sa=0 sb=0 sd=0 mult=1 m=1
XMRD_op1_1000_nl_s0p1_r0_2 rbl_op1_1000_nl_s0p1_r0 sn_op1_1000_nl_s0p1_r0_2 rwl_des 0 sky130_fd_pr__nfet_01v8 L=0.15 W=0.42 nf=1 ad=0.1218 as=0.1218 pd=1.42 ps=1.42 nrd=0.69047619047619  nrs=0.69047619047619 sa=0 sb=0 sd=0 mult=1 m=1
csn_op1_1000_nl_s0p1_r0_2 sn_op1_1000_nl_s0p1_r0_2 0 {C_SN}
XMWR_op1_1000_nl_s0p1_r0_3 sn_op1_1000_nl_s0p1_r0_3 wwl_des wbl_op1_1000_nl_s0p1_r0 0 sky130_fd_pr__nfet_01v8 L=0.15 W=0.42 nf=1 ad=0.1218 as=0.1218 pd=1.42 ps=1.42 nrd=0.69047619047619  nrs=0.69047619047619 sa=0 sb=0 sd=0 mult=1 m=1
XMRD_op1_1000_nl_s0p1_r0_3 rbl_op1_1000_nl_s0p1_r0 sn_op1_1000_nl_s0p1_r0_3 rwl_des 0 sky130_fd_pr__nfet_01v8 L=0.15 W=0.42 nf=1 ad=0.1218 as=0.1218 pd=1.42 ps=1.42 nrd=0.69047619047619  nrs=0.69047619047619 sa=0 sb=0 sd=0 mult=1 m=1
csn_op1_1000_nl_s0p1_r0_3 sn_op1_1000_nl_s0p1_r0_3 0 {C_SN}
XMN1_op1_1000_nl_s0p1_r0 rbl_op1_1000_nl_s0p1_r0 ref_op1_1000_nl_s0p1_r0 vn_op1_1000_nl_s0p1_r0 0 sky130_fd_pr__nfet_01v8 L=0.15 W=1 nf=1 ad=0.29 as=0.29 pd=2.58 ps=2.58 mult=1 m=1
XMN2_op1_1000_nl_s0p1_r0 ref_op1_1000_nl_s0p1_r0 rbl_op1_1000_nl_s0p1_r0 vn_op1_1000_nl_s0p1_r0 0 sky130_fd_pr__nfet_01v8 L=0.15 W=1 nf=1 ad=0.29 as=0.29 pd=2.58 ps=2.58 mult=1 m=1
XMP1_op1_1000_nl_s0p1_r0 rbl_op1_1000_nl_s0p1_r0 ref_op1_1000_nl_s0p1_r0 vp_op1_1000_nl_s0p1_r0 vdd sky130_fd_pr__pfet_01v8 L=0.15 W=2 nf=1 ad=0.58 as=0.58 pd=4.58 ps=4.58 mult=1 m=1
XMP2_op1_1000_nl_s0p1_r0 ref_op1_1000_nl_s0p1_r0 rbl_op1_1000_nl_s0p1_r0 vp_op1_1000_nl_s0p1_r0 vdd sky130_fd_pr__pfet_01v8 L=0.15 W=2 nf=1 ad=0.58 as=0.58 pd=4.58 ps=4.58 mult=1 m=1
XMNF_op1_1000_nl_s0p1_r0 vn_op1_1000_nl_s0p1_r0 en_op1_1000_nl_s0p1_r0 0 0 sky130_fd_pr__nfet_01v8 L=0.15 W=2 nf=1 ad=0.58 as=0.58 pd=4.58 ps=4.58 mult=1 m=1
XMPH_op1_1000_nl_s0p1_r0 vp_op1_1000_nl_s0p1_r0 enb_op1_1000_nl_s0p1_r0 vdd vdd sky130_fd_pr__pfet_01v8 L=0.15 W=4 nf=1 ad=1.16 as=1.16 pd=8.58 ps=8.58 mult=1 m=1
bd_op1_1000_nl_s0p1_r0 d_op1_1000_nl_s0p1_r0 0 v=v(rbl_op1_1000_nl_s0p1_r0)-v(ref_op1_1000_nl_s0p1_r0)

* ---- instance 343: op0_n100_nl_s0p1_r0 (variant nl_s0p1_r0; probe dec 11.9 ns, release 34 ns, meas 36 ns) ----
vctl_op0_n100_nl_s0p1_r0 ctl_op0_n100_nl_s0p1_r0 0 pwl(0.0000e+00 {VDD} 2.0000e-09 {VDD} 2.1000e-09 0)
* RWL driver model (EXPERIMENTAL): slew 0.1 ns, series R 0 ohm; cell pin = rwls_op0_n100_nl_s0p1_r0
vrs_op0_n100_nl_s0p1_r0 rwls_op0_n100_nl_s0p1_r0 0 pwl(0.0000e+00 {VDD} 2.0000e-09 {VDD} 2.1000e-09 0 3.4000e-08 0 3.4100e-08 {VDD})
ven_op0_n100_nl_s0p1_r0 en_op0_n100_nl_s0p1_r0 0 pwl(0.0000e+00 0 1.1000e-08 0 1.1100e-08 {VDD} 3.4000e-08 {VDD} 3.4100e-08 0)
venb_op0_n100_nl_s0p1_r0 enb_op0_n100_nl_s0p1_r0 0 pwl(0.0000e+00 {VDD} 1.1000e-08 {VDD} 1.1100e-08 0 3.4000e-08 0 3.4100e-08 {VDD})
vww_op0_n100_nl_s0p1_r0 wwl_op0_n100_nl_s0p1_r0 0 pwl(0.0000e+00 0)
vwc_op0_n100_nl_s0p1_r0 wbc_op0_n100_nl_s0p1_r0 0 pwl(0.0000e+00 0)
swb_op0_n100_nl_s0p1_r0 ref_op0_n100_nl_s0p1_r0 wbl_op0_n100_nl_s0p1_r0 wbc_op0_n100_nl_s0p1_r0 0 swwbl
cwbl_op0_n100_nl_s0p1_r0 wbl_op0_n100_nl_s0p1_r0 0 {C_WBL}
spa_op0_n100_nl_s0p1_r0 prea rbl_op0_n100_nl_s0p1_r0 ctl_op0_n100_nl_s0p1_r0 0 swpre
spr_op0_n100_nl_s0p1_r0 pref ref_op0_n100_nl_s0p1_r0 ctl_op0_n100_nl_s0p1_r0 0 swpre
crbl_op0_n100_nl_s0p1_r0 rbl_op0_n100_nl_s0p1_r0 0 {C_RBL}
cref_op0_n100_nl_s0p1_r0 ref_op0_n100_nl_s0p1_r0 0 {C_RBL}   $ ASSUMPTION: ideal matched dummy load
XMWR_op0_n100_nl_s0p1_r0_0 sn_op0_n100_nl_s0p1_r0_0 wwl_op0_n100_nl_s0p1_r0 wbl_op0_n100_nl_s0p1_r0 0 sky130_fd_pr__nfet_01v8 L=0.15 W=0.42 nf=1 ad=0.1218 as=0.1218 pd=1.42 ps=1.42 nrd=0.69047619047619  nrs=0.69047619047619 sa=0 sb=0 sd=0 mult=1 m=1
XMRD_op0_n100_nl_s0p1_r0_0 rbl_op0_n100_nl_s0p1_r0 sn_op0_n100_nl_s0p1_r0_0 rwls_op0_n100_nl_s0p1_r0 0 sky130_fd_pr__nfet_01v8 L=0.15 W=0.42 nf=1 ad=0.1218 as=0.1218 pd=1.42 ps=1.42 nrd=0.69047619047619  nrs=0.69047619047619 sa=0 sb=0 sd=0 mult=1 m=1
csn_op0_n100_nl_s0p1_r0_0 sn_op0_n100_nl_s0p1_r0_0 0 {C_SN}
XMWR_op0_n100_nl_s0p1_r0_1 sn_op0_n100_nl_s0p1_r0_1 wwl_des wbl_op0_n100_nl_s0p1_r0 0 sky130_fd_pr__nfet_01v8 L=0.15 W=0.42 nf=1 ad=0.1218 as=0.1218 pd=1.42 ps=1.42 nrd=0.69047619047619  nrs=0.69047619047619 sa=0 sb=0 sd=0 mult=1 m=1
XMRD_op0_n100_nl_s0p1_r0_1 rbl_op0_n100_nl_s0p1_r0 sn_op0_n100_nl_s0p1_r0_1 rwl_des 0 sky130_fd_pr__nfet_01v8 L=0.15 W=0.42 nf=1 ad=0.1218 as=0.1218 pd=1.42 ps=1.42 nrd=0.69047619047619  nrs=0.69047619047619 sa=0 sb=0 sd=0 mult=1 m=1
csn_op0_n100_nl_s0p1_r0_1 sn_op0_n100_nl_s0p1_r0_1 0 {C_SN}
XMWR_op0_n100_nl_s0p1_r0_2 sn_op0_n100_nl_s0p1_r0_2 wwl_des wbl_op0_n100_nl_s0p1_r0 0 sky130_fd_pr__nfet_01v8 L=0.15 W=0.42 nf=1 ad=0.1218 as=0.1218 pd=1.42 ps=1.42 nrd=0.69047619047619  nrs=0.69047619047619 sa=0 sb=0 sd=0 mult=1 m=1
XMRD_op0_n100_nl_s0p1_r0_2 rbl_op0_n100_nl_s0p1_r0 sn_op0_n100_nl_s0p1_r0_2 rwl_des 0 sky130_fd_pr__nfet_01v8 L=0.15 W=0.42 nf=1 ad=0.1218 as=0.1218 pd=1.42 ps=1.42 nrd=0.69047619047619  nrs=0.69047619047619 sa=0 sb=0 sd=0 mult=1 m=1
csn_op0_n100_nl_s0p1_r0_2 sn_op0_n100_nl_s0p1_r0_2 0 {C_SN}
XMWR_op0_n100_nl_s0p1_r0_3 sn_op0_n100_nl_s0p1_r0_3 wwl_des wbl_op0_n100_nl_s0p1_r0 0 sky130_fd_pr__nfet_01v8 L=0.15 W=0.42 nf=1 ad=0.1218 as=0.1218 pd=1.42 ps=1.42 nrd=0.69047619047619  nrs=0.69047619047619 sa=0 sb=0 sd=0 mult=1 m=1
XMRD_op0_n100_nl_s0p1_r0_3 rbl_op0_n100_nl_s0p1_r0 sn_op0_n100_nl_s0p1_r0_3 rwl_des 0 sky130_fd_pr__nfet_01v8 L=0.15 W=0.42 nf=1 ad=0.1218 as=0.1218 pd=1.42 ps=1.42 nrd=0.69047619047619  nrs=0.69047619047619 sa=0 sb=0 sd=0 mult=1 m=1
csn_op0_n100_nl_s0p1_r0_3 sn_op0_n100_nl_s0p1_r0_3 0 {C_SN}
XMN1_op0_n100_nl_s0p1_r0 rbl_op0_n100_nl_s0p1_r0 ref_op0_n100_nl_s0p1_r0 vn_op0_n100_nl_s0p1_r0 0 sky130_fd_pr__nfet_01v8 L=0.15 W=1 nf=1 ad=0.29 as=0.29 pd=2.58 ps=2.58 mult=1 m=1
XMN2_op0_n100_nl_s0p1_r0 ref_op0_n100_nl_s0p1_r0 rbl_op0_n100_nl_s0p1_r0 vn_op0_n100_nl_s0p1_r0 0 sky130_fd_pr__nfet_01v8 L=0.15 W=1 nf=1 ad=0.29 as=0.29 pd=2.58 ps=2.58 mult=1 m=1
XMP1_op0_n100_nl_s0p1_r0 rbl_op0_n100_nl_s0p1_r0 ref_op0_n100_nl_s0p1_r0 vp_op0_n100_nl_s0p1_r0 vdd sky130_fd_pr__pfet_01v8 L=0.15 W=2 nf=1 ad=0.58 as=0.58 pd=4.58 ps=4.58 mult=1 m=1
XMP2_op0_n100_nl_s0p1_r0 ref_op0_n100_nl_s0p1_r0 rbl_op0_n100_nl_s0p1_r0 vp_op0_n100_nl_s0p1_r0 vdd sky130_fd_pr__pfet_01v8 L=0.15 W=2 nf=1 ad=0.58 as=0.58 pd=4.58 ps=4.58 mult=1 m=1
XMNF_op0_n100_nl_s0p1_r0 vn_op0_n100_nl_s0p1_r0 en_op0_n100_nl_s0p1_r0 0 0 sky130_fd_pr__nfet_01v8 L=0.15 W=2 nf=1 ad=0.58 as=0.58 pd=4.58 ps=4.58 mult=1 m=1
XMPH_op0_n100_nl_s0p1_r0 vp_op0_n100_nl_s0p1_r0 enb_op0_n100_nl_s0p1_r0 vdd vdd sky130_fd_pr__pfet_01v8 L=0.15 W=4 nf=1 ad=1.16 as=1.16 pd=8.58 ps=8.58 mult=1 m=1
bd_op0_n100_nl_s0p1_r0 d_op0_n100_nl_s0p1_r0 0 v=v(rbl_op0_n100_nl_s0p1_r0)-v(ref_op0_n100_nl_s0p1_r0)

* ---- instance 344: op0_0000_nl_s0p1_r0 (variant nl_s0p1_r0; probe dec 11.9 ns, release 34 ns, meas 36 ns) ----
vctl_op0_0000_nl_s0p1_r0 ctl_op0_0000_nl_s0p1_r0 0 pwl(0.0000e+00 {VDD} 2.0000e-09 {VDD} 2.1000e-09 0)
* RWL driver model (EXPERIMENTAL): slew 0.1 ns, series R 0 ohm; cell pin = rwls_op0_0000_nl_s0p1_r0
vrs_op0_0000_nl_s0p1_r0 rwls_op0_0000_nl_s0p1_r0 0 pwl(0.0000e+00 {VDD} 2.0000e-09 {VDD} 2.1000e-09 0 3.4000e-08 0 3.4100e-08 {VDD})
ven_op0_0000_nl_s0p1_r0 en_op0_0000_nl_s0p1_r0 0 pwl(0.0000e+00 0 1.1000e-08 0 1.1100e-08 {VDD} 3.4000e-08 {VDD} 3.4100e-08 0)
venb_op0_0000_nl_s0p1_r0 enb_op0_0000_nl_s0p1_r0 0 pwl(0.0000e+00 {VDD} 1.1000e-08 {VDD} 1.1100e-08 0 3.4000e-08 0 3.4100e-08 {VDD})
vww_op0_0000_nl_s0p1_r0 wwl_op0_0000_nl_s0p1_r0 0 pwl(0.0000e+00 0)
vwc_op0_0000_nl_s0p1_r0 wbc_op0_0000_nl_s0p1_r0 0 pwl(0.0000e+00 0)
swb_op0_0000_nl_s0p1_r0 ref_op0_0000_nl_s0p1_r0 wbl_op0_0000_nl_s0p1_r0 wbc_op0_0000_nl_s0p1_r0 0 swwbl
cwbl_op0_0000_nl_s0p1_r0 wbl_op0_0000_nl_s0p1_r0 0 {C_WBL}
spa_op0_0000_nl_s0p1_r0 prea rbl_op0_0000_nl_s0p1_r0 ctl_op0_0000_nl_s0p1_r0 0 swpre
spr_op0_0000_nl_s0p1_r0 pref ref_op0_0000_nl_s0p1_r0 ctl_op0_0000_nl_s0p1_r0 0 swpre
crbl_op0_0000_nl_s0p1_r0 rbl_op0_0000_nl_s0p1_r0 0 {C_RBL}
cref_op0_0000_nl_s0p1_r0 ref_op0_0000_nl_s0p1_r0 0 {C_RBL}   $ ASSUMPTION: ideal matched dummy load
XMWR_op0_0000_nl_s0p1_r0_0 sn_op0_0000_nl_s0p1_r0_0 wwl_op0_0000_nl_s0p1_r0 wbl_op0_0000_nl_s0p1_r0 0 sky130_fd_pr__nfet_01v8 L=0.15 W=0.42 nf=1 ad=0.1218 as=0.1218 pd=1.42 ps=1.42 nrd=0.69047619047619  nrs=0.69047619047619 sa=0 sb=0 sd=0 mult=1 m=1
XMRD_op0_0000_nl_s0p1_r0_0 rbl_op0_0000_nl_s0p1_r0 sn_op0_0000_nl_s0p1_r0_0 rwls_op0_0000_nl_s0p1_r0 0 sky130_fd_pr__nfet_01v8 L=0.15 W=0.42 nf=1 ad=0.1218 as=0.1218 pd=1.42 ps=1.42 nrd=0.69047619047619  nrs=0.69047619047619 sa=0 sb=0 sd=0 mult=1 m=1
csn_op0_0000_nl_s0p1_r0_0 sn_op0_0000_nl_s0p1_r0_0 0 {C_SN}
XMWR_op0_0000_nl_s0p1_r0_1 sn_op0_0000_nl_s0p1_r0_1 wwl_des wbl_op0_0000_nl_s0p1_r0 0 sky130_fd_pr__nfet_01v8 L=0.15 W=0.42 nf=1 ad=0.1218 as=0.1218 pd=1.42 ps=1.42 nrd=0.69047619047619  nrs=0.69047619047619 sa=0 sb=0 sd=0 mult=1 m=1
XMRD_op0_0000_nl_s0p1_r0_1 rbl_op0_0000_nl_s0p1_r0 sn_op0_0000_nl_s0p1_r0_1 rwl_des 0 sky130_fd_pr__nfet_01v8 L=0.15 W=0.42 nf=1 ad=0.1218 as=0.1218 pd=1.42 ps=1.42 nrd=0.69047619047619  nrs=0.69047619047619 sa=0 sb=0 sd=0 mult=1 m=1
csn_op0_0000_nl_s0p1_r0_1 sn_op0_0000_nl_s0p1_r0_1 0 {C_SN}
XMWR_op0_0000_nl_s0p1_r0_2 sn_op0_0000_nl_s0p1_r0_2 wwl_des wbl_op0_0000_nl_s0p1_r0 0 sky130_fd_pr__nfet_01v8 L=0.15 W=0.42 nf=1 ad=0.1218 as=0.1218 pd=1.42 ps=1.42 nrd=0.69047619047619  nrs=0.69047619047619 sa=0 sb=0 sd=0 mult=1 m=1
XMRD_op0_0000_nl_s0p1_r0_2 rbl_op0_0000_nl_s0p1_r0 sn_op0_0000_nl_s0p1_r0_2 rwl_des 0 sky130_fd_pr__nfet_01v8 L=0.15 W=0.42 nf=1 ad=0.1218 as=0.1218 pd=1.42 ps=1.42 nrd=0.69047619047619  nrs=0.69047619047619 sa=0 sb=0 sd=0 mult=1 m=1
csn_op0_0000_nl_s0p1_r0_2 sn_op0_0000_nl_s0p1_r0_2 0 {C_SN}
XMWR_op0_0000_nl_s0p1_r0_3 sn_op0_0000_nl_s0p1_r0_3 wwl_des wbl_op0_0000_nl_s0p1_r0 0 sky130_fd_pr__nfet_01v8 L=0.15 W=0.42 nf=1 ad=0.1218 as=0.1218 pd=1.42 ps=1.42 nrd=0.69047619047619  nrs=0.69047619047619 sa=0 sb=0 sd=0 mult=1 m=1
XMRD_op0_0000_nl_s0p1_r0_3 rbl_op0_0000_nl_s0p1_r0 sn_op0_0000_nl_s0p1_r0_3 rwl_des 0 sky130_fd_pr__nfet_01v8 L=0.15 W=0.42 nf=1 ad=0.1218 as=0.1218 pd=1.42 ps=1.42 nrd=0.69047619047619  nrs=0.69047619047619 sa=0 sb=0 sd=0 mult=1 m=1
csn_op0_0000_nl_s0p1_r0_3 sn_op0_0000_nl_s0p1_r0_3 0 {C_SN}
XMN1_op0_0000_nl_s0p1_r0 rbl_op0_0000_nl_s0p1_r0 ref_op0_0000_nl_s0p1_r0 vn_op0_0000_nl_s0p1_r0 0 sky130_fd_pr__nfet_01v8 L=0.15 W=1 nf=1 ad=0.29 as=0.29 pd=2.58 ps=2.58 mult=1 m=1
XMN2_op0_0000_nl_s0p1_r0 ref_op0_0000_nl_s0p1_r0 rbl_op0_0000_nl_s0p1_r0 vn_op0_0000_nl_s0p1_r0 0 sky130_fd_pr__nfet_01v8 L=0.15 W=1 nf=1 ad=0.29 as=0.29 pd=2.58 ps=2.58 mult=1 m=1
XMP1_op0_0000_nl_s0p1_r0 rbl_op0_0000_nl_s0p1_r0 ref_op0_0000_nl_s0p1_r0 vp_op0_0000_nl_s0p1_r0 vdd sky130_fd_pr__pfet_01v8 L=0.15 W=2 nf=1 ad=0.58 as=0.58 pd=4.58 ps=4.58 mult=1 m=1
XMP2_op0_0000_nl_s0p1_r0 ref_op0_0000_nl_s0p1_r0 rbl_op0_0000_nl_s0p1_r0 vp_op0_0000_nl_s0p1_r0 vdd sky130_fd_pr__pfet_01v8 L=0.15 W=2 nf=1 ad=0.58 as=0.58 pd=4.58 ps=4.58 mult=1 m=1
XMNF_op0_0000_nl_s0p1_r0 vn_op0_0000_nl_s0p1_r0 en_op0_0000_nl_s0p1_r0 0 0 sky130_fd_pr__nfet_01v8 L=0.15 W=2 nf=1 ad=0.58 as=0.58 pd=4.58 ps=4.58 mult=1 m=1
XMPH_op0_0000_nl_s0p1_r0 vp_op0_0000_nl_s0p1_r0 enb_op0_0000_nl_s0p1_r0 vdd vdd sky130_fd_pr__pfet_01v8 L=0.15 W=4 nf=1 ad=1.16 as=1.16 pd=8.58 ps=8.58 mult=1 m=1
bd_op0_0000_nl_s0p1_r0 d_op0_0000_nl_s0p1_r0 0 v=v(rbl_op0_0000_nl_s0p1_r0)-v(ref_op0_0000_nl_s0p1_r0)

* ---- instance 345: op1_0900_nr_s1_r10k (variant nr_s1_r10k; probe dec 11.9 ns, release 34 ns, meas 36 ns) ----
vctl_op1_0900_nr_s1_r10k ctl_op1_0900_nr_s1_r10k 0 pwl(0.0000e+00 {VDD} 2.0000e-09 {VDD} 2.1000e-09 0)
* RWL driver model (EXPERIMENTAL): slew 1 ns, series R 10000 ohm; cell pin = rwls_op1_0900_nr_s1_r10k
vrs_op1_0900_nr_s1_r10k rwlsrc_op1_0900_nr_s1_r10k 0 pwl(0.0000e+00 {VDD} 2.0000e-09 {VDD} 3.0000e-09 0 1.2000e-08 0 1.3000e-08 {VDD})
rdrv_op1_0900_nr_s1_r10k rwlsrc_op1_0900_nr_s1_r10k rwls_op1_0900_nr_s1_r10k 10000
ven_op1_0900_nr_s1_r10k en_op1_0900_nr_s1_r10k 0 pwl(0.0000e+00 0 1.1000e-08 0 1.1100e-08 {VDD} 3.4000e-08 {VDD} 3.4100e-08 0)
venb_op1_0900_nr_s1_r10k enb_op1_0900_nr_s1_r10k 0 pwl(0.0000e+00 {VDD} 1.1000e-08 {VDD} 1.1100e-08 0 3.4000e-08 0 3.4100e-08 {VDD})
vww_op1_0900_nr_s1_r10k wwl_op1_0900_nr_s1_r10k 0 pwl(0.0000e+00 0)
vwc_op1_0900_nr_s1_r10k wbc_op1_0900_nr_s1_r10k 0 pwl(0.0000e+00 0)
swb_op1_0900_nr_s1_r10k ref_op1_0900_nr_s1_r10k wbl_op1_0900_nr_s1_r10k wbc_op1_0900_nr_s1_r10k 0 swwbl
cwbl_op1_0900_nr_s1_r10k wbl_op1_0900_nr_s1_r10k 0 {C_WBL}
spa_op1_0900_nr_s1_r10k prea rbl_op1_0900_nr_s1_r10k ctl_op1_0900_nr_s1_r10k 0 swpre
spr_op1_0900_nr_s1_r10k pref ref_op1_0900_nr_s1_r10k ctl_op1_0900_nr_s1_r10k 0 swpre
crbl_op1_0900_nr_s1_r10k rbl_op1_0900_nr_s1_r10k 0 {C_RBL}
cref_op1_0900_nr_s1_r10k ref_op1_0900_nr_s1_r10k 0 {C_RBL}   $ ASSUMPTION: ideal matched dummy load
XMWR_op1_0900_nr_s1_r10k_0 sn_op1_0900_nr_s1_r10k_0 wwl_op1_0900_nr_s1_r10k wbl_op1_0900_nr_s1_r10k 0 sky130_fd_pr__nfet_01v8 L=0.15 W=0.42 nf=1 ad=0.1218 as=0.1218 pd=1.42 ps=1.42 nrd=0.69047619047619  nrs=0.69047619047619 sa=0 sb=0 sd=0 mult=1 m=1
XMRD_op1_0900_nr_s1_r10k_0 rbl_op1_0900_nr_s1_r10k sn_op1_0900_nr_s1_r10k_0 rwls_op1_0900_nr_s1_r10k 0 sky130_fd_pr__nfet_01v8 L=0.15 W=0.42 nf=1 ad=0.1218 as=0.1218 pd=1.42 ps=1.42 nrd=0.69047619047619  nrs=0.69047619047619 sa=0 sb=0 sd=0 mult=1 m=1
csn_op1_0900_nr_s1_r10k_0 sn_op1_0900_nr_s1_r10k_0 0 {C_SN}
XMWR_op1_0900_nr_s1_r10k_1 sn_op1_0900_nr_s1_r10k_1 wwl_des wbl_op1_0900_nr_s1_r10k 0 sky130_fd_pr__nfet_01v8 L=0.15 W=0.42 nf=1 ad=0.1218 as=0.1218 pd=1.42 ps=1.42 nrd=0.69047619047619  nrs=0.69047619047619 sa=0 sb=0 sd=0 mult=1 m=1
XMRD_op1_0900_nr_s1_r10k_1 rbl_op1_0900_nr_s1_r10k sn_op1_0900_nr_s1_r10k_1 rwl_des 0 sky130_fd_pr__nfet_01v8 L=0.15 W=0.42 nf=1 ad=0.1218 as=0.1218 pd=1.42 ps=1.42 nrd=0.69047619047619  nrs=0.69047619047619 sa=0 sb=0 sd=0 mult=1 m=1
csn_op1_0900_nr_s1_r10k_1 sn_op1_0900_nr_s1_r10k_1 0 {C_SN}
XMWR_op1_0900_nr_s1_r10k_2 sn_op1_0900_nr_s1_r10k_2 wwl_des wbl_op1_0900_nr_s1_r10k 0 sky130_fd_pr__nfet_01v8 L=0.15 W=0.42 nf=1 ad=0.1218 as=0.1218 pd=1.42 ps=1.42 nrd=0.69047619047619  nrs=0.69047619047619 sa=0 sb=0 sd=0 mult=1 m=1
XMRD_op1_0900_nr_s1_r10k_2 rbl_op1_0900_nr_s1_r10k sn_op1_0900_nr_s1_r10k_2 rwl_des 0 sky130_fd_pr__nfet_01v8 L=0.15 W=0.42 nf=1 ad=0.1218 as=0.1218 pd=1.42 ps=1.42 nrd=0.69047619047619  nrs=0.69047619047619 sa=0 sb=0 sd=0 mult=1 m=1
csn_op1_0900_nr_s1_r10k_2 sn_op1_0900_nr_s1_r10k_2 0 {C_SN}
XMWR_op1_0900_nr_s1_r10k_3 sn_op1_0900_nr_s1_r10k_3 wwl_des wbl_op1_0900_nr_s1_r10k 0 sky130_fd_pr__nfet_01v8 L=0.15 W=0.42 nf=1 ad=0.1218 as=0.1218 pd=1.42 ps=1.42 nrd=0.69047619047619  nrs=0.69047619047619 sa=0 sb=0 sd=0 mult=1 m=1
XMRD_op1_0900_nr_s1_r10k_3 rbl_op1_0900_nr_s1_r10k sn_op1_0900_nr_s1_r10k_3 rwl_des 0 sky130_fd_pr__nfet_01v8 L=0.15 W=0.42 nf=1 ad=0.1218 as=0.1218 pd=1.42 ps=1.42 nrd=0.69047619047619  nrs=0.69047619047619 sa=0 sb=0 sd=0 mult=1 m=1
csn_op1_0900_nr_s1_r10k_3 sn_op1_0900_nr_s1_r10k_3 0 {C_SN}
XMN1_op1_0900_nr_s1_r10k rbl_op1_0900_nr_s1_r10k ref_op1_0900_nr_s1_r10k vn_op1_0900_nr_s1_r10k 0 sky130_fd_pr__nfet_01v8 L=0.15 W=1 nf=1 ad=0.29 as=0.29 pd=2.58 ps=2.58 mult=1 m=1
XMN2_op1_0900_nr_s1_r10k ref_op1_0900_nr_s1_r10k rbl_op1_0900_nr_s1_r10k vn_op1_0900_nr_s1_r10k 0 sky130_fd_pr__nfet_01v8 L=0.15 W=1 nf=1 ad=0.29 as=0.29 pd=2.58 ps=2.58 mult=1 m=1
XMP1_op1_0900_nr_s1_r10k rbl_op1_0900_nr_s1_r10k ref_op1_0900_nr_s1_r10k vp_op1_0900_nr_s1_r10k vdd sky130_fd_pr__pfet_01v8 L=0.15 W=2 nf=1 ad=0.58 as=0.58 pd=4.58 ps=4.58 mult=1 m=1
XMP2_op1_0900_nr_s1_r10k ref_op1_0900_nr_s1_r10k rbl_op1_0900_nr_s1_r10k vp_op1_0900_nr_s1_r10k vdd sky130_fd_pr__pfet_01v8 L=0.15 W=2 nf=1 ad=0.58 as=0.58 pd=4.58 ps=4.58 mult=1 m=1
XMNF_op1_0900_nr_s1_r10k vn_op1_0900_nr_s1_r10k en_op1_0900_nr_s1_r10k 0 0 sky130_fd_pr__nfet_01v8 L=0.15 W=2 nf=1 ad=0.58 as=0.58 pd=4.58 ps=4.58 mult=1 m=1
XMPH_op1_0900_nr_s1_r10k vp_op1_0900_nr_s1_r10k enb_op1_0900_nr_s1_r10k vdd vdd sky130_fd_pr__pfet_01v8 L=0.15 W=4 nf=1 ad=1.16 as=1.16 pd=8.58 ps=8.58 mult=1 m=1
bd_op1_0900_nr_s1_r10k d_op1_0900_nr_s1_r10k 0 v=v(rbl_op1_0900_nr_s1_r10k)-v(ref_op1_0900_nr_s1_r10k)

* ---- instance 346: op1_1000_nr_s1_r10k (variant nr_s1_r10k; probe dec 11.9 ns, release 34 ns, meas 36 ns) ----
vctl_op1_1000_nr_s1_r10k ctl_op1_1000_nr_s1_r10k 0 pwl(0.0000e+00 {VDD} 2.0000e-09 {VDD} 2.1000e-09 0)
* RWL driver model (EXPERIMENTAL): slew 1 ns, series R 10000 ohm; cell pin = rwls_op1_1000_nr_s1_r10k
vrs_op1_1000_nr_s1_r10k rwlsrc_op1_1000_nr_s1_r10k 0 pwl(0.0000e+00 {VDD} 2.0000e-09 {VDD} 3.0000e-09 0 1.2000e-08 0 1.3000e-08 {VDD})
rdrv_op1_1000_nr_s1_r10k rwlsrc_op1_1000_nr_s1_r10k rwls_op1_1000_nr_s1_r10k 10000
ven_op1_1000_nr_s1_r10k en_op1_1000_nr_s1_r10k 0 pwl(0.0000e+00 0 1.1000e-08 0 1.1100e-08 {VDD} 3.4000e-08 {VDD} 3.4100e-08 0)
venb_op1_1000_nr_s1_r10k enb_op1_1000_nr_s1_r10k 0 pwl(0.0000e+00 {VDD} 1.1000e-08 {VDD} 1.1100e-08 0 3.4000e-08 0 3.4100e-08 {VDD})
vww_op1_1000_nr_s1_r10k wwl_op1_1000_nr_s1_r10k 0 pwl(0.0000e+00 0)
vwc_op1_1000_nr_s1_r10k wbc_op1_1000_nr_s1_r10k 0 pwl(0.0000e+00 0)
swb_op1_1000_nr_s1_r10k ref_op1_1000_nr_s1_r10k wbl_op1_1000_nr_s1_r10k wbc_op1_1000_nr_s1_r10k 0 swwbl
cwbl_op1_1000_nr_s1_r10k wbl_op1_1000_nr_s1_r10k 0 {C_WBL}
spa_op1_1000_nr_s1_r10k prea rbl_op1_1000_nr_s1_r10k ctl_op1_1000_nr_s1_r10k 0 swpre
spr_op1_1000_nr_s1_r10k pref ref_op1_1000_nr_s1_r10k ctl_op1_1000_nr_s1_r10k 0 swpre
crbl_op1_1000_nr_s1_r10k rbl_op1_1000_nr_s1_r10k 0 {C_RBL}
cref_op1_1000_nr_s1_r10k ref_op1_1000_nr_s1_r10k 0 {C_RBL}   $ ASSUMPTION: ideal matched dummy load
XMWR_op1_1000_nr_s1_r10k_0 sn_op1_1000_nr_s1_r10k_0 wwl_op1_1000_nr_s1_r10k wbl_op1_1000_nr_s1_r10k 0 sky130_fd_pr__nfet_01v8 L=0.15 W=0.42 nf=1 ad=0.1218 as=0.1218 pd=1.42 ps=1.42 nrd=0.69047619047619  nrs=0.69047619047619 sa=0 sb=0 sd=0 mult=1 m=1
XMRD_op1_1000_nr_s1_r10k_0 rbl_op1_1000_nr_s1_r10k sn_op1_1000_nr_s1_r10k_0 rwls_op1_1000_nr_s1_r10k 0 sky130_fd_pr__nfet_01v8 L=0.15 W=0.42 nf=1 ad=0.1218 as=0.1218 pd=1.42 ps=1.42 nrd=0.69047619047619  nrs=0.69047619047619 sa=0 sb=0 sd=0 mult=1 m=1
csn_op1_1000_nr_s1_r10k_0 sn_op1_1000_nr_s1_r10k_0 0 {C_SN}
XMWR_op1_1000_nr_s1_r10k_1 sn_op1_1000_nr_s1_r10k_1 wwl_des wbl_op1_1000_nr_s1_r10k 0 sky130_fd_pr__nfet_01v8 L=0.15 W=0.42 nf=1 ad=0.1218 as=0.1218 pd=1.42 ps=1.42 nrd=0.69047619047619  nrs=0.69047619047619 sa=0 sb=0 sd=0 mult=1 m=1
XMRD_op1_1000_nr_s1_r10k_1 rbl_op1_1000_nr_s1_r10k sn_op1_1000_nr_s1_r10k_1 rwl_des 0 sky130_fd_pr__nfet_01v8 L=0.15 W=0.42 nf=1 ad=0.1218 as=0.1218 pd=1.42 ps=1.42 nrd=0.69047619047619  nrs=0.69047619047619 sa=0 sb=0 sd=0 mult=1 m=1
csn_op1_1000_nr_s1_r10k_1 sn_op1_1000_nr_s1_r10k_1 0 {C_SN}
XMWR_op1_1000_nr_s1_r10k_2 sn_op1_1000_nr_s1_r10k_2 wwl_des wbl_op1_1000_nr_s1_r10k 0 sky130_fd_pr__nfet_01v8 L=0.15 W=0.42 nf=1 ad=0.1218 as=0.1218 pd=1.42 ps=1.42 nrd=0.69047619047619  nrs=0.69047619047619 sa=0 sb=0 sd=0 mult=1 m=1
XMRD_op1_1000_nr_s1_r10k_2 rbl_op1_1000_nr_s1_r10k sn_op1_1000_nr_s1_r10k_2 rwl_des 0 sky130_fd_pr__nfet_01v8 L=0.15 W=0.42 nf=1 ad=0.1218 as=0.1218 pd=1.42 ps=1.42 nrd=0.69047619047619  nrs=0.69047619047619 sa=0 sb=0 sd=0 mult=1 m=1
csn_op1_1000_nr_s1_r10k_2 sn_op1_1000_nr_s1_r10k_2 0 {C_SN}
XMWR_op1_1000_nr_s1_r10k_3 sn_op1_1000_nr_s1_r10k_3 wwl_des wbl_op1_1000_nr_s1_r10k 0 sky130_fd_pr__nfet_01v8 L=0.15 W=0.42 nf=1 ad=0.1218 as=0.1218 pd=1.42 ps=1.42 nrd=0.69047619047619  nrs=0.69047619047619 sa=0 sb=0 sd=0 mult=1 m=1
XMRD_op1_1000_nr_s1_r10k_3 rbl_op1_1000_nr_s1_r10k sn_op1_1000_nr_s1_r10k_3 rwl_des 0 sky130_fd_pr__nfet_01v8 L=0.15 W=0.42 nf=1 ad=0.1218 as=0.1218 pd=1.42 ps=1.42 nrd=0.69047619047619  nrs=0.69047619047619 sa=0 sb=0 sd=0 mult=1 m=1
csn_op1_1000_nr_s1_r10k_3 sn_op1_1000_nr_s1_r10k_3 0 {C_SN}
XMN1_op1_1000_nr_s1_r10k rbl_op1_1000_nr_s1_r10k ref_op1_1000_nr_s1_r10k vn_op1_1000_nr_s1_r10k 0 sky130_fd_pr__nfet_01v8 L=0.15 W=1 nf=1 ad=0.29 as=0.29 pd=2.58 ps=2.58 mult=1 m=1
XMN2_op1_1000_nr_s1_r10k ref_op1_1000_nr_s1_r10k rbl_op1_1000_nr_s1_r10k vn_op1_1000_nr_s1_r10k 0 sky130_fd_pr__nfet_01v8 L=0.15 W=1 nf=1 ad=0.29 as=0.29 pd=2.58 ps=2.58 mult=1 m=1
XMP1_op1_1000_nr_s1_r10k rbl_op1_1000_nr_s1_r10k ref_op1_1000_nr_s1_r10k vp_op1_1000_nr_s1_r10k vdd sky130_fd_pr__pfet_01v8 L=0.15 W=2 nf=1 ad=0.58 as=0.58 pd=4.58 ps=4.58 mult=1 m=1
XMP2_op1_1000_nr_s1_r10k ref_op1_1000_nr_s1_r10k rbl_op1_1000_nr_s1_r10k vp_op1_1000_nr_s1_r10k vdd sky130_fd_pr__pfet_01v8 L=0.15 W=2 nf=1 ad=0.58 as=0.58 pd=4.58 ps=4.58 mult=1 m=1
XMNF_op1_1000_nr_s1_r10k vn_op1_1000_nr_s1_r10k en_op1_1000_nr_s1_r10k 0 0 sky130_fd_pr__nfet_01v8 L=0.15 W=2 nf=1 ad=0.58 as=0.58 pd=4.58 ps=4.58 mult=1 m=1
XMPH_op1_1000_nr_s1_r10k vp_op1_1000_nr_s1_r10k enb_op1_1000_nr_s1_r10k vdd vdd sky130_fd_pr__pfet_01v8 L=0.15 W=4 nf=1 ad=1.16 as=1.16 pd=8.58 ps=8.58 mult=1 m=1
bd_op1_1000_nr_s1_r10k d_op1_1000_nr_s1_r10k 0 v=v(rbl_op1_1000_nr_s1_r10k)-v(ref_op1_1000_nr_s1_r10k)

* ---- instance 347: op0_n100_nr_s1_r10k (variant nr_s1_r10k; probe dec 11.9 ns, release 34 ns, meas 36 ns) ----
vctl_op0_n100_nr_s1_r10k ctl_op0_n100_nr_s1_r10k 0 pwl(0.0000e+00 {VDD} 2.0000e-09 {VDD} 2.1000e-09 0)
* RWL driver model (EXPERIMENTAL): slew 1 ns, series R 10000 ohm; cell pin = rwls_op0_n100_nr_s1_r10k
vrs_op0_n100_nr_s1_r10k rwlsrc_op0_n100_nr_s1_r10k 0 pwl(0.0000e+00 {VDD} 2.0000e-09 {VDD} 3.0000e-09 0 1.2000e-08 0 1.3000e-08 {VDD})
rdrv_op0_n100_nr_s1_r10k rwlsrc_op0_n100_nr_s1_r10k rwls_op0_n100_nr_s1_r10k 10000
ven_op0_n100_nr_s1_r10k en_op0_n100_nr_s1_r10k 0 pwl(0.0000e+00 0 1.1000e-08 0 1.1100e-08 {VDD} 3.4000e-08 {VDD} 3.4100e-08 0)
venb_op0_n100_nr_s1_r10k enb_op0_n100_nr_s1_r10k 0 pwl(0.0000e+00 {VDD} 1.1000e-08 {VDD} 1.1100e-08 0 3.4000e-08 0 3.4100e-08 {VDD})
vww_op0_n100_nr_s1_r10k wwl_op0_n100_nr_s1_r10k 0 pwl(0.0000e+00 0)
vwc_op0_n100_nr_s1_r10k wbc_op0_n100_nr_s1_r10k 0 pwl(0.0000e+00 0)
swb_op0_n100_nr_s1_r10k ref_op0_n100_nr_s1_r10k wbl_op0_n100_nr_s1_r10k wbc_op0_n100_nr_s1_r10k 0 swwbl
cwbl_op0_n100_nr_s1_r10k wbl_op0_n100_nr_s1_r10k 0 {C_WBL}
spa_op0_n100_nr_s1_r10k prea rbl_op0_n100_nr_s1_r10k ctl_op0_n100_nr_s1_r10k 0 swpre
spr_op0_n100_nr_s1_r10k pref ref_op0_n100_nr_s1_r10k ctl_op0_n100_nr_s1_r10k 0 swpre
crbl_op0_n100_nr_s1_r10k rbl_op0_n100_nr_s1_r10k 0 {C_RBL}
cref_op0_n100_nr_s1_r10k ref_op0_n100_nr_s1_r10k 0 {C_RBL}   $ ASSUMPTION: ideal matched dummy load
XMWR_op0_n100_nr_s1_r10k_0 sn_op0_n100_nr_s1_r10k_0 wwl_op0_n100_nr_s1_r10k wbl_op0_n100_nr_s1_r10k 0 sky130_fd_pr__nfet_01v8 L=0.15 W=0.42 nf=1 ad=0.1218 as=0.1218 pd=1.42 ps=1.42 nrd=0.69047619047619  nrs=0.69047619047619 sa=0 sb=0 sd=0 mult=1 m=1
XMRD_op0_n100_nr_s1_r10k_0 rbl_op0_n100_nr_s1_r10k sn_op0_n100_nr_s1_r10k_0 rwls_op0_n100_nr_s1_r10k 0 sky130_fd_pr__nfet_01v8 L=0.15 W=0.42 nf=1 ad=0.1218 as=0.1218 pd=1.42 ps=1.42 nrd=0.69047619047619  nrs=0.69047619047619 sa=0 sb=0 sd=0 mult=1 m=1
csn_op0_n100_nr_s1_r10k_0 sn_op0_n100_nr_s1_r10k_0 0 {C_SN}
XMWR_op0_n100_nr_s1_r10k_1 sn_op0_n100_nr_s1_r10k_1 wwl_des wbl_op0_n100_nr_s1_r10k 0 sky130_fd_pr__nfet_01v8 L=0.15 W=0.42 nf=1 ad=0.1218 as=0.1218 pd=1.42 ps=1.42 nrd=0.69047619047619  nrs=0.69047619047619 sa=0 sb=0 sd=0 mult=1 m=1
XMRD_op0_n100_nr_s1_r10k_1 rbl_op0_n100_nr_s1_r10k sn_op0_n100_nr_s1_r10k_1 rwl_des 0 sky130_fd_pr__nfet_01v8 L=0.15 W=0.42 nf=1 ad=0.1218 as=0.1218 pd=1.42 ps=1.42 nrd=0.69047619047619  nrs=0.69047619047619 sa=0 sb=0 sd=0 mult=1 m=1
csn_op0_n100_nr_s1_r10k_1 sn_op0_n100_nr_s1_r10k_1 0 {C_SN}
XMWR_op0_n100_nr_s1_r10k_2 sn_op0_n100_nr_s1_r10k_2 wwl_des wbl_op0_n100_nr_s1_r10k 0 sky130_fd_pr__nfet_01v8 L=0.15 W=0.42 nf=1 ad=0.1218 as=0.1218 pd=1.42 ps=1.42 nrd=0.69047619047619  nrs=0.69047619047619 sa=0 sb=0 sd=0 mult=1 m=1
XMRD_op0_n100_nr_s1_r10k_2 rbl_op0_n100_nr_s1_r10k sn_op0_n100_nr_s1_r10k_2 rwl_des 0 sky130_fd_pr__nfet_01v8 L=0.15 W=0.42 nf=1 ad=0.1218 as=0.1218 pd=1.42 ps=1.42 nrd=0.69047619047619  nrs=0.69047619047619 sa=0 sb=0 sd=0 mult=1 m=1
csn_op0_n100_nr_s1_r10k_2 sn_op0_n100_nr_s1_r10k_2 0 {C_SN}
XMWR_op0_n100_nr_s1_r10k_3 sn_op0_n100_nr_s1_r10k_3 wwl_des wbl_op0_n100_nr_s1_r10k 0 sky130_fd_pr__nfet_01v8 L=0.15 W=0.42 nf=1 ad=0.1218 as=0.1218 pd=1.42 ps=1.42 nrd=0.69047619047619  nrs=0.69047619047619 sa=0 sb=0 sd=0 mult=1 m=1
XMRD_op0_n100_nr_s1_r10k_3 rbl_op0_n100_nr_s1_r10k sn_op0_n100_nr_s1_r10k_3 rwl_des 0 sky130_fd_pr__nfet_01v8 L=0.15 W=0.42 nf=1 ad=0.1218 as=0.1218 pd=1.42 ps=1.42 nrd=0.69047619047619  nrs=0.69047619047619 sa=0 sb=0 sd=0 mult=1 m=1
csn_op0_n100_nr_s1_r10k_3 sn_op0_n100_nr_s1_r10k_3 0 {C_SN}
XMN1_op0_n100_nr_s1_r10k rbl_op0_n100_nr_s1_r10k ref_op0_n100_nr_s1_r10k vn_op0_n100_nr_s1_r10k 0 sky130_fd_pr__nfet_01v8 L=0.15 W=1 nf=1 ad=0.29 as=0.29 pd=2.58 ps=2.58 mult=1 m=1
XMN2_op0_n100_nr_s1_r10k ref_op0_n100_nr_s1_r10k rbl_op0_n100_nr_s1_r10k vn_op0_n100_nr_s1_r10k 0 sky130_fd_pr__nfet_01v8 L=0.15 W=1 nf=1 ad=0.29 as=0.29 pd=2.58 ps=2.58 mult=1 m=1
XMP1_op0_n100_nr_s1_r10k rbl_op0_n100_nr_s1_r10k ref_op0_n100_nr_s1_r10k vp_op0_n100_nr_s1_r10k vdd sky130_fd_pr__pfet_01v8 L=0.15 W=2 nf=1 ad=0.58 as=0.58 pd=4.58 ps=4.58 mult=1 m=1
XMP2_op0_n100_nr_s1_r10k ref_op0_n100_nr_s1_r10k rbl_op0_n100_nr_s1_r10k vp_op0_n100_nr_s1_r10k vdd sky130_fd_pr__pfet_01v8 L=0.15 W=2 nf=1 ad=0.58 as=0.58 pd=4.58 ps=4.58 mult=1 m=1
XMNF_op0_n100_nr_s1_r10k vn_op0_n100_nr_s1_r10k en_op0_n100_nr_s1_r10k 0 0 sky130_fd_pr__nfet_01v8 L=0.15 W=2 nf=1 ad=0.58 as=0.58 pd=4.58 ps=4.58 mult=1 m=1
XMPH_op0_n100_nr_s1_r10k vp_op0_n100_nr_s1_r10k enb_op0_n100_nr_s1_r10k vdd vdd sky130_fd_pr__pfet_01v8 L=0.15 W=4 nf=1 ad=1.16 as=1.16 pd=8.58 ps=8.58 mult=1 m=1
bd_op0_n100_nr_s1_r10k d_op0_n100_nr_s1_r10k 0 v=v(rbl_op0_n100_nr_s1_r10k)-v(ref_op0_n100_nr_s1_r10k)

* ---- instance 348: op0_0000_nr_s1_r10k (variant nr_s1_r10k; probe dec 11.9 ns, release 34 ns, meas 36 ns) ----
vctl_op0_0000_nr_s1_r10k ctl_op0_0000_nr_s1_r10k 0 pwl(0.0000e+00 {VDD} 2.0000e-09 {VDD} 2.1000e-09 0)
* RWL driver model (EXPERIMENTAL): slew 1 ns, series R 10000 ohm; cell pin = rwls_op0_0000_nr_s1_r10k
vrs_op0_0000_nr_s1_r10k rwlsrc_op0_0000_nr_s1_r10k 0 pwl(0.0000e+00 {VDD} 2.0000e-09 {VDD} 3.0000e-09 0 1.2000e-08 0 1.3000e-08 {VDD})
rdrv_op0_0000_nr_s1_r10k rwlsrc_op0_0000_nr_s1_r10k rwls_op0_0000_nr_s1_r10k 10000
ven_op0_0000_nr_s1_r10k en_op0_0000_nr_s1_r10k 0 pwl(0.0000e+00 0 1.1000e-08 0 1.1100e-08 {VDD} 3.4000e-08 {VDD} 3.4100e-08 0)
venb_op0_0000_nr_s1_r10k enb_op0_0000_nr_s1_r10k 0 pwl(0.0000e+00 {VDD} 1.1000e-08 {VDD} 1.1100e-08 0 3.4000e-08 0 3.4100e-08 {VDD})
vww_op0_0000_nr_s1_r10k wwl_op0_0000_nr_s1_r10k 0 pwl(0.0000e+00 0)
vwc_op0_0000_nr_s1_r10k wbc_op0_0000_nr_s1_r10k 0 pwl(0.0000e+00 0)
swb_op0_0000_nr_s1_r10k ref_op0_0000_nr_s1_r10k wbl_op0_0000_nr_s1_r10k wbc_op0_0000_nr_s1_r10k 0 swwbl
cwbl_op0_0000_nr_s1_r10k wbl_op0_0000_nr_s1_r10k 0 {C_WBL}
spa_op0_0000_nr_s1_r10k prea rbl_op0_0000_nr_s1_r10k ctl_op0_0000_nr_s1_r10k 0 swpre
spr_op0_0000_nr_s1_r10k pref ref_op0_0000_nr_s1_r10k ctl_op0_0000_nr_s1_r10k 0 swpre
crbl_op0_0000_nr_s1_r10k rbl_op0_0000_nr_s1_r10k 0 {C_RBL}
cref_op0_0000_nr_s1_r10k ref_op0_0000_nr_s1_r10k 0 {C_RBL}   $ ASSUMPTION: ideal matched dummy load
XMWR_op0_0000_nr_s1_r10k_0 sn_op0_0000_nr_s1_r10k_0 wwl_op0_0000_nr_s1_r10k wbl_op0_0000_nr_s1_r10k 0 sky130_fd_pr__nfet_01v8 L=0.15 W=0.42 nf=1 ad=0.1218 as=0.1218 pd=1.42 ps=1.42 nrd=0.69047619047619  nrs=0.69047619047619 sa=0 sb=0 sd=0 mult=1 m=1
XMRD_op0_0000_nr_s1_r10k_0 rbl_op0_0000_nr_s1_r10k sn_op0_0000_nr_s1_r10k_0 rwls_op0_0000_nr_s1_r10k 0 sky130_fd_pr__nfet_01v8 L=0.15 W=0.42 nf=1 ad=0.1218 as=0.1218 pd=1.42 ps=1.42 nrd=0.69047619047619  nrs=0.69047619047619 sa=0 sb=0 sd=0 mult=1 m=1
csn_op0_0000_nr_s1_r10k_0 sn_op0_0000_nr_s1_r10k_0 0 {C_SN}
XMWR_op0_0000_nr_s1_r10k_1 sn_op0_0000_nr_s1_r10k_1 wwl_des wbl_op0_0000_nr_s1_r10k 0 sky130_fd_pr__nfet_01v8 L=0.15 W=0.42 nf=1 ad=0.1218 as=0.1218 pd=1.42 ps=1.42 nrd=0.69047619047619  nrs=0.69047619047619 sa=0 sb=0 sd=0 mult=1 m=1
XMRD_op0_0000_nr_s1_r10k_1 rbl_op0_0000_nr_s1_r10k sn_op0_0000_nr_s1_r10k_1 rwl_des 0 sky130_fd_pr__nfet_01v8 L=0.15 W=0.42 nf=1 ad=0.1218 as=0.1218 pd=1.42 ps=1.42 nrd=0.69047619047619  nrs=0.69047619047619 sa=0 sb=0 sd=0 mult=1 m=1
csn_op0_0000_nr_s1_r10k_1 sn_op0_0000_nr_s1_r10k_1 0 {C_SN}
XMWR_op0_0000_nr_s1_r10k_2 sn_op0_0000_nr_s1_r10k_2 wwl_des wbl_op0_0000_nr_s1_r10k 0 sky130_fd_pr__nfet_01v8 L=0.15 W=0.42 nf=1 ad=0.1218 as=0.1218 pd=1.42 ps=1.42 nrd=0.69047619047619  nrs=0.69047619047619 sa=0 sb=0 sd=0 mult=1 m=1
XMRD_op0_0000_nr_s1_r10k_2 rbl_op0_0000_nr_s1_r10k sn_op0_0000_nr_s1_r10k_2 rwl_des 0 sky130_fd_pr__nfet_01v8 L=0.15 W=0.42 nf=1 ad=0.1218 as=0.1218 pd=1.42 ps=1.42 nrd=0.69047619047619  nrs=0.69047619047619 sa=0 sb=0 sd=0 mult=1 m=1
csn_op0_0000_nr_s1_r10k_2 sn_op0_0000_nr_s1_r10k_2 0 {C_SN}
XMWR_op0_0000_nr_s1_r10k_3 sn_op0_0000_nr_s1_r10k_3 wwl_des wbl_op0_0000_nr_s1_r10k 0 sky130_fd_pr__nfet_01v8 L=0.15 W=0.42 nf=1 ad=0.1218 as=0.1218 pd=1.42 ps=1.42 nrd=0.69047619047619  nrs=0.69047619047619 sa=0 sb=0 sd=0 mult=1 m=1
XMRD_op0_0000_nr_s1_r10k_3 rbl_op0_0000_nr_s1_r10k sn_op0_0000_nr_s1_r10k_3 rwl_des 0 sky130_fd_pr__nfet_01v8 L=0.15 W=0.42 nf=1 ad=0.1218 as=0.1218 pd=1.42 ps=1.42 nrd=0.69047619047619  nrs=0.69047619047619 sa=0 sb=0 sd=0 mult=1 m=1
csn_op0_0000_nr_s1_r10k_3 sn_op0_0000_nr_s1_r10k_3 0 {C_SN}
XMN1_op0_0000_nr_s1_r10k rbl_op0_0000_nr_s1_r10k ref_op0_0000_nr_s1_r10k vn_op0_0000_nr_s1_r10k 0 sky130_fd_pr__nfet_01v8 L=0.15 W=1 nf=1 ad=0.29 as=0.29 pd=2.58 ps=2.58 mult=1 m=1
XMN2_op0_0000_nr_s1_r10k ref_op0_0000_nr_s1_r10k rbl_op0_0000_nr_s1_r10k vn_op0_0000_nr_s1_r10k 0 sky130_fd_pr__nfet_01v8 L=0.15 W=1 nf=1 ad=0.29 as=0.29 pd=2.58 ps=2.58 mult=1 m=1
XMP1_op0_0000_nr_s1_r10k rbl_op0_0000_nr_s1_r10k ref_op0_0000_nr_s1_r10k vp_op0_0000_nr_s1_r10k vdd sky130_fd_pr__pfet_01v8 L=0.15 W=2 nf=1 ad=0.58 as=0.58 pd=4.58 ps=4.58 mult=1 m=1
XMP2_op0_0000_nr_s1_r10k ref_op0_0000_nr_s1_r10k rbl_op0_0000_nr_s1_r10k vp_op0_0000_nr_s1_r10k vdd sky130_fd_pr__pfet_01v8 L=0.15 W=2 nf=1 ad=0.58 as=0.58 pd=4.58 ps=4.58 mult=1 m=1
XMNF_op0_0000_nr_s1_r10k vn_op0_0000_nr_s1_r10k en_op0_0000_nr_s1_r10k 0 0 sky130_fd_pr__nfet_01v8 L=0.15 W=2 nf=1 ad=0.58 as=0.58 pd=4.58 ps=4.58 mult=1 m=1
XMPH_op0_0000_nr_s1_r10k vp_op0_0000_nr_s1_r10k enb_op0_0000_nr_s1_r10k vdd vdd sky130_fd_pr__pfet_01v8 L=0.15 W=4 nf=1 ad=1.16 as=1.16 pd=8.58 ps=8.58 mult=1 m=1
bd_op0_0000_nr_s1_r10k d_op0_0000_nr_s1_r10k 0 v=v(rbl_op0_0000_nr_s1_r10k)-v(ref_op0_0000_nr_s1_r10k)

* ---- instance 349: op1_0900_nl_s1_r10k (variant nl_s1_r10k; probe dec 11.9 ns, release 34 ns, meas 36 ns) ----
vctl_op1_0900_nl_s1_r10k ctl_op1_0900_nl_s1_r10k 0 pwl(0.0000e+00 {VDD} 2.0000e-09 {VDD} 2.1000e-09 0)
* RWL driver model (EXPERIMENTAL): slew 1 ns, series R 10000 ohm; cell pin = rwls_op1_0900_nl_s1_r10k
vrs_op1_0900_nl_s1_r10k rwlsrc_op1_0900_nl_s1_r10k 0 pwl(0.0000e+00 {VDD} 2.0000e-09 {VDD} 3.0000e-09 0 3.4000e-08 0 3.5000e-08 {VDD})
rdrv_op1_0900_nl_s1_r10k rwlsrc_op1_0900_nl_s1_r10k rwls_op1_0900_nl_s1_r10k 10000
ven_op1_0900_nl_s1_r10k en_op1_0900_nl_s1_r10k 0 pwl(0.0000e+00 0 1.1000e-08 0 1.1100e-08 {VDD} 3.4000e-08 {VDD} 3.4100e-08 0)
venb_op1_0900_nl_s1_r10k enb_op1_0900_nl_s1_r10k 0 pwl(0.0000e+00 {VDD} 1.1000e-08 {VDD} 1.1100e-08 0 3.4000e-08 0 3.4100e-08 {VDD})
vww_op1_0900_nl_s1_r10k wwl_op1_0900_nl_s1_r10k 0 pwl(0.0000e+00 0)
vwc_op1_0900_nl_s1_r10k wbc_op1_0900_nl_s1_r10k 0 pwl(0.0000e+00 0)
swb_op1_0900_nl_s1_r10k ref_op1_0900_nl_s1_r10k wbl_op1_0900_nl_s1_r10k wbc_op1_0900_nl_s1_r10k 0 swwbl
cwbl_op1_0900_nl_s1_r10k wbl_op1_0900_nl_s1_r10k 0 {C_WBL}
spa_op1_0900_nl_s1_r10k prea rbl_op1_0900_nl_s1_r10k ctl_op1_0900_nl_s1_r10k 0 swpre
spr_op1_0900_nl_s1_r10k pref ref_op1_0900_nl_s1_r10k ctl_op1_0900_nl_s1_r10k 0 swpre
crbl_op1_0900_nl_s1_r10k rbl_op1_0900_nl_s1_r10k 0 {C_RBL}
cref_op1_0900_nl_s1_r10k ref_op1_0900_nl_s1_r10k 0 {C_RBL}   $ ASSUMPTION: ideal matched dummy load
XMWR_op1_0900_nl_s1_r10k_0 sn_op1_0900_nl_s1_r10k_0 wwl_op1_0900_nl_s1_r10k wbl_op1_0900_nl_s1_r10k 0 sky130_fd_pr__nfet_01v8 L=0.15 W=0.42 nf=1 ad=0.1218 as=0.1218 pd=1.42 ps=1.42 nrd=0.69047619047619  nrs=0.69047619047619 sa=0 sb=0 sd=0 mult=1 m=1
XMRD_op1_0900_nl_s1_r10k_0 rbl_op1_0900_nl_s1_r10k sn_op1_0900_nl_s1_r10k_0 rwls_op1_0900_nl_s1_r10k 0 sky130_fd_pr__nfet_01v8 L=0.15 W=0.42 nf=1 ad=0.1218 as=0.1218 pd=1.42 ps=1.42 nrd=0.69047619047619  nrs=0.69047619047619 sa=0 sb=0 sd=0 mult=1 m=1
csn_op1_0900_nl_s1_r10k_0 sn_op1_0900_nl_s1_r10k_0 0 {C_SN}
XMWR_op1_0900_nl_s1_r10k_1 sn_op1_0900_nl_s1_r10k_1 wwl_des wbl_op1_0900_nl_s1_r10k 0 sky130_fd_pr__nfet_01v8 L=0.15 W=0.42 nf=1 ad=0.1218 as=0.1218 pd=1.42 ps=1.42 nrd=0.69047619047619  nrs=0.69047619047619 sa=0 sb=0 sd=0 mult=1 m=1
XMRD_op1_0900_nl_s1_r10k_1 rbl_op1_0900_nl_s1_r10k sn_op1_0900_nl_s1_r10k_1 rwl_des 0 sky130_fd_pr__nfet_01v8 L=0.15 W=0.42 nf=1 ad=0.1218 as=0.1218 pd=1.42 ps=1.42 nrd=0.69047619047619  nrs=0.69047619047619 sa=0 sb=0 sd=0 mult=1 m=1
csn_op1_0900_nl_s1_r10k_1 sn_op1_0900_nl_s1_r10k_1 0 {C_SN}
XMWR_op1_0900_nl_s1_r10k_2 sn_op1_0900_nl_s1_r10k_2 wwl_des wbl_op1_0900_nl_s1_r10k 0 sky130_fd_pr__nfet_01v8 L=0.15 W=0.42 nf=1 ad=0.1218 as=0.1218 pd=1.42 ps=1.42 nrd=0.69047619047619  nrs=0.69047619047619 sa=0 sb=0 sd=0 mult=1 m=1
XMRD_op1_0900_nl_s1_r10k_2 rbl_op1_0900_nl_s1_r10k sn_op1_0900_nl_s1_r10k_2 rwl_des 0 sky130_fd_pr__nfet_01v8 L=0.15 W=0.42 nf=1 ad=0.1218 as=0.1218 pd=1.42 ps=1.42 nrd=0.69047619047619  nrs=0.69047619047619 sa=0 sb=0 sd=0 mult=1 m=1
csn_op1_0900_nl_s1_r10k_2 sn_op1_0900_nl_s1_r10k_2 0 {C_SN}
XMWR_op1_0900_nl_s1_r10k_3 sn_op1_0900_nl_s1_r10k_3 wwl_des wbl_op1_0900_nl_s1_r10k 0 sky130_fd_pr__nfet_01v8 L=0.15 W=0.42 nf=1 ad=0.1218 as=0.1218 pd=1.42 ps=1.42 nrd=0.69047619047619  nrs=0.69047619047619 sa=0 sb=0 sd=0 mult=1 m=1
XMRD_op1_0900_nl_s1_r10k_3 rbl_op1_0900_nl_s1_r10k sn_op1_0900_nl_s1_r10k_3 rwl_des 0 sky130_fd_pr__nfet_01v8 L=0.15 W=0.42 nf=1 ad=0.1218 as=0.1218 pd=1.42 ps=1.42 nrd=0.69047619047619  nrs=0.69047619047619 sa=0 sb=0 sd=0 mult=1 m=1
csn_op1_0900_nl_s1_r10k_3 sn_op1_0900_nl_s1_r10k_3 0 {C_SN}
XMN1_op1_0900_nl_s1_r10k rbl_op1_0900_nl_s1_r10k ref_op1_0900_nl_s1_r10k vn_op1_0900_nl_s1_r10k 0 sky130_fd_pr__nfet_01v8 L=0.15 W=1 nf=1 ad=0.29 as=0.29 pd=2.58 ps=2.58 mult=1 m=1
XMN2_op1_0900_nl_s1_r10k ref_op1_0900_nl_s1_r10k rbl_op1_0900_nl_s1_r10k vn_op1_0900_nl_s1_r10k 0 sky130_fd_pr__nfet_01v8 L=0.15 W=1 nf=1 ad=0.29 as=0.29 pd=2.58 ps=2.58 mult=1 m=1
XMP1_op1_0900_nl_s1_r10k rbl_op1_0900_nl_s1_r10k ref_op1_0900_nl_s1_r10k vp_op1_0900_nl_s1_r10k vdd sky130_fd_pr__pfet_01v8 L=0.15 W=2 nf=1 ad=0.58 as=0.58 pd=4.58 ps=4.58 mult=1 m=1
XMP2_op1_0900_nl_s1_r10k ref_op1_0900_nl_s1_r10k rbl_op1_0900_nl_s1_r10k vp_op1_0900_nl_s1_r10k vdd sky130_fd_pr__pfet_01v8 L=0.15 W=2 nf=1 ad=0.58 as=0.58 pd=4.58 ps=4.58 mult=1 m=1
XMNF_op1_0900_nl_s1_r10k vn_op1_0900_nl_s1_r10k en_op1_0900_nl_s1_r10k 0 0 sky130_fd_pr__nfet_01v8 L=0.15 W=2 nf=1 ad=0.58 as=0.58 pd=4.58 ps=4.58 mult=1 m=1
XMPH_op1_0900_nl_s1_r10k vp_op1_0900_nl_s1_r10k enb_op1_0900_nl_s1_r10k vdd vdd sky130_fd_pr__pfet_01v8 L=0.15 W=4 nf=1 ad=1.16 as=1.16 pd=8.58 ps=8.58 mult=1 m=1
bd_op1_0900_nl_s1_r10k d_op1_0900_nl_s1_r10k 0 v=v(rbl_op1_0900_nl_s1_r10k)-v(ref_op1_0900_nl_s1_r10k)

* ---- instance 350: op1_1000_nl_s1_r10k (variant nl_s1_r10k; probe dec 11.9 ns, release 34 ns, meas 36 ns) ----
vctl_op1_1000_nl_s1_r10k ctl_op1_1000_nl_s1_r10k 0 pwl(0.0000e+00 {VDD} 2.0000e-09 {VDD} 2.1000e-09 0)
* RWL driver model (EXPERIMENTAL): slew 1 ns, series R 10000 ohm; cell pin = rwls_op1_1000_nl_s1_r10k
vrs_op1_1000_nl_s1_r10k rwlsrc_op1_1000_nl_s1_r10k 0 pwl(0.0000e+00 {VDD} 2.0000e-09 {VDD} 3.0000e-09 0 3.4000e-08 0 3.5000e-08 {VDD})
rdrv_op1_1000_nl_s1_r10k rwlsrc_op1_1000_nl_s1_r10k rwls_op1_1000_nl_s1_r10k 10000
ven_op1_1000_nl_s1_r10k en_op1_1000_nl_s1_r10k 0 pwl(0.0000e+00 0 1.1000e-08 0 1.1100e-08 {VDD} 3.4000e-08 {VDD} 3.4100e-08 0)
venb_op1_1000_nl_s1_r10k enb_op1_1000_nl_s1_r10k 0 pwl(0.0000e+00 {VDD} 1.1000e-08 {VDD} 1.1100e-08 0 3.4000e-08 0 3.4100e-08 {VDD})
vww_op1_1000_nl_s1_r10k wwl_op1_1000_nl_s1_r10k 0 pwl(0.0000e+00 0)
vwc_op1_1000_nl_s1_r10k wbc_op1_1000_nl_s1_r10k 0 pwl(0.0000e+00 0)
swb_op1_1000_nl_s1_r10k ref_op1_1000_nl_s1_r10k wbl_op1_1000_nl_s1_r10k wbc_op1_1000_nl_s1_r10k 0 swwbl
cwbl_op1_1000_nl_s1_r10k wbl_op1_1000_nl_s1_r10k 0 {C_WBL}
spa_op1_1000_nl_s1_r10k prea rbl_op1_1000_nl_s1_r10k ctl_op1_1000_nl_s1_r10k 0 swpre
spr_op1_1000_nl_s1_r10k pref ref_op1_1000_nl_s1_r10k ctl_op1_1000_nl_s1_r10k 0 swpre
crbl_op1_1000_nl_s1_r10k rbl_op1_1000_nl_s1_r10k 0 {C_RBL}
cref_op1_1000_nl_s1_r10k ref_op1_1000_nl_s1_r10k 0 {C_RBL}   $ ASSUMPTION: ideal matched dummy load
XMWR_op1_1000_nl_s1_r10k_0 sn_op1_1000_nl_s1_r10k_0 wwl_op1_1000_nl_s1_r10k wbl_op1_1000_nl_s1_r10k 0 sky130_fd_pr__nfet_01v8 L=0.15 W=0.42 nf=1 ad=0.1218 as=0.1218 pd=1.42 ps=1.42 nrd=0.69047619047619  nrs=0.69047619047619 sa=0 sb=0 sd=0 mult=1 m=1
XMRD_op1_1000_nl_s1_r10k_0 rbl_op1_1000_nl_s1_r10k sn_op1_1000_nl_s1_r10k_0 rwls_op1_1000_nl_s1_r10k 0 sky130_fd_pr__nfet_01v8 L=0.15 W=0.42 nf=1 ad=0.1218 as=0.1218 pd=1.42 ps=1.42 nrd=0.69047619047619  nrs=0.69047619047619 sa=0 sb=0 sd=0 mult=1 m=1
csn_op1_1000_nl_s1_r10k_0 sn_op1_1000_nl_s1_r10k_0 0 {C_SN}
XMWR_op1_1000_nl_s1_r10k_1 sn_op1_1000_nl_s1_r10k_1 wwl_des wbl_op1_1000_nl_s1_r10k 0 sky130_fd_pr__nfet_01v8 L=0.15 W=0.42 nf=1 ad=0.1218 as=0.1218 pd=1.42 ps=1.42 nrd=0.69047619047619  nrs=0.69047619047619 sa=0 sb=0 sd=0 mult=1 m=1
XMRD_op1_1000_nl_s1_r10k_1 rbl_op1_1000_nl_s1_r10k sn_op1_1000_nl_s1_r10k_1 rwl_des 0 sky130_fd_pr__nfet_01v8 L=0.15 W=0.42 nf=1 ad=0.1218 as=0.1218 pd=1.42 ps=1.42 nrd=0.69047619047619  nrs=0.69047619047619 sa=0 sb=0 sd=0 mult=1 m=1
csn_op1_1000_nl_s1_r10k_1 sn_op1_1000_nl_s1_r10k_1 0 {C_SN}
XMWR_op1_1000_nl_s1_r10k_2 sn_op1_1000_nl_s1_r10k_2 wwl_des wbl_op1_1000_nl_s1_r10k 0 sky130_fd_pr__nfet_01v8 L=0.15 W=0.42 nf=1 ad=0.1218 as=0.1218 pd=1.42 ps=1.42 nrd=0.69047619047619  nrs=0.69047619047619 sa=0 sb=0 sd=0 mult=1 m=1
XMRD_op1_1000_nl_s1_r10k_2 rbl_op1_1000_nl_s1_r10k sn_op1_1000_nl_s1_r10k_2 rwl_des 0 sky130_fd_pr__nfet_01v8 L=0.15 W=0.42 nf=1 ad=0.1218 as=0.1218 pd=1.42 ps=1.42 nrd=0.69047619047619  nrs=0.69047619047619 sa=0 sb=0 sd=0 mult=1 m=1
csn_op1_1000_nl_s1_r10k_2 sn_op1_1000_nl_s1_r10k_2 0 {C_SN}
XMWR_op1_1000_nl_s1_r10k_3 sn_op1_1000_nl_s1_r10k_3 wwl_des wbl_op1_1000_nl_s1_r10k 0 sky130_fd_pr__nfet_01v8 L=0.15 W=0.42 nf=1 ad=0.1218 as=0.1218 pd=1.42 ps=1.42 nrd=0.69047619047619  nrs=0.69047619047619 sa=0 sb=0 sd=0 mult=1 m=1
XMRD_op1_1000_nl_s1_r10k_3 rbl_op1_1000_nl_s1_r10k sn_op1_1000_nl_s1_r10k_3 rwl_des 0 sky130_fd_pr__nfet_01v8 L=0.15 W=0.42 nf=1 ad=0.1218 as=0.1218 pd=1.42 ps=1.42 nrd=0.69047619047619  nrs=0.69047619047619 sa=0 sb=0 sd=0 mult=1 m=1
csn_op1_1000_nl_s1_r10k_3 sn_op1_1000_nl_s1_r10k_3 0 {C_SN}
XMN1_op1_1000_nl_s1_r10k rbl_op1_1000_nl_s1_r10k ref_op1_1000_nl_s1_r10k vn_op1_1000_nl_s1_r10k 0 sky130_fd_pr__nfet_01v8 L=0.15 W=1 nf=1 ad=0.29 as=0.29 pd=2.58 ps=2.58 mult=1 m=1
XMN2_op1_1000_nl_s1_r10k ref_op1_1000_nl_s1_r10k rbl_op1_1000_nl_s1_r10k vn_op1_1000_nl_s1_r10k 0 sky130_fd_pr__nfet_01v8 L=0.15 W=1 nf=1 ad=0.29 as=0.29 pd=2.58 ps=2.58 mult=1 m=1
XMP1_op1_1000_nl_s1_r10k rbl_op1_1000_nl_s1_r10k ref_op1_1000_nl_s1_r10k vp_op1_1000_nl_s1_r10k vdd sky130_fd_pr__pfet_01v8 L=0.15 W=2 nf=1 ad=0.58 as=0.58 pd=4.58 ps=4.58 mult=1 m=1
XMP2_op1_1000_nl_s1_r10k ref_op1_1000_nl_s1_r10k rbl_op1_1000_nl_s1_r10k vp_op1_1000_nl_s1_r10k vdd sky130_fd_pr__pfet_01v8 L=0.15 W=2 nf=1 ad=0.58 as=0.58 pd=4.58 ps=4.58 mult=1 m=1
XMNF_op1_1000_nl_s1_r10k vn_op1_1000_nl_s1_r10k en_op1_1000_nl_s1_r10k 0 0 sky130_fd_pr__nfet_01v8 L=0.15 W=2 nf=1 ad=0.58 as=0.58 pd=4.58 ps=4.58 mult=1 m=1
XMPH_op1_1000_nl_s1_r10k vp_op1_1000_nl_s1_r10k enb_op1_1000_nl_s1_r10k vdd vdd sky130_fd_pr__pfet_01v8 L=0.15 W=4 nf=1 ad=1.16 as=1.16 pd=8.58 ps=8.58 mult=1 m=1
bd_op1_1000_nl_s1_r10k d_op1_1000_nl_s1_r10k 0 v=v(rbl_op1_1000_nl_s1_r10k)-v(ref_op1_1000_nl_s1_r10k)

* ---- instance 351: op0_n100_nl_s1_r10k (variant nl_s1_r10k; probe dec 11.9 ns, release 34 ns, meas 36 ns) ----
vctl_op0_n100_nl_s1_r10k ctl_op0_n100_nl_s1_r10k 0 pwl(0.0000e+00 {VDD} 2.0000e-09 {VDD} 2.1000e-09 0)
* RWL driver model (EXPERIMENTAL): slew 1 ns, series R 10000 ohm; cell pin = rwls_op0_n100_nl_s1_r10k
vrs_op0_n100_nl_s1_r10k rwlsrc_op0_n100_nl_s1_r10k 0 pwl(0.0000e+00 {VDD} 2.0000e-09 {VDD} 3.0000e-09 0 3.4000e-08 0 3.5000e-08 {VDD})
rdrv_op0_n100_nl_s1_r10k rwlsrc_op0_n100_nl_s1_r10k rwls_op0_n100_nl_s1_r10k 10000
ven_op0_n100_nl_s1_r10k en_op0_n100_nl_s1_r10k 0 pwl(0.0000e+00 0 1.1000e-08 0 1.1100e-08 {VDD} 3.4000e-08 {VDD} 3.4100e-08 0)
venb_op0_n100_nl_s1_r10k enb_op0_n100_nl_s1_r10k 0 pwl(0.0000e+00 {VDD} 1.1000e-08 {VDD} 1.1100e-08 0 3.4000e-08 0 3.4100e-08 {VDD})
vww_op0_n100_nl_s1_r10k wwl_op0_n100_nl_s1_r10k 0 pwl(0.0000e+00 0)
vwc_op0_n100_nl_s1_r10k wbc_op0_n100_nl_s1_r10k 0 pwl(0.0000e+00 0)
swb_op0_n100_nl_s1_r10k ref_op0_n100_nl_s1_r10k wbl_op0_n100_nl_s1_r10k wbc_op0_n100_nl_s1_r10k 0 swwbl
cwbl_op0_n100_nl_s1_r10k wbl_op0_n100_nl_s1_r10k 0 {C_WBL}
spa_op0_n100_nl_s1_r10k prea rbl_op0_n100_nl_s1_r10k ctl_op0_n100_nl_s1_r10k 0 swpre
spr_op0_n100_nl_s1_r10k pref ref_op0_n100_nl_s1_r10k ctl_op0_n100_nl_s1_r10k 0 swpre
crbl_op0_n100_nl_s1_r10k rbl_op0_n100_nl_s1_r10k 0 {C_RBL}
cref_op0_n100_nl_s1_r10k ref_op0_n100_nl_s1_r10k 0 {C_RBL}   $ ASSUMPTION: ideal matched dummy load
XMWR_op0_n100_nl_s1_r10k_0 sn_op0_n100_nl_s1_r10k_0 wwl_op0_n100_nl_s1_r10k wbl_op0_n100_nl_s1_r10k 0 sky130_fd_pr__nfet_01v8 L=0.15 W=0.42 nf=1 ad=0.1218 as=0.1218 pd=1.42 ps=1.42 nrd=0.69047619047619  nrs=0.69047619047619 sa=0 sb=0 sd=0 mult=1 m=1
XMRD_op0_n100_nl_s1_r10k_0 rbl_op0_n100_nl_s1_r10k sn_op0_n100_nl_s1_r10k_0 rwls_op0_n100_nl_s1_r10k 0 sky130_fd_pr__nfet_01v8 L=0.15 W=0.42 nf=1 ad=0.1218 as=0.1218 pd=1.42 ps=1.42 nrd=0.69047619047619  nrs=0.69047619047619 sa=0 sb=0 sd=0 mult=1 m=1
csn_op0_n100_nl_s1_r10k_0 sn_op0_n100_nl_s1_r10k_0 0 {C_SN}
XMWR_op0_n100_nl_s1_r10k_1 sn_op0_n100_nl_s1_r10k_1 wwl_des wbl_op0_n100_nl_s1_r10k 0 sky130_fd_pr__nfet_01v8 L=0.15 W=0.42 nf=1 ad=0.1218 as=0.1218 pd=1.42 ps=1.42 nrd=0.69047619047619  nrs=0.69047619047619 sa=0 sb=0 sd=0 mult=1 m=1
XMRD_op0_n100_nl_s1_r10k_1 rbl_op0_n100_nl_s1_r10k sn_op0_n100_nl_s1_r10k_1 rwl_des 0 sky130_fd_pr__nfet_01v8 L=0.15 W=0.42 nf=1 ad=0.1218 as=0.1218 pd=1.42 ps=1.42 nrd=0.69047619047619  nrs=0.69047619047619 sa=0 sb=0 sd=0 mult=1 m=1
csn_op0_n100_nl_s1_r10k_1 sn_op0_n100_nl_s1_r10k_1 0 {C_SN}
XMWR_op0_n100_nl_s1_r10k_2 sn_op0_n100_nl_s1_r10k_2 wwl_des wbl_op0_n100_nl_s1_r10k 0 sky130_fd_pr__nfet_01v8 L=0.15 W=0.42 nf=1 ad=0.1218 as=0.1218 pd=1.42 ps=1.42 nrd=0.69047619047619  nrs=0.69047619047619 sa=0 sb=0 sd=0 mult=1 m=1
XMRD_op0_n100_nl_s1_r10k_2 rbl_op0_n100_nl_s1_r10k sn_op0_n100_nl_s1_r10k_2 rwl_des 0 sky130_fd_pr__nfet_01v8 L=0.15 W=0.42 nf=1 ad=0.1218 as=0.1218 pd=1.42 ps=1.42 nrd=0.69047619047619  nrs=0.69047619047619 sa=0 sb=0 sd=0 mult=1 m=1
csn_op0_n100_nl_s1_r10k_2 sn_op0_n100_nl_s1_r10k_2 0 {C_SN}
XMWR_op0_n100_nl_s1_r10k_3 sn_op0_n100_nl_s1_r10k_3 wwl_des wbl_op0_n100_nl_s1_r10k 0 sky130_fd_pr__nfet_01v8 L=0.15 W=0.42 nf=1 ad=0.1218 as=0.1218 pd=1.42 ps=1.42 nrd=0.69047619047619  nrs=0.69047619047619 sa=0 sb=0 sd=0 mult=1 m=1
XMRD_op0_n100_nl_s1_r10k_3 rbl_op0_n100_nl_s1_r10k sn_op0_n100_nl_s1_r10k_3 rwl_des 0 sky130_fd_pr__nfet_01v8 L=0.15 W=0.42 nf=1 ad=0.1218 as=0.1218 pd=1.42 ps=1.42 nrd=0.69047619047619  nrs=0.69047619047619 sa=0 sb=0 sd=0 mult=1 m=1
csn_op0_n100_nl_s1_r10k_3 sn_op0_n100_nl_s1_r10k_3 0 {C_SN}
XMN1_op0_n100_nl_s1_r10k rbl_op0_n100_nl_s1_r10k ref_op0_n100_nl_s1_r10k vn_op0_n100_nl_s1_r10k 0 sky130_fd_pr__nfet_01v8 L=0.15 W=1 nf=1 ad=0.29 as=0.29 pd=2.58 ps=2.58 mult=1 m=1
XMN2_op0_n100_nl_s1_r10k ref_op0_n100_nl_s1_r10k rbl_op0_n100_nl_s1_r10k vn_op0_n100_nl_s1_r10k 0 sky130_fd_pr__nfet_01v8 L=0.15 W=1 nf=1 ad=0.29 as=0.29 pd=2.58 ps=2.58 mult=1 m=1
XMP1_op0_n100_nl_s1_r10k rbl_op0_n100_nl_s1_r10k ref_op0_n100_nl_s1_r10k vp_op0_n100_nl_s1_r10k vdd sky130_fd_pr__pfet_01v8 L=0.15 W=2 nf=1 ad=0.58 as=0.58 pd=4.58 ps=4.58 mult=1 m=1
XMP2_op0_n100_nl_s1_r10k ref_op0_n100_nl_s1_r10k rbl_op0_n100_nl_s1_r10k vp_op0_n100_nl_s1_r10k vdd sky130_fd_pr__pfet_01v8 L=0.15 W=2 nf=1 ad=0.58 as=0.58 pd=4.58 ps=4.58 mult=1 m=1
XMNF_op0_n100_nl_s1_r10k vn_op0_n100_nl_s1_r10k en_op0_n100_nl_s1_r10k 0 0 sky130_fd_pr__nfet_01v8 L=0.15 W=2 nf=1 ad=0.58 as=0.58 pd=4.58 ps=4.58 mult=1 m=1
XMPH_op0_n100_nl_s1_r10k vp_op0_n100_nl_s1_r10k enb_op0_n100_nl_s1_r10k vdd vdd sky130_fd_pr__pfet_01v8 L=0.15 W=4 nf=1 ad=1.16 as=1.16 pd=8.58 ps=8.58 mult=1 m=1
bd_op0_n100_nl_s1_r10k d_op0_n100_nl_s1_r10k 0 v=v(rbl_op0_n100_nl_s1_r10k)-v(ref_op0_n100_nl_s1_r10k)

* ---- instance 352: op0_0000_nl_s1_r10k (variant nl_s1_r10k; probe dec 11.9 ns, release 34 ns, meas 36 ns) ----
vctl_op0_0000_nl_s1_r10k ctl_op0_0000_nl_s1_r10k 0 pwl(0.0000e+00 {VDD} 2.0000e-09 {VDD} 2.1000e-09 0)
* RWL driver model (EXPERIMENTAL): slew 1 ns, series R 10000 ohm; cell pin = rwls_op0_0000_nl_s1_r10k
vrs_op0_0000_nl_s1_r10k rwlsrc_op0_0000_nl_s1_r10k 0 pwl(0.0000e+00 {VDD} 2.0000e-09 {VDD} 3.0000e-09 0 3.4000e-08 0 3.5000e-08 {VDD})
rdrv_op0_0000_nl_s1_r10k rwlsrc_op0_0000_nl_s1_r10k rwls_op0_0000_nl_s1_r10k 10000
ven_op0_0000_nl_s1_r10k en_op0_0000_nl_s1_r10k 0 pwl(0.0000e+00 0 1.1000e-08 0 1.1100e-08 {VDD} 3.4000e-08 {VDD} 3.4100e-08 0)
venb_op0_0000_nl_s1_r10k enb_op0_0000_nl_s1_r10k 0 pwl(0.0000e+00 {VDD} 1.1000e-08 {VDD} 1.1100e-08 0 3.4000e-08 0 3.4100e-08 {VDD})
vww_op0_0000_nl_s1_r10k wwl_op0_0000_nl_s1_r10k 0 pwl(0.0000e+00 0)
vwc_op0_0000_nl_s1_r10k wbc_op0_0000_nl_s1_r10k 0 pwl(0.0000e+00 0)
swb_op0_0000_nl_s1_r10k ref_op0_0000_nl_s1_r10k wbl_op0_0000_nl_s1_r10k wbc_op0_0000_nl_s1_r10k 0 swwbl
cwbl_op0_0000_nl_s1_r10k wbl_op0_0000_nl_s1_r10k 0 {C_WBL}
spa_op0_0000_nl_s1_r10k prea rbl_op0_0000_nl_s1_r10k ctl_op0_0000_nl_s1_r10k 0 swpre
spr_op0_0000_nl_s1_r10k pref ref_op0_0000_nl_s1_r10k ctl_op0_0000_nl_s1_r10k 0 swpre
crbl_op0_0000_nl_s1_r10k rbl_op0_0000_nl_s1_r10k 0 {C_RBL}
cref_op0_0000_nl_s1_r10k ref_op0_0000_nl_s1_r10k 0 {C_RBL}   $ ASSUMPTION: ideal matched dummy load
XMWR_op0_0000_nl_s1_r10k_0 sn_op0_0000_nl_s1_r10k_0 wwl_op0_0000_nl_s1_r10k wbl_op0_0000_nl_s1_r10k 0 sky130_fd_pr__nfet_01v8 L=0.15 W=0.42 nf=1 ad=0.1218 as=0.1218 pd=1.42 ps=1.42 nrd=0.69047619047619  nrs=0.69047619047619 sa=0 sb=0 sd=0 mult=1 m=1
XMRD_op0_0000_nl_s1_r10k_0 rbl_op0_0000_nl_s1_r10k sn_op0_0000_nl_s1_r10k_0 rwls_op0_0000_nl_s1_r10k 0 sky130_fd_pr__nfet_01v8 L=0.15 W=0.42 nf=1 ad=0.1218 as=0.1218 pd=1.42 ps=1.42 nrd=0.69047619047619  nrs=0.69047619047619 sa=0 sb=0 sd=0 mult=1 m=1
csn_op0_0000_nl_s1_r10k_0 sn_op0_0000_nl_s1_r10k_0 0 {C_SN}
XMWR_op0_0000_nl_s1_r10k_1 sn_op0_0000_nl_s1_r10k_1 wwl_des wbl_op0_0000_nl_s1_r10k 0 sky130_fd_pr__nfet_01v8 L=0.15 W=0.42 nf=1 ad=0.1218 as=0.1218 pd=1.42 ps=1.42 nrd=0.69047619047619  nrs=0.69047619047619 sa=0 sb=0 sd=0 mult=1 m=1
XMRD_op0_0000_nl_s1_r10k_1 rbl_op0_0000_nl_s1_r10k sn_op0_0000_nl_s1_r10k_1 rwl_des 0 sky130_fd_pr__nfet_01v8 L=0.15 W=0.42 nf=1 ad=0.1218 as=0.1218 pd=1.42 ps=1.42 nrd=0.69047619047619  nrs=0.69047619047619 sa=0 sb=0 sd=0 mult=1 m=1
csn_op0_0000_nl_s1_r10k_1 sn_op0_0000_nl_s1_r10k_1 0 {C_SN}
XMWR_op0_0000_nl_s1_r10k_2 sn_op0_0000_nl_s1_r10k_2 wwl_des wbl_op0_0000_nl_s1_r10k 0 sky130_fd_pr__nfet_01v8 L=0.15 W=0.42 nf=1 ad=0.1218 as=0.1218 pd=1.42 ps=1.42 nrd=0.69047619047619  nrs=0.69047619047619 sa=0 sb=0 sd=0 mult=1 m=1
XMRD_op0_0000_nl_s1_r10k_2 rbl_op0_0000_nl_s1_r10k sn_op0_0000_nl_s1_r10k_2 rwl_des 0 sky130_fd_pr__nfet_01v8 L=0.15 W=0.42 nf=1 ad=0.1218 as=0.1218 pd=1.42 ps=1.42 nrd=0.69047619047619  nrs=0.69047619047619 sa=0 sb=0 sd=0 mult=1 m=1
csn_op0_0000_nl_s1_r10k_2 sn_op0_0000_nl_s1_r10k_2 0 {C_SN}
XMWR_op0_0000_nl_s1_r10k_3 sn_op0_0000_nl_s1_r10k_3 wwl_des wbl_op0_0000_nl_s1_r10k 0 sky130_fd_pr__nfet_01v8 L=0.15 W=0.42 nf=1 ad=0.1218 as=0.1218 pd=1.42 ps=1.42 nrd=0.69047619047619  nrs=0.69047619047619 sa=0 sb=0 sd=0 mult=1 m=1
XMRD_op0_0000_nl_s1_r10k_3 rbl_op0_0000_nl_s1_r10k sn_op0_0000_nl_s1_r10k_3 rwl_des 0 sky130_fd_pr__nfet_01v8 L=0.15 W=0.42 nf=1 ad=0.1218 as=0.1218 pd=1.42 ps=1.42 nrd=0.69047619047619  nrs=0.69047619047619 sa=0 sb=0 sd=0 mult=1 m=1
csn_op0_0000_nl_s1_r10k_3 sn_op0_0000_nl_s1_r10k_3 0 {C_SN}
XMN1_op0_0000_nl_s1_r10k rbl_op0_0000_nl_s1_r10k ref_op0_0000_nl_s1_r10k vn_op0_0000_nl_s1_r10k 0 sky130_fd_pr__nfet_01v8 L=0.15 W=1 nf=1 ad=0.29 as=0.29 pd=2.58 ps=2.58 mult=1 m=1
XMN2_op0_0000_nl_s1_r10k ref_op0_0000_nl_s1_r10k rbl_op0_0000_nl_s1_r10k vn_op0_0000_nl_s1_r10k 0 sky130_fd_pr__nfet_01v8 L=0.15 W=1 nf=1 ad=0.29 as=0.29 pd=2.58 ps=2.58 mult=1 m=1
XMP1_op0_0000_nl_s1_r10k rbl_op0_0000_nl_s1_r10k ref_op0_0000_nl_s1_r10k vp_op0_0000_nl_s1_r10k vdd sky130_fd_pr__pfet_01v8 L=0.15 W=2 nf=1 ad=0.58 as=0.58 pd=4.58 ps=4.58 mult=1 m=1
XMP2_op0_0000_nl_s1_r10k ref_op0_0000_nl_s1_r10k rbl_op0_0000_nl_s1_r10k vp_op0_0000_nl_s1_r10k vdd sky130_fd_pr__pfet_01v8 L=0.15 W=2 nf=1 ad=0.58 as=0.58 pd=4.58 ps=4.58 mult=1 m=1
XMNF_op0_0000_nl_s1_r10k vn_op0_0000_nl_s1_r10k en_op0_0000_nl_s1_r10k 0 0 sky130_fd_pr__nfet_01v8 L=0.15 W=2 nf=1 ad=0.58 as=0.58 pd=4.58 ps=4.58 mult=1 m=1
XMPH_op0_0000_nl_s1_r10k vp_op0_0000_nl_s1_r10k enb_op0_0000_nl_s1_r10k vdd vdd sky130_fd_pr__pfet_01v8 L=0.15 W=4 nf=1 ad=1.16 as=1.16 pd=8.58 ps=8.58 mult=1 m=1
bd_op0_0000_nl_s1_r10k d_op0_0000_nl_s1_r10k 0 v=v(rbl_op0_0000_nl_s1_r10k)-v(ref_op0_0000_nl_s1_r10k)

* ---- instance 353: op1_0900_nr_s2_r100k (variant nr_s2_r100k; probe dec 11.9 ns, release 34 ns, meas 36 ns) ----
vctl_op1_0900_nr_s2_r100k ctl_op1_0900_nr_s2_r100k 0 pwl(0.0000e+00 {VDD} 2.0000e-09 {VDD} 2.1000e-09 0)
* RWL driver model (EXPERIMENTAL): slew 2 ns, series R 100000 ohm; cell pin = rwls_op1_0900_nr_s2_r100k
vrs_op1_0900_nr_s2_r100k rwlsrc_op1_0900_nr_s2_r100k 0 pwl(0.0000e+00 {VDD} 2.0000e-09 {VDD} 4.0000e-09 0 1.2000e-08 0 1.4000e-08 {VDD})
rdrv_op1_0900_nr_s2_r100k rwlsrc_op1_0900_nr_s2_r100k rwls_op1_0900_nr_s2_r100k 100000
ven_op1_0900_nr_s2_r100k en_op1_0900_nr_s2_r100k 0 pwl(0.0000e+00 0 1.1000e-08 0 1.1100e-08 {VDD} 3.4000e-08 {VDD} 3.4100e-08 0)
venb_op1_0900_nr_s2_r100k enb_op1_0900_nr_s2_r100k 0 pwl(0.0000e+00 {VDD} 1.1000e-08 {VDD} 1.1100e-08 0 3.4000e-08 0 3.4100e-08 {VDD})
vww_op1_0900_nr_s2_r100k wwl_op1_0900_nr_s2_r100k 0 pwl(0.0000e+00 0)
vwc_op1_0900_nr_s2_r100k wbc_op1_0900_nr_s2_r100k 0 pwl(0.0000e+00 0)
swb_op1_0900_nr_s2_r100k ref_op1_0900_nr_s2_r100k wbl_op1_0900_nr_s2_r100k wbc_op1_0900_nr_s2_r100k 0 swwbl
cwbl_op1_0900_nr_s2_r100k wbl_op1_0900_nr_s2_r100k 0 {C_WBL}
spa_op1_0900_nr_s2_r100k prea rbl_op1_0900_nr_s2_r100k ctl_op1_0900_nr_s2_r100k 0 swpre
spr_op1_0900_nr_s2_r100k pref ref_op1_0900_nr_s2_r100k ctl_op1_0900_nr_s2_r100k 0 swpre
crbl_op1_0900_nr_s2_r100k rbl_op1_0900_nr_s2_r100k 0 {C_RBL}
cref_op1_0900_nr_s2_r100k ref_op1_0900_nr_s2_r100k 0 {C_RBL}   $ ASSUMPTION: ideal matched dummy load
XMWR_op1_0900_nr_s2_r100k_0 sn_op1_0900_nr_s2_r100k_0 wwl_op1_0900_nr_s2_r100k wbl_op1_0900_nr_s2_r100k 0 sky130_fd_pr__nfet_01v8 L=0.15 W=0.42 nf=1 ad=0.1218 as=0.1218 pd=1.42 ps=1.42 nrd=0.69047619047619  nrs=0.69047619047619 sa=0 sb=0 sd=0 mult=1 m=1
XMRD_op1_0900_nr_s2_r100k_0 rbl_op1_0900_nr_s2_r100k sn_op1_0900_nr_s2_r100k_0 rwls_op1_0900_nr_s2_r100k 0 sky130_fd_pr__nfet_01v8 L=0.15 W=0.42 nf=1 ad=0.1218 as=0.1218 pd=1.42 ps=1.42 nrd=0.69047619047619  nrs=0.69047619047619 sa=0 sb=0 sd=0 mult=1 m=1
csn_op1_0900_nr_s2_r100k_0 sn_op1_0900_nr_s2_r100k_0 0 {C_SN}
XMWR_op1_0900_nr_s2_r100k_1 sn_op1_0900_nr_s2_r100k_1 wwl_des wbl_op1_0900_nr_s2_r100k 0 sky130_fd_pr__nfet_01v8 L=0.15 W=0.42 nf=1 ad=0.1218 as=0.1218 pd=1.42 ps=1.42 nrd=0.69047619047619  nrs=0.69047619047619 sa=0 sb=0 sd=0 mult=1 m=1
XMRD_op1_0900_nr_s2_r100k_1 rbl_op1_0900_nr_s2_r100k sn_op1_0900_nr_s2_r100k_1 rwl_des 0 sky130_fd_pr__nfet_01v8 L=0.15 W=0.42 nf=1 ad=0.1218 as=0.1218 pd=1.42 ps=1.42 nrd=0.69047619047619  nrs=0.69047619047619 sa=0 sb=0 sd=0 mult=1 m=1
csn_op1_0900_nr_s2_r100k_1 sn_op1_0900_nr_s2_r100k_1 0 {C_SN}
XMWR_op1_0900_nr_s2_r100k_2 sn_op1_0900_nr_s2_r100k_2 wwl_des wbl_op1_0900_nr_s2_r100k 0 sky130_fd_pr__nfet_01v8 L=0.15 W=0.42 nf=1 ad=0.1218 as=0.1218 pd=1.42 ps=1.42 nrd=0.69047619047619  nrs=0.69047619047619 sa=0 sb=0 sd=0 mult=1 m=1
XMRD_op1_0900_nr_s2_r100k_2 rbl_op1_0900_nr_s2_r100k sn_op1_0900_nr_s2_r100k_2 rwl_des 0 sky130_fd_pr__nfet_01v8 L=0.15 W=0.42 nf=1 ad=0.1218 as=0.1218 pd=1.42 ps=1.42 nrd=0.69047619047619  nrs=0.69047619047619 sa=0 sb=0 sd=0 mult=1 m=1
csn_op1_0900_nr_s2_r100k_2 sn_op1_0900_nr_s2_r100k_2 0 {C_SN}
XMWR_op1_0900_nr_s2_r100k_3 sn_op1_0900_nr_s2_r100k_3 wwl_des wbl_op1_0900_nr_s2_r100k 0 sky130_fd_pr__nfet_01v8 L=0.15 W=0.42 nf=1 ad=0.1218 as=0.1218 pd=1.42 ps=1.42 nrd=0.69047619047619  nrs=0.69047619047619 sa=0 sb=0 sd=0 mult=1 m=1
XMRD_op1_0900_nr_s2_r100k_3 rbl_op1_0900_nr_s2_r100k sn_op1_0900_nr_s2_r100k_3 rwl_des 0 sky130_fd_pr__nfet_01v8 L=0.15 W=0.42 nf=1 ad=0.1218 as=0.1218 pd=1.42 ps=1.42 nrd=0.69047619047619  nrs=0.69047619047619 sa=0 sb=0 sd=0 mult=1 m=1
csn_op1_0900_nr_s2_r100k_3 sn_op1_0900_nr_s2_r100k_3 0 {C_SN}
XMN1_op1_0900_nr_s2_r100k rbl_op1_0900_nr_s2_r100k ref_op1_0900_nr_s2_r100k vn_op1_0900_nr_s2_r100k 0 sky130_fd_pr__nfet_01v8 L=0.15 W=1 nf=1 ad=0.29 as=0.29 pd=2.58 ps=2.58 mult=1 m=1
XMN2_op1_0900_nr_s2_r100k ref_op1_0900_nr_s2_r100k rbl_op1_0900_nr_s2_r100k vn_op1_0900_nr_s2_r100k 0 sky130_fd_pr__nfet_01v8 L=0.15 W=1 nf=1 ad=0.29 as=0.29 pd=2.58 ps=2.58 mult=1 m=1
XMP1_op1_0900_nr_s2_r100k rbl_op1_0900_nr_s2_r100k ref_op1_0900_nr_s2_r100k vp_op1_0900_nr_s2_r100k vdd sky130_fd_pr__pfet_01v8 L=0.15 W=2 nf=1 ad=0.58 as=0.58 pd=4.58 ps=4.58 mult=1 m=1
XMP2_op1_0900_nr_s2_r100k ref_op1_0900_nr_s2_r100k rbl_op1_0900_nr_s2_r100k vp_op1_0900_nr_s2_r100k vdd sky130_fd_pr__pfet_01v8 L=0.15 W=2 nf=1 ad=0.58 as=0.58 pd=4.58 ps=4.58 mult=1 m=1
XMNF_op1_0900_nr_s2_r100k vn_op1_0900_nr_s2_r100k en_op1_0900_nr_s2_r100k 0 0 sky130_fd_pr__nfet_01v8 L=0.15 W=2 nf=1 ad=0.58 as=0.58 pd=4.58 ps=4.58 mult=1 m=1
XMPH_op1_0900_nr_s2_r100k vp_op1_0900_nr_s2_r100k enb_op1_0900_nr_s2_r100k vdd vdd sky130_fd_pr__pfet_01v8 L=0.15 W=4 nf=1 ad=1.16 as=1.16 pd=8.58 ps=8.58 mult=1 m=1
bd_op1_0900_nr_s2_r100k d_op1_0900_nr_s2_r100k 0 v=v(rbl_op1_0900_nr_s2_r100k)-v(ref_op1_0900_nr_s2_r100k)

* ---- instance 354: op1_1000_nr_s2_r100k (variant nr_s2_r100k; probe dec 11.9 ns, release 34 ns, meas 36 ns) ----
vctl_op1_1000_nr_s2_r100k ctl_op1_1000_nr_s2_r100k 0 pwl(0.0000e+00 {VDD} 2.0000e-09 {VDD} 2.1000e-09 0)
* RWL driver model (EXPERIMENTAL): slew 2 ns, series R 100000 ohm; cell pin = rwls_op1_1000_nr_s2_r100k
vrs_op1_1000_nr_s2_r100k rwlsrc_op1_1000_nr_s2_r100k 0 pwl(0.0000e+00 {VDD} 2.0000e-09 {VDD} 4.0000e-09 0 1.2000e-08 0 1.4000e-08 {VDD})
rdrv_op1_1000_nr_s2_r100k rwlsrc_op1_1000_nr_s2_r100k rwls_op1_1000_nr_s2_r100k 100000
ven_op1_1000_nr_s2_r100k en_op1_1000_nr_s2_r100k 0 pwl(0.0000e+00 0 1.1000e-08 0 1.1100e-08 {VDD} 3.4000e-08 {VDD} 3.4100e-08 0)
venb_op1_1000_nr_s2_r100k enb_op1_1000_nr_s2_r100k 0 pwl(0.0000e+00 {VDD} 1.1000e-08 {VDD} 1.1100e-08 0 3.4000e-08 0 3.4100e-08 {VDD})
vww_op1_1000_nr_s2_r100k wwl_op1_1000_nr_s2_r100k 0 pwl(0.0000e+00 0)
vwc_op1_1000_nr_s2_r100k wbc_op1_1000_nr_s2_r100k 0 pwl(0.0000e+00 0)
swb_op1_1000_nr_s2_r100k ref_op1_1000_nr_s2_r100k wbl_op1_1000_nr_s2_r100k wbc_op1_1000_nr_s2_r100k 0 swwbl
cwbl_op1_1000_nr_s2_r100k wbl_op1_1000_nr_s2_r100k 0 {C_WBL}
spa_op1_1000_nr_s2_r100k prea rbl_op1_1000_nr_s2_r100k ctl_op1_1000_nr_s2_r100k 0 swpre
spr_op1_1000_nr_s2_r100k pref ref_op1_1000_nr_s2_r100k ctl_op1_1000_nr_s2_r100k 0 swpre
crbl_op1_1000_nr_s2_r100k rbl_op1_1000_nr_s2_r100k 0 {C_RBL}
cref_op1_1000_nr_s2_r100k ref_op1_1000_nr_s2_r100k 0 {C_RBL}   $ ASSUMPTION: ideal matched dummy load
XMWR_op1_1000_nr_s2_r100k_0 sn_op1_1000_nr_s2_r100k_0 wwl_op1_1000_nr_s2_r100k wbl_op1_1000_nr_s2_r100k 0 sky130_fd_pr__nfet_01v8 L=0.15 W=0.42 nf=1 ad=0.1218 as=0.1218 pd=1.42 ps=1.42 nrd=0.69047619047619  nrs=0.69047619047619 sa=0 sb=0 sd=0 mult=1 m=1
XMRD_op1_1000_nr_s2_r100k_0 rbl_op1_1000_nr_s2_r100k sn_op1_1000_nr_s2_r100k_0 rwls_op1_1000_nr_s2_r100k 0 sky130_fd_pr__nfet_01v8 L=0.15 W=0.42 nf=1 ad=0.1218 as=0.1218 pd=1.42 ps=1.42 nrd=0.69047619047619  nrs=0.69047619047619 sa=0 sb=0 sd=0 mult=1 m=1
csn_op1_1000_nr_s2_r100k_0 sn_op1_1000_nr_s2_r100k_0 0 {C_SN}
XMWR_op1_1000_nr_s2_r100k_1 sn_op1_1000_nr_s2_r100k_1 wwl_des wbl_op1_1000_nr_s2_r100k 0 sky130_fd_pr__nfet_01v8 L=0.15 W=0.42 nf=1 ad=0.1218 as=0.1218 pd=1.42 ps=1.42 nrd=0.69047619047619  nrs=0.69047619047619 sa=0 sb=0 sd=0 mult=1 m=1
XMRD_op1_1000_nr_s2_r100k_1 rbl_op1_1000_nr_s2_r100k sn_op1_1000_nr_s2_r100k_1 rwl_des 0 sky130_fd_pr__nfet_01v8 L=0.15 W=0.42 nf=1 ad=0.1218 as=0.1218 pd=1.42 ps=1.42 nrd=0.69047619047619  nrs=0.69047619047619 sa=0 sb=0 sd=0 mult=1 m=1
csn_op1_1000_nr_s2_r100k_1 sn_op1_1000_nr_s2_r100k_1 0 {C_SN}
XMWR_op1_1000_nr_s2_r100k_2 sn_op1_1000_nr_s2_r100k_2 wwl_des wbl_op1_1000_nr_s2_r100k 0 sky130_fd_pr__nfet_01v8 L=0.15 W=0.42 nf=1 ad=0.1218 as=0.1218 pd=1.42 ps=1.42 nrd=0.69047619047619  nrs=0.69047619047619 sa=0 sb=0 sd=0 mult=1 m=1
XMRD_op1_1000_nr_s2_r100k_2 rbl_op1_1000_nr_s2_r100k sn_op1_1000_nr_s2_r100k_2 rwl_des 0 sky130_fd_pr__nfet_01v8 L=0.15 W=0.42 nf=1 ad=0.1218 as=0.1218 pd=1.42 ps=1.42 nrd=0.69047619047619  nrs=0.69047619047619 sa=0 sb=0 sd=0 mult=1 m=1
csn_op1_1000_nr_s2_r100k_2 sn_op1_1000_nr_s2_r100k_2 0 {C_SN}
XMWR_op1_1000_nr_s2_r100k_3 sn_op1_1000_nr_s2_r100k_3 wwl_des wbl_op1_1000_nr_s2_r100k 0 sky130_fd_pr__nfet_01v8 L=0.15 W=0.42 nf=1 ad=0.1218 as=0.1218 pd=1.42 ps=1.42 nrd=0.69047619047619  nrs=0.69047619047619 sa=0 sb=0 sd=0 mult=1 m=1
XMRD_op1_1000_nr_s2_r100k_3 rbl_op1_1000_nr_s2_r100k sn_op1_1000_nr_s2_r100k_3 rwl_des 0 sky130_fd_pr__nfet_01v8 L=0.15 W=0.42 nf=1 ad=0.1218 as=0.1218 pd=1.42 ps=1.42 nrd=0.69047619047619  nrs=0.69047619047619 sa=0 sb=0 sd=0 mult=1 m=1
csn_op1_1000_nr_s2_r100k_3 sn_op1_1000_nr_s2_r100k_3 0 {C_SN}
XMN1_op1_1000_nr_s2_r100k rbl_op1_1000_nr_s2_r100k ref_op1_1000_nr_s2_r100k vn_op1_1000_nr_s2_r100k 0 sky130_fd_pr__nfet_01v8 L=0.15 W=1 nf=1 ad=0.29 as=0.29 pd=2.58 ps=2.58 mult=1 m=1
XMN2_op1_1000_nr_s2_r100k ref_op1_1000_nr_s2_r100k rbl_op1_1000_nr_s2_r100k vn_op1_1000_nr_s2_r100k 0 sky130_fd_pr__nfet_01v8 L=0.15 W=1 nf=1 ad=0.29 as=0.29 pd=2.58 ps=2.58 mult=1 m=1
XMP1_op1_1000_nr_s2_r100k rbl_op1_1000_nr_s2_r100k ref_op1_1000_nr_s2_r100k vp_op1_1000_nr_s2_r100k vdd sky130_fd_pr__pfet_01v8 L=0.15 W=2 nf=1 ad=0.58 as=0.58 pd=4.58 ps=4.58 mult=1 m=1
XMP2_op1_1000_nr_s2_r100k ref_op1_1000_nr_s2_r100k rbl_op1_1000_nr_s2_r100k vp_op1_1000_nr_s2_r100k vdd sky130_fd_pr__pfet_01v8 L=0.15 W=2 nf=1 ad=0.58 as=0.58 pd=4.58 ps=4.58 mult=1 m=1
XMNF_op1_1000_nr_s2_r100k vn_op1_1000_nr_s2_r100k en_op1_1000_nr_s2_r100k 0 0 sky130_fd_pr__nfet_01v8 L=0.15 W=2 nf=1 ad=0.58 as=0.58 pd=4.58 ps=4.58 mult=1 m=1
XMPH_op1_1000_nr_s2_r100k vp_op1_1000_nr_s2_r100k enb_op1_1000_nr_s2_r100k vdd vdd sky130_fd_pr__pfet_01v8 L=0.15 W=4 nf=1 ad=1.16 as=1.16 pd=8.58 ps=8.58 mult=1 m=1
bd_op1_1000_nr_s2_r100k d_op1_1000_nr_s2_r100k 0 v=v(rbl_op1_1000_nr_s2_r100k)-v(ref_op1_1000_nr_s2_r100k)

* ---- instance 355: op0_n100_nr_s2_r100k (variant nr_s2_r100k; probe dec 11.9 ns, release 34 ns, meas 36 ns) ----
vctl_op0_n100_nr_s2_r100k ctl_op0_n100_nr_s2_r100k 0 pwl(0.0000e+00 {VDD} 2.0000e-09 {VDD} 2.1000e-09 0)
* RWL driver model (EXPERIMENTAL): slew 2 ns, series R 100000 ohm; cell pin = rwls_op0_n100_nr_s2_r100k
vrs_op0_n100_nr_s2_r100k rwlsrc_op0_n100_nr_s2_r100k 0 pwl(0.0000e+00 {VDD} 2.0000e-09 {VDD} 4.0000e-09 0 1.2000e-08 0 1.4000e-08 {VDD})
rdrv_op0_n100_nr_s2_r100k rwlsrc_op0_n100_nr_s2_r100k rwls_op0_n100_nr_s2_r100k 100000
ven_op0_n100_nr_s2_r100k en_op0_n100_nr_s2_r100k 0 pwl(0.0000e+00 0 1.1000e-08 0 1.1100e-08 {VDD} 3.4000e-08 {VDD} 3.4100e-08 0)
venb_op0_n100_nr_s2_r100k enb_op0_n100_nr_s2_r100k 0 pwl(0.0000e+00 {VDD} 1.1000e-08 {VDD} 1.1100e-08 0 3.4000e-08 0 3.4100e-08 {VDD})
vww_op0_n100_nr_s2_r100k wwl_op0_n100_nr_s2_r100k 0 pwl(0.0000e+00 0)
vwc_op0_n100_nr_s2_r100k wbc_op0_n100_nr_s2_r100k 0 pwl(0.0000e+00 0)
swb_op0_n100_nr_s2_r100k ref_op0_n100_nr_s2_r100k wbl_op0_n100_nr_s2_r100k wbc_op0_n100_nr_s2_r100k 0 swwbl
cwbl_op0_n100_nr_s2_r100k wbl_op0_n100_nr_s2_r100k 0 {C_WBL}
spa_op0_n100_nr_s2_r100k prea rbl_op0_n100_nr_s2_r100k ctl_op0_n100_nr_s2_r100k 0 swpre
spr_op0_n100_nr_s2_r100k pref ref_op0_n100_nr_s2_r100k ctl_op0_n100_nr_s2_r100k 0 swpre
crbl_op0_n100_nr_s2_r100k rbl_op0_n100_nr_s2_r100k 0 {C_RBL}
cref_op0_n100_nr_s2_r100k ref_op0_n100_nr_s2_r100k 0 {C_RBL}   $ ASSUMPTION: ideal matched dummy load
XMWR_op0_n100_nr_s2_r100k_0 sn_op0_n100_nr_s2_r100k_0 wwl_op0_n100_nr_s2_r100k wbl_op0_n100_nr_s2_r100k 0 sky130_fd_pr__nfet_01v8 L=0.15 W=0.42 nf=1 ad=0.1218 as=0.1218 pd=1.42 ps=1.42 nrd=0.69047619047619  nrs=0.69047619047619 sa=0 sb=0 sd=0 mult=1 m=1
XMRD_op0_n100_nr_s2_r100k_0 rbl_op0_n100_nr_s2_r100k sn_op0_n100_nr_s2_r100k_0 rwls_op0_n100_nr_s2_r100k 0 sky130_fd_pr__nfet_01v8 L=0.15 W=0.42 nf=1 ad=0.1218 as=0.1218 pd=1.42 ps=1.42 nrd=0.69047619047619  nrs=0.69047619047619 sa=0 sb=0 sd=0 mult=1 m=1
csn_op0_n100_nr_s2_r100k_0 sn_op0_n100_nr_s2_r100k_0 0 {C_SN}
XMWR_op0_n100_nr_s2_r100k_1 sn_op0_n100_nr_s2_r100k_1 wwl_des wbl_op0_n100_nr_s2_r100k 0 sky130_fd_pr__nfet_01v8 L=0.15 W=0.42 nf=1 ad=0.1218 as=0.1218 pd=1.42 ps=1.42 nrd=0.69047619047619  nrs=0.69047619047619 sa=0 sb=0 sd=0 mult=1 m=1
XMRD_op0_n100_nr_s2_r100k_1 rbl_op0_n100_nr_s2_r100k sn_op0_n100_nr_s2_r100k_1 rwl_des 0 sky130_fd_pr__nfet_01v8 L=0.15 W=0.42 nf=1 ad=0.1218 as=0.1218 pd=1.42 ps=1.42 nrd=0.69047619047619  nrs=0.69047619047619 sa=0 sb=0 sd=0 mult=1 m=1
csn_op0_n100_nr_s2_r100k_1 sn_op0_n100_nr_s2_r100k_1 0 {C_SN}
XMWR_op0_n100_nr_s2_r100k_2 sn_op0_n100_nr_s2_r100k_2 wwl_des wbl_op0_n100_nr_s2_r100k 0 sky130_fd_pr__nfet_01v8 L=0.15 W=0.42 nf=1 ad=0.1218 as=0.1218 pd=1.42 ps=1.42 nrd=0.69047619047619  nrs=0.69047619047619 sa=0 sb=0 sd=0 mult=1 m=1
XMRD_op0_n100_nr_s2_r100k_2 rbl_op0_n100_nr_s2_r100k sn_op0_n100_nr_s2_r100k_2 rwl_des 0 sky130_fd_pr__nfet_01v8 L=0.15 W=0.42 nf=1 ad=0.1218 as=0.1218 pd=1.42 ps=1.42 nrd=0.69047619047619  nrs=0.69047619047619 sa=0 sb=0 sd=0 mult=1 m=1
csn_op0_n100_nr_s2_r100k_2 sn_op0_n100_nr_s2_r100k_2 0 {C_SN}
XMWR_op0_n100_nr_s2_r100k_3 sn_op0_n100_nr_s2_r100k_3 wwl_des wbl_op0_n100_nr_s2_r100k 0 sky130_fd_pr__nfet_01v8 L=0.15 W=0.42 nf=1 ad=0.1218 as=0.1218 pd=1.42 ps=1.42 nrd=0.69047619047619  nrs=0.69047619047619 sa=0 sb=0 sd=0 mult=1 m=1
XMRD_op0_n100_nr_s2_r100k_3 rbl_op0_n100_nr_s2_r100k sn_op0_n100_nr_s2_r100k_3 rwl_des 0 sky130_fd_pr__nfet_01v8 L=0.15 W=0.42 nf=1 ad=0.1218 as=0.1218 pd=1.42 ps=1.42 nrd=0.69047619047619  nrs=0.69047619047619 sa=0 sb=0 sd=0 mult=1 m=1
csn_op0_n100_nr_s2_r100k_3 sn_op0_n100_nr_s2_r100k_3 0 {C_SN}
XMN1_op0_n100_nr_s2_r100k rbl_op0_n100_nr_s2_r100k ref_op0_n100_nr_s2_r100k vn_op0_n100_nr_s2_r100k 0 sky130_fd_pr__nfet_01v8 L=0.15 W=1 nf=1 ad=0.29 as=0.29 pd=2.58 ps=2.58 mult=1 m=1
XMN2_op0_n100_nr_s2_r100k ref_op0_n100_nr_s2_r100k rbl_op0_n100_nr_s2_r100k vn_op0_n100_nr_s2_r100k 0 sky130_fd_pr__nfet_01v8 L=0.15 W=1 nf=1 ad=0.29 as=0.29 pd=2.58 ps=2.58 mult=1 m=1
XMP1_op0_n100_nr_s2_r100k rbl_op0_n100_nr_s2_r100k ref_op0_n100_nr_s2_r100k vp_op0_n100_nr_s2_r100k vdd sky130_fd_pr__pfet_01v8 L=0.15 W=2 nf=1 ad=0.58 as=0.58 pd=4.58 ps=4.58 mult=1 m=1
XMP2_op0_n100_nr_s2_r100k ref_op0_n100_nr_s2_r100k rbl_op0_n100_nr_s2_r100k vp_op0_n100_nr_s2_r100k vdd sky130_fd_pr__pfet_01v8 L=0.15 W=2 nf=1 ad=0.58 as=0.58 pd=4.58 ps=4.58 mult=1 m=1
XMNF_op0_n100_nr_s2_r100k vn_op0_n100_nr_s2_r100k en_op0_n100_nr_s2_r100k 0 0 sky130_fd_pr__nfet_01v8 L=0.15 W=2 nf=1 ad=0.58 as=0.58 pd=4.58 ps=4.58 mult=1 m=1
XMPH_op0_n100_nr_s2_r100k vp_op0_n100_nr_s2_r100k enb_op0_n100_nr_s2_r100k vdd vdd sky130_fd_pr__pfet_01v8 L=0.15 W=4 nf=1 ad=1.16 as=1.16 pd=8.58 ps=8.58 mult=1 m=1
bd_op0_n100_nr_s2_r100k d_op0_n100_nr_s2_r100k 0 v=v(rbl_op0_n100_nr_s2_r100k)-v(ref_op0_n100_nr_s2_r100k)

* ---- instance 356: op0_0000_nr_s2_r100k (variant nr_s2_r100k; probe dec 11.9 ns, release 34 ns, meas 36 ns) ----
vctl_op0_0000_nr_s2_r100k ctl_op0_0000_nr_s2_r100k 0 pwl(0.0000e+00 {VDD} 2.0000e-09 {VDD} 2.1000e-09 0)
* RWL driver model (EXPERIMENTAL): slew 2 ns, series R 100000 ohm; cell pin = rwls_op0_0000_nr_s2_r100k
vrs_op0_0000_nr_s2_r100k rwlsrc_op0_0000_nr_s2_r100k 0 pwl(0.0000e+00 {VDD} 2.0000e-09 {VDD} 4.0000e-09 0 1.2000e-08 0 1.4000e-08 {VDD})
rdrv_op0_0000_nr_s2_r100k rwlsrc_op0_0000_nr_s2_r100k rwls_op0_0000_nr_s2_r100k 100000
ven_op0_0000_nr_s2_r100k en_op0_0000_nr_s2_r100k 0 pwl(0.0000e+00 0 1.1000e-08 0 1.1100e-08 {VDD} 3.4000e-08 {VDD} 3.4100e-08 0)
venb_op0_0000_nr_s2_r100k enb_op0_0000_nr_s2_r100k 0 pwl(0.0000e+00 {VDD} 1.1000e-08 {VDD} 1.1100e-08 0 3.4000e-08 0 3.4100e-08 {VDD})
vww_op0_0000_nr_s2_r100k wwl_op0_0000_nr_s2_r100k 0 pwl(0.0000e+00 0)
vwc_op0_0000_nr_s2_r100k wbc_op0_0000_nr_s2_r100k 0 pwl(0.0000e+00 0)
swb_op0_0000_nr_s2_r100k ref_op0_0000_nr_s2_r100k wbl_op0_0000_nr_s2_r100k wbc_op0_0000_nr_s2_r100k 0 swwbl
cwbl_op0_0000_nr_s2_r100k wbl_op0_0000_nr_s2_r100k 0 {C_WBL}
spa_op0_0000_nr_s2_r100k prea rbl_op0_0000_nr_s2_r100k ctl_op0_0000_nr_s2_r100k 0 swpre
spr_op0_0000_nr_s2_r100k pref ref_op0_0000_nr_s2_r100k ctl_op0_0000_nr_s2_r100k 0 swpre
crbl_op0_0000_nr_s2_r100k rbl_op0_0000_nr_s2_r100k 0 {C_RBL}
cref_op0_0000_nr_s2_r100k ref_op0_0000_nr_s2_r100k 0 {C_RBL}   $ ASSUMPTION: ideal matched dummy load
XMWR_op0_0000_nr_s2_r100k_0 sn_op0_0000_nr_s2_r100k_0 wwl_op0_0000_nr_s2_r100k wbl_op0_0000_nr_s2_r100k 0 sky130_fd_pr__nfet_01v8 L=0.15 W=0.42 nf=1 ad=0.1218 as=0.1218 pd=1.42 ps=1.42 nrd=0.69047619047619  nrs=0.69047619047619 sa=0 sb=0 sd=0 mult=1 m=1
XMRD_op0_0000_nr_s2_r100k_0 rbl_op0_0000_nr_s2_r100k sn_op0_0000_nr_s2_r100k_0 rwls_op0_0000_nr_s2_r100k 0 sky130_fd_pr__nfet_01v8 L=0.15 W=0.42 nf=1 ad=0.1218 as=0.1218 pd=1.42 ps=1.42 nrd=0.69047619047619  nrs=0.69047619047619 sa=0 sb=0 sd=0 mult=1 m=1
csn_op0_0000_nr_s2_r100k_0 sn_op0_0000_nr_s2_r100k_0 0 {C_SN}
XMWR_op0_0000_nr_s2_r100k_1 sn_op0_0000_nr_s2_r100k_1 wwl_des wbl_op0_0000_nr_s2_r100k 0 sky130_fd_pr__nfet_01v8 L=0.15 W=0.42 nf=1 ad=0.1218 as=0.1218 pd=1.42 ps=1.42 nrd=0.69047619047619  nrs=0.69047619047619 sa=0 sb=0 sd=0 mult=1 m=1
XMRD_op0_0000_nr_s2_r100k_1 rbl_op0_0000_nr_s2_r100k sn_op0_0000_nr_s2_r100k_1 rwl_des 0 sky130_fd_pr__nfet_01v8 L=0.15 W=0.42 nf=1 ad=0.1218 as=0.1218 pd=1.42 ps=1.42 nrd=0.69047619047619  nrs=0.69047619047619 sa=0 sb=0 sd=0 mult=1 m=1
csn_op0_0000_nr_s2_r100k_1 sn_op0_0000_nr_s2_r100k_1 0 {C_SN}
XMWR_op0_0000_nr_s2_r100k_2 sn_op0_0000_nr_s2_r100k_2 wwl_des wbl_op0_0000_nr_s2_r100k 0 sky130_fd_pr__nfet_01v8 L=0.15 W=0.42 nf=1 ad=0.1218 as=0.1218 pd=1.42 ps=1.42 nrd=0.69047619047619  nrs=0.69047619047619 sa=0 sb=0 sd=0 mult=1 m=1
XMRD_op0_0000_nr_s2_r100k_2 rbl_op0_0000_nr_s2_r100k sn_op0_0000_nr_s2_r100k_2 rwl_des 0 sky130_fd_pr__nfet_01v8 L=0.15 W=0.42 nf=1 ad=0.1218 as=0.1218 pd=1.42 ps=1.42 nrd=0.69047619047619  nrs=0.69047619047619 sa=0 sb=0 sd=0 mult=1 m=1
csn_op0_0000_nr_s2_r100k_2 sn_op0_0000_nr_s2_r100k_2 0 {C_SN}
XMWR_op0_0000_nr_s2_r100k_3 sn_op0_0000_nr_s2_r100k_3 wwl_des wbl_op0_0000_nr_s2_r100k 0 sky130_fd_pr__nfet_01v8 L=0.15 W=0.42 nf=1 ad=0.1218 as=0.1218 pd=1.42 ps=1.42 nrd=0.69047619047619  nrs=0.69047619047619 sa=0 sb=0 sd=0 mult=1 m=1
XMRD_op0_0000_nr_s2_r100k_3 rbl_op0_0000_nr_s2_r100k sn_op0_0000_nr_s2_r100k_3 rwl_des 0 sky130_fd_pr__nfet_01v8 L=0.15 W=0.42 nf=1 ad=0.1218 as=0.1218 pd=1.42 ps=1.42 nrd=0.69047619047619  nrs=0.69047619047619 sa=0 sb=0 sd=0 mult=1 m=1
csn_op0_0000_nr_s2_r100k_3 sn_op0_0000_nr_s2_r100k_3 0 {C_SN}
XMN1_op0_0000_nr_s2_r100k rbl_op0_0000_nr_s2_r100k ref_op0_0000_nr_s2_r100k vn_op0_0000_nr_s2_r100k 0 sky130_fd_pr__nfet_01v8 L=0.15 W=1 nf=1 ad=0.29 as=0.29 pd=2.58 ps=2.58 mult=1 m=1
XMN2_op0_0000_nr_s2_r100k ref_op0_0000_nr_s2_r100k rbl_op0_0000_nr_s2_r100k vn_op0_0000_nr_s2_r100k 0 sky130_fd_pr__nfet_01v8 L=0.15 W=1 nf=1 ad=0.29 as=0.29 pd=2.58 ps=2.58 mult=1 m=1
XMP1_op0_0000_nr_s2_r100k rbl_op0_0000_nr_s2_r100k ref_op0_0000_nr_s2_r100k vp_op0_0000_nr_s2_r100k vdd sky130_fd_pr__pfet_01v8 L=0.15 W=2 nf=1 ad=0.58 as=0.58 pd=4.58 ps=4.58 mult=1 m=1
XMP2_op0_0000_nr_s2_r100k ref_op0_0000_nr_s2_r100k rbl_op0_0000_nr_s2_r100k vp_op0_0000_nr_s2_r100k vdd sky130_fd_pr__pfet_01v8 L=0.15 W=2 nf=1 ad=0.58 as=0.58 pd=4.58 ps=4.58 mult=1 m=1
XMNF_op0_0000_nr_s2_r100k vn_op0_0000_nr_s2_r100k en_op0_0000_nr_s2_r100k 0 0 sky130_fd_pr__nfet_01v8 L=0.15 W=2 nf=1 ad=0.58 as=0.58 pd=4.58 ps=4.58 mult=1 m=1
XMPH_op0_0000_nr_s2_r100k vp_op0_0000_nr_s2_r100k enb_op0_0000_nr_s2_r100k vdd vdd sky130_fd_pr__pfet_01v8 L=0.15 W=4 nf=1 ad=1.16 as=1.16 pd=8.58 ps=8.58 mult=1 m=1
bd_op0_0000_nr_s2_r100k d_op0_0000_nr_s2_r100k 0 v=v(rbl_op0_0000_nr_s2_r100k)-v(ref_op0_0000_nr_s2_r100k)

* ---- instance 357: op1_0900_nl_s2_r100k (variant nl_s2_r100k; probe dec 11.9 ns, release 34 ns, meas 36 ns) ----
vctl_op1_0900_nl_s2_r100k ctl_op1_0900_nl_s2_r100k 0 pwl(0.0000e+00 {VDD} 2.0000e-09 {VDD} 2.1000e-09 0)
* RWL driver model (EXPERIMENTAL): slew 2 ns, series R 100000 ohm; cell pin = rwls_op1_0900_nl_s2_r100k
vrs_op1_0900_nl_s2_r100k rwlsrc_op1_0900_nl_s2_r100k 0 pwl(0.0000e+00 {VDD} 2.0000e-09 {VDD} 4.0000e-09 0 3.4000e-08 0 3.6000e-08 {VDD})
rdrv_op1_0900_nl_s2_r100k rwlsrc_op1_0900_nl_s2_r100k rwls_op1_0900_nl_s2_r100k 100000
ven_op1_0900_nl_s2_r100k en_op1_0900_nl_s2_r100k 0 pwl(0.0000e+00 0 1.1000e-08 0 1.1100e-08 {VDD} 3.4000e-08 {VDD} 3.4100e-08 0)
venb_op1_0900_nl_s2_r100k enb_op1_0900_nl_s2_r100k 0 pwl(0.0000e+00 {VDD} 1.1000e-08 {VDD} 1.1100e-08 0 3.4000e-08 0 3.4100e-08 {VDD})
vww_op1_0900_nl_s2_r100k wwl_op1_0900_nl_s2_r100k 0 pwl(0.0000e+00 0)
vwc_op1_0900_nl_s2_r100k wbc_op1_0900_nl_s2_r100k 0 pwl(0.0000e+00 0)
swb_op1_0900_nl_s2_r100k ref_op1_0900_nl_s2_r100k wbl_op1_0900_nl_s2_r100k wbc_op1_0900_nl_s2_r100k 0 swwbl
cwbl_op1_0900_nl_s2_r100k wbl_op1_0900_nl_s2_r100k 0 {C_WBL}
spa_op1_0900_nl_s2_r100k prea rbl_op1_0900_nl_s2_r100k ctl_op1_0900_nl_s2_r100k 0 swpre
spr_op1_0900_nl_s2_r100k pref ref_op1_0900_nl_s2_r100k ctl_op1_0900_nl_s2_r100k 0 swpre
crbl_op1_0900_nl_s2_r100k rbl_op1_0900_nl_s2_r100k 0 {C_RBL}
cref_op1_0900_nl_s2_r100k ref_op1_0900_nl_s2_r100k 0 {C_RBL}   $ ASSUMPTION: ideal matched dummy load
XMWR_op1_0900_nl_s2_r100k_0 sn_op1_0900_nl_s2_r100k_0 wwl_op1_0900_nl_s2_r100k wbl_op1_0900_nl_s2_r100k 0 sky130_fd_pr__nfet_01v8 L=0.15 W=0.42 nf=1 ad=0.1218 as=0.1218 pd=1.42 ps=1.42 nrd=0.69047619047619  nrs=0.69047619047619 sa=0 sb=0 sd=0 mult=1 m=1
XMRD_op1_0900_nl_s2_r100k_0 rbl_op1_0900_nl_s2_r100k sn_op1_0900_nl_s2_r100k_0 rwls_op1_0900_nl_s2_r100k 0 sky130_fd_pr__nfet_01v8 L=0.15 W=0.42 nf=1 ad=0.1218 as=0.1218 pd=1.42 ps=1.42 nrd=0.69047619047619  nrs=0.69047619047619 sa=0 sb=0 sd=0 mult=1 m=1
csn_op1_0900_nl_s2_r100k_0 sn_op1_0900_nl_s2_r100k_0 0 {C_SN}
XMWR_op1_0900_nl_s2_r100k_1 sn_op1_0900_nl_s2_r100k_1 wwl_des wbl_op1_0900_nl_s2_r100k 0 sky130_fd_pr__nfet_01v8 L=0.15 W=0.42 nf=1 ad=0.1218 as=0.1218 pd=1.42 ps=1.42 nrd=0.69047619047619  nrs=0.69047619047619 sa=0 sb=0 sd=0 mult=1 m=1
XMRD_op1_0900_nl_s2_r100k_1 rbl_op1_0900_nl_s2_r100k sn_op1_0900_nl_s2_r100k_1 rwl_des 0 sky130_fd_pr__nfet_01v8 L=0.15 W=0.42 nf=1 ad=0.1218 as=0.1218 pd=1.42 ps=1.42 nrd=0.69047619047619  nrs=0.69047619047619 sa=0 sb=0 sd=0 mult=1 m=1
csn_op1_0900_nl_s2_r100k_1 sn_op1_0900_nl_s2_r100k_1 0 {C_SN}
XMWR_op1_0900_nl_s2_r100k_2 sn_op1_0900_nl_s2_r100k_2 wwl_des wbl_op1_0900_nl_s2_r100k 0 sky130_fd_pr__nfet_01v8 L=0.15 W=0.42 nf=1 ad=0.1218 as=0.1218 pd=1.42 ps=1.42 nrd=0.69047619047619  nrs=0.69047619047619 sa=0 sb=0 sd=0 mult=1 m=1
XMRD_op1_0900_nl_s2_r100k_2 rbl_op1_0900_nl_s2_r100k sn_op1_0900_nl_s2_r100k_2 rwl_des 0 sky130_fd_pr__nfet_01v8 L=0.15 W=0.42 nf=1 ad=0.1218 as=0.1218 pd=1.42 ps=1.42 nrd=0.69047619047619  nrs=0.69047619047619 sa=0 sb=0 sd=0 mult=1 m=1
csn_op1_0900_nl_s2_r100k_2 sn_op1_0900_nl_s2_r100k_2 0 {C_SN}
XMWR_op1_0900_nl_s2_r100k_3 sn_op1_0900_nl_s2_r100k_3 wwl_des wbl_op1_0900_nl_s2_r100k 0 sky130_fd_pr__nfet_01v8 L=0.15 W=0.42 nf=1 ad=0.1218 as=0.1218 pd=1.42 ps=1.42 nrd=0.69047619047619  nrs=0.69047619047619 sa=0 sb=0 sd=0 mult=1 m=1
XMRD_op1_0900_nl_s2_r100k_3 rbl_op1_0900_nl_s2_r100k sn_op1_0900_nl_s2_r100k_3 rwl_des 0 sky130_fd_pr__nfet_01v8 L=0.15 W=0.42 nf=1 ad=0.1218 as=0.1218 pd=1.42 ps=1.42 nrd=0.69047619047619  nrs=0.69047619047619 sa=0 sb=0 sd=0 mult=1 m=1
csn_op1_0900_nl_s2_r100k_3 sn_op1_0900_nl_s2_r100k_3 0 {C_SN}
XMN1_op1_0900_nl_s2_r100k rbl_op1_0900_nl_s2_r100k ref_op1_0900_nl_s2_r100k vn_op1_0900_nl_s2_r100k 0 sky130_fd_pr__nfet_01v8 L=0.15 W=1 nf=1 ad=0.29 as=0.29 pd=2.58 ps=2.58 mult=1 m=1
XMN2_op1_0900_nl_s2_r100k ref_op1_0900_nl_s2_r100k rbl_op1_0900_nl_s2_r100k vn_op1_0900_nl_s2_r100k 0 sky130_fd_pr__nfet_01v8 L=0.15 W=1 nf=1 ad=0.29 as=0.29 pd=2.58 ps=2.58 mult=1 m=1
XMP1_op1_0900_nl_s2_r100k rbl_op1_0900_nl_s2_r100k ref_op1_0900_nl_s2_r100k vp_op1_0900_nl_s2_r100k vdd sky130_fd_pr__pfet_01v8 L=0.15 W=2 nf=1 ad=0.58 as=0.58 pd=4.58 ps=4.58 mult=1 m=1
XMP2_op1_0900_nl_s2_r100k ref_op1_0900_nl_s2_r100k rbl_op1_0900_nl_s2_r100k vp_op1_0900_nl_s2_r100k vdd sky130_fd_pr__pfet_01v8 L=0.15 W=2 nf=1 ad=0.58 as=0.58 pd=4.58 ps=4.58 mult=1 m=1
XMNF_op1_0900_nl_s2_r100k vn_op1_0900_nl_s2_r100k en_op1_0900_nl_s2_r100k 0 0 sky130_fd_pr__nfet_01v8 L=0.15 W=2 nf=1 ad=0.58 as=0.58 pd=4.58 ps=4.58 mult=1 m=1
XMPH_op1_0900_nl_s2_r100k vp_op1_0900_nl_s2_r100k enb_op1_0900_nl_s2_r100k vdd vdd sky130_fd_pr__pfet_01v8 L=0.15 W=4 nf=1 ad=1.16 as=1.16 pd=8.58 ps=8.58 mult=1 m=1
bd_op1_0900_nl_s2_r100k d_op1_0900_nl_s2_r100k 0 v=v(rbl_op1_0900_nl_s2_r100k)-v(ref_op1_0900_nl_s2_r100k)

* ---- instance 358: op1_1000_nl_s2_r100k (variant nl_s2_r100k; probe dec 11.9 ns, release 34 ns, meas 36 ns) ----
vctl_op1_1000_nl_s2_r100k ctl_op1_1000_nl_s2_r100k 0 pwl(0.0000e+00 {VDD} 2.0000e-09 {VDD} 2.1000e-09 0)
* RWL driver model (EXPERIMENTAL): slew 2 ns, series R 100000 ohm; cell pin = rwls_op1_1000_nl_s2_r100k
vrs_op1_1000_nl_s2_r100k rwlsrc_op1_1000_nl_s2_r100k 0 pwl(0.0000e+00 {VDD} 2.0000e-09 {VDD} 4.0000e-09 0 3.4000e-08 0 3.6000e-08 {VDD})
rdrv_op1_1000_nl_s2_r100k rwlsrc_op1_1000_nl_s2_r100k rwls_op1_1000_nl_s2_r100k 100000
ven_op1_1000_nl_s2_r100k en_op1_1000_nl_s2_r100k 0 pwl(0.0000e+00 0 1.1000e-08 0 1.1100e-08 {VDD} 3.4000e-08 {VDD} 3.4100e-08 0)
venb_op1_1000_nl_s2_r100k enb_op1_1000_nl_s2_r100k 0 pwl(0.0000e+00 {VDD} 1.1000e-08 {VDD} 1.1100e-08 0 3.4000e-08 0 3.4100e-08 {VDD})
vww_op1_1000_nl_s2_r100k wwl_op1_1000_nl_s2_r100k 0 pwl(0.0000e+00 0)
vwc_op1_1000_nl_s2_r100k wbc_op1_1000_nl_s2_r100k 0 pwl(0.0000e+00 0)
swb_op1_1000_nl_s2_r100k ref_op1_1000_nl_s2_r100k wbl_op1_1000_nl_s2_r100k wbc_op1_1000_nl_s2_r100k 0 swwbl
cwbl_op1_1000_nl_s2_r100k wbl_op1_1000_nl_s2_r100k 0 {C_WBL}
spa_op1_1000_nl_s2_r100k prea rbl_op1_1000_nl_s2_r100k ctl_op1_1000_nl_s2_r100k 0 swpre
spr_op1_1000_nl_s2_r100k pref ref_op1_1000_nl_s2_r100k ctl_op1_1000_nl_s2_r100k 0 swpre
crbl_op1_1000_nl_s2_r100k rbl_op1_1000_nl_s2_r100k 0 {C_RBL}
cref_op1_1000_nl_s2_r100k ref_op1_1000_nl_s2_r100k 0 {C_RBL}   $ ASSUMPTION: ideal matched dummy load
XMWR_op1_1000_nl_s2_r100k_0 sn_op1_1000_nl_s2_r100k_0 wwl_op1_1000_nl_s2_r100k wbl_op1_1000_nl_s2_r100k 0 sky130_fd_pr__nfet_01v8 L=0.15 W=0.42 nf=1 ad=0.1218 as=0.1218 pd=1.42 ps=1.42 nrd=0.69047619047619  nrs=0.69047619047619 sa=0 sb=0 sd=0 mult=1 m=1
XMRD_op1_1000_nl_s2_r100k_0 rbl_op1_1000_nl_s2_r100k sn_op1_1000_nl_s2_r100k_0 rwls_op1_1000_nl_s2_r100k 0 sky130_fd_pr__nfet_01v8 L=0.15 W=0.42 nf=1 ad=0.1218 as=0.1218 pd=1.42 ps=1.42 nrd=0.69047619047619  nrs=0.69047619047619 sa=0 sb=0 sd=0 mult=1 m=1
csn_op1_1000_nl_s2_r100k_0 sn_op1_1000_nl_s2_r100k_0 0 {C_SN}
XMWR_op1_1000_nl_s2_r100k_1 sn_op1_1000_nl_s2_r100k_1 wwl_des wbl_op1_1000_nl_s2_r100k 0 sky130_fd_pr__nfet_01v8 L=0.15 W=0.42 nf=1 ad=0.1218 as=0.1218 pd=1.42 ps=1.42 nrd=0.69047619047619  nrs=0.69047619047619 sa=0 sb=0 sd=0 mult=1 m=1
XMRD_op1_1000_nl_s2_r100k_1 rbl_op1_1000_nl_s2_r100k sn_op1_1000_nl_s2_r100k_1 rwl_des 0 sky130_fd_pr__nfet_01v8 L=0.15 W=0.42 nf=1 ad=0.1218 as=0.1218 pd=1.42 ps=1.42 nrd=0.69047619047619  nrs=0.69047619047619 sa=0 sb=0 sd=0 mult=1 m=1
csn_op1_1000_nl_s2_r100k_1 sn_op1_1000_nl_s2_r100k_1 0 {C_SN}
XMWR_op1_1000_nl_s2_r100k_2 sn_op1_1000_nl_s2_r100k_2 wwl_des wbl_op1_1000_nl_s2_r100k 0 sky130_fd_pr__nfet_01v8 L=0.15 W=0.42 nf=1 ad=0.1218 as=0.1218 pd=1.42 ps=1.42 nrd=0.69047619047619  nrs=0.69047619047619 sa=0 sb=0 sd=0 mult=1 m=1
XMRD_op1_1000_nl_s2_r100k_2 rbl_op1_1000_nl_s2_r100k sn_op1_1000_nl_s2_r100k_2 rwl_des 0 sky130_fd_pr__nfet_01v8 L=0.15 W=0.42 nf=1 ad=0.1218 as=0.1218 pd=1.42 ps=1.42 nrd=0.69047619047619  nrs=0.69047619047619 sa=0 sb=0 sd=0 mult=1 m=1
csn_op1_1000_nl_s2_r100k_2 sn_op1_1000_nl_s2_r100k_2 0 {C_SN}
XMWR_op1_1000_nl_s2_r100k_3 sn_op1_1000_nl_s2_r100k_3 wwl_des wbl_op1_1000_nl_s2_r100k 0 sky130_fd_pr__nfet_01v8 L=0.15 W=0.42 nf=1 ad=0.1218 as=0.1218 pd=1.42 ps=1.42 nrd=0.69047619047619  nrs=0.69047619047619 sa=0 sb=0 sd=0 mult=1 m=1
XMRD_op1_1000_nl_s2_r100k_3 rbl_op1_1000_nl_s2_r100k sn_op1_1000_nl_s2_r100k_3 rwl_des 0 sky130_fd_pr__nfet_01v8 L=0.15 W=0.42 nf=1 ad=0.1218 as=0.1218 pd=1.42 ps=1.42 nrd=0.69047619047619  nrs=0.69047619047619 sa=0 sb=0 sd=0 mult=1 m=1
csn_op1_1000_nl_s2_r100k_3 sn_op1_1000_nl_s2_r100k_3 0 {C_SN}
XMN1_op1_1000_nl_s2_r100k rbl_op1_1000_nl_s2_r100k ref_op1_1000_nl_s2_r100k vn_op1_1000_nl_s2_r100k 0 sky130_fd_pr__nfet_01v8 L=0.15 W=1 nf=1 ad=0.29 as=0.29 pd=2.58 ps=2.58 mult=1 m=1
XMN2_op1_1000_nl_s2_r100k ref_op1_1000_nl_s2_r100k rbl_op1_1000_nl_s2_r100k vn_op1_1000_nl_s2_r100k 0 sky130_fd_pr__nfet_01v8 L=0.15 W=1 nf=1 ad=0.29 as=0.29 pd=2.58 ps=2.58 mult=1 m=1
XMP1_op1_1000_nl_s2_r100k rbl_op1_1000_nl_s2_r100k ref_op1_1000_nl_s2_r100k vp_op1_1000_nl_s2_r100k vdd sky130_fd_pr__pfet_01v8 L=0.15 W=2 nf=1 ad=0.58 as=0.58 pd=4.58 ps=4.58 mult=1 m=1
XMP2_op1_1000_nl_s2_r100k ref_op1_1000_nl_s2_r100k rbl_op1_1000_nl_s2_r100k vp_op1_1000_nl_s2_r100k vdd sky130_fd_pr__pfet_01v8 L=0.15 W=2 nf=1 ad=0.58 as=0.58 pd=4.58 ps=4.58 mult=1 m=1
XMNF_op1_1000_nl_s2_r100k vn_op1_1000_nl_s2_r100k en_op1_1000_nl_s2_r100k 0 0 sky130_fd_pr__nfet_01v8 L=0.15 W=2 nf=1 ad=0.58 as=0.58 pd=4.58 ps=4.58 mult=1 m=1
XMPH_op1_1000_nl_s2_r100k vp_op1_1000_nl_s2_r100k enb_op1_1000_nl_s2_r100k vdd vdd sky130_fd_pr__pfet_01v8 L=0.15 W=4 nf=1 ad=1.16 as=1.16 pd=8.58 ps=8.58 mult=1 m=1
bd_op1_1000_nl_s2_r100k d_op1_1000_nl_s2_r100k 0 v=v(rbl_op1_1000_nl_s2_r100k)-v(ref_op1_1000_nl_s2_r100k)

* ---- instance 359: op0_n100_nl_s2_r100k (variant nl_s2_r100k; probe dec 11.9 ns, release 34 ns, meas 36 ns) ----
vctl_op0_n100_nl_s2_r100k ctl_op0_n100_nl_s2_r100k 0 pwl(0.0000e+00 {VDD} 2.0000e-09 {VDD} 2.1000e-09 0)
* RWL driver model (EXPERIMENTAL): slew 2 ns, series R 100000 ohm; cell pin = rwls_op0_n100_nl_s2_r100k
vrs_op0_n100_nl_s2_r100k rwlsrc_op0_n100_nl_s2_r100k 0 pwl(0.0000e+00 {VDD} 2.0000e-09 {VDD} 4.0000e-09 0 3.4000e-08 0 3.6000e-08 {VDD})
rdrv_op0_n100_nl_s2_r100k rwlsrc_op0_n100_nl_s2_r100k rwls_op0_n100_nl_s2_r100k 100000
ven_op0_n100_nl_s2_r100k en_op0_n100_nl_s2_r100k 0 pwl(0.0000e+00 0 1.1000e-08 0 1.1100e-08 {VDD} 3.4000e-08 {VDD} 3.4100e-08 0)
venb_op0_n100_nl_s2_r100k enb_op0_n100_nl_s2_r100k 0 pwl(0.0000e+00 {VDD} 1.1000e-08 {VDD} 1.1100e-08 0 3.4000e-08 0 3.4100e-08 {VDD})
vww_op0_n100_nl_s2_r100k wwl_op0_n100_nl_s2_r100k 0 pwl(0.0000e+00 0)
vwc_op0_n100_nl_s2_r100k wbc_op0_n100_nl_s2_r100k 0 pwl(0.0000e+00 0)
swb_op0_n100_nl_s2_r100k ref_op0_n100_nl_s2_r100k wbl_op0_n100_nl_s2_r100k wbc_op0_n100_nl_s2_r100k 0 swwbl
cwbl_op0_n100_nl_s2_r100k wbl_op0_n100_nl_s2_r100k 0 {C_WBL}
spa_op0_n100_nl_s2_r100k prea rbl_op0_n100_nl_s2_r100k ctl_op0_n100_nl_s2_r100k 0 swpre
spr_op0_n100_nl_s2_r100k pref ref_op0_n100_nl_s2_r100k ctl_op0_n100_nl_s2_r100k 0 swpre
crbl_op0_n100_nl_s2_r100k rbl_op0_n100_nl_s2_r100k 0 {C_RBL}
cref_op0_n100_nl_s2_r100k ref_op0_n100_nl_s2_r100k 0 {C_RBL}   $ ASSUMPTION: ideal matched dummy load
XMWR_op0_n100_nl_s2_r100k_0 sn_op0_n100_nl_s2_r100k_0 wwl_op0_n100_nl_s2_r100k wbl_op0_n100_nl_s2_r100k 0 sky130_fd_pr__nfet_01v8 L=0.15 W=0.42 nf=1 ad=0.1218 as=0.1218 pd=1.42 ps=1.42 nrd=0.69047619047619  nrs=0.69047619047619 sa=0 sb=0 sd=0 mult=1 m=1
XMRD_op0_n100_nl_s2_r100k_0 rbl_op0_n100_nl_s2_r100k sn_op0_n100_nl_s2_r100k_0 rwls_op0_n100_nl_s2_r100k 0 sky130_fd_pr__nfet_01v8 L=0.15 W=0.42 nf=1 ad=0.1218 as=0.1218 pd=1.42 ps=1.42 nrd=0.69047619047619  nrs=0.69047619047619 sa=0 sb=0 sd=0 mult=1 m=1
csn_op0_n100_nl_s2_r100k_0 sn_op0_n100_nl_s2_r100k_0 0 {C_SN}
XMWR_op0_n100_nl_s2_r100k_1 sn_op0_n100_nl_s2_r100k_1 wwl_des wbl_op0_n100_nl_s2_r100k 0 sky130_fd_pr__nfet_01v8 L=0.15 W=0.42 nf=1 ad=0.1218 as=0.1218 pd=1.42 ps=1.42 nrd=0.69047619047619  nrs=0.69047619047619 sa=0 sb=0 sd=0 mult=1 m=1
XMRD_op0_n100_nl_s2_r100k_1 rbl_op0_n100_nl_s2_r100k sn_op0_n100_nl_s2_r100k_1 rwl_des 0 sky130_fd_pr__nfet_01v8 L=0.15 W=0.42 nf=1 ad=0.1218 as=0.1218 pd=1.42 ps=1.42 nrd=0.69047619047619  nrs=0.69047619047619 sa=0 sb=0 sd=0 mult=1 m=1
csn_op0_n100_nl_s2_r100k_1 sn_op0_n100_nl_s2_r100k_1 0 {C_SN}
XMWR_op0_n100_nl_s2_r100k_2 sn_op0_n100_nl_s2_r100k_2 wwl_des wbl_op0_n100_nl_s2_r100k 0 sky130_fd_pr__nfet_01v8 L=0.15 W=0.42 nf=1 ad=0.1218 as=0.1218 pd=1.42 ps=1.42 nrd=0.69047619047619  nrs=0.69047619047619 sa=0 sb=0 sd=0 mult=1 m=1
XMRD_op0_n100_nl_s2_r100k_2 rbl_op0_n100_nl_s2_r100k sn_op0_n100_nl_s2_r100k_2 rwl_des 0 sky130_fd_pr__nfet_01v8 L=0.15 W=0.42 nf=1 ad=0.1218 as=0.1218 pd=1.42 ps=1.42 nrd=0.69047619047619  nrs=0.69047619047619 sa=0 sb=0 sd=0 mult=1 m=1
csn_op0_n100_nl_s2_r100k_2 sn_op0_n100_nl_s2_r100k_2 0 {C_SN}
XMWR_op0_n100_nl_s2_r100k_3 sn_op0_n100_nl_s2_r100k_3 wwl_des wbl_op0_n100_nl_s2_r100k 0 sky130_fd_pr__nfet_01v8 L=0.15 W=0.42 nf=1 ad=0.1218 as=0.1218 pd=1.42 ps=1.42 nrd=0.69047619047619  nrs=0.69047619047619 sa=0 sb=0 sd=0 mult=1 m=1
XMRD_op0_n100_nl_s2_r100k_3 rbl_op0_n100_nl_s2_r100k sn_op0_n100_nl_s2_r100k_3 rwl_des 0 sky130_fd_pr__nfet_01v8 L=0.15 W=0.42 nf=1 ad=0.1218 as=0.1218 pd=1.42 ps=1.42 nrd=0.69047619047619  nrs=0.69047619047619 sa=0 sb=0 sd=0 mult=1 m=1
csn_op0_n100_nl_s2_r100k_3 sn_op0_n100_nl_s2_r100k_3 0 {C_SN}
XMN1_op0_n100_nl_s2_r100k rbl_op0_n100_nl_s2_r100k ref_op0_n100_nl_s2_r100k vn_op0_n100_nl_s2_r100k 0 sky130_fd_pr__nfet_01v8 L=0.15 W=1 nf=1 ad=0.29 as=0.29 pd=2.58 ps=2.58 mult=1 m=1
XMN2_op0_n100_nl_s2_r100k ref_op0_n100_nl_s2_r100k rbl_op0_n100_nl_s2_r100k vn_op0_n100_nl_s2_r100k 0 sky130_fd_pr__nfet_01v8 L=0.15 W=1 nf=1 ad=0.29 as=0.29 pd=2.58 ps=2.58 mult=1 m=1
XMP1_op0_n100_nl_s2_r100k rbl_op0_n100_nl_s2_r100k ref_op0_n100_nl_s2_r100k vp_op0_n100_nl_s2_r100k vdd sky130_fd_pr__pfet_01v8 L=0.15 W=2 nf=1 ad=0.58 as=0.58 pd=4.58 ps=4.58 mult=1 m=1
XMP2_op0_n100_nl_s2_r100k ref_op0_n100_nl_s2_r100k rbl_op0_n100_nl_s2_r100k vp_op0_n100_nl_s2_r100k vdd sky130_fd_pr__pfet_01v8 L=0.15 W=2 nf=1 ad=0.58 as=0.58 pd=4.58 ps=4.58 mult=1 m=1
XMNF_op0_n100_nl_s2_r100k vn_op0_n100_nl_s2_r100k en_op0_n100_nl_s2_r100k 0 0 sky130_fd_pr__nfet_01v8 L=0.15 W=2 nf=1 ad=0.58 as=0.58 pd=4.58 ps=4.58 mult=1 m=1
XMPH_op0_n100_nl_s2_r100k vp_op0_n100_nl_s2_r100k enb_op0_n100_nl_s2_r100k vdd vdd sky130_fd_pr__pfet_01v8 L=0.15 W=4 nf=1 ad=1.16 as=1.16 pd=8.58 ps=8.58 mult=1 m=1
bd_op0_n100_nl_s2_r100k d_op0_n100_nl_s2_r100k 0 v=v(rbl_op0_n100_nl_s2_r100k)-v(ref_op0_n100_nl_s2_r100k)

* ---- instance 360: op0_0000_nl_s2_r100k (variant nl_s2_r100k; probe dec 11.9 ns, release 34 ns, meas 36 ns) ----
vctl_op0_0000_nl_s2_r100k ctl_op0_0000_nl_s2_r100k 0 pwl(0.0000e+00 {VDD} 2.0000e-09 {VDD} 2.1000e-09 0)
* RWL driver model (EXPERIMENTAL): slew 2 ns, series R 100000 ohm; cell pin = rwls_op0_0000_nl_s2_r100k
vrs_op0_0000_nl_s2_r100k rwlsrc_op0_0000_nl_s2_r100k 0 pwl(0.0000e+00 {VDD} 2.0000e-09 {VDD} 4.0000e-09 0 3.4000e-08 0 3.6000e-08 {VDD})
rdrv_op0_0000_nl_s2_r100k rwlsrc_op0_0000_nl_s2_r100k rwls_op0_0000_nl_s2_r100k 100000
ven_op0_0000_nl_s2_r100k en_op0_0000_nl_s2_r100k 0 pwl(0.0000e+00 0 1.1000e-08 0 1.1100e-08 {VDD} 3.4000e-08 {VDD} 3.4100e-08 0)
venb_op0_0000_nl_s2_r100k enb_op0_0000_nl_s2_r100k 0 pwl(0.0000e+00 {VDD} 1.1000e-08 {VDD} 1.1100e-08 0 3.4000e-08 0 3.4100e-08 {VDD})
vww_op0_0000_nl_s2_r100k wwl_op0_0000_nl_s2_r100k 0 pwl(0.0000e+00 0)
vwc_op0_0000_nl_s2_r100k wbc_op0_0000_nl_s2_r100k 0 pwl(0.0000e+00 0)
swb_op0_0000_nl_s2_r100k ref_op0_0000_nl_s2_r100k wbl_op0_0000_nl_s2_r100k wbc_op0_0000_nl_s2_r100k 0 swwbl
cwbl_op0_0000_nl_s2_r100k wbl_op0_0000_nl_s2_r100k 0 {C_WBL}
spa_op0_0000_nl_s2_r100k prea rbl_op0_0000_nl_s2_r100k ctl_op0_0000_nl_s2_r100k 0 swpre
spr_op0_0000_nl_s2_r100k pref ref_op0_0000_nl_s2_r100k ctl_op0_0000_nl_s2_r100k 0 swpre
crbl_op0_0000_nl_s2_r100k rbl_op0_0000_nl_s2_r100k 0 {C_RBL}
cref_op0_0000_nl_s2_r100k ref_op0_0000_nl_s2_r100k 0 {C_RBL}   $ ASSUMPTION: ideal matched dummy load
XMWR_op0_0000_nl_s2_r100k_0 sn_op0_0000_nl_s2_r100k_0 wwl_op0_0000_nl_s2_r100k wbl_op0_0000_nl_s2_r100k 0 sky130_fd_pr__nfet_01v8 L=0.15 W=0.42 nf=1 ad=0.1218 as=0.1218 pd=1.42 ps=1.42 nrd=0.69047619047619  nrs=0.69047619047619 sa=0 sb=0 sd=0 mult=1 m=1
XMRD_op0_0000_nl_s2_r100k_0 rbl_op0_0000_nl_s2_r100k sn_op0_0000_nl_s2_r100k_0 rwls_op0_0000_nl_s2_r100k 0 sky130_fd_pr__nfet_01v8 L=0.15 W=0.42 nf=1 ad=0.1218 as=0.1218 pd=1.42 ps=1.42 nrd=0.69047619047619  nrs=0.69047619047619 sa=0 sb=0 sd=0 mult=1 m=1
csn_op0_0000_nl_s2_r100k_0 sn_op0_0000_nl_s2_r100k_0 0 {C_SN}
XMWR_op0_0000_nl_s2_r100k_1 sn_op0_0000_nl_s2_r100k_1 wwl_des wbl_op0_0000_nl_s2_r100k 0 sky130_fd_pr__nfet_01v8 L=0.15 W=0.42 nf=1 ad=0.1218 as=0.1218 pd=1.42 ps=1.42 nrd=0.69047619047619  nrs=0.69047619047619 sa=0 sb=0 sd=0 mult=1 m=1
XMRD_op0_0000_nl_s2_r100k_1 rbl_op0_0000_nl_s2_r100k sn_op0_0000_nl_s2_r100k_1 rwl_des 0 sky130_fd_pr__nfet_01v8 L=0.15 W=0.42 nf=1 ad=0.1218 as=0.1218 pd=1.42 ps=1.42 nrd=0.69047619047619  nrs=0.69047619047619 sa=0 sb=0 sd=0 mult=1 m=1
csn_op0_0000_nl_s2_r100k_1 sn_op0_0000_nl_s2_r100k_1 0 {C_SN}
XMWR_op0_0000_nl_s2_r100k_2 sn_op0_0000_nl_s2_r100k_2 wwl_des wbl_op0_0000_nl_s2_r100k 0 sky130_fd_pr__nfet_01v8 L=0.15 W=0.42 nf=1 ad=0.1218 as=0.1218 pd=1.42 ps=1.42 nrd=0.69047619047619  nrs=0.69047619047619 sa=0 sb=0 sd=0 mult=1 m=1
XMRD_op0_0000_nl_s2_r100k_2 rbl_op0_0000_nl_s2_r100k sn_op0_0000_nl_s2_r100k_2 rwl_des 0 sky130_fd_pr__nfet_01v8 L=0.15 W=0.42 nf=1 ad=0.1218 as=0.1218 pd=1.42 ps=1.42 nrd=0.69047619047619  nrs=0.69047619047619 sa=0 sb=0 sd=0 mult=1 m=1
csn_op0_0000_nl_s2_r100k_2 sn_op0_0000_nl_s2_r100k_2 0 {C_SN}
XMWR_op0_0000_nl_s2_r100k_3 sn_op0_0000_nl_s2_r100k_3 wwl_des wbl_op0_0000_nl_s2_r100k 0 sky130_fd_pr__nfet_01v8 L=0.15 W=0.42 nf=1 ad=0.1218 as=0.1218 pd=1.42 ps=1.42 nrd=0.69047619047619  nrs=0.69047619047619 sa=0 sb=0 sd=0 mult=1 m=1
XMRD_op0_0000_nl_s2_r100k_3 rbl_op0_0000_nl_s2_r100k sn_op0_0000_nl_s2_r100k_3 rwl_des 0 sky130_fd_pr__nfet_01v8 L=0.15 W=0.42 nf=1 ad=0.1218 as=0.1218 pd=1.42 ps=1.42 nrd=0.69047619047619  nrs=0.69047619047619 sa=0 sb=0 sd=0 mult=1 m=1
csn_op0_0000_nl_s2_r100k_3 sn_op0_0000_nl_s2_r100k_3 0 {C_SN}
XMN1_op0_0000_nl_s2_r100k rbl_op0_0000_nl_s2_r100k ref_op0_0000_nl_s2_r100k vn_op0_0000_nl_s2_r100k 0 sky130_fd_pr__nfet_01v8 L=0.15 W=1 nf=1 ad=0.29 as=0.29 pd=2.58 ps=2.58 mult=1 m=1
XMN2_op0_0000_nl_s2_r100k ref_op0_0000_nl_s2_r100k rbl_op0_0000_nl_s2_r100k vn_op0_0000_nl_s2_r100k 0 sky130_fd_pr__nfet_01v8 L=0.15 W=1 nf=1 ad=0.29 as=0.29 pd=2.58 ps=2.58 mult=1 m=1
XMP1_op0_0000_nl_s2_r100k rbl_op0_0000_nl_s2_r100k ref_op0_0000_nl_s2_r100k vp_op0_0000_nl_s2_r100k vdd sky130_fd_pr__pfet_01v8 L=0.15 W=2 nf=1 ad=0.58 as=0.58 pd=4.58 ps=4.58 mult=1 m=1
XMP2_op0_0000_nl_s2_r100k ref_op0_0000_nl_s2_r100k rbl_op0_0000_nl_s2_r100k vp_op0_0000_nl_s2_r100k vdd sky130_fd_pr__pfet_01v8 L=0.15 W=2 nf=1 ad=0.58 as=0.58 pd=4.58 ps=4.58 mult=1 m=1
XMNF_op0_0000_nl_s2_r100k vn_op0_0000_nl_s2_r100k en_op0_0000_nl_s2_r100k 0 0 sky130_fd_pr__nfet_01v8 L=0.15 W=2 nf=1 ad=0.58 as=0.58 pd=4.58 ps=4.58 mult=1 m=1
XMPH_op0_0000_nl_s2_r100k vp_op0_0000_nl_s2_r100k enb_op0_0000_nl_s2_r100k vdd vdd sky130_fd_pr__pfet_01v8 L=0.15 W=4 nf=1 ad=1.16 as=1.16 pd=8.58 ps=8.58 mult=1 m=1
bd_op0_0000_nl_s2_r100k d_op0_0000_nl_s2_r100k 0 v=v(rbl_op0_0000_nl_s2_r100k)-v(ref_op0_0000_nl_s2_r100k)

* initial conditions (tran uic)
.ic v(wbl_op1_0900_baseline_analog)=0 v(rbl_op1_0900_baseline_analog)=1.8 v(ref_op1_0900_baseline_analog)=0 v(sn_op1_0900_baseline_analog_0)=0.9 v(sn_op1_0900_baseline_analog_1)=0.9 v(sn_op1_0900_baseline_analog_2)=0.9
.ic v(sn_op1_0900_baseline_analog_3)=0.9 v(vn_op1_0900_baseline_analog)=0.45 v(vp_op1_0900_baseline_analog)=1.35 v(wbl_op1_1000_baseline_analog)=0 v(rbl_op1_1000_baseline_analog)=1.8 v(ref_op1_1000_baseline_analog)=0
.ic v(sn_op1_1000_baseline_analog_0)=1 v(sn_op1_1000_baseline_analog_1)=1 v(sn_op1_1000_baseline_analog_2)=1 v(sn_op1_1000_baseline_analog_3)=1 v(vn_op1_1000_baseline_analog)=0.45 v(vp_op1_1000_baseline_analog)=1.35
.ic v(wbl_op0_n100_baseline_analog)=0 v(rbl_op0_n100_baseline_analog)=1.8 v(ref_op0_n100_baseline_analog)=0 v(sn_op0_n100_baseline_analog_0)=-0.1 v(sn_op0_n100_baseline_analog_1)=-0.1 v(sn_op0_n100_baseline_analog_2)=-0.1
.ic v(sn_op0_n100_baseline_analog_3)=-0.1 v(vn_op0_n100_baseline_analog)=0.45 v(vp_op0_n100_baseline_analog)=1.35 v(wbl_op0_0000_baseline_analog)=0 v(rbl_op0_0000_baseline_analog)=1.8 v(ref_op0_0000_baseline_analog)=0
.ic v(sn_op0_0000_baseline_analog_0)=0 v(sn_op0_0000_baseline_analog_1)=0 v(sn_op0_0000_baseline_analog_2)=0 v(sn_op0_0000_baseline_analog_3)=0 v(vn_op0_0000_baseline_analog)=0.45 v(vp_op0_0000_baseline_analog)=1.35
.ic v(wbl_op1_0900_rtl_raw)=0 v(rbl_op1_0900_rtl_raw)=1.8 v(ref_op1_0900_rtl_raw)=0 v(sn_op1_0900_rtl_raw_0)=0.9 v(sn_op1_0900_rtl_raw_1)=0.9 v(sn_op1_0900_rtl_raw_2)=0.9
.ic v(sn_op1_0900_rtl_raw_3)=0.9 v(vn_op1_0900_rtl_raw)=0.45 v(vp_op1_0900_rtl_raw)=1.35 v(wbl_op1_1000_rtl_raw)=0 v(rbl_op1_1000_rtl_raw)=1.8 v(ref_op1_1000_rtl_raw)=0
.ic v(sn_op1_1000_rtl_raw_0)=1 v(sn_op1_1000_rtl_raw_1)=1 v(sn_op1_1000_rtl_raw_2)=1 v(sn_op1_1000_rtl_raw_3)=1 v(vn_op1_1000_rtl_raw)=0.45 v(vp_op1_1000_rtl_raw)=1.35
.ic v(wbl_op0_n100_rtl_raw)=0 v(rbl_op0_n100_rtl_raw)=1.8 v(ref_op0_n100_rtl_raw)=0 v(sn_op0_n100_rtl_raw_0)=-0.1 v(sn_op0_n100_rtl_raw_1)=-0.1 v(sn_op0_n100_rtl_raw_2)=-0.1
.ic v(sn_op0_n100_rtl_raw_3)=-0.1 v(vn_op0_n100_rtl_raw)=0.45 v(vp_op0_n100_rtl_raw)=1.35 v(wbl_op0_0000_rtl_raw)=0 v(rbl_op0_0000_rtl_raw)=1.8 v(ref_op0_0000_rtl_raw)=0
.ic v(sn_op0_0000_rtl_raw_0)=0 v(sn_op0_0000_rtl_raw_1)=0 v(sn_op0_0000_rtl_raw_2)=0 v(sn_op0_0000_rtl_raw_3)=0 v(vn_op0_0000_rtl_raw)=0.45 v(vp_op0_0000_rtl_raw)=1.35
.ic v(wbl_op1_0900_rtl_hold)=0 v(rbl_op1_0900_rtl_hold)=1.8 v(ref_op1_0900_rtl_hold)=0 v(sn_op1_0900_rtl_hold_0)=0.9 v(sn_op1_0900_rtl_hold_1)=0.9 v(sn_op1_0900_rtl_hold_2)=0.9
.ic v(sn_op1_0900_rtl_hold_3)=0.9 v(vn_op1_0900_rtl_hold)=0.45 v(vp_op1_0900_rtl_hold)=1.35 v(wbl_op1_1000_rtl_hold)=0 v(rbl_op1_1000_rtl_hold)=1.8 v(ref_op1_1000_rtl_hold)=0
.ic v(sn_op1_1000_rtl_hold_0)=1 v(sn_op1_1000_rtl_hold_1)=1 v(sn_op1_1000_rtl_hold_2)=1 v(sn_op1_1000_rtl_hold_3)=1 v(vn_op1_1000_rtl_hold)=0.45 v(vp_op1_1000_rtl_hold)=1.35
.ic v(wbl_op0_n100_rtl_hold)=0 v(rbl_op0_n100_rtl_hold)=1.8 v(ref_op0_n100_rtl_hold)=0 v(sn_op0_n100_rtl_hold_0)=-0.1 v(sn_op0_n100_rtl_hold_1)=-0.1 v(sn_op0_n100_rtl_hold_2)=-0.1
.ic v(sn_op0_n100_rtl_hold_3)=-0.1 v(vn_op0_n100_rtl_hold)=0.45 v(vp_op0_n100_rtl_hold)=1.35 v(wbl_op0_0000_rtl_hold)=0 v(rbl_op0_0000_rtl_hold)=1.8 v(ref_op0_0000_rtl_hold)=0
.ic v(sn_op0_0000_rtl_hold_0)=0 v(sn_op0_0000_rtl_hold_1)=0 v(sn_op0_0000_rtl_hold_2)=0 v(sn_op0_0000_rtl_hold_3)=0 v(vn_op0_0000_rtl_hold)=0.45 v(vp_op0_0000_rtl_hold)=1.35
.ic v(wbl_op1_0900_neg_missing_wb)=0 v(rbl_op1_0900_neg_missing_wb)=1.8 v(ref_op1_0900_neg_missing_wb)=0 v(sn_op1_0900_neg_missing_wb_0)=0.9 v(sn_op1_0900_neg_missing_wb_1)=0.9 v(sn_op1_0900_neg_missing_wb_2)=0.9
.ic v(sn_op1_0900_neg_missing_wb_3)=0.9 v(vn_op1_0900_neg_missing_wb)=0.45 v(vp_op1_0900_neg_missing_wb)=1.35 v(wbl_op1_1000_neg_missing_wb)=0 v(rbl_op1_1000_neg_missing_wb)=1.8 v(ref_op1_1000_neg_missing_wb)=0
.ic v(sn_op1_1000_neg_missing_wb_0)=1 v(sn_op1_1000_neg_missing_wb_1)=1 v(sn_op1_1000_neg_missing_wb_2)=1 v(sn_op1_1000_neg_missing_wb_3)=1 v(vn_op1_1000_neg_missing_wb)=0.45 v(vp_op1_1000_neg_missing_wb)=1.35
.ic v(wbl_op0_n100_neg_missing_wb)=0 v(rbl_op0_n100_neg_missing_wb)=1.8 v(ref_op0_n100_neg_missing_wb)=0 v(sn_op0_n100_neg_missing_wb_0)=-0.1 v(sn_op0_n100_neg_missing_wb_1)=-0.1 v(sn_op0_n100_neg_missing_wb_2)=-0.1
.ic v(sn_op0_n100_neg_missing_wb_3)=-0.1 v(vn_op0_n100_neg_missing_wb)=0.45 v(vp_op0_n100_neg_missing_wb)=1.35 v(wbl_op0_0000_neg_missing_wb)=0 v(rbl_op0_0000_neg_missing_wb)=1.8 v(ref_op0_0000_neg_missing_wb)=0
.ic v(sn_op0_0000_neg_missing_wb_0)=0 v(sn_op0_0000_neg_missing_wb_1)=0 v(sn_op0_0000_neg_missing_wb_2)=0 v(sn_op0_0000_neg_missing_wb_3)=0 v(vn_op0_0000_neg_missing_wb)=0.45 v(vp_op0_0000_neg_missing_wb)=1.35
.ic v(wbl_op1_0900_neg_short_wb)=0 v(rbl_op1_0900_neg_short_wb)=1.8 v(ref_op1_0900_neg_short_wb)=0 v(sn_op1_0900_neg_short_wb_0)=0.9 v(sn_op1_0900_neg_short_wb_1)=0.9 v(sn_op1_0900_neg_short_wb_2)=0.9
.ic v(sn_op1_0900_neg_short_wb_3)=0.9 v(vn_op1_0900_neg_short_wb)=0.45 v(vp_op1_0900_neg_short_wb)=1.35 v(wbl_op1_1000_neg_short_wb)=0 v(rbl_op1_1000_neg_short_wb)=1.8 v(ref_op1_1000_neg_short_wb)=0
.ic v(sn_op1_1000_neg_short_wb_0)=1 v(sn_op1_1000_neg_short_wb_1)=1 v(sn_op1_1000_neg_short_wb_2)=1 v(sn_op1_1000_neg_short_wb_3)=1 v(vn_op1_1000_neg_short_wb)=0.45 v(vp_op1_1000_neg_short_wb)=1.35
.ic v(wbl_op0_n100_neg_short_wb)=0 v(rbl_op0_n100_neg_short_wb)=1.8 v(ref_op0_n100_neg_short_wb)=0 v(sn_op0_n100_neg_short_wb_0)=-0.1 v(sn_op0_n100_neg_short_wb_1)=-0.1 v(sn_op0_n100_neg_short_wb_2)=-0.1
.ic v(sn_op0_n100_neg_short_wb_3)=-0.1 v(vn_op0_n100_neg_short_wb)=0.45 v(vp_op0_n100_neg_short_wb)=1.35 v(wbl_op0_0000_neg_short_wb)=0 v(rbl_op0_0000_neg_short_wb)=1.8 v(ref_op0_0000_neg_short_wb)=0
.ic v(sn_op0_0000_neg_short_wb_0)=0 v(sn_op0_0000_neg_short_wb_1)=0 v(sn_op0_0000_neg_short_wb_2)=0 v(sn_op0_0000_neg_short_wb_3)=0 v(vn_op0_0000_neg_short_wb)=0.45 v(vp_op0_0000_neg_short_wb)=1.35
.ic v(wbl_op1_0900_rwl_late_raw)=0 v(rbl_op1_0900_rwl_late_raw)=1.8 v(ref_op1_0900_rwl_late_raw)=0 v(sn_op1_0900_rwl_late_raw_0)=0.9 v(sn_op1_0900_rwl_late_raw_1)=0.9 v(sn_op1_0900_rwl_late_raw_2)=0.9
.ic v(sn_op1_0900_rwl_late_raw_3)=0.9 v(vn_op1_0900_rwl_late_raw)=0.45 v(vp_op1_0900_rwl_late_raw)=1.35 v(wbl_op1_1000_rwl_late_raw)=0 v(rbl_op1_1000_rwl_late_raw)=1.8 v(ref_op1_1000_rwl_late_raw)=0
.ic v(sn_op1_1000_rwl_late_raw_0)=1 v(sn_op1_1000_rwl_late_raw_1)=1 v(sn_op1_1000_rwl_late_raw_2)=1 v(sn_op1_1000_rwl_late_raw_3)=1 v(vn_op1_1000_rwl_late_raw)=0.45 v(vp_op1_1000_rwl_late_raw)=1.35
.ic v(wbl_op0_n100_rwl_late_raw)=0 v(rbl_op0_n100_rwl_late_raw)=1.8 v(ref_op0_n100_rwl_late_raw)=0 v(sn_op0_n100_rwl_late_raw_0)=-0.1 v(sn_op0_n100_rwl_late_raw_1)=-0.1 v(sn_op0_n100_rwl_late_raw_2)=-0.1
.ic v(sn_op0_n100_rwl_late_raw_3)=-0.1 v(vn_op0_n100_rwl_late_raw)=0.45 v(vp_op0_n100_rwl_late_raw)=1.35 v(wbl_op0_0000_rwl_late_raw)=0 v(rbl_op0_0000_rwl_late_raw)=1.8 v(ref_op0_0000_rwl_late_raw)=0
.ic v(sn_op0_0000_rwl_late_raw_0)=0 v(sn_op0_0000_rwl_late_raw_1)=0 v(sn_op0_0000_rwl_late_raw_2)=0 v(sn_op0_0000_rwl_late_raw_3)=0 v(vn_op0_0000_rwl_late_raw)=0.45 v(vp_op0_0000_rwl_late_raw)=1.35
.ic v(wbl_op1_0900_rwl_late_hold)=0 v(rbl_op1_0900_rwl_late_hold)=1.8 v(ref_op1_0900_rwl_late_hold)=0 v(sn_op1_0900_rwl_late_hold_0)=0.9 v(sn_op1_0900_rwl_late_hold_1)=0.9 v(sn_op1_0900_rwl_late_hold_2)=0.9
.ic v(sn_op1_0900_rwl_late_hold_3)=0.9 v(vn_op1_0900_rwl_late_hold)=0.45 v(vp_op1_0900_rwl_late_hold)=1.35 v(wbl_op1_1000_rwl_late_hold)=0 v(rbl_op1_1000_rwl_late_hold)=1.8 v(ref_op1_1000_rwl_late_hold)=0
.ic v(sn_op1_1000_rwl_late_hold_0)=1 v(sn_op1_1000_rwl_late_hold_1)=1 v(sn_op1_1000_rwl_late_hold_2)=1 v(sn_op1_1000_rwl_late_hold_3)=1 v(vn_op1_1000_rwl_late_hold)=0.45 v(vp_op1_1000_rwl_late_hold)=1.35
.ic v(wbl_op0_n100_rwl_late_hold)=0 v(rbl_op0_n100_rwl_late_hold)=1.8 v(ref_op0_n100_rwl_late_hold)=0 v(sn_op0_n100_rwl_late_hold_0)=-0.1 v(sn_op0_n100_rwl_late_hold_1)=-0.1 v(sn_op0_n100_rwl_late_hold_2)=-0.1
.ic v(sn_op0_n100_rwl_late_hold_3)=-0.1 v(vn_op0_n100_rwl_late_hold)=0.45 v(vp_op0_n100_rwl_late_hold)=1.35 v(wbl_op0_0000_rwl_late_hold)=0 v(rbl_op0_0000_rwl_late_hold)=1.8 v(ref_op0_0000_rwl_late_hold)=0
.ic v(sn_op0_0000_rwl_late_hold_0)=0 v(sn_op0_0000_rwl_late_hold_1)=0 v(sn_op0_0000_rwl_late_hold_2)=0 v(sn_op0_0000_rwl_late_hold_3)=0 v(vn_op0_0000_rwl_late_hold)=0.45 v(vp_op0_0000_rwl_late_hold)=1.35
.ic v(wbl_op1_0900_latch_early_hold)=0 v(rbl_op1_0900_latch_early_hold)=1.8 v(ref_op1_0900_latch_early_hold)=0 v(sn_op1_0900_latch_early_hold_0)=0.9 v(sn_op1_0900_latch_early_hold_1)=0.9 v(sn_op1_0900_latch_early_hold_2)=0.9
.ic v(sn_op1_0900_latch_early_hold_3)=0.9 v(vn_op1_0900_latch_early_hold)=0.45 v(vp_op1_0900_latch_early_hold)=1.35 v(wbl_op1_1000_latch_early_hold)=0 v(rbl_op1_1000_latch_early_hold)=1.8 v(ref_op1_1000_latch_early_hold)=0
.ic v(sn_op1_1000_latch_early_hold_0)=1 v(sn_op1_1000_latch_early_hold_1)=1 v(sn_op1_1000_latch_early_hold_2)=1 v(sn_op1_1000_latch_early_hold_3)=1 v(vn_op1_1000_latch_early_hold)=0.45 v(vp_op1_1000_latch_early_hold)=1.35
.ic v(wbl_op0_n100_latch_early_hold)=0 v(rbl_op0_n100_latch_early_hold)=1.8 v(ref_op0_n100_latch_early_hold)=0 v(sn_op0_n100_latch_early_hold_0)=-0.1 v(sn_op0_n100_latch_early_hold_1)=-0.1 v(sn_op0_n100_latch_early_hold_2)=-0.1
.ic v(sn_op0_n100_latch_early_hold_3)=-0.1 v(vn_op0_n100_latch_early_hold)=0.45 v(vp_op0_n100_latch_early_hold)=1.35 v(wbl_op0_0000_latch_early_hold)=0 v(rbl_op0_0000_latch_early_hold)=1.8 v(ref_op0_0000_latch_early_hold)=0
.ic v(sn_op0_0000_latch_early_hold_0)=0 v(sn_op0_0000_latch_early_hold_1)=0 v(sn_op0_0000_latch_early_hold_2)=0 v(sn_op0_0000_latch_early_hold_3)=0 v(vn_op0_0000_latch_early_hold)=0.45 v(vp_op0_0000_latch_early_hold)=1.35
.ic v(wbl_op1_0900_latch_late_hold)=0 v(rbl_op1_0900_latch_late_hold)=1.8 v(ref_op1_0900_latch_late_hold)=0 v(sn_op1_0900_latch_late_hold_0)=0.9 v(sn_op1_0900_latch_late_hold_1)=0.9 v(sn_op1_0900_latch_late_hold_2)=0.9
.ic v(sn_op1_0900_latch_late_hold_3)=0.9 v(vn_op1_0900_latch_late_hold)=0.45 v(vp_op1_0900_latch_late_hold)=1.35 v(wbl_op1_1000_latch_late_hold)=0 v(rbl_op1_1000_latch_late_hold)=1.8 v(ref_op1_1000_latch_late_hold)=0
.ic v(sn_op1_1000_latch_late_hold_0)=1 v(sn_op1_1000_latch_late_hold_1)=1 v(sn_op1_1000_latch_late_hold_2)=1 v(sn_op1_1000_latch_late_hold_3)=1 v(vn_op1_1000_latch_late_hold)=0.45 v(vp_op1_1000_latch_late_hold)=1.35
.ic v(wbl_op0_n100_latch_late_hold)=0 v(rbl_op0_n100_latch_late_hold)=1.8 v(ref_op0_n100_latch_late_hold)=0 v(sn_op0_n100_latch_late_hold_0)=-0.1 v(sn_op0_n100_latch_late_hold_1)=-0.1 v(sn_op0_n100_latch_late_hold_2)=-0.1
.ic v(sn_op0_n100_latch_late_hold_3)=-0.1 v(vn_op0_n100_latch_late_hold)=0.45 v(vp_op0_n100_latch_late_hold)=1.35 v(wbl_op0_0000_latch_late_hold)=0 v(rbl_op0_0000_latch_late_hold)=1.8 v(ref_op0_0000_latch_late_hold)=0
.ic v(sn_op0_0000_latch_late_hold_0)=0 v(sn_op0_0000_latch_late_hold_1)=0 v(sn_op0_0000_latch_late_hold_2)=0 v(sn_op0_0000_latch_late_hold_3)=0 v(vn_op0_0000_latch_late_hold)=0.45 v(vp_op0_0000_latch_late_hold)=1.35
.ic v(wbl_op1_0900_combined_hold)=0 v(rbl_op1_0900_combined_hold)=1.8 v(ref_op1_0900_combined_hold)=0 v(sn_op1_0900_combined_hold_0)=0.9 v(sn_op1_0900_combined_hold_1)=0.9 v(sn_op1_0900_combined_hold_2)=0.9
.ic v(sn_op1_0900_combined_hold_3)=0.9 v(vn_op1_0900_combined_hold)=0.45 v(vp_op1_0900_combined_hold)=1.35 v(wbl_op1_1000_combined_hold)=0 v(rbl_op1_1000_combined_hold)=1.8 v(ref_op1_1000_combined_hold)=0
.ic v(sn_op1_1000_combined_hold_0)=1 v(sn_op1_1000_combined_hold_1)=1 v(sn_op1_1000_combined_hold_2)=1 v(sn_op1_1000_combined_hold_3)=1 v(vn_op1_1000_combined_hold)=0.45 v(vp_op1_1000_combined_hold)=1.35
.ic v(wbl_op0_n100_combined_hold)=0 v(rbl_op0_n100_combined_hold)=1.8 v(ref_op0_n100_combined_hold)=0 v(sn_op0_n100_combined_hold_0)=-0.1 v(sn_op0_n100_combined_hold_1)=-0.1 v(sn_op0_n100_combined_hold_2)=-0.1
.ic v(sn_op0_n100_combined_hold_3)=-0.1 v(vn_op0_n100_combined_hold)=0.45 v(vp_op0_n100_combined_hold)=1.35 v(wbl_op0_0000_combined_hold)=0 v(rbl_op0_0000_combined_hold)=1.8 v(ref_op0_0000_combined_hold)=0
.ic v(sn_op0_0000_combined_hold_0)=0 v(sn_op0_0000_combined_hold_1)=0 v(sn_op0_0000_combined_hold_2)=0 v(sn_op0_0000_combined_hold_3)=0 v(vn_op0_0000_combined_hold)=0.45 v(vp_op0_0000_combined_hold)=1.35
.ic v(wbl_refw)=1.8 v(rbl_refw)=1.8 v(ref_refw)=0 v(sn_refw_0)=0 v(sn_refw_1)=0 v(sn_refw_2)=0
.ic v(sn_refw_3)=0 v(vn_refw)=0.45 v(vp_refw)=1.35 v(wbl_op1_0900_an_s0p5_r0)=0 v(rbl_op1_0900_an_s0p5_r0)=1.8 v(ref_op1_0900_an_s0p5_r0)=0
.ic v(sn_op1_0900_an_s0p5_r0_0)=0.9 v(sn_op1_0900_an_s0p5_r0_1)=0.9 v(sn_op1_0900_an_s0p5_r0_2)=0.9 v(sn_op1_0900_an_s0p5_r0_3)=0.9 v(vn_op1_0900_an_s0p5_r0)=0.45 v(vp_op1_0900_an_s0p5_r0)=1.35
.ic v(wbl_op1_1000_an_s0p5_r0)=0 v(rbl_op1_1000_an_s0p5_r0)=1.8 v(ref_op1_1000_an_s0p5_r0)=0 v(sn_op1_1000_an_s0p5_r0_0)=1 v(sn_op1_1000_an_s0p5_r0_1)=1 v(sn_op1_1000_an_s0p5_r0_2)=1
.ic v(sn_op1_1000_an_s0p5_r0_3)=1 v(vn_op1_1000_an_s0p5_r0)=0.45 v(vp_op1_1000_an_s0p5_r0)=1.35 v(wbl_op0_n100_an_s0p5_r0)=0 v(rbl_op0_n100_an_s0p5_r0)=1.8 v(ref_op0_n100_an_s0p5_r0)=0
.ic v(sn_op0_n100_an_s0p5_r0_0)=-0.1 v(sn_op0_n100_an_s0p5_r0_1)=-0.1 v(sn_op0_n100_an_s0p5_r0_2)=-0.1 v(sn_op0_n100_an_s0p5_r0_3)=-0.1 v(vn_op0_n100_an_s0p5_r0)=0.45 v(vp_op0_n100_an_s0p5_r0)=1.35
.ic v(wbl_op0_0000_an_s0p5_r0)=0 v(rbl_op0_0000_an_s0p5_r0)=1.8 v(ref_op0_0000_an_s0p5_r0)=0 v(sn_op0_0000_an_s0p5_r0_0)=0 v(sn_op0_0000_an_s0p5_r0_1)=0 v(sn_op0_0000_an_s0p5_r0_2)=0
.ic v(sn_op0_0000_an_s0p5_r0_3)=0 v(vn_op0_0000_an_s0p5_r0)=0.45 v(vp_op0_0000_an_s0p5_r0)=1.35 v(wbl_op1_0900_an_s1_r0)=0 v(rbl_op1_0900_an_s1_r0)=1.8 v(ref_op1_0900_an_s1_r0)=0
.ic v(sn_op1_0900_an_s1_r0_0)=0.9 v(sn_op1_0900_an_s1_r0_1)=0.9 v(sn_op1_0900_an_s1_r0_2)=0.9 v(sn_op1_0900_an_s1_r0_3)=0.9 v(vn_op1_0900_an_s1_r0)=0.45 v(vp_op1_0900_an_s1_r0)=1.35
.ic v(wbl_op1_1000_an_s1_r0)=0 v(rbl_op1_1000_an_s1_r0)=1.8 v(ref_op1_1000_an_s1_r0)=0 v(sn_op1_1000_an_s1_r0_0)=1 v(sn_op1_1000_an_s1_r0_1)=1 v(sn_op1_1000_an_s1_r0_2)=1
.ic v(sn_op1_1000_an_s1_r0_3)=1 v(vn_op1_1000_an_s1_r0)=0.45 v(vp_op1_1000_an_s1_r0)=1.35 v(wbl_op0_n100_an_s1_r0)=0 v(rbl_op0_n100_an_s1_r0)=1.8 v(ref_op0_n100_an_s1_r0)=0
.ic v(sn_op0_n100_an_s1_r0_0)=-0.1 v(sn_op0_n100_an_s1_r0_1)=-0.1 v(sn_op0_n100_an_s1_r0_2)=-0.1 v(sn_op0_n100_an_s1_r0_3)=-0.1 v(vn_op0_n100_an_s1_r0)=0.45 v(vp_op0_n100_an_s1_r0)=1.35
.ic v(wbl_op0_0000_an_s1_r0)=0 v(rbl_op0_0000_an_s1_r0)=1.8 v(ref_op0_0000_an_s1_r0)=0 v(sn_op0_0000_an_s1_r0_0)=0 v(sn_op0_0000_an_s1_r0_1)=0 v(sn_op0_0000_an_s1_r0_2)=0
.ic v(sn_op0_0000_an_s1_r0_3)=0 v(vn_op0_0000_an_s1_r0)=0.45 v(vp_op0_0000_an_s1_r0)=1.35 v(wbl_op1_0900_an_s2_r0)=0 v(rbl_op1_0900_an_s2_r0)=1.8 v(ref_op1_0900_an_s2_r0)=0
.ic v(sn_op1_0900_an_s2_r0_0)=0.9 v(sn_op1_0900_an_s2_r0_1)=0.9 v(sn_op1_0900_an_s2_r0_2)=0.9 v(sn_op1_0900_an_s2_r0_3)=0.9 v(vn_op1_0900_an_s2_r0)=0.45 v(vp_op1_0900_an_s2_r0)=1.35
.ic v(wbl_op1_1000_an_s2_r0)=0 v(rbl_op1_1000_an_s2_r0)=1.8 v(ref_op1_1000_an_s2_r0)=0 v(sn_op1_1000_an_s2_r0_0)=1 v(sn_op1_1000_an_s2_r0_1)=1 v(sn_op1_1000_an_s2_r0_2)=1
.ic v(sn_op1_1000_an_s2_r0_3)=1 v(vn_op1_1000_an_s2_r0)=0.45 v(vp_op1_1000_an_s2_r0)=1.35 v(wbl_op0_n100_an_s2_r0)=0 v(rbl_op0_n100_an_s2_r0)=1.8 v(ref_op0_n100_an_s2_r0)=0
.ic v(sn_op0_n100_an_s2_r0_0)=-0.1 v(sn_op0_n100_an_s2_r0_1)=-0.1 v(sn_op0_n100_an_s2_r0_2)=-0.1 v(sn_op0_n100_an_s2_r0_3)=-0.1 v(vn_op0_n100_an_s2_r0)=0.45 v(vp_op0_n100_an_s2_r0)=1.35
.ic v(wbl_op0_0000_an_s2_r0)=0 v(rbl_op0_0000_an_s2_r0)=1.8 v(ref_op0_0000_an_s2_r0)=0 v(sn_op0_0000_an_s2_r0_0)=0 v(sn_op0_0000_an_s2_r0_1)=0 v(sn_op0_0000_an_s2_r0_2)=0
.ic v(sn_op0_0000_an_s2_r0_3)=0 v(vn_op0_0000_an_s2_r0)=0.45 v(vp_op0_0000_an_s2_r0)=1.35 v(wbl_op1_0900_an_s5_r0)=0 v(rbl_op1_0900_an_s5_r0)=1.8 v(ref_op1_0900_an_s5_r0)=0
.ic v(sn_op1_0900_an_s5_r0_0)=0.9 v(sn_op1_0900_an_s5_r0_1)=0.9 v(sn_op1_0900_an_s5_r0_2)=0.9 v(sn_op1_0900_an_s5_r0_3)=0.9 v(vn_op1_0900_an_s5_r0)=0.45 v(vp_op1_0900_an_s5_r0)=1.35
.ic v(wbl_op1_1000_an_s5_r0)=0 v(rbl_op1_1000_an_s5_r0)=1.8 v(ref_op1_1000_an_s5_r0)=0 v(sn_op1_1000_an_s5_r0_0)=1 v(sn_op1_1000_an_s5_r0_1)=1 v(sn_op1_1000_an_s5_r0_2)=1
.ic v(sn_op1_1000_an_s5_r0_3)=1 v(vn_op1_1000_an_s5_r0)=0.45 v(vp_op1_1000_an_s5_r0)=1.35 v(wbl_op0_n100_an_s5_r0)=0 v(rbl_op0_n100_an_s5_r0)=1.8 v(ref_op0_n100_an_s5_r0)=0
.ic v(sn_op0_n100_an_s5_r0_0)=-0.1 v(sn_op0_n100_an_s5_r0_1)=-0.1 v(sn_op0_n100_an_s5_r0_2)=-0.1 v(sn_op0_n100_an_s5_r0_3)=-0.1 v(vn_op0_n100_an_s5_r0)=0.45 v(vp_op0_n100_an_s5_r0)=1.35
.ic v(wbl_op0_0000_an_s5_r0)=0 v(rbl_op0_0000_an_s5_r0)=1.8 v(ref_op0_0000_an_s5_r0)=0 v(sn_op0_0000_an_s5_r0_0)=0 v(sn_op0_0000_an_s5_r0_1)=0 v(sn_op0_0000_an_s5_r0_2)=0
.ic v(sn_op0_0000_an_s5_r0_3)=0 v(vn_op0_0000_an_s5_r0)=0.45 v(vp_op0_0000_an_s5_r0)=1.35 v(wbl_op1_0900_an_s0p1_r1k)=0 v(rbl_op1_0900_an_s0p1_r1k)=1.8 v(ref_op1_0900_an_s0p1_r1k)=0
.ic v(sn_op1_0900_an_s0p1_r1k_0)=0.9 v(sn_op1_0900_an_s0p1_r1k_1)=0.9 v(sn_op1_0900_an_s0p1_r1k_2)=0.9 v(sn_op1_0900_an_s0p1_r1k_3)=0.9 v(vn_op1_0900_an_s0p1_r1k)=0.45 v(vp_op1_0900_an_s0p1_r1k)=1.35
.ic v(wbl_op1_1000_an_s0p1_r1k)=0 v(rbl_op1_1000_an_s0p1_r1k)=1.8 v(ref_op1_1000_an_s0p1_r1k)=0 v(sn_op1_1000_an_s0p1_r1k_0)=1 v(sn_op1_1000_an_s0p1_r1k_1)=1 v(sn_op1_1000_an_s0p1_r1k_2)=1
.ic v(sn_op1_1000_an_s0p1_r1k_3)=1 v(vn_op1_1000_an_s0p1_r1k)=0.45 v(vp_op1_1000_an_s0p1_r1k)=1.35 v(wbl_op0_n100_an_s0p1_r1k)=0 v(rbl_op0_n100_an_s0p1_r1k)=1.8 v(ref_op0_n100_an_s0p1_r1k)=0
.ic v(sn_op0_n100_an_s0p1_r1k_0)=-0.1 v(sn_op0_n100_an_s0p1_r1k_1)=-0.1 v(sn_op0_n100_an_s0p1_r1k_2)=-0.1 v(sn_op0_n100_an_s0p1_r1k_3)=-0.1 v(vn_op0_n100_an_s0p1_r1k)=0.45 v(vp_op0_n100_an_s0p1_r1k)=1.35
.ic v(wbl_op0_0000_an_s0p1_r1k)=0 v(rbl_op0_0000_an_s0p1_r1k)=1.8 v(ref_op0_0000_an_s0p1_r1k)=0 v(sn_op0_0000_an_s0p1_r1k_0)=0 v(sn_op0_0000_an_s0p1_r1k_1)=0 v(sn_op0_0000_an_s0p1_r1k_2)=0
.ic v(sn_op0_0000_an_s0p1_r1k_3)=0 v(vn_op0_0000_an_s0p1_r1k)=0.45 v(vp_op0_0000_an_s0p1_r1k)=1.35 v(wbl_op1_0900_an_s0p1_r3k)=0 v(rbl_op1_0900_an_s0p1_r3k)=1.8 v(ref_op1_0900_an_s0p1_r3k)=0
.ic v(sn_op1_0900_an_s0p1_r3k_0)=0.9 v(sn_op1_0900_an_s0p1_r3k_1)=0.9 v(sn_op1_0900_an_s0p1_r3k_2)=0.9 v(sn_op1_0900_an_s0p1_r3k_3)=0.9 v(vn_op1_0900_an_s0p1_r3k)=0.45 v(vp_op1_0900_an_s0p1_r3k)=1.35
.ic v(wbl_op1_1000_an_s0p1_r3k)=0 v(rbl_op1_1000_an_s0p1_r3k)=1.8 v(ref_op1_1000_an_s0p1_r3k)=0 v(sn_op1_1000_an_s0p1_r3k_0)=1 v(sn_op1_1000_an_s0p1_r3k_1)=1 v(sn_op1_1000_an_s0p1_r3k_2)=1
.ic v(sn_op1_1000_an_s0p1_r3k_3)=1 v(vn_op1_1000_an_s0p1_r3k)=0.45 v(vp_op1_1000_an_s0p1_r3k)=1.35 v(wbl_op0_n100_an_s0p1_r3k)=0 v(rbl_op0_n100_an_s0p1_r3k)=1.8 v(ref_op0_n100_an_s0p1_r3k)=0
.ic v(sn_op0_n100_an_s0p1_r3k_0)=-0.1 v(sn_op0_n100_an_s0p1_r3k_1)=-0.1 v(sn_op0_n100_an_s0p1_r3k_2)=-0.1 v(sn_op0_n100_an_s0p1_r3k_3)=-0.1 v(vn_op0_n100_an_s0p1_r3k)=0.45 v(vp_op0_n100_an_s0p1_r3k)=1.35
.ic v(wbl_op0_0000_an_s0p1_r3k)=0 v(rbl_op0_0000_an_s0p1_r3k)=1.8 v(ref_op0_0000_an_s0p1_r3k)=0 v(sn_op0_0000_an_s0p1_r3k_0)=0 v(sn_op0_0000_an_s0p1_r3k_1)=0 v(sn_op0_0000_an_s0p1_r3k_2)=0
.ic v(sn_op0_0000_an_s0p1_r3k_3)=0 v(vn_op0_0000_an_s0p1_r3k)=0.45 v(vp_op0_0000_an_s0p1_r3k)=1.35 v(wbl_op1_0900_an_s0p1_r10k)=0 v(rbl_op1_0900_an_s0p1_r10k)=1.8 v(ref_op1_0900_an_s0p1_r10k)=0
.ic v(sn_op1_0900_an_s0p1_r10k_0)=0.9 v(sn_op1_0900_an_s0p1_r10k_1)=0.9 v(sn_op1_0900_an_s0p1_r10k_2)=0.9 v(sn_op1_0900_an_s0p1_r10k_3)=0.9 v(vn_op1_0900_an_s0p1_r10k)=0.45 v(vp_op1_0900_an_s0p1_r10k)=1.35
.ic v(wbl_op1_1000_an_s0p1_r10k)=0 v(rbl_op1_1000_an_s0p1_r10k)=1.8 v(ref_op1_1000_an_s0p1_r10k)=0 v(sn_op1_1000_an_s0p1_r10k_0)=1 v(sn_op1_1000_an_s0p1_r10k_1)=1 v(sn_op1_1000_an_s0p1_r10k_2)=1
.ic v(sn_op1_1000_an_s0p1_r10k_3)=1 v(vn_op1_1000_an_s0p1_r10k)=0.45 v(vp_op1_1000_an_s0p1_r10k)=1.35 v(wbl_op0_n100_an_s0p1_r10k)=0 v(rbl_op0_n100_an_s0p1_r10k)=1.8 v(ref_op0_n100_an_s0p1_r10k)=0
.ic v(sn_op0_n100_an_s0p1_r10k_0)=-0.1 v(sn_op0_n100_an_s0p1_r10k_1)=-0.1 v(sn_op0_n100_an_s0p1_r10k_2)=-0.1 v(sn_op0_n100_an_s0p1_r10k_3)=-0.1 v(vn_op0_n100_an_s0p1_r10k)=0.45 v(vp_op0_n100_an_s0p1_r10k)=1.35
.ic v(wbl_op0_0000_an_s0p1_r10k)=0 v(rbl_op0_0000_an_s0p1_r10k)=1.8 v(ref_op0_0000_an_s0p1_r10k)=0 v(sn_op0_0000_an_s0p1_r10k_0)=0 v(sn_op0_0000_an_s0p1_r10k_1)=0 v(sn_op0_0000_an_s0p1_r10k_2)=0
.ic v(sn_op0_0000_an_s0p1_r10k_3)=0 v(vn_op0_0000_an_s0p1_r10k)=0.45 v(vp_op0_0000_an_s0p1_r10k)=1.35 v(wbl_op1_0900_an_s0p1_r30k)=0 v(rbl_op1_0900_an_s0p1_r30k)=1.8 v(ref_op1_0900_an_s0p1_r30k)=0
.ic v(sn_op1_0900_an_s0p1_r30k_0)=0.9 v(sn_op1_0900_an_s0p1_r30k_1)=0.9 v(sn_op1_0900_an_s0p1_r30k_2)=0.9 v(sn_op1_0900_an_s0p1_r30k_3)=0.9 v(vn_op1_0900_an_s0p1_r30k)=0.45 v(vp_op1_0900_an_s0p1_r30k)=1.35
.ic v(wbl_op1_1000_an_s0p1_r30k)=0 v(rbl_op1_1000_an_s0p1_r30k)=1.8 v(ref_op1_1000_an_s0p1_r30k)=0 v(sn_op1_1000_an_s0p1_r30k_0)=1 v(sn_op1_1000_an_s0p1_r30k_1)=1 v(sn_op1_1000_an_s0p1_r30k_2)=1
.ic v(sn_op1_1000_an_s0p1_r30k_3)=1 v(vn_op1_1000_an_s0p1_r30k)=0.45 v(vp_op1_1000_an_s0p1_r30k)=1.35 v(wbl_op0_n100_an_s0p1_r30k)=0 v(rbl_op0_n100_an_s0p1_r30k)=1.8 v(ref_op0_n100_an_s0p1_r30k)=0
.ic v(sn_op0_n100_an_s0p1_r30k_0)=-0.1 v(sn_op0_n100_an_s0p1_r30k_1)=-0.1 v(sn_op0_n100_an_s0p1_r30k_2)=-0.1 v(sn_op0_n100_an_s0p1_r30k_3)=-0.1 v(vn_op0_n100_an_s0p1_r30k)=0.45 v(vp_op0_n100_an_s0p1_r30k)=1.35
.ic v(wbl_op0_0000_an_s0p1_r30k)=0 v(rbl_op0_0000_an_s0p1_r30k)=1.8 v(ref_op0_0000_an_s0p1_r30k)=0 v(sn_op0_0000_an_s0p1_r30k_0)=0 v(sn_op0_0000_an_s0p1_r30k_1)=0 v(sn_op0_0000_an_s0p1_r30k_2)=0
.ic v(sn_op0_0000_an_s0p1_r30k_3)=0 v(vn_op0_0000_an_s0p1_r30k)=0.45 v(vp_op0_0000_an_s0p1_r30k)=1.35 v(wbl_op1_0900_an_s0p1_r100k)=0 v(rbl_op1_0900_an_s0p1_r100k)=1.8 v(ref_op1_0900_an_s0p1_r100k)=0
.ic v(sn_op1_0900_an_s0p1_r100k_0)=0.9 v(sn_op1_0900_an_s0p1_r100k_1)=0.9 v(sn_op1_0900_an_s0p1_r100k_2)=0.9 v(sn_op1_0900_an_s0p1_r100k_3)=0.9 v(vn_op1_0900_an_s0p1_r100k)=0.45 v(vp_op1_0900_an_s0p1_r100k)=1.35
.ic v(wbl_op1_1000_an_s0p1_r100k)=0 v(rbl_op1_1000_an_s0p1_r100k)=1.8 v(ref_op1_1000_an_s0p1_r100k)=0 v(sn_op1_1000_an_s0p1_r100k_0)=1 v(sn_op1_1000_an_s0p1_r100k_1)=1 v(sn_op1_1000_an_s0p1_r100k_2)=1
.ic v(sn_op1_1000_an_s0p1_r100k_3)=1 v(vn_op1_1000_an_s0p1_r100k)=0.45 v(vp_op1_1000_an_s0p1_r100k)=1.35 v(wbl_op0_n100_an_s0p1_r100k)=0 v(rbl_op0_n100_an_s0p1_r100k)=1.8 v(ref_op0_n100_an_s0p1_r100k)=0
.ic v(sn_op0_n100_an_s0p1_r100k_0)=-0.1 v(sn_op0_n100_an_s0p1_r100k_1)=-0.1 v(sn_op0_n100_an_s0p1_r100k_2)=-0.1 v(sn_op0_n100_an_s0p1_r100k_3)=-0.1 v(vn_op0_n100_an_s0p1_r100k)=0.45 v(vp_op0_n100_an_s0p1_r100k)=1.35
.ic v(wbl_op0_0000_an_s0p1_r100k)=0 v(rbl_op0_0000_an_s0p1_r100k)=1.8 v(ref_op0_0000_an_s0p1_r100k)=0 v(sn_op0_0000_an_s0p1_r100k_0)=0 v(sn_op0_0000_an_s0p1_r100k_1)=0 v(sn_op0_0000_an_s0p1_r100k_2)=0
.ic v(sn_op0_0000_an_s0p1_r100k_3)=0 v(vn_op0_0000_an_s0p1_r100k)=0.45 v(vp_op0_0000_an_s0p1_r100k)=1.35 v(wbl_op1_0900_an_s0p1_r300k)=0 v(rbl_op1_0900_an_s0p1_r300k)=1.8 v(ref_op1_0900_an_s0p1_r300k)=0
.ic v(sn_op1_0900_an_s0p1_r300k_0)=0.9 v(sn_op1_0900_an_s0p1_r300k_1)=0.9 v(sn_op1_0900_an_s0p1_r300k_2)=0.9 v(sn_op1_0900_an_s0p1_r300k_3)=0.9 v(vn_op1_0900_an_s0p1_r300k)=0.45 v(vp_op1_0900_an_s0p1_r300k)=1.35
.ic v(wbl_op1_1000_an_s0p1_r300k)=0 v(rbl_op1_1000_an_s0p1_r300k)=1.8 v(ref_op1_1000_an_s0p1_r300k)=0 v(sn_op1_1000_an_s0p1_r300k_0)=1 v(sn_op1_1000_an_s0p1_r300k_1)=1 v(sn_op1_1000_an_s0p1_r300k_2)=1
.ic v(sn_op1_1000_an_s0p1_r300k_3)=1 v(vn_op1_1000_an_s0p1_r300k)=0.45 v(vp_op1_1000_an_s0p1_r300k)=1.35 v(wbl_op0_n100_an_s0p1_r300k)=0 v(rbl_op0_n100_an_s0p1_r300k)=1.8 v(ref_op0_n100_an_s0p1_r300k)=0
.ic v(sn_op0_n100_an_s0p1_r300k_0)=-0.1 v(sn_op0_n100_an_s0p1_r300k_1)=-0.1 v(sn_op0_n100_an_s0p1_r300k_2)=-0.1 v(sn_op0_n100_an_s0p1_r300k_3)=-0.1 v(vn_op0_n100_an_s0p1_r300k)=0.45 v(vp_op0_n100_an_s0p1_r300k)=1.35
.ic v(wbl_op0_0000_an_s0p1_r300k)=0 v(rbl_op0_0000_an_s0p1_r300k)=1.8 v(ref_op0_0000_an_s0p1_r300k)=0 v(sn_op0_0000_an_s0p1_r300k_0)=0 v(sn_op0_0000_an_s0p1_r300k_1)=0 v(sn_op0_0000_an_s0p1_r300k_2)=0
.ic v(sn_op0_0000_an_s0p1_r300k_3)=0 v(vn_op0_0000_an_s0p1_r300k)=0.45 v(vp_op0_0000_an_s0p1_r300k)=1.35 v(wbl_op1_0900_an_s0p1_r1000k)=0 v(rbl_op1_0900_an_s0p1_r1000k)=1.8 v(ref_op1_0900_an_s0p1_r1000k)=0
.ic v(sn_op1_0900_an_s0p1_r1000k_0)=0.9 v(sn_op1_0900_an_s0p1_r1000k_1)=0.9 v(sn_op1_0900_an_s0p1_r1000k_2)=0.9 v(sn_op1_0900_an_s0p1_r1000k_3)=0.9 v(vn_op1_0900_an_s0p1_r1000k)=0.45 v(vp_op1_0900_an_s0p1_r1000k)=1.35
.ic v(wbl_op1_1000_an_s0p1_r1000k)=0 v(rbl_op1_1000_an_s0p1_r1000k)=1.8 v(ref_op1_1000_an_s0p1_r1000k)=0 v(sn_op1_1000_an_s0p1_r1000k_0)=1 v(sn_op1_1000_an_s0p1_r1000k_1)=1 v(sn_op1_1000_an_s0p1_r1000k_2)=1
.ic v(sn_op1_1000_an_s0p1_r1000k_3)=1 v(vn_op1_1000_an_s0p1_r1000k)=0.45 v(vp_op1_1000_an_s0p1_r1000k)=1.35 v(wbl_op0_n100_an_s0p1_r1000k)=0 v(rbl_op0_n100_an_s0p1_r1000k)=1.8 v(ref_op0_n100_an_s0p1_r1000k)=0
.ic v(sn_op0_n100_an_s0p1_r1000k_0)=-0.1 v(sn_op0_n100_an_s0p1_r1000k_1)=-0.1 v(sn_op0_n100_an_s0p1_r1000k_2)=-0.1 v(sn_op0_n100_an_s0p1_r1000k_3)=-0.1 v(vn_op0_n100_an_s0p1_r1000k)=0.45 v(vp_op0_n100_an_s0p1_r1000k)=1.35
.ic v(wbl_op0_0000_an_s0p1_r1000k)=0 v(rbl_op0_0000_an_s0p1_r1000k)=1.8 v(ref_op0_0000_an_s0p1_r1000k)=0 v(sn_op0_0000_an_s0p1_r1000k_0)=0 v(sn_op0_0000_an_s0p1_r1000k_1)=0 v(sn_op0_0000_an_s0p1_r1000k_2)=0
.ic v(sn_op0_0000_an_s0p1_r1000k_3)=0 v(vn_op0_0000_an_s0p1_r1000k)=0.45 v(vp_op0_0000_an_s0p1_r1000k)=1.35 v(wbl_op1_0900_an_s1_r10k)=0 v(rbl_op1_0900_an_s1_r10k)=1.8 v(ref_op1_0900_an_s1_r10k)=0
.ic v(sn_op1_0900_an_s1_r10k_0)=0.9 v(sn_op1_0900_an_s1_r10k_1)=0.9 v(sn_op1_0900_an_s1_r10k_2)=0.9 v(sn_op1_0900_an_s1_r10k_3)=0.9 v(vn_op1_0900_an_s1_r10k)=0.45 v(vp_op1_0900_an_s1_r10k)=1.35
.ic v(wbl_op1_1000_an_s1_r10k)=0 v(rbl_op1_1000_an_s1_r10k)=1.8 v(ref_op1_1000_an_s1_r10k)=0 v(sn_op1_1000_an_s1_r10k_0)=1 v(sn_op1_1000_an_s1_r10k_1)=1 v(sn_op1_1000_an_s1_r10k_2)=1
.ic v(sn_op1_1000_an_s1_r10k_3)=1 v(vn_op1_1000_an_s1_r10k)=0.45 v(vp_op1_1000_an_s1_r10k)=1.35 v(wbl_op0_n100_an_s1_r10k)=0 v(rbl_op0_n100_an_s1_r10k)=1.8 v(ref_op0_n100_an_s1_r10k)=0
.ic v(sn_op0_n100_an_s1_r10k_0)=-0.1 v(sn_op0_n100_an_s1_r10k_1)=-0.1 v(sn_op0_n100_an_s1_r10k_2)=-0.1 v(sn_op0_n100_an_s1_r10k_3)=-0.1 v(vn_op0_n100_an_s1_r10k)=0.45 v(vp_op0_n100_an_s1_r10k)=1.35
.ic v(wbl_op0_0000_an_s1_r10k)=0 v(rbl_op0_0000_an_s1_r10k)=1.8 v(ref_op0_0000_an_s1_r10k)=0 v(sn_op0_0000_an_s1_r10k_0)=0 v(sn_op0_0000_an_s1_r10k_1)=0 v(sn_op0_0000_an_s1_r10k_2)=0
.ic v(sn_op0_0000_an_s1_r10k_3)=0 v(vn_op0_0000_an_s1_r10k)=0.45 v(vp_op0_0000_an_s1_r10k)=1.35 v(wbl_op1_0900_an_s1_r100k)=0 v(rbl_op1_0900_an_s1_r100k)=1.8 v(ref_op1_0900_an_s1_r100k)=0
.ic v(sn_op1_0900_an_s1_r100k_0)=0.9 v(sn_op1_0900_an_s1_r100k_1)=0.9 v(sn_op1_0900_an_s1_r100k_2)=0.9 v(sn_op1_0900_an_s1_r100k_3)=0.9 v(vn_op1_0900_an_s1_r100k)=0.45 v(vp_op1_0900_an_s1_r100k)=1.35
.ic v(wbl_op1_1000_an_s1_r100k)=0 v(rbl_op1_1000_an_s1_r100k)=1.8 v(ref_op1_1000_an_s1_r100k)=0 v(sn_op1_1000_an_s1_r100k_0)=1 v(sn_op1_1000_an_s1_r100k_1)=1 v(sn_op1_1000_an_s1_r100k_2)=1
.ic v(sn_op1_1000_an_s1_r100k_3)=1 v(vn_op1_1000_an_s1_r100k)=0.45 v(vp_op1_1000_an_s1_r100k)=1.35 v(wbl_op0_n100_an_s1_r100k)=0 v(rbl_op0_n100_an_s1_r100k)=1.8 v(ref_op0_n100_an_s1_r100k)=0
.ic v(sn_op0_n100_an_s1_r100k_0)=-0.1 v(sn_op0_n100_an_s1_r100k_1)=-0.1 v(sn_op0_n100_an_s1_r100k_2)=-0.1 v(sn_op0_n100_an_s1_r100k_3)=-0.1 v(vn_op0_n100_an_s1_r100k)=0.45 v(vp_op0_n100_an_s1_r100k)=1.35
.ic v(wbl_op0_0000_an_s1_r100k)=0 v(rbl_op0_0000_an_s1_r100k)=1.8 v(ref_op0_0000_an_s1_r100k)=0 v(sn_op0_0000_an_s1_r100k_0)=0 v(sn_op0_0000_an_s1_r100k_1)=0 v(sn_op0_0000_an_s1_r100k_2)=0
.ic v(sn_op0_0000_an_s1_r100k_3)=0 v(vn_op0_0000_an_s1_r100k)=0.45 v(vp_op0_0000_an_s1_r100k)=1.35 v(wbl_op1_0900_an_s2_r10k)=0 v(rbl_op1_0900_an_s2_r10k)=1.8 v(ref_op1_0900_an_s2_r10k)=0
.ic v(sn_op1_0900_an_s2_r10k_0)=0.9 v(sn_op1_0900_an_s2_r10k_1)=0.9 v(sn_op1_0900_an_s2_r10k_2)=0.9 v(sn_op1_0900_an_s2_r10k_3)=0.9 v(vn_op1_0900_an_s2_r10k)=0.45 v(vp_op1_0900_an_s2_r10k)=1.35
.ic v(wbl_op1_1000_an_s2_r10k)=0 v(rbl_op1_1000_an_s2_r10k)=1.8 v(ref_op1_1000_an_s2_r10k)=0 v(sn_op1_1000_an_s2_r10k_0)=1 v(sn_op1_1000_an_s2_r10k_1)=1 v(sn_op1_1000_an_s2_r10k_2)=1
.ic v(sn_op1_1000_an_s2_r10k_3)=1 v(vn_op1_1000_an_s2_r10k)=0.45 v(vp_op1_1000_an_s2_r10k)=1.35 v(wbl_op0_n100_an_s2_r10k)=0 v(rbl_op0_n100_an_s2_r10k)=1.8 v(ref_op0_n100_an_s2_r10k)=0
.ic v(sn_op0_n100_an_s2_r10k_0)=-0.1 v(sn_op0_n100_an_s2_r10k_1)=-0.1 v(sn_op0_n100_an_s2_r10k_2)=-0.1 v(sn_op0_n100_an_s2_r10k_3)=-0.1 v(vn_op0_n100_an_s2_r10k)=0.45 v(vp_op0_n100_an_s2_r10k)=1.35
.ic v(wbl_op0_0000_an_s2_r10k)=0 v(rbl_op0_0000_an_s2_r10k)=1.8 v(ref_op0_0000_an_s2_r10k)=0 v(sn_op0_0000_an_s2_r10k_0)=0 v(sn_op0_0000_an_s2_r10k_1)=0 v(sn_op0_0000_an_s2_r10k_2)=0
.ic v(sn_op0_0000_an_s2_r10k_3)=0 v(vn_op0_0000_an_s2_r10k)=0.45 v(vp_op0_0000_an_s2_r10k)=1.35 v(wbl_op1_0900_an_s2_r100k)=0 v(rbl_op1_0900_an_s2_r100k)=1.8 v(ref_op1_0900_an_s2_r100k)=0
.ic v(sn_op1_0900_an_s2_r100k_0)=0.9 v(sn_op1_0900_an_s2_r100k_1)=0.9 v(sn_op1_0900_an_s2_r100k_2)=0.9 v(sn_op1_0900_an_s2_r100k_3)=0.9 v(vn_op1_0900_an_s2_r100k)=0.45 v(vp_op1_0900_an_s2_r100k)=1.35
.ic v(wbl_op1_1000_an_s2_r100k)=0 v(rbl_op1_1000_an_s2_r100k)=1.8 v(ref_op1_1000_an_s2_r100k)=0 v(sn_op1_1000_an_s2_r100k_0)=1 v(sn_op1_1000_an_s2_r100k_1)=1 v(sn_op1_1000_an_s2_r100k_2)=1
.ic v(sn_op1_1000_an_s2_r100k_3)=1 v(vn_op1_1000_an_s2_r100k)=0.45 v(vp_op1_1000_an_s2_r100k)=1.35 v(wbl_op0_n100_an_s2_r100k)=0 v(rbl_op0_n100_an_s2_r100k)=1.8 v(ref_op0_n100_an_s2_r100k)=0
.ic v(sn_op0_n100_an_s2_r100k_0)=-0.1 v(sn_op0_n100_an_s2_r100k_1)=-0.1 v(sn_op0_n100_an_s2_r100k_2)=-0.1 v(sn_op0_n100_an_s2_r100k_3)=-0.1 v(vn_op0_n100_an_s2_r100k)=0.45 v(vp_op0_n100_an_s2_r100k)=1.35
.ic v(wbl_op0_0000_an_s2_r100k)=0 v(rbl_op0_0000_an_s2_r100k)=1.8 v(ref_op0_0000_an_s2_r100k)=0 v(sn_op0_0000_an_s2_r100k_0)=0 v(sn_op0_0000_an_s2_r100k_1)=0 v(sn_op0_0000_an_s2_r100k_2)=0
.ic v(sn_op0_0000_an_s2_r100k_3)=0 v(vn_op0_0000_an_s2_r100k)=0.45 v(vp_op0_0000_an_s2_r100k)=1.35 v(wbl_op1_0900_rh_s0p5_r0)=0 v(rbl_op1_0900_rh_s0p5_r0)=1.8 v(ref_op1_0900_rh_s0p5_r0)=0
.ic v(sn_op1_0900_rh_s0p5_r0_0)=0.9 v(sn_op1_0900_rh_s0p5_r0_1)=0.9 v(sn_op1_0900_rh_s0p5_r0_2)=0.9 v(sn_op1_0900_rh_s0p5_r0_3)=0.9 v(vn_op1_0900_rh_s0p5_r0)=0.45 v(vp_op1_0900_rh_s0p5_r0)=1.35
.ic v(wbl_op1_1000_rh_s0p5_r0)=0 v(rbl_op1_1000_rh_s0p5_r0)=1.8 v(ref_op1_1000_rh_s0p5_r0)=0 v(sn_op1_1000_rh_s0p5_r0_0)=1 v(sn_op1_1000_rh_s0p5_r0_1)=1 v(sn_op1_1000_rh_s0p5_r0_2)=1
.ic v(sn_op1_1000_rh_s0p5_r0_3)=1 v(vn_op1_1000_rh_s0p5_r0)=0.45 v(vp_op1_1000_rh_s0p5_r0)=1.35 v(wbl_op0_n100_rh_s0p5_r0)=0 v(rbl_op0_n100_rh_s0p5_r0)=1.8 v(ref_op0_n100_rh_s0p5_r0)=0
.ic v(sn_op0_n100_rh_s0p5_r0_0)=-0.1 v(sn_op0_n100_rh_s0p5_r0_1)=-0.1 v(sn_op0_n100_rh_s0p5_r0_2)=-0.1 v(sn_op0_n100_rh_s0p5_r0_3)=-0.1 v(vn_op0_n100_rh_s0p5_r0)=0.45 v(vp_op0_n100_rh_s0p5_r0)=1.35
.ic v(wbl_op0_0000_rh_s0p5_r0)=0 v(rbl_op0_0000_rh_s0p5_r0)=1.8 v(ref_op0_0000_rh_s0p5_r0)=0 v(sn_op0_0000_rh_s0p5_r0_0)=0 v(sn_op0_0000_rh_s0p5_r0_1)=0 v(sn_op0_0000_rh_s0p5_r0_2)=0
.ic v(sn_op0_0000_rh_s0p5_r0_3)=0 v(vn_op0_0000_rh_s0p5_r0)=0.45 v(vp_op0_0000_rh_s0p5_r0)=1.35 v(wbl_op1_0900_rh_s1_r0)=0 v(rbl_op1_0900_rh_s1_r0)=1.8 v(ref_op1_0900_rh_s1_r0)=0
.ic v(sn_op1_0900_rh_s1_r0_0)=0.9 v(sn_op1_0900_rh_s1_r0_1)=0.9 v(sn_op1_0900_rh_s1_r0_2)=0.9 v(sn_op1_0900_rh_s1_r0_3)=0.9 v(vn_op1_0900_rh_s1_r0)=0.45 v(vp_op1_0900_rh_s1_r0)=1.35
.ic v(wbl_op1_1000_rh_s1_r0)=0 v(rbl_op1_1000_rh_s1_r0)=1.8 v(ref_op1_1000_rh_s1_r0)=0 v(sn_op1_1000_rh_s1_r0_0)=1 v(sn_op1_1000_rh_s1_r0_1)=1 v(sn_op1_1000_rh_s1_r0_2)=1
.ic v(sn_op1_1000_rh_s1_r0_3)=1 v(vn_op1_1000_rh_s1_r0)=0.45 v(vp_op1_1000_rh_s1_r0)=1.35 v(wbl_op0_n100_rh_s1_r0)=0 v(rbl_op0_n100_rh_s1_r0)=1.8 v(ref_op0_n100_rh_s1_r0)=0
.ic v(sn_op0_n100_rh_s1_r0_0)=-0.1 v(sn_op0_n100_rh_s1_r0_1)=-0.1 v(sn_op0_n100_rh_s1_r0_2)=-0.1 v(sn_op0_n100_rh_s1_r0_3)=-0.1 v(vn_op0_n100_rh_s1_r0)=0.45 v(vp_op0_n100_rh_s1_r0)=1.35
.ic v(wbl_op0_0000_rh_s1_r0)=0 v(rbl_op0_0000_rh_s1_r0)=1.8 v(ref_op0_0000_rh_s1_r0)=0 v(sn_op0_0000_rh_s1_r0_0)=0 v(sn_op0_0000_rh_s1_r0_1)=0 v(sn_op0_0000_rh_s1_r0_2)=0
.ic v(sn_op0_0000_rh_s1_r0_3)=0 v(vn_op0_0000_rh_s1_r0)=0.45 v(vp_op0_0000_rh_s1_r0)=1.35 v(wbl_op1_0900_rh_s2_r0)=0 v(rbl_op1_0900_rh_s2_r0)=1.8 v(ref_op1_0900_rh_s2_r0)=0
.ic v(sn_op1_0900_rh_s2_r0_0)=0.9 v(sn_op1_0900_rh_s2_r0_1)=0.9 v(sn_op1_0900_rh_s2_r0_2)=0.9 v(sn_op1_0900_rh_s2_r0_3)=0.9 v(vn_op1_0900_rh_s2_r0)=0.45 v(vp_op1_0900_rh_s2_r0)=1.35
.ic v(wbl_op1_1000_rh_s2_r0)=0 v(rbl_op1_1000_rh_s2_r0)=1.8 v(ref_op1_1000_rh_s2_r0)=0 v(sn_op1_1000_rh_s2_r0_0)=1 v(sn_op1_1000_rh_s2_r0_1)=1 v(sn_op1_1000_rh_s2_r0_2)=1
.ic v(sn_op1_1000_rh_s2_r0_3)=1 v(vn_op1_1000_rh_s2_r0)=0.45 v(vp_op1_1000_rh_s2_r0)=1.35 v(wbl_op0_n100_rh_s2_r0)=0 v(rbl_op0_n100_rh_s2_r0)=1.8 v(ref_op0_n100_rh_s2_r0)=0
.ic v(sn_op0_n100_rh_s2_r0_0)=-0.1 v(sn_op0_n100_rh_s2_r0_1)=-0.1 v(sn_op0_n100_rh_s2_r0_2)=-0.1 v(sn_op0_n100_rh_s2_r0_3)=-0.1 v(vn_op0_n100_rh_s2_r0)=0.45 v(vp_op0_n100_rh_s2_r0)=1.35
.ic v(wbl_op0_0000_rh_s2_r0)=0 v(rbl_op0_0000_rh_s2_r0)=1.8 v(ref_op0_0000_rh_s2_r0)=0 v(sn_op0_0000_rh_s2_r0_0)=0 v(sn_op0_0000_rh_s2_r0_1)=0 v(sn_op0_0000_rh_s2_r0_2)=0
.ic v(sn_op0_0000_rh_s2_r0_3)=0 v(vn_op0_0000_rh_s2_r0)=0.45 v(vp_op0_0000_rh_s2_r0)=1.35 v(wbl_op1_0900_rh_s5_r0)=0 v(rbl_op1_0900_rh_s5_r0)=1.8 v(ref_op1_0900_rh_s5_r0)=0
.ic v(sn_op1_0900_rh_s5_r0_0)=0.9 v(sn_op1_0900_rh_s5_r0_1)=0.9 v(sn_op1_0900_rh_s5_r0_2)=0.9 v(sn_op1_0900_rh_s5_r0_3)=0.9 v(vn_op1_0900_rh_s5_r0)=0.45 v(vp_op1_0900_rh_s5_r0)=1.35
.ic v(wbl_op1_1000_rh_s5_r0)=0 v(rbl_op1_1000_rh_s5_r0)=1.8 v(ref_op1_1000_rh_s5_r0)=0 v(sn_op1_1000_rh_s5_r0_0)=1 v(sn_op1_1000_rh_s5_r0_1)=1 v(sn_op1_1000_rh_s5_r0_2)=1
.ic v(sn_op1_1000_rh_s5_r0_3)=1 v(vn_op1_1000_rh_s5_r0)=0.45 v(vp_op1_1000_rh_s5_r0)=1.35 v(wbl_op0_n100_rh_s5_r0)=0 v(rbl_op0_n100_rh_s5_r0)=1.8 v(ref_op0_n100_rh_s5_r0)=0
.ic v(sn_op0_n100_rh_s5_r0_0)=-0.1 v(sn_op0_n100_rh_s5_r0_1)=-0.1 v(sn_op0_n100_rh_s5_r0_2)=-0.1 v(sn_op0_n100_rh_s5_r0_3)=-0.1 v(vn_op0_n100_rh_s5_r0)=0.45 v(vp_op0_n100_rh_s5_r0)=1.35
.ic v(wbl_op0_0000_rh_s5_r0)=0 v(rbl_op0_0000_rh_s5_r0)=1.8 v(ref_op0_0000_rh_s5_r0)=0 v(sn_op0_0000_rh_s5_r0_0)=0 v(sn_op0_0000_rh_s5_r0_1)=0 v(sn_op0_0000_rh_s5_r0_2)=0
.ic v(sn_op0_0000_rh_s5_r0_3)=0 v(vn_op0_0000_rh_s5_r0)=0.45 v(vp_op0_0000_rh_s5_r0)=1.35 v(wbl_op1_0900_rh_s0p1_r1k)=0 v(rbl_op1_0900_rh_s0p1_r1k)=1.8 v(ref_op1_0900_rh_s0p1_r1k)=0
.ic v(sn_op1_0900_rh_s0p1_r1k_0)=0.9 v(sn_op1_0900_rh_s0p1_r1k_1)=0.9 v(sn_op1_0900_rh_s0p1_r1k_2)=0.9 v(sn_op1_0900_rh_s0p1_r1k_3)=0.9 v(vn_op1_0900_rh_s0p1_r1k)=0.45 v(vp_op1_0900_rh_s0p1_r1k)=1.35
.ic v(wbl_op1_1000_rh_s0p1_r1k)=0 v(rbl_op1_1000_rh_s0p1_r1k)=1.8 v(ref_op1_1000_rh_s0p1_r1k)=0 v(sn_op1_1000_rh_s0p1_r1k_0)=1 v(sn_op1_1000_rh_s0p1_r1k_1)=1 v(sn_op1_1000_rh_s0p1_r1k_2)=1
.ic v(sn_op1_1000_rh_s0p1_r1k_3)=1 v(vn_op1_1000_rh_s0p1_r1k)=0.45 v(vp_op1_1000_rh_s0p1_r1k)=1.35 v(wbl_op0_n100_rh_s0p1_r1k)=0 v(rbl_op0_n100_rh_s0p1_r1k)=1.8 v(ref_op0_n100_rh_s0p1_r1k)=0
.ic v(sn_op0_n100_rh_s0p1_r1k_0)=-0.1 v(sn_op0_n100_rh_s0p1_r1k_1)=-0.1 v(sn_op0_n100_rh_s0p1_r1k_2)=-0.1 v(sn_op0_n100_rh_s0p1_r1k_3)=-0.1 v(vn_op0_n100_rh_s0p1_r1k)=0.45 v(vp_op0_n100_rh_s0p1_r1k)=1.35
.ic v(wbl_op0_0000_rh_s0p1_r1k)=0 v(rbl_op0_0000_rh_s0p1_r1k)=1.8 v(ref_op0_0000_rh_s0p1_r1k)=0 v(sn_op0_0000_rh_s0p1_r1k_0)=0 v(sn_op0_0000_rh_s0p1_r1k_1)=0 v(sn_op0_0000_rh_s0p1_r1k_2)=0
.ic v(sn_op0_0000_rh_s0p1_r1k_3)=0 v(vn_op0_0000_rh_s0p1_r1k)=0.45 v(vp_op0_0000_rh_s0p1_r1k)=1.35 v(wbl_op1_0900_rh_s0p1_r3k)=0 v(rbl_op1_0900_rh_s0p1_r3k)=1.8 v(ref_op1_0900_rh_s0p1_r3k)=0
.ic v(sn_op1_0900_rh_s0p1_r3k_0)=0.9 v(sn_op1_0900_rh_s0p1_r3k_1)=0.9 v(sn_op1_0900_rh_s0p1_r3k_2)=0.9 v(sn_op1_0900_rh_s0p1_r3k_3)=0.9 v(vn_op1_0900_rh_s0p1_r3k)=0.45 v(vp_op1_0900_rh_s0p1_r3k)=1.35
.ic v(wbl_op1_1000_rh_s0p1_r3k)=0 v(rbl_op1_1000_rh_s0p1_r3k)=1.8 v(ref_op1_1000_rh_s0p1_r3k)=0 v(sn_op1_1000_rh_s0p1_r3k_0)=1 v(sn_op1_1000_rh_s0p1_r3k_1)=1 v(sn_op1_1000_rh_s0p1_r3k_2)=1
.ic v(sn_op1_1000_rh_s0p1_r3k_3)=1 v(vn_op1_1000_rh_s0p1_r3k)=0.45 v(vp_op1_1000_rh_s0p1_r3k)=1.35 v(wbl_op0_n100_rh_s0p1_r3k)=0 v(rbl_op0_n100_rh_s0p1_r3k)=1.8 v(ref_op0_n100_rh_s0p1_r3k)=0
.ic v(sn_op0_n100_rh_s0p1_r3k_0)=-0.1 v(sn_op0_n100_rh_s0p1_r3k_1)=-0.1 v(sn_op0_n100_rh_s0p1_r3k_2)=-0.1 v(sn_op0_n100_rh_s0p1_r3k_3)=-0.1 v(vn_op0_n100_rh_s0p1_r3k)=0.45 v(vp_op0_n100_rh_s0p1_r3k)=1.35
.ic v(wbl_op0_0000_rh_s0p1_r3k)=0 v(rbl_op0_0000_rh_s0p1_r3k)=1.8 v(ref_op0_0000_rh_s0p1_r3k)=0 v(sn_op0_0000_rh_s0p1_r3k_0)=0 v(sn_op0_0000_rh_s0p1_r3k_1)=0 v(sn_op0_0000_rh_s0p1_r3k_2)=0
.ic v(sn_op0_0000_rh_s0p1_r3k_3)=0 v(vn_op0_0000_rh_s0p1_r3k)=0.45 v(vp_op0_0000_rh_s0p1_r3k)=1.35 v(wbl_op1_0900_rh_s0p1_r10k)=0 v(rbl_op1_0900_rh_s0p1_r10k)=1.8 v(ref_op1_0900_rh_s0p1_r10k)=0
.ic v(sn_op1_0900_rh_s0p1_r10k_0)=0.9 v(sn_op1_0900_rh_s0p1_r10k_1)=0.9 v(sn_op1_0900_rh_s0p1_r10k_2)=0.9 v(sn_op1_0900_rh_s0p1_r10k_3)=0.9 v(vn_op1_0900_rh_s0p1_r10k)=0.45 v(vp_op1_0900_rh_s0p1_r10k)=1.35
.ic v(wbl_op1_1000_rh_s0p1_r10k)=0 v(rbl_op1_1000_rh_s0p1_r10k)=1.8 v(ref_op1_1000_rh_s0p1_r10k)=0 v(sn_op1_1000_rh_s0p1_r10k_0)=1 v(sn_op1_1000_rh_s0p1_r10k_1)=1 v(sn_op1_1000_rh_s0p1_r10k_2)=1
.ic v(sn_op1_1000_rh_s0p1_r10k_3)=1 v(vn_op1_1000_rh_s0p1_r10k)=0.45 v(vp_op1_1000_rh_s0p1_r10k)=1.35 v(wbl_op0_n100_rh_s0p1_r10k)=0 v(rbl_op0_n100_rh_s0p1_r10k)=1.8 v(ref_op0_n100_rh_s0p1_r10k)=0
.ic v(sn_op0_n100_rh_s0p1_r10k_0)=-0.1 v(sn_op0_n100_rh_s0p1_r10k_1)=-0.1 v(sn_op0_n100_rh_s0p1_r10k_2)=-0.1 v(sn_op0_n100_rh_s0p1_r10k_3)=-0.1 v(vn_op0_n100_rh_s0p1_r10k)=0.45 v(vp_op0_n100_rh_s0p1_r10k)=1.35
.ic v(wbl_op0_0000_rh_s0p1_r10k)=0 v(rbl_op0_0000_rh_s0p1_r10k)=1.8 v(ref_op0_0000_rh_s0p1_r10k)=0 v(sn_op0_0000_rh_s0p1_r10k_0)=0 v(sn_op0_0000_rh_s0p1_r10k_1)=0 v(sn_op0_0000_rh_s0p1_r10k_2)=0
.ic v(sn_op0_0000_rh_s0p1_r10k_3)=0 v(vn_op0_0000_rh_s0p1_r10k)=0.45 v(vp_op0_0000_rh_s0p1_r10k)=1.35 v(wbl_op1_0900_rh_s0p1_r30k)=0 v(rbl_op1_0900_rh_s0p1_r30k)=1.8 v(ref_op1_0900_rh_s0p1_r30k)=0
.ic v(sn_op1_0900_rh_s0p1_r30k_0)=0.9 v(sn_op1_0900_rh_s0p1_r30k_1)=0.9 v(sn_op1_0900_rh_s0p1_r30k_2)=0.9 v(sn_op1_0900_rh_s0p1_r30k_3)=0.9 v(vn_op1_0900_rh_s0p1_r30k)=0.45 v(vp_op1_0900_rh_s0p1_r30k)=1.35
.ic v(wbl_op1_1000_rh_s0p1_r30k)=0 v(rbl_op1_1000_rh_s0p1_r30k)=1.8 v(ref_op1_1000_rh_s0p1_r30k)=0 v(sn_op1_1000_rh_s0p1_r30k_0)=1 v(sn_op1_1000_rh_s0p1_r30k_1)=1 v(sn_op1_1000_rh_s0p1_r30k_2)=1
.ic v(sn_op1_1000_rh_s0p1_r30k_3)=1 v(vn_op1_1000_rh_s0p1_r30k)=0.45 v(vp_op1_1000_rh_s0p1_r30k)=1.35 v(wbl_op0_n100_rh_s0p1_r30k)=0 v(rbl_op0_n100_rh_s0p1_r30k)=1.8 v(ref_op0_n100_rh_s0p1_r30k)=0
.ic v(sn_op0_n100_rh_s0p1_r30k_0)=-0.1 v(sn_op0_n100_rh_s0p1_r30k_1)=-0.1 v(sn_op0_n100_rh_s0p1_r30k_2)=-0.1 v(sn_op0_n100_rh_s0p1_r30k_3)=-0.1 v(vn_op0_n100_rh_s0p1_r30k)=0.45 v(vp_op0_n100_rh_s0p1_r30k)=1.35
.ic v(wbl_op0_0000_rh_s0p1_r30k)=0 v(rbl_op0_0000_rh_s0p1_r30k)=1.8 v(ref_op0_0000_rh_s0p1_r30k)=0 v(sn_op0_0000_rh_s0p1_r30k_0)=0 v(sn_op0_0000_rh_s0p1_r30k_1)=0 v(sn_op0_0000_rh_s0p1_r30k_2)=0
.ic v(sn_op0_0000_rh_s0p1_r30k_3)=0 v(vn_op0_0000_rh_s0p1_r30k)=0.45 v(vp_op0_0000_rh_s0p1_r30k)=1.35 v(wbl_op1_0900_rh_s0p1_r100k)=0 v(rbl_op1_0900_rh_s0p1_r100k)=1.8 v(ref_op1_0900_rh_s0p1_r100k)=0
.ic v(sn_op1_0900_rh_s0p1_r100k_0)=0.9 v(sn_op1_0900_rh_s0p1_r100k_1)=0.9 v(sn_op1_0900_rh_s0p1_r100k_2)=0.9 v(sn_op1_0900_rh_s0p1_r100k_3)=0.9 v(vn_op1_0900_rh_s0p1_r100k)=0.45 v(vp_op1_0900_rh_s0p1_r100k)=1.35
.ic v(wbl_op1_1000_rh_s0p1_r100k)=0 v(rbl_op1_1000_rh_s0p1_r100k)=1.8 v(ref_op1_1000_rh_s0p1_r100k)=0 v(sn_op1_1000_rh_s0p1_r100k_0)=1 v(sn_op1_1000_rh_s0p1_r100k_1)=1 v(sn_op1_1000_rh_s0p1_r100k_2)=1
.ic v(sn_op1_1000_rh_s0p1_r100k_3)=1 v(vn_op1_1000_rh_s0p1_r100k)=0.45 v(vp_op1_1000_rh_s0p1_r100k)=1.35 v(wbl_op0_n100_rh_s0p1_r100k)=0 v(rbl_op0_n100_rh_s0p1_r100k)=1.8 v(ref_op0_n100_rh_s0p1_r100k)=0
.ic v(sn_op0_n100_rh_s0p1_r100k_0)=-0.1 v(sn_op0_n100_rh_s0p1_r100k_1)=-0.1 v(sn_op0_n100_rh_s0p1_r100k_2)=-0.1 v(sn_op0_n100_rh_s0p1_r100k_3)=-0.1 v(vn_op0_n100_rh_s0p1_r100k)=0.45 v(vp_op0_n100_rh_s0p1_r100k)=1.35
.ic v(wbl_op0_0000_rh_s0p1_r100k)=0 v(rbl_op0_0000_rh_s0p1_r100k)=1.8 v(ref_op0_0000_rh_s0p1_r100k)=0 v(sn_op0_0000_rh_s0p1_r100k_0)=0 v(sn_op0_0000_rh_s0p1_r100k_1)=0 v(sn_op0_0000_rh_s0p1_r100k_2)=0
.ic v(sn_op0_0000_rh_s0p1_r100k_3)=0 v(vn_op0_0000_rh_s0p1_r100k)=0.45 v(vp_op0_0000_rh_s0p1_r100k)=1.35 v(wbl_op1_0900_rh_s0p1_r300k)=0 v(rbl_op1_0900_rh_s0p1_r300k)=1.8 v(ref_op1_0900_rh_s0p1_r300k)=0
.ic v(sn_op1_0900_rh_s0p1_r300k_0)=0.9 v(sn_op1_0900_rh_s0p1_r300k_1)=0.9 v(sn_op1_0900_rh_s0p1_r300k_2)=0.9 v(sn_op1_0900_rh_s0p1_r300k_3)=0.9 v(vn_op1_0900_rh_s0p1_r300k)=0.45 v(vp_op1_0900_rh_s0p1_r300k)=1.35
.ic v(wbl_op1_1000_rh_s0p1_r300k)=0 v(rbl_op1_1000_rh_s0p1_r300k)=1.8 v(ref_op1_1000_rh_s0p1_r300k)=0 v(sn_op1_1000_rh_s0p1_r300k_0)=1 v(sn_op1_1000_rh_s0p1_r300k_1)=1 v(sn_op1_1000_rh_s0p1_r300k_2)=1
.ic v(sn_op1_1000_rh_s0p1_r300k_3)=1 v(vn_op1_1000_rh_s0p1_r300k)=0.45 v(vp_op1_1000_rh_s0p1_r300k)=1.35 v(wbl_op0_n100_rh_s0p1_r300k)=0 v(rbl_op0_n100_rh_s0p1_r300k)=1.8 v(ref_op0_n100_rh_s0p1_r300k)=0
.ic v(sn_op0_n100_rh_s0p1_r300k_0)=-0.1 v(sn_op0_n100_rh_s0p1_r300k_1)=-0.1 v(sn_op0_n100_rh_s0p1_r300k_2)=-0.1 v(sn_op0_n100_rh_s0p1_r300k_3)=-0.1 v(vn_op0_n100_rh_s0p1_r300k)=0.45 v(vp_op0_n100_rh_s0p1_r300k)=1.35
.ic v(wbl_op0_0000_rh_s0p1_r300k)=0 v(rbl_op0_0000_rh_s0p1_r300k)=1.8 v(ref_op0_0000_rh_s0p1_r300k)=0 v(sn_op0_0000_rh_s0p1_r300k_0)=0 v(sn_op0_0000_rh_s0p1_r300k_1)=0 v(sn_op0_0000_rh_s0p1_r300k_2)=0
.ic v(sn_op0_0000_rh_s0p1_r300k_3)=0 v(vn_op0_0000_rh_s0p1_r300k)=0.45 v(vp_op0_0000_rh_s0p1_r300k)=1.35 v(wbl_op1_0900_rh_s0p1_r1000k)=0 v(rbl_op1_0900_rh_s0p1_r1000k)=1.8 v(ref_op1_0900_rh_s0p1_r1000k)=0
.ic v(sn_op1_0900_rh_s0p1_r1000k_0)=0.9 v(sn_op1_0900_rh_s0p1_r1000k_1)=0.9 v(sn_op1_0900_rh_s0p1_r1000k_2)=0.9 v(sn_op1_0900_rh_s0p1_r1000k_3)=0.9 v(vn_op1_0900_rh_s0p1_r1000k)=0.45 v(vp_op1_0900_rh_s0p1_r1000k)=1.35
.ic v(wbl_op1_1000_rh_s0p1_r1000k)=0 v(rbl_op1_1000_rh_s0p1_r1000k)=1.8 v(ref_op1_1000_rh_s0p1_r1000k)=0 v(sn_op1_1000_rh_s0p1_r1000k_0)=1 v(sn_op1_1000_rh_s0p1_r1000k_1)=1 v(sn_op1_1000_rh_s0p1_r1000k_2)=1
.ic v(sn_op1_1000_rh_s0p1_r1000k_3)=1 v(vn_op1_1000_rh_s0p1_r1000k)=0.45 v(vp_op1_1000_rh_s0p1_r1000k)=1.35 v(wbl_op0_n100_rh_s0p1_r1000k)=0 v(rbl_op0_n100_rh_s0p1_r1000k)=1.8 v(ref_op0_n100_rh_s0p1_r1000k)=0
.ic v(sn_op0_n100_rh_s0p1_r1000k_0)=-0.1 v(sn_op0_n100_rh_s0p1_r1000k_1)=-0.1 v(sn_op0_n100_rh_s0p1_r1000k_2)=-0.1 v(sn_op0_n100_rh_s0p1_r1000k_3)=-0.1 v(vn_op0_n100_rh_s0p1_r1000k)=0.45 v(vp_op0_n100_rh_s0p1_r1000k)=1.35
.ic v(wbl_op0_0000_rh_s0p1_r1000k)=0 v(rbl_op0_0000_rh_s0p1_r1000k)=1.8 v(ref_op0_0000_rh_s0p1_r1000k)=0 v(sn_op0_0000_rh_s0p1_r1000k_0)=0 v(sn_op0_0000_rh_s0p1_r1000k_1)=0 v(sn_op0_0000_rh_s0p1_r1000k_2)=0
.ic v(sn_op0_0000_rh_s0p1_r1000k_3)=0 v(vn_op0_0000_rh_s0p1_r1000k)=0.45 v(vp_op0_0000_rh_s0p1_r1000k)=1.35 v(wbl_op1_0900_rh_s1_r10k)=0 v(rbl_op1_0900_rh_s1_r10k)=1.8 v(ref_op1_0900_rh_s1_r10k)=0
.ic v(sn_op1_0900_rh_s1_r10k_0)=0.9 v(sn_op1_0900_rh_s1_r10k_1)=0.9 v(sn_op1_0900_rh_s1_r10k_2)=0.9 v(sn_op1_0900_rh_s1_r10k_3)=0.9 v(vn_op1_0900_rh_s1_r10k)=0.45 v(vp_op1_0900_rh_s1_r10k)=1.35
.ic v(wbl_op1_1000_rh_s1_r10k)=0 v(rbl_op1_1000_rh_s1_r10k)=1.8 v(ref_op1_1000_rh_s1_r10k)=0 v(sn_op1_1000_rh_s1_r10k_0)=1 v(sn_op1_1000_rh_s1_r10k_1)=1 v(sn_op1_1000_rh_s1_r10k_2)=1
.ic v(sn_op1_1000_rh_s1_r10k_3)=1 v(vn_op1_1000_rh_s1_r10k)=0.45 v(vp_op1_1000_rh_s1_r10k)=1.35 v(wbl_op0_n100_rh_s1_r10k)=0 v(rbl_op0_n100_rh_s1_r10k)=1.8 v(ref_op0_n100_rh_s1_r10k)=0
.ic v(sn_op0_n100_rh_s1_r10k_0)=-0.1 v(sn_op0_n100_rh_s1_r10k_1)=-0.1 v(sn_op0_n100_rh_s1_r10k_2)=-0.1 v(sn_op0_n100_rh_s1_r10k_3)=-0.1 v(vn_op0_n100_rh_s1_r10k)=0.45 v(vp_op0_n100_rh_s1_r10k)=1.35
.ic v(wbl_op0_0000_rh_s1_r10k)=0 v(rbl_op0_0000_rh_s1_r10k)=1.8 v(ref_op0_0000_rh_s1_r10k)=0 v(sn_op0_0000_rh_s1_r10k_0)=0 v(sn_op0_0000_rh_s1_r10k_1)=0 v(sn_op0_0000_rh_s1_r10k_2)=0
.ic v(sn_op0_0000_rh_s1_r10k_3)=0 v(vn_op0_0000_rh_s1_r10k)=0.45 v(vp_op0_0000_rh_s1_r10k)=1.35 v(wbl_op1_0900_rh_s1_r100k)=0 v(rbl_op1_0900_rh_s1_r100k)=1.8 v(ref_op1_0900_rh_s1_r100k)=0
.ic v(sn_op1_0900_rh_s1_r100k_0)=0.9 v(sn_op1_0900_rh_s1_r100k_1)=0.9 v(sn_op1_0900_rh_s1_r100k_2)=0.9 v(sn_op1_0900_rh_s1_r100k_3)=0.9 v(vn_op1_0900_rh_s1_r100k)=0.45 v(vp_op1_0900_rh_s1_r100k)=1.35
.ic v(wbl_op1_1000_rh_s1_r100k)=0 v(rbl_op1_1000_rh_s1_r100k)=1.8 v(ref_op1_1000_rh_s1_r100k)=0 v(sn_op1_1000_rh_s1_r100k_0)=1 v(sn_op1_1000_rh_s1_r100k_1)=1 v(sn_op1_1000_rh_s1_r100k_2)=1
.ic v(sn_op1_1000_rh_s1_r100k_3)=1 v(vn_op1_1000_rh_s1_r100k)=0.45 v(vp_op1_1000_rh_s1_r100k)=1.35 v(wbl_op0_n100_rh_s1_r100k)=0 v(rbl_op0_n100_rh_s1_r100k)=1.8 v(ref_op0_n100_rh_s1_r100k)=0
.ic v(sn_op0_n100_rh_s1_r100k_0)=-0.1 v(sn_op0_n100_rh_s1_r100k_1)=-0.1 v(sn_op0_n100_rh_s1_r100k_2)=-0.1 v(sn_op0_n100_rh_s1_r100k_3)=-0.1 v(vn_op0_n100_rh_s1_r100k)=0.45 v(vp_op0_n100_rh_s1_r100k)=1.35
.ic v(wbl_op0_0000_rh_s1_r100k)=0 v(rbl_op0_0000_rh_s1_r100k)=1.8 v(ref_op0_0000_rh_s1_r100k)=0 v(sn_op0_0000_rh_s1_r100k_0)=0 v(sn_op0_0000_rh_s1_r100k_1)=0 v(sn_op0_0000_rh_s1_r100k_2)=0
.ic v(sn_op0_0000_rh_s1_r100k_3)=0 v(vn_op0_0000_rh_s1_r100k)=0.45 v(vp_op0_0000_rh_s1_r100k)=1.35 v(wbl_op1_0900_rh_s2_r10k)=0 v(rbl_op1_0900_rh_s2_r10k)=1.8 v(ref_op1_0900_rh_s2_r10k)=0
.ic v(sn_op1_0900_rh_s2_r10k_0)=0.9 v(sn_op1_0900_rh_s2_r10k_1)=0.9 v(sn_op1_0900_rh_s2_r10k_2)=0.9 v(sn_op1_0900_rh_s2_r10k_3)=0.9 v(vn_op1_0900_rh_s2_r10k)=0.45 v(vp_op1_0900_rh_s2_r10k)=1.35
.ic v(wbl_op1_1000_rh_s2_r10k)=0 v(rbl_op1_1000_rh_s2_r10k)=1.8 v(ref_op1_1000_rh_s2_r10k)=0 v(sn_op1_1000_rh_s2_r10k_0)=1 v(sn_op1_1000_rh_s2_r10k_1)=1 v(sn_op1_1000_rh_s2_r10k_2)=1
.ic v(sn_op1_1000_rh_s2_r10k_3)=1 v(vn_op1_1000_rh_s2_r10k)=0.45 v(vp_op1_1000_rh_s2_r10k)=1.35 v(wbl_op0_n100_rh_s2_r10k)=0 v(rbl_op0_n100_rh_s2_r10k)=1.8 v(ref_op0_n100_rh_s2_r10k)=0
.ic v(sn_op0_n100_rh_s2_r10k_0)=-0.1 v(sn_op0_n100_rh_s2_r10k_1)=-0.1 v(sn_op0_n100_rh_s2_r10k_2)=-0.1 v(sn_op0_n100_rh_s2_r10k_3)=-0.1 v(vn_op0_n100_rh_s2_r10k)=0.45 v(vp_op0_n100_rh_s2_r10k)=1.35
.ic v(wbl_op0_0000_rh_s2_r10k)=0 v(rbl_op0_0000_rh_s2_r10k)=1.8 v(ref_op0_0000_rh_s2_r10k)=0 v(sn_op0_0000_rh_s2_r10k_0)=0 v(sn_op0_0000_rh_s2_r10k_1)=0 v(sn_op0_0000_rh_s2_r10k_2)=0
.ic v(sn_op0_0000_rh_s2_r10k_3)=0 v(vn_op0_0000_rh_s2_r10k)=0.45 v(vp_op0_0000_rh_s2_r10k)=1.35 v(wbl_op1_0900_rh_s2_r100k)=0 v(rbl_op1_0900_rh_s2_r100k)=1.8 v(ref_op1_0900_rh_s2_r100k)=0
.ic v(sn_op1_0900_rh_s2_r100k_0)=0.9 v(sn_op1_0900_rh_s2_r100k_1)=0.9 v(sn_op1_0900_rh_s2_r100k_2)=0.9 v(sn_op1_0900_rh_s2_r100k_3)=0.9 v(vn_op1_0900_rh_s2_r100k)=0.45 v(vp_op1_0900_rh_s2_r100k)=1.35
.ic v(wbl_op1_1000_rh_s2_r100k)=0 v(rbl_op1_1000_rh_s2_r100k)=1.8 v(ref_op1_1000_rh_s2_r100k)=0 v(sn_op1_1000_rh_s2_r100k_0)=1 v(sn_op1_1000_rh_s2_r100k_1)=1 v(sn_op1_1000_rh_s2_r100k_2)=1
.ic v(sn_op1_1000_rh_s2_r100k_3)=1 v(vn_op1_1000_rh_s2_r100k)=0.45 v(vp_op1_1000_rh_s2_r100k)=1.35 v(wbl_op0_n100_rh_s2_r100k)=0 v(rbl_op0_n100_rh_s2_r100k)=1.8 v(ref_op0_n100_rh_s2_r100k)=0
.ic v(sn_op0_n100_rh_s2_r100k_0)=-0.1 v(sn_op0_n100_rh_s2_r100k_1)=-0.1 v(sn_op0_n100_rh_s2_r100k_2)=-0.1 v(sn_op0_n100_rh_s2_r100k_3)=-0.1 v(vn_op0_n100_rh_s2_r100k)=0.45 v(vp_op0_n100_rh_s2_r100k)=1.35
.ic v(wbl_op0_0000_rh_s2_r100k)=0 v(rbl_op0_0000_rh_s2_r100k)=1.8 v(ref_op0_0000_rh_s2_r100k)=0 v(sn_op0_0000_rh_s2_r100k_0)=0 v(sn_op0_0000_rh_s2_r100k_1)=0 v(sn_op0_0000_rh_s2_r100k_2)=0
.ic v(sn_op0_0000_rh_s2_r100k_3)=0 v(vn_op0_0000_rh_s2_r100k)=0.45 v(vp_op0_0000_rh_s2_r100k)=1.35 v(wbl_op1_0900_rl_s0p5_r0)=0 v(rbl_op1_0900_rl_s0p5_r0)=1.8 v(ref_op1_0900_rl_s0p5_r0)=0
.ic v(sn_op1_0900_rl_s0p5_r0_0)=0.9 v(sn_op1_0900_rl_s0p5_r0_1)=0.9 v(sn_op1_0900_rl_s0p5_r0_2)=0.9 v(sn_op1_0900_rl_s0p5_r0_3)=0.9 v(vn_op1_0900_rl_s0p5_r0)=0.45 v(vp_op1_0900_rl_s0p5_r0)=1.35
.ic v(wbl_op1_1000_rl_s0p5_r0)=0 v(rbl_op1_1000_rl_s0p5_r0)=1.8 v(ref_op1_1000_rl_s0p5_r0)=0 v(sn_op1_1000_rl_s0p5_r0_0)=1 v(sn_op1_1000_rl_s0p5_r0_1)=1 v(sn_op1_1000_rl_s0p5_r0_2)=1
.ic v(sn_op1_1000_rl_s0p5_r0_3)=1 v(vn_op1_1000_rl_s0p5_r0)=0.45 v(vp_op1_1000_rl_s0p5_r0)=1.35 v(wbl_op0_n100_rl_s0p5_r0)=0 v(rbl_op0_n100_rl_s0p5_r0)=1.8 v(ref_op0_n100_rl_s0p5_r0)=0
.ic v(sn_op0_n100_rl_s0p5_r0_0)=-0.1 v(sn_op0_n100_rl_s0p5_r0_1)=-0.1 v(sn_op0_n100_rl_s0p5_r0_2)=-0.1 v(sn_op0_n100_rl_s0p5_r0_3)=-0.1 v(vn_op0_n100_rl_s0p5_r0)=0.45 v(vp_op0_n100_rl_s0p5_r0)=1.35
.ic v(wbl_op0_0000_rl_s0p5_r0)=0 v(rbl_op0_0000_rl_s0p5_r0)=1.8 v(ref_op0_0000_rl_s0p5_r0)=0 v(sn_op0_0000_rl_s0p5_r0_0)=0 v(sn_op0_0000_rl_s0p5_r0_1)=0 v(sn_op0_0000_rl_s0p5_r0_2)=0
.ic v(sn_op0_0000_rl_s0p5_r0_3)=0 v(vn_op0_0000_rl_s0p5_r0)=0.45 v(vp_op0_0000_rl_s0p5_r0)=1.35 v(wbl_op1_0900_rl_s1_r0)=0 v(rbl_op1_0900_rl_s1_r0)=1.8 v(ref_op1_0900_rl_s1_r0)=0
.ic v(sn_op1_0900_rl_s1_r0_0)=0.9 v(sn_op1_0900_rl_s1_r0_1)=0.9 v(sn_op1_0900_rl_s1_r0_2)=0.9 v(sn_op1_0900_rl_s1_r0_3)=0.9 v(vn_op1_0900_rl_s1_r0)=0.45 v(vp_op1_0900_rl_s1_r0)=1.35
.ic v(wbl_op1_1000_rl_s1_r0)=0 v(rbl_op1_1000_rl_s1_r0)=1.8 v(ref_op1_1000_rl_s1_r0)=0 v(sn_op1_1000_rl_s1_r0_0)=1 v(sn_op1_1000_rl_s1_r0_1)=1 v(sn_op1_1000_rl_s1_r0_2)=1
.ic v(sn_op1_1000_rl_s1_r0_3)=1 v(vn_op1_1000_rl_s1_r0)=0.45 v(vp_op1_1000_rl_s1_r0)=1.35 v(wbl_op0_n100_rl_s1_r0)=0 v(rbl_op0_n100_rl_s1_r0)=1.8 v(ref_op0_n100_rl_s1_r0)=0
.ic v(sn_op0_n100_rl_s1_r0_0)=-0.1 v(sn_op0_n100_rl_s1_r0_1)=-0.1 v(sn_op0_n100_rl_s1_r0_2)=-0.1 v(sn_op0_n100_rl_s1_r0_3)=-0.1 v(vn_op0_n100_rl_s1_r0)=0.45 v(vp_op0_n100_rl_s1_r0)=1.35
.ic v(wbl_op0_0000_rl_s1_r0)=0 v(rbl_op0_0000_rl_s1_r0)=1.8 v(ref_op0_0000_rl_s1_r0)=0 v(sn_op0_0000_rl_s1_r0_0)=0 v(sn_op0_0000_rl_s1_r0_1)=0 v(sn_op0_0000_rl_s1_r0_2)=0
.ic v(sn_op0_0000_rl_s1_r0_3)=0 v(vn_op0_0000_rl_s1_r0)=0.45 v(vp_op0_0000_rl_s1_r0)=1.35 v(wbl_op1_0900_rl_s2_r0)=0 v(rbl_op1_0900_rl_s2_r0)=1.8 v(ref_op1_0900_rl_s2_r0)=0
.ic v(sn_op1_0900_rl_s2_r0_0)=0.9 v(sn_op1_0900_rl_s2_r0_1)=0.9 v(sn_op1_0900_rl_s2_r0_2)=0.9 v(sn_op1_0900_rl_s2_r0_3)=0.9 v(vn_op1_0900_rl_s2_r0)=0.45 v(vp_op1_0900_rl_s2_r0)=1.35
.ic v(wbl_op1_1000_rl_s2_r0)=0 v(rbl_op1_1000_rl_s2_r0)=1.8 v(ref_op1_1000_rl_s2_r0)=0 v(sn_op1_1000_rl_s2_r0_0)=1 v(sn_op1_1000_rl_s2_r0_1)=1 v(sn_op1_1000_rl_s2_r0_2)=1
.ic v(sn_op1_1000_rl_s2_r0_3)=1 v(vn_op1_1000_rl_s2_r0)=0.45 v(vp_op1_1000_rl_s2_r0)=1.35 v(wbl_op0_n100_rl_s2_r0)=0 v(rbl_op0_n100_rl_s2_r0)=1.8 v(ref_op0_n100_rl_s2_r0)=0
.ic v(sn_op0_n100_rl_s2_r0_0)=-0.1 v(sn_op0_n100_rl_s2_r0_1)=-0.1 v(sn_op0_n100_rl_s2_r0_2)=-0.1 v(sn_op0_n100_rl_s2_r0_3)=-0.1 v(vn_op0_n100_rl_s2_r0)=0.45 v(vp_op0_n100_rl_s2_r0)=1.35
.ic v(wbl_op0_0000_rl_s2_r0)=0 v(rbl_op0_0000_rl_s2_r0)=1.8 v(ref_op0_0000_rl_s2_r0)=0 v(sn_op0_0000_rl_s2_r0_0)=0 v(sn_op0_0000_rl_s2_r0_1)=0 v(sn_op0_0000_rl_s2_r0_2)=0
.ic v(sn_op0_0000_rl_s2_r0_3)=0 v(vn_op0_0000_rl_s2_r0)=0.45 v(vp_op0_0000_rl_s2_r0)=1.35 v(wbl_op1_0900_rl_s5_r0)=0 v(rbl_op1_0900_rl_s5_r0)=1.8 v(ref_op1_0900_rl_s5_r0)=0
.ic v(sn_op1_0900_rl_s5_r0_0)=0.9 v(sn_op1_0900_rl_s5_r0_1)=0.9 v(sn_op1_0900_rl_s5_r0_2)=0.9 v(sn_op1_0900_rl_s5_r0_3)=0.9 v(vn_op1_0900_rl_s5_r0)=0.45 v(vp_op1_0900_rl_s5_r0)=1.35
.ic v(wbl_op1_1000_rl_s5_r0)=0 v(rbl_op1_1000_rl_s5_r0)=1.8 v(ref_op1_1000_rl_s5_r0)=0 v(sn_op1_1000_rl_s5_r0_0)=1 v(sn_op1_1000_rl_s5_r0_1)=1 v(sn_op1_1000_rl_s5_r0_2)=1
.ic v(sn_op1_1000_rl_s5_r0_3)=1 v(vn_op1_1000_rl_s5_r0)=0.45 v(vp_op1_1000_rl_s5_r0)=1.35 v(wbl_op0_n100_rl_s5_r0)=0 v(rbl_op0_n100_rl_s5_r0)=1.8 v(ref_op0_n100_rl_s5_r0)=0
.ic v(sn_op0_n100_rl_s5_r0_0)=-0.1 v(sn_op0_n100_rl_s5_r0_1)=-0.1 v(sn_op0_n100_rl_s5_r0_2)=-0.1 v(sn_op0_n100_rl_s5_r0_3)=-0.1 v(vn_op0_n100_rl_s5_r0)=0.45 v(vp_op0_n100_rl_s5_r0)=1.35
.ic v(wbl_op0_0000_rl_s5_r0)=0 v(rbl_op0_0000_rl_s5_r0)=1.8 v(ref_op0_0000_rl_s5_r0)=0 v(sn_op0_0000_rl_s5_r0_0)=0 v(sn_op0_0000_rl_s5_r0_1)=0 v(sn_op0_0000_rl_s5_r0_2)=0
.ic v(sn_op0_0000_rl_s5_r0_3)=0 v(vn_op0_0000_rl_s5_r0)=0.45 v(vp_op0_0000_rl_s5_r0)=1.35 v(wbl_op1_0900_rl_s0p1_r1k)=0 v(rbl_op1_0900_rl_s0p1_r1k)=1.8 v(ref_op1_0900_rl_s0p1_r1k)=0
.ic v(sn_op1_0900_rl_s0p1_r1k_0)=0.9 v(sn_op1_0900_rl_s0p1_r1k_1)=0.9 v(sn_op1_0900_rl_s0p1_r1k_2)=0.9 v(sn_op1_0900_rl_s0p1_r1k_3)=0.9 v(vn_op1_0900_rl_s0p1_r1k)=0.45 v(vp_op1_0900_rl_s0p1_r1k)=1.35
.ic v(wbl_op1_1000_rl_s0p1_r1k)=0 v(rbl_op1_1000_rl_s0p1_r1k)=1.8 v(ref_op1_1000_rl_s0p1_r1k)=0 v(sn_op1_1000_rl_s0p1_r1k_0)=1 v(sn_op1_1000_rl_s0p1_r1k_1)=1 v(sn_op1_1000_rl_s0p1_r1k_2)=1
.ic v(sn_op1_1000_rl_s0p1_r1k_3)=1 v(vn_op1_1000_rl_s0p1_r1k)=0.45 v(vp_op1_1000_rl_s0p1_r1k)=1.35 v(wbl_op0_n100_rl_s0p1_r1k)=0 v(rbl_op0_n100_rl_s0p1_r1k)=1.8 v(ref_op0_n100_rl_s0p1_r1k)=0
.ic v(sn_op0_n100_rl_s0p1_r1k_0)=-0.1 v(sn_op0_n100_rl_s0p1_r1k_1)=-0.1 v(sn_op0_n100_rl_s0p1_r1k_2)=-0.1 v(sn_op0_n100_rl_s0p1_r1k_3)=-0.1 v(vn_op0_n100_rl_s0p1_r1k)=0.45 v(vp_op0_n100_rl_s0p1_r1k)=1.35
.ic v(wbl_op0_0000_rl_s0p1_r1k)=0 v(rbl_op0_0000_rl_s0p1_r1k)=1.8 v(ref_op0_0000_rl_s0p1_r1k)=0 v(sn_op0_0000_rl_s0p1_r1k_0)=0 v(sn_op0_0000_rl_s0p1_r1k_1)=0 v(sn_op0_0000_rl_s0p1_r1k_2)=0
.ic v(sn_op0_0000_rl_s0p1_r1k_3)=0 v(vn_op0_0000_rl_s0p1_r1k)=0.45 v(vp_op0_0000_rl_s0p1_r1k)=1.35 v(wbl_op1_0900_rl_s0p1_r3k)=0 v(rbl_op1_0900_rl_s0p1_r3k)=1.8 v(ref_op1_0900_rl_s0p1_r3k)=0
.ic v(sn_op1_0900_rl_s0p1_r3k_0)=0.9 v(sn_op1_0900_rl_s0p1_r3k_1)=0.9 v(sn_op1_0900_rl_s0p1_r3k_2)=0.9 v(sn_op1_0900_rl_s0p1_r3k_3)=0.9 v(vn_op1_0900_rl_s0p1_r3k)=0.45 v(vp_op1_0900_rl_s0p1_r3k)=1.35
.ic v(wbl_op1_1000_rl_s0p1_r3k)=0 v(rbl_op1_1000_rl_s0p1_r3k)=1.8 v(ref_op1_1000_rl_s0p1_r3k)=0 v(sn_op1_1000_rl_s0p1_r3k_0)=1 v(sn_op1_1000_rl_s0p1_r3k_1)=1 v(sn_op1_1000_rl_s0p1_r3k_2)=1
.ic v(sn_op1_1000_rl_s0p1_r3k_3)=1 v(vn_op1_1000_rl_s0p1_r3k)=0.45 v(vp_op1_1000_rl_s0p1_r3k)=1.35 v(wbl_op0_n100_rl_s0p1_r3k)=0 v(rbl_op0_n100_rl_s0p1_r3k)=1.8 v(ref_op0_n100_rl_s0p1_r3k)=0
.ic v(sn_op0_n100_rl_s0p1_r3k_0)=-0.1 v(sn_op0_n100_rl_s0p1_r3k_1)=-0.1 v(sn_op0_n100_rl_s0p1_r3k_2)=-0.1 v(sn_op0_n100_rl_s0p1_r3k_3)=-0.1 v(vn_op0_n100_rl_s0p1_r3k)=0.45 v(vp_op0_n100_rl_s0p1_r3k)=1.35
.ic v(wbl_op0_0000_rl_s0p1_r3k)=0 v(rbl_op0_0000_rl_s0p1_r3k)=1.8 v(ref_op0_0000_rl_s0p1_r3k)=0 v(sn_op0_0000_rl_s0p1_r3k_0)=0 v(sn_op0_0000_rl_s0p1_r3k_1)=0 v(sn_op0_0000_rl_s0p1_r3k_2)=0
.ic v(sn_op0_0000_rl_s0p1_r3k_3)=0 v(vn_op0_0000_rl_s0p1_r3k)=0.45 v(vp_op0_0000_rl_s0p1_r3k)=1.35 v(wbl_op1_0900_rl_s0p1_r10k)=0 v(rbl_op1_0900_rl_s0p1_r10k)=1.8 v(ref_op1_0900_rl_s0p1_r10k)=0
.ic v(sn_op1_0900_rl_s0p1_r10k_0)=0.9 v(sn_op1_0900_rl_s0p1_r10k_1)=0.9 v(sn_op1_0900_rl_s0p1_r10k_2)=0.9 v(sn_op1_0900_rl_s0p1_r10k_3)=0.9 v(vn_op1_0900_rl_s0p1_r10k)=0.45 v(vp_op1_0900_rl_s0p1_r10k)=1.35
.ic v(wbl_op1_1000_rl_s0p1_r10k)=0 v(rbl_op1_1000_rl_s0p1_r10k)=1.8 v(ref_op1_1000_rl_s0p1_r10k)=0 v(sn_op1_1000_rl_s0p1_r10k_0)=1 v(sn_op1_1000_rl_s0p1_r10k_1)=1 v(sn_op1_1000_rl_s0p1_r10k_2)=1
.ic v(sn_op1_1000_rl_s0p1_r10k_3)=1 v(vn_op1_1000_rl_s0p1_r10k)=0.45 v(vp_op1_1000_rl_s0p1_r10k)=1.35 v(wbl_op0_n100_rl_s0p1_r10k)=0 v(rbl_op0_n100_rl_s0p1_r10k)=1.8 v(ref_op0_n100_rl_s0p1_r10k)=0
.ic v(sn_op0_n100_rl_s0p1_r10k_0)=-0.1 v(sn_op0_n100_rl_s0p1_r10k_1)=-0.1 v(sn_op0_n100_rl_s0p1_r10k_2)=-0.1 v(sn_op0_n100_rl_s0p1_r10k_3)=-0.1 v(vn_op0_n100_rl_s0p1_r10k)=0.45 v(vp_op0_n100_rl_s0p1_r10k)=1.35
.ic v(wbl_op0_0000_rl_s0p1_r10k)=0 v(rbl_op0_0000_rl_s0p1_r10k)=1.8 v(ref_op0_0000_rl_s0p1_r10k)=0 v(sn_op0_0000_rl_s0p1_r10k_0)=0 v(sn_op0_0000_rl_s0p1_r10k_1)=0 v(sn_op0_0000_rl_s0p1_r10k_2)=0
.ic v(sn_op0_0000_rl_s0p1_r10k_3)=0 v(vn_op0_0000_rl_s0p1_r10k)=0.45 v(vp_op0_0000_rl_s0p1_r10k)=1.35 v(wbl_op1_0900_rl_s0p1_r30k)=0 v(rbl_op1_0900_rl_s0p1_r30k)=1.8 v(ref_op1_0900_rl_s0p1_r30k)=0
.ic v(sn_op1_0900_rl_s0p1_r30k_0)=0.9 v(sn_op1_0900_rl_s0p1_r30k_1)=0.9 v(sn_op1_0900_rl_s0p1_r30k_2)=0.9 v(sn_op1_0900_rl_s0p1_r30k_3)=0.9 v(vn_op1_0900_rl_s0p1_r30k)=0.45 v(vp_op1_0900_rl_s0p1_r30k)=1.35
.ic v(wbl_op1_1000_rl_s0p1_r30k)=0 v(rbl_op1_1000_rl_s0p1_r30k)=1.8 v(ref_op1_1000_rl_s0p1_r30k)=0 v(sn_op1_1000_rl_s0p1_r30k_0)=1 v(sn_op1_1000_rl_s0p1_r30k_1)=1 v(sn_op1_1000_rl_s0p1_r30k_2)=1
.ic v(sn_op1_1000_rl_s0p1_r30k_3)=1 v(vn_op1_1000_rl_s0p1_r30k)=0.45 v(vp_op1_1000_rl_s0p1_r30k)=1.35 v(wbl_op0_n100_rl_s0p1_r30k)=0 v(rbl_op0_n100_rl_s0p1_r30k)=1.8 v(ref_op0_n100_rl_s0p1_r30k)=0
.ic v(sn_op0_n100_rl_s0p1_r30k_0)=-0.1 v(sn_op0_n100_rl_s0p1_r30k_1)=-0.1 v(sn_op0_n100_rl_s0p1_r30k_2)=-0.1 v(sn_op0_n100_rl_s0p1_r30k_3)=-0.1 v(vn_op0_n100_rl_s0p1_r30k)=0.45 v(vp_op0_n100_rl_s0p1_r30k)=1.35
.ic v(wbl_op0_0000_rl_s0p1_r30k)=0 v(rbl_op0_0000_rl_s0p1_r30k)=1.8 v(ref_op0_0000_rl_s0p1_r30k)=0 v(sn_op0_0000_rl_s0p1_r30k_0)=0 v(sn_op0_0000_rl_s0p1_r30k_1)=0 v(sn_op0_0000_rl_s0p1_r30k_2)=0
.ic v(sn_op0_0000_rl_s0p1_r30k_3)=0 v(vn_op0_0000_rl_s0p1_r30k)=0.45 v(vp_op0_0000_rl_s0p1_r30k)=1.35 v(wbl_op1_0900_rl_s0p1_r100k)=0 v(rbl_op1_0900_rl_s0p1_r100k)=1.8 v(ref_op1_0900_rl_s0p1_r100k)=0
.ic v(sn_op1_0900_rl_s0p1_r100k_0)=0.9 v(sn_op1_0900_rl_s0p1_r100k_1)=0.9 v(sn_op1_0900_rl_s0p1_r100k_2)=0.9 v(sn_op1_0900_rl_s0p1_r100k_3)=0.9 v(vn_op1_0900_rl_s0p1_r100k)=0.45 v(vp_op1_0900_rl_s0p1_r100k)=1.35
.ic v(wbl_op1_1000_rl_s0p1_r100k)=0 v(rbl_op1_1000_rl_s0p1_r100k)=1.8 v(ref_op1_1000_rl_s0p1_r100k)=0 v(sn_op1_1000_rl_s0p1_r100k_0)=1 v(sn_op1_1000_rl_s0p1_r100k_1)=1 v(sn_op1_1000_rl_s0p1_r100k_2)=1
.ic v(sn_op1_1000_rl_s0p1_r100k_3)=1 v(vn_op1_1000_rl_s0p1_r100k)=0.45 v(vp_op1_1000_rl_s0p1_r100k)=1.35 v(wbl_op0_n100_rl_s0p1_r100k)=0 v(rbl_op0_n100_rl_s0p1_r100k)=1.8 v(ref_op0_n100_rl_s0p1_r100k)=0
.ic v(sn_op0_n100_rl_s0p1_r100k_0)=-0.1 v(sn_op0_n100_rl_s0p1_r100k_1)=-0.1 v(sn_op0_n100_rl_s0p1_r100k_2)=-0.1 v(sn_op0_n100_rl_s0p1_r100k_3)=-0.1 v(vn_op0_n100_rl_s0p1_r100k)=0.45 v(vp_op0_n100_rl_s0p1_r100k)=1.35
.ic v(wbl_op0_0000_rl_s0p1_r100k)=0 v(rbl_op0_0000_rl_s0p1_r100k)=1.8 v(ref_op0_0000_rl_s0p1_r100k)=0 v(sn_op0_0000_rl_s0p1_r100k_0)=0 v(sn_op0_0000_rl_s0p1_r100k_1)=0 v(sn_op0_0000_rl_s0p1_r100k_2)=0
.ic v(sn_op0_0000_rl_s0p1_r100k_3)=0 v(vn_op0_0000_rl_s0p1_r100k)=0.45 v(vp_op0_0000_rl_s0p1_r100k)=1.35 v(wbl_op1_0900_rl_s0p1_r300k)=0 v(rbl_op1_0900_rl_s0p1_r300k)=1.8 v(ref_op1_0900_rl_s0p1_r300k)=0
.ic v(sn_op1_0900_rl_s0p1_r300k_0)=0.9 v(sn_op1_0900_rl_s0p1_r300k_1)=0.9 v(sn_op1_0900_rl_s0p1_r300k_2)=0.9 v(sn_op1_0900_rl_s0p1_r300k_3)=0.9 v(vn_op1_0900_rl_s0p1_r300k)=0.45 v(vp_op1_0900_rl_s0p1_r300k)=1.35
.ic v(wbl_op1_1000_rl_s0p1_r300k)=0 v(rbl_op1_1000_rl_s0p1_r300k)=1.8 v(ref_op1_1000_rl_s0p1_r300k)=0 v(sn_op1_1000_rl_s0p1_r300k_0)=1 v(sn_op1_1000_rl_s0p1_r300k_1)=1 v(sn_op1_1000_rl_s0p1_r300k_2)=1
.ic v(sn_op1_1000_rl_s0p1_r300k_3)=1 v(vn_op1_1000_rl_s0p1_r300k)=0.45 v(vp_op1_1000_rl_s0p1_r300k)=1.35 v(wbl_op0_n100_rl_s0p1_r300k)=0 v(rbl_op0_n100_rl_s0p1_r300k)=1.8 v(ref_op0_n100_rl_s0p1_r300k)=0
.ic v(sn_op0_n100_rl_s0p1_r300k_0)=-0.1 v(sn_op0_n100_rl_s0p1_r300k_1)=-0.1 v(sn_op0_n100_rl_s0p1_r300k_2)=-0.1 v(sn_op0_n100_rl_s0p1_r300k_3)=-0.1 v(vn_op0_n100_rl_s0p1_r300k)=0.45 v(vp_op0_n100_rl_s0p1_r300k)=1.35
.ic v(wbl_op0_0000_rl_s0p1_r300k)=0 v(rbl_op0_0000_rl_s0p1_r300k)=1.8 v(ref_op0_0000_rl_s0p1_r300k)=0 v(sn_op0_0000_rl_s0p1_r300k_0)=0 v(sn_op0_0000_rl_s0p1_r300k_1)=0 v(sn_op0_0000_rl_s0p1_r300k_2)=0
.ic v(sn_op0_0000_rl_s0p1_r300k_3)=0 v(vn_op0_0000_rl_s0p1_r300k)=0.45 v(vp_op0_0000_rl_s0p1_r300k)=1.35 v(wbl_op1_0900_rl_s0p1_r1000k)=0 v(rbl_op1_0900_rl_s0p1_r1000k)=1.8 v(ref_op1_0900_rl_s0p1_r1000k)=0
.ic v(sn_op1_0900_rl_s0p1_r1000k_0)=0.9 v(sn_op1_0900_rl_s0p1_r1000k_1)=0.9 v(sn_op1_0900_rl_s0p1_r1000k_2)=0.9 v(sn_op1_0900_rl_s0p1_r1000k_3)=0.9 v(vn_op1_0900_rl_s0p1_r1000k)=0.45 v(vp_op1_0900_rl_s0p1_r1000k)=1.35
.ic v(wbl_op1_1000_rl_s0p1_r1000k)=0 v(rbl_op1_1000_rl_s0p1_r1000k)=1.8 v(ref_op1_1000_rl_s0p1_r1000k)=0 v(sn_op1_1000_rl_s0p1_r1000k_0)=1 v(sn_op1_1000_rl_s0p1_r1000k_1)=1 v(sn_op1_1000_rl_s0p1_r1000k_2)=1
.ic v(sn_op1_1000_rl_s0p1_r1000k_3)=1 v(vn_op1_1000_rl_s0p1_r1000k)=0.45 v(vp_op1_1000_rl_s0p1_r1000k)=1.35 v(wbl_op0_n100_rl_s0p1_r1000k)=0 v(rbl_op0_n100_rl_s0p1_r1000k)=1.8 v(ref_op0_n100_rl_s0p1_r1000k)=0
.ic v(sn_op0_n100_rl_s0p1_r1000k_0)=-0.1 v(sn_op0_n100_rl_s0p1_r1000k_1)=-0.1 v(sn_op0_n100_rl_s0p1_r1000k_2)=-0.1 v(sn_op0_n100_rl_s0p1_r1000k_3)=-0.1 v(vn_op0_n100_rl_s0p1_r1000k)=0.45 v(vp_op0_n100_rl_s0p1_r1000k)=1.35
.ic v(wbl_op0_0000_rl_s0p1_r1000k)=0 v(rbl_op0_0000_rl_s0p1_r1000k)=1.8 v(ref_op0_0000_rl_s0p1_r1000k)=0 v(sn_op0_0000_rl_s0p1_r1000k_0)=0 v(sn_op0_0000_rl_s0p1_r1000k_1)=0 v(sn_op0_0000_rl_s0p1_r1000k_2)=0
.ic v(sn_op0_0000_rl_s0p1_r1000k_3)=0 v(vn_op0_0000_rl_s0p1_r1000k)=0.45 v(vp_op0_0000_rl_s0p1_r1000k)=1.35 v(wbl_op1_0900_rl_s1_r10k)=0 v(rbl_op1_0900_rl_s1_r10k)=1.8 v(ref_op1_0900_rl_s1_r10k)=0
.ic v(sn_op1_0900_rl_s1_r10k_0)=0.9 v(sn_op1_0900_rl_s1_r10k_1)=0.9 v(sn_op1_0900_rl_s1_r10k_2)=0.9 v(sn_op1_0900_rl_s1_r10k_3)=0.9 v(vn_op1_0900_rl_s1_r10k)=0.45 v(vp_op1_0900_rl_s1_r10k)=1.35
.ic v(wbl_op1_1000_rl_s1_r10k)=0 v(rbl_op1_1000_rl_s1_r10k)=1.8 v(ref_op1_1000_rl_s1_r10k)=0 v(sn_op1_1000_rl_s1_r10k_0)=1 v(sn_op1_1000_rl_s1_r10k_1)=1 v(sn_op1_1000_rl_s1_r10k_2)=1
.ic v(sn_op1_1000_rl_s1_r10k_3)=1 v(vn_op1_1000_rl_s1_r10k)=0.45 v(vp_op1_1000_rl_s1_r10k)=1.35 v(wbl_op0_n100_rl_s1_r10k)=0 v(rbl_op0_n100_rl_s1_r10k)=1.8 v(ref_op0_n100_rl_s1_r10k)=0
.ic v(sn_op0_n100_rl_s1_r10k_0)=-0.1 v(sn_op0_n100_rl_s1_r10k_1)=-0.1 v(sn_op0_n100_rl_s1_r10k_2)=-0.1 v(sn_op0_n100_rl_s1_r10k_3)=-0.1 v(vn_op0_n100_rl_s1_r10k)=0.45 v(vp_op0_n100_rl_s1_r10k)=1.35
.ic v(wbl_op0_0000_rl_s1_r10k)=0 v(rbl_op0_0000_rl_s1_r10k)=1.8 v(ref_op0_0000_rl_s1_r10k)=0 v(sn_op0_0000_rl_s1_r10k_0)=0 v(sn_op0_0000_rl_s1_r10k_1)=0 v(sn_op0_0000_rl_s1_r10k_2)=0
.ic v(sn_op0_0000_rl_s1_r10k_3)=0 v(vn_op0_0000_rl_s1_r10k)=0.45 v(vp_op0_0000_rl_s1_r10k)=1.35 v(wbl_op1_0900_rl_s1_r100k)=0 v(rbl_op1_0900_rl_s1_r100k)=1.8 v(ref_op1_0900_rl_s1_r100k)=0
.ic v(sn_op1_0900_rl_s1_r100k_0)=0.9 v(sn_op1_0900_rl_s1_r100k_1)=0.9 v(sn_op1_0900_rl_s1_r100k_2)=0.9 v(sn_op1_0900_rl_s1_r100k_3)=0.9 v(vn_op1_0900_rl_s1_r100k)=0.45 v(vp_op1_0900_rl_s1_r100k)=1.35
.ic v(wbl_op1_1000_rl_s1_r100k)=0 v(rbl_op1_1000_rl_s1_r100k)=1.8 v(ref_op1_1000_rl_s1_r100k)=0 v(sn_op1_1000_rl_s1_r100k_0)=1 v(sn_op1_1000_rl_s1_r100k_1)=1 v(sn_op1_1000_rl_s1_r100k_2)=1
.ic v(sn_op1_1000_rl_s1_r100k_3)=1 v(vn_op1_1000_rl_s1_r100k)=0.45 v(vp_op1_1000_rl_s1_r100k)=1.35 v(wbl_op0_n100_rl_s1_r100k)=0 v(rbl_op0_n100_rl_s1_r100k)=1.8 v(ref_op0_n100_rl_s1_r100k)=0
.ic v(sn_op0_n100_rl_s1_r100k_0)=-0.1 v(sn_op0_n100_rl_s1_r100k_1)=-0.1 v(sn_op0_n100_rl_s1_r100k_2)=-0.1 v(sn_op0_n100_rl_s1_r100k_3)=-0.1 v(vn_op0_n100_rl_s1_r100k)=0.45 v(vp_op0_n100_rl_s1_r100k)=1.35
.ic v(wbl_op0_0000_rl_s1_r100k)=0 v(rbl_op0_0000_rl_s1_r100k)=1.8 v(ref_op0_0000_rl_s1_r100k)=0 v(sn_op0_0000_rl_s1_r100k_0)=0 v(sn_op0_0000_rl_s1_r100k_1)=0 v(sn_op0_0000_rl_s1_r100k_2)=0
.ic v(sn_op0_0000_rl_s1_r100k_3)=0 v(vn_op0_0000_rl_s1_r100k)=0.45 v(vp_op0_0000_rl_s1_r100k)=1.35 v(wbl_op1_0900_rl_s2_r10k)=0 v(rbl_op1_0900_rl_s2_r10k)=1.8 v(ref_op1_0900_rl_s2_r10k)=0
.ic v(sn_op1_0900_rl_s2_r10k_0)=0.9 v(sn_op1_0900_rl_s2_r10k_1)=0.9 v(sn_op1_0900_rl_s2_r10k_2)=0.9 v(sn_op1_0900_rl_s2_r10k_3)=0.9 v(vn_op1_0900_rl_s2_r10k)=0.45 v(vp_op1_0900_rl_s2_r10k)=1.35
.ic v(wbl_op1_1000_rl_s2_r10k)=0 v(rbl_op1_1000_rl_s2_r10k)=1.8 v(ref_op1_1000_rl_s2_r10k)=0 v(sn_op1_1000_rl_s2_r10k_0)=1 v(sn_op1_1000_rl_s2_r10k_1)=1 v(sn_op1_1000_rl_s2_r10k_2)=1
.ic v(sn_op1_1000_rl_s2_r10k_3)=1 v(vn_op1_1000_rl_s2_r10k)=0.45 v(vp_op1_1000_rl_s2_r10k)=1.35 v(wbl_op0_n100_rl_s2_r10k)=0 v(rbl_op0_n100_rl_s2_r10k)=1.8 v(ref_op0_n100_rl_s2_r10k)=0
.ic v(sn_op0_n100_rl_s2_r10k_0)=-0.1 v(sn_op0_n100_rl_s2_r10k_1)=-0.1 v(sn_op0_n100_rl_s2_r10k_2)=-0.1 v(sn_op0_n100_rl_s2_r10k_3)=-0.1 v(vn_op0_n100_rl_s2_r10k)=0.45 v(vp_op0_n100_rl_s2_r10k)=1.35
.ic v(wbl_op0_0000_rl_s2_r10k)=0 v(rbl_op0_0000_rl_s2_r10k)=1.8 v(ref_op0_0000_rl_s2_r10k)=0 v(sn_op0_0000_rl_s2_r10k_0)=0 v(sn_op0_0000_rl_s2_r10k_1)=0 v(sn_op0_0000_rl_s2_r10k_2)=0
.ic v(sn_op0_0000_rl_s2_r10k_3)=0 v(vn_op0_0000_rl_s2_r10k)=0.45 v(vp_op0_0000_rl_s2_r10k)=1.35 v(wbl_op1_0900_rl_s2_r100k)=0 v(rbl_op1_0900_rl_s2_r100k)=1.8 v(ref_op1_0900_rl_s2_r100k)=0
.ic v(sn_op1_0900_rl_s2_r100k_0)=0.9 v(sn_op1_0900_rl_s2_r100k_1)=0.9 v(sn_op1_0900_rl_s2_r100k_2)=0.9 v(sn_op1_0900_rl_s2_r100k_3)=0.9 v(vn_op1_0900_rl_s2_r100k)=0.45 v(vp_op1_0900_rl_s2_r100k)=1.35
.ic v(wbl_op1_1000_rl_s2_r100k)=0 v(rbl_op1_1000_rl_s2_r100k)=1.8 v(ref_op1_1000_rl_s2_r100k)=0 v(sn_op1_1000_rl_s2_r100k_0)=1 v(sn_op1_1000_rl_s2_r100k_1)=1 v(sn_op1_1000_rl_s2_r100k_2)=1
.ic v(sn_op1_1000_rl_s2_r100k_3)=1 v(vn_op1_1000_rl_s2_r100k)=0.45 v(vp_op1_1000_rl_s2_r100k)=1.35 v(wbl_op0_n100_rl_s2_r100k)=0 v(rbl_op0_n100_rl_s2_r100k)=1.8 v(ref_op0_n100_rl_s2_r100k)=0
.ic v(sn_op0_n100_rl_s2_r100k_0)=-0.1 v(sn_op0_n100_rl_s2_r100k_1)=-0.1 v(sn_op0_n100_rl_s2_r100k_2)=-0.1 v(sn_op0_n100_rl_s2_r100k_3)=-0.1 v(vn_op0_n100_rl_s2_r100k)=0.45 v(vp_op0_n100_rl_s2_r100k)=1.35
.ic v(wbl_op0_0000_rl_s2_r100k)=0 v(rbl_op0_0000_rl_s2_r100k)=1.8 v(ref_op0_0000_rl_s2_r100k)=0 v(sn_op0_0000_rl_s2_r100k_0)=0 v(sn_op0_0000_rl_s2_r100k_1)=0 v(sn_op0_0000_rl_s2_r100k_2)=0
.ic v(sn_op0_0000_rl_s2_r100k_3)=0 v(vn_op0_0000_rl_s2_r100k)=0.45 v(vp_op0_0000_rl_s2_r100k)=1.35 v(wbl_op1_0900_rl_s0p1_r0_dm016p0)=0 v(rbl_op1_0900_rl_s0p1_r0_dm016p0)=1.8 v(ref_op1_0900_rl_s0p1_r0_dm016p0)=0
.ic v(sn_op1_0900_rl_s0p1_r0_dm016p0_0)=0.9 v(sn_op1_0900_rl_s0p1_r0_dm016p0_1)=0.9 v(sn_op1_0900_rl_s0p1_r0_dm016p0_2)=0.9 v(sn_op1_0900_rl_s0p1_r0_dm016p0_3)=0.9 v(vn_op1_0900_rl_s0p1_r0_dm016p0)=0.45 v(vp_op1_0900_rl_s0p1_r0_dm016p0)=1.35
.ic v(wbl_op1_1000_rl_s0p1_r0_dm016p0)=0 v(rbl_op1_1000_rl_s0p1_r0_dm016p0)=1.8 v(ref_op1_1000_rl_s0p1_r0_dm016p0)=0 v(sn_op1_1000_rl_s0p1_r0_dm016p0_0)=1 v(sn_op1_1000_rl_s0p1_r0_dm016p0_1)=1 v(sn_op1_1000_rl_s0p1_r0_dm016p0_2)=1
.ic v(sn_op1_1000_rl_s0p1_r0_dm016p0_3)=1 v(vn_op1_1000_rl_s0p1_r0_dm016p0)=0.45 v(vp_op1_1000_rl_s0p1_r0_dm016p0)=1.35 v(wbl_op0_n100_rl_s0p1_r0_dm016p0)=0 v(rbl_op0_n100_rl_s0p1_r0_dm016p0)=1.8 v(ref_op0_n100_rl_s0p1_r0_dm016p0)=0
.ic v(sn_op0_n100_rl_s0p1_r0_dm016p0_0)=-0.1 v(sn_op0_n100_rl_s0p1_r0_dm016p0_1)=-0.1 v(sn_op0_n100_rl_s0p1_r0_dm016p0_2)=-0.1 v(sn_op0_n100_rl_s0p1_r0_dm016p0_3)=-0.1 v(vn_op0_n100_rl_s0p1_r0_dm016p0)=0.45 v(vp_op0_n100_rl_s0p1_r0_dm016p0)=1.35
.ic v(wbl_op0_0000_rl_s0p1_r0_dm016p0)=0 v(rbl_op0_0000_rl_s0p1_r0_dm016p0)=1.8 v(ref_op0_0000_rl_s0p1_r0_dm016p0)=0 v(sn_op0_0000_rl_s0p1_r0_dm016p0_0)=0 v(sn_op0_0000_rl_s0p1_r0_dm016p0_1)=0 v(sn_op0_0000_rl_s0p1_r0_dm016p0_2)=0
.ic v(sn_op0_0000_rl_s0p1_r0_dm016p0_3)=0 v(vn_op0_0000_rl_s0p1_r0_dm016p0)=0.45 v(vp_op0_0000_rl_s0p1_r0_dm016p0)=1.35 v(wbl_op1_0900_rl_s0p1_r0_dm008p0)=0 v(rbl_op1_0900_rl_s0p1_r0_dm008p0)=1.8 v(ref_op1_0900_rl_s0p1_r0_dm008p0)=0
.ic v(sn_op1_0900_rl_s0p1_r0_dm008p0_0)=0.9 v(sn_op1_0900_rl_s0p1_r0_dm008p0_1)=0.9 v(sn_op1_0900_rl_s0p1_r0_dm008p0_2)=0.9 v(sn_op1_0900_rl_s0p1_r0_dm008p0_3)=0.9 v(vn_op1_0900_rl_s0p1_r0_dm008p0)=0.45 v(vp_op1_0900_rl_s0p1_r0_dm008p0)=1.35
.ic v(wbl_op1_1000_rl_s0p1_r0_dm008p0)=0 v(rbl_op1_1000_rl_s0p1_r0_dm008p0)=1.8 v(ref_op1_1000_rl_s0p1_r0_dm008p0)=0 v(sn_op1_1000_rl_s0p1_r0_dm008p0_0)=1 v(sn_op1_1000_rl_s0p1_r0_dm008p0_1)=1 v(sn_op1_1000_rl_s0p1_r0_dm008p0_2)=1
.ic v(sn_op1_1000_rl_s0p1_r0_dm008p0_3)=1 v(vn_op1_1000_rl_s0p1_r0_dm008p0)=0.45 v(vp_op1_1000_rl_s0p1_r0_dm008p0)=1.35 v(wbl_op0_n100_rl_s0p1_r0_dm008p0)=0 v(rbl_op0_n100_rl_s0p1_r0_dm008p0)=1.8 v(ref_op0_n100_rl_s0p1_r0_dm008p0)=0
.ic v(sn_op0_n100_rl_s0p1_r0_dm008p0_0)=-0.1 v(sn_op0_n100_rl_s0p1_r0_dm008p0_1)=-0.1 v(sn_op0_n100_rl_s0p1_r0_dm008p0_2)=-0.1 v(sn_op0_n100_rl_s0p1_r0_dm008p0_3)=-0.1 v(vn_op0_n100_rl_s0p1_r0_dm008p0)=0.45 v(vp_op0_n100_rl_s0p1_r0_dm008p0)=1.35
.ic v(wbl_op0_0000_rl_s0p1_r0_dm008p0)=0 v(rbl_op0_0000_rl_s0p1_r0_dm008p0)=1.8 v(ref_op0_0000_rl_s0p1_r0_dm008p0)=0 v(sn_op0_0000_rl_s0p1_r0_dm008p0_0)=0 v(sn_op0_0000_rl_s0p1_r0_dm008p0_1)=0 v(sn_op0_0000_rl_s0p1_r0_dm008p0_2)=0
.ic v(sn_op0_0000_rl_s0p1_r0_dm008p0_3)=0 v(vn_op0_0000_rl_s0p1_r0_dm008p0)=0.45 v(vp_op0_0000_rl_s0p1_r0_dm008p0)=1.35 v(wbl_op1_0900_rl_s0p1_r0_dm004p0)=0 v(rbl_op1_0900_rl_s0p1_r0_dm004p0)=1.8 v(ref_op1_0900_rl_s0p1_r0_dm004p0)=0
.ic v(sn_op1_0900_rl_s0p1_r0_dm004p0_0)=0.9 v(sn_op1_0900_rl_s0p1_r0_dm004p0_1)=0.9 v(sn_op1_0900_rl_s0p1_r0_dm004p0_2)=0.9 v(sn_op1_0900_rl_s0p1_r0_dm004p0_3)=0.9 v(vn_op1_0900_rl_s0p1_r0_dm004p0)=0.45 v(vp_op1_0900_rl_s0p1_r0_dm004p0)=1.35
.ic v(wbl_op1_1000_rl_s0p1_r0_dm004p0)=0 v(rbl_op1_1000_rl_s0p1_r0_dm004p0)=1.8 v(ref_op1_1000_rl_s0p1_r0_dm004p0)=0 v(sn_op1_1000_rl_s0p1_r0_dm004p0_0)=1 v(sn_op1_1000_rl_s0p1_r0_dm004p0_1)=1 v(sn_op1_1000_rl_s0p1_r0_dm004p0_2)=1
.ic v(sn_op1_1000_rl_s0p1_r0_dm004p0_3)=1 v(vn_op1_1000_rl_s0p1_r0_dm004p0)=0.45 v(vp_op1_1000_rl_s0p1_r0_dm004p0)=1.35 v(wbl_op0_n100_rl_s0p1_r0_dm004p0)=0 v(rbl_op0_n100_rl_s0p1_r0_dm004p0)=1.8 v(ref_op0_n100_rl_s0p1_r0_dm004p0)=0
.ic v(sn_op0_n100_rl_s0p1_r0_dm004p0_0)=-0.1 v(sn_op0_n100_rl_s0p1_r0_dm004p0_1)=-0.1 v(sn_op0_n100_rl_s0p1_r0_dm004p0_2)=-0.1 v(sn_op0_n100_rl_s0p1_r0_dm004p0_3)=-0.1 v(vn_op0_n100_rl_s0p1_r0_dm004p0)=0.45 v(vp_op0_n100_rl_s0p1_r0_dm004p0)=1.35
.ic v(wbl_op0_0000_rl_s0p1_r0_dm004p0)=0 v(rbl_op0_0000_rl_s0p1_r0_dm004p0)=1.8 v(ref_op0_0000_rl_s0p1_r0_dm004p0)=0 v(sn_op0_0000_rl_s0p1_r0_dm004p0_0)=0 v(sn_op0_0000_rl_s0p1_r0_dm004p0_1)=0 v(sn_op0_0000_rl_s0p1_r0_dm004p0_2)=0
.ic v(sn_op0_0000_rl_s0p1_r0_dm004p0_3)=0 v(vn_op0_0000_rl_s0p1_r0_dm004p0)=0.45 v(vp_op0_0000_rl_s0p1_r0_dm004p0)=1.35 v(wbl_op1_0900_rl_s0p1_r0_dm002p0)=0 v(rbl_op1_0900_rl_s0p1_r0_dm002p0)=1.8 v(ref_op1_0900_rl_s0p1_r0_dm002p0)=0
.ic v(sn_op1_0900_rl_s0p1_r0_dm002p0_0)=0.9 v(sn_op1_0900_rl_s0p1_r0_dm002p0_1)=0.9 v(sn_op1_0900_rl_s0p1_r0_dm002p0_2)=0.9 v(sn_op1_0900_rl_s0p1_r0_dm002p0_3)=0.9 v(vn_op1_0900_rl_s0p1_r0_dm002p0)=0.45 v(vp_op1_0900_rl_s0p1_r0_dm002p0)=1.35
.ic v(wbl_op1_1000_rl_s0p1_r0_dm002p0)=0 v(rbl_op1_1000_rl_s0p1_r0_dm002p0)=1.8 v(ref_op1_1000_rl_s0p1_r0_dm002p0)=0 v(sn_op1_1000_rl_s0p1_r0_dm002p0_0)=1 v(sn_op1_1000_rl_s0p1_r0_dm002p0_1)=1 v(sn_op1_1000_rl_s0p1_r0_dm002p0_2)=1
.ic v(sn_op1_1000_rl_s0p1_r0_dm002p0_3)=1 v(vn_op1_1000_rl_s0p1_r0_dm002p0)=0.45 v(vp_op1_1000_rl_s0p1_r0_dm002p0)=1.35 v(wbl_op0_n100_rl_s0p1_r0_dm002p0)=0 v(rbl_op0_n100_rl_s0p1_r0_dm002p0)=1.8 v(ref_op0_n100_rl_s0p1_r0_dm002p0)=0
.ic v(sn_op0_n100_rl_s0p1_r0_dm002p0_0)=-0.1 v(sn_op0_n100_rl_s0p1_r0_dm002p0_1)=-0.1 v(sn_op0_n100_rl_s0p1_r0_dm002p0_2)=-0.1 v(sn_op0_n100_rl_s0p1_r0_dm002p0_3)=-0.1 v(vn_op0_n100_rl_s0p1_r0_dm002p0)=0.45 v(vp_op0_n100_rl_s0p1_r0_dm002p0)=1.35
.ic v(wbl_op0_0000_rl_s0p1_r0_dm002p0)=0 v(rbl_op0_0000_rl_s0p1_r0_dm002p0)=1.8 v(ref_op0_0000_rl_s0p1_r0_dm002p0)=0 v(sn_op0_0000_rl_s0p1_r0_dm002p0_0)=0 v(sn_op0_0000_rl_s0p1_r0_dm002p0_1)=0 v(sn_op0_0000_rl_s0p1_r0_dm002p0_2)=0
.ic v(sn_op0_0000_rl_s0p1_r0_dm002p0_3)=0 v(vn_op0_0000_rl_s0p1_r0_dm002p0)=0.45 v(vp_op0_0000_rl_s0p1_r0_dm002p0)=1.35 v(wbl_op1_0900_rl_s0p1_r0_dp000p0)=0 v(rbl_op1_0900_rl_s0p1_r0_dp000p0)=1.8 v(ref_op1_0900_rl_s0p1_r0_dp000p0)=0
.ic v(sn_op1_0900_rl_s0p1_r0_dp000p0_0)=0.9 v(sn_op1_0900_rl_s0p1_r0_dp000p0_1)=0.9 v(sn_op1_0900_rl_s0p1_r0_dp000p0_2)=0.9 v(sn_op1_0900_rl_s0p1_r0_dp000p0_3)=0.9 v(vn_op1_0900_rl_s0p1_r0_dp000p0)=0.45 v(vp_op1_0900_rl_s0p1_r0_dp000p0)=1.35
.ic v(wbl_op1_1000_rl_s0p1_r0_dp000p0)=0 v(rbl_op1_1000_rl_s0p1_r0_dp000p0)=1.8 v(ref_op1_1000_rl_s0p1_r0_dp000p0)=0 v(sn_op1_1000_rl_s0p1_r0_dp000p0_0)=1 v(sn_op1_1000_rl_s0p1_r0_dp000p0_1)=1 v(sn_op1_1000_rl_s0p1_r0_dp000p0_2)=1
.ic v(sn_op1_1000_rl_s0p1_r0_dp000p0_3)=1 v(vn_op1_1000_rl_s0p1_r0_dp000p0)=0.45 v(vp_op1_1000_rl_s0p1_r0_dp000p0)=1.35 v(wbl_op0_n100_rl_s0p1_r0_dp000p0)=0 v(rbl_op0_n100_rl_s0p1_r0_dp000p0)=1.8 v(ref_op0_n100_rl_s0p1_r0_dp000p0)=0
.ic v(sn_op0_n100_rl_s0p1_r0_dp000p0_0)=-0.1 v(sn_op0_n100_rl_s0p1_r0_dp000p0_1)=-0.1 v(sn_op0_n100_rl_s0p1_r0_dp000p0_2)=-0.1 v(sn_op0_n100_rl_s0p1_r0_dp000p0_3)=-0.1 v(vn_op0_n100_rl_s0p1_r0_dp000p0)=0.45 v(vp_op0_n100_rl_s0p1_r0_dp000p0)=1.35
.ic v(wbl_op0_0000_rl_s0p1_r0_dp000p0)=0 v(rbl_op0_0000_rl_s0p1_r0_dp000p0)=1.8 v(ref_op0_0000_rl_s0p1_r0_dp000p0)=0 v(sn_op0_0000_rl_s0p1_r0_dp000p0_0)=0 v(sn_op0_0000_rl_s0p1_r0_dp000p0_1)=0 v(sn_op0_0000_rl_s0p1_r0_dp000p0_2)=0
.ic v(sn_op0_0000_rl_s0p1_r0_dp000p0_3)=0 v(vn_op0_0000_rl_s0p1_r0_dp000p0)=0.45 v(vp_op0_0000_rl_s0p1_r0_dp000p0)=1.35 v(wbl_op1_0900_rl_s0p1_r0_dp001p0)=0 v(rbl_op1_0900_rl_s0p1_r0_dp001p0)=1.8 v(ref_op1_0900_rl_s0p1_r0_dp001p0)=0
.ic v(sn_op1_0900_rl_s0p1_r0_dp001p0_0)=0.9 v(sn_op1_0900_rl_s0p1_r0_dp001p0_1)=0.9 v(sn_op1_0900_rl_s0p1_r0_dp001p0_2)=0.9 v(sn_op1_0900_rl_s0p1_r0_dp001p0_3)=0.9 v(vn_op1_0900_rl_s0p1_r0_dp001p0)=0.45 v(vp_op1_0900_rl_s0p1_r0_dp001p0)=1.35
.ic v(wbl_op1_1000_rl_s0p1_r0_dp001p0)=0 v(rbl_op1_1000_rl_s0p1_r0_dp001p0)=1.8 v(ref_op1_1000_rl_s0p1_r0_dp001p0)=0 v(sn_op1_1000_rl_s0p1_r0_dp001p0_0)=1 v(sn_op1_1000_rl_s0p1_r0_dp001p0_1)=1 v(sn_op1_1000_rl_s0p1_r0_dp001p0_2)=1
.ic v(sn_op1_1000_rl_s0p1_r0_dp001p0_3)=1 v(vn_op1_1000_rl_s0p1_r0_dp001p0)=0.45 v(vp_op1_1000_rl_s0p1_r0_dp001p0)=1.35 v(wbl_op0_n100_rl_s0p1_r0_dp001p0)=0 v(rbl_op0_n100_rl_s0p1_r0_dp001p0)=1.8 v(ref_op0_n100_rl_s0p1_r0_dp001p0)=0
.ic v(sn_op0_n100_rl_s0p1_r0_dp001p0_0)=-0.1 v(sn_op0_n100_rl_s0p1_r0_dp001p0_1)=-0.1 v(sn_op0_n100_rl_s0p1_r0_dp001p0_2)=-0.1 v(sn_op0_n100_rl_s0p1_r0_dp001p0_3)=-0.1 v(vn_op0_n100_rl_s0p1_r0_dp001p0)=0.45 v(vp_op0_n100_rl_s0p1_r0_dp001p0)=1.35
.ic v(wbl_op0_0000_rl_s0p1_r0_dp001p0)=0 v(rbl_op0_0000_rl_s0p1_r0_dp001p0)=1.8 v(ref_op0_0000_rl_s0p1_r0_dp001p0)=0 v(sn_op0_0000_rl_s0p1_r0_dp001p0_0)=0 v(sn_op0_0000_rl_s0p1_r0_dp001p0_1)=0 v(sn_op0_0000_rl_s0p1_r0_dp001p0_2)=0
.ic v(sn_op0_0000_rl_s0p1_r0_dp001p0_3)=0 v(vn_op0_0000_rl_s0p1_r0_dp001p0)=0.45 v(vp_op0_0000_rl_s0p1_r0_dp001p0)=1.35 v(wbl_op1_0900_rl_s0p1_r0_dp002p0)=0 v(rbl_op1_0900_rl_s0p1_r0_dp002p0)=1.8 v(ref_op1_0900_rl_s0p1_r0_dp002p0)=0
.ic v(sn_op1_0900_rl_s0p1_r0_dp002p0_0)=0.9 v(sn_op1_0900_rl_s0p1_r0_dp002p0_1)=0.9 v(sn_op1_0900_rl_s0p1_r0_dp002p0_2)=0.9 v(sn_op1_0900_rl_s0p1_r0_dp002p0_3)=0.9 v(vn_op1_0900_rl_s0p1_r0_dp002p0)=0.45 v(vp_op1_0900_rl_s0p1_r0_dp002p0)=1.35
.ic v(wbl_op1_1000_rl_s0p1_r0_dp002p0)=0 v(rbl_op1_1000_rl_s0p1_r0_dp002p0)=1.8 v(ref_op1_1000_rl_s0p1_r0_dp002p0)=0 v(sn_op1_1000_rl_s0p1_r0_dp002p0_0)=1 v(sn_op1_1000_rl_s0p1_r0_dp002p0_1)=1 v(sn_op1_1000_rl_s0p1_r0_dp002p0_2)=1
.ic v(sn_op1_1000_rl_s0p1_r0_dp002p0_3)=1 v(vn_op1_1000_rl_s0p1_r0_dp002p0)=0.45 v(vp_op1_1000_rl_s0p1_r0_dp002p0)=1.35 v(wbl_op0_n100_rl_s0p1_r0_dp002p0)=0 v(rbl_op0_n100_rl_s0p1_r0_dp002p0)=1.8 v(ref_op0_n100_rl_s0p1_r0_dp002p0)=0
.ic v(sn_op0_n100_rl_s0p1_r0_dp002p0_0)=-0.1 v(sn_op0_n100_rl_s0p1_r0_dp002p0_1)=-0.1 v(sn_op0_n100_rl_s0p1_r0_dp002p0_2)=-0.1 v(sn_op0_n100_rl_s0p1_r0_dp002p0_3)=-0.1 v(vn_op0_n100_rl_s0p1_r0_dp002p0)=0.45 v(vp_op0_n100_rl_s0p1_r0_dp002p0)=1.35
.ic v(wbl_op0_0000_rl_s0p1_r0_dp002p0)=0 v(rbl_op0_0000_rl_s0p1_r0_dp002p0)=1.8 v(ref_op0_0000_rl_s0p1_r0_dp002p0)=0 v(sn_op0_0000_rl_s0p1_r0_dp002p0_0)=0 v(sn_op0_0000_rl_s0p1_r0_dp002p0_1)=0 v(sn_op0_0000_rl_s0p1_r0_dp002p0_2)=0
.ic v(sn_op0_0000_rl_s0p1_r0_dp002p0_3)=0 v(vn_op0_0000_rl_s0p1_r0_dp002p0)=0.45 v(vp_op0_0000_rl_s0p1_r0_dp002p0)=1.35 v(wbl_op1_0900_rl_s0p1_r0_dp003p0)=0 v(rbl_op1_0900_rl_s0p1_r0_dp003p0)=1.8 v(ref_op1_0900_rl_s0p1_r0_dp003p0)=0
.ic v(sn_op1_0900_rl_s0p1_r0_dp003p0_0)=0.9 v(sn_op1_0900_rl_s0p1_r0_dp003p0_1)=0.9 v(sn_op1_0900_rl_s0p1_r0_dp003p0_2)=0.9 v(sn_op1_0900_rl_s0p1_r0_dp003p0_3)=0.9 v(vn_op1_0900_rl_s0p1_r0_dp003p0)=0.45 v(vp_op1_0900_rl_s0p1_r0_dp003p0)=1.35
.ic v(wbl_op1_1000_rl_s0p1_r0_dp003p0)=0 v(rbl_op1_1000_rl_s0p1_r0_dp003p0)=1.8 v(ref_op1_1000_rl_s0p1_r0_dp003p0)=0 v(sn_op1_1000_rl_s0p1_r0_dp003p0_0)=1 v(sn_op1_1000_rl_s0p1_r0_dp003p0_1)=1 v(sn_op1_1000_rl_s0p1_r0_dp003p0_2)=1
.ic v(sn_op1_1000_rl_s0p1_r0_dp003p0_3)=1 v(vn_op1_1000_rl_s0p1_r0_dp003p0)=0.45 v(vp_op1_1000_rl_s0p1_r0_dp003p0)=1.35 v(wbl_op0_n100_rl_s0p1_r0_dp003p0)=0 v(rbl_op0_n100_rl_s0p1_r0_dp003p0)=1.8 v(ref_op0_n100_rl_s0p1_r0_dp003p0)=0
.ic v(sn_op0_n100_rl_s0p1_r0_dp003p0_0)=-0.1 v(sn_op0_n100_rl_s0p1_r0_dp003p0_1)=-0.1 v(sn_op0_n100_rl_s0p1_r0_dp003p0_2)=-0.1 v(sn_op0_n100_rl_s0p1_r0_dp003p0_3)=-0.1 v(vn_op0_n100_rl_s0p1_r0_dp003p0)=0.45 v(vp_op0_n100_rl_s0p1_r0_dp003p0)=1.35
.ic v(wbl_op0_0000_rl_s0p1_r0_dp003p0)=0 v(rbl_op0_0000_rl_s0p1_r0_dp003p0)=1.8 v(ref_op0_0000_rl_s0p1_r0_dp003p0)=0 v(sn_op0_0000_rl_s0p1_r0_dp003p0_0)=0 v(sn_op0_0000_rl_s0p1_r0_dp003p0_1)=0 v(sn_op0_0000_rl_s0p1_r0_dp003p0_2)=0
.ic v(sn_op0_0000_rl_s0p1_r0_dp003p0_3)=0 v(vn_op0_0000_rl_s0p1_r0_dp003p0)=0.45 v(vp_op0_0000_rl_s0p1_r0_dp003p0)=1.35 v(wbl_op1_0900_rl_s1_r10k_dm016p0)=0 v(rbl_op1_0900_rl_s1_r10k_dm016p0)=1.8 v(ref_op1_0900_rl_s1_r10k_dm016p0)=0
.ic v(sn_op1_0900_rl_s1_r10k_dm016p0_0)=0.9 v(sn_op1_0900_rl_s1_r10k_dm016p0_1)=0.9 v(sn_op1_0900_rl_s1_r10k_dm016p0_2)=0.9 v(sn_op1_0900_rl_s1_r10k_dm016p0_3)=0.9 v(vn_op1_0900_rl_s1_r10k_dm016p0)=0.45 v(vp_op1_0900_rl_s1_r10k_dm016p0)=1.35
.ic v(wbl_op1_1000_rl_s1_r10k_dm016p0)=0 v(rbl_op1_1000_rl_s1_r10k_dm016p0)=1.8 v(ref_op1_1000_rl_s1_r10k_dm016p0)=0 v(sn_op1_1000_rl_s1_r10k_dm016p0_0)=1 v(sn_op1_1000_rl_s1_r10k_dm016p0_1)=1 v(sn_op1_1000_rl_s1_r10k_dm016p0_2)=1
.ic v(sn_op1_1000_rl_s1_r10k_dm016p0_3)=1 v(vn_op1_1000_rl_s1_r10k_dm016p0)=0.45 v(vp_op1_1000_rl_s1_r10k_dm016p0)=1.35 v(wbl_op0_n100_rl_s1_r10k_dm016p0)=0 v(rbl_op0_n100_rl_s1_r10k_dm016p0)=1.8 v(ref_op0_n100_rl_s1_r10k_dm016p0)=0
.ic v(sn_op0_n100_rl_s1_r10k_dm016p0_0)=-0.1 v(sn_op0_n100_rl_s1_r10k_dm016p0_1)=-0.1 v(sn_op0_n100_rl_s1_r10k_dm016p0_2)=-0.1 v(sn_op0_n100_rl_s1_r10k_dm016p0_3)=-0.1 v(vn_op0_n100_rl_s1_r10k_dm016p0)=0.45 v(vp_op0_n100_rl_s1_r10k_dm016p0)=1.35
.ic v(wbl_op0_0000_rl_s1_r10k_dm016p0)=0 v(rbl_op0_0000_rl_s1_r10k_dm016p0)=1.8 v(ref_op0_0000_rl_s1_r10k_dm016p0)=0 v(sn_op0_0000_rl_s1_r10k_dm016p0_0)=0 v(sn_op0_0000_rl_s1_r10k_dm016p0_1)=0 v(sn_op0_0000_rl_s1_r10k_dm016p0_2)=0
.ic v(sn_op0_0000_rl_s1_r10k_dm016p0_3)=0 v(vn_op0_0000_rl_s1_r10k_dm016p0)=0.45 v(vp_op0_0000_rl_s1_r10k_dm016p0)=1.35 v(wbl_op1_0900_rl_s1_r10k_dm008p0)=0 v(rbl_op1_0900_rl_s1_r10k_dm008p0)=1.8 v(ref_op1_0900_rl_s1_r10k_dm008p0)=0
.ic v(sn_op1_0900_rl_s1_r10k_dm008p0_0)=0.9 v(sn_op1_0900_rl_s1_r10k_dm008p0_1)=0.9 v(sn_op1_0900_rl_s1_r10k_dm008p0_2)=0.9 v(sn_op1_0900_rl_s1_r10k_dm008p0_3)=0.9 v(vn_op1_0900_rl_s1_r10k_dm008p0)=0.45 v(vp_op1_0900_rl_s1_r10k_dm008p0)=1.35
.ic v(wbl_op1_1000_rl_s1_r10k_dm008p0)=0 v(rbl_op1_1000_rl_s1_r10k_dm008p0)=1.8 v(ref_op1_1000_rl_s1_r10k_dm008p0)=0 v(sn_op1_1000_rl_s1_r10k_dm008p0_0)=1 v(sn_op1_1000_rl_s1_r10k_dm008p0_1)=1 v(sn_op1_1000_rl_s1_r10k_dm008p0_2)=1
.ic v(sn_op1_1000_rl_s1_r10k_dm008p0_3)=1 v(vn_op1_1000_rl_s1_r10k_dm008p0)=0.45 v(vp_op1_1000_rl_s1_r10k_dm008p0)=1.35 v(wbl_op0_n100_rl_s1_r10k_dm008p0)=0 v(rbl_op0_n100_rl_s1_r10k_dm008p0)=1.8 v(ref_op0_n100_rl_s1_r10k_dm008p0)=0
.ic v(sn_op0_n100_rl_s1_r10k_dm008p0_0)=-0.1 v(sn_op0_n100_rl_s1_r10k_dm008p0_1)=-0.1 v(sn_op0_n100_rl_s1_r10k_dm008p0_2)=-0.1 v(sn_op0_n100_rl_s1_r10k_dm008p0_3)=-0.1 v(vn_op0_n100_rl_s1_r10k_dm008p0)=0.45 v(vp_op0_n100_rl_s1_r10k_dm008p0)=1.35
.ic v(wbl_op0_0000_rl_s1_r10k_dm008p0)=0 v(rbl_op0_0000_rl_s1_r10k_dm008p0)=1.8 v(ref_op0_0000_rl_s1_r10k_dm008p0)=0 v(sn_op0_0000_rl_s1_r10k_dm008p0_0)=0 v(sn_op0_0000_rl_s1_r10k_dm008p0_1)=0 v(sn_op0_0000_rl_s1_r10k_dm008p0_2)=0
.ic v(sn_op0_0000_rl_s1_r10k_dm008p0_3)=0 v(vn_op0_0000_rl_s1_r10k_dm008p0)=0.45 v(vp_op0_0000_rl_s1_r10k_dm008p0)=1.35 v(wbl_op1_0900_rl_s1_r10k_dm004p0)=0 v(rbl_op1_0900_rl_s1_r10k_dm004p0)=1.8 v(ref_op1_0900_rl_s1_r10k_dm004p0)=0
.ic v(sn_op1_0900_rl_s1_r10k_dm004p0_0)=0.9 v(sn_op1_0900_rl_s1_r10k_dm004p0_1)=0.9 v(sn_op1_0900_rl_s1_r10k_dm004p0_2)=0.9 v(sn_op1_0900_rl_s1_r10k_dm004p0_3)=0.9 v(vn_op1_0900_rl_s1_r10k_dm004p0)=0.45 v(vp_op1_0900_rl_s1_r10k_dm004p0)=1.35
.ic v(wbl_op1_1000_rl_s1_r10k_dm004p0)=0 v(rbl_op1_1000_rl_s1_r10k_dm004p0)=1.8 v(ref_op1_1000_rl_s1_r10k_dm004p0)=0 v(sn_op1_1000_rl_s1_r10k_dm004p0_0)=1 v(sn_op1_1000_rl_s1_r10k_dm004p0_1)=1 v(sn_op1_1000_rl_s1_r10k_dm004p0_2)=1
.ic v(sn_op1_1000_rl_s1_r10k_dm004p0_3)=1 v(vn_op1_1000_rl_s1_r10k_dm004p0)=0.45 v(vp_op1_1000_rl_s1_r10k_dm004p0)=1.35 v(wbl_op0_n100_rl_s1_r10k_dm004p0)=0 v(rbl_op0_n100_rl_s1_r10k_dm004p0)=1.8 v(ref_op0_n100_rl_s1_r10k_dm004p0)=0
.ic v(sn_op0_n100_rl_s1_r10k_dm004p0_0)=-0.1 v(sn_op0_n100_rl_s1_r10k_dm004p0_1)=-0.1 v(sn_op0_n100_rl_s1_r10k_dm004p0_2)=-0.1 v(sn_op0_n100_rl_s1_r10k_dm004p0_3)=-0.1 v(vn_op0_n100_rl_s1_r10k_dm004p0)=0.45 v(vp_op0_n100_rl_s1_r10k_dm004p0)=1.35
.ic v(wbl_op0_0000_rl_s1_r10k_dm004p0)=0 v(rbl_op0_0000_rl_s1_r10k_dm004p0)=1.8 v(ref_op0_0000_rl_s1_r10k_dm004p0)=0 v(sn_op0_0000_rl_s1_r10k_dm004p0_0)=0 v(sn_op0_0000_rl_s1_r10k_dm004p0_1)=0 v(sn_op0_0000_rl_s1_r10k_dm004p0_2)=0
.ic v(sn_op0_0000_rl_s1_r10k_dm004p0_3)=0 v(vn_op0_0000_rl_s1_r10k_dm004p0)=0.45 v(vp_op0_0000_rl_s1_r10k_dm004p0)=1.35 v(wbl_op1_0900_rl_s1_r10k_dm002p0)=0 v(rbl_op1_0900_rl_s1_r10k_dm002p0)=1.8 v(ref_op1_0900_rl_s1_r10k_dm002p0)=0
.ic v(sn_op1_0900_rl_s1_r10k_dm002p0_0)=0.9 v(sn_op1_0900_rl_s1_r10k_dm002p0_1)=0.9 v(sn_op1_0900_rl_s1_r10k_dm002p0_2)=0.9 v(sn_op1_0900_rl_s1_r10k_dm002p0_3)=0.9 v(vn_op1_0900_rl_s1_r10k_dm002p0)=0.45 v(vp_op1_0900_rl_s1_r10k_dm002p0)=1.35
.ic v(wbl_op1_1000_rl_s1_r10k_dm002p0)=0 v(rbl_op1_1000_rl_s1_r10k_dm002p0)=1.8 v(ref_op1_1000_rl_s1_r10k_dm002p0)=0 v(sn_op1_1000_rl_s1_r10k_dm002p0_0)=1 v(sn_op1_1000_rl_s1_r10k_dm002p0_1)=1 v(sn_op1_1000_rl_s1_r10k_dm002p0_2)=1
.ic v(sn_op1_1000_rl_s1_r10k_dm002p0_3)=1 v(vn_op1_1000_rl_s1_r10k_dm002p0)=0.45 v(vp_op1_1000_rl_s1_r10k_dm002p0)=1.35 v(wbl_op0_n100_rl_s1_r10k_dm002p0)=0 v(rbl_op0_n100_rl_s1_r10k_dm002p0)=1.8 v(ref_op0_n100_rl_s1_r10k_dm002p0)=0
.ic v(sn_op0_n100_rl_s1_r10k_dm002p0_0)=-0.1 v(sn_op0_n100_rl_s1_r10k_dm002p0_1)=-0.1 v(sn_op0_n100_rl_s1_r10k_dm002p0_2)=-0.1 v(sn_op0_n100_rl_s1_r10k_dm002p0_3)=-0.1 v(vn_op0_n100_rl_s1_r10k_dm002p0)=0.45 v(vp_op0_n100_rl_s1_r10k_dm002p0)=1.35
.ic v(wbl_op0_0000_rl_s1_r10k_dm002p0)=0 v(rbl_op0_0000_rl_s1_r10k_dm002p0)=1.8 v(ref_op0_0000_rl_s1_r10k_dm002p0)=0 v(sn_op0_0000_rl_s1_r10k_dm002p0_0)=0 v(sn_op0_0000_rl_s1_r10k_dm002p0_1)=0 v(sn_op0_0000_rl_s1_r10k_dm002p0_2)=0
.ic v(sn_op0_0000_rl_s1_r10k_dm002p0_3)=0 v(vn_op0_0000_rl_s1_r10k_dm002p0)=0.45 v(vp_op0_0000_rl_s1_r10k_dm002p0)=1.35 v(wbl_op1_0900_rl_s1_r10k_dp000p0)=0 v(rbl_op1_0900_rl_s1_r10k_dp000p0)=1.8 v(ref_op1_0900_rl_s1_r10k_dp000p0)=0
.ic v(sn_op1_0900_rl_s1_r10k_dp000p0_0)=0.9 v(sn_op1_0900_rl_s1_r10k_dp000p0_1)=0.9 v(sn_op1_0900_rl_s1_r10k_dp000p0_2)=0.9 v(sn_op1_0900_rl_s1_r10k_dp000p0_3)=0.9 v(vn_op1_0900_rl_s1_r10k_dp000p0)=0.45 v(vp_op1_0900_rl_s1_r10k_dp000p0)=1.35
.ic v(wbl_op1_1000_rl_s1_r10k_dp000p0)=0 v(rbl_op1_1000_rl_s1_r10k_dp000p0)=1.8 v(ref_op1_1000_rl_s1_r10k_dp000p0)=0 v(sn_op1_1000_rl_s1_r10k_dp000p0_0)=1 v(sn_op1_1000_rl_s1_r10k_dp000p0_1)=1 v(sn_op1_1000_rl_s1_r10k_dp000p0_2)=1
.ic v(sn_op1_1000_rl_s1_r10k_dp000p0_3)=1 v(vn_op1_1000_rl_s1_r10k_dp000p0)=0.45 v(vp_op1_1000_rl_s1_r10k_dp000p0)=1.35 v(wbl_op0_n100_rl_s1_r10k_dp000p0)=0 v(rbl_op0_n100_rl_s1_r10k_dp000p0)=1.8 v(ref_op0_n100_rl_s1_r10k_dp000p0)=0
.ic v(sn_op0_n100_rl_s1_r10k_dp000p0_0)=-0.1 v(sn_op0_n100_rl_s1_r10k_dp000p0_1)=-0.1 v(sn_op0_n100_rl_s1_r10k_dp000p0_2)=-0.1 v(sn_op0_n100_rl_s1_r10k_dp000p0_3)=-0.1 v(vn_op0_n100_rl_s1_r10k_dp000p0)=0.45 v(vp_op0_n100_rl_s1_r10k_dp000p0)=1.35
.ic v(wbl_op0_0000_rl_s1_r10k_dp000p0)=0 v(rbl_op0_0000_rl_s1_r10k_dp000p0)=1.8 v(ref_op0_0000_rl_s1_r10k_dp000p0)=0 v(sn_op0_0000_rl_s1_r10k_dp000p0_0)=0 v(sn_op0_0000_rl_s1_r10k_dp000p0_1)=0 v(sn_op0_0000_rl_s1_r10k_dp000p0_2)=0
.ic v(sn_op0_0000_rl_s1_r10k_dp000p0_3)=0 v(vn_op0_0000_rl_s1_r10k_dp000p0)=0.45 v(vp_op0_0000_rl_s1_r10k_dp000p0)=1.35 v(wbl_op1_0900_rl_s1_r10k_dp001p0)=0 v(rbl_op1_0900_rl_s1_r10k_dp001p0)=1.8 v(ref_op1_0900_rl_s1_r10k_dp001p0)=0
.ic v(sn_op1_0900_rl_s1_r10k_dp001p0_0)=0.9 v(sn_op1_0900_rl_s1_r10k_dp001p0_1)=0.9 v(sn_op1_0900_rl_s1_r10k_dp001p0_2)=0.9 v(sn_op1_0900_rl_s1_r10k_dp001p0_3)=0.9 v(vn_op1_0900_rl_s1_r10k_dp001p0)=0.45 v(vp_op1_0900_rl_s1_r10k_dp001p0)=1.35
.ic v(wbl_op1_1000_rl_s1_r10k_dp001p0)=0 v(rbl_op1_1000_rl_s1_r10k_dp001p0)=1.8 v(ref_op1_1000_rl_s1_r10k_dp001p0)=0 v(sn_op1_1000_rl_s1_r10k_dp001p0_0)=1 v(sn_op1_1000_rl_s1_r10k_dp001p0_1)=1 v(sn_op1_1000_rl_s1_r10k_dp001p0_2)=1
.ic v(sn_op1_1000_rl_s1_r10k_dp001p0_3)=1 v(vn_op1_1000_rl_s1_r10k_dp001p0)=0.45 v(vp_op1_1000_rl_s1_r10k_dp001p0)=1.35 v(wbl_op0_n100_rl_s1_r10k_dp001p0)=0 v(rbl_op0_n100_rl_s1_r10k_dp001p0)=1.8 v(ref_op0_n100_rl_s1_r10k_dp001p0)=0
.ic v(sn_op0_n100_rl_s1_r10k_dp001p0_0)=-0.1 v(sn_op0_n100_rl_s1_r10k_dp001p0_1)=-0.1 v(sn_op0_n100_rl_s1_r10k_dp001p0_2)=-0.1 v(sn_op0_n100_rl_s1_r10k_dp001p0_3)=-0.1 v(vn_op0_n100_rl_s1_r10k_dp001p0)=0.45 v(vp_op0_n100_rl_s1_r10k_dp001p0)=1.35
.ic v(wbl_op0_0000_rl_s1_r10k_dp001p0)=0 v(rbl_op0_0000_rl_s1_r10k_dp001p0)=1.8 v(ref_op0_0000_rl_s1_r10k_dp001p0)=0 v(sn_op0_0000_rl_s1_r10k_dp001p0_0)=0 v(sn_op0_0000_rl_s1_r10k_dp001p0_1)=0 v(sn_op0_0000_rl_s1_r10k_dp001p0_2)=0
.ic v(sn_op0_0000_rl_s1_r10k_dp001p0_3)=0 v(vn_op0_0000_rl_s1_r10k_dp001p0)=0.45 v(vp_op0_0000_rl_s1_r10k_dp001p0)=1.35 v(wbl_op1_0900_rl_s1_r10k_dp002p0)=0 v(rbl_op1_0900_rl_s1_r10k_dp002p0)=1.8 v(ref_op1_0900_rl_s1_r10k_dp002p0)=0
.ic v(sn_op1_0900_rl_s1_r10k_dp002p0_0)=0.9 v(sn_op1_0900_rl_s1_r10k_dp002p0_1)=0.9 v(sn_op1_0900_rl_s1_r10k_dp002p0_2)=0.9 v(sn_op1_0900_rl_s1_r10k_dp002p0_3)=0.9 v(vn_op1_0900_rl_s1_r10k_dp002p0)=0.45 v(vp_op1_0900_rl_s1_r10k_dp002p0)=1.35
.ic v(wbl_op1_1000_rl_s1_r10k_dp002p0)=0 v(rbl_op1_1000_rl_s1_r10k_dp002p0)=1.8 v(ref_op1_1000_rl_s1_r10k_dp002p0)=0 v(sn_op1_1000_rl_s1_r10k_dp002p0_0)=1 v(sn_op1_1000_rl_s1_r10k_dp002p0_1)=1 v(sn_op1_1000_rl_s1_r10k_dp002p0_2)=1
.ic v(sn_op1_1000_rl_s1_r10k_dp002p0_3)=1 v(vn_op1_1000_rl_s1_r10k_dp002p0)=0.45 v(vp_op1_1000_rl_s1_r10k_dp002p0)=1.35 v(wbl_op0_n100_rl_s1_r10k_dp002p0)=0 v(rbl_op0_n100_rl_s1_r10k_dp002p0)=1.8 v(ref_op0_n100_rl_s1_r10k_dp002p0)=0
.ic v(sn_op0_n100_rl_s1_r10k_dp002p0_0)=-0.1 v(sn_op0_n100_rl_s1_r10k_dp002p0_1)=-0.1 v(sn_op0_n100_rl_s1_r10k_dp002p0_2)=-0.1 v(sn_op0_n100_rl_s1_r10k_dp002p0_3)=-0.1 v(vn_op0_n100_rl_s1_r10k_dp002p0)=0.45 v(vp_op0_n100_rl_s1_r10k_dp002p0)=1.35
.ic v(wbl_op0_0000_rl_s1_r10k_dp002p0)=0 v(rbl_op0_0000_rl_s1_r10k_dp002p0)=1.8 v(ref_op0_0000_rl_s1_r10k_dp002p0)=0 v(sn_op0_0000_rl_s1_r10k_dp002p0_0)=0 v(sn_op0_0000_rl_s1_r10k_dp002p0_1)=0 v(sn_op0_0000_rl_s1_r10k_dp002p0_2)=0
.ic v(sn_op0_0000_rl_s1_r10k_dp002p0_3)=0 v(vn_op0_0000_rl_s1_r10k_dp002p0)=0.45 v(vp_op0_0000_rl_s1_r10k_dp002p0)=1.35 v(wbl_op1_0900_rl_s1_r10k_dp003p0)=0 v(rbl_op1_0900_rl_s1_r10k_dp003p0)=1.8 v(ref_op1_0900_rl_s1_r10k_dp003p0)=0
.ic v(sn_op1_0900_rl_s1_r10k_dp003p0_0)=0.9 v(sn_op1_0900_rl_s1_r10k_dp003p0_1)=0.9 v(sn_op1_0900_rl_s1_r10k_dp003p0_2)=0.9 v(sn_op1_0900_rl_s1_r10k_dp003p0_3)=0.9 v(vn_op1_0900_rl_s1_r10k_dp003p0)=0.45 v(vp_op1_0900_rl_s1_r10k_dp003p0)=1.35
.ic v(wbl_op1_1000_rl_s1_r10k_dp003p0)=0 v(rbl_op1_1000_rl_s1_r10k_dp003p0)=1.8 v(ref_op1_1000_rl_s1_r10k_dp003p0)=0 v(sn_op1_1000_rl_s1_r10k_dp003p0_0)=1 v(sn_op1_1000_rl_s1_r10k_dp003p0_1)=1 v(sn_op1_1000_rl_s1_r10k_dp003p0_2)=1
.ic v(sn_op1_1000_rl_s1_r10k_dp003p0_3)=1 v(vn_op1_1000_rl_s1_r10k_dp003p0)=0.45 v(vp_op1_1000_rl_s1_r10k_dp003p0)=1.35 v(wbl_op0_n100_rl_s1_r10k_dp003p0)=0 v(rbl_op0_n100_rl_s1_r10k_dp003p0)=1.8 v(ref_op0_n100_rl_s1_r10k_dp003p0)=0
.ic v(sn_op0_n100_rl_s1_r10k_dp003p0_0)=-0.1 v(sn_op0_n100_rl_s1_r10k_dp003p0_1)=-0.1 v(sn_op0_n100_rl_s1_r10k_dp003p0_2)=-0.1 v(sn_op0_n100_rl_s1_r10k_dp003p0_3)=-0.1 v(vn_op0_n100_rl_s1_r10k_dp003p0)=0.45 v(vp_op0_n100_rl_s1_r10k_dp003p0)=1.35
.ic v(wbl_op0_0000_rl_s1_r10k_dp003p0)=0 v(rbl_op0_0000_rl_s1_r10k_dp003p0)=1.8 v(ref_op0_0000_rl_s1_r10k_dp003p0)=0 v(sn_op0_0000_rl_s1_r10k_dp003p0_0)=0 v(sn_op0_0000_rl_s1_r10k_dp003p0_1)=0 v(sn_op0_0000_rl_s1_r10k_dp003p0_2)=0
.ic v(sn_op0_0000_rl_s1_r10k_dp003p0_3)=0 v(vn_op0_0000_rl_s1_r10k_dp003p0)=0.45 v(vp_op0_0000_rl_s1_r10k_dp003p0)=1.35 v(wbl_op1_0900_rl_s2_r100k_dm016p0)=0 v(rbl_op1_0900_rl_s2_r100k_dm016p0)=1.8 v(ref_op1_0900_rl_s2_r100k_dm016p0)=0
.ic v(sn_op1_0900_rl_s2_r100k_dm016p0_0)=0.9 v(sn_op1_0900_rl_s2_r100k_dm016p0_1)=0.9 v(sn_op1_0900_rl_s2_r100k_dm016p0_2)=0.9 v(sn_op1_0900_rl_s2_r100k_dm016p0_3)=0.9 v(vn_op1_0900_rl_s2_r100k_dm016p0)=0.45 v(vp_op1_0900_rl_s2_r100k_dm016p0)=1.35
.ic v(wbl_op1_1000_rl_s2_r100k_dm016p0)=0 v(rbl_op1_1000_rl_s2_r100k_dm016p0)=1.8 v(ref_op1_1000_rl_s2_r100k_dm016p0)=0 v(sn_op1_1000_rl_s2_r100k_dm016p0_0)=1 v(sn_op1_1000_rl_s2_r100k_dm016p0_1)=1 v(sn_op1_1000_rl_s2_r100k_dm016p0_2)=1
.ic v(sn_op1_1000_rl_s2_r100k_dm016p0_3)=1 v(vn_op1_1000_rl_s2_r100k_dm016p0)=0.45 v(vp_op1_1000_rl_s2_r100k_dm016p0)=1.35 v(wbl_op0_n100_rl_s2_r100k_dm016p0)=0 v(rbl_op0_n100_rl_s2_r100k_dm016p0)=1.8 v(ref_op0_n100_rl_s2_r100k_dm016p0)=0
.ic v(sn_op0_n100_rl_s2_r100k_dm016p0_0)=-0.1 v(sn_op0_n100_rl_s2_r100k_dm016p0_1)=-0.1 v(sn_op0_n100_rl_s2_r100k_dm016p0_2)=-0.1 v(sn_op0_n100_rl_s2_r100k_dm016p0_3)=-0.1 v(vn_op0_n100_rl_s2_r100k_dm016p0)=0.45 v(vp_op0_n100_rl_s2_r100k_dm016p0)=1.35
.ic v(wbl_op0_0000_rl_s2_r100k_dm016p0)=0 v(rbl_op0_0000_rl_s2_r100k_dm016p0)=1.8 v(ref_op0_0000_rl_s2_r100k_dm016p0)=0 v(sn_op0_0000_rl_s2_r100k_dm016p0_0)=0 v(sn_op0_0000_rl_s2_r100k_dm016p0_1)=0 v(sn_op0_0000_rl_s2_r100k_dm016p0_2)=0
.ic v(sn_op0_0000_rl_s2_r100k_dm016p0_3)=0 v(vn_op0_0000_rl_s2_r100k_dm016p0)=0.45 v(vp_op0_0000_rl_s2_r100k_dm016p0)=1.35 v(wbl_op1_0900_rl_s2_r100k_dm008p0)=0 v(rbl_op1_0900_rl_s2_r100k_dm008p0)=1.8 v(ref_op1_0900_rl_s2_r100k_dm008p0)=0
.ic v(sn_op1_0900_rl_s2_r100k_dm008p0_0)=0.9 v(sn_op1_0900_rl_s2_r100k_dm008p0_1)=0.9 v(sn_op1_0900_rl_s2_r100k_dm008p0_2)=0.9 v(sn_op1_0900_rl_s2_r100k_dm008p0_3)=0.9 v(vn_op1_0900_rl_s2_r100k_dm008p0)=0.45 v(vp_op1_0900_rl_s2_r100k_dm008p0)=1.35
.ic v(wbl_op1_1000_rl_s2_r100k_dm008p0)=0 v(rbl_op1_1000_rl_s2_r100k_dm008p0)=1.8 v(ref_op1_1000_rl_s2_r100k_dm008p0)=0 v(sn_op1_1000_rl_s2_r100k_dm008p0_0)=1 v(sn_op1_1000_rl_s2_r100k_dm008p0_1)=1 v(sn_op1_1000_rl_s2_r100k_dm008p0_2)=1
.ic v(sn_op1_1000_rl_s2_r100k_dm008p0_3)=1 v(vn_op1_1000_rl_s2_r100k_dm008p0)=0.45 v(vp_op1_1000_rl_s2_r100k_dm008p0)=1.35 v(wbl_op0_n100_rl_s2_r100k_dm008p0)=0 v(rbl_op0_n100_rl_s2_r100k_dm008p0)=1.8 v(ref_op0_n100_rl_s2_r100k_dm008p0)=0
.ic v(sn_op0_n100_rl_s2_r100k_dm008p0_0)=-0.1 v(sn_op0_n100_rl_s2_r100k_dm008p0_1)=-0.1 v(sn_op0_n100_rl_s2_r100k_dm008p0_2)=-0.1 v(sn_op0_n100_rl_s2_r100k_dm008p0_3)=-0.1 v(vn_op0_n100_rl_s2_r100k_dm008p0)=0.45 v(vp_op0_n100_rl_s2_r100k_dm008p0)=1.35
.ic v(wbl_op0_0000_rl_s2_r100k_dm008p0)=0 v(rbl_op0_0000_rl_s2_r100k_dm008p0)=1.8 v(ref_op0_0000_rl_s2_r100k_dm008p0)=0 v(sn_op0_0000_rl_s2_r100k_dm008p0_0)=0 v(sn_op0_0000_rl_s2_r100k_dm008p0_1)=0 v(sn_op0_0000_rl_s2_r100k_dm008p0_2)=0
.ic v(sn_op0_0000_rl_s2_r100k_dm008p0_3)=0 v(vn_op0_0000_rl_s2_r100k_dm008p0)=0.45 v(vp_op0_0000_rl_s2_r100k_dm008p0)=1.35 v(wbl_op1_0900_rl_s2_r100k_dm004p0)=0 v(rbl_op1_0900_rl_s2_r100k_dm004p0)=1.8 v(ref_op1_0900_rl_s2_r100k_dm004p0)=0
.ic v(sn_op1_0900_rl_s2_r100k_dm004p0_0)=0.9 v(sn_op1_0900_rl_s2_r100k_dm004p0_1)=0.9 v(sn_op1_0900_rl_s2_r100k_dm004p0_2)=0.9 v(sn_op1_0900_rl_s2_r100k_dm004p0_3)=0.9 v(vn_op1_0900_rl_s2_r100k_dm004p0)=0.45 v(vp_op1_0900_rl_s2_r100k_dm004p0)=1.35
.ic v(wbl_op1_1000_rl_s2_r100k_dm004p0)=0 v(rbl_op1_1000_rl_s2_r100k_dm004p0)=1.8 v(ref_op1_1000_rl_s2_r100k_dm004p0)=0 v(sn_op1_1000_rl_s2_r100k_dm004p0_0)=1 v(sn_op1_1000_rl_s2_r100k_dm004p0_1)=1 v(sn_op1_1000_rl_s2_r100k_dm004p0_2)=1
.ic v(sn_op1_1000_rl_s2_r100k_dm004p0_3)=1 v(vn_op1_1000_rl_s2_r100k_dm004p0)=0.45 v(vp_op1_1000_rl_s2_r100k_dm004p0)=1.35 v(wbl_op0_n100_rl_s2_r100k_dm004p0)=0 v(rbl_op0_n100_rl_s2_r100k_dm004p0)=1.8 v(ref_op0_n100_rl_s2_r100k_dm004p0)=0
.ic v(sn_op0_n100_rl_s2_r100k_dm004p0_0)=-0.1 v(sn_op0_n100_rl_s2_r100k_dm004p0_1)=-0.1 v(sn_op0_n100_rl_s2_r100k_dm004p0_2)=-0.1 v(sn_op0_n100_rl_s2_r100k_dm004p0_3)=-0.1 v(vn_op0_n100_rl_s2_r100k_dm004p0)=0.45 v(vp_op0_n100_rl_s2_r100k_dm004p0)=1.35
.ic v(wbl_op0_0000_rl_s2_r100k_dm004p0)=0 v(rbl_op0_0000_rl_s2_r100k_dm004p0)=1.8 v(ref_op0_0000_rl_s2_r100k_dm004p0)=0 v(sn_op0_0000_rl_s2_r100k_dm004p0_0)=0 v(sn_op0_0000_rl_s2_r100k_dm004p0_1)=0 v(sn_op0_0000_rl_s2_r100k_dm004p0_2)=0
.ic v(sn_op0_0000_rl_s2_r100k_dm004p0_3)=0 v(vn_op0_0000_rl_s2_r100k_dm004p0)=0.45 v(vp_op0_0000_rl_s2_r100k_dm004p0)=1.35 v(wbl_op1_0900_rl_s2_r100k_dm002p0)=0 v(rbl_op1_0900_rl_s2_r100k_dm002p0)=1.8 v(ref_op1_0900_rl_s2_r100k_dm002p0)=0
.ic v(sn_op1_0900_rl_s2_r100k_dm002p0_0)=0.9 v(sn_op1_0900_rl_s2_r100k_dm002p0_1)=0.9 v(sn_op1_0900_rl_s2_r100k_dm002p0_2)=0.9 v(sn_op1_0900_rl_s2_r100k_dm002p0_3)=0.9 v(vn_op1_0900_rl_s2_r100k_dm002p0)=0.45 v(vp_op1_0900_rl_s2_r100k_dm002p0)=1.35
.ic v(wbl_op1_1000_rl_s2_r100k_dm002p0)=0 v(rbl_op1_1000_rl_s2_r100k_dm002p0)=1.8 v(ref_op1_1000_rl_s2_r100k_dm002p0)=0 v(sn_op1_1000_rl_s2_r100k_dm002p0_0)=1 v(sn_op1_1000_rl_s2_r100k_dm002p0_1)=1 v(sn_op1_1000_rl_s2_r100k_dm002p0_2)=1
.ic v(sn_op1_1000_rl_s2_r100k_dm002p0_3)=1 v(vn_op1_1000_rl_s2_r100k_dm002p0)=0.45 v(vp_op1_1000_rl_s2_r100k_dm002p0)=1.35 v(wbl_op0_n100_rl_s2_r100k_dm002p0)=0 v(rbl_op0_n100_rl_s2_r100k_dm002p0)=1.8 v(ref_op0_n100_rl_s2_r100k_dm002p0)=0
.ic v(sn_op0_n100_rl_s2_r100k_dm002p0_0)=-0.1 v(sn_op0_n100_rl_s2_r100k_dm002p0_1)=-0.1 v(sn_op0_n100_rl_s2_r100k_dm002p0_2)=-0.1 v(sn_op0_n100_rl_s2_r100k_dm002p0_3)=-0.1 v(vn_op0_n100_rl_s2_r100k_dm002p0)=0.45 v(vp_op0_n100_rl_s2_r100k_dm002p0)=1.35
.ic v(wbl_op0_0000_rl_s2_r100k_dm002p0)=0 v(rbl_op0_0000_rl_s2_r100k_dm002p0)=1.8 v(ref_op0_0000_rl_s2_r100k_dm002p0)=0 v(sn_op0_0000_rl_s2_r100k_dm002p0_0)=0 v(sn_op0_0000_rl_s2_r100k_dm002p0_1)=0 v(sn_op0_0000_rl_s2_r100k_dm002p0_2)=0
.ic v(sn_op0_0000_rl_s2_r100k_dm002p0_3)=0 v(vn_op0_0000_rl_s2_r100k_dm002p0)=0.45 v(vp_op0_0000_rl_s2_r100k_dm002p0)=1.35 v(wbl_op1_0900_rl_s2_r100k_dp000p0)=0 v(rbl_op1_0900_rl_s2_r100k_dp000p0)=1.8 v(ref_op1_0900_rl_s2_r100k_dp000p0)=0
.ic v(sn_op1_0900_rl_s2_r100k_dp000p0_0)=0.9 v(sn_op1_0900_rl_s2_r100k_dp000p0_1)=0.9 v(sn_op1_0900_rl_s2_r100k_dp000p0_2)=0.9 v(sn_op1_0900_rl_s2_r100k_dp000p0_3)=0.9 v(vn_op1_0900_rl_s2_r100k_dp000p0)=0.45 v(vp_op1_0900_rl_s2_r100k_dp000p0)=1.35
.ic v(wbl_op1_1000_rl_s2_r100k_dp000p0)=0 v(rbl_op1_1000_rl_s2_r100k_dp000p0)=1.8 v(ref_op1_1000_rl_s2_r100k_dp000p0)=0 v(sn_op1_1000_rl_s2_r100k_dp000p0_0)=1 v(sn_op1_1000_rl_s2_r100k_dp000p0_1)=1 v(sn_op1_1000_rl_s2_r100k_dp000p0_2)=1
.ic v(sn_op1_1000_rl_s2_r100k_dp000p0_3)=1 v(vn_op1_1000_rl_s2_r100k_dp000p0)=0.45 v(vp_op1_1000_rl_s2_r100k_dp000p0)=1.35 v(wbl_op0_n100_rl_s2_r100k_dp000p0)=0 v(rbl_op0_n100_rl_s2_r100k_dp000p0)=1.8 v(ref_op0_n100_rl_s2_r100k_dp000p0)=0
.ic v(sn_op0_n100_rl_s2_r100k_dp000p0_0)=-0.1 v(sn_op0_n100_rl_s2_r100k_dp000p0_1)=-0.1 v(sn_op0_n100_rl_s2_r100k_dp000p0_2)=-0.1 v(sn_op0_n100_rl_s2_r100k_dp000p0_3)=-0.1 v(vn_op0_n100_rl_s2_r100k_dp000p0)=0.45 v(vp_op0_n100_rl_s2_r100k_dp000p0)=1.35
.ic v(wbl_op0_0000_rl_s2_r100k_dp000p0)=0 v(rbl_op0_0000_rl_s2_r100k_dp000p0)=1.8 v(ref_op0_0000_rl_s2_r100k_dp000p0)=0 v(sn_op0_0000_rl_s2_r100k_dp000p0_0)=0 v(sn_op0_0000_rl_s2_r100k_dp000p0_1)=0 v(sn_op0_0000_rl_s2_r100k_dp000p0_2)=0
.ic v(sn_op0_0000_rl_s2_r100k_dp000p0_3)=0 v(vn_op0_0000_rl_s2_r100k_dp000p0)=0.45 v(vp_op0_0000_rl_s2_r100k_dp000p0)=1.35 v(wbl_op1_0900_rl_s2_r100k_dp001p0)=0 v(rbl_op1_0900_rl_s2_r100k_dp001p0)=1.8 v(ref_op1_0900_rl_s2_r100k_dp001p0)=0
.ic v(sn_op1_0900_rl_s2_r100k_dp001p0_0)=0.9 v(sn_op1_0900_rl_s2_r100k_dp001p0_1)=0.9 v(sn_op1_0900_rl_s2_r100k_dp001p0_2)=0.9 v(sn_op1_0900_rl_s2_r100k_dp001p0_3)=0.9 v(vn_op1_0900_rl_s2_r100k_dp001p0)=0.45 v(vp_op1_0900_rl_s2_r100k_dp001p0)=1.35
.ic v(wbl_op1_1000_rl_s2_r100k_dp001p0)=0 v(rbl_op1_1000_rl_s2_r100k_dp001p0)=1.8 v(ref_op1_1000_rl_s2_r100k_dp001p0)=0 v(sn_op1_1000_rl_s2_r100k_dp001p0_0)=1 v(sn_op1_1000_rl_s2_r100k_dp001p0_1)=1 v(sn_op1_1000_rl_s2_r100k_dp001p0_2)=1
.ic v(sn_op1_1000_rl_s2_r100k_dp001p0_3)=1 v(vn_op1_1000_rl_s2_r100k_dp001p0)=0.45 v(vp_op1_1000_rl_s2_r100k_dp001p0)=1.35 v(wbl_op0_n100_rl_s2_r100k_dp001p0)=0 v(rbl_op0_n100_rl_s2_r100k_dp001p0)=1.8 v(ref_op0_n100_rl_s2_r100k_dp001p0)=0
.ic v(sn_op0_n100_rl_s2_r100k_dp001p0_0)=-0.1 v(sn_op0_n100_rl_s2_r100k_dp001p0_1)=-0.1 v(sn_op0_n100_rl_s2_r100k_dp001p0_2)=-0.1 v(sn_op0_n100_rl_s2_r100k_dp001p0_3)=-0.1 v(vn_op0_n100_rl_s2_r100k_dp001p0)=0.45 v(vp_op0_n100_rl_s2_r100k_dp001p0)=1.35
.ic v(wbl_op0_0000_rl_s2_r100k_dp001p0)=0 v(rbl_op0_0000_rl_s2_r100k_dp001p0)=1.8 v(ref_op0_0000_rl_s2_r100k_dp001p0)=0 v(sn_op0_0000_rl_s2_r100k_dp001p0_0)=0 v(sn_op0_0000_rl_s2_r100k_dp001p0_1)=0 v(sn_op0_0000_rl_s2_r100k_dp001p0_2)=0
.ic v(sn_op0_0000_rl_s2_r100k_dp001p0_3)=0 v(vn_op0_0000_rl_s2_r100k_dp001p0)=0.45 v(vp_op0_0000_rl_s2_r100k_dp001p0)=1.35 v(wbl_op1_0900_rl_s2_r100k_dp002p0)=0 v(rbl_op1_0900_rl_s2_r100k_dp002p0)=1.8 v(ref_op1_0900_rl_s2_r100k_dp002p0)=0
.ic v(sn_op1_0900_rl_s2_r100k_dp002p0_0)=0.9 v(sn_op1_0900_rl_s2_r100k_dp002p0_1)=0.9 v(sn_op1_0900_rl_s2_r100k_dp002p0_2)=0.9 v(sn_op1_0900_rl_s2_r100k_dp002p0_3)=0.9 v(vn_op1_0900_rl_s2_r100k_dp002p0)=0.45 v(vp_op1_0900_rl_s2_r100k_dp002p0)=1.35
.ic v(wbl_op1_1000_rl_s2_r100k_dp002p0)=0 v(rbl_op1_1000_rl_s2_r100k_dp002p0)=1.8 v(ref_op1_1000_rl_s2_r100k_dp002p0)=0 v(sn_op1_1000_rl_s2_r100k_dp002p0_0)=1 v(sn_op1_1000_rl_s2_r100k_dp002p0_1)=1 v(sn_op1_1000_rl_s2_r100k_dp002p0_2)=1
.ic v(sn_op1_1000_rl_s2_r100k_dp002p0_3)=1 v(vn_op1_1000_rl_s2_r100k_dp002p0)=0.45 v(vp_op1_1000_rl_s2_r100k_dp002p0)=1.35 v(wbl_op0_n100_rl_s2_r100k_dp002p0)=0 v(rbl_op0_n100_rl_s2_r100k_dp002p0)=1.8 v(ref_op0_n100_rl_s2_r100k_dp002p0)=0
.ic v(sn_op0_n100_rl_s2_r100k_dp002p0_0)=-0.1 v(sn_op0_n100_rl_s2_r100k_dp002p0_1)=-0.1 v(sn_op0_n100_rl_s2_r100k_dp002p0_2)=-0.1 v(sn_op0_n100_rl_s2_r100k_dp002p0_3)=-0.1 v(vn_op0_n100_rl_s2_r100k_dp002p0)=0.45 v(vp_op0_n100_rl_s2_r100k_dp002p0)=1.35
.ic v(wbl_op0_0000_rl_s2_r100k_dp002p0)=0 v(rbl_op0_0000_rl_s2_r100k_dp002p0)=1.8 v(ref_op0_0000_rl_s2_r100k_dp002p0)=0 v(sn_op0_0000_rl_s2_r100k_dp002p0_0)=0 v(sn_op0_0000_rl_s2_r100k_dp002p0_1)=0 v(sn_op0_0000_rl_s2_r100k_dp002p0_2)=0
.ic v(sn_op0_0000_rl_s2_r100k_dp002p0_3)=0 v(vn_op0_0000_rl_s2_r100k_dp002p0)=0.45 v(vp_op0_0000_rl_s2_r100k_dp002p0)=1.35 v(wbl_op1_0900_rl_s2_r100k_dp003p0)=0 v(rbl_op1_0900_rl_s2_r100k_dp003p0)=1.8 v(ref_op1_0900_rl_s2_r100k_dp003p0)=0
.ic v(sn_op1_0900_rl_s2_r100k_dp003p0_0)=0.9 v(sn_op1_0900_rl_s2_r100k_dp003p0_1)=0.9 v(sn_op1_0900_rl_s2_r100k_dp003p0_2)=0.9 v(sn_op1_0900_rl_s2_r100k_dp003p0_3)=0.9 v(vn_op1_0900_rl_s2_r100k_dp003p0)=0.45 v(vp_op1_0900_rl_s2_r100k_dp003p0)=1.35
.ic v(wbl_op1_1000_rl_s2_r100k_dp003p0)=0 v(rbl_op1_1000_rl_s2_r100k_dp003p0)=1.8 v(ref_op1_1000_rl_s2_r100k_dp003p0)=0 v(sn_op1_1000_rl_s2_r100k_dp003p0_0)=1 v(sn_op1_1000_rl_s2_r100k_dp003p0_1)=1 v(sn_op1_1000_rl_s2_r100k_dp003p0_2)=1
.ic v(sn_op1_1000_rl_s2_r100k_dp003p0_3)=1 v(vn_op1_1000_rl_s2_r100k_dp003p0)=0.45 v(vp_op1_1000_rl_s2_r100k_dp003p0)=1.35 v(wbl_op0_n100_rl_s2_r100k_dp003p0)=0 v(rbl_op0_n100_rl_s2_r100k_dp003p0)=1.8 v(ref_op0_n100_rl_s2_r100k_dp003p0)=0
.ic v(sn_op0_n100_rl_s2_r100k_dp003p0_0)=-0.1 v(sn_op0_n100_rl_s2_r100k_dp003p0_1)=-0.1 v(sn_op0_n100_rl_s2_r100k_dp003p0_2)=-0.1 v(sn_op0_n100_rl_s2_r100k_dp003p0_3)=-0.1 v(vn_op0_n100_rl_s2_r100k_dp003p0)=0.45 v(vp_op0_n100_rl_s2_r100k_dp003p0)=1.35
.ic v(wbl_op0_0000_rl_s2_r100k_dp003p0)=0 v(rbl_op0_0000_rl_s2_r100k_dp003p0)=1.8 v(ref_op0_0000_rl_s2_r100k_dp003p0)=0 v(sn_op0_0000_rl_s2_r100k_dp003p0_0)=0 v(sn_op0_0000_rl_s2_r100k_dp003p0_1)=0 v(sn_op0_0000_rl_s2_r100k_dp003p0_2)=0
.ic v(sn_op0_0000_rl_s2_r100k_dp003p0_3)=0 v(vn_op0_0000_rl_s2_r100k_dp003p0)=0.45 v(vp_op0_0000_rl_s2_r100k_dp003p0)=1.35 v(wbl_op1_0900_an_s0p1_r0_ic)=0 v(rbl_op1_0900_an_s0p1_r0_ic)=1.8 v(ref_op1_0900_an_s0p1_r0_ic)=0
.ic v(sn_op1_0900_an_s0p1_r0_ic_0)=0.9 v(sn_op1_0900_an_s0p1_r0_ic_1)=0.9 v(sn_op1_0900_an_s0p1_r0_ic_2)=0.9 v(sn_op1_0900_an_s0p1_r0_ic_3)=0.9 v(vn_op1_0900_an_s0p1_r0_ic)=0.45 v(vp_op1_0900_an_s0p1_r0_ic)=1.35
.ic v(wbl_op1_1000_an_s0p1_r0_ic)=0 v(rbl_op1_1000_an_s0p1_r0_ic)=1.8 v(ref_op1_1000_an_s0p1_r0_ic)=0 v(sn_op1_1000_an_s0p1_r0_ic_0)=1 v(sn_op1_1000_an_s0p1_r0_ic_1)=1 v(sn_op1_1000_an_s0p1_r0_ic_2)=1
.ic v(sn_op1_1000_an_s0p1_r0_ic_3)=1 v(vn_op1_1000_an_s0p1_r0_ic)=0.45 v(vp_op1_1000_an_s0p1_r0_ic)=1.35 v(wbl_op0_n100_an_s0p1_r0_ic)=0 v(rbl_op0_n100_an_s0p1_r0_ic)=1.8 v(ref_op0_n100_an_s0p1_r0_ic)=0
.ic v(sn_op0_n100_an_s0p1_r0_ic_0)=-0.1 v(sn_op0_n100_an_s0p1_r0_ic_1)=-0.1 v(sn_op0_n100_an_s0p1_r0_ic_2)=-0.1 v(sn_op0_n100_an_s0p1_r0_ic_3)=-0.1 v(vn_op0_n100_an_s0p1_r0_ic)=0.45 v(vp_op0_n100_an_s0p1_r0_ic)=1.35
.ic v(wbl_op0_0000_an_s0p1_r0_ic)=0 v(rbl_op0_0000_an_s0p1_r0_ic)=1.8 v(ref_op0_0000_an_s0p1_r0_ic)=0 v(sn_op0_0000_an_s0p1_r0_ic_0)=0 v(sn_op0_0000_an_s0p1_r0_ic_1)=0 v(sn_op0_0000_an_s0p1_r0_ic_2)=0
.ic v(sn_op0_0000_an_s0p1_r0_ic_3)=0 v(vn_op0_0000_an_s0p1_r0_ic)=0.45 v(vp_op0_0000_an_s0p1_r0_ic)=1.35 v(wbl_op1_0900_rh_s0p1_r0_ic)=0 v(rbl_op1_0900_rh_s0p1_r0_ic)=1.8 v(ref_op1_0900_rh_s0p1_r0_ic)=0
.ic v(sn_op1_0900_rh_s0p1_r0_ic_0)=0.9 v(sn_op1_0900_rh_s0p1_r0_ic_1)=0.9 v(sn_op1_0900_rh_s0p1_r0_ic_2)=0.9 v(sn_op1_0900_rh_s0p1_r0_ic_3)=0.9 v(vn_op1_0900_rh_s0p1_r0_ic)=0.45 v(vp_op1_0900_rh_s0p1_r0_ic)=1.35
.ic v(wbl_op1_1000_rh_s0p1_r0_ic)=0 v(rbl_op1_1000_rh_s0p1_r0_ic)=1.8 v(ref_op1_1000_rh_s0p1_r0_ic)=0 v(sn_op1_1000_rh_s0p1_r0_ic_0)=1 v(sn_op1_1000_rh_s0p1_r0_ic_1)=1 v(sn_op1_1000_rh_s0p1_r0_ic_2)=1
.ic v(sn_op1_1000_rh_s0p1_r0_ic_3)=1 v(vn_op1_1000_rh_s0p1_r0_ic)=0.45 v(vp_op1_1000_rh_s0p1_r0_ic)=1.35 v(wbl_op0_n100_rh_s0p1_r0_ic)=0 v(rbl_op0_n100_rh_s0p1_r0_ic)=1.8 v(ref_op0_n100_rh_s0p1_r0_ic)=0
.ic v(sn_op0_n100_rh_s0p1_r0_ic_0)=-0.1 v(sn_op0_n100_rh_s0p1_r0_ic_1)=-0.1 v(sn_op0_n100_rh_s0p1_r0_ic_2)=-0.1 v(sn_op0_n100_rh_s0p1_r0_ic_3)=-0.1 v(vn_op0_n100_rh_s0p1_r0_ic)=0.45 v(vp_op0_n100_rh_s0p1_r0_ic)=1.35
.ic v(wbl_op0_0000_rh_s0p1_r0_ic)=0 v(rbl_op0_0000_rh_s0p1_r0_ic)=1.8 v(ref_op0_0000_rh_s0p1_r0_ic)=0 v(sn_op0_0000_rh_s0p1_r0_ic_0)=0 v(sn_op0_0000_rh_s0p1_r0_ic_1)=0 v(sn_op0_0000_rh_s0p1_r0_ic_2)=0
.ic v(sn_op0_0000_rh_s0p1_r0_ic_3)=0 v(vn_op0_0000_rh_s0p1_r0_ic)=0.45 v(vp_op0_0000_rh_s0p1_r0_ic)=1.35 v(wbl_op1_0900_rl_s0p1_r0_ic)=0 v(rbl_op1_0900_rl_s0p1_r0_ic)=1.8 v(ref_op1_0900_rl_s0p1_r0_ic)=0
.ic v(sn_op1_0900_rl_s0p1_r0_ic_0)=0.9 v(sn_op1_0900_rl_s0p1_r0_ic_1)=0.9 v(sn_op1_0900_rl_s0p1_r0_ic_2)=0.9 v(sn_op1_0900_rl_s0p1_r0_ic_3)=0.9 v(vn_op1_0900_rl_s0p1_r0_ic)=0.45 v(vp_op1_0900_rl_s0p1_r0_ic)=1.35
.ic v(wbl_op1_1000_rl_s0p1_r0_ic)=0 v(rbl_op1_1000_rl_s0p1_r0_ic)=1.8 v(ref_op1_1000_rl_s0p1_r0_ic)=0 v(sn_op1_1000_rl_s0p1_r0_ic_0)=1 v(sn_op1_1000_rl_s0p1_r0_ic_1)=1 v(sn_op1_1000_rl_s0p1_r0_ic_2)=1
.ic v(sn_op1_1000_rl_s0p1_r0_ic_3)=1 v(vn_op1_1000_rl_s0p1_r0_ic)=0.45 v(vp_op1_1000_rl_s0p1_r0_ic)=1.35 v(wbl_op0_n100_rl_s0p1_r0_ic)=0 v(rbl_op0_n100_rl_s0p1_r0_ic)=1.8 v(ref_op0_n100_rl_s0p1_r0_ic)=0
.ic v(sn_op0_n100_rl_s0p1_r0_ic_0)=-0.1 v(sn_op0_n100_rl_s0p1_r0_ic_1)=-0.1 v(sn_op0_n100_rl_s0p1_r0_ic_2)=-0.1 v(sn_op0_n100_rl_s0p1_r0_ic_3)=-0.1 v(vn_op0_n100_rl_s0p1_r0_ic)=0.45 v(vp_op0_n100_rl_s0p1_r0_ic)=1.35
.ic v(wbl_op0_0000_rl_s0p1_r0_ic)=0 v(rbl_op0_0000_rl_s0p1_r0_ic)=1.8 v(ref_op0_0000_rl_s0p1_r0_ic)=0 v(sn_op0_0000_rl_s0p1_r0_ic_0)=0 v(sn_op0_0000_rl_s0p1_r0_ic_1)=0 v(sn_op0_0000_rl_s0p1_r0_ic_2)=0
.ic v(sn_op0_0000_rl_s0p1_r0_ic_3)=0 v(vn_op0_0000_rl_s0p1_r0_ic)=0.45 v(vp_op0_0000_rl_s0p1_r0_ic)=1.35 v(wbl_op1_0900_rl_s0p1_r1k_ic)=0 v(rbl_op1_0900_rl_s0p1_r1k_ic)=1.8 v(ref_op1_0900_rl_s0p1_r1k_ic)=0
.ic v(sn_op1_0900_rl_s0p1_r1k_ic_0)=0.9 v(sn_op1_0900_rl_s0p1_r1k_ic_1)=0.9 v(sn_op1_0900_rl_s0p1_r1k_ic_2)=0.9 v(sn_op1_0900_rl_s0p1_r1k_ic_3)=0.9 v(vn_op1_0900_rl_s0p1_r1k_ic)=0.45 v(vp_op1_0900_rl_s0p1_r1k_ic)=1.35
.ic v(wbl_op1_1000_rl_s0p1_r1k_ic)=0 v(rbl_op1_1000_rl_s0p1_r1k_ic)=1.8 v(ref_op1_1000_rl_s0p1_r1k_ic)=0 v(sn_op1_1000_rl_s0p1_r1k_ic_0)=1 v(sn_op1_1000_rl_s0p1_r1k_ic_1)=1 v(sn_op1_1000_rl_s0p1_r1k_ic_2)=1
.ic v(sn_op1_1000_rl_s0p1_r1k_ic_3)=1 v(vn_op1_1000_rl_s0p1_r1k_ic)=0.45 v(vp_op1_1000_rl_s0p1_r1k_ic)=1.35 v(wbl_op0_n100_rl_s0p1_r1k_ic)=0 v(rbl_op0_n100_rl_s0p1_r1k_ic)=1.8 v(ref_op0_n100_rl_s0p1_r1k_ic)=0
.ic v(sn_op0_n100_rl_s0p1_r1k_ic_0)=-0.1 v(sn_op0_n100_rl_s0p1_r1k_ic_1)=-0.1 v(sn_op0_n100_rl_s0p1_r1k_ic_2)=-0.1 v(sn_op0_n100_rl_s0p1_r1k_ic_3)=-0.1 v(vn_op0_n100_rl_s0p1_r1k_ic)=0.45 v(vp_op0_n100_rl_s0p1_r1k_ic)=1.35
.ic v(wbl_op0_0000_rl_s0p1_r1k_ic)=0 v(rbl_op0_0000_rl_s0p1_r1k_ic)=1.8 v(ref_op0_0000_rl_s0p1_r1k_ic)=0 v(sn_op0_0000_rl_s0p1_r1k_ic_0)=0 v(sn_op0_0000_rl_s0p1_r1k_ic_1)=0 v(sn_op0_0000_rl_s0p1_r1k_ic_2)=0
.ic v(sn_op0_0000_rl_s0p1_r1k_ic_3)=0 v(vn_op0_0000_rl_s0p1_r1k_ic)=0.45 v(vp_op0_0000_rl_s0p1_r1k_ic)=1.35 v(wbl_op1_0900_rl_s0p1_r10k_ic)=0 v(rbl_op1_0900_rl_s0p1_r10k_ic)=1.8 v(ref_op1_0900_rl_s0p1_r10k_ic)=0
.ic v(sn_op1_0900_rl_s0p1_r10k_ic_0)=0.9 v(sn_op1_0900_rl_s0p1_r10k_ic_1)=0.9 v(sn_op1_0900_rl_s0p1_r10k_ic_2)=0.9 v(sn_op1_0900_rl_s0p1_r10k_ic_3)=0.9 v(vn_op1_0900_rl_s0p1_r10k_ic)=0.45 v(vp_op1_0900_rl_s0p1_r10k_ic)=1.35
.ic v(wbl_op1_1000_rl_s0p1_r10k_ic)=0 v(rbl_op1_1000_rl_s0p1_r10k_ic)=1.8 v(ref_op1_1000_rl_s0p1_r10k_ic)=0 v(sn_op1_1000_rl_s0p1_r10k_ic_0)=1 v(sn_op1_1000_rl_s0p1_r10k_ic_1)=1 v(sn_op1_1000_rl_s0p1_r10k_ic_2)=1
.ic v(sn_op1_1000_rl_s0p1_r10k_ic_3)=1 v(vn_op1_1000_rl_s0p1_r10k_ic)=0.45 v(vp_op1_1000_rl_s0p1_r10k_ic)=1.35 v(wbl_op0_n100_rl_s0p1_r10k_ic)=0 v(rbl_op0_n100_rl_s0p1_r10k_ic)=1.8 v(ref_op0_n100_rl_s0p1_r10k_ic)=0
.ic v(sn_op0_n100_rl_s0p1_r10k_ic_0)=-0.1 v(sn_op0_n100_rl_s0p1_r10k_ic_1)=-0.1 v(sn_op0_n100_rl_s0p1_r10k_ic_2)=-0.1 v(sn_op0_n100_rl_s0p1_r10k_ic_3)=-0.1 v(vn_op0_n100_rl_s0p1_r10k_ic)=0.45 v(vp_op0_n100_rl_s0p1_r10k_ic)=1.35
.ic v(wbl_op0_0000_rl_s0p1_r10k_ic)=0 v(rbl_op0_0000_rl_s0p1_r10k_ic)=1.8 v(ref_op0_0000_rl_s0p1_r10k_ic)=0 v(sn_op0_0000_rl_s0p1_r10k_ic_0)=0 v(sn_op0_0000_rl_s0p1_r10k_ic_1)=0 v(sn_op0_0000_rl_s0p1_r10k_ic_2)=0
.ic v(sn_op0_0000_rl_s0p1_r10k_ic_3)=0 v(vn_op0_0000_rl_s0p1_r10k_ic)=0.45 v(vp_op0_0000_rl_s0p1_r10k_ic)=1.35 v(wbl_op1_0900_nr_s0p1_r0)=0 v(rbl_op1_0900_nr_s0p1_r0)=1.8 v(ref_op1_0900_nr_s0p1_r0)=0
.ic v(sn_op1_0900_nr_s0p1_r0_0)=0.9 v(sn_op1_0900_nr_s0p1_r0_1)=0.9 v(sn_op1_0900_nr_s0p1_r0_2)=0.9 v(sn_op1_0900_nr_s0p1_r0_3)=0.9 v(vn_op1_0900_nr_s0p1_r0)=0.45 v(vp_op1_0900_nr_s0p1_r0)=1.35
.ic v(wbl_op1_1000_nr_s0p1_r0)=0 v(rbl_op1_1000_nr_s0p1_r0)=1.8 v(ref_op1_1000_nr_s0p1_r0)=0 v(sn_op1_1000_nr_s0p1_r0_0)=1 v(sn_op1_1000_nr_s0p1_r0_1)=1 v(sn_op1_1000_nr_s0p1_r0_2)=1
.ic v(sn_op1_1000_nr_s0p1_r0_3)=1 v(vn_op1_1000_nr_s0p1_r0)=0.45 v(vp_op1_1000_nr_s0p1_r0)=1.35 v(wbl_op0_n100_nr_s0p1_r0)=0 v(rbl_op0_n100_nr_s0p1_r0)=1.8 v(ref_op0_n100_nr_s0p1_r0)=0
.ic v(sn_op0_n100_nr_s0p1_r0_0)=-0.1 v(sn_op0_n100_nr_s0p1_r0_1)=-0.1 v(sn_op0_n100_nr_s0p1_r0_2)=-0.1 v(sn_op0_n100_nr_s0p1_r0_3)=-0.1 v(vn_op0_n100_nr_s0p1_r0)=0.45 v(vp_op0_n100_nr_s0p1_r0)=1.35
.ic v(wbl_op0_0000_nr_s0p1_r0)=0 v(rbl_op0_0000_nr_s0p1_r0)=1.8 v(ref_op0_0000_nr_s0p1_r0)=0 v(sn_op0_0000_nr_s0p1_r0_0)=0 v(sn_op0_0000_nr_s0p1_r0_1)=0 v(sn_op0_0000_nr_s0p1_r0_2)=0
.ic v(sn_op0_0000_nr_s0p1_r0_3)=0 v(vn_op0_0000_nr_s0p1_r0)=0.45 v(vp_op0_0000_nr_s0p1_r0)=1.35 v(wbl_op1_0900_nl_s0p1_r0)=0 v(rbl_op1_0900_nl_s0p1_r0)=1.8 v(ref_op1_0900_nl_s0p1_r0)=0
.ic v(sn_op1_0900_nl_s0p1_r0_0)=0.9 v(sn_op1_0900_nl_s0p1_r0_1)=0.9 v(sn_op1_0900_nl_s0p1_r0_2)=0.9 v(sn_op1_0900_nl_s0p1_r0_3)=0.9 v(vn_op1_0900_nl_s0p1_r0)=0.45 v(vp_op1_0900_nl_s0p1_r0)=1.35
.ic v(wbl_op1_1000_nl_s0p1_r0)=0 v(rbl_op1_1000_nl_s0p1_r0)=1.8 v(ref_op1_1000_nl_s0p1_r0)=0 v(sn_op1_1000_nl_s0p1_r0_0)=1 v(sn_op1_1000_nl_s0p1_r0_1)=1 v(sn_op1_1000_nl_s0p1_r0_2)=1
.ic v(sn_op1_1000_nl_s0p1_r0_3)=1 v(vn_op1_1000_nl_s0p1_r0)=0.45 v(vp_op1_1000_nl_s0p1_r0)=1.35 v(wbl_op0_n100_nl_s0p1_r0)=0 v(rbl_op0_n100_nl_s0p1_r0)=1.8 v(ref_op0_n100_nl_s0p1_r0)=0
.ic v(sn_op0_n100_nl_s0p1_r0_0)=-0.1 v(sn_op0_n100_nl_s0p1_r0_1)=-0.1 v(sn_op0_n100_nl_s0p1_r0_2)=-0.1 v(sn_op0_n100_nl_s0p1_r0_3)=-0.1 v(vn_op0_n100_nl_s0p1_r0)=0.45 v(vp_op0_n100_nl_s0p1_r0)=1.35
.ic v(wbl_op0_0000_nl_s0p1_r0)=0 v(rbl_op0_0000_nl_s0p1_r0)=1.8 v(ref_op0_0000_nl_s0p1_r0)=0 v(sn_op0_0000_nl_s0p1_r0_0)=0 v(sn_op0_0000_nl_s0p1_r0_1)=0 v(sn_op0_0000_nl_s0p1_r0_2)=0
.ic v(sn_op0_0000_nl_s0p1_r0_3)=0 v(vn_op0_0000_nl_s0p1_r0)=0.45 v(vp_op0_0000_nl_s0p1_r0)=1.35 v(wbl_op1_0900_nr_s1_r10k)=0 v(rbl_op1_0900_nr_s1_r10k)=1.8 v(ref_op1_0900_nr_s1_r10k)=0
.ic v(sn_op1_0900_nr_s1_r10k_0)=0.9 v(sn_op1_0900_nr_s1_r10k_1)=0.9 v(sn_op1_0900_nr_s1_r10k_2)=0.9 v(sn_op1_0900_nr_s1_r10k_3)=0.9 v(vn_op1_0900_nr_s1_r10k)=0.45 v(vp_op1_0900_nr_s1_r10k)=1.35
.ic v(wbl_op1_1000_nr_s1_r10k)=0 v(rbl_op1_1000_nr_s1_r10k)=1.8 v(ref_op1_1000_nr_s1_r10k)=0 v(sn_op1_1000_nr_s1_r10k_0)=1 v(sn_op1_1000_nr_s1_r10k_1)=1 v(sn_op1_1000_nr_s1_r10k_2)=1
.ic v(sn_op1_1000_nr_s1_r10k_3)=1 v(vn_op1_1000_nr_s1_r10k)=0.45 v(vp_op1_1000_nr_s1_r10k)=1.35 v(wbl_op0_n100_nr_s1_r10k)=0 v(rbl_op0_n100_nr_s1_r10k)=1.8 v(ref_op0_n100_nr_s1_r10k)=0
.ic v(sn_op0_n100_nr_s1_r10k_0)=-0.1 v(sn_op0_n100_nr_s1_r10k_1)=-0.1 v(sn_op0_n100_nr_s1_r10k_2)=-0.1 v(sn_op0_n100_nr_s1_r10k_3)=-0.1 v(vn_op0_n100_nr_s1_r10k)=0.45 v(vp_op0_n100_nr_s1_r10k)=1.35
.ic v(wbl_op0_0000_nr_s1_r10k)=0 v(rbl_op0_0000_nr_s1_r10k)=1.8 v(ref_op0_0000_nr_s1_r10k)=0 v(sn_op0_0000_nr_s1_r10k_0)=0 v(sn_op0_0000_nr_s1_r10k_1)=0 v(sn_op0_0000_nr_s1_r10k_2)=0
.ic v(sn_op0_0000_nr_s1_r10k_3)=0 v(vn_op0_0000_nr_s1_r10k)=0.45 v(vp_op0_0000_nr_s1_r10k)=1.35 v(wbl_op1_0900_nl_s1_r10k)=0 v(rbl_op1_0900_nl_s1_r10k)=1.8 v(ref_op1_0900_nl_s1_r10k)=0
.ic v(sn_op1_0900_nl_s1_r10k_0)=0.9 v(sn_op1_0900_nl_s1_r10k_1)=0.9 v(sn_op1_0900_nl_s1_r10k_2)=0.9 v(sn_op1_0900_nl_s1_r10k_3)=0.9 v(vn_op1_0900_nl_s1_r10k)=0.45 v(vp_op1_0900_nl_s1_r10k)=1.35
.ic v(wbl_op1_1000_nl_s1_r10k)=0 v(rbl_op1_1000_nl_s1_r10k)=1.8 v(ref_op1_1000_nl_s1_r10k)=0 v(sn_op1_1000_nl_s1_r10k_0)=1 v(sn_op1_1000_nl_s1_r10k_1)=1 v(sn_op1_1000_nl_s1_r10k_2)=1
.ic v(sn_op1_1000_nl_s1_r10k_3)=1 v(vn_op1_1000_nl_s1_r10k)=0.45 v(vp_op1_1000_nl_s1_r10k)=1.35 v(wbl_op0_n100_nl_s1_r10k)=0 v(rbl_op0_n100_nl_s1_r10k)=1.8 v(ref_op0_n100_nl_s1_r10k)=0
.ic v(sn_op0_n100_nl_s1_r10k_0)=-0.1 v(sn_op0_n100_nl_s1_r10k_1)=-0.1 v(sn_op0_n100_nl_s1_r10k_2)=-0.1 v(sn_op0_n100_nl_s1_r10k_3)=-0.1 v(vn_op0_n100_nl_s1_r10k)=0.45 v(vp_op0_n100_nl_s1_r10k)=1.35
.ic v(wbl_op0_0000_nl_s1_r10k)=0 v(rbl_op0_0000_nl_s1_r10k)=1.8 v(ref_op0_0000_nl_s1_r10k)=0 v(sn_op0_0000_nl_s1_r10k_0)=0 v(sn_op0_0000_nl_s1_r10k_1)=0 v(sn_op0_0000_nl_s1_r10k_2)=0
.ic v(sn_op0_0000_nl_s1_r10k_3)=0 v(vn_op0_0000_nl_s1_r10k)=0.45 v(vp_op0_0000_nl_s1_r10k)=1.35 v(wbl_op1_0900_nr_s2_r100k)=0 v(rbl_op1_0900_nr_s2_r100k)=1.8 v(ref_op1_0900_nr_s2_r100k)=0
.ic v(sn_op1_0900_nr_s2_r100k_0)=0.9 v(sn_op1_0900_nr_s2_r100k_1)=0.9 v(sn_op1_0900_nr_s2_r100k_2)=0.9 v(sn_op1_0900_nr_s2_r100k_3)=0.9 v(vn_op1_0900_nr_s2_r100k)=0.45 v(vp_op1_0900_nr_s2_r100k)=1.35
.ic v(wbl_op1_1000_nr_s2_r100k)=0 v(rbl_op1_1000_nr_s2_r100k)=1.8 v(ref_op1_1000_nr_s2_r100k)=0 v(sn_op1_1000_nr_s2_r100k_0)=1 v(sn_op1_1000_nr_s2_r100k_1)=1 v(sn_op1_1000_nr_s2_r100k_2)=1
.ic v(sn_op1_1000_nr_s2_r100k_3)=1 v(vn_op1_1000_nr_s2_r100k)=0.45 v(vp_op1_1000_nr_s2_r100k)=1.35 v(wbl_op0_n100_nr_s2_r100k)=0 v(rbl_op0_n100_nr_s2_r100k)=1.8 v(ref_op0_n100_nr_s2_r100k)=0
.ic v(sn_op0_n100_nr_s2_r100k_0)=-0.1 v(sn_op0_n100_nr_s2_r100k_1)=-0.1 v(sn_op0_n100_nr_s2_r100k_2)=-0.1 v(sn_op0_n100_nr_s2_r100k_3)=-0.1 v(vn_op0_n100_nr_s2_r100k)=0.45 v(vp_op0_n100_nr_s2_r100k)=1.35
.ic v(wbl_op0_0000_nr_s2_r100k)=0 v(rbl_op0_0000_nr_s2_r100k)=1.8 v(ref_op0_0000_nr_s2_r100k)=0 v(sn_op0_0000_nr_s2_r100k_0)=0 v(sn_op0_0000_nr_s2_r100k_1)=0 v(sn_op0_0000_nr_s2_r100k_2)=0
.ic v(sn_op0_0000_nr_s2_r100k_3)=0 v(vn_op0_0000_nr_s2_r100k)=0.45 v(vp_op0_0000_nr_s2_r100k)=1.35 v(wbl_op1_0900_nl_s2_r100k)=0 v(rbl_op1_0900_nl_s2_r100k)=1.8 v(ref_op1_0900_nl_s2_r100k)=0
.ic v(sn_op1_0900_nl_s2_r100k_0)=0.9 v(sn_op1_0900_nl_s2_r100k_1)=0.9 v(sn_op1_0900_nl_s2_r100k_2)=0.9 v(sn_op1_0900_nl_s2_r100k_3)=0.9 v(vn_op1_0900_nl_s2_r100k)=0.45 v(vp_op1_0900_nl_s2_r100k)=1.35
.ic v(wbl_op1_1000_nl_s2_r100k)=0 v(rbl_op1_1000_nl_s2_r100k)=1.8 v(ref_op1_1000_nl_s2_r100k)=0 v(sn_op1_1000_nl_s2_r100k_0)=1 v(sn_op1_1000_nl_s2_r100k_1)=1 v(sn_op1_1000_nl_s2_r100k_2)=1
.ic v(sn_op1_1000_nl_s2_r100k_3)=1 v(vn_op1_1000_nl_s2_r100k)=0.45 v(vp_op1_1000_nl_s2_r100k)=1.35 v(wbl_op0_n100_nl_s2_r100k)=0 v(rbl_op0_n100_nl_s2_r100k)=1.8 v(ref_op0_n100_nl_s2_r100k)=0
.ic v(sn_op0_n100_nl_s2_r100k_0)=-0.1 v(sn_op0_n100_nl_s2_r100k_1)=-0.1 v(sn_op0_n100_nl_s2_r100k_2)=-0.1 v(sn_op0_n100_nl_s2_r100k_3)=-0.1 v(vn_op0_n100_nl_s2_r100k)=0.45 v(vp_op0_n100_nl_s2_r100k)=1.35
.ic v(wbl_op0_0000_nl_s2_r100k)=0 v(rbl_op0_0000_nl_s2_r100k)=1.8 v(ref_op0_0000_nl_s2_r100k)=0 v(sn_op0_0000_nl_s2_r100k_0)=0 v(sn_op0_0000_nl_s2_r100k_1)=0 v(sn_op0_0000_nl_s2_r100k_2)=0
.ic v(sn_op0_0000_nl_s2_r100k_3)=0 v(vn_op0_0000_nl_s2_r100k)=0.45 v(vp_op0_0000_nl_s2_r100k)=1.35
* initial conditions of the finite-impedance RWL pins (idle = VDD)
.ic v(rwls_op1_0900_an_s0p1_r0_ic)=1.8 v(rwls_op1_1000_an_s0p1_r0_ic)=1.8 v(rwls_op0_n100_an_s0p1_r0_ic)=1.8 v(rwls_op0_0000_an_s0p1_r0_ic)=1.8
.ic v(rwls_op1_0900_rh_s0p1_r0_ic)=1.8 v(rwls_op1_1000_rh_s0p1_r0_ic)=1.8 v(rwls_op0_n100_rh_s0p1_r0_ic)=1.8 v(rwls_op0_0000_rh_s0p1_r0_ic)=1.8
.ic v(rwls_op1_0900_rl_s0p1_r0_ic)=1.8 v(rwls_op1_1000_rl_s0p1_r0_ic)=1.8 v(rwls_op0_n100_rl_s0p1_r0_ic)=1.8 v(rwls_op0_0000_rl_s0p1_r0_ic)=1.8
.ic v(rwls_op1_0900_rl_s0p1_r1k_ic)=1.8 v(rwlsrc_op1_0900_rl_s0p1_r1k_ic)=1.8 v(rwls_op1_1000_rl_s0p1_r1k_ic)=1.8 v(rwlsrc_op1_1000_rl_s0p1_r1k_ic)=1.8 v(rwls_op0_n100_rl_s0p1_r1k_ic)=1.8 v(rwlsrc_op0_n100_rl_s0p1_r1k_ic)=1.8 v(rwls_op0_0000_rl_s0p1_r1k_ic)=1.8 v(rwlsrc_op0_0000_rl_s0p1_r1k_ic)=1.8
.ic v(rwls_op1_0900_rl_s0p1_r10k_ic)=1.8 v(rwlsrc_op1_0900_rl_s0p1_r10k_ic)=1.8 v(rwls_op1_1000_rl_s0p1_r10k_ic)=1.8 v(rwlsrc_op1_1000_rl_s0p1_r10k_ic)=1.8 v(rwls_op0_n100_rl_s0p1_r10k_ic)=1.8 v(rwlsrc_op0_n100_rl_s0p1_r10k_ic)=1.8 v(rwls_op0_0000_rl_s0p1_r10k_ic)=1.8 v(rwlsrc_op0_0000_rl_s0p1_r10k_ic)=1.8
