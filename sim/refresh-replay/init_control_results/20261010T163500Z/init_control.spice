* refresh_replay.spice -- RTL-strobe replay of one REFRESH op in the refresh-op circuit, issue #128
* GENERATED by gen_refresh_replay.py; do not edit by hand.
*
* PROPOSED/UNRATIFIED SCOPE: 27 C and 125 C, tt/ss/ff/sf/fs global corners, 1.8 V, no mismatch.
* Circuit body identical to sim/refresh-op/refresh_op.spice (ideal drivers, 100 ohm switches,
* C_RBL = C_WBL = 10 fF assumed, 4-row column, ref = VRBL - 100 mV, same latch); ONLY the control
* PWL sources differ. Sources per instance: ctl<-pre_en, rwls<-rwl_sel (inverted), en/enb<-sense_en
* (or the latch-hold adapter waveform), wwl<-wwl_en, wbc<-bl_drive. Instance suffix = variant.

.param VDD   = 1.8
.param VRBL  = 0.9   $ ASSUMPTION (contract)
.param C_RBL = 1e-14   $ ASSUMPTION (contract; not extracted)
.param C_WBL = 1e-14   $ ASSUMPTION (not extracted)
.param C_SN  = 6.05354e-16   $ extracted-from-netlist (layout/gain_cell_2t.extract.parasitics.json)

* ---- shared static drivers (ideal) ----
vdd   vdd 0 dc {VDD}
vrwld rwl_des 0 dc {VDD}
vwwld wwl_des 0 dc 0
vpre  prea 0 dc {VRBL}
vref  pref 0 dc 0.8   $ reference = VRBL - 0.1 (ASSUMPTION)
.model swpre sw(vt=0.9 vh=0.1 ron=100 roff=1e12)
.model swwbl sw(vt=0.9 vh=0.1 ron=100 roff=1e12)

* ---- instance 0: op1_0900_baseline_analog (variant baseline_analog; probe dec 14.9 ns, release 37 ns, meas 39 ns) ----
vctl_op1_0900_baseline_analog ctl_op1_0900_baseline_analog 0 pwl(0.0000e+00 {VDD} 2.0000e-09 {VDD} 2.1000e-09 0)
vrs_op1_0900_baseline_analog rwls_op1_0900_baseline_analog 0 pwl(0.0000e+00 {VDD} 4.0000e-09 {VDD} 4.1000e-09 0 3.7000e-08 0 3.7100e-08 {VDD})
ven_op1_0900_baseline_analog en_op1_0900_baseline_analog 0 pwl(0.0000e+00 0 1.4000e-08 0 1.4100e-08 {VDD} 3.7000e-08 {VDD} 3.7100e-08 0)
venb_op1_0900_baseline_analog enb_op1_0900_baseline_analog 0 pwl(0.0000e+00 {VDD} 1.4000e-08 {VDD} 1.4100e-08 0 3.7000e-08 0 3.7100e-08 {VDD})
vww_op1_0900_baseline_analog wwl_op1_0900_baseline_analog 0 pwl(0.0000e+00 0 1.5000e-08 0 1.5100e-08 {VDD} 3.5000e-08 {VDD} 3.5100e-08 0)
vwc_op1_0900_baseline_analog wbc_op1_0900_baseline_analog 0 pwl(0.0000e+00 0 1.5000e-08 0 1.5100e-08 {VDD} 3.7000e-08 {VDD} 3.7100e-08 0)
swb_op1_0900_baseline_analog ref_op1_0900_baseline_analog wbl_op1_0900_baseline_analog wbc_op1_0900_baseline_analog 0 swwbl
cwbl_op1_0900_baseline_analog wbl_op1_0900_baseline_analog 0 {C_WBL}
spa_op1_0900_baseline_analog prea rbl_op1_0900_baseline_analog ctl_op1_0900_baseline_analog 0 swpre
spr_op1_0900_baseline_analog pref ref_op1_0900_baseline_analog ctl_op1_0900_baseline_analog 0 swpre
crbl_op1_0900_baseline_analog rbl_op1_0900_baseline_analog 0 {C_RBL}
cref_op1_0900_baseline_analog ref_op1_0900_baseline_analog 0 {C_RBL}   $ ASSUMPTION: ideal matched dummy load
XMWR_op1_0900_baseline_analog_0 sn_op1_0900_baseline_analog_0 wwl_op1_0900_baseline_analog wbl_op1_0900_baseline_analog 0 sky130_fd_pr__nfet_01v8 L=0.15 W=0.42 nf=1 ad=0.1218 as=0.1218 pd=1.42 ps=1.42 nrd=0.69047619047619  nrs=0.69047619047619 sa=0 sb=0 sd=0 mult=1 m=1
XMRD_op1_0900_baseline_analog_0 rbl_op1_0900_baseline_analog sn_op1_0900_baseline_analog_0 rwls_op1_0900_baseline_analog 0 sky130_fd_pr__nfet_01v8 L=0.15 W=0.42 nf=1 ad=0.1218 as=0.1218 pd=1.42 ps=1.42 nrd=0.69047619047619  nrs=0.69047619047619 sa=0 sb=0 sd=0 mult=1 m=1
csn_op1_0900_baseline_analog_0 sn_op1_0900_baseline_analog_0 0 {C_SN}
XMWR_op1_0900_baseline_analog_1 sn_op1_0900_baseline_analog_1 wwl_des wbl_op1_0900_baseline_analog 0 sky130_fd_pr__nfet_01v8 L=0.15 W=0.42 nf=1 ad=0.1218 as=0.1218 pd=1.42 ps=1.42 nrd=0.69047619047619  nrs=0.69047619047619 sa=0 sb=0 sd=0 mult=1 m=1
XMRD_op1_0900_baseline_analog_1 rbl_op1_0900_baseline_analog sn_op1_0900_baseline_analog_1 rwl_des 0 sky130_fd_pr__nfet_01v8 L=0.15 W=0.42 nf=1 ad=0.1218 as=0.1218 pd=1.42 ps=1.42 nrd=0.69047619047619  nrs=0.69047619047619 sa=0 sb=0 sd=0 mult=1 m=1
csn_op1_0900_baseline_analog_1 sn_op1_0900_baseline_analog_1 0 {C_SN}
XMWR_op1_0900_baseline_analog_2 sn_op1_0900_baseline_analog_2 wwl_des wbl_op1_0900_baseline_analog 0 sky130_fd_pr__nfet_01v8 L=0.15 W=0.42 nf=1 ad=0.1218 as=0.1218 pd=1.42 ps=1.42 nrd=0.69047619047619  nrs=0.69047619047619 sa=0 sb=0 sd=0 mult=1 m=1
XMRD_op1_0900_baseline_analog_2 rbl_op1_0900_baseline_analog sn_op1_0900_baseline_analog_2 rwl_des 0 sky130_fd_pr__nfet_01v8 L=0.15 W=0.42 nf=1 ad=0.1218 as=0.1218 pd=1.42 ps=1.42 nrd=0.69047619047619  nrs=0.69047619047619 sa=0 sb=0 sd=0 mult=1 m=1
csn_op1_0900_baseline_analog_2 sn_op1_0900_baseline_analog_2 0 {C_SN}
XMWR_op1_0900_baseline_analog_3 sn_op1_0900_baseline_analog_3 wwl_des wbl_op1_0900_baseline_analog 0 sky130_fd_pr__nfet_01v8 L=0.15 W=0.42 nf=1 ad=0.1218 as=0.1218 pd=1.42 ps=1.42 nrd=0.69047619047619  nrs=0.69047619047619 sa=0 sb=0 sd=0 mult=1 m=1
XMRD_op1_0900_baseline_analog_3 rbl_op1_0900_baseline_analog sn_op1_0900_baseline_analog_3 rwl_des 0 sky130_fd_pr__nfet_01v8 L=0.15 W=0.42 nf=1 ad=0.1218 as=0.1218 pd=1.42 ps=1.42 nrd=0.69047619047619  nrs=0.69047619047619 sa=0 sb=0 sd=0 mult=1 m=1
csn_op1_0900_baseline_analog_3 sn_op1_0900_baseline_analog_3 0 {C_SN}
XMN1_op1_0900_baseline_analog rbl_op1_0900_baseline_analog ref_op1_0900_baseline_analog vn_op1_0900_baseline_analog 0 sky130_fd_pr__nfet_01v8 L=0.15 W=1 nf=1 ad=0.29 as=0.29 pd=2.58 ps=2.58 mult=1 m=1
XMN2_op1_0900_baseline_analog ref_op1_0900_baseline_analog rbl_op1_0900_baseline_analog vn_op1_0900_baseline_analog 0 sky130_fd_pr__nfet_01v8 L=0.15 W=1 nf=1 ad=0.29 as=0.29 pd=2.58 ps=2.58 mult=1 m=1
XMP1_op1_0900_baseline_analog rbl_op1_0900_baseline_analog ref_op1_0900_baseline_analog vp_op1_0900_baseline_analog vdd sky130_fd_pr__pfet_01v8 L=0.15 W=2 nf=1 ad=0.58 as=0.58 pd=4.58 ps=4.58 mult=1 m=1
XMP2_op1_0900_baseline_analog ref_op1_0900_baseline_analog rbl_op1_0900_baseline_analog vp_op1_0900_baseline_analog vdd sky130_fd_pr__pfet_01v8 L=0.15 W=2 nf=1 ad=0.58 as=0.58 pd=4.58 ps=4.58 mult=1 m=1
XMNF_op1_0900_baseline_analog vn_op1_0900_baseline_analog en_op1_0900_baseline_analog 0 0 sky130_fd_pr__nfet_01v8 L=0.15 W=2 nf=1 ad=0.58 as=0.58 pd=4.58 ps=4.58 mult=1 m=1
XMPH_op1_0900_baseline_analog vp_op1_0900_baseline_analog enb_op1_0900_baseline_analog vdd vdd sky130_fd_pr__pfet_01v8 L=0.15 W=4 nf=1 ad=1.16 as=1.16 pd=8.58 ps=8.58 mult=1 m=1
bd_op1_0900_baseline_analog d_op1_0900_baseline_analog 0 v=v(rbl_op1_0900_baseline_analog)-v(ref_op1_0900_baseline_analog)

* ---- instance 1: op1_1000_baseline_analog (variant baseline_analog; probe dec 14.9 ns, release 37 ns, meas 39 ns) ----
vctl_op1_1000_baseline_analog ctl_op1_1000_baseline_analog 0 pwl(0.0000e+00 {VDD} 2.0000e-09 {VDD} 2.1000e-09 0)
vrs_op1_1000_baseline_analog rwls_op1_1000_baseline_analog 0 pwl(0.0000e+00 {VDD} 4.0000e-09 {VDD} 4.1000e-09 0 3.7000e-08 0 3.7100e-08 {VDD})
ven_op1_1000_baseline_analog en_op1_1000_baseline_analog 0 pwl(0.0000e+00 0 1.4000e-08 0 1.4100e-08 {VDD} 3.7000e-08 {VDD} 3.7100e-08 0)
venb_op1_1000_baseline_analog enb_op1_1000_baseline_analog 0 pwl(0.0000e+00 {VDD} 1.4000e-08 {VDD} 1.4100e-08 0 3.7000e-08 0 3.7100e-08 {VDD})
vww_op1_1000_baseline_analog wwl_op1_1000_baseline_analog 0 pwl(0.0000e+00 0 1.5000e-08 0 1.5100e-08 {VDD} 3.5000e-08 {VDD} 3.5100e-08 0)
vwc_op1_1000_baseline_analog wbc_op1_1000_baseline_analog 0 pwl(0.0000e+00 0 1.5000e-08 0 1.5100e-08 {VDD} 3.7000e-08 {VDD} 3.7100e-08 0)
swb_op1_1000_baseline_analog ref_op1_1000_baseline_analog wbl_op1_1000_baseline_analog wbc_op1_1000_baseline_analog 0 swwbl
cwbl_op1_1000_baseline_analog wbl_op1_1000_baseline_analog 0 {C_WBL}
spa_op1_1000_baseline_analog prea rbl_op1_1000_baseline_analog ctl_op1_1000_baseline_analog 0 swpre
spr_op1_1000_baseline_analog pref ref_op1_1000_baseline_analog ctl_op1_1000_baseline_analog 0 swpre
crbl_op1_1000_baseline_analog rbl_op1_1000_baseline_analog 0 {C_RBL}
cref_op1_1000_baseline_analog ref_op1_1000_baseline_analog 0 {C_RBL}   $ ASSUMPTION: ideal matched dummy load
XMWR_op1_1000_baseline_analog_0 sn_op1_1000_baseline_analog_0 wwl_op1_1000_baseline_analog wbl_op1_1000_baseline_analog 0 sky130_fd_pr__nfet_01v8 L=0.15 W=0.42 nf=1 ad=0.1218 as=0.1218 pd=1.42 ps=1.42 nrd=0.69047619047619  nrs=0.69047619047619 sa=0 sb=0 sd=0 mult=1 m=1
XMRD_op1_1000_baseline_analog_0 rbl_op1_1000_baseline_analog sn_op1_1000_baseline_analog_0 rwls_op1_1000_baseline_analog 0 sky130_fd_pr__nfet_01v8 L=0.15 W=0.42 nf=1 ad=0.1218 as=0.1218 pd=1.42 ps=1.42 nrd=0.69047619047619  nrs=0.69047619047619 sa=0 sb=0 sd=0 mult=1 m=1
csn_op1_1000_baseline_analog_0 sn_op1_1000_baseline_analog_0 0 {C_SN}
XMWR_op1_1000_baseline_analog_1 sn_op1_1000_baseline_analog_1 wwl_des wbl_op1_1000_baseline_analog 0 sky130_fd_pr__nfet_01v8 L=0.15 W=0.42 nf=1 ad=0.1218 as=0.1218 pd=1.42 ps=1.42 nrd=0.69047619047619  nrs=0.69047619047619 sa=0 sb=0 sd=0 mult=1 m=1
XMRD_op1_1000_baseline_analog_1 rbl_op1_1000_baseline_analog sn_op1_1000_baseline_analog_1 rwl_des 0 sky130_fd_pr__nfet_01v8 L=0.15 W=0.42 nf=1 ad=0.1218 as=0.1218 pd=1.42 ps=1.42 nrd=0.69047619047619  nrs=0.69047619047619 sa=0 sb=0 sd=0 mult=1 m=1
csn_op1_1000_baseline_analog_1 sn_op1_1000_baseline_analog_1 0 {C_SN}
XMWR_op1_1000_baseline_analog_2 sn_op1_1000_baseline_analog_2 wwl_des wbl_op1_1000_baseline_analog 0 sky130_fd_pr__nfet_01v8 L=0.15 W=0.42 nf=1 ad=0.1218 as=0.1218 pd=1.42 ps=1.42 nrd=0.69047619047619  nrs=0.69047619047619 sa=0 sb=0 sd=0 mult=1 m=1
XMRD_op1_1000_baseline_analog_2 rbl_op1_1000_baseline_analog sn_op1_1000_baseline_analog_2 rwl_des 0 sky130_fd_pr__nfet_01v8 L=0.15 W=0.42 nf=1 ad=0.1218 as=0.1218 pd=1.42 ps=1.42 nrd=0.69047619047619  nrs=0.69047619047619 sa=0 sb=0 sd=0 mult=1 m=1
csn_op1_1000_baseline_analog_2 sn_op1_1000_baseline_analog_2 0 {C_SN}
XMWR_op1_1000_baseline_analog_3 sn_op1_1000_baseline_analog_3 wwl_des wbl_op1_1000_baseline_analog 0 sky130_fd_pr__nfet_01v8 L=0.15 W=0.42 nf=1 ad=0.1218 as=0.1218 pd=1.42 ps=1.42 nrd=0.69047619047619  nrs=0.69047619047619 sa=0 sb=0 sd=0 mult=1 m=1
XMRD_op1_1000_baseline_analog_3 rbl_op1_1000_baseline_analog sn_op1_1000_baseline_analog_3 rwl_des 0 sky130_fd_pr__nfet_01v8 L=0.15 W=0.42 nf=1 ad=0.1218 as=0.1218 pd=1.42 ps=1.42 nrd=0.69047619047619  nrs=0.69047619047619 sa=0 sb=0 sd=0 mult=1 m=1
csn_op1_1000_baseline_analog_3 sn_op1_1000_baseline_analog_3 0 {C_SN}
XMN1_op1_1000_baseline_analog rbl_op1_1000_baseline_analog ref_op1_1000_baseline_analog vn_op1_1000_baseline_analog 0 sky130_fd_pr__nfet_01v8 L=0.15 W=1 nf=1 ad=0.29 as=0.29 pd=2.58 ps=2.58 mult=1 m=1
XMN2_op1_1000_baseline_analog ref_op1_1000_baseline_analog rbl_op1_1000_baseline_analog vn_op1_1000_baseline_analog 0 sky130_fd_pr__nfet_01v8 L=0.15 W=1 nf=1 ad=0.29 as=0.29 pd=2.58 ps=2.58 mult=1 m=1
XMP1_op1_1000_baseline_analog rbl_op1_1000_baseline_analog ref_op1_1000_baseline_analog vp_op1_1000_baseline_analog vdd sky130_fd_pr__pfet_01v8 L=0.15 W=2 nf=1 ad=0.58 as=0.58 pd=4.58 ps=4.58 mult=1 m=1
XMP2_op1_1000_baseline_analog ref_op1_1000_baseline_analog rbl_op1_1000_baseline_analog vp_op1_1000_baseline_analog vdd sky130_fd_pr__pfet_01v8 L=0.15 W=2 nf=1 ad=0.58 as=0.58 pd=4.58 ps=4.58 mult=1 m=1
XMNF_op1_1000_baseline_analog vn_op1_1000_baseline_analog en_op1_1000_baseline_analog 0 0 sky130_fd_pr__nfet_01v8 L=0.15 W=2 nf=1 ad=0.58 as=0.58 pd=4.58 ps=4.58 mult=1 m=1
XMPH_op1_1000_baseline_analog vp_op1_1000_baseline_analog enb_op1_1000_baseline_analog vdd vdd sky130_fd_pr__pfet_01v8 L=0.15 W=4 nf=1 ad=1.16 as=1.16 pd=8.58 ps=8.58 mult=1 m=1
bd_op1_1000_baseline_analog d_op1_1000_baseline_analog 0 v=v(rbl_op1_1000_baseline_analog)-v(ref_op1_1000_baseline_analog)

* ---- instance 2: op0_n100_baseline_analog (variant baseline_analog; probe dec 14.9 ns, release 37 ns, meas 39 ns) ----
vctl_op0_n100_baseline_analog ctl_op0_n100_baseline_analog 0 pwl(0.0000e+00 {VDD} 2.0000e-09 {VDD} 2.1000e-09 0)
vrs_op0_n100_baseline_analog rwls_op0_n100_baseline_analog 0 pwl(0.0000e+00 {VDD} 4.0000e-09 {VDD} 4.1000e-09 0 3.7000e-08 0 3.7100e-08 {VDD})
ven_op0_n100_baseline_analog en_op0_n100_baseline_analog 0 pwl(0.0000e+00 0 1.4000e-08 0 1.4100e-08 {VDD} 3.7000e-08 {VDD} 3.7100e-08 0)
venb_op0_n100_baseline_analog enb_op0_n100_baseline_analog 0 pwl(0.0000e+00 {VDD} 1.4000e-08 {VDD} 1.4100e-08 0 3.7000e-08 0 3.7100e-08 {VDD})
vww_op0_n100_baseline_analog wwl_op0_n100_baseline_analog 0 pwl(0.0000e+00 0 1.5000e-08 0 1.5100e-08 {VDD} 3.5000e-08 {VDD} 3.5100e-08 0)
vwc_op0_n100_baseline_analog wbc_op0_n100_baseline_analog 0 pwl(0.0000e+00 0 1.5000e-08 0 1.5100e-08 {VDD} 3.7000e-08 {VDD} 3.7100e-08 0)
swb_op0_n100_baseline_analog ref_op0_n100_baseline_analog wbl_op0_n100_baseline_analog wbc_op0_n100_baseline_analog 0 swwbl
cwbl_op0_n100_baseline_analog wbl_op0_n100_baseline_analog 0 {C_WBL}
spa_op0_n100_baseline_analog prea rbl_op0_n100_baseline_analog ctl_op0_n100_baseline_analog 0 swpre
spr_op0_n100_baseline_analog pref ref_op0_n100_baseline_analog ctl_op0_n100_baseline_analog 0 swpre
crbl_op0_n100_baseline_analog rbl_op0_n100_baseline_analog 0 {C_RBL}
cref_op0_n100_baseline_analog ref_op0_n100_baseline_analog 0 {C_RBL}   $ ASSUMPTION: ideal matched dummy load
XMWR_op0_n100_baseline_analog_0 sn_op0_n100_baseline_analog_0 wwl_op0_n100_baseline_analog wbl_op0_n100_baseline_analog 0 sky130_fd_pr__nfet_01v8 L=0.15 W=0.42 nf=1 ad=0.1218 as=0.1218 pd=1.42 ps=1.42 nrd=0.69047619047619  nrs=0.69047619047619 sa=0 sb=0 sd=0 mult=1 m=1
XMRD_op0_n100_baseline_analog_0 rbl_op0_n100_baseline_analog sn_op0_n100_baseline_analog_0 rwls_op0_n100_baseline_analog 0 sky130_fd_pr__nfet_01v8 L=0.15 W=0.42 nf=1 ad=0.1218 as=0.1218 pd=1.42 ps=1.42 nrd=0.69047619047619  nrs=0.69047619047619 sa=0 sb=0 sd=0 mult=1 m=1
csn_op0_n100_baseline_analog_0 sn_op0_n100_baseline_analog_0 0 {C_SN}
XMWR_op0_n100_baseline_analog_1 sn_op0_n100_baseline_analog_1 wwl_des wbl_op0_n100_baseline_analog 0 sky130_fd_pr__nfet_01v8 L=0.15 W=0.42 nf=1 ad=0.1218 as=0.1218 pd=1.42 ps=1.42 nrd=0.69047619047619  nrs=0.69047619047619 sa=0 sb=0 sd=0 mult=1 m=1
XMRD_op0_n100_baseline_analog_1 rbl_op0_n100_baseline_analog sn_op0_n100_baseline_analog_1 rwl_des 0 sky130_fd_pr__nfet_01v8 L=0.15 W=0.42 nf=1 ad=0.1218 as=0.1218 pd=1.42 ps=1.42 nrd=0.69047619047619  nrs=0.69047619047619 sa=0 sb=0 sd=0 mult=1 m=1
csn_op0_n100_baseline_analog_1 sn_op0_n100_baseline_analog_1 0 {C_SN}
XMWR_op0_n100_baseline_analog_2 sn_op0_n100_baseline_analog_2 wwl_des wbl_op0_n100_baseline_analog 0 sky130_fd_pr__nfet_01v8 L=0.15 W=0.42 nf=1 ad=0.1218 as=0.1218 pd=1.42 ps=1.42 nrd=0.69047619047619  nrs=0.69047619047619 sa=0 sb=0 sd=0 mult=1 m=1
XMRD_op0_n100_baseline_analog_2 rbl_op0_n100_baseline_analog sn_op0_n100_baseline_analog_2 rwl_des 0 sky130_fd_pr__nfet_01v8 L=0.15 W=0.42 nf=1 ad=0.1218 as=0.1218 pd=1.42 ps=1.42 nrd=0.69047619047619  nrs=0.69047619047619 sa=0 sb=0 sd=0 mult=1 m=1
csn_op0_n100_baseline_analog_2 sn_op0_n100_baseline_analog_2 0 {C_SN}
XMWR_op0_n100_baseline_analog_3 sn_op0_n100_baseline_analog_3 wwl_des wbl_op0_n100_baseline_analog 0 sky130_fd_pr__nfet_01v8 L=0.15 W=0.42 nf=1 ad=0.1218 as=0.1218 pd=1.42 ps=1.42 nrd=0.69047619047619  nrs=0.69047619047619 sa=0 sb=0 sd=0 mult=1 m=1
XMRD_op0_n100_baseline_analog_3 rbl_op0_n100_baseline_analog sn_op0_n100_baseline_analog_3 rwl_des 0 sky130_fd_pr__nfet_01v8 L=0.15 W=0.42 nf=1 ad=0.1218 as=0.1218 pd=1.42 ps=1.42 nrd=0.69047619047619  nrs=0.69047619047619 sa=0 sb=0 sd=0 mult=1 m=1
csn_op0_n100_baseline_analog_3 sn_op0_n100_baseline_analog_3 0 {C_SN}
XMN1_op0_n100_baseline_analog rbl_op0_n100_baseline_analog ref_op0_n100_baseline_analog vn_op0_n100_baseline_analog 0 sky130_fd_pr__nfet_01v8 L=0.15 W=1 nf=1 ad=0.29 as=0.29 pd=2.58 ps=2.58 mult=1 m=1
XMN2_op0_n100_baseline_analog ref_op0_n100_baseline_analog rbl_op0_n100_baseline_analog vn_op0_n100_baseline_analog 0 sky130_fd_pr__nfet_01v8 L=0.15 W=1 nf=1 ad=0.29 as=0.29 pd=2.58 ps=2.58 mult=1 m=1
XMP1_op0_n100_baseline_analog rbl_op0_n100_baseline_analog ref_op0_n100_baseline_analog vp_op0_n100_baseline_analog vdd sky130_fd_pr__pfet_01v8 L=0.15 W=2 nf=1 ad=0.58 as=0.58 pd=4.58 ps=4.58 mult=1 m=1
XMP2_op0_n100_baseline_analog ref_op0_n100_baseline_analog rbl_op0_n100_baseline_analog vp_op0_n100_baseline_analog vdd sky130_fd_pr__pfet_01v8 L=0.15 W=2 nf=1 ad=0.58 as=0.58 pd=4.58 ps=4.58 mult=1 m=1
XMNF_op0_n100_baseline_analog vn_op0_n100_baseline_analog en_op0_n100_baseline_analog 0 0 sky130_fd_pr__nfet_01v8 L=0.15 W=2 nf=1 ad=0.58 as=0.58 pd=4.58 ps=4.58 mult=1 m=1
XMPH_op0_n100_baseline_analog vp_op0_n100_baseline_analog enb_op0_n100_baseline_analog vdd vdd sky130_fd_pr__pfet_01v8 L=0.15 W=4 nf=1 ad=1.16 as=1.16 pd=8.58 ps=8.58 mult=1 m=1
bd_op0_n100_baseline_analog d_op0_n100_baseline_analog 0 v=v(rbl_op0_n100_baseline_analog)-v(ref_op0_n100_baseline_analog)

* ---- instance 3: op0_0000_baseline_analog (variant baseline_analog; probe dec 14.9 ns, release 37 ns, meas 39 ns) ----
vctl_op0_0000_baseline_analog ctl_op0_0000_baseline_analog 0 pwl(0.0000e+00 {VDD} 2.0000e-09 {VDD} 2.1000e-09 0)
vrs_op0_0000_baseline_analog rwls_op0_0000_baseline_analog 0 pwl(0.0000e+00 {VDD} 4.0000e-09 {VDD} 4.1000e-09 0 3.7000e-08 0 3.7100e-08 {VDD})
ven_op0_0000_baseline_analog en_op0_0000_baseline_analog 0 pwl(0.0000e+00 0 1.4000e-08 0 1.4100e-08 {VDD} 3.7000e-08 {VDD} 3.7100e-08 0)
venb_op0_0000_baseline_analog enb_op0_0000_baseline_analog 0 pwl(0.0000e+00 {VDD} 1.4000e-08 {VDD} 1.4100e-08 0 3.7000e-08 0 3.7100e-08 {VDD})
vww_op0_0000_baseline_analog wwl_op0_0000_baseline_analog 0 pwl(0.0000e+00 0 1.5000e-08 0 1.5100e-08 {VDD} 3.5000e-08 {VDD} 3.5100e-08 0)
vwc_op0_0000_baseline_analog wbc_op0_0000_baseline_analog 0 pwl(0.0000e+00 0 1.5000e-08 0 1.5100e-08 {VDD} 3.7000e-08 {VDD} 3.7100e-08 0)
swb_op0_0000_baseline_analog ref_op0_0000_baseline_analog wbl_op0_0000_baseline_analog wbc_op0_0000_baseline_analog 0 swwbl
cwbl_op0_0000_baseline_analog wbl_op0_0000_baseline_analog 0 {C_WBL}
spa_op0_0000_baseline_analog prea rbl_op0_0000_baseline_analog ctl_op0_0000_baseline_analog 0 swpre
spr_op0_0000_baseline_analog pref ref_op0_0000_baseline_analog ctl_op0_0000_baseline_analog 0 swpre
crbl_op0_0000_baseline_analog rbl_op0_0000_baseline_analog 0 {C_RBL}
cref_op0_0000_baseline_analog ref_op0_0000_baseline_analog 0 {C_RBL}   $ ASSUMPTION: ideal matched dummy load
XMWR_op0_0000_baseline_analog_0 sn_op0_0000_baseline_analog_0 wwl_op0_0000_baseline_analog wbl_op0_0000_baseline_analog 0 sky130_fd_pr__nfet_01v8 L=0.15 W=0.42 nf=1 ad=0.1218 as=0.1218 pd=1.42 ps=1.42 nrd=0.69047619047619  nrs=0.69047619047619 sa=0 sb=0 sd=0 mult=1 m=1
XMRD_op0_0000_baseline_analog_0 rbl_op0_0000_baseline_analog sn_op0_0000_baseline_analog_0 rwls_op0_0000_baseline_analog 0 sky130_fd_pr__nfet_01v8 L=0.15 W=0.42 nf=1 ad=0.1218 as=0.1218 pd=1.42 ps=1.42 nrd=0.69047619047619  nrs=0.69047619047619 sa=0 sb=0 sd=0 mult=1 m=1
csn_op0_0000_baseline_analog_0 sn_op0_0000_baseline_analog_0 0 {C_SN}
XMWR_op0_0000_baseline_analog_1 sn_op0_0000_baseline_analog_1 wwl_des wbl_op0_0000_baseline_analog 0 sky130_fd_pr__nfet_01v8 L=0.15 W=0.42 nf=1 ad=0.1218 as=0.1218 pd=1.42 ps=1.42 nrd=0.69047619047619  nrs=0.69047619047619 sa=0 sb=0 sd=0 mult=1 m=1
XMRD_op0_0000_baseline_analog_1 rbl_op0_0000_baseline_analog sn_op0_0000_baseline_analog_1 rwl_des 0 sky130_fd_pr__nfet_01v8 L=0.15 W=0.42 nf=1 ad=0.1218 as=0.1218 pd=1.42 ps=1.42 nrd=0.69047619047619  nrs=0.69047619047619 sa=0 sb=0 sd=0 mult=1 m=1
csn_op0_0000_baseline_analog_1 sn_op0_0000_baseline_analog_1 0 {C_SN}
XMWR_op0_0000_baseline_analog_2 sn_op0_0000_baseline_analog_2 wwl_des wbl_op0_0000_baseline_analog 0 sky130_fd_pr__nfet_01v8 L=0.15 W=0.42 nf=1 ad=0.1218 as=0.1218 pd=1.42 ps=1.42 nrd=0.69047619047619  nrs=0.69047619047619 sa=0 sb=0 sd=0 mult=1 m=1
XMRD_op0_0000_baseline_analog_2 rbl_op0_0000_baseline_analog sn_op0_0000_baseline_analog_2 rwl_des 0 sky130_fd_pr__nfet_01v8 L=0.15 W=0.42 nf=1 ad=0.1218 as=0.1218 pd=1.42 ps=1.42 nrd=0.69047619047619  nrs=0.69047619047619 sa=0 sb=0 sd=0 mult=1 m=1
csn_op0_0000_baseline_analog_2 sn_op0_0000_baseline_analog_2 0 {C_SN}
XMWR_op0_0000_baseline_analog_3 sn_op0_0000_baseline_analog_3 wwl_des wbl_op0_0000_baseline_analog 0 sky130_fd_pr__nfet_01v8 L=0.15 W=0.42 nf=1 ad=0.1218 as=0.1218 pd=1.42 ps=1.42 nrd=0.69047619047619  nrs=0.69047619047619 sa=0 sb=0 sd=0 mult=1 m=1
XMRD_op0_0000_baseline_analog_3 rbl_op0_0000_baseline_analog sn_op0_0000_baseline_analog_3 rwl_des 0 sky130_fd_pr__nfet_01v8 L=0.15 W=0.42 nf=1 ad=0.1218 as=0.1218 pd=1.42 ps=1.42 nrd=0.69047619047619  nrs=0.69047619047619 sa=0 sb=0 sd=0 mult=1 m=1
csn_op0_0000_baseline_analog_3 sn_op0_0000_baseline_analog_3 0 {C_SN}
XMN1_op0_0000_baseline_analog rbl_op0_0000_baseline_analog ref_op0_0000_baseline_analog vn_op0_0000_baseline_analog 0 sky130_fd_pr__nfet_01v8 L=0.15 W=1 nf=1 ad=0.29 as=0.29 pd=2.58 ps=2.58 mult=1 m=1
XMN2_op0_0000_baseline_analog ref_op0_0000_baseline_analog rbl_op0_0000_baseline_analog vn_op0_0000_baseline_analog 0 sky130_fd_pr__nfet_01v8 L=0.15 W=1 nf=1 ad=0.29 as=0.29 pd=2.58 ps=2.58 mult=1 m=1
XMP1_op0_0000_baseline_analog rbl_op0_0000_baseline_analog ref_op0_0000_baseline_analog vp_op0_0000_baseline_analog vdd sky130_fd_pr__pfet_01v8 L=0.15 W=2 nf=1 ad=0.58 as=0.58 pd=4.58 ps=4.58 mult=1 m=1
XMP2_op0_0000_baseline_analog ref_op0_0000_baseline_analog rbl_op0_0000_baseline_analog vp_op0_0000_baseline_analog vdd sky130_fd_pr__pfet_01v8 L=0.15 W=2 nf=1 ad=0.58 as=0.58 pd=4.58 ps=4.58 mult=1 m=1
XMNF_op0_0000_baseline_analog vn_op0_0000_baseline_analog en_op0_0000_baseline_analog 0 0 sky130_fd_pr__nfet_01v8 L=0.15 W=2 nf=1 ad=0.58 as=0.58 pd=4.58 ps=4.58 mult=1 m=1
XMPH_op0_0000_baseline_analog vp_op0_0000_baseline_analog enb_op0_0000_baseline_analog vdd vdd sky130_fd_pr__pfet_01v8 L=0.15 W=4 nf=1 ad=1.16 as=1.16 pd=8.58 ps=8.58 mult=1 m=1
bd_op0_0000_baseline_analog d_op0_0000_baseline_analog 0 v=v(rbl_op0_0000_baseline_analog)-v(ref_op0_0000_baseline_analog)

* ---- instance 4: op1_0900_rtl_hold (variant rtl_hold; probe dec 11.9 ns, release 34 ns, meas 36 ns) ----
vctl_op1_0900_rtl_hold ctl_op1_0900_rtl_hold 0 pwl(0.0000e+00 {VDD} 2.0000e-09 {VDD} 2.1000e-09 0)
vrs_op1_0900_rtl_hold rwls_op1_0900_rtl_hold 0 pwl(0.0000e+00 {VDD} 2.0000e-09 {VDD} 2.1000e-09 0 1.2000e-08 0 1.2100e-08 {VDD})
ven_op1_0900_rtl_hold en_op1_0900_rtl_hold 0 pwl(0.0000e+00 0 1.1000e-08 0 1.1100e-08 {VDD} 3.4000e-08 {VDD} 3.4100e-08 0)
venb_op1_0900_rtl_hold enb_op1_0900_rtl_hold 0 pwl(0.0000e+00 {VDD} 1.1000e-08 {VDD} 1.1100e-08 0 3.4000e-08 0 3.4100e-08 {VDD})
vww_op1_0900_rtl_hold wwl_op1_0900_rtl_hold 0 pwl(0.0000e+00 0 1.2000e-08 0 1.2100e-08 {VDD} 3.2000e-08 {VDD} 3.2100e-08 0)
vwc_op1_0900_rtl_hold wbc_op1_0900_rtl_hold 0 pwl(0.0000e+00 0 1.2000e-08 0 1.2100e-08 {VDD} 3.4000e-08 {VDD} 3.4100e-08 0)
swb_op1_0900_rtl_hold ref_op1_0900_rtl_hold wbl_op1_0900_rtl_hold wbc_op1_0900_rtl_hold 0 swwbl
cwbl_op1_0900_rtl_hold wbl_op1_0900_rtl_hold 0 {C_WBL}
spa_op1_0900_rtl_hold prea rbl_op1_0900_rtl_hold ctl_op1_0900_rtl_hold 0 swpre
spr_op1_0900_rtl_hold pref ref_op1_0900_rtl_hold ctl_op1_0900_rtl_hold 0 swpre
crbl_op1_0900_rtl_hold rbl_op1_0900_rtl_hold 0 {C_RBL}
cref_op1_0900_rtl_hold ref_op1_0900_rtl_hold 0 {C_RBL}   $ ASSUMPTION: ideal matched dummy load
XMWR_op1_0900_rtl_hold_0 sn_op1_0900_rtl_hold_0 wwl_op1_0900_rtl_hold wbl_op1_0900_rtl_hold 0 sky130_fd_pr__nfet_01v8 L=0.15 W=0.42 nf=1 ad=0.1218 as=0.1218 pd=1.42 ps=1.42 nrd=0.69047619047619  nrs=0.69047619047619 sa=0 sb=0 sd=0 mult=1 m=1
XMRD_op1_0900_rtl_hold_0 rbl_op1_0900_rtl_hold sn_op1_0900_rtl_hold_0 rwls_op1_0900_rtl_hold 0 sky130_fd_pr__nfet_01v8 L=0.15 W=0.42 nf=1 ad=0.1218 as=0.1218 pd=1.42 ps=1.42 nrd=0.69047619047619  nrs=0.69047619047619 sa=0 sb=0 sd=0 mult=1 m=1
csn_op1_0900_rtl_hold_0 sn_op1_0900_rtl_hold_0 0 {C_SN}
XMWR_op1_0900_rtl_hold_1 sn_op1_0900_rtl_hold_1 wwl_des wbl_op1_0900_rtl_hold 0 sky130_fd_pr__nfet_01v8 L=0.15 W=0.42 nf=1 ad=0.1218 as=0.1218 pd=1.42 ps=1.42 nrd=0.69047619047619  nrs=0.69047619047619 sa=0 sb=0 sd=0 mult=1 m=1
XMRD_op1_0900_rtl_hold_1 rbl_op1_0900_rtl_hold sn_op1_0900_rtl_hold_1 rwl_des 0 sky130_fd_pr__nfet_01v8 L=0.15 W=0.42 nf=1 ad=0.1218 as=0.1218 pd=1.42 ps=1.42 nrd=0.69047619047619  nrs=0.69047619047619 sa=0 sb=0 sd=0 mult=1 m=1
csn_op1_0900_rtl_hold_1 sn_op1_0900_rtl_hold_1 0 {C_SN}
XMWR_op1_0900_rtl_hold_2 sn_op1_0900_rtl_hold_2 wwl_des wbl_op1_0900_rtl_hold 0 sky130_fd_pr__nfet_01v8 L=0.15 W=0.42 nf=1 ad=0.1218 as=0.1218 pd=1.42 ps=1.42 nrd=0.69047619047619  nrs=0.69047619047619 sa=0 sb=0 sd=0 mult=1 m=1
XMRD_op1_0900_rtl_hold_2 rbl_op1_0900_rtl_hold sn_op1_0900_rtl_hold_2 rwl_des 0 sky130_fd_pr__nfet_01v8 L=0.15 W=0.42 nf=1 ad=0.1218 as=0.1218 pd=1.42 ps=1.42 nrd=0.69047619047619  nrs=0.69047619047619 sa=0 sb=0 sd=0 mult=1 m=1
csn_op1_0900_rtl_hold_2 sn_op1_0900_rtl_hold_2 0 {C_SN}
XMWR_op1_0900_rtl_hold_3 sn_op1_0900_rtl_hold_3 wwl_des wbl_op1_0900_rtl_hold 0 sky130_fd_pr__nfet_01v8 L=0.15 W=0.42 nf=1 ad=0.1218 as=0.1218 pd=1.42 ps=1.42 nrd=0.69047619047619  nrs=0.69047619047619 sa=0 sb=0 sd=0 mult=1 m=1
XMRD_op1_0900_rtl_hold_3 rbl_op1_0900_rtl_hold sn_op1_0900_rtl_hold_3 rwl_des 0 sky130_fd_pr__nfet_01v8 L=0.15 W=0.42 nf=1 ad=0.1218 as=0.1218 pd=1.42 ps=1.42 nrd=0.69047619047619  nrs=0.69047619047619 sa=0 sb=0 sd=0 mult=1 m=1
csn_op1_0900_rtl_hold_3 sn_op1_0900_rtl_hold_3 0 {C_SN}
XMN1_op1_0900_rtl_hold rbl_op1_0900_rtl_hold ref_op1_0900_rtl_hold vn_op1_0900_rtl_hold 0 sky130_fd_pr__nfet_01v8 L=0.15 W=1 nf=1 ad=0.29 as=0.29 pd=2.58 ps=2.58 mult=1 m=1
XMN2_op1_0900_rtl_hold ref_op1_0900_rtl_hold rbl_op1_0900_rtl_hold vn_op1_0900_rtl_hold 0 sky130_fd_pr__nfet_01v8 L=0.15 W=1 nf=1 ad=0.29 as=0.29 pd=2.58 ps=2.58 mult=1 m=1
XMP1_op1_0900_rtl_hold rbl_op1_0900_rtl_hold ref_op1_0900_rtl_hold vp_op1_0900_rtl_hold vdd sky130_fd_pr__pfet_01v8 L=0.15 W=2 nf=1 ad=0.58 as=0.58 pd=4.58 ps=4.58 mult=1 m=1
XMP2_op1_0900_rtl_hold ref_op1_0900_rtl_hold rbl_op1_0900_rtl_hold vp_op1_0900_rtl_hold vdd sky130_fd_pr__pfet_01v8 L=0.15 W=2 nf=1 ad=0.58 as=0.58 pd=4.58 ps=4.58 mult=1 m=1
XMNF_op1_0900_rtl_hold vn_op1_0900_rtl_hold en_op1_0900_rtl_hold 0 0 sky130_fd_pr__nfet_01v8 L=0.15 W=2 nf=1 ad=0.58 as=0.58 pd=4.58 ps=4.58 mult=1 m=1
XMPH_op1_0900_rtl_hold vp_op1_0900_rtl_hold enb_op1_0900_rtl_hold vdd vdd sky130_fd_pr__pfet_01v8 L=0.15 W=4 nf=1 ad=1.16 as=1.16 pd=8.58 ps=8.58 mult=1 m=1
bd_op1_0900_rtl_hold d_op1_0900_rtl_hold 0 v=v(rbl_op1_0900_rtl_hold)-v(ref_op1_0900_rtl_hold)

* ---- instance 5: op1_1000_rtl_hold (variant rtl_hold; probe dec 11.9 ns, release 34 ns, meas 36 ns) ----
vctl_op1_1000_rtl_hold ctl_op1_1000_rtl_hold 0 pwl(0.0000e+00 {VDD} 2.0000e-09 {VDD} 2.1000e-09 0)
vrs_op1_1000_rtl_hold rwls_op1_1000_rtl_hold 0 pwl(0.0000e+00 {VDD} 2.0000e-09 {VDD} 2.1000e-09 0 1.2000e-08 0 1.2100e-08 {VDD})
ven_op1_1000_rtl_hold en_op1_1000_rtl_hold 0 pwl(0.0000e+00 0 1.1000e-08 0 1.1100e-08 {VDD} 3.4000e-08 {VDD} 3.4100e-08 0)
venb_op1_1000_rtl_hold enb_op1_1000_rtl_hold 0 pwl(0.0000e+00 {VDD} 1.1000e-08 {VDD} 1.1100e-08 0 3.4000e-08 0 3.4100e-08 {VDD})
vww_op1_1000_rtl_hold wwl_op1_1000_rtl_hold 0 pwl(0.0000e+00 0 1.2000e-08 0 1.2100e-08 {VDD} 3.2000e-08 {VDD} 3.2100e-08 0)
vwc_op1_1000_rtl_hold wbc_op1_1000_rtl_hold 0 pwl(0.0000e+00 0 1.2000e-08 0 1.2100e-08 {VDD} 3.4000e-08 {VDD} 3.4100e-08 0)
swb_op1_1000_rtl_hold ref_op1_1000_rtl_hold wbl_op1_1000_rtl_hold wbc_op1_1000_rtl_hold 0 swwbl
cwbl_op1_1000_rtl_hold wbl_op1_1000_rtl_hold 0 {C_WBL}
spa_op1_1000_rtl_hold prea rbl_op1_1000_rtl_hold ctl_op1_1000_rtl_hold 0 swpre
spr_op1_1000_rtl_hold pref ref_op1_1000_rtl_hold ctl_op1_1000_rtl_hold 0 swpre
crbl_op1_1000_rtl_hold rbl_op1_1000_rtl_hold 0 {C_RBL}
cref_op1_1000_rtl_hold ref_op1_1000_rtl_hold 0 {C_RBL}   $ ASSUMPTION: ideal matched dummy load
XMWR_op1_1000_rtl_hold_0 sn_op1_1000_rtl_hold_0 wwl_op1_1000_rtl_hold wbl_op1_1000_rtl_hold 0 sky130_fd_pr__nfet_01v8 L=0.15 W=0.42 nf=1 ad=0.1218 as=0.1218 pd=1.42 ps=1.42 nrd=0.69047619047619  nrs=0.69047619047619 sa=0 sb=0 sd=0 mult=1 m=1
XMRD_op1_1000_rtl_hold_0 rbl_op1_1000_rtl_hold sn_op1_1000_rtl_hold_0 rwls_op1_1000_rtl_hold 0 sky130_fd_pr__nfet_01v8 L=0.15 W=0.42 nf=1 ad=0.1218 as=0.1218 pd=1.42 ps=1.42 nrd=0.69047619047619  nrs=0.69047619047619 sa=0 sb=0 sd=0 mult=1 m=1
csn_op1_1000_rtl_hold_0 sn_op1_1000_rtl_hold_0 0 {C_SN}
XMWR_op1_1000_rtl_hold_1 sn_op1_1000_rtl_hold_1 wwl_des wbl_op1_1000_rtl_hold 0 sky130_fd_pr__nfet_01v8 L=0.15 W=0.42 nf=1 ad=0.1218 as=0.1218 pd=1.42 ps=1.42 nrd=0.69047619047619  nrs=0.69047619047619 sa=0 sb=0 sd=0 mult=1 m=1
XMRD_op1_1000_rtl_hold_1 rbl_op1_1000_rtl_hold sn_op1_1000_rtl_hold_1 rwl_des 0 sky130_fd_pr__nfet_01v8 L=0.15 W=0.42 nf=1 ad=0.1218 as=0.1218 pd=1.42 ps=1.42 nrd=0.69047619047619  nrs=0.69047619047619 sa=0 sb=0 sd=0 mult=1 m=1
csn_op1_1000_rtl_hold_1 sn_op1_1000_rtl_hold_1 0 {C_SN}
XMWR_op1_1000_rtl_hold_2 sn_op1_1000_rtl_hold_2 wwl_des wbl_op1_1000_rtl_hold 0 sky130_fd_pr__nfet_01v8 L=0.15 W=0.42 nf=1 ad=0.1218 as=0.1218 pd=1.42 ps=1.42 nrd=0.69047619047619  nrs=0.69047619047619 sa=0 sb=0 sd=0 mult=1 m=1
XMRD_op1_1000_rtl_hold_2 rbl_op1_1000_rtl_hold sn_op1_1000_rtl_hold_2 rwl_des 0 sky130_fd_pr__nfet_01v8 L=0.15 W=0.42 nf=1 ad=0.1218 as=0.1218 pd=1.42 ps=1.42 nrd=0.69047619047619  nrs=0.69047619047619 sa=0 sb=0 sd=0 mult=1 m=1
csn_op1_1000_rtl_hold_2 sn_op1_1000_rtl_hold_2 0 {C_SN}
XMWR_op1_1000_rtl_hold_3 sn_op1_1000_rtl_hold_3 wwl_des wbl_op1_1000_rtl_hold 0 sky130_fd_pr__nfet_01v8 L=0.15 W=0.42 nf=1 ad=0.1218 as=0.1218 pd=1.42 ps=1.42 nrd=0.69047619047619  nrs=0.69047619047619 sa=0 sb=0 sd=0 mult=1 m=1
XMRD_op1_1000_rtl_hold_3 rbl_op1_1000_rtl_hold sn_op1_1000_rtl_hold_3 rwl_des 0 sky130_fd_pr__nfet_01v8 L=0.15 W=0.42 nf=1 ad=0.1218 as=0.1218 pd=1.42 ps=1.42 nrd=0.69047619047619  nrs=0.69047619047619 sa=0 sb=0 sd=0 mult=1 m=1
csn_op1_1000_rtl_hold_3 sn_op1_1000_rtl_hold_3 0 {C_SN}
XMN1_op1_1000_rtl_hold rbl_op1_1000_rtl_hold ref_op1_1000_rtl_hold vn_op1_1000_rtl_hold 0 sky130_fd_pr__nfet_01v8 L=0.15 W=1 nf=1 ad=0.29 as=0.29 pd=2.58 ps=2.58 mult=1 m=1
XMN2_op1_1000_rtl_hold ref_op1_1000_rtl_hold rbl_op1_1000_rtl_hold vn_op1_1000_rtl_hold 0 sky130_fd_pr__nfet_01v8 L=0.15 W=1 nf=1 ad=0.29 as=0.29 pd=2.58 ps=2.58 mult=1 m=1
XMP1_op1_1000_rtl_hold rbl_op1_1000_rtl_hold ref_op1_1000_rtl_hold vp_op1_1000_rtl_hold vdd sky130_fd_pr__pfet_01v8 L=0.15 W=2 nf=1 ad=0.58 as=0.58 pd=4.58 ps=4.58 mult=1 m=1
XMP2_op1_1000_rtl_hold ref_op1_1000_rtl_hold rbl_op1_1000_rtl_hold vp_op1_1000_rtl_hold vdd sky130_fd_pr__pfet_01v8 L=0.15 W=2 nf=1 ad=0.58 as=0.58 pd=4.58 ps=4.58 mult=1 m=1
XMNF_op1_1000_rtl_hold vn_op1_1000_rtl_hold en_op1_1000_rtl_hold 0 0 sky130_fd_pr__nfet_01v8 L=0.15 W=2 nf=1 ad=0.58 as=0.58 pd=4.58 ps=4.58 mult=1 m=1
XMPH_op1_1000_rtl_hold vp_op1_1000_rtl_hold enb_op1_1000_rtl_hold vdd vdd sky130_fd_pr__pfet_01v8 L=0.15 W=4 nf=1 ad=1.16 as=1.16 pd=8.58 ps=8.58 mult=1 m=1
bd_op1_1000_rtl_hold d_op1_1000_rtl_hold 0 v=v(rbl_op1_1000_rtl_hold)-v(ref_op1_1000_rtl_hold)

* ---- instance 6: op0_n100_rtl_hold (variant rtl_hold; probe dec 11.9 ns, release 34 ns, meas 36 ns) ----
vctl_op0_n100_rtl_hold ctl_op0_n100_rtl_hold 0 pwl(0.0000e+00 {VDD} 2.0000e-09 {VDD} 2.1000e-09 0)
vrs_op0_n100_rtl_hold rwls_op0_n100_rtl_hold 0 pwl(0.0000e+00 {VDD} 2.0000e-09 {VDD} 2.1000e-09 0 1.2000e-08 0 1.2100e-08 {VDD})
ven_op0_n100_rtl_hold en_op0_n100_rtl_hold 0 pwl(0.0000e+00 0 1.1000e-08 0 1.1100e-08 {VDD} 3.4000e-08 {VDD} 3.4100e-08 0)
venb_op0_n100_rtl_hold enb_op0_n100_rtl_hold 0 pwl(0.0000e+00 {VDD} 1.1000e-08 {VDD} 1.1100e-08 0 3.4000e-08 0 3.4100e-08 {VDD})
vww_op0_n100_rtl_hold wwl_op0_n100_rtl_hold 0 pwl(0.0000e+00 0 1.2000e-08 0 1.2100e-08 {VDD} 3.2000e-08 {VDD} 3.2100e-08 0)
vwc_op0_n100_rtl_hold wbc_op0_n100_rtl_hold 0 pwl(0.0000e+00 0 1.2000e-08 0 1.2100e-08 {VDD} 3.4000e-08 {VDD} 3.4100e-08 0)
swb_op0_n100_rtl_hold ref_op0_n100_rtl_hold wbl_op0_n100_rtl_hold wbc_op0_n100_rtl_hold 0 swwbl
cwbl_op0_n100_rtl_hold wbl_op0_n100_rtl_hold 0 {C_WBL}
spa_op0_n100_rtl_hold prea rbl_op0_n100_rtl_hold ctl_op0_n100_rtl_hold 0 swpre
spr_op0_n100_rtl_hold pref ref_op0_n100_rtl_hold ctl_op0_n100_rtl_hold 0 swpre
crbl_op0_n100_rtl_hold rbl_op0_n100_rtl_hold 0 {C_RBL}
cref_op0_n100_rtl_hold ref_op0_n100_rtl_hold 0 {C_RBL}   $ ASSUMPTION: ideal matched dummy load
XMWR_op0_n100_rtl_hold_0 sn_op0_n100_rtl_hold_0 wwl_op0_n100_rtl_hold wbl_op0_n100_rtl_hold 0 sky130_fd_pr__nfet_01v8 L=0.15 W=0.42 nf=1 ad=0.1218 as=0.1218 pd=1.42 ps=1.42 nrd=0.69047619047619  nrs=0.69047619047619 sa=0 sb=0 sd=0 mult=1 m=1
XMRD_op0_n100_rtl_hold_0 rbl_op0_n100_rtl_hold sn_op0_n100_rtl_hold_0 rwls_op0_n100_rtl_hold 0 sky130_fd_pr__nfet_01v8 L=0.15 W=0.42 nf=1 ad=0.1218 as=0.1218 pd=1.42 ps=1.42 nrd=0.69047619047619  nrs=0.69047619047619 sa=0 sb=0 sd=0 mult=1 m=1
csn_op0_n100_rtl_hold_0 sn_op0_n100_rtl_hold_0 0 {C_SN}
XMWR_op0_n100_rtl_hold_1 sn_op0_n100_rtl_hold_1 wwl_des wbl_op0_n100_rtl_hold 0 sky130_fd_pr__nfet_01v8 L=0.15 W=0.42 nf=1 ad=0.1218 as=0.1218 pd=1.42 ps=1.42 nrd=0.69047619047619  nrs=0.69047619047619 sa=0 sb=0 sd=0 mult=1 m=1
XMRD_op0_n100_rtl_hold_1 rbl_op0_n100_rtl_hold sn_op0_n100_rtl_hold_1 rwl_des 0 sky130_fd_pr__nfet_01v8 L=0.15 W=0.42 nf=1 ad=0.1218 as=0.1218 pd=1.42 ps=1.42 nrd=0.69047619047619  nrs=0.69047619047619 sa=0 sb=0 sd=0 mult=1 m=1
csn_op0_n100_rtl_hold_1 sn_op0_n100_rtl_hold_1 0 {C_SN}
XMWR_op0_n100_rtl_hold_2 sn_op0_n100_rtl_hold_2 wwl_des wbl_op0_n100_rtl_hold 0 sky130_fd_pr__nfet_01v8 L=0.15 W=0.42 nf=1 ad=0.1218 as=0.1218 pd=1.42 ps=1.42 nrd=0.69047619047619  nrs=0.69047619047619 sa=0 sb=0 sd=0 mult=1 m=1
XMRD_op0_n100_rtl_hold_2 rbl_op0_n100_rtl_hold sn_op0_n100_rtl_hold_2 rwl_des 0 sky130_fd_pr__nfet_01v8 L=0.15 W=0.42 nf=1 ad=0.1218 as=0.1218 pd=1.42 ps=1.42 nrd=0.69047619047619  nrs=0.69047619047619 sa=0 sb=0 sd=0 mult=1 m=1
csn_op0_n100_rtl_hold_2 sn_op0_n100_rtl_hold_2 0 {C_SN}
XMWR_op0_n100_rtl_hold_3 sn_op0_n100_rtl_hold_3 wwl_des wbl_op0_n100_rtl_hold 0 sky130_fd_pr__nfet_01v8 L=0.15 W=0.42 nf=1 ad=0.1218 as=0.1218 pd=1.42 ps=1.42 nrd=0.69047619047619  nrs=0.69047619047619 sa=0 sb=0 sd=0 mult=1 m=1
XMRD_op0_n100_rtl_hold_3 rbl_op0_n100_rtl_hold sn_op0_n100_rtl_hold_3 rwl_des 0 sky130_fd_pr__nfet_01v8 L=0.15 W=0.42 nf=1 ad=0.1218 as=0.1218 pd=1.42 ps=1.42 nrd=0.69047619047619  nrs=0.69047619047619 sa=0 sb=0 sd=0 mult=1 m=1
csn_op0_n100_rtl_hold_3 sn_op0_n100_rtl_hold_3 0 {C_SN}
XMN1_op0_n100_rtl_hold rbl_op0_n100_rtl_hold ref_op0_n100_rtl_hold vn_op0_n100_rtl_hold 0 sky130_fd_pr__nfet_01v8 L=0.15 W=1 nf=1 ad=0.29 as=0.29 pd=2.58 ps=2.58 mult=1 m=1
XMN2_op0_n100_rtl_hold ref_op0_n100_rtl_hold rbl_op0_n100_rtl_hold vn_op0_n100_rtl_hold 0 sky130_fd_pr__nfet_01v8 L=0.15 W=1 nf=1 ad=0.29 as=0.29 pd=2.58 ps=2.58 mult=1 m=1
XMP1_op0_n100_rtl_hold rbl_op0_n100_rtl_hold ref_op0_n100_rtl_hold vp_op0_n100_rtl_hold vdd sky130_fd_pr__pfet_01v8 L=0.15 W=2 nf=1 ad=0.58 as=0.58 pd=4.58 ps=4.58 mult=1 m=1
XMP2_op0_n100_rtl_hold ref_op0_n100_rtl_hold rbl_op0_n100_rtl_hold vp_op0_n100_rtl_hold vdd sky130_fd_pr__pfet_01v8 L=0.15 W=2 nf=1 ad=0.58 as=0.58 pd=4.58 ps=4.58 mult=1 m=1
XMNF_op0_n100_rtl_hold vn_op0_n100_rtl_hold en_op0_n100_rtl_hold 0 0 sky130_fd_pr__nfet_01v8 L=0.15 W=2 nf=1 ad=0.58 as=0.58 pd=4.58 ps=4.58 mult=1 m=1
XMPH_op0_n100_rtl_hold vp_op0_n100_rtl_hold enb_op0_n100_rtl_hold vdd vdd sky130_fd_pr__pfet_01v8 L=0.15 W=4 nf=1 ad=1.16 as=1.16 pd=8.58 ps=8.58 mult=1 m=1
bd_op0_n100_rtl_hold d_op0_n100_rtl_hold 0 v=v(rbl_op0_n100_rtl_hold)-v(ref_op0_n100_rtl_hold)

* ---- instance 7: op0_0000_rtl_hold (variant rtl_hold; probe dec 11.9 ns, release 34 ns, meas 36 ns) ----
vctl_op0_0000_rtl_hold ctl_op0_0000_rtl_hold 0 pwl(0.0000e+00 {VDD} 2.0000e-09 {VDD} 2.1000e-09 0)
vrs_op0_0000_rtl_hold rwls_op0_0000_rtl_hold 0 pwl(0.0000e+00 {VDD} 2.0000e-09 {VDD} 2.1000e-09 0 1.2000e-08 0 1.2100e-08 {VDD})
ven_op0_0000_rtl_hold en_op0_0000_rtl_hold 0 pwl(0.0000e+00 0 1.1000e-08 0 1.1100e-08 {VDD} 3.4000e-08 {VDD} 3.4100e-08 0)
venb_op0_0000_rtl_hold enb_op0_0000_rtl_hold 0 pwl(0.0000e+00 {VDD} 1.1000e-08 {VDD} 1.1100e-08 0 3.4000e-08 0 3.4100e-08 {VDD})
vww_op0_0000_rtl_hold wwl_op0_0000_rtl_hold 0 pwl(0.0000e+00 0 1.2000e-08 0 1.2100e-08 {VDD} 3.2000e-08 {VDD} 3.2100e-08 0)
vwc_op0_0000_rtl_hold wbc_op0_0000_rtl_hold 0 pwl(0.0000e+00 0 1.2000e-08 0 1.2100e-08 {VDD} 3.4000e-08 {VDD} 3.4100e-08 0)
swb_op0_0000_rtl_hold ref_op0_0000_rtl_hold wbl_op0_0000_rtl_hold wbc_op0_0000_rtl_hold 0 swwbl
cwbl_op0_0000_rtl_hold wbl_op0_0000_rtl_hold 0 {C_WBL}
spa_op0_0000_rtl_hold prea rbl_op0_0000_rtl_hold ctl_op0_0000_rtl_hold 0 swpre
spr_op0_0000_rtl_hold pref ref_op0_0000_rtl_hold ctl_op0_0000_rtl_hold 0 swpre
crbl_op0_0000_rtl_hold rbl_op0_0000_rtl_hold 0 {C_RBL}
cref_op0_0000_rtl_hold ref_op0_0000_rtl_hold 0 {C_RBL}   $ ASSUMPTION: ideal matched dummy load
XMWR_op0_0000_rtl_hold_0 sn_op0_0000_rtl_hold_0 wwl_op0_0000_rtl_hold wbl_op0_0000_rtl_hold 0 sky130_fd_pr__nfet_01v8 L=0.15 W=0.42 nf=1 ad=0.1218 as=0.1218 pd=1.42 ps=1.42 nrd=0.69047619047619  nrs=0.69047619047619 sa=0 sb=0 sd=0 mult=1 m=1
XMRD_op0_0000_rtl_hold_0 rbl_op0_0000_rtl_hold sn_op0_0000_rtl_hold_0 rwls_op0_0000_rtl_hold 0 sky130_fd_pr__nfet_01v8 L=0.15 W=0.42 nf=1 ad=0.1218 as=0.1218 pd=1.42 ps=1.42 nrd=0.69047619047619  nrs=0.69047619047619 sa=0 sb=0 sd=0 mult=1 m=1
csn_op0_0000_rtl_hold_0 sn_op0_0000_rtl_hold_0 0 {C_SN}
XMWR_op0_0000_rtl_hold_1 sn_op0_0000_rtl_hold_1 wwl_des wbl_op0_0000_rtl_hold 0 sky130_fd_pr__nfet_01v8 L=0.15 W=0.42 nf=1 ad=0.1218 as=0.1218 pd=1.42 ps=1.42 nrd=0.69047619047619  nrs=0.69047619047619 sa=0 sb=0 sd=0 mult=1 m=1
XMRD_op0_0000_rtl_hold_1 rbl_op0_0000_rtl_hold sn_op0_0000_rtl_hold_1 rwl_des 0 sky130_fd_pr__nfet_01v8 L=0.15 W=0.42 nf=1 ad=0.1218 as=0.1218 pd=1.42 ps=1.42 nrd=0.69047619047619  nrs=0.69047619047619 sa=0 sb=0 sd=0 mult=1 m=1
csn_op0_0000_rtl_hold_1 sn_op0_0000_rtl_hold_1 0 {C_SN}
XMWR_op0_0000_rtl_hold_2 sn_op0_0000_rtl_hold_2 wwl_des wbl_op0_0000_rtl_hold 0 sky130_fd_pr__nfet_01v8 L=0.15 W=0.42 nf=1 ad=0.1218 as=0.1218 pd=1.42 ps=1.42 nrd=0.69047619047619  nrs=0.69047619047619 sa=0 sb=0 sd=0 mult=1 m=1
XMRD_op0_0000_rtl_hold_2 rbl_op0_0000_rtl_hold sn_op0_0000_rtl_hold_2 rwl_des 0 sky130_fd_pr__nfet_01v8 L=0.15 W=0.42 nf=1 ad=0.1218 as=0.1218 pd=1.42 ps=1.42 nrd=0.69047619047619  nrs=0.69047619047619 sa=0 sb=0 sd=0 mult=1 m=1
csn_op0_0000_rtl_hold_2 sn_op0_0000_rtl_hold_2 0 {C_SN}
XMWR_op0_0000_rtl_hold_3 sn_op0_0000_rtl_hold_3 wwl_des wbl_op0_0000_rtl_hold 0 sky130_fd_pr__nfet_01v8 L=0.15 W=0.42 nf=1 ad=0.1218 as=0.1218 pd=1.42 ps=1.42 nrd=0.69047619047619  nrs=0.69047619047619 sa=0 sb=0 sd=0 mult=1 m=1
XMRD_op0_0000_rtl_hold_3 rbl_op0_0000_rtl_hold sn_op0_0000_rtl_hold_3 rwl_des 0 sky130_fd_pr__nfet_01v8 L=0.15 W=0.42 nf=1 ad=0.1218 as=0.1218 pd=1.42 ps=1.42 nrd=0.69047619047619  nrs=0.69047619047619 sa=0 sb=0 sd=0 mult=1 m=1
csn_op0_0000_rtl_hold_3 sn_op0_0000_rtl_hold_3 0 {C_SN}
XMN1_op0_0000_rtl_hold rbl_op0_0000_rtl_hold ref_op0_0000_rtl_hold vn_op0_0000_rtl_hold 0 sky130_fd_pr__nfet_01v8 L=0.15 W=1 nf=1 ad=0.29 as=0.29 pd=2.58 ps=2.58 mult=1 m=1
XMN2_op0_0000_rtl_hold ref_op0_0000_rtl_hold rbl_op0_0000_rtl_hold vn_op0_0000_rtl_hold 0 sky130_fd_pr__nfet_01v8 L=0.15 W=1 nf=1 ad=0.29 as=0.29 pd=2.58 ps=2.58 mult=1 m=1
XMP1_op0_0000_rtl_hold rbl_op0_0000_rtl_hold ref_op0_0000_rtl_hold vp_op0_0000_rtl_hold vdd sky130_fd_pr__pfet_01v8 L=0.15 W=2 nf=1 ad=0.58 as=0.58 pd=4.58 ps=4.58 mult=1 m=1
XMP2_op0_0000_rtl_hold ref_op0_0000_rtl_hold rbl_op0_0000_rtl_hold vp_op0_0000_rtl_hold vdd sky130_fd_pr__pfet_01v8 L=0.15 W=2 nf=1 ad=0.58 as=0.58 pd=4.58 ps=4.58 mult=1 m=1
XMNF_op0_0000_rtl_hold vn_op0_0000_rtl_hold en_op0_0000_rtl_hold 0 0 sky130_fd_pr__nfet_01v8 L=0.15 W=2 nf=1 ad=0.58 as=0.58 pd=4.58 ps=4.58 mult=1 m=1
XMPH_op0_0000_rtl_hold vp_op0_0000_rtl_hold enb_op0_0000_rtl_hold vdd vdd sky130_fd_pr__pfet_01v8 L=0.15 W=4 nf=1 ad=1.16 as=1.16 pd=8.58 ps=8.58 mult=1 m=1
bd_op0_0000_rtl_hold d_op0_0000_rtl_hold 0 v=v(rbl_op0_0000_rtl_hold)-v(ref_op0_0000_rtl_hold)

* ---- instance 8: op1_0900_rwl_late_hold (variant rwl_late_hold; probe dec 11.9 ns, release 34 ns, meas 36 ns) ----
vctl_op1_0900_rwl_late_hold ctl_op1_0900_rwl_late_hold 0 pwl(0.0000e+00 {VDD} 2.0000e-09 {VDD} 2.1000e-09 0)
vrs_op1_0900_rwl_late_hold rwls_op1_0900_rwl_late_hold 0 pwl(0.0000e+00 {VDD} 2.0000e-09 {VDD} 2.1000e-09 0 3.4000e-08 0 3.4100e-08 {VDD})
ven_op1_0900_rwl_late_hold en_op1_0900_rwl_late_hold 0 pwl(0.0000e+00 0 1.1000e-08 0 1.1100e-08 {VDD} 3.4000e-08 {VDD} 3.4100e-08 0)
venb_op1_0900_rwl_late_hold enb_op1_0900_rwl_late_hold 0 pwl(0.0000e+00 {VDD} 1.1000e-08 {VDD} 1.1100e-08 0 3.4000e-08 0 3.4100e-08 {VDD})
vww_op1_0900_rwl_late_hold wwl_op1_0900_rwl_late_hold 0 pwl(0.0000e+00 0 1.2000e-08 0 1.2100e-08 {VDD} 3.2000e-08 {VDD} 3.2100e-08 0)
vwc_op1_0900_rwl_late_hold wbc_op1_0900_rwl_late_hold 0 pwl(0.0000e+00 0 1.2000e-08 0 1.2100e-08 {VDD} 3.4000e-08 {VDD} 3.4100e-08 0)
swb_op1_0900_rwl_late_hold ref_op1_0900_rwl_late_hold wbl_op1_0900_rwl_late_hold wbc_op1_0900_rwl_late_hold 0 swwbl
cwbl_op1_0900_rwl_late_hold wbl_op1_0900_rwl_late_hold 0 {C_WBL}
spa_op1_0900_rwl_late_hold prea rbl_op1_0900_rwl_late_hold ctl_op1_0900_rwl_late_hold 0 swpre
spr_op1_0900_rwl_late_hold pref ref_op1_0900_rwl_late_hold ctl_op1_0900_rwl_late_hold 0 swpre
crbl_op1_0900_rwl_late_hold rbl_op1_0900_rwl_late_hold 0 {C_RBL}
cref_op1_0900_rwl_late_hold ref_op1_0900_rwl_late_hold 0 {C_RBL}   $ ASSUMPTION: ideal matched dummy load
XMWR_op1_0900_rwl_late_hold_0 sn_op1_0900_rwl_late_hold_0 wwl_op1_0900_rwl_late_hold wbl_op1_0900_rwl_late_hold 0 sky130_fd_pr__nfet_01v8 L=0.15 W=0.42 nf=1 ad=0.1218 as=0.1218 pd=1.42 ps=1.42 nrd=0.69047619047619  nrs=0.69047619047619 sa=0 sb=0 sd=0 mult=1 m=1
XMRD_op1_0900_rwl_late_hold_0 rbl_op1_0900_rwl_late_hold sn_op1_0900_rwl_late_hold_0 rwls_op1_0900_rwl_late_hold 0 sky130_fd_pr__nfet_01v8 L=0.15 W=0.42 nf=1 ad=0.1218 as=0.1218 pd=1.42 ps=1.42 nrd=0.69047619047619  nrs=0.69047619047619 sa=0 sb=0 sd=0 mult=1 m=1
csn_op1_0900_rwl_late_hold_0 sn_op1_0900_rwl_late_hold_0 0 {C_SN}
XMWR_op1_0900_rwl_late_hold_1 sn_op1_0900_rwl_late_hold_1 wwl_des wbl_op1_0900_rwl_late_hold 0 sky130_fd_pr__nfet_01v8 L=0.15 W=0.42 nf=1 ad=0.1218 as=0.1218 pd=1.42 ps=1.42 nrd=0.69047619047619  nrs=0.69047619047619 sa=0 sb=0 sd=0 mult=1 m=1
XMRD_op1_0900_rwl_late_hold_1 rbl_op1_0900_rwl_late_hold sn_op1_0900_rwl_late_hold_1 rwl_des 0 sky130_fd_pr__nfet_01v8 L=0.15 W=0.42 nf=1 ad=0.1218 as=0.1218 pd=1.42 ps=1.42 nrd=0.69047619047619  nrs=0.69047619047619 sa=0 sb=0 sd=0 mult=1 m=1
csn_op1_0900_rwl_late_hold_1 sn_op1_0900_rwl_late_hold_1 0 {C_SN}
XMWR_op1_0900_rwl_late_hold_2 sn_op1_0900_rwl_late_hold_2 wwl_des wbl_op1_0900_rwl_late_hold 0 sky130_fd_pr__nfet_01v8 L=0.15 W=0.42 nf=1 ad=0.1218 as=0.1218 pd=1.42 ps=1.42 nrd=0.69047619047619  nrs=0.69047619047619 sa=0 sb=0 sd=0 mult=1 m=1
XMRD_op1_0900_rwl_late_hold_2 rbl_op1_0900_rwl_late_hold sn_op1_0900_rwl_late_hold_2 rwl_des 0 sky130_fd_pr__nfet_01v8 L=0.15 W=0.42 nf=1 ad=0.1218 as=0.1218 pd=1.42 ps=1.42 nrd=0.69047619047619  nrs=0.69047619047619 sa=0 sb=0 sd=0 mult=1 m=1
csn_op1_0900_rwl_late_hold_2 sn_op1_0900_rwl_late_hold_2 0 {C_SN}
XMWR_op1_0900_rwl_late_hold_3 sn_op1_0900_rwl_late_hold_3 wwl_des wbl_op1_0900_rwl_late_hold 0 sky130_fd_pr__nfet_01v8 L=0.15 W=0.42 nf=1 ad=0.1218 as=0.1218 pd=1.42 ps=1.42 nrd=0.69047619047619  nrs=0.69047619047619 sa=0 sb=0 sd=0 mult=1 m=1
XMRD_op1_0900_rwl_late_hold_3 rbl_op1_0900_rwl_late_hold sn_op1_0900_rwl_late_hold_3 rwl_des 0 sky130_fd_pr__nfet_01v8 L=0.15 W=0.42 nf=1 ad=0.1218 as=0.1218 pd=1.42 ps=1.42 nrd=0.69047619047619  nrs=0.69047619047619 sa=0 sb=0 sd=0 mult=1 m=1
csn_op1_0900_rwl_late_hold_3 sn_op1_0900_rwl_late_hold_3 0 {C_SN}
XMN1_op1_0900_rwl_late_hold rbl_op1_0900_rwl_late_hold ref_op1_0900_rwl_late_hold vn_op1_0900_rwl_late_hold 0 sky130_fd_pr__nfet_01v8 L=0.15 W=1 nf=1 ad=0.29 as=0.29 pd=2.58 ps=2.58 mult=1 m=1
XMN2_op1_0900_rwl_late_hold ref_op1_0900_rwl_late_hold rbl_op1_0900_rwl_late_hold vn_op1_0900_rwl_late_hold 0 sky130_fd_pr__nfet_01v8 L=0.15 W=1 nf=1 ad=0.29 as=0.29 pd=2.58 ps=2.58 mult=1 m=1
XMP1_op1_0900_rwl_late_hold rbl_op1_0900_rwl_late_hold ref_op1_0900_rwl_late_hold vp_op1_0900_rwl_late_hold vdd sky130_fd_pr__pfet_01v8 L=0.15 W=2 nf=1 ad=0.58 as=0.58 pd=4.58 ps=4.58 mult=1 m=1
XMP2_op1_0900_rwl_late_hold ref_op1_0900_rwl_late_hold rbl_op1_0900_rwl_late_hold vp_op1_0900_rwl_late_hold vdd sky130_fd_pr__pfet_01v8 L=0.15 W=2 nf=1 ad=0.58 as=0.58 pd=4.58 ps=4.58 mult=1 m=1
XMNF_op1_0900_rwl_late_hold vn_op1_0900_rwl_late_hold en_op1_0900_rwl_late_hold 0 0 sky130_fd_pr__nfet_01v8 L=0.15 W=2 nf=1 ad=0.58 as=0.58 pd=4.58 ps=4.58 mult=1 m=1
XMPH_op1_0900_rwl_late_hold vp_op1_0900_rwl_late_hold enb_op1_0900_rwl_late_hold vdd vdd sky130_fd_pr__pfet_01v8 L=0.15 W=4 nf=1 ad=1.16 as=1.16 pd=8.58 ps=8.58 mult=1 m=1
bd_op1_0900_rwl_late_hold d_op1_0900_rwl_late_hold 0 v=v(rbl_op1_0900_rwl_late_hold)-v(ref_op1_0900_rwl_late_hold)

* ---- instance 9: op1_1000_rwl_late_hold (variant rwl_late_hold; probe dec 11.9 ns, release 34 ns, meas 36 ns) ----
vctl_op1_1000_rwl_late_hold ctl_op1_1000_rwl_late_hold 0 pwl(0.0000e+00 {VDD} 2.0000e-09 {VDD} 2.1000e-09 0)
vrs_op1_1000_rwl_late_hold rwls_op1_1000_rwl_late_hold 0 pwl(0.0000e+00 {VDD} 2.0000e-09 {VDD} 2.1000e-09 0 3.4000e-08 0 3.4100e-08 {VDD})
ven_op1_1000_rwl_late_hold en_op1_1000_rwl_late_hold 0 pwl(0.0000e+00 0 1.1000e-08 0 1.1100e-08 {VDD} 3.4000e-08 {VDD} 3.4100e-08 0)
venb_op1_1000_rwl_late_hold enb_op1_1000_rwl_late_hold 0 pwl(0.0000e+00 {VDD} 1.1000e-08 {VDD} 1.1100e-08 0 3.4000e-08 0 3.4100e-08 {VDD})
vww_op1_1000_rwl_late_hold wwl_op1_1000_rwl_late_hold 0 pwl(0.0000e+00 0 1.2000e-08 0 1.2100e-08 {VDD} 3.2000e-08 {VDD} 3.2100e-08 0)
vwc_op1_1000_rwl_late_hold wbc_op1_1000_rwl_late_hold 0 pwl(0.0000e+00 0 1.2000e-08 0 1.2100e-08 {VDD} 3.4000e-08 {VDD} 3.4100e-08 0)
swb_op1_1000_rwl_late_hold ref_op1_1000_rwl_late_hold wbl_op1_1000_rwl_late_hold wbc_op1_1000_rwl_late_hold 0 swwbl
cwbl_op1_1000_rwl_late_hold wbl_op1_1000_rwl_late_hold 0 {C_WBL}
spa_op1_1000_rwl_late_hold prea rbl_op1_1000_rwl_late_hold ctl_op1_1000_rwl_late_hold 0 swpre
spr_op1_1000_rwl_late_hold pref ref_op1_1000_rwl_late_hold ctl_op1_1000_rwl_late_hold 0 swpre
crbl_op1_1000_rwl_late_hold rbl_op1_1000_rwl_late_hold 0 {C_RBL}
cref_op1_1000_rwl_late_hold ref_op1_1000_rwl_late_hold 0 {C_RBL}   $ ASSUMPTION: ideal matched dummy load
XMWR_op1_1000_rwl_late_hold_0 sn_op1_1000_rwl_late_hold_0 wwl_op1_1000_rwl_late_hold wbl_op1_1000_rwl_late_hold 0 sky130_fd_pr__nfet_01v8 L=0.15 W=0.42 nf=1 ad=0.1218 as=0.1218 pd=1.42 ps=1.42 nrd=0.69047619047619  nrs=0.69047619047619 sa=0 sb=0 sd=0 mult=1 m=1
XMRD_op1_1000_rwl_late_hold_0 rbl_op1_1000_rwl_late_hold sn_op1_1000_rwl_late_hold_0 rwls_op1_1000_rwl_late_hold 0 sky130_fd_pr__nfet_01v8 L=0.15 W=0.42 nf=1 ad=0.1218 as=0.1218 pd=1.42 ps=1.42 nrd=0.69047619047619  nrs=0.69047619047619 sa=0 sb=0 sd=0 mult=1 m=1
csn_op1_1000_rwl_late_hold_0 sn_op1_1000_rwl_late_hold_0 0 {C_SN}
XMWR_op1_1000_rwl_late_hold_1 sn_op1_1000_rwl_late_hold_1 wwl_des wbl_op1_1000_rwl_late_hold 0 sky130_fd_pr__nfet_01v8 L=0.15 W=0.42 nf=1 ad=0.1218 as=0.1218 pd=1.42 ps=1.42 nrd=0.69047619047619  nrs=0.69047619047619 sa=0 sb=0 sd=0 mult=1 m=1
XMRD_op1_1000_rwl_late_hold_1 rbl_op1_1000_rwl_late_hold sn_op1_1000_rwl_late_hold_1 rwl_des 0 sky130_fd_pr__nfet_01v8 L=0.15 W=0.42 nf=1 ad=0.1218 as=0.1218 pd=1.42 ps=1.42 nrd=0.69047619047619  nrs=0.69047619047619 sa=0 sb=0 sd=0 mult=1 m=1
csn_op1_1000_rwl_late_hold_1 sn_op1_1000_rwl_late_hold_1 0 {C_SN}
XMWR_op1_1000_rwl_late_hold_2 sn_op1_1000_rwl_late_hold_2 wwl_des wbl_op1_1000_rwl_late_hold 0 sky130_fd_pr__nfet_01v8 L=0.15 W=0.42 nf=1 ad=0.1218 as=0.1218 pd=1.42 ps=1.42 nrd=0.69047619047619  nrs=0.69047619047619 sa=0 sb=0 sd=0 mult=1 m=1
XMRD_op1_1000_rwl_late_hold_2 rbl_op1_1000_rwl_late_hold sn_op1_1000_rwl_late_hold_2 rwl_des 0 sky130_fd_pr__nfet_01v8 L=0.15 W=0.42 nf=1 ad=0.1218 as=0.1218 pd=1.42 ps=1.42 nrd=0.69047619047619  nrs=0.69047619047619 sa=0 sb=0 sd=0 mult=1 m=1
csn_op1_1000_rwl_late_hold_2 sn_op1_1000_rwl_late_hold_2 0 {C_SN}
XMWR_op1_1000_rwl_late_hold_3 sn_op1_1000_rwl_late_hold_3 wwl_des wbl_op1_1000_rwl_late_hold 0 sky130_fd_pr__nfet_01v8 L=0.15 W=0.42 nf=1 ad=0.1218 as=0.1218 pd=1.42 ps=1.42 nrd=0.69047619047619  nrs=0.69047619047619 sa=0 sb=0 sd=0 mult=1 m=1
XMRD_op1_1000_rwl_late_hold_3 rbl_op1_1000_rwl_late_hold sn_op1_1000_rwl_late_hold_3 rwl_des 0 sky130_fd_pr__nfet_01v8 L=0.15 W=0.42 nf=1 ad=0.1218 as=0.1218 pd=1.42 ps=1.42 nrd=0.69047619047619  nrs=0.69047619047619 sa=0 sb=0 sd=0 mult=1 m=1
csn_op1_1000_rwl_late_hold_3 sn_op1_1000_rwl_late_hold_3 0 {C_SN}
XMN1_op1_1000_rwl_late_hold rbl_op1_1000_rwl_late_hold ref_op1_1000_rwl_late_hold vn_op1_1000_rwl_late_hold 0 sky130_fd_pr__nfet_01v8 L=0.15 W=1 nf=1 ad=0.29 as=0.29 pd=2.58 ps=2.58 mult=1 m=1
XMN2_op1_1000_rwl_late_hold ref_op1_1000_rwl_late_hold rbl_op1_1000_rwl_late_hold vn_op1_1000_rwl_late_hold 0 sky130_fd_pr__nfet_01v8 L=0.15 W=1 nf=1 ad=0.29 as=0.29 pd=2.58 ps=2.58 mult=1 m=1
XMP1_op1_1000_rwl_late_hold rbl_op1_1000_rwl_late_hold ref_op1_1000_rwl_late_hold vp_op1_1000_rwl_late_hold vdd sky130_fd_pr__pfet_01v8 L=0.15 W=2 nf=1 ad=0.58 as=0.58 pd=4.58 ps=4.58 mult=1 m=1
XMP2_op1_1000_rwl_late_hold ref_op1_1000_rwl_late_hold rbl_op1_1000_rwl_late_hold vp_op1_1000_rwl_late_hold vdd sky130_fd_pr__pfet_01v8 L=0.15 W=2 nf=1 ad=0.58 as=0.58 pd=4.58 ps=4.58 mult=1 m=1
XMNF_op1_1000_rwl_late_hold vn_op1_1000_rwl_late_hold en_op1_1000_rwl_late_hold 0 0 sky130_fd_pr__nfet_01v8 L=0.15 W=2 nf=1 ad=0.58 as=0.58 pd=4.58 ps=4.58 mult=1 m=1
XMPH_op1_1000_rwl_late_hold vp_op1_1000_rwl_late_hold enb_op1_1000_rwl_late_hold vdd vdd sky130_fd_pr__pfet_01v8 L=0.15 W=4 nf=1 ad=1.16 as=1.16 pd=8.58 ps=8.58 mult=1 m=1
bd_op1_1000_rwl_late_hold d_op1_1000_rwl_late_hold 0 v=v(rbl_op1_1000_rwl_late_hold)-v(ref_op1_1000_rwl_late_hold)

* ---- instance 10: op0_n100_rwl_late_hold (variant rwl_late_hold; probe dec 11.9 ns, release 34 ns, meas 36 ns) ----
vctl_op0_n100_rwl_late_hold ctl_op0_n100_rwl_late_hold 0 pwl(0.0000e+00 {VDD} 2.0000e-09 {VDD} 2.1000e-09 0)
vrs_op0_n100_rwl_late_hold rwls_op0_n100_rwl_late_hold 0 pwl(0.0000e+00 {VDD} 2.0000e-09 {VDD} 2.1000e-09 0 3.4000e-08 0 3.4100e-08 {VDD})
ven_op0_n100_rwl_late_hold en_op0_n100_rwl_late_hold 0 pwl(0.0000e+00 0 1.1000e-08 0 1.1100e-08 {VDD} 3.4000e-08 {VDD} 3.4100e-08 0)
venb_op0_n100_rwl_late_hold enb_op0_n100_rwl_late_hold 0 pwl(0.0000e+00 {VDD} 1.1000e-08 {VDD} 1.1100e-08 0 3.4000e-08 0 3.4100e-08 {VDD})
vww_op0_n100_rwl_late_hold wwl_op0_n100_rwl_late_hold 0 pwl(0.0000e+00 0 1.2000e-08 0 1.2100e-08 {VDD} 3.2000e-08 {VDD} 3.2100e-08 0)
vwc_op0_n100_rwl_late_hold wbc_op0_n100_rwl_late_hold 0 pwl(0.0000e+00 0 1.2000e-08 0 1.2100e-08 {VDD} 3.4000e-08 {VDD} 3.4100e-08 0)
swb_op0_n100_rwl_late_hold ref_op0_n100_rwl_late_hold wbl_op0_n100_rwl_late_hold wbc_op0_n100_rwl_late_hold 0 swwbl
cwbl_op0_n100_rwl_late_hold wbl_op0_n100_rwl_late_hold 0 {C_WBL}
spa_op0_n100_rwl_late_hold prea rbl_op0_n100_rwl_late_hold ctl_op0_n100_rwl_late_hold 0 swpre
spr_op0_n100_rwl_late_hold pref ref_op0_n100_rwl_late_hold ctl_op0_n100_rwl_late_hold 0 swpre
crbl_op0_n100_rwl_late_hold rbl_op0_n100_rwl_late_hold 0 {C_RBL}
cref_op0_n100_rwl_late_hold ref_op0_n100_rwl_late_hold 0 {C_RBL}   $ ASSUMPTION: ideal matched dummy load
XMWR_op0_n100_rwl_late_hold_0 sn_op0_n100_rwl_late_hold_0 wwl_op0_n100_rwl_late_hold wbl_op0_n100_rwl_late_hold 0 sky130_fd_pr__nfet_01v8 L=0.15 W=0.42 nf=1 ad=0.1218 as=0.1218 pd=1.42 ps=1.42 nrd=0.69047619047619  nrs=0.69047619047619 sa=0 sb=0 sd=0 mult=1 m=1
XMRD_op0_n100_rwl_late_hold_0 rbl_op0_n100_rwl_late_hold sn_op0_n100_rwl_late_hold_0 rwls_op0_n100_rwl_late_hold 0 sky130_fd_pr__nfet_01v8 L=0.15 W=0.42 nf=1 ad=0.1218 as=0.1218 pd=1.42 ps=1.42 nrd=0.69047619047619  nrs=0.69047619047619 sa=0 sb=0 sd=0 mult=1 m=1
csn_op0_n100_rwl_late_hold_0 sn_op0_n100_rwl_late_hold_0 0 {C_SN}
XMWR_op0_n100_rwl_late_hold_1 sn_op0_n100_rwl_late_hold_1 wwl_des wbl_op0_n100_rwl_late_hold 0 sky130_fd_pr__nfet_01v8 L=0.15 W=0.42 nf=1 ad=0.1218 as=0.1218 pd=1.42 ps=1.42 nrd=0.69047619047619  nrs=0.69047619047619 sa=0 sb=0 sd=0 mult=1 m=1
XMRD_op0_n100_rwl_late_hold_1 rbl_op0_n100_rwl_late_hold sn_op0_n100_rwl_late_hold_1 rwl_des 0 sky130_fd_pr__nfet_01v8 L=0.15 W=0.42 nf=1 ad=0.1218 as=0.1218 pd=1.42 ps=1.42 nrd=0.69047619047619  nrs=0.69047619047619 sa=0 sb=0 sd=0 mult=1 m=1
csn_op0_n100_rwl_late_hold_1 sn_op0_n100_rwl_late_hold_1 0 {C_SN}
XMWR_op0_n100_rwl_late_hold_2 sn_op0_n100_rwl_late_hold_2 wwl_des wbl_op0_n100_rwl_late_hold 0 sky130_fd_pr__nfet_01v8 L=0.15 W=0.42 nf=1 ad=0.1218 as=0.1218 pd=1.42 ps=1.42 nrd=0.69047619047619  nrs=0.69047619047619 sa=0 sb=0 sd=0 mult=1 m=1
XMRD_op0_n100_rwl_late_hold_2 rbl_op0_n100_rwl_late_hold sn_op0_n100_rwl_late_hold_2 rwl_des 0 sky130_fd_pr__nfet_01v8 L=0.15 W=0.42 nf=1 ad=0.1218 as=0.1218 pd=1.42 ps=1.42 nrd=0.69047619047619  nrs=0.69047619047619 sa=0 sb=0 sd=0 mult=1 m=1
csn_op0_n100_rwl_late_hold_2 sn_op0_n100_rwl_late_hold_2 0 {C_SN}
XMWR_op0_n100_rwl_late_hold_3 sn_op0_n100_rwl_late_hold_3 wwl_des wbl_op0_n100_rwl_late_hold 0 sky130_fd_pr__nfet_01v8 L=0.15 W=0.42 nf=1 ad=0.1218 as=0.1218 pd=1.42 ps=1.42 nrd=0.69047619047619  nrs=0.69047619047619 sa=0 sb=0 sd=0 mult=1 m=1
XMRD_op0_n100_rwl_late_hold_3 rbl_op0_n100_rwl_late_hold sn_op0_n100_rwl_late_hold_3 rwl_des 0 sky130_fd_pr__nfet_01v8 L=0.15 W=0.42 nf=1 ad=0.1218 as=0.1218 pd=1.42 ps=1.42 nrd=0.69047619047619  nrs=0.69047619047619 sa=0 sb=0 sd=0 mult=1 m=1
csn_op0_n100_rwl_late_hold_3 sn_op0_n100_rwl_late_hold_3 0 {C_SN}
XMN1_op0_n100_rwl_late_hold rbl_op0_n100_rwl_late_hold ref_op0_n100_rwl_late_hold vn_op0_n100_rwl_late_hold 0 sky130_fd_pr__nfet_01v8 L=0.15 W=1 nf=1 ad=0.29 as=0.29 pd=2.58 ps=2.58 mult=1 m=1
XMN2_op0_n100_rwl_late_hold ref_op0_n100_rwl_late_hold rbl_op0_n100_rwl_late_hold vn_op0_n100_rwl_late_hold 0 sky130_fd_pr__nfet_01v8 L=0.15 W=1 nf=1 ad=0.29 as=0.29 pd=2.58 ps=2.58 mult=1 m=1
XMP1_op0_n100_rwl_late_hold rbl_op0_n100_rwl_late_hold ref_op0_n100_rwl_late_hold vp_op0_n100_rwl_late_hold vdd sky130_fd_pr__pfet_01v8 L=0.15 W=2 nf=1 ad=0.58 as=0.58 pd=4.58 ps=4.58 mult=1 m=1
XMP2_op0_n100_rwl_late_hold ref_op0_n100_rwl_late_hold rbl_op0_n100_rwl_late_hold vp_op0_n100_rwl_late_hold vdd sky130_fd_pr__pfet_01v8 L=0.15 W=2 nf=1 ad=0.58 as=0.58 pd=4.58 ps=4.58 mult=1 m=1
XMNF_op0_n100_rwl_late_hold vn_op0_n100_rwl_late_hold en_op0_n100_rwl_late_hold 0 0 sky130_fd_pr__nfet_01v8 L=0.15 W=2 nf=1 ad=0.58 as=0.58 pd=4.58 ps=4.58 mult=1 m=1
XMPH_op0_n100_rwl_late_hold vp_op0_n100_rwl_late_hold enb_op0_n100_rwl_late_hold vdd vdd sky130_fd_pr__pfet_01v8 L=0.15 W=4 nf=1 ad=1.16 as=1.16 pd=8.58 ps=8.58 mult=1 m=1
bd_op0_n100_rwl_late_hold d_op0_n100_rwl_late_hold 0 v=v(rbl_op0_n100_rwl_late_hold)-v(ref_op0_n100_rwl_late_hold)

* ---- instance 11: op0_0000_rwl_late_hold (variant rwl_late_hold; probe dec 11.9 ns, release 34 ns, meas 36 ns) ----
vctl_op0_0000_rwl_late_hold ctl_op0_0000_rwl_late_hold 0 pwl(0.0000e+00 {VDD} 2.0000e-09 {VDD} 2.1000e-09 0)
vrs_op0_0000_rwl_late_hold rwls_op0_0000_rwl_late_hold 0 pwl(0.0000e+00 {VDD} 2.0000e-09 {VDD} 2.1000e-09 0 3.4000e-08 0 3.4100e-08 {VDD})
ven_op0_0000_rwl_late_hold en_op0_0000_rwl_late_hold 0 pwl(0.0000e+00 0 1.1000e-08 0 1.1100e-08 {VDD} 3.4000e-08 {VDD} 3.4100e-08 0)
venb_op0_0000_rwl_late_hold enb_op0_0000_rwl_late_hold 0 pwl(0.0000e+00 {VDD} 1.1000e-08 {VDD} 1.1100e-08 0 3.4000e-08 0 3.4100e-08 {VDD})
vww_op0_0000_rwl_late_hold wwl_op0_0000_rwl_late_hold 0 pwl(0.0000e+00 0 1.2000e-08 0 1.2100e-08 {VDD} 3.2000e-08 {VDD} 3.2100e-08 0)
vwc_op0_0000_rwl_late_hold wbc_op0_0000_rwl_late_hold 0 pwl(0.0000e+00 0 1.2000e-08 0 1.2100e-08 {VDD} 3.4000e-08 {VDD} 3.4100e-08 0)
swb_op0_0000_rwl_late_hold ref_op0_0000_rwl_late_hold wbl_op0_0000_rwl_late_hold wbc_op0_0000_rwl_late_hold 0 swwbl
cwbl_op0_0000_rwl_late_hold wbl_op0_0000_rwl_late_hold 0 {C_WBL}
spa_op0_0000_rwl_late_hold prea rbl_op0_0000_rwl_late_hold ctl_op0_0000_rwl_late_hold 0 swpre
spr_op0_0000_rwl_late_hold pref ref_op0_0000_rwl_late_hold ctl_op0_0000_rwl_late_hold 0 swpre
crbl_op0_0000_rwl_late_hold rbl_op0_0000_rwl_late_hold 0 {C_RBL}
cref_op0_0000_rwl_late_hold ref_op0_0000_rwl_late_hold 0 {C_RBL}   $ ASSUMPTION: ideal matched dummy load
XMWR_op0_0000_rwl_late_hold_0 sn_op0_0000_rwl_late_hold_0 wwl_op0_0000_rwl_late_hold wbl_op0_0000_rwl_late_hold 0 sky130_fd_pr__nfet_01v8 L=0.15 W=0.42 nf=1 ad=0.1218 as=0.1218 pd=1.42 ps=1.42 nrd=0.69047619047619  nrs=0.69047619047619 sa=0 sb=0 sd=0 mult=1 m=1
XMRD_op0_0000_rwl_late_hold_0 rbl_op0_0000_rwl_late_hold sn_op0_0000_rwl_late_hold_0 rwls_op0_0000_rwl_late_hold 0 sky130_fd_pr__nfet_01v8 L=0.15 W=0.42 nf=1 ad=0.1218 as=0.1218 pd=1.42 ps=1.42 nrd=0.69047619047619  nrs=0.69047619047619 sa=0 sb=0 sd=0 mult=1 m=1
csn_op0_0000_rwl_late_hold_0 sn_op0_0000_rwl_late_hold_0 0 {C_SN}
XMWR_op0_0000_rwl_late_hold_1 sn_op0_0000_rwl_late_hold_1 wwl_des wbl_op0_0000_rwl_late_hold 0 sky130_fd_pr__nfet_01v8 L=0.15 W=0.42 nf=1 ad=0.1218 as=0.1218 pd=1.42 ps=1.42 nrd=0.69047619047619  nrs=0.69047619047619 sa=0 sb=0 sd=0 mult=1 m=1
XMRD_op0_0000_rwl_late_hold_1 rbl_op0_0000_rwl_late_hold sn_op0_0000_rwl_late_hold_1 rwl_des 0 sky130_fd_pr__nfet_01v8 L=0.15 W=0.42 nf=1 ad=0.1218 as=0.1218 pd=1.42 ps=1.42 nrd=0.69047619047619  nrs=0.69047619047619 sa=0 sb=0 sd=0 mult=1 m=1
csn_op0_0000_rwl_late_hold_1 sn_op0_0000_rwl_late_hold_1 0 {C_SN}
XMWR_op0_0000_rwl_late_hold_2 sn_op0_0000_rwl_late_hold_2 wwl_des wbl_op0_0000_rwl_late_hold 0 sky130_fd_pr__nfet_01v8 L=0.15 W=0.42 nf=1 ad=0.1218 as=0.1218 pd=1.42 ps=1.42 nrd=0.69047619047619  nrs=0.69047619047619 sa=0 sb=0 sd=0 mult=1 m=1
XMRD_op0_0000_rwl_late_hold_2 rbl_op0_0000_rwl_late_hold sn_op0_0000_rwl_late_hold_2 rwl_des 0 sky130_fd_pr__nfet_01v8 L=0.15 W=0.42 nf=1 ad=0.1218 as=0.1218 pd=1.42 ps=1.42 nrd=0.69047619047619  nrs=0.69047619047619 sa=0 sb=0 sd=0 mult=1 m=1
csn_op0_0000_rwl_late_hold_2 sn_op0_0000_rwl_late_hold_2 0 {C_SN}
XMWR_op0_0000_rwl_late_hold_3 sn_op0_0000_rwl_late_hold_3 wwl_des wbl_op0_0000_rwl_late_hold 0 sky130_fd_pr__nfet_01v8 L=0.15 W=0.42 nf=1 ad=0.1218 as=0.1218 pd=1.42 ps=1.42 nrd=0.69047619047619  nrs=0.69047619047619 sa=0 sb=0 sd=0 mult=1 m=1
XMRD_op0_0000_rwl_late_hold_3 rbl_op0_0000_rwl_late_hold sn_op0_0000_rwl_late_hold_3 rwl_des 0 sky130_fd_pr__nfet_01v8 L=0.15 W=0.42 nf=1 ad=0.1218 as=0.1218 pd=1.42 ps=1.42 nrd=0.69047619047619  nrs=0.69047619047619 sa=0 sb=0 sd=0 mult=1 m=1
csn_op0_0000_rwl_late_hold_3 sn_op0_0000_rwl_late_hold_3 0 {C_SN}
XMN1_op0_0000_rwl_late_hold rbl_op0_0000_rwl_late_hold ref_op0_0000_rwl_late_hold vn_op0_0000_rwl_late_hold 0 sky130_fd_pr__nfet_01v8 L=0.15 W=1 nf=1 ad=0.29 as=0.29 pd=2.58 ps=2.58 mult=1 m=1
XMN2_op0_0000_rwl_late_hold ref_op0_0000_rwl_late_hold rbl_op0_0000_rwl_late_hold vn_op0_0000_rwl_late_hold 0 sky130_fd_pr__nfet_01v8 L=0.15 W=1 nf=1 ad=0.29 as=0.29 pd=2.58 ps=2.58 mult=1 m=1
XMP1_op0_0000_rwl_late_hold rbl_op0_0000_rwl_late_hold ref_op0_0000_rwl_late_hold vp_op0_0000_rwl_late_hold vdd sky130_fd_pr__pfet_01v8 L=0.15 W=2 nf=1 ad=0.58 as=0.58 pd=4.58 ps=4.58 mult=1 m=1
XMP2_op0_0000_rwl_late_hold ref_op0_0000_rwl_late_hold rbl_op0_0000_rwl_late_hold vp_op0_0000_rwl_late_hold vdd sky130_fd_pr__pfet_01v8 L=0.15 W=2 nf=1 ad=0.58 as=0.58 pd=4.58 ps=4.58 mult=1 m=1
XMNF_op0_0000_rwl_late_hold vn_op0_0000_rwl_late_hold en_op0_0000_rwl_late_hold 0 0 sky130_fd_pr__nfet_01v8 L=0.15 W=2 nf=1 ad=0.58 as=0.58 pd=4.58 ps=4.58 mult=1 m=1
XMPH_op0_0000_rwl_late_hold vp_op0_0000_rwl_late_hold enb_op0_0000_rwl_late_hold vdd vdd sky130_fd_pr__pfet_01v8 L=0.15 W=4 nf=1 ad=1.16 as=1.16 pd=8.58 ps=8.58 mult=1 m=1
bd_op0_0000_rwl_late_hold d_op0_0000_rwl_late_hold 0 v=v(rbl_op0_0000_rwl_late_hold)-v(ref_op0_0000_rwl_late_hold)

* ---- instance 12: op1_0900_neg_missing_wb (variant neg_missing_wb; probe dec 11.9 ns, release 34 ns, meas 36 ns) ----
vctl_op1_0900_neg_missing_wb ctl_op1_0900_neg_missing_wb 0 pwl(0.0000e+00 {VDD} 2.0000e-09 {VDD} 2.1000e-09 0)
vrs_op1_0900_neg_missing_wb rwls_op1_0900_neg_missing_wb 0 pwl(0.0000e+00 {VDD} 2.0000e-09 {VDD} 2.1000e-09 0 1.2000e-08 0 1.2100e-08 {VDD})
ven_op1_0900_neg_missing_wb en_op1_0900_neg_missing_wb 0 pwl(0.0000e+00 0 1.1000e-08 0 1.1100e-08 {VDD} 3.4000e-08 {VDD} 3.4100e-08 0)
venb_op1_0900_neg_missing_wb enb_op1_0900_neg_missing_wb 0 pwl(0.0000e+00 {VDD} 1.1000e-08 {VDD} 1.1100e-08 0 3.4000e-08 0 3.4100e-08 {VDD})
vww_op1_0900_neg_missing_wb wwl_op1_0900_neg_missing_wb 0 pwl(0.0000e+00 0)
vwc_op1_0900_neg_missing_wb wbc_op1_0900_neg_missing_wb 0 pwl(0.0000e+00 0)
swb_op1_0900_neg_missing_wb ref_op1_0900_neg_missing_wb wbl_op1_0900_neg_missing_wb wbc_op1_0900_neg_missing_wb 0 swwbl
cwbl_op1_0900_neg_missing_wb wbl_op1_0900_neg_missing_wb 0 {C_WBL}
spa_op1_0900_neg_missing_wb prea rbl_op1_0900_neg_missing_wb ctl_op1_0900_neg_missing_wb 0 swpre
spr_op1_0900_neg_missing_wb pref ref_op1_0900_neg_missing_wb ctl_op1_0900_neg_missing_wb 0 swpre
crbl_op1_0900_neg_missing_wb rbl_op1_0900_neg_missing_wb 0 {C_RBL}
cref_op1_0900_neg_missing_wb ref_op1_0900_neg_missing_wb 0 {C_RBL}   $ ASSUMPTION: ideal matched dummy load
XMWR_op1_0900_neg_missing_wb_0 sn_op1_0900_neg_missing_wb_0 wwl_op1_0900_neg_missing_wb wbl_op1_0900_neg_missing_wb 0 sky130_fd_pr__nfet_01v8 L=0.15 W=0.42 nf=1 ad=0.1218 as=0.1218 pd=1.42 ps=1.42 nrd=0.69047619047619  nrs=0.69047619047619 sa=0 sb=0 sd=0 mult=1 m=1
XMRD_op1_0900_neg_missing_wb_0 rbl_op1_0900_neg_missing_wb sn_op1_0900_neg_missing_wb_0 rwls_op1_0900_neg_missing_wb 0 sky130_fd_pr__nfet_01v8 L=0.15 W=0.42 nf=1 ad=0.1218 as=0.1218 pd=1.42 ps=1.42 nrd=0.69047619047619  nrs=0.69047619047619 sa=0 sb=0 sd=0 mult=1 m=1
csn_op1_0900_neg_missing_wb_0 sn_op1_0900_neg_missing_wb_0 0 {C_SN}
XMWR_op1_0900_neg_missing_wb_1 sn_op1_0900_neg_missing_wb_1 wwl_des wbl_op1_0900_neg_missing_wb 0 sky130_fd_pr__nfet_01v8 L=0.15 W=0.42 nf=1 ad=0.1218 as=0.1218 pd=1.42 ps=1.42 nrd=0.69047619047619  nrs=0.69047619047619 sa=0 sb=0 sd=0 mult=1 m=1
XMRD_op1_0900_neg_missing_wb_1 rbl_op1_0900_neg_missing_wb sn_op1_0900_neg_missing_wb_1 rwl_des 0 sky130_fd_pr__nfet_01v8 L=0.15 W=0.42 nf=1 ad=0.1218 as=0.1218 pd=1.42 ps=1.42 nrd=0.69047619047619  nrs=0.69047619047619 sa=0 sb=0 sd=0 mult=1 m=1
csn_op1_0900_neg_missing_wb_1 sn_op1_0900_neg_missing_wb_1 0 {C_SN}
XMWR_op1_0900_neg_missing_wb_2 sn_op1_0900_neg_missing_wb_2 wwl_des wbl_op1_0900_neg_missing_wb 0 sky130_fd_pr__nfet_01v8 L=0.15 W=0.42 nf=1 ad=0.1218 as=0.1218 pd=1.42 ps=1.42 nrd=0.69047619047619  nrs=0.69047619047619 sa=0 sb=0 sd=0 mult=1 m=1
XMRD_op1_0900_neg_missing_wb_2 rbl_op1_0900_neg_missing_wb sn_op1_0900_neg_missing_wb_2 rwl_des 0 sky130_fd_pr__nfet_01v8 L=0.15 W=0.42 nf=1 ad=0.1218 as=0.1218 pd=1.42 ps=1.42 nrd=0.69047619047619  nrs=0.69047619047619 sa=0 sb=0 sd=0 mult=1 m=1
csn_op1_0900_neg_missing_wb_2 sn_op1_0900_neg_missing_wb_2 0 {C_SN}
XMWR_op1_0900_neg_missing_wb_3 sn_op1_0900_neg_missing_wb_3 wwl_des wbl_op1_0900_neg_missing_wb 0 sky130_fd_pr__nfet_01v8 L=0.15 W=0.42 nf=1 ad=0.1218 as=0.1218 pd=1.42 ps=1.42 nrd=0.69047619047619  nrs=0.69047619047619 sa=0 sb=0 sd=0 mult=1 m=1
XMRD_op1_0900_neg_missing_wb_3 rbl_op1_0900_neg_missing_wb sn_op1_0900_neg_missing_wb_3 rwl_des 0 sky130_fd_pr__nfet_01v8 L=0.15 W=0.42 nf=1 ad=0.1218 as=0.1218 pd=1.42 ps=1.42 nrd=0.69047619047619  nrs=0.69047619047619 sa=0 sb=0 sd=0 mult=1 m=1
csn_op1_0900_neg_missing_wb_3 sn_op1_0900_neg_missing_wb_3 0 {C_SN}
XMN1_op1_0900_neg_missing_wb rbl_op1_0900_neg_missing_wb ref_op1_0900_neg_missing_wb vn_op1_0900_neg_missing_wb 0 sky130_fd_pr__nfet_01v8 L=0.15 W=1 nf=1 ad=0.29 as=0.29 pd=2.58 ps=2.58 mult=1 m=1
XMN2_op1_0900_neg_missing_wb ref_op1_0900_neg_missing_wb rbl_op1_0900_neg_missing_wb vn_op1_0900_neg_missing_wb 0 sky130_fd_pr__nfet_01v8 L=0.15 W=1 nf=1 ad=0.29 as=0.29 pd=2.58 ps=2.58 mult=1 m=1
XMP1_op1_0900_neg_missing_wb rbl_op1_0900_neg_missing_wb ref_op1_0900_neg_missing_wb vp_op1_0900_neg_missing_wb vdd sky130_fd_pr__pfet_01v8 L=0.15 W=2 nf=1 ad=0.58 as=0.58 pd=4.58 ps=4.58 mult=1 m=1
XMP2_op1_0900_neg_missing_wb ref_op1_0900_neg_missing_wb rbl_op1_0900_neg_missing_wb vp_op1_0900_neg_missing_wb vdd sky130_fd_pr__pfet_01v8 L=0.15 W=2 nf=1 ad=0.58 as=0.58 pd=4.58 ps=4.58 mult=1 m=1
XMNF_op1_0900_neg_missing_wb vn_op1_0900_neg_missing_wb en_op1_0900_neg_missing_wb 0 0 sky130_fd_pr__nfet_01v8 L=0.15 W=2 nf=1 ad=0.58 as=0.58 pd=4.58 ps=4.58 mult=1 m=1
XMPH_op1_0900_neg_missing_wb vp_op1_0900_neg_missing_wb enb_op1_0900_neg_missing_wb vdd vdd sky130_fd_pr__pfet_01v8 L=0.15 W=4 nf=1 ad=1.16 as=1.16 pd=8.58 ps=8.58 mult=1 m=1
bd_op1_0900_neg_missing_wb d_op1_0900_neg_missing_wb 0 v=v(rbl_op1_0900_neg_missing_wb)-v(ref_op1_0900_neg_missing_wb)

* ---- instance 13: op1_1000_neg_missing_wb (variant neg_missing_wb; probe dec 11.9 ns, release 34 ns, meas 36 ns) ----
vctl_op1_1000_neg_missing_wb ctl_op1_1000_neg_missing_wb 0 pwl(0.0000e+00 {VDD} 2.0000e-09 {VDD} 2.1000e-09 0)
vrs_op1_1000_neg_missing_wb rwls_op1_1000_neg_missing_wb 0 pwl(0.0000e+00 {VDD} 2.0000e-09 {VDD} 2.1000e-09 0 1.2000e-08 0 1.2100e-08 {VDD})
ven_op1_1000_neg_missing_wb en_op1_1000_neg_missing_wb 0 pwl(0.0000e+00 0 1.1000e-08 0 1.1100e-08 {VDD} 3.4000e-08 {VDD} 3.4100e-08 0)
venb_op1_1000_neg_missing_wb enb_op1_1000_neg_missing_wb 0 pwl(0.0000e+00 {VDD} 1.1000e-08 {VDD} 1.1100e-08 0 3.4000e-08 0 3.4100e-08 {VDD})
vww_op1_1000_neg_missing_wb wwl_op1_1000_neg_missing_wb 0 pwl(0.0000e+00 0)
vwc_op1_1000_neg_missing_wb wbc_op1_1000_neg_missing_wb 0 pwl(0.0000e+00 0)
swb_op1_1000_neg_missing_wb ref_op1_1000_neg_missing_wb wbl_op1_1000_neg_missing_wb wbc_op1_1000_neg_missing_wb 0 swwbl
cwbl_op1_1000_neg_missing_wb wbl_op1_1000_neg_missing_wb 0 {C_WBL}
spa_op1_1000_neg_missing_wb prea rbl_op1_1000_neg_missing_wb ctl_op1_1000_neg_missing_wb 0 swpre
spr_op1_1000_neg_missing_wb pref ref_op1_1000_neg_missing_wb ctl_op1_1000_neg_missing_wb 0 swpre
crbl_op1_1000_neg_missing_wb rbl_op1_1000_neg_missing_wb 0 {C_RBL}
cref_op1_1000_neg_missing_wb ref_op1_1000_neg_missing_wb 0 {C_RBL}   $ ASSUMPTION: ideal matched dummy load
XMWR_op1_1000_neg_missing_wb_0 sn_op1_1000_neg_missing_wb_0 wwl_op1_1000_neg_missing_wb wbl_op1_1000_neg_missing_wb 0 sky130_fd_pr__nfet_01v8 L=0.15 W=0.42 nf=1 ad=0.1218 as=0.1218 pd=1.42 ps=1.42 nrd=0.69047619047619  nrs=0.69047619047619 sa=0 sb=0 sd=0 mult=1 m=1
XMRD_op1_1000_neg_missing_wb_0 rbl_op1_1000_neg_missing_wb sn_op1_1000_neg_missing_wb_0 rwls_op1_1000_neg_missing_wb 0 sky130_fd_pr__nfet_01v8 L=0.15 W=0.42 nf=1 ad=0.1218 as=0.1218 pd=1.42 ps=1.42 nrd=0.69047619047619  nrs=0.69047619047619 sa=0 sb=0 sd=0 mult=1 m=1
csn_op1_1000_neg_missing_wb_0 sn_op1_1000_neg_missing_wb_0 0 {C_SN}
XMWR_op1_1000_neg_missing_wb_1 sn_op1_1000_neg_missing_wb_1 wwl_des wbl_op1_1000_neg_missing_wb 0 sky130_fd_pr__nfet_01v8 L=0.15 W=0.42 nf=1 ad=0.1218 as=0.1218 pd=1.42 ps=1.42 nrd=0.69047619047619  nrs=0.69047619047619 sa=0 sb=0 sd=0 mult=1 m=1
XMRD_op1_1000_neg_missing_wb_1 rbl_op1_1000_neg_missing_wb sn_op1_1000_neg_missing_wb_1 rwl_des 0 sky130_fd_pr__nfet_01v8 L=0.15 W=0.42 nf=1 ad=0.1218 as=0.1218 pd=1.42 ps=1.42 nrd=0.69047619047619  nrs=0.69047619047619 sa=0 sb=0 sd=0 mult=1 m=1
csn_op1_1000_neg_missing_wb_1 sn_op1_1000_neg_missing_wb_1 0 {C_SN}
XMWR_op1_1000_neg_missing_wb_2 sn_op1_1000_neg_missing_wb_2 wwl_des wbl_op1_1000_neg_missing_wb 0 sky130_fd_pr__nfet_01v8 L=0.15 W=0.42 nf=1 ad=0.1218 as=0.1218 pd=1.42 ps=1.42 nrd=0.69047619047619  nrs=0.69047619047619 sa=0 sb=0 sd=0 mult=1 m=1
XMRD_op1_1000_neg_missing_wb_2 rbl_op1_1000_neg_missing_wb sn_op1_1000_neg_missing_wb_2 rwl_des 0 sky130_fd_pr__nfet_01v8 L=0.15 W=0.42 nf=1 ad=0.1218 as=0.1218 pd=1.42 ps=1.42 nrd=0.69047619047619  nrs=0.69047619047619 sa=0 sb=0 sd=0 mult=1 m=1
csn_op1_1000_neg_missing_wb_2 sn_op1_1000_neg_missing_wb_2 0 {C_SN}
XMWR_op1_1000_neg_missing_wb_3 sn_op1_1000_neg_missing_wb_3 wwl_des wbl_op1_1000_neg_missing_wb 0 sky130_fd_pr__nfet_01v8 L=0.15 W=0.42 nf=1 ad=0.1218 as=0.1218 pd=1.42 ps=1.42 nrd=0.69047619047619  nrs=0.69047619047619 sa=0 sb=0 sd=0 mult=1 m=1
XMRD_op1_1000_neg_missing_wb_3 rbl_op1_1000_neg_missing_wb sn_op1_1000_neg_missing_wb_3 rwl_des 0 sky130_fd_pr__nfet_01v8 L=0.15 W=0.42 nf=1 ad=0.1218 as=0.1218 pd=1.42 ps=1.42 nrd=0.69047619047619  nrs=0.69047619047619 sa=0 sb=0 sd=0 mult=1 m=1
csn_op1_1000_neg_missing_wb_3 sn_op1_1000_neg_missing_wb_3 0 {C_SN}
XMN1_op1_1000_neg_missing_wb rbl_op1_1000_neg_missing_wb ref_op1_1000_neg_missing_wb vn_op1_1000_neg_missing_wb 0 sky130_fd_pr__nfet_01v8 L=0.15 W=1 nf=1 ad=0.29 as=0.29 pd=2.58 ps=2.58 mult=1 m=1
XMN2_op1_1000_neg_missing_wb ref_op1_1000_neg_missing_wb rbl_op1_1000_neg_missing_wb vn_op1_1000_neg_missing_wb 0 sky130_fd_pr__nfet_01v8 L=0.15 W=1 nf=1 ad=0.29 as=0.29 pd=2.58 ps=2.58 mult=1 m=1
XMP1_op1_1000_neg_missing_wb rbl_op1_1000_neg_missing_wb ref_op1_1000_neg_missing_wb vp_op1_1000_neg_missing_wb vdd sky130_fd_pr__pfet_01v8 L=0.15 W=2 nf=1 ad=0.58 as=0.58 pd=4.58 ps=4.58 mult=1 m=1
XMP2_op1_1000_neg_missing_wb ref_op1_1000_neg_missing_wb rbl_op1_1000_neg_missing_wb vp_op1_1000_neg_missing_wb vdd sky130_fd_pr__pfet_01v8 L=0.15 W=2 nf=1 ad=0.58 as=0.58 pd=4.58 ps=4.58 mult=1 m=1
XMNF_op1_1000_neg_missing_wb vn_op1_1000_neg_missing_wb en_op1_1000_neg_missing_wb 0 0 sky130_fd_pr__nfet_01v8 L=0.15 W=2 nf=1 ad=0.58 as=0.58 pd=4.58 ps=4.58 mult=1 m=1
XMPH_op1_1000_neg_missing_wb vp_op1_1000_neg_missing_wb enb_op1_1000_neg_missing_wb vdd vdd sky130_fd_pr__pfet_01v8 L=0.15 W=4 nf=1 ad=1.16 as=1.16 pd=8.58 ps=8.58 mult=1 m=1
bd_op1_1000_neg_missing_wb d_op1_1000_neg_missing_wb 0 v=v(rbl_op1_1000_neg_missing_wb)-v(ref_op1_1000_neg_missing_wb)

* ---- instance 14: op0_n100_neg_missing_wb (variant neg_missing_wb; probe dec 11.9 ns, release 34 ns, meas 36 ns) ----
vctl_op0_n100_neg_missing_wb ctl_op0_n100_neg_missing_wb 0 pwl(0.0000e+00 {VDD} 2.0000e-09 {VDD} 2.1000e-09 0)
vrs_op0_n100_neg_missing_wb rwls_op0_n100_neg_missing_wb 0 pwl(0.0000e+00 {VDD} 2.0000e-09 {VDD} 2.1000e-09 0 1.2000e-08 0 1.2100e-08 {VDD})
ven_op0_n100_neg_missing_wb en_op0_n100_neg_missing_wb 0 pwl(0.0000e+00 0 1.1000e-08 0 1.1100e-08 {VDD} 3.4000e-08 {VDD} 3.4100e-08 0)
venb_op0_n100_neg_missing_wb enb_op0_n100_neg_missing_wb 0 pwl(0.0000e+00 {VDD} 1.1000e-08 {VDD} 1.1100e-08 0 3.4000e-08 0 3.4100e-08 {VDD})
vww_op0_n100_neg_missing_wb wwl_op0_n100_neg_missing_wb 0 pwl(0.0000e+00 0)
vwc_op0_n100_neg_missing_wb wbc_op0_n100_neg_missing_wb 0 pwl(0.0000e+00 0)
swb_op0_n100_neg_missing_wb ref_op0_n100_neg_missing_wb wbl_op0_n100_neg_missing_wb wbc_op0_n100_neg_missing_wb 0 swwbl
cwbl_op0_n100_neg_missing_wb wbl_op0_n100_neg_missing_wb 0 {C_WBL}
spa_op0_n100_neg_missing_wb prea rbl_op0_n100_neg_missing_wb ctl_op0_n100_neg_missing_wb 0 swpre
spr_op0_n100_neg_missing_wb pref ref_op0_n100_neg_missing_wb ctl_op0_n100_neg_missing_wb 0 swpre
crbl_op0_n100_neg_missing_wb rbl_op0_n100_neg_missing_wb 0 {C_RBL}
cref_op0_n100_neg_missing_wb ref_op0_n100_neg_missing_wb 0 {C_RBL}   $ ASSUMPTION: ideal matched dummy load
XMWR_op0_n100_neg_missing_wb_0 sn_op0_n100_neg_missing_wb_0 wwl_op0_n100_neg_missing_wb wbl_op0_n100_neg_missing_wb 0 sky130_fd_pr__nfet_01v8 L=0.15 W=0.42 nf=1 ad=0.1218 as=0.1218 pd=1.42 ps=1.42 nrd=0.69047619047619  nrs=0.69047619047619 sa=0 sb=0 sd=0 mult=1 m=1
XMRD_op0_n100_neg_missing_wb_0 rbl_op0_n100_neg_missing_wb sn_op0_n100_neg_missing_wb_0 rwls_op0_n100_neg_missing_wb 0 sky130_fd_pr__nfet_01v8 L=0.15 W=0.42 nf=1 ad=0.1218 as=0.1218 pd=1.42 ps=1.42 nrd=0.69047619047619  nrs=0.69047619047619 sa=0 sb=0 sd=0 mult=1 m=1
csn_op0_n100_neg_missing_wb_0 sn_op0_n100_neg_missing_wb_0 0 {C_SN}
XMWR_op0_n100_neg_missing_wb_1 sn_op0_n100_neg_missing_wb_1 wwl_des wbl_op0_n100_neg_missing_wb 0 sky130_fd_pr__nfet_01v8 L=0.15 W=0.42 nf=1 ad=0.1218 as=0.1218 pd=1.42 ps=1.42 nrd=0.69047619047619  nrs=0.69047619047619 sa=0 sb=0 sd=0 mult=1 m=1
XMRD_op0_n100_neg_missing_wb_1 rbl_op0_n100_neg_missing_wb sn_op0_n100_neg_missing_wb_1 rwl_des 0 sky130_fd_pr__nfet_01v8 L=0.15 W=0.42 nf=1 ad=0.1218 as=0.1218 pd=1.42 ps=1.42 nrd=0.69047619047619  nrs=0.69047619047619 sa=0 sb=0 sd=0 mult=1 m=1
csn_op0_n100_neg_missing_wb_1 sn_op0_n100_neg_missing_wb_1 0 {C_SN}
XMWR_op0_n100_neg_missing_wb_2 sn_op0_n100_neg_missing_wb_2 wwl_des wbl_op0_n100_neg_missing_wb 0 sky130_fd_pr__nfet_01v8 L=0.15 W=0.42 nf=1 ad=0.1218 as=0.1218 pd=1.42 ps=1.42 nrd=0.69047619047619  nrs=0.69047619047619 sa=0 sb=0 sd=0 mult=1 m=1
XMRD_op0_n100_neg_missing_wb_2 rbl_op0_n100_neg_missing_wb sn_op0_n100_neg_missing_wb_2 rwl_des 0 sky130_fd_pr__nfet_01v8 L=0.15 W=0.42 nf=1 ad=0.1218 as=0.1218 pd=1.42 ps=1.42 nrd=0.69047619047619  nrs=0.69047619047619 sa=0 sb=0 sd=0 mult=1 m=1
csn_op0_n100_neg_missing_wb_2 sn_op0_n100_neg_missing_wb_2 0 {C_SN}
XMWR_op0_n100_neg_missing_wb_3 sn_op0_n100_neg_missing_wb_3 wwl_des wbl_op0_n100_neg_missing_wb 0 sky130_fd_pr__nfet_01v8 L=0.15 W=0.42 nf=1 ad=0.1218 as=0.1218 pd=1.42 ps=1.42 nrd=0.69047619047619  nrs=0.69047619047619 sa=0 sb=0 sd=0 mult=1 m=1
XMRD_op0_n100_neg_missing_wb_3 rbl_op0_n100_neg_missing_wb sn_op0_n100_neg_missing_wb_3 rwl_des 0 sky130_fd_pr__nfet_01v8 L=0.15 W=0.42 nf=1 ad=0.1218 as=0.1218 pd=1.42 ps=1.42 nrd=0.69047619047619  nrs=0.69047619047619 sa=0 sb=0 sd=0 mult=1 m=1
csn_op0_n100_neg_missing_wb_3 sn_op0_n100_neg_missing_wb_3 0 {C_SN}
XMN1_op0_n100_neg_missing_wb rbl_op0_n100_neg_missing_wb ref_op0_n100_neg_missing_wb vn_op0_n100_neg_missing_wb 0 sky130_fd_pr__nfet_01v8 L=0.15 W=1 nf=1 ad=0.29 as=0.29 pd=2.58 ps=2.58 mult=1 m=1
XMN2_op0_n100_neg_missing_wb ref_op0_n100_neg_missing_wb rbl_op0_n100_neg_missing_wb vn_op0_n100_neg_missing_wb 0 sky130_fd_pr__nfet_01v8 L=0.15 W=1 nf=1 ad=0.29 as=0.29 pd=2.58 ps=2.58 mult=1 m=1
XMP1_op0_n100_neg_missing_wb rbl_op0_n100_neg_missing_wb ref_op0_n100_neg_missing_wb vp_op0_n100_neg_missing_wb vdd sky130_fd_pr__pfet_01v8 L=0.15 W=2 nf=1 ad=0.58 as=0.58 pd=4.58 ps=4.58 mult=1 m=1
XMP2_op0_n100_neg_missing_wb ref_op0_n100_neg_missing_wb rbl_op0_n100_neg_missing_wb vp_op0_n100_neg_missing_wb vdd sky130_fd_pr__pfet_01v8 L=0.15 W=2 nf=1 ad=0.58 as=0.58 pd=4.58 ps=4.58 mult=1 m=1
XMNF_op0_n100_neg_missing_wb vn_op0_n100_neg_missing_wb en_op0_n100_neg_missing_wb 0 0 sky130_fd_pr__nfet_01v8 L=0.15 W=2 nf=1 ad=0.58 as=0.58 pd=4.58 ps=4.58 mult=1 m=1
XMPH_op0_n100_neg_missing_wb vp_op0_n100_neg_missing_wb enb_op0_n100_neg_missing_wb vdd vdd sky130_fd_pr__pfet_01v8 L=0.15 W=4 nf=1 ad=1.16 as=1.16 pd=8.58 ps=8.58 mult=1 m=1
bd_op0_n100_neg_missing_wb d_op0_n100_neg_missing_wb 0 v=v(rbl_op0_n100_neg_missing_wb)-v(ref_op0_n100_neg_missing_wb)

* ---- instance 15: op0_0000_neg_missing_wb (variant neg_missing_wb; probe dec 11.9 ns, release 34 ns, meas 36 ns) ----
vctl_op0_0000_neg_missing_wb ctl_op0_0000_neg_missing_wb 0 pwl(0.0000e+00 {VDD} 2.0000e-09 {VDD} 2.1000e-09 0)
vrs_op0_0000_neg_missing_wb rwls_op0_0000_neg_missing_wb 0 pwl(0.0000e+00 {VDD} 2.0000e-09 {VDD} 2.1000e-09 0 1.2000e-08 0 1.2100e-08 {VDD})
ven_op0_0000_neg_missing_wb en_op0_0000_neg_missing_wb 0 pwl(0.0000e+00 0 1.1000e-08 0 1.1100e-08 {VDD} 3.4000e-08 {VDD} 3.4100e-08 0)
venb_op0_0000_neg_missing_wb enb_op0_0000_neg_missing_wb 0 pwl(0.0000e+00 {VDD} 1.1000e-08 {VDD} 1.1100e-08 0 3.4000e-08 0 3.4100e-08 {VDD})
vww_op0_0000_neg_missing_wb wwl_op0_0000_neg_missing_wb 0 pwl(0.0000e+00 0)
vwc_op0_0000_neg_missing_wb wbc_op0_0000_neg_missing_wb 0 pwl(0.0000e+00 0)
swb_op0_0000_neg_missing_wb ref_op0_0000_neg_missing_wb wbl_op0_0000_neg_missing_wb wbc_op0_0000_neg_missing_wb 0 swwbl
cwbl_op0_0000_neg_missing_wb wbl_op0_0000_neg_missing_wb 0 {C_WBL}
spa_op0_0000_neg_missing_wb prea rbl_op0_0000_neg_missing_wb ctl_op0_0000_neg_missing_wb 0 swpre
spr_op0_0000_neg_missing_wb pref ref_op0_0000_neg_missing_wb ctl_op0_0000_neg_missing_wb 0 swpre
crbl_op0_0000_neg_missing_wb rbl_op0_0000_neg_missing_wb 0 {C_RBL}
cref_op0_0000_neg_missing_wb ref_op0_0000_neg_missing_wb 0 {C_RBL}   $ ASSUMPTION: ideal matched dummy load
XMWR_op0_0000_neg_missing_wb_0 sn_op0_0000_neg_missing_wb_0 wwl_op0_0000_neg_missing_wb wbl_op0_0000_neg_missing_wb 0 sky130_fd_pr__nfet_01v8 L=0.15 W=0.42 nf=1 ad=0.1218 as=0.1218 pd=1.42 ps=1.42 nrd=0.69047619047619  nrs=0.69047619047619 sa=0 sb=0 sd=0 mult=1 m=1
XMRD_op0_0000_neg_missing_wb_0 rbl_op0_0000_neg_missing_wb sn_op0_0000_neg_missing_wb_0 rwls_op0_0000_neg_missing_wb 0 sky130_fd_pr__nfet_01v8 L=0.15 W=0.42 nf=1 ad=0.1218 as=0.1218 pd=1.42 ps=1.42 nrd=0.69047619047619  nrs=0.69047619047619 sa=0 sb=0 sd=0 mult=1 m=1
csn_op0_0000_neg_missing_wb_0 sn_op0_0000_neg_missing_wb_0 0 {C_SN}
XMWR_op0_0000_neg_missing_wb_1 sn_op0_0000_neg_missing_wb_1 wwl_des wbl_op0_0000_neg_missing_wb 0 sky130_fd_pr__nfet_01v8 L=0.15 W=0.42 nf=1 ad=0.1218 as=0.1218 pd=1.42 ps=1.42 nrd=0.69047619047619  nrs=0.69047619047619 sa=0 sb=0 sd=0 mult=1 m=1
XMRD_op0_0000_neg_missing_wb_1 rbl_op0_0000_neg_missing_wb sn_op0_0000_neg_missing_wb_1 rwl_des 0 sky130_fd_pr__nfet_01v8 L=0.15 W=0.42 nf=1 ad=0.1218 as=0.1218 pd=1.42 ps=1.42 nrd=0.69047619047619  nrs=0.69047619047619 sa=0 sb=0 sd=0 mult=1 m=1
csn_op0_0000_neg_missing_wb_1 sn_op0_0000_neg_missing_wb_1 0 {C_SN}
XMWR_op0_0000_neg_missing_wb_2 sn_op0_0000_neg_missing_wb_2 wwl_des wbl_op0_0000_neg_missing_wb 0 sky130_fd_pr__nfet_01v8 L=0.15 W=0.42 nf=1 ad=0.1218 as=0.1218 pd=1.42 ps=1.42 nrd=0.69047619047619  nrs=0.69047619047619 sa=0 sb=0 sd=0 mult=1 m=1
XMRD_op0_0000_neg_missing_wb_2 rbl_op0_0000_neg_missing_wb sn_op0_0000_neg_missing_wb_2 rwl_des 0 sky130_fd_pr__nfet_01v8 L=0.15 W=0.42 nf=1 ad=0.1218 as=0.1218 pd=1.42 ps=1.42 nrd=0.69047619047619  nrs=0.69047619047619 sa=0 sb=0 sd=0 mult=1 m=1
csn_op0_0000_neg_missing_wb_2 sn_op0_0000_neg_missing_wb_2 0 {C_SN}
XMWR_op0_0000_neg_missing_wb_3 sn_op0_0000_neg_missing_wb_3 wwl_des wbl_op0_0000_neg_missing_wb 0 sky130_fd_pr__nfet_01v8 L=0.15 W=0.42 nf=1 ad=0.1218 as=0.1218 pd=1.42 ps=1.42 nrd=0.69047619047619  nrs=0.69047619047619 sa=0 sb=0 sd=0 mult=1 m=1
XMRD_op0_0000_neg_missing_wb_3 rbl_op0_0000_neg_missing_wb sn_op0_0000_neg_missing_wb_3 rwl_des 0 sky130_fd_pr__nfet_01v8 L=0.15 W=0.42 nf=1 ad=0.1218 as=0.1218 pd=1.42 ps=1.42 nrd=0.69047619047619  nrs=0.69047619047619 sa=0 sb=0 sd=0 mult=1 m=1
csn_op0_0000_neg_missing_wb_3 sn_op0_0000_neg_missing_wb_3 0 {C_SN}
XMN1_op0_0000_neg_missing_wb rbl_op0_0000_neg_missing_wb ref_op0_0000_neg_missing_wb vn_op0_0000_neg_missing_wb 0 sky130_fd_pr__nfet_01v8 L=0.15 W=1 nf=1 ad=0.29 as=0.29 pd=2.58 ps=2.58 mult=1 m=1
XMN2_op0_0000_neg_missing_wb ref_op0_0000_neg_missing_wb rbl_op0_0000_neg_missing_wb vn_op0_0000_neg_missing_wb 0 sky130_fd_pr__nfet_01v8 L=0.15 W=1 nf=1 ad=0.29 as=0.29 pd=2.58 ps=2.58 mult=1 m=1
XMP1_op0_0000_neg_missing_wb rbl_op0_0000_neg_missing_wb ref_op0_0000_neg_missing_wb vp_op0_0000_neg_missing_wb vdd sky130_fd_pr__pfet_01v8 L=0.15 W=2 nf=1 ad=0.58 as=0.58 pd=4.58 ps=4.58 mult=1 m=1
XMP2_op0_0000_neg_missing_wb ref_op0_0000_neg_missing_wb rbl_op0_0000_neg_missing_wb vp_op0_0000_neg_missing_wb vdd sky130_fd_pr__pfet_01v8 L=0.15 W=2 nf=1 ad=0.58 as=0.58 pd=4.58 ps=4.58 mult=1 m=1
XMNF_op0_0000_neg_missing_wb vn_op0_0000_neg_missing_wb en_op0_0000_neg_missing_wb 0 0 sky130_fd_pr__nfet_01v8 L=0.15 W=2 nf=1 ad=0.58 as=0.58 pd=4.58 ps=4.58 mult=1 m=1
XMPH_op0_0000_neg_missing_wb vp_op0_0000_neg_missing_wb enb_op0_0000_neg_missing_wb vdd vdd sky130_fd_pr__pfet_01v8 L=0.15 W=4 nf=1 ad=1.16 as=1.16 pd=8.58 ps=8.58 mult=1 m=1
bd_op0_0000_neg_missing_wb d_op0_0000_neg_missing_wb 0 v=v(rbl_op0_0000_neg_missing_wb)-v(ref_op0_0000_neg_missing_wb)

* ---- instance 16: op1_0900_pic_baseline_analog (variant pic_baseline_analog; probe dec 14.9 ns, release 37 ns, meas 39 ns) ----
vctl_op1_0900_pic_baseline_analog ctl_op1_0900_pic_baseline_analog 0 pwl(0.0000e+00 {VDD} 2.0000e-09 {VDD} 2.1000e-09 0)
vrs_op1_0900_pic_baseline_analog rwls_op1_0900_pic_baseline_analog 0 pwl(0.0000e+00 {VDD} 4.0000e-09 {VDD} 4.1000e-09 0 3.7000e-08 0 3.7100e-08 {VDD})
ven_op1_0900_pic_baseline_analog en_op1_0900_pic_baseline_analog 0 pwl(0.0000e+00 0 1.4000e-08 0 1.4100e-08 {VDD} 3.7000e-08 {VDD} 3.7100e-08 0)
venb_op1_0900_pic_baseline_analog enb_op1_0900_pic_baseline_analog 0 pwl(0.0000e+00 {VDD} 1.4000e-08 {VDD} 1.4100e-08 0 3.7000e-08 0 3.7100e-08 {VDD})
vww_op1_0900_pic_baseline_analog wwl_op1_0900_pic_baseline_analog 0 pwl(0.0000e+00 0 1.5000e-08 0 1.5100e-08 {VDD} 3.5000e-08 {VDD} 3.5100e-08 0)
vwc_op1_0900_pic_baseline_analog wbc_op1_0900_pic_baseline_analog 0 pwl(0.0000e+00 0 1.5000e-08 0 1.5100e-08 {VDD} 3.7000e-08 {VDD} 3.7100e-08 0)
swb_op1_0900_pic_baseline_analog ref_op1_0900_pic_baseline_analog wbl_op1_0900_pic_baseline_analog wbc_op1_0900_pic_baseline_analog 0 swwbl
cwbl_op1_0900_pic_baseline_analog wbl_op1_0900_pic_baseline_analog 0 {C_WBL}
spa_op1_0900_pic_baseline_analog prea rbl_op1_0900_pic_baseline_analog ctl_op1_0900_pic_baseline_analog 0 swpre
spr_op1_0900_pic_baseline_analog pref ref_op1_0900_pic_baseline_analog ctl_op1_0900_pic_baseline_analog 0 swpre
crbl_op1_0900_pic_baseline_analog rbl_op1_0900_pic_baseline_analog 0 {C_RBL}
cref_op1_0900_pic_baseline_analog ref_op1_0900_pic_baseline_analog 0 {C_RBL}   $ ASSUMPTION: ideal matched dummy load
XMWR_op1_0900_pic_baseline_analog_0 sn_op1_0900_pic_baseline_analog_0 wwl_op1_0900_pic_baseline_analog wbl_op1_0900_pic_baseline_analog 0 sky130_fd_pr__nfet_01v8 L=0.15 W=0.42 nf=1 ad=0.1218 as=0.1218 pd=1.42 ps=1.42 nrd=0.69047619047619  nrs=0.69047619047619 sa=0 sb=0 sd=0 mult=1 m=1
XMRD_op1_0900_pic_baseline_analog_0 rbl_op1_0900_pic_baseline_analog sn_op1_0900_pic_baseline_analog_0 rwls_op1_0900_pic_baseline_analog 0 sky130_fd_pr__nfet_01v8 L=0.15 W=0.42 nf=1 ad=0.1218 as=0.1218 pd=1.42 ps=1.42 nrd=0.69047619047619  nrs=0.69047619047619 sa=0 sb=0 sd=0 mult=1 m=1
csn_op1_0900_pic_baseline_analog_0 sn_op1_0900_pic_baseline_analog_0 0 {C_SN}
XMWR_op1_0900_pic_baseline_analog_1 sn_op1_0900_pic_baseline_analog_1 wwl_des wbl_op1_0900_pic_baseline_analog 0 sky130_fd_pr__nfet_01v8 L=0.15 W=0.42 nf=1 ad=0.1218 as=0.1218 pd=1.42 ps=1.42 nrd=0.69047619047619  nrs=0.69047619047619 sa=0 sb=0 sd=0 mult=1 m=1
XMRD_op1_0900_pic_baseline_analog_1 rbl_op1_0900_pic_baseline_analog sn_op1_0900_pic_baseline_analog_1 rwl_des 0 sky130_fd_pr__nfet_01v8 L=0.15 W=0.42 nf=1 ad=0.1218 as=0.1218 pd=1.42 ps=1.42 nrd=0.69047619047619  nrs=0.69047619047619 sa=0 sb=0 sd=0 mult=1 m=1
csn_op1_0900_pic_baseline_analog_1 sn_op1_0900_pic_baseline_analog_1 0 {C_SN}
XMWR_op1_0900_pic_baseline_analog_2 sn_op1_0900_pic_baseline_analog_2 wwl_des wbl_op1_0900_pic_baseline_analog 0 sky130_fd_pr__nfet_01v8 L=0.15 W=0.42 nf=1 ad=0.1218 as=0.1218 pd=1.42 ps=1.42 nrd=0.69047619047619  nrs=0.69047619047619 sa=0 sb=0 sd=0 mult=1 m=1
XMRD_op1_0900_pic_baseline_analog_2 rbl_op1_0900_pic_baseline_analog sn_op1_0900_pic_baseline_analog_2 rwl_des 0 sky130_fd_pr__nfet_01v8 L=0.15 W=0.42 nf=1 ad=0.1218 as=0.1218 pd=1.42 ps=1.42 nrd=0.69047619047619  nrs=0.69047619047619 sa=0 sb=0 sd=0 mult=1 m=1
csn_op1_0900_pic_baseline_analog_2 sn_op1_0900_pic_baseline_analog_2 0 {C_SN}
XMWR_op1_0900_pic_baseline_analog_3 sn_op1_0900_pic_baseline_analog_3 wwl_des wbl_op1_0900_pic_baseline_analog 0 sky130_fd_pr__nfet_01v8 L=0.15 W=0.42 nf=1 ad=0.1218 as=0.1218 pd=1.42 ps=1.42 nrd=0.69047619047619  nrs=0.69047619047619 sa=0 sb=0 sd=0 mult=1 m=1
XMRD_op1_0900_pic_baseline_analog_3 rbl_op1_0900_pic_baseline_analog sn_op1_0900_pic_baseline_analog_3 rwl_des 0 sky130_fd_pr__nfet_01v8 L=0.15 W=0.42 nf=1 ad=0.1218 as=0.1218 pd=1.42 ps=1.42 nrd=0.69047619047619  nrs=0.69047619047619 sa=0 sb=0 sd=0 mult=1 m=1
csn_op1_0900_pic_baseline_analog_3 sn_op1_0900_pic_baseline_analog_3 0 {C_SN}
XMN1_op1_0900_pic_baseline_analog rbl_op1_0900_pic_baseline_analog ref_op1_0900_pic_baseline_analog vn_op1_0900_pic_baseline_analog 0 sky130_fd_pr__nfet_01v8 L=0.15 W=1 nf=1 ad=0.29 as=0.29 pd=2.58 ps=2.58 mult=1 m=1
XMN2_op1_0900_pic_baseline_analog ref_op1_0900_pic_baseline_analog rbl_op1_0900_pic_baseline_analog vn_op1_0900_pic_baseline_analog 0 sky130_fd_pr__nfet_01v8 L=0.15 W=1 nf=1 ad=0.29 as=0.29 pd=2.58 ps=2.58 mult=1 m=1
XMP1_op1_0900_pic_baseline_analog rbl_op1_0900_pic_baseline_analog ref_op1_0900_pic_baseline_analog vp_op1_0900_pic_baseline_analog vdd sky130_fd_pr__pfet_01v8 L=0.15 W=2 nf=1 ad=0.58 as=0.58 pd=4.58 ps=4.58 mult=1 m=1
XMP2_op1_0900_pic_baseline_analog ref_op1_0900_pic_baseline_analog rbl_op1_0900_pic_baseline_analog vp_op1_0900_pic_baseline_analog vdd sky130_fd_pr__pfet_01v8 L=0.15 W=2 nf=1 ad=0.58 as=0.58 pd=4.58 ps=4.58 mult=1 m=1
XMNF_op1_0900_pic_baseline_analog vn_op1_0900_pic_baseline_analog en_op1_0900_pic_baseline_analog 0 0 sky130_fd_pr__nfet_01v8 L=0.15 W=2 nf=1 ad=0.58 as=0.58 pd=4.58 ps=4.58 mult=1 m=1
XMPH_op1_0900_pic_baseline_analog vp_op1_0900_pic_baseline_analog enb_op1_0900_pic_baseline_analog vdd vdd sky130_fd_pr__pfet_01v8 L=0.15 W=4 nf=1 ad=1.16 as=1.16 pd=8.58 ps=8.58 mult=1 m=1
bd_op1_0900_pic_baseline_analog d_op1_0900_pic_baseline_analog 0 v=v(rbl_op1_0900_pic_baseline_analog)-v(ref_op1_0900_pic_baseline_analog)

* ---- instance 17: op1_1000_pic_baseline_analog (variant pic_baseline_analog; probe dec 14.9 ns, release 37 ns, meas 39 ns) ----
vctl_op1_1000_pic_baseline_analog ctl_op1_1000_pic_baseline_analog 0 pwl(0.0000e+00 {VDD} 2.0000e-09 {VDD} 2.1000e-09 0)
vrs_op1_1000_pic_baseline_analog rwls_op1_1000_pic_baseline_analog 0 pwl(0.0000e+00 {VDD} 4.0000e-09 {VDD} 4.1000e-09 0 3.7000e-08 0 3.7100e-08 {VDD})
ven_op1_1000_pic_baseline_analog en_op1_1000_pic_baseline_analog 0 pwl(0.0000e+00 0 1.4000e-08 0 1.4100e-08 {VDD} 3.7000e-08 {VDD} 3.7100e-08 0)
venb_op1_1000_pic_baseline_analog enb_op1_1000_pic_baseline_analog 0 pwl(0.0000e+00 {VDD} 1.4000e-08 {VDD} 1.4100e-08 0 3.7000e-08 0 3.7100e-08 {VDD})
vww_op1_1000_pic_baseline_analog wwl_op1_1000_pic_baseline_analog 0 pwl(0.0000e+00 0 1.5000e-08 0 1.5100e-08 {VDD} 3.5000e-08 {VDD} 3.5100e-08 0)
vwc_op1_1000_pic_baseline_analog wbc_op1_1000_pic_baseline_analog 0 pwl(0.0000e+00 0 1.5000e-08 0 1.5100e-08 {VDD} 3.7000e-08 {VDD} 3.7100e-08 0)
swb_op1_1000_pic_baseline_analog ref_op1_1000_pic_baseline_analog wbl_op1_1000_pic_baseline_analog wbc_op1_1000_pic_baseline_analog 0 swwbl
cwbl_op1_1000_pic_baseline_analog wbl_op1_1000_pic_baseline_analog 0 {C_WBL}
spa_op1_1000_pic_baseline_analog prea rbl_op1_1000_pic_baseline_analog ctl_op1_1000_pic_baseline_analog 0 swpre
spr_op1_1000_pic_baseline_analog pref ref_op1_1000_pic_baseline_analog ctl_op1_1000_pic_baseline_analog 0 swpre
crbl_op1_1000_pic_baseline_analog rbl_op1_1000_pic_baseline_analog 0 {C_RBL}
cref_op1_1000_pic_baseline_analog ref_op1_1000_pic_baseline_analog 0 {C_RBL}   $ ASSUMPTION: ideal matched dummy load
XMWR_op1_1000_pic_baseline_analog_0 sn_op1_1000_pic_baseline_analog_0 wwl_op1_1000_pic_baseline_analog wbl_op1_1000_pic_baseline_analog 0 sky130_fd_pr__nfet_01v8 L=0.15 W=0.42 nf=1 ad=0.1218 as=0.1218 pd=1.42 ps=1.42 nrd=0.69047619047619  nrs=0.69047619047619 sa=0 sb=0 sd=0 mult=1 m=1
XMRD_op1_1000_pic_baseline_analog_0 rbl_op1_1000_pic_baseline_analog sn_op1_1000_pic_baseline_analog_0 rwls_op1_1000_pic_baseline_analog 0 sky130_fd_pr__nfet_01v8 L=0.15 W=0.42 nf=1 ad=0.1218 as=0.1218 pd=1.42 ps=1.42 nrd=0.69047619047619  nrs=0.69047619047619 sa=0 sb=0 sd=0 mult=1 m=1
csn_op1_1000_pic_baseline_analog_0 sn_op1_1000_pic_baseline_analog_0 0 {C_SN}
XMWR_op1_1000_pic_baseline_analog_1 sn_op1_1000_pic_baseline_analog_1 wwl_des wbl_op1_1000_pic_baseline_analog 0 sky130_fd_pr__nfet_01v8 L=0.15 W=0.42 nf=1 ad=0.1218 as=0.1218 pd=1.42 ps=1.42 nrd=0.69047619047619  nrs=0.69047619047619 sa=0 sb=0 sd=0 mult=1 m=1
XMRD_op1_1000_pic_baseline_analog_1 rbl_op1_1000_pic_baseline_analog sn_op1_1000_pic_baseline_analog_1 rwl_des 0 sky130_fd_pr__nfet_01v8 L=0.15 W=0.42 nf=1 ad=0.1218 as=0.1218 pd=1.42 ps=1.42 nrd=0.69047619047619  nrs=0.69047619047619 sa=0 sb=0 sd=0 mult=1 m=1
csn_op1_1000_pic_baseline_analog_1 sn_op1_1000_pic_baseline_analog_1 0 {C_SN}
XMWR_op1_1000_pic_baseline_analog_2 sn_op1_1000_pic_baseline_analog_2 wwl_des wbl_op1_1000_pic_baseline_analog 0 sky130_fd_pr__nfet_01v8 L=0.15 W=0.42 nf=1 ad=0.1218 as=0.1218 pd=1.42 ps=1.42 nrd=0.69047619047619  nrs=0.69047619047619 sa=0 sb=0 sd=0 mult=1 m=1
XMRD_op1_1000_pic_baseline_analog_2 rbl_op1_1000_pic_baseline_analog sn_op1_1000_pic_baseline_analog_2 rwl_des 0 sky130_fd_pr__nfet_01v8 L=0.15 W=0.42 nf=1 ad=0.1218 as=0.1218 pd=1.42 ps=1.42 nrd=0.69047619047619  nrs=0.69047619047619 sa=0 sb=0 sd=0 mult=1 m=1
csn_op1_1000_pic_baseline_analog_2 sn_op1_1000_pic_baseline_analog_2 0 {C_SN}
XMWR_op1_1000_pic_baseline_analog_3 sn_op1_1000_pic_baseline_analog_3 wwl_des wbl_op1_1000_pic_baseline_analog 0 sky130_fd_pr__nfet_01v8 L=0.15 W=0.42 nf=1 ad=0.1218 as=0.1218 pd=1.42 ps=1.42 nrd=0.69047619047619  nrs=0.69047619047619 sa=0 sb=0 sd=0 mult=1 m=1
XMRD_op1_1000_pic_baseline_analog_3 rbl_op1_1000_pic_baseline_analog sn_op1_1000_pic_baseline_analog_3 rwl_des 0 sky130_fd_pr__nfet_01v8 L=0.15 W=0.42 nf=1 ad=0.1218 as=0.1218 pd=1.42 ps=1.42 nrd=0.69047619047619  nrs=0.69047619047619 sa=0 sb=0 sd=0 mult=1 m=1
csn_op1_1000_pic_baseline_analog_3 sn_op1_1000_pic_baseline_analog_3 0 {C_SN}
XMN1_op1_1000_pic_baseline_analog rbl_op1_1000_pic_baseline_analog ref_op1_1000_pic_baseline_analog vn_op1_1000_pic_baseline_analog 0 sky130_fd_pr__nfet_01v8 L=0.15 W=1 nf=1 ad=0.29 as=0.29 pd=2.58 ps=2.58 mult=1 m=1
XMN2_op1_1000_pic_baseline_analog ref_op1_1000_pic_baseline_analog rbl_op1_1000_pic_baseline_analog vn_op1_1000_pic_baseline_analog 0 sky130_fd_pr__nfet_01v8 L=0.15 W=1 nf=1 ad=0.29 as=0.29 pd=2.58 ps=2.58 mult=1 m=1
XMP1_op1_1000_pic_baseline_analog rbl_op1_1000_pic_baseline_analog ref_op1_1000_pic_baseline_analog vp_op1_1000_pic_baseline_analog vdd sky130_fd_pr__pfet_01v8 L=0.15 W=2 nf=1 ad=0.58 as=0.58 pd=4.58 ps=4.58 mult=1 m=1
XMP2_op1_1000_pic_baseline_analog ref_op1_1000_pic_baseline_analog rbl_op1_1000_pic_baseline_analog vp_op1_1000_pic_baseline_analog vdd sky130_fd_pr__pfet_01v8 L=0.15 W=2 nf=1 ad=0.58 as=0.58 pd=4.58 ps=4.58 mult=1 m=1
XMNF_op1_1000_pic_baseline_analog vn_op1_1000_pic_baseline_analog en_op1_1000_pic_baseline_analog 0 0 sky130_fd_pr__nfet_01v8 L=0.15 W=2 nf=1 ad=0.58 as=0.58 pd=4.58 ps=4.58 mult=1 m=1
XMPH_op1_1000_pic_baseline_analog vp_op1_1000_pic_baseline_analog enb_op1_1000_pic_baseline_analog vdd vdd sky130_fd_pr__pfet_01v8 L=0.15 W=4 nf=1 ad=1.16 as=1.16 pd=8.58 ps=8.58 mult=1 m=1
bd_op1_1000_pic_baseline_analog d_op1_1000_pic_baseline_analog 0 v=v(rbl_op1_1000_pic_baseline_analog)-v(ref_op1_1000_pic_baseline_analog)

* ---- instance 18: op0_n100_pic_baseline_analog (variant pic_baseline_analog; probe dec 14.9 ns, release 37 ns, meas 39 ns) ----
vctl_op0_n100_pic_baseline_analog ctl_op0_n100_pic_baseline_analog 0 pwl(0.0000e+00 {VDD} 2.0000e-09 {VDD} 2.1000e-09 0)
vrs_op0_n100_pic_baseline_analog rwls_op0_n100_pic_baseline_analog 0 pwl(0.0000e+00 {VDD} 4.0000e-09 {VDD} 4.1000e-09 0 3.7000e-08 0 3.7100e-08 {VDD})
ven_op0_n100_pic_baseline_analog en_op0_n100_pic_baseline_analog 0 pwl(0.0000e+00 0 1.4000e-08 0 1.4100e-08 {VDD} 3.7000e-08 {VDD} 3.7100e-08 0)
venb_op0_n100_pic_baseline_analog enb_op0_n100_pic_baseline_analog 0 pwl(0.0000e+00 {VDD} 1.4000e-08 {VDD} 1.4100e-08 0 3.7000e-08 0 3.7100e-08 {VDD})
vww_op0_n100_pic_baseline_analog wwl_op0_n100_pic_baseline_analog 0 pwl(0.0000e+00 0 1.5000e-08 0 1.5100e-08 {VDD} 3.5000e-08 {VDD} 3.5100e-08 0)
vwc_op0_n100_pic_baseline_analog wbc_op0_n100_pic_baseline_analog 0 pwl(0.0000e+00 0 1.5000e-08 0 1.5100e-08 {VDD} 3.7000e-08 {VDD} 3.7100e-08 0)
swb_op0_n100_pic_baseline_analog ref_op0_n100_pic_baseline_analog wbl_op0_n100_pic_baseline_analog wbc_op0_n100_pic_baseline_analog 0 swwbl
cwbl_op0_n100_pic_baseline_analog wbl_op0_n100_pic_baseline_analog 0 {C_WBL}
spa_op0_n100_pic_baseline_analog prea rbl_op0_n100_pic_baseline_analog ctl_op0_n100_pic_baseline_analog 0 swpre
spr_op0_n100_pic_baseline_analog pref ref_op0_n100_pic_baseline_analog ctl_op0_n100_pic_baseline_analog 0 swpre
crbl_op0_n100_pic_baseline_analog rbl_op0_n100_pic_baseline_analog 0 {C_RBL}
cref_op0_n100_pic_baseline_analog ref_op0_n100_pic_baseline_analog 0 {C_RBL}   $ ASSUMPTION: ideal matched dummy load
XMWR_op0_n100_pic_baseline_analog_0 sn_op0_n100_pic_baseline_analog_0 wwl_op0_n100_pic_baseline_analog wbl_op0_n100_pic_baseline_analog 0 sky130_fd_pr__nfet_01v8 L=0.15 W=0.42 nf=1 ad=0.1218 as=0.1218 pd=1.42 ps=1.42 nrd=0.69047619047619  nrs=0.69047619047619 sa=0 sb=0 sd=0 mult=1 m=1
XMRD_op0_n100_pic_baseline_analog_0 rbl_op0_n100_pic_baseline_analog sn_op0_n100_pic_baseline_analog_0 rwls_op0_n100_pic_baseline_analog 0 sky130_fd_pr__nfet_01v8 L=0.15 W=0.42 nf=1 ad=0.1218 as=0.1218 pd=1.42 ps=1.42 nrd=0.69047619047619  nrs=0.69047619047619 sa=0 sb=0 sd=0 mult=1 m=1
csn_op0_n100_pic_baseline_analog_0 sn_op0_n100_pic_baseline_analog_0 0 {C_SN}
XMWR_op0_n100_pic_baseline_analog_1 sn_op0_n100_pic_baseline_analog_1 wwl_des wbl_op0_n100_pic_baseline_analog 0 sky130_fd_pr__nfet_01v8 L=0.15 W=0.42 nf=1 ad=0.1218 as=0.1218 pd=1.42 ps=1.42 nrd=0.69047619047619  nrs=0.69047619047619 sa=0 sb=0 sd=0 mult=1 m=1
XMRD_op0_n100_pic_baseline_analog_1 rbl_op0_n100_pic_baseline_analog sn_op0_n100_pic_baseline_analog_1 rwl_des 0 sky130_fd_pr__nfet_01v8 L=0.15 W=0.42 nf=1 ad=0.1218 as=0.1218 pd=1.42 ps=1.42 nrd=0.69047619047619  nrs=0.69047619047619 sa=0 sb=0 sd=0 mult=1 m=1
csn_op0_n100_pic_baseline_analog_1 sn_op0_n100_pic_baseline_analog_1 0 {C_SN}
XMWR_op0_n100_pic_baseline_analog_2 sn_op0_n100_pic_baseline_analog_2 wwl_des wbl_op0_n100_pic_baseline_analog 0 sky130_fd_pr__nfet_01v8 L=0.15 W=0.42 nf=1 ad=0.1218 as=0.1218 pd=1.42 ps=1.42 nrd=0.69047619047619  nrs=0.69047619047619 sa=0 sb=0 sd=0 mult=1 m=1
XMRD_op0_n100_pic_baseline_analog_2 rbl_op0_n100_pic_baseline_analog sn_op0_n100_pic_baseline_analog_2 rwl_des 0 sky130_fd_pr__nfet_01v8 L=0.15 W=0.42 nf=1 ad=0.1218 as=0.1218 pd=1.42 ps=1.42 nrd=0.69047619047619  nrs=0.69047619047619 sa=0 sb=0 sd=0 mult=1 m=1
csn_op0_n100_pic_baseline_analog_2 sn_op0_n100_pic_baseline_analog_2 0 {C_SN}
XMWR_op0_n100_pic_baseline_analog_3 sn_op0_n100_pic_baseline_analog_3 wwl_des wbl_op0_n100_pic_baseline_analog 0 sky130_fd_pr__nfet_01v8 L=0.15 W=0.42 nf=1 ad=0.1218 as=0.1218 pd=1.42 ps=1.42 nrd=0.69047619047619  nrs=0.69047619047619 sa=0 sb=0 sd=0 mult=1 m=1
XMRD_op0_n100_pic_baseline_analog_3 rbl_op0_n100_pic_baseline_analog sn_op0_n100_pic_baseline_analog_3 rwl_des 0 sky130_fd_pr__nfet_01v8 L=0.15 W=0.42 nf=1 ad=0.1218 as=0.1218 pd=1.42 ps=1.42 nrd=0.69047619047619  nrs=0.69047619047619 sa=0 sb=0 sd=0 mult=1 m=1
csn_op0_n100_pic_baseline_analog_3 sn_op0_n100_pic_baseline_analog_3 0 {C_SN}
XMN1_op0_n100_pic_baseline_analog rbl_op0_n100_pic_baseline_analog ref_op0_n100_pic_baseline_analog vn_op0_n100_pic_baseline_analog 0 sky130_fd_pr__nfet_01v8 L=0.15 W=1 nf=1 ad=0.29 as=0.29 pd=2.58 ps=2.58 mult=1 m=1
XMN2_op0_n100_pic_baseline_analog ref_op0_n100_pic_baseline_analog rbl_op0_n100_pic_baseline_analog vn_op0_n100_pic_baseline_analog 0 sky130_fd_pr__nfet_01v8 L=0.15 W=1 nf=1 ad=0.29 as=0.29 pd=2.58 ps=2.58 mult=1 m=1
XMP1_op0_n100_pic_baseline_analog rbl_op0_n100_pic_baseline_analog ref_op0_n100_pic_baseline_analog vp_op0_n100_pic_baseline_analog vdd sky130_fd_pr__pfet_01v8 L=0.15 W=2 nf=1 ad=0.58 as=0.58 pd=4.58 ps=4.58 mult=1 m=1
XMP2_op0_n100_pic_baseline_analog ref_op0_n100_pic_baseline_analog rbl_op0_n100_pic_baseline_analog vp_op0_n100_pic_baseline_analog vdd sky130_fd_pr__pfet_01v8 L=0.15 W=2 nf=1 ad=0.58 as=0.58 pd=4.58 ps=4.58 mult=1 m=1
XMNF_op0_n100_pic_baseline_analog vn_op0_n100_pic_baseline_analog en_op0_n100_pic_baseline_analog 0 0 sky130_fd_pr__nfet_01v8 L=0.15 W=2 nf=1 ad=0.58 as=0.58 pd=4.58 ps=4.58 mult=1 m=1
XMPH_op0_n100_pic_baseline_analog vp_op0_n100_pic_baseline_analog enb_op0_n100_pic_baseline_analog vdd vdd sky130_fd_pr__pfet_01v8 L=0.15 W=4 nf=1 ad=1.16 as=1.16 pd=8.58 ps=8.58 mult=1 m=1
bd_op0_n100_pic_baseline_analog d_op0_n100_pic_baseline_analog 0 v=v(rbl_op0_n100_pic_baseline_analog)-v(ref_op0_n100_pic_baseline_analog)

* ---- instance 19: op0_0000_pic_baseline_analog (variant pic_baseline_analog; probe dec 14.9 ns, release 37 ns, meas 39 ns) ----
vctl_op0_0000_pic_baseline_analog ctl_op0_0000_pic_baseline_analog 0 pwl(0.0000e+00 {VDD} 2.0000e-09 {VDD} 2.1000e-09 0)
vrs_op0_0000_pic_baseline_analog rwls_op0_0000_pic_baseline_analog 0 pwl(0.0000e+00 {VDD} 4.0000e-09 {VDD} 4.1000e-09 0 3.7000e-08 0 3.7100e-08 {VDD})
ven_op0_0000_pic_baseline_analog en_op0_0000_pic_baseline_analog 0 pwl(0.0000e+00 0 1.4000e-08 0 1.4100e-08 {VDD} 3.7000e-08 {VDD} 3.7100e-08 0)
venb_op0_0000_pic_baseline_analog enb_op0_0000_pic_baseline_analog 0 pwl(0.0000e+00 {VDD} 1.4000e-08 {VDD} 1.4100e-08 0 3.7000e-08 0 3.7100e-08 {VDD})
vww_op0_0000_pic_baseline_analog wwl_op0_0000_pic_baseline_analog 0 pwl(0.0000e+00 0 1.5000e-08 0 1.5100e-08 {VDD} 3.5000e-08 {VDD} 3.5100e-08 0)
vwc_op0_0000_pic_baseline_analog wbc_op0_0000_pic_baseline_analog 0 pwl(0.0000e+00 0 1.5000e-08 0 1.5100e-08 {VDD} 3.7000e-08 {VDD} 3.7100e-08 0)
swb_op0_0000_pic_baseline_analog ref_op0_0000_pic_baseline_analog wbl_op0_0000_pic_baseline_analog wbc_op0_0000_pic_baseline_analog 0 swwbl
cwbl_op0_0000_pic_baseline_analog wbl_op0_0000_pic_baseline_analog 0 {C_WBL}
spa_op0_0000_pic_baseline_analog prea rbl_op0_0000_pic_baseline_analog ctl_op0_0000_pic_baseline_analog 0 swpre
spr_op0_0000_pic_baseline_analog pref ref_op0_0000_pic_baseline_analog ctl_op0_0000_pic_baseline_analog 0 swpre
crbl_op0_0000_pic_baseline_analog rbl_op0_0000_pic_baseline_analog 0 {C_RBL}
cref_op0_0000_pic_baseline_analog ref_op0_0000_pic_baseline_analog 0 {C_RBL}   $ ASSUMPTION: ideal matched dummy load
XMWR_op0_0000_pic_baseline_analog_0 sn_op0_0000_pic_baseline_analog_0 wwl_op0_0000_pic_baseline_analog wbl_op0_0000_pic_baseline_analog 0 sky130_fd_pr__nfet_01v8 L=0.15 W=0.42 nf=1 ad=0.1218 as=0.1218 pd=1.42 ps=1.42 nrd=0.69047619047619  nrs=0.69047619047619 sa=0 sb=0 sd=0 mult=1 m=1
XMRD_op0_0000_pic_baseline_analog_0 rbl_op0_0000_pic_baseline_analog sn_op0_0000_pic_baseline_analog_0 rwls_op0_0000_pic_baseline_analog 0 sky130_fd_pr__nfet_01v8 L=0.15 W=0.42 nf=1 ad=0.1218 as=0.1218 pd=1.42 ps=1.42 nrd=0.69047619047619  nrs=0.69047619047619 sa=0 sb=0 sd=0 mult=1 m=1
csn_op0_0000_pic_baseline_analog_0 sn_op0_0000_pic_baseline_analog_0 0 {C_SN}
XMWR_op0_0000_pic_baseline_analog_1 sn_op0_0000_pic_baseline_analog_1 wwl_des wbl_op0_0000_pic_baseline_analog 0 sky130_fd_pr__nfet_01v8 L=0.15 W=0.42 nf=1 ad=0.1218 as=0.1218 pd=1.42 ps=1.42 nrd=0.69047619047619  nrs=0.69047619047619 sa=0 sb=0 sd=0 mult=1 m=1
XMRD_op0_0000_pic_baseline_analog_1 rbl_op0_0000_pic_baseline_analog sn_op0_0000_pic_baseline_analog_1 rwl_des 0 sky130_fd_pr__nfet_01v8 L=0.15 W=0.42 nf=1 ad=0.1218 as=0.1218 pd=1.42 ps=1.42 nrd=0.69047619047619  nrs=0.69047619047619 sa=0 sb=0 sd=0 mult=1 m=1
csn_op0_0000_pic_baseline_analog_1 sn_op0_0000_pic_baseline_analog_1 0 {C_SN}
XMWR_op0_0000_pic_baseline_analog_2 sn_op0_0000_pic_baseline_analog_2 wwl_des wbl_op0_0000_pic_baseline_analog 0 sky130_fd_pr__nfet_01v8 L=0.15 W=0.42 nf=1 ad=0.1218 as=0.1218 pd=1.42 ps=1.42 nrd=0.69047619047619  nrs=0.69047619047619 sa=0 sb=0 sd=0 mult=1 m=1
XMRD_op0_0000_pic_baseline_analog_2 rbl_op0_0000_pic_baseline_analog sn_op0_0000_pic_baseline_analog_2 rwl_des 0 sky130_fd_pr__nfet_01v8 L=0.15 W=0.42 nf=1 ad=0.1218 as=0.1218 pd=1.42 ps=1.42 nrd=0.69047619047619  nrs=0.69047619047619 sa=0 sb=0 sd=0 mult=1 m=1
csn_op0_0000_pic_baseline_analog_2 sn_op0_0000_pic_baseline_analog_2 0 {C_SN}
XMWR_op0_0000_pic_baseline_analog_3 sn_op0_0000_pic_baseline_analog_3 wwl_des wbl_op0_0000_pic_baseline_analog 0 sky130_fd_pr__nfet_01v8 L=0.15 W=0.42 nf=1 ad=0.1218 as=0.1218 pd=1.42 ps=1.42 nrd=0.69047619047619  nrs=0.69047619047619 sa=0 sb=0 sd=0 mult=1 m=1
XMRD_op0_0000_pic_baseline_analog_3 rbl_op0_0000_pic_baseline_analog sn_op0_0000_pic_baseline_analog_3 rwl_des 0 sky130_fd_pr__nfet_01v8 L=0.15 W=0.42 nf=1 ad=0.1218 as=0.1218 pd=1.42 ps=1.42 nrd=0.69047619047619  nrs=0.69047619047619 sa=0 sb=0 sd=0 mult=1 m=1
csn_op0_0000_pic_baseline_analog_3 sn_op0_0000_pic_baseline_analog_3 0 {C_SN}
XMN1_op0_0000_pic_baseline_analog rbl_op0_0000_pic_baseline_analog ref_op0_0000_pic_baseline_analog vn_op0_0000_pic_baseline_analog 0 sky130_fd_pr__nfet_01v8 L=0.15 W=1 nf=1 ad=0.29 as=0.29 pd=2.58 ps=2.58 mult=1 m=1
XMN2_op0_0000_pic_baseline_analog ref_op0_0000_pic_baseline_analog rbl_op0_0000_pic_baseline_analog vn_op0_0000_pic_baseline_analog 0 sky130_fd_pr__nfet_01v8 L=0.15 W=1 nf=1 ad=0.29 as=0.29 pd=2.58 ps=2.58 mult=1 m=1
XMP1_op0_0000_pic_baseline_analog rbl_op0_0000_pic_baseline_analog ref_op0_0000_pic_baseline_analog vp_op0_0000_pic_baseline_analog vdd sky130_fd_pr__pfet_01v8 L=0.15 W=2 nf=1 ad=0.58 as=0.58 pd=4.58 ps=4.58 mult=1 m=1
XMP2_op0_0000_pic_baseline_analog ref_op0_0000_pic_baseline_analog rbl_op0_0000_pic_baseline_analog vp_op0_0000_pic_baseline_analog vdd sky130_fd_pr__pfet_01v8 L=0.15 W=2 nf=1 ad=0.58 as=0.58 pd=4.58 ps=4.58 mult=1 m=1
XMNF_op0_0000_pic_baseline_analog vn_op0_0000_pic_baseline_analog en_op0_0000_pic_baseline_analog 0 0 sky130_fd_pr__nfet_01v8 L=0.15 W=2 nf=1 ad=0.58 as=0.58 pd=4.58 ps=4.58 mult=1 m=1
XMPH_op0_0000_pic_baseline_analog vp_op0_0000_pic_baseline_analog enb_op0_0000_pic_baseline_analog vdd vdd sky130_fd_pr__pfet_01v8 L=0.15 W=4 nf=1 ad=1.16 as=1.16 pd=8.58 ps=8.58 mult=1 m=1
bd_op0_0000_pic_baseline_analog d_op0_0000_pic_baseline_analog 0 v=v(rbl_op0_0000_pic_baseline_analog)-v(ref_op0_0000_pic_baseline_analog)

* ---- instance 20: op1_0900_pic_rtl_hold (variant pic_rtl_hold; probe dec 11.9 ns, release 34 ns, meas 36 ns) ----
vctl_op1_0900_pic_rtl_hold ctl_op1_0900_pic_rtl_hold 0 pwl(0.0000e+00 {VDD} 2.0000e-09 {VDD} 2.1000e-09 0)
vrs_op1_0900_pic_rtl_hold rwls_op1_0900_pic_rtl_hold 0 pwl(0.0000e+00 {VDD} 2.0000e-09 {VDD} 2.1000e-09 0 1.2000e-08 0 1.2100e-08 {VDD})
ven_op1_0900_pic_rtl_hold en_op1_0900_pic_rtl_hold 0 pwl(0.0000e+00 0 1.1000e-08 0 1.1100e-08 {VDD} 3.4000e-08 {VDD} 3.4100e-08 0)
venb_op1_0900_pic_rtl_hold enb_op1_0900_pic_rtl_hold 0 pwl(0.0000e+00 {VDD} 1.1000e-08 {VDD} 1.1100e-08 0 3.4000e-08 0 3.4100e-08 {VDD})
vww_op1_0900_pic_rtl_hold wwl_op1_0900_pic_rtl_hold 0 pwl(0.0000e+00 0 1.2000e-08 0 1.2100e-08 {VDD} 3.2000e-08 {VDD} 3.2100e-08 0)
vwc_op1_0900_pic_rtl_hold wbc_op1_0900_pic_rtl_hold 0 pwl(0.0000e+00 0 1.2000e-08 0 1.2100e-08 {VDD} 3.4000e-08 {VDD} 3.4100e-08 0)
swb_op1_0900_pic_rtl_hold ref_op1_0900_pic_rtl_hold wbl_op1_0900_pic_rtl_hold wbc_op1_0900_pic_rtl_hold 0 swwbl
cwbl_op1_0900_pic_rtl_hold wbl_op1_0900_pic_rtl_hold 0 {C_WBL}
spa_op1_0900_pic_rtl_hold prea rbl_op1_0900_pic_rtl_hold ctl_op1_0900_pic_rtl_hold 0 swpre
spr_op1_0900_pic_rtl_hold pref ref_op1_0900_pic_rtl_hold ctl_op1_0900_pic_rtl_hold 0 swpre
crbl_op1_0900_pic_rtl_hold rbl_op1_0900_pic_rtl_hold 0 {C_RBL}
cref_op1_0900_pic_rtl_hold ref_op1_0900_pic_rtl_hold 0 {C_RBL}   $ ASSUMPTION: ideal matched dummy load
XMWR_op1_0900_pic_rtl_hold_0 sn_op1_0900_pic_rtl_hold_0 wwl_op1_0900_pic_rtl_hold wbl_op1_0900_pic_rtl_hold 0 sky130_fd_pr__nfet_01v8 L=0.15 W=0.42 nf=1 ad=0.1218 as=0.1218 pd=1.42 ps=1.42 nrd=0.69047619047619  nrs=0.69047619047619 sa=0 sb=0 sd=0 mult=1 m=1
XMRD_op1_0900_pic_rtl_hold_0 rbl_op1_0900_pic_rtl_hold sn_op1_0900_pic_rtl_hold_0 rwls_op1_0900_pic_rtl_hold 0 sky130_fd_pr__nfet_01v8 L=0.15 W=0.42 nf=1 ad=0.1218 as=0.1218 pd=1.42 ps=1.42 nrd=0.69047619047619  nrs=0.69047619047619 sa=0 sb=0 sd=0 mult=1 m=1
csn_op1_0900_pic_rtl_hold_0 sn_op1_0900_pic_rtl_hold_0 0 {C_SN}
XMWR_op1_0900_pic_rtl_hold_1 sn_op1_0900_pic_rtl_hold_1 wwl_des wbl_op1_0900_pic_rtl_hold 0 sky130_fd_pr__nfet_01v8 L=0.15 W=0.42 nf=1 ad=0.1218 as=0.1218 pd=1.42 ps=1.42 nrd=0.69047619047619  nrs=0.69047619047619 sa=0 sb=0 sd=0 mult=1 m=1
XMRD_op1_0900_pic_rtl_hold_1 rbl_op1_0900_pic_rtl_hold sn_op1_0900_pic_rtl_hold_1 rwl_des 0 sky130_fd_pr__nfet_01v8 L=0.15 W=0.42 nf=1 ad=0.1218 as=0.1218 pd=1.42 ps=1.42 nrd=0.69047619047619  nrs=0.69047619047619 sa=0 sb=0 sd=0 mult=1 m=1
csn_op1_0900_pic_rtl_hold_1 sn_op1_0900_pic_rtl_hold_1 0 {C_SN}
XMWR_op1_0900_pic_rtl_hold_2 sn_op1_0900_pic_rtl_hold_2 wwl_des wbl_op1_0900_pic_rtl_hold 0 sky130_fd_pr__nfet_01v8 L=0.15 W=0.42 nf=1 ad=0.1218 as=0.1218 pd=1.42 ps=1.42 nrd=0.69047619047619  nrs=0.69047619047619 sa=0 sb=0 sd=0 mult=1 m=1
XMRD_op1_0900_pic_rtl_hold_2 rbl_op1_0900_pic_rtl_hold sn_op1_0900_pic_rtl_hold_2 rwl_des 0 sky130_fd_pr__nfet_01v8 L=0.15 W=0.42 nf=1 ad=0.1218 as=0.1218 pd=1.42 ps=1.42 nrd=0.69047619047619  nrs=0.69047619047619 sa=0 sb=0 sd=0 mult=1 m=1
csn_op1_0900_pic_rtl_hold_2 sn_op1_0900_pic_rtl_hold_2 0 {C_SN}
XMWR_op1_0900_pic_rtl_hold_3 sn_op1_0900_pic_rtl_hold_3 wwl_des wbl_op1_0900_pic_rtl_hold 0 sky130_fd_pr__nfet_01v8 L=0.15 W=0.42 nf=1 ad=0.1218 as=0.1218 pd=1.42 ps=1.42 nrd=0.69047619047619  nrs=0.69047619047619 sa=0 sb=0 sd=0 mult=1 m=1
XMRD_op1_0900_pic_rtl_hold_3 rbl_op1_0900_pic_rtl_hold sn_op1_0900_pic_rtl_hold_3 rwl_des 0 sky130_fd_pr__nfet_01v8 L=0.15 W=0.42 nf=1 ad=0.1218 as=0.1218 pd=1.42 ps=1.42 nrd=0.69047619047619  nrs=0.69047619047619 sa=0 sb=0 sd=0 mult=1 m=1
csn_op1_0900_pic_rtl_hold_3 sn_op1_0900_pic_rtl_hold_3 0 {C_SN}
XMN1_op1_0900_pic_rtl_hold rbl_op1_0900_pic_rtl_hold ref_op1_0900_pic_rtl_hold vn_op1_0900_pic_rtl_hold 0 sky130_fd_pr__nfet_01v8 L=0.15 W=1 nf=1 ad=0.29 as=0.29 pd=2.58 ps=2.58 mult=1 m=1
XMN2_op1_0900_pic_rtl_hold ref_op1_0900_pic_rtl_hold rbl_op1_0900_pic_rtl_hold vn_op1_0900_pic_rtl_hold 0 sky130_fd_pr__nfet_01v8 L=0.15 W=1 nf=1 ad=0.29 as=0.29 pd=2.58 ps=2.58 mult=1 m=1
XMP1_op1_0900_pic_rtl_hold rbl_op1_0900_pic_rtl_hold ref_op1_0900_pic_rtl_hold vp_op1_0900_pic_rtl_hold vdd sky130_fd_pr__pfet_01v8 L=0.15 W=2 nf=1 ad=0.58 as=0.58 pd=4.58 ps=4.58 mult=1 m=1
XMP2_op1_0900_pic_rtl_hold ref_op1_0900_pic_rtl_hold rbl_op1_0900_pic_rtl_hold vp_op1_0900_pic_rtl_hold vdd sky130_fd_pr__pfet_01v8 L=0.15 W=2 nf=1 ad=0.58 as=0.58 pd=4.58 ps=4.58 mult=1 m=1
XMNF_op1_0900_pic_rtl_hold vn_op1_0900_pic_rtl_hold en_op1_0900_pic_rtl_hold 0 0 sky130_fd_pr__nfet_01v8 L=0.15 W=2 nf=1 ad=0.58 as=0.58 pd=4.58 ps=4.58 mult=1 m=1
XMPH_op1_0900_pic_rtl_hold vp_op1_0900_pic_rtl_hold enb_op1_0900_pic_rtl_hold vdd vdd sky130_fd_pr__pfet_01v8 L=0.15 W=4 nf=1 ad=1.16 as=1.16 pd=8.58 ps=8.58 mult=1 m=1
bd_op1_0900_pic_rtl_hold d_op1_0900_pic_rtl_hold 0 v=v(rbl_op1_0900_pic_rtl_hold)-v(ref_op1_0900_pic_rtl_hold)

* ---- instance 21: op1_1000_pic_rtl_hold (variant pic_rtl_hold; probe dec 11.9 ns, release 34 ns, meas 36 ns) ----
vctl_op1_1000_pic_rtl_hold ctl_op1_1000_pic_rtl_hold 0 pwl(0.0000e+00 {VDD} 2.0000e-09 {VDD} 2.1000e-09 0)
vrs_op1_1000_pic_rtl_hold rwls_op1_1000_pic_rtl_hold 0 pwl(0.0000e+00 {VDD} 2.0000e-09 {VDD} 2.1000e-09 0 1.2000e-08 0 1.2100e-08 {VDD})
ven_op1_1000_pic_rtl_hold en_op1_1000_pic_rtl_hold 0 pwl(0.0000e+00 0 1.1000e-08 0 1.1100e-08 {VDD} 3.4000e-08 {VDD} 3.4100e-08 0)
venb_op1_1000_pic_rtl_hold enb_op1_1000_pic_rtl_hold 0 pwl(0.0000e+00 {VDD} 1.1000e-08 {VDD} 1.1100e-08 0 3.4000e-08 0 3.4100e-08 {VDD})
vww_op1_1000_pic_rtl_hold wwl_op1_1000_pic_rtl_hold 0 pwl(0.0000e+00 0 1.2000e-08 0 1.2100e-08 {VDD} 3.2000e-08 {VDD} 3.2100e-08 0)
vwc_op1_1000_pic_rtl_hold wbc_op1_1000_pic_rtl_hold 0 pwl(0.0000e+00 0 1.2000e-08 0 1.2100e-08 {VDD} 3.4000e-08 {VDD} 3.4100e-08 0)
swb_op1_1000_pic_rtl_hold ref_op1_1000_pic_rtl_hold wbl_op1_1000_pic_rtl_hold wbc_op1_1000_pic_rtl_hold 0 swwbl
cwbl_op1_1000_pic_rtl_hold wbl_op1_1000_pic_rtl_hold 0 {C_WBL}
spa_op1_1000_pic_rtl_hold prea rbl_op1_1000_pic_rtl_hold ctl_op1_1000_pic_rtl_hold 0 swpre
spr_op1_1000_pic_rtl_hold pref ref_op1_1000_pic_rtl_hold ctl_op1_1000_pic_rtl_hold 0 swpre
crbl_op1_1000_pic_rtl_hold rbl_op1_1000_pic_rtl_hold 0 {C_RBL}
cref_op1_1000_pic_rtl_hold ref_op1_1000_pic_rtl_hold 0 {C_RBL}   $ ASSUMPTION: ideal matched dummy load
XMWR_op1_1000_pic_rtl_hold_0 sn_op1_1000_pic_rtl_hold_0 wwl_op1_1000_pic_rtl_hold wbl_op1_1000_pic_rtl_hold 0 sky130_fd_pr__nfet_01v8 L=0.15 W=0.42 nf=1 ad=0.1218 as=0.1218 pd=1.42 ps=1.42 nrd=0.69047619047619  nrs=0.69047619047619 sa=0 sb=0 sd=0 mult=1 m=1
XMRD_op1_1000_pic_rtl_hold_0 rbl_op1_1000_pic_rtl_hold sn_op1_1000_pic_rtl_hold_0 rwls_op1_1000_pic_rtl_hold 0 sky130_fd_pr__nfet_01v8 L=0.15 W=0.42 nf=1 ad=0.1218 as=0.1218 pd=1.42 ps=1.42 nrd=0.69047619047619  nrs=0.69047619047619 sa=0 sb=0 sd=0 mult=1 m=1
csn_op1_1000_pic_rtl_hold_0 sn_op1_1000_pic_rtl_hold_0 0 {C_SN}
XMWR_op1_1000_pic_rtl_hold_1 sn_op1_1000_pic_rtl_hold_1 wwl_des wbl_op1_1000_pic_rtl_hold 0 sky130_fd_pr__nfet_01v8 L=0.15 W=0.42 nf=1 ad=0.1218 as=0.1218 pd=1.42 ps=1.42 nrd=0.69047619047619  nrs=0.69047619047619 sa=0 sb=0 sd=0 mult=1 m=1
XMRD_op1_1000_pic_rtl_hold_1 rbl_op1_1000_pic_rtl_hold sn_op1_1000_pic_rtl_hold_1 rwl_des 0 sky130_fd_pr__nfet_01v8 L=0.15 W=0.42 nf=1 ad=0.1218 as=0.1218 pd=1.42 ps=1.42 nrd=0.69047619047619  nrs=0.69047619047619 sa=0 sb=0 sd=0 mult=1 m=1
csn_op1_1000_pic_rtl_hold_1 sn_op1_1000_pic_rtl_hold_1 0 {C_SN}
XMWR_op1_1000_pic_rtl_hold_2 sn_op1_1000_pic_rtl_hold_2 wwl_des wbl_op1_1000_pic_rtl_hold 0 sky130_fd_pr__nfet_01v8 L=0.15 W=0.42 nf=1 ad=0.1218 as=0.1218 pd=1.42 ps=1.42 nrd=0.69047619047619  nrs=0.69047619047619 sa=0 sb=0 sd=0 mult=1 m=1
XMRD_op1_1000_pic_rtl_hold_2 rbl_op1_1000_pic_rtl_hold sn_op1_1000_pic_rtl_hold_2 rwl_des 0 sky130_fd_pr__nfet_01v8 L=0.15 W=0.42 nf=1 ad=0.1218 as=0.1218 pd=1.42 ps=1.42 nrd=0.69047619047619  nrs=0.69047619047619 sa=0 sb=0 sd=0 mult=1 m=1
csn_op1_1000_pic_rtl_hold_2 sn_op1_1000_pic_rtl_hold_2 0 {C_SN}
XMWR_op1_1000_pic_rtl_hold_3 sn_op1_1000_pic_rtl_hold_3 wwl_des wbl_op1_1000_pic_rtl_hold 0 sky130_fd_pr__nfet_01v8 L=0.15 W=0.42 nf=1 ad=0.1218 as=0.1218 pd=1.42 ps=1.42 nrd=0.69047619047619  nrs=0.69047619047619 sa=0 sb=0 sd=0 mult=1 m=1
XMRD_op1_1000_pic_rtl_hold_3 rbl_op1_1000_pic_rtl_hold sn_op1_1000_pic_rtl_hold_3 rwl_des 0 sky130_fd_pr__nfet_01v8 L=0.15 W=0.42 nf=1 ad=0.1218 as=0.1218 pd=1.42 ps=1.42 nrd=0.69047619047619  nrs=0.69047619047619 sa=0 sb=0 sd=0 mult=1 m=1
csn_op1_1000_pic_rtl_hold_3 sn_op1_1000_pic_rtl_hold_3 0 {C_SN}
XMN1_op1_1000_pic_rtl_hold rbl_op1_1000_pic_rtl_hold ref_op1_1000_pic_rtl_hold vn_op1_1000_pic_rtl_hold 0 sky130_fd_pr__nfet_01v8 L=0.15 W=1 nf=1 ad=0.29 as=0.29 pd=2.58 ps=2.58 mult=1 m=1
XMN2_op1_1000_pic_rtl_hold ref_op1_1000_pic_rtl_hold rbl_op1_1000_pic_rtl_hold vn_op1_1000_pic_rtl_hold 0 sky130_fd_pr__nfet_01v8 L=0.15 W=1 nf=1 ad=0.29 as=0.29 pd=2.58 ps=2.58 mult=1 m=1
XMP1_op1_1000_pic_rtl_hold rbl_op1_1000_pic_rtl_hold ref_op1_1000_pic_rtl_hold vp_op1_1000_pic_rtl_hold vdd sky130_fd_pr__pfet_01v8 L=0.15 W=2 nf=1 ad=0.58 as=0.58 pd=4.58 ps=4.58 mult=1 m=1
XMP2_op1_1000_pic_rtl_hold ref_op1_1000_pic_rtl_hold rbl_op1_1000_pic_rtl_hold vp_op1_1000_pic_rtl_hold vdd sky130_fd_pr__pfet_01v8 L=0.15 W=2 nf=1 ad=0.58 as=0.58 pd=4.58 ps=4.58 mult=1 m=1
XMNF_op1_1000_pic_rtl_hold vn_op1_1000_pic_rtl_hold en_op1_1000_pic_rtl_hold 0 0 sky130_fd_pr__nfet_01v8 L=0.15 W=2 nf=1 ad=0.58 as=0.58 pd=4.58 ps=4.58 mult=1 m=1
XMPH_op1_1000_pic_rtl_hold vp_op1_1000_pic_rtl_hold enb_op1_1000_pic_rtl_hold vdd vdd sky130_fd_pr__pfet_01v8 L=0.15 W=4 nf=1 ad=1.16 as=1.16 pd=8.58 ps=8.58 mult=1 m=1
bd_op1_1000_pic_rtl_hold d_op1_1000_pic_rtl_hold 0 v=v(rbl_op1_1000_pic_rtl_hold)-v(ref_op1_1000_pic_rtl_hold)

* ---- instance 22: op0_n100_pic_rtl_hold (variant pic_rtl_hold; probe dec 11.9 ns, release 34 ns, meas 36 ns) ----
vctl_op0_n100_pic_rtl_hold ctl_op0_n100_pic_rtl_hold 0 pwl(0.0000e+00 {VDD} 2.0000e-09 {VDD} 2.1000e-09 0)
vrs_op0_n100_pic_rtl_hold rwls_op0_n100_pic_rtl_hold 0 pwl(0.0000e+00 {VDD} 2.0000e-09 {VDD} 2.1000e-09 0 1.2000e-08 0 1.2100e-08 {VDD})
ven_op0_n100_pic_rtl_hold en_op0_n100_pic_rtl_hold 0 pwl(0.0000e+00 0 1.1000e-08 0 1.1100e-08 {VDD} 3.4000e-08 {VDD} 3.4100e-08 0)
venb_op0_n100_pic_rtl_hold enb_op0_n100_pic_rtl_hold 0 pwl(0.0000e+00 {VDD} 1.1000e-08 {VDD} 1.1100e-08 0 3.4000e-08 0 3.4100e-08 {VDD})
vww_op0_n100_pic_rtl_hold wwl_op0_n100_pic_rtl_hold 0 pwl(0.0000e+00 0 1.2000e-08 0 1.2100e-08 {VDD} 3.2000e-08 {VDD} 3.2100e-08 0)
vwc_op0_n100_pic_rtl_hold wbc_op0_n100_pic_rtl_hold 0 pwl(0.0000e+00 0 1.2000e-08 0 1.2100e-08 {VDD} 3.4000e-08 {VDD} 3.4100e-08 0)
swb_op0_n100_pic_rtl_hold ref_op0_n100_pic_rtl_hold wbl_op0_n100_pic_rtl_hold wbc_op0_n100_pic_rtl_hold 0 swwbl
cwbl_op0_n100_pic_rtl_hold wbl_op0_n100_pic_rtl_hold 0 {C_WBL}
spa_op0_n100_pic_rtl_hold prea rbl_op0_n100_pic_rtl_hold ctl_op0_n100_pic_rtl_hold 0 swpre
spr_op0_n100_pic_rtl_hold pref ref_op0_n100_pic_rtl_hold ctl_op0_n100_pic_rtl_hold 0 swpre
crbl_op0_n100_pic_rtl_hold rbl_op0_n100_pic_rtl_hold 0 {C_RBL}
cref_op0_n100_pic_rtl_hold ref_op0_n100_pic_rtl_hold 0 {C_RBL}   $ ASSUMPTION: ideal matched dummy load
XMWR_op0_n100_pic_rtl_hold_0 sn_op0_n100_pic_rtl_hold_0 wwl_op0_n100_pic_rtl_hold wbl_op0_n100_pic_rtl_hold 0 sky130_fd_pr__nfet_01v8 L=0.15 W=0.42 nf=1 ad=0.1218 as=0.1218 pd=1.42 ps=1.42 nrd=0.69047619047619  nrs=0.69047619047619 sa=0 sb=0 sd=0 mult=1 m=1
XMRD_op0_n100_pic_rtl_hold_0 rbl_op0_n100_pic_rtl_hold sn_op0_n100_pic_rtl_hold_0 rwls_op0_n100_pic_rtl_hold 0 sky130_fd_pr__nfet_01v8 L=0.15 W=0.42 nf=1 ad=0.1218 as=0.1218 pd=1.42 ps=1.42 nrd=0.69047619047619  nrs=0.69047619047619 sa=0 sb=0 sd=0 mult=1 m=1
csn_op0_n100_pic_rtl_hold_0 sn_op0_n100_pic_rtl_hold_0 0 {C_SN}
XMWR_op0_n100_pic_rtl_hold_1 sn_op0_n100_pic_rtl_hold_1 wwl_des wbl_op0_n100_pic_rtl_hold 0 sky130_fd_pr__nfet_01v8 L=0.15 W=0.42 nf=1 ad=0.1218 as=0.1218 pd=1.42 ps=1.42 nrd=0.69047619047619  nrs=0.69047619047619 sa=0 sb=0 sd=0 mult=1 m=1
XMRD_op0_n100_pic_rtl_hold_1 rbl_op0_n100_pic_rtl_hold sn_op0_n100_pic_rtl_hold_1 rwl_des 0 sky130_fd_pr__nfet_01v8 L=0.15 W=0.42 nf=1 ad=0.1218 as=0.1218 pd=1.42 ps=1.42 nrd=0.69047619047619  nrs=0.69047619047619 sa=0 sb=0 sd=0 mult=1 m=1
csn_op0_n100_pic_rtl_hold_1 sn_op0_n100_pic_rtl_hold_1 0 {C_SN}
XMWR_op0_n100_pic_rtl_hold_2 sn_op0_n100_pic_rtl_hold_2 wwl_des wbl_op0_n100_pic_rtl_hold 0 sky130_fd_pr__nfet_01v8 L=0.15 W=0.42 nf=1 ad=0.1218 as=0.1218 pd=1.42 ps=1.42 nrd=0.69047619047619  nrs=0.69047619047619 sa=0 sb=0 sd=0 mult=1 m=1
XMRD_op0_n100_pic_rtl_hold_2 rbl_op0_n100_pic_rtl_hold sn_op0_n100_pic_rtl_hold_2 rwl_des 0 sky130_fd_pr__nfet_01v8 L=0.15 W=0.42 nf=1 ad=0.1218 as=0.1218 pd=1.42 ps=1.42 nrd=0.69047619047619  nrs=0.69047619047619 sa=0 sb=0 sd=0 mult=1 m=1
csn_op0_n100_pic_rtl_hold_2 sn_op0_n100_pic_rtl_hold_2 0 {C_SN}
XMWR_op0_n100_pic_rtl_hold_3 sn_op0_n100_pic_rtl_hold_3 wwl_des wbl_op0_n100_pic_rtl_hold 0 sky130_fd_pr__nfet_01v8 L=0.15 W=0.42 nf=1 ad=0.1218 as=0.1218 pd=1.42 ps=1.42 nrd=0.69047619047619  nrs=0.69047619047619 sa=0 sb=0 sd=0 mult=1 m=1
XMRD_op0_n100_pic_rtl_hold_3 rbl_op0_n100_pic_rtl_hold sn_op0_n100_pic_rtl_hold_3 rwl_des 0 sky130_fd_pr__nfet_01v8 L=0.15 W=0.42 nf=1 ad=0.1218 as=0.1218 pd=1.42 ps=1.42 nrd=0.69047619047619  nrs=0.69047619047619 sa=0 sb=0 sd=0 mult=1 m=1
csn_op0_n100_pic_rtl_hold_3 sn_op0_n100_pic_rtl_hold_3 0 {C_SN}
XMN1_op0_n100_pic_rtl_hold rbl_op0_n100_pic_rtl_hold ref_op0_n100_pic_rtl_hold vn_op0_n100_pic_rtl_hold 0 sky130_fd_pr__nfet_01v8 L=0.15 W=1 nf=1 ad=0.29 as=0.29 pd=2.58 ps=2.58 mult=1 m=1
XMN2_op0_n100_pic_rtl_hold ref_op0_n100_pic_rtl_hold rbl_op0_n100_pic_rtl_hold vn_op0_n100_pic_rtl_hold 0 sky130_fd_pr__nfet_01v8 L=0.15 W=1 nf=1 ad=0.29 as=0.29 pd=2.58 ps=2.58 mult=1 m=1
XMP1_op0_n100_pic_rtl_hold rbl_op0_n100_pic_rtl_hold ref_op0_n100_pic_rtl_hold vp_op0_n100_pic_rtl_hold vdd sky130_fd_pr__pfet_01v8 L=0.15 W=2 nf=1 ad=0.58 as=0.58 pd=4.58 ps=4.58 mult=1 m=1
XMP2_op0_n100_pic_rtl_hold ref_op0_n100_pic_rtl_hold rbl_op0_n100_pic_rtl_hold vp_op0_n100_pic_rtl_hold vdd sky130_fd_pr__pfet_01v8 L=0.15 W=2 nf=1 ad=0.58 as=0.58 pd=4.58 ps=4.58 mult=1 m=1
XMNF_op0_n100_pic_rtl_hold vn_op0_n100_pic_rtl_hold en_op0_n100_pic_rtl_hold 0 0 sky130_fd_pr__nfet_01v8 L=0.15 W=2 nf=1 ad=0.58 as=0.58 pd=4.58 ps=4.58 mult=1 m=1
XMPH_op0_n100_pic_rtl_hold vp_op0_n100_pic_rtl_hold enb_op0_n100_pic_rtl_hold vdd vdd sky130_fd_pr__pfet_01v8 L=0.15 W=4 nf=1 ad=1.16 as=1.16 pd=8.58 ps=8.58 mult=1 m=1
bd_op0_n100_pic_rtl_hold d_op0_n100_pic_rtl_hold 0 v=v(rbl_op0_n100_pic_rtl_hold)-v(ref_op0_n100_pic_rtl_hold)

* ---- instance 23: op0_0000_pic_rtl_hold (variant pic_rtl_hold; probe dec 11.9 ns, release 34 ns, meas 36 ns) ----
vctl_op0_0000_pic_rtl_hold ctl_op0_0000_pic_rtl_hold 0 pwl(0.0000e+00 {VDD} 2.0000e-09 {VDD} 2.1000e-09 0)
vrs_op0_0000_pic_rtl_hold rwls_op0_0000_pic_rtl_hold 0 pwl(0.0000e+00 {VDD} 2.0000e-09 {VDD} 2.1000e-09 0 1.2000e-08 0 1.2100e-08 {VDD})
ven_op0_0000_pic_rtl_hold en_op0_0000_pic_rtl_hold 0 pwl(0.0000e+00 0 1.1000e-08 0 1.1100e-08 {VDD} 3.4000e-08 {VDD} 3.4100e-08 0)
venb_op0_0000_pic_rtl_hold enb_op0_0000_pic_rtl_hold 0 pwl(0.0000e+00 {VDD} 1.1000e-08 {VDD} 1.1100e-08 0 3.4000e-08 0 3.4100e-08 {VDD})
vww_op0_0000_pic_rtl_hold wwl_op0_0000_pic_rtl_hold 0 pwl(0.0000e+00 0 1.2000e-08 0 1.2100e-08 {VDD} 3.2000e-08 {VDD} 3.2100e-08 0)
vwc_op0_0000_pic_rtl_hold wbc_op0_0000_pic_rtl_hold 0 pwl(0.0000e+00 0 1.2000e-08 0 1.2100e-08 {VDD} 3.4000e-08 {VDD} 3.4100e-08 0)
swb_op0_0000_pic_rtl_hold ref_op0_0000_pic_rtl_hold wbl_op0_0000_pic_rtl_hold wbc_op0_0000_pic_rtl_hold 0 swwbl
cwbl_op0_0000_pic_rtl_hold wbl_op0_0000_pic_rtl_hold 0 {C_WBL}
spa_op0_0000_pic_rtl_hold prea rbl_op0_0000_pic_rtl_hold ctl_op0_0000_pic_rtl_hold 0 swpre
spr_op0_0000_pic_rtl_hold pref ref_op0_0000_pic_rtl_hold ctl_op0_0000_pic_rtl_hold 0 swpre
crbl_op0_0000_pic_rtl_hold rbl_op0_0000_pic_rtl_hold 0 {C_RBL}
cref_op0_0000_pic_rtl_hold ref_op0_0000_pic_rtl_hold 0 {C_RBL}   $ ASSUMPTION: ideal matched dummy load
XMWR_op0_0000_pic_rtl_hold_0 sn_op0_0000_pic_rtl_hold_0 wwl_op0_0000_pic_rtl_hold wbl_op0_0000_pic_rtl_hold 0 sky130_fd_pr__nfet_01v8 L=0.15 W=0.42 nf=1 ad=0.1218 as=0.1218 pd=1.42 ps=1.42 nrd=0.69047619047619  nrs=0.69047619047619 sa=0 sb=0 sd=0 mult=1 m=1
XMRD_op0_0000_pic_rtl_hold_0 rbl_op0_0000_pic_rtl_hold sn_op0_0000_pic_rtl_hold_0 rwls_op0_0000_pic_rtl_hold 0 sky130_fd_pr__nfet_01v8 L=0.15 W=0.42 nf=1 ad=0.1218 as=0.1218 pd=1.42 ps=1.42 nrd=0.69047619047619  nrs=0.69047619047619 sa=0 sb=0 sd=0 mult=1 m=1
csn_op0_0000_pic_rtl_hold_0 sn_op0_0000_pic_rtl_hold_0 0 {C_SN}
XMWR_op0_0000_pic_rtl_hold_1 sn_op0_0000_pic_rtl_hold_1 wwl_des wbl_op0_0000_pic_rtl_hold 0 sky130_fd_pr__nfet_01v8 L=0.15 W=0.42 nf=1 ad=0.1218 as=0.1218 pd=1.42 ps=1.42 nrd=0.69047619047619  nrs=0.69047619047619 sa=0 sb=0 sd=0 mult=1 m=1
XMRD_op0_0000_pic_rtl_hold_1 rbl_op0_0000_pic_rtl_hold sn_op0_0000_pic_rtl_hold_1 rwl_des 0 sky130_fd_pr__nfet_01v8 L=0.15 W=0.42 nf=1 ad=0.1218 as=0.1218 pd=1.42 ps=1.42 nrd=0.69047619047619  nrs=0.69047619047619 sa=0 sb=0 sd=0 mult=1 m=1
csn_op0_0000_pic_rtl_hold_1 sn_op0_0000_pic_rtl_hold_1 0 {C_SN}
XMWR_op0_0000_pic_rtl_hold_2 sn_op0_0000_pic_rtl_hold_2 wwl_des wbl_op0_0000_pic_rtl_hold 0 sky130_fd_pr__nfet_01v8 L=0.15 W=0.42 nf=1 ad=0.1218 as=0.1218 pd=1.42 ps=1.42 nrd=0.69047619047619  nrs=0.69047619047619 sa=0 sb=0 sd=0 mult=1 m=1
XMRD_op0_0000_pic_rtl_hold_2 rbl_op0_0000_pic_rtl_hold sn_op0_0000_pic_rtl_hold_2 rwl_des 0 sky130_fd_pr__nfet_01v8 L=0.15 W=0.42 nf=1 ad=0.1218 as=0.1218 pd=1.42 ps=1.42 nrd=0.69047619047619  nrs=0.69047619047619 sa=0 sb=0 sd=0 mult=1 m=1
csn_op0_0000_pic_rtl_hold_2 sn_op0_0000_pic_rtl_hold_2 0 {C_SN}
XMWR_op0_0000_pic_rtl_hold_3 sn_op0_0000_pic_rtl_hold_3 wwl_des wbl_op0_0000_pic_rtl_hold 0 sky130_fd_pr__nfet_01v8 L=0.15 W=0.42 nf=1 ad=0.1218 as=0.1218 pd=1.42 ps=1.42 nrd=0.69047619047619  nrs=0.69047619047619 sa=0 sb=0 sd=0 mult=1 m=1
XMRD_op0_0000_pic_rtl_hold_3 rbl_op0_0000_pic_rtl_hold sn_op0_0000_pic_rtl_hold_3 rwl_des 0 sky130_fd_pr__nfet_01v8 L=0.15 W=0.42 nf=1 ad=0.1218 as=0.1218 pd=1.42 ps=1.42 nrd=0.69047619047619  nrs=0.69047619047619 sa=0 sb=0 sd=0 mult=1 m=1
csn_op0_0000_pic_rtl_hold_3 sn_op0_0000_pic_rtl_hold_3 0 {C_SN}
XMN1_op0_0000_pic_rtl_hold rbl_op0_0000_pic_rtl_hold ref_op0_0000_pic_rtl_hold vn_op0_0000_pic_rtl_hold 0 sky130_fd_pr__nfet_01v8 L=0.15 W=1 nf=1 ad=0.29 as=0.29 pd=2.58 ps=2.58 mult=1 m=1
XMN2_op0_0000_pic_rtl_hold ref_op0_0000_pic_rtl_hold rbl_op0_0000_pic_rtl_hold vn_op0_0000_pic_rtl_hold 0 sky130_fd_pr__nfet_01v8 L=0.15 W=1 nf=1 ad=0.29 as=0.29 pd=2.58 ps=2.58 mult=1 m=1
XMP1_op0_0000_pic_rtl_hold rbl_op0_0000_pic_rtl_hold ref_op0_0000_pic_rtl_hold vp_op0_0000_pic_rtl_hold vdd sky130_fd_pr__pfet_01v8 L=0.15 W=2 nf=1 ad=0.58 as=0.58 pd=4.58 ps=4.58 mult=1 m=1
XMP2_op0_0000_pic_rtl_hold ref_op0_0000_pic_rtl_hold rbl_op0_0000_pic_rtl_hold vp_op0_0000_pic_rtl_hold vdd sky130_fd_pr__pfet_01v8 L=0.15 W=2 nf=1 ad=0.58 as=0.58 pd=4.58 ps=4.58 mult=1 m=1
XMNF_op0_0000_pic_rtl_hold vn_op0_0000_pic_rtl_hold en_op0_0000_pic_rtl_hold 0 0 sky130_fd_pr__nfet_01v8 L=0.15 W=2 nf=1 ad=0.58 as=0.58 pd=4.58 ps=4.58 mult=1 m=1
XMPH_op0_0000_pic_rtl_hold vp_op0_0000_pic_rtl_hold enb_op0_0000_pic_rtl_hold vdd vdd sky130_fd_pr__pfet_01v8 L=0.15 W=4 nf=1 ad=1.16 as=1.16 pd=8.58 ps=8.58 mult=1 m=1
bd_op0_0000_pic_rtl_hold d_op0_0000_pic_rtl_hold 0 v=v(rbl_op0_0000_pic_rtl_hold)-v(ref_op0_0000_pic_rtl_hold)

* ---- instance 24: op1_0900_pic_rwl_late_hold (variant pic_rwl_late_hold; probe dec 11.9 ns, release 34 ns, meas 36 ns) ----
vctl_op1_0900_pic_rwl_late_hold ctl_op1_0900_pic_rwl_late_hold 0 pwl(0.0000e+00 {VDD} 2.0000e-09 {VDD} 2.1000e-09 0)
vrs_op1_0900_pic_rwl_late_hold rwls_op1_0900_pic_rwl_late_hold 0 pwl(0.0000e+00 {VDD} 2.0000e-09 {VDD} 2.1000e-09 0 3.4000e-08 0 3.4100e-08 {VDD})
ven_op1_0900_pic_rwl_late_hold en_op1_0900_pic_rwl_late_hold 0 pwl(0.0000e+00 0 1.1000e-08 0 1.1100e-08 {VDD} 3.4000e-08 {VDD} 3.4100e-08 0)
venb_op1_0900_pic_rwl_late_hold enb_op1_0900_pic_rwl_late_hold 0 pwl(0.0000e+00 {VDD} 1.1000e-08 {VDD} 1.1100e-08 0 3.4000e-08 0 3.4100e-08 {VDD})
vww_op1_0900_pic_rwl_late_hold wwl_op1_0900_pic_rwl_late_hold 0 pwl(0.0000e+00 0 1.2000e-08 0 1.2100e-08 {VDD} 3.2000e-08 {VDD} 3.2100e-08 0)
vwc_op1_0900_pic_rwl_late_hold wbc_op1_0900_pic_rwl_late_hold 0 pwl(0.0000e+00 0 1.2000e-08 0 1.2100e-08 {VDD} 3.4000e-08 {VDD} 3.4100e-08 0)
swb_op1_0900_pic_rwl_late_hold ref_op1_0900_pic_rwl_late_hold wbl_op1_0900_pic_rwl_late_hold wbc_op1_0900_pic_rwl_late_hold 0 swwbl
cwbl_op1_0900_pic_rwl_late_hold wbl_op1_0900_pic_rwl_late_hold 0 {C_WBL}
spa_op1_0900_pic_rwl_late_hold prea rbl_op1_0900_pic_rwl_late_hold ctl_op1_0900_pic_rwl_late_hold 0 swpre
spr_op1_0900_pic_rwl_late_hold pref ref_op1_0900_pic_rwl_late_hold ctl_op1_0900_pic_rwl_late_hold 0 swpre
crbl_op1_0900_pic_rwl_late_hold rbl_op1_0900_pic_rwl_late_hold 0 {C_RBL}
cref_op1_0900_pic_rwl_late_hold ref_op1_0900_pic_rwl_late_hold 0 {C_RBL}   $ ASSUMPTION: ideal matched dummy load
XMWR_op1_0900_pic_rwl_late_hold_0 sn_op1_0900_pic_rwl_late_hold_0 wwl_op1_0900_pic_rwl_late_hold wbl_op1_0900_pic_rwl_late_hold 0 sky130_fd_pr__nfet_01v8 L=0.15 W=0.42 nf=1 ad=0.1218 as=0.1218 pd=1.42 ps=1.42 nrd=0.69047619047619  nrs=0.69047619047619 sa=0 sb=0 sd=0 mult=1 m=1
XMRD_op1_0900_pic_rwl_late_hold_0 rbl_op1_0900_pic_rwl_late_hold sn_op1_0900_pic_rwl_late_hold_0 rwls_op1_0900_pic_rwl_late_hold 0 sky130_fd_pr__nfet_01v8 L=0.15 W=0.42 nf=1 ad=0.1218 as=0.1218 pd=1.42 ps=1.42 nrd=0.69047619047619  nrs=0.69047619047619 sa=0 sb=0 sd=0 mult=1 m=1
csn_op1_0900_pic_rwl_late_hold_0 sn_op1_0900_pic_rwl_late_hold_0 0 {C_SN}
XMWR_op1_0900_pic_rwl_late_hold_1 sn_op1_0900_pic_rwl_late_hold_1 wwl_des wbl_op1_0900_pic_rwl_late_hold 0 sky130_fd_pr__nfet_01v8 L=0.15 W=0.42 nf=1 ad=0.1218 as=0.1218 pd=1.42 ps=1.42 nrd=0.69047619047619  nrs=0.69047619047619 sa=0 sb=0 sd=0 mult=1 m=1
XMRD_op1_0900_pic_rwl_late_hold_1 rbl_op1_0900_pic_rwl_late_hold sn_op1_0900_pic_rwl_late_hold_1 rwl_des 0 sky130_fd_pr__nfet_01v8 L=0.15 W=0.42 nf=1 ad=0.1218 as=0.1218 pd=1.42 ps=1.42 nrd=0.69047619047619  nrs=0.69047619047619 sa=0 sb=0 sd=0 mult=1 m=1
csn_op1_0900_pic_rwl_late_hold_1 sn_op1_0900_pic_rwl_late_hold_1 0 {C_SN}
XMWR_op1_0900_pic_rwl_late_hold_2 sn_op1_0900_pic_rwl_late_hold_2 wwl_des wbl_op1_0900_pic_rwl_late_hold 0 sky130_fd_pr__nfet_01v8 L=0.15 W=0.42 nf=1 ad=0.1218 as=0.1218 pd=1.42 ps=1.42 nrd=0.69047619047619  nrs=0.69047619047619 sa=0 sb=0 sd=0 mult=1 m=1
XMRD_op1_0900_pic_rwl_late_hold_2 rbl_op1_0900_pic_rwl_late_hold sn_op1_0900_pic_rwl_late_hold_2 rwl_des 0 sky130_fd_pr__nfet_01v8 L=0.15 W=0.42 nf=1 ad=0.1218 as=0.1218 pd=1.42 ps=1.42 nrd=0.69047619047619  nrs=0.69047619047619 sa=0 sb=0 sd=0 mult=1 m=1
csn_op1_0900_pic_rwl_late_hold_2 sn_op1_0900_pic_rwl_late_hold_2 0 {C_SN}
XMWR_op1_0900_pic_rwl_late_hold_3 sn_op1_0900_pic_rwl_late_hold_3 wwl_des wbl_op1_0900_pic_rwl_late_hold 0 sky130_fd_pr__nfet_01v8 L=0.15 W=0.42 nf=1 ad=0.1218 as=0.1218 pd=1.42 ps=1.42 nrd=0.69047619047619  nrs=0.69047619047619 sa=0 sb=0 sd=0 mult=1 m=1
XMRD_op1_0900_pic_rwl_late_hold_3 rbl_op1_0900_pic_rwl_late_hold sn_op1_0900_pic_rwl_late_hold_3 rwl_des 0 sky130_fd_pr__nfet_01v8 L=0.15 W=0.42 nf=1 ad=0.1218 as=0.1218 pd=1.42 ps=1.42 nrd=0.69047619047619  nrs=0.69047619047619 sa=0 sb=0 sd=0 mult=1 m=1
csn_op1_0900_pic_rwl_late_hold_3 sn_op1_0900_pic_rwl_late_hold_3 0 {C_SN}
XMN1_op1_0900_pic_rwl_late_hold rbl_op1_0900_pic_rwl_late_hold ref_op1_0900_pic_rwl_late_hold vn_op1_0900_pic_rwl_late_hold 0 sky130_fd_pr__nfet_01v8 L=0.15 W=1 nf=1 ad=0.29 as=0.29 pd=2.58 ps=2.58 mult=1 m=1
XMN2_op1_0900_pic_rwl_late_hold ref_op1_0900_pic_rwl_late_hold rbl_op1_0900_pic_rwl_late_hold vn_op1_0900_pic_rwl_late_hold 0 sky130_fd_pr__nfet_01v8 L=0.15 W=1 nf=1 ad=0.29 as=0.29 pd=2.58 ps=2.58 mult=1 m=1
XMP1_op1_0900_pic_rwl_late_hold rbl_op1_0900_pic_rwl_late_hold ref_op1_0900_pic_rwl_late_hold vp_op1_0900_pic_rwl_late_hold vdd sky130_fd_pr__pfet_01v8 L=0.15 W=2 nf=1 ad=0.58 as=0.58 pd=4.58 ps=4.58 mult=1 m=1
XMP2_op1_0900_pic_rwl_late_hold ref_op1_0900_pic_rwl_late_hold rbl_op1_0900_pic_rwl_late_hold vp_op1_0900_pic_rwl_late_hold vdd sky130_fd_pr__pfet_01v8 L=0.15 W=2 nf=1 ad=0.58 as=0.58 pd=4.58 ps=4.58 mult=1 m=1
XMNF_op1_0900_pic_rwl_late_hold vn_op1_0900_pic_rwl_late_hold en_op1_0900_pic_rwl_late_hold 0 0 sky130_fd_pr__nfet_01v8 L=0.15 W=2 nf=1 ad=0.58 as=0.58 pd=4.58 ps=4.58 mult=1 m=1
XMPH_op1_0900_pic_rwl_late_hold vp_op1_0900_pic_rwl_late_hold enb_op1_0900_pic_rwl_late_hold vdd vdd sky130_fd_pr__pfet_01v8 L=0.15 W=4 nf=1 ad=1.16 as=1.16 pd=8.58 ps=8.58 mult=1 m=1
bd_op1_0900_pic_rwl_late_hold d_op1_0900_pic_rwl_late_hold 0 v=v(rbl_op1_0900_pic_rwl_late_hold)-v(ref_op1_0900_pic_rwl_late_hold)

* ---- instance 25: op1_1000_pic_rwl_late_hold (variant pic_rwl_late_hold; probe dec 11.9 ns, release 34 ns, meas 36 ns) ----
vctl_op1_1000_pic_rwl_late_hold ctl_op1_1000_pic_rwl_late_hold 0 pwl(0.0000e+00 {VDD} 2.0000e-09 {VDD} 2.1000e-09 0)
vrs_op1_1000_pic_rwl_late_hold rwls_op1_1000_pic_rwl_late_hold 0 pwl(0.0000e+00 {VDD} 2.0000e-09 {VDD} 2.1000e-09 0 3.4000e-08 0 3.4100e-08 {VDD})
ven_op1_1000_pic_rwl_late_hold en_op1_1000_pic_rwl_late_hold 0 pwl(0.0000e+00 0 1.1000e-08 0 1.1100e-08 {VDD} 3.4000e-08 {VDD} 3.4100e-08 0)
venb_op1_1000_pic_rwl_late_hold enb_op1_1000_pic_rwl_late_hold 0 pwl(0.0000e+00 {VDD} 1.1000e-08 {VDD} 1.1100e-08 0 3.4000e-08 0 3.4100e-08 {VDD})
vww_op1_1000_pic_rwl_late_hold wwl_op1_1000_pic_rwl_late_hold 0 pwl(0.0000e+00 0 1.2000e-08 0 1.2100e-08 {VDD} 3.2000e-08 {VDD} 3.2100e-08 0)
vwc_op1_1000_pic_rwl_late_hold wbc_op1_1000_pic_rwl_late_hold 0 pwl(0.0000e+00 0 1.2000e-08 0 1.2100e-08 {VDD} 3.4000e-08 {VDD} 3.4100e-08 0)
swb_op1_1000_pic_rwl_late_hold ref_op1_1000_pic_rwl_late_hold wbl_op1_1000_pic_rwl_late_hold wbc_op1_1000_pic_rwl_late_hold 0 swwbl
cwbl_op1_1000_pic_rwl_late_hold wbl_op1_1000_pic_rwl_late_hold 0 {C_WBL}
spa_op1_1000_pic_rwl_late_hold prea rbl_op1_1000_pic_rwl_late_hold ctl_op1_1000_pic_rwl_late_hold 0 swpre
spr_op1_1000_pic_rwl_late_hold pref ref_op1_1000_pic_rwl_late_hold ctl_op1_1000_pic_rwl_late_hold 0 swpre
crbl_op1_1000_pic_rwl_late_hold rbl_op1_1000_pic_rwl_late_hold 0 {C_RBL}
cref_op1_1000_pic_rwl_late_hold ref_op1_1000_pic_rwl_late_hold 0 {C_RBL}   $ ASSUMPTION: ideal matched dummy load
XMWR_op1_1000_pic_rwl_late_hold_0 sn_op1_1000_pic_rwl_late_hold_0 wwl_op1_1000_pic_rwl_late_hold wbl_op1_1000_pic_rwl_late_hold 0 sky130_fd_pr__nfet_01v8 L=0.15 W=0.42 nf=1 ad=0.1218 as=0.1218 pd=1.42 ps=1.42 nrd=0.69047619047619  nrs=0.69047619047619 sa=0 sb=0 sd=0 mult=1 m=1
XMRD_op1_1000_pic_rwl_late_hold_0 rbl_op1_1000_pic_rwl_late_hold sn_op1_1000_pic_rwl_late_hold_0 rwls_op1_1000_pic_rwl_late_hold 0 sky130_fd_pr__nfet_01v8 L=0.15 W=0.42 nf=1 ad=0.1218 as=0.1218 pd=1.42 ps=1.42 nrd=0.69047619047619  nrs=0.69047619047619 sa=0 sb=0 sd=0 mult=1 m=1
csn_op1_1000_pic_rwl_late_hold_0 sn_op1_1000_pic_rwl_late_hold_0 0 {C_SN}
XMWR_op1_1000_pic_rwl_late_hold_1 sn_op1_1000_pic_rwl_late_hold_1 wwl_des wbl_op1_1000_pic_rwl_late_hold 0 sky130_fd_pr__nfet_01v8 L=0.15 W=0.42 nf=1 ad=0.1218 as=0.1218 pd=1.42 ps=1.42 nrd=0.69047619047619  nrs=0.69047619047619 sa=0 sb=0 sd=0 mult=1 m=1
XMRD_op1_1000_pic_rwl_late_hold_1 rbl_op1_1000_pic_rwl_late_hold sn_op1_1000_pic_rwl_late_hold_1 rwl_des 0 sky130_fd_pr__nfet_01v8 L=0.15 W=0.42 nf=1 ad=0.1218 as=0.1218 pd=1.42 ps=1.42 nrd=0.69047619047619  nrs=0.69047619047619 sa=0 sb=0 sd=0 mult=1 m=1
csn_op1_1000_pic_rwl_late_hold_1 sn_op1_1000_pic_rwl_late_hold_1 0 {C_SN}
XMWR_op1_1000_pic_rwl_late_hold_2 sn_op1_1000_pic_rwl_late_hold_2 wwl_des wbl_op1_1000_pic_rwl_late_hold 0 sky130_fd_pr__nfet_01v8 L=0.15 W=0.42 nf=1 ad=0.1218 as=0.1218 pd=1.42 ps=1.42 nrd=0.69047619047619  nrs=0.69047619047619 sa=0 sb=0 sd=0 mult=1 m=1
XMRD_op1_1000_pic_rwl_late_hold_2 rbl_op1_1000_pic_rwl_late_hold sn_op1_1000_pic_rwl_late_hold_2 rwl_des 0 sky130_fd_pr__nfet_01v8 L=0.15 W=0.42 nf=1 ad=0.1218 as=0.1218 pd=1.42 ps=1.42 nrd=0.69047619047619  nrs=0.69047619047619 sa=0 sb=0 sd=0 mult=1 m=1
csn_op1_1000_pic_rwl_late_hold_2 sn_op1_1000_pic_rwl_late_hold_2 0 {C_SN}
XMWR_op1_1000_pic_rwl_late_hold_3 sn_op1_1000_pic_rwl_late_hold_3 wwl_des wbl_op1_1000_pic_rwl_late_hold 0 sky130_fd_pr__nfet_01v8 L=0.15 W=0.42 nf=1 ad=0.1218 as=0.1218 pd=1.42 ps=1.42 nrd=0.69047619047619  nrs=0.69047619047619 sa=0 sb=0 sd=0 mult=1 m=1
XMRD_op1_1000_pic_rwl_late_hold_3 rbl_op1_1000_pic_rwl_late_hold sn_op1_1000_pic_rwl_late_hold_3 rwl_des 0 sky130_fd_pr__nfet_01v8 L=0.15 W=0.42 nf=1 ad=0.1218 as=0.1218 pd=1.42 ps=1.42 nrd=0.69047619047619  nrs=0.69047619047619 sa=0 sb=0 sd=0 mult=1 m=1
csn_op1_1000_pic_rwl_late_hold_3 sn_op1_1000_pic_rwl_late_hold_3 0 {C_SN}
XMN1_op1_1000_pic_rwl_late_hold rbl_op1_1000_pic_rwl_late_hold ref_op1_1000_pic_rwl_late_hold vn_op1_1000_pic_rwl_late_hold 0 sky130_fd_pr__nfet_01v8 L=0.15 W=1 nf=1 ad=0.29 as=0.29 pd=2.58 ps=2.58 mult=1 m=1
XMN2_op1_1000_pic_rwl_late_hold ref_op1_1000_pic_rwl_late_hold rbl_op1_1000_pic_rwl_late_hold vn_op1_1000_pic_rwl_late_hold 0 sky130_fd_pr__nfet_01v8 L=0.15 W=1 nf=1 ad=0.29 as=0.29 pd=2.58 ps=2.58 mult=1 m=1
XMP1_op1_1000_pic_rwl_late_hold rbl_op1_1000_pic_rwl_late_hold ref_op1_1000_pic_rwl_late_hold vp_op1_1000_pic_rwl_late_hold vdd sky130_fd_pr__pfet_01v8 L=0.15 W=2 nf=1 ad=0.58 as=0.58 pd=4.58 ps=4.58 mult=1 m=1
XMP2_op1_1000_pic_rwl_late_hold ref_op1_1000_pic_rwl_late_hold rbl_op1_1000_pic_rwl_late_hold vp_op1_1000_pic_rwl_late_hold vdd sky130_fd_pr__pfet_01v8 L=0.15 W=2 nf=1 ad=0.58 as=0.58 pd=4.58 ps=4.58 mult=1 m=1
XMNF_op1_1000_pic_rwl_late_hold vn_op1_1000_pic_rwl_late_hold en_op1_1000_pic_rwl_late_hold 0 0 sky130_fd_pr__nfet_01v8 L=0.15 W=2 nf=1 ad=0.58 as=0.58 pd=4.58 ps=4.58 mult=1 m=1
XMPH_op1_1000_pic_rwl_late_hold vp_op1_1000_pic_rwl_late_hold enb_op1_1000_pic_rwl_late_hold vdd vdd sky130_fd_pr__pfet_01v8 L=0.15 W=4 nf=1 ad=1.16 as=1.16 pd=8.58 ps=8.58 mult=1 m=1
bd_op1_1000_pic_rwl_late_hold d_op1_1000_pic_rwl_late_hold 0 v=v(rbl_op1_1000_pic_rwl_late_hold)-v(ref_op1_1000_pic_rwl_late_hold)

* ---- instance 26: op0_n100_pic_rwl_late_hold (variant pic_rwl_late_hold; probe dec 11.9 ns, release 34 ns, meas 36 ns) ----
vctl_op0_n100_pic_rwl_late_hold ctl_op0_n100_pic_rwl_late_hold 0 pwl(0.0000e+00 {VDD} 2.0000e-09 {VDD} 2.1000e-09 0)
vrs_op0_n100_pic_rwl_late_hold rwls_op0_n100_pic_rwl_late_hold 0 pwl(0.0000e+00 {VDD} 2.0000e-09 {VDD} 2.1000e-09 0 3.4000e-08 0 3.4100e-08 {VDD})
ven_op0_n100_pic_rwl_late_hold en_op0_n100_pic_rwl_late_hold 0 pwl(0.0000e+00 0 1.1000e-08 0 1.1100e-08 {VDD} 3.4000e-08 {VDD} 3.4100e-08 0)
venb_op0_n100_pic_rwl_late_hold enb_op0_n100_pic_rwl_late_hold 0 pwl(0.0000e+00 {VDD} 1.1000e-08 {VDD} 1.1100e-08 0 3.4000e-08 0 3.4100e-08 {VDD})
vww_op0_n100_pic_rwl_late_hold wwl_op0_n100_pic_rwl_late_hold 0 pwl(0.0000e+00 0 1.2000e-08 0 1.2100e-08 {VDD} 3.2000e-08 {VDD} 3.2100e-08 0)
vwc_op0_n100_pic_rwl_late_hold wbc_op0_n100_pic_rwl_late_hold 0 pwl(0.0000e+00 0 1.2000e-08 0 1.2100e-08 {VDD} 3.4000e-08 {VDD} 3.4100e-08 0)
swb_op0_n100_pic_rwl_late_hold ref_op0_n100_pic_rwl_late_hold wbl_op0_n100_pic_rwl_late_hold wbc_op0_n100_pic_rwl_late_hold 0 swwbl
cwbl_op0_n100_pic_rwl_late_hold wbl_op0_n100_pic_rwl_late_hold 0 {C_WBL}
spa_op0_n100_pic_rwl_late_hold prea rbl_op0_n100_pic_rwl_late_hold ctl_op0_n100_pic_rwl_late_hold 0 swpre
spr_op0_n100_pic_rwl_late_hold pref ref_op0_n100_pic_rwl_late_hold ctl_op0_n100_pic_rwl_late_hold 0 swpre
crbl_op0_n100_pic_rwl_late_hold rbl_op0_n100_pic_rwl_late_hold 0 {C_RBL}
cref_op0_n100_pic_rwl_late_hold ref_op0_n100_pic_rwl_late_hold 0 {C_RBL}   $ ASSUMPTION: ideal matched dummy load
XMWR_op0_n100_pic_rwl_late_hold_0 sn_op0_n100_pic_rwl_late_hold_0 wwl_op0_n100_pic_rwl_late_hold wbl_op0_n100_pic_rwl_late_hold 0 sky130_fd_pr__nfet_01v8 L=0.15 W=0.42 nf=1 ad=0.1218 as=0.1218 pd=1.42 ps=1.42 nrd=0.69047619047619  nrs=0.69047619047619 sa=0 sb=0 sd=0 mult=1 m=1
XMRD_op0_n100_pic_rwl_late_hold_0 rbl_op0_n100_pic_rwl_late_hold sn_op0_n100_pic_rwl_late_hold_0 rwls_op0_n100_pic_rwl_late_hold 0 sky130_fd_pr__nfet_01v8 L=0.15 W=0.42 nf=1 ad=0.1218 as=0.1218 pd=1.42 ps=1.42 nrd=0.69047619047619  nrs=0.69047619047619 sa=0 sb=0 sd=0 mult=1 m=1
csn_op0_n100_pic_rwl_late_hold_0 sn_op0_n100_pic_rwl_late_hold_0 0 {C_SN}
XMWR_op0_n100_pic_rwl_late_hold_1 sn_op0_n100_pic_rwl_late_hold_1 wwl_des wbl_op0_n100_pic_rwl_late_hold 0 sky130_fd_pr__nfet_01v8 L=0.15 W=0.42 nf=1 ad=0.1218 as=0.1218 pd=1.42 ps=1.42 nrd=0.69047619047619  nrs=0.69047619047619 sa=0 sb=0 sd=0 mult=1 m=1
XMRD_op0_n100_pic_rwl_late_hold_1 rbl_op0_n100_pic_rwl_late_hold sn_op0_n100_pic_rwl_late_hold_1 rwl_des 0 sky130_fd_pr__nfet_01v8 L=0.15 W=0.42 nf=1 ad=0.1218 as=0.1218 pd=1.42 ps=1.42 nrd=0.69047619047619  nrs=0.69047619047619 sa=0 sb=0 sd=0 mult=1 m=1
csn_op0_n100_pic_rwl_late_hold_1 sn_op0_n100_pic_rwl_late_hold_1 0 {C_SN}
XMWR_op0_n100_pic_rwl_late_hold_2 sn_op0_n100_pic_rwl_late_hold_2 wwl_des wbl_op0_n100_pic_rwl_late_hold 0 sky130_fd_pr__nfet_01v8 L=0.15 W=0.42 nf=1 ad=0.1218 as=0.1218 pd=1.42 ps=1.42 nrd=0.69047619047619  nrs=0.69047619047619 sa=0 sb=0 sd=0 mult=1 m=1
XMRD_op0_n100_pic_rwl_late_hold_2 rbl_op0_n100_pic_rwl_late_hold sn_op0_n100_pic_rwl_late_hold_2 rwl_des 0 sky130_fd_pr__nfet_01v8 L=0.15 W=0.42 nf=1 ad=0.1218 as=0.1218 pd=1.42 ps=1.42 nrd=0.69047619047619  nrs=0.69047619047619 sa=0 sb=0 sd=0 mult=1 m=1
csn_op0_n100_pic_rwl_late_hold_2 sn_op0_n100_pic_rwl_late_hold_2 0 {C_SN}
XMWR_op0_n100_pic_rwl_late_hold_3 sn_op0_n100_pic_rwl_late_hold_3 wwl_des wbl_op0_n100_pic_rwl_late_hold 0 sky130_fd_pr__nfet_01v8 L=0.15 W=0.42 nf=1 ad=0.1218 as=0.1218 pd=1.42 ps=1.42 nrd=0.69047619047619  nrs=0.69047619047619 sa=0 sb=0 sd=0 mult=1 m=1
XMRD_op0_n100_pic_rwl_late_hold_3 rbl_op0_n100_pic_rwl_late_hold sn_op0_n100_pic_rwl_late_hold_3 rwl_des 0 sky130_fd_pr__nfet_01v8 L=0.15 W=0.42 nf=1 ad=0.1218 as=0.1218 pd=1.42 ps=1.42 nrd=0.69047619047619  nrs=0.69047619047619 sa=0 sb=0 sd=0 mult=1 m=1
csn_op0_n100_pic_rwl_late_hold_3 sn_op0_n100_pic_rwl_late_hold_3 0 {C_SN}
XMN1_op0_n100_pic_rwl_late_hold rbl_op0_n100_pic_rwl_late_hold ref_op0_n100_pic_rwl_late_hold vn_op0_n100_pic_rwl_late_hold 0 sky130_fd_pr__nfet_01v8 L=0.15 W=1 nf=1 ad=0.29 as=0.29 pd=2.58 ps=2.58 mult=1 m=1
XMN2_op0_n100_pic_rwl_late_hold ref_op0_n100_pic_rwl_late_hold rbl_op0_n100_pic_rwl_late_hold vn_op0_n100_pic_rwl_late_hold 0 sky130_fd_pr__nfet_01v8 L=0.15 W=1 nf=1 ad=0.29 as=0.29 pd=2.58 ps=2.58 mult=1 m=1
XMP1_op0_n100_pic_rwl_late_hold rbl_op0_n100_pic_rwl_late_hold ref_op0_n100_pic_rwl_late_hold vp_op0_n100_pic_rwl_late_hold vdd sky130_fd_pr__pfet_01v8 L=0.15 W=2 nf=1 ad=0.58 as=0.58 pd=4.58 ps=4.58 mult=1 m=1
XMP2_op0_n100_pic_rwl_late_hold ref_op0_n100_pic_rwl_late_hold rbl_op0_n100_pic_rwl_late_hold vp_op0_n100_pic_rwl_late_hold vdd sky130_fd_pr__pfet_01v8 L=0.15 W=2 nf=1 ad=0.58 as=0.58 pd=4.58 ps=4.58 mult=1 m=1
XMNF_op0_n100_pic_rwl_late_hold vn_op0_n100_pic_rwl_late_hold en_op0_n100_pic_rwl_late_hold 0 0 sky130_fd_pr__nfet_01v8 L=0.15 W=2 nf=1 ad=0.58 as=0.58 pd=4.58 ps=4.58 mult=1 m=1
XMPH_op0_n100_pic_rwl_late_hold vp_op0_n100_pic_rwl_late_hold enb_op0_n100_pic_rwl_late_hold vdd vdd sky130_fd_pr__pfet_01v8 L=0.15 W=4 nf=1 ad=1.16 as=1.16 pd=8.58 ps=8.58 mult=1 m=1
bd_op0_n100_pic_rwl_late_hold d_op0_n100_pic_rwl_late_hold 0 v=v(rbl_op0_n100_pic_rwl_late_hold)-v(ref_op0_n100_pic_rwl_late_hold)

* ---- instance 27: op0_0000_pic_rwl_late_hold (variant pic_rwl_late_hold; probe dec 11.9 ns, release 34 ns, meas 36 ns) ----
vctl_op0_0000_pic_rwl_late_hold ctl_op0_0000_pic_rwl_late_hold 0 pwl(0.0000e+00 {VDD} 2.0000e-09 {VDD} 2.1000e-09 0)
vrs_op0_0000_pic_rwl_late_hold rwls_op0_0000_pic_rwl_late_hold 0 pwl(0.0000e+00 {VDD} 2.0000e-09 {VDD} 2.1000e-09 0 3.4000e-08 0 3.4100e-08 {VDD})
ven_op0_0000_pic_rwl_late_hold en_op0_0000_pic_rwl_late_hold 0 pwl(0.0000e+00 0 1.1000e-08 0 1.1100e-08 {VDD} 3.4000e-08 {VDD} 3.4100e-08 0)
venb_op0_0000_pic_rwl_late_hold enb_op0_0000_pic_rwl_late_hold 0 pwl(0.0000e+00 {VDD} 1.1000e-08 {VDD} 1.1100e-08 0 3.4000e-08 0 3.4100e-08 {VDD})
vww_op0_0000_pic_rwl_late_hold wwl_op0_0000_pic_rwl_late_hold 0 pwl(0.0000e+00 0 1.2000e-08 0 1.2100e-08 {VDD} 3.2000e-08 {VDD} 3.2100e-08 0)
vwc_op0_0000_pic_rwl_late_hold wbc_op0_0000_pic_rwl_late_hold 0 pwl(0.0000e+00 0 1.2000e-08 0 1.2100e-08 {VDD} 3.4000e-08 {VDD} 3.4100e-08 0)
swb_op0_0000_pic_rwl_late_hold ref_op0_0000_pic_rwl_late_hold wbl_op0_0000_pic_rwl_late_hold wbc_op0_0000_pic_rwl_late_hold 0 swwbl
cwbl_op0_0000_pic_rwl_late_hold wbl_op0_0000_pic_rwl_late_hold 0 {C_WBL}
spa_op0_0000_pic_rwl_late_hold prea rbl_op0_0000_pic_rwl_late_hold ctl_op0_0000_pic_rwl_late_hold 0 swpre
spr_op0_0000_pic_rwl_late_hold pref ref_op0_0000_pic_rwl_late_hold ctl_op0_0000_pic_rwl_late_hold 0 swpre
crbl_op0_0000_pic_rwl_late_hold rbl_op0_0000_pic_rwl_late_hold 0 {C_RBL}
cref_op0_0000_pic_rwl_late_hold ref_op0_0000_pic_rwl_late_hold 0 {C_RBL}   $ ASSUMPTION: ideal matched dummy load
XMWR_op0_0000_pic_rwl_late_hold_0 sn_op0_0000_pic_rwl_late_hold_0 wwl_op0_0000_pic_rwl_late_hold wbl_op0_0000_pic_rwl_late_hold 0 sky130_fd_pr__nfet_01v8 L=0.15 W=0.42 nf=1 ad=0.1218 as=0.1218 pd=1.42 ps=1.42 nrd=0.69047619047619  nrs=0.69047619047619 sa=0 sb=0 sd=0 mult=1 m=1
XMRD_op0_0000_pic_rwl_late_hold_0 rbl_op0_0000_pic_rwl_late_hold sn_op0_0000_pic_rwl_late_hold_0 rwls_op0_0000_pic_rwl_late_hold 0 sky130_fd_pr__nfet_01v8 L=0.15 W=0.42 nf=1 ad=0.1218 as=0.1218 pd=1.42 ps=1.42 nrd=0.69047619047619  nrs=0.69047619047619 sa=0 sb=0 sd=0 mult=1 m=1
csn_op0_0000_pic_rwl_late_hold_0 sn_op0_0000_pic_rwl_late_hold_0 0 {C_SN}
XMWR_op0_0000_pic_rwl_late_hold_1 sn_op0_0000_pic_rwl_late_hold_1 wwl_des wbl_op0_0000_pic_rwl_late_hold 0 sky130_fd_pr__nfet_01v8 L=0.15 W=0.42 nf=1 ad=0.1218 as=0.1218 pd=1.42 ps=1.42 nrd=0.69047619047619  nrs=0.69047619047619 sa=0 sb=0 sd=0 mult=1 m=1
XMRD_op0_0000_pic_rwl_late_hold_1 rbl_op0_0000_pic_rwl_late_hold sn_op0_0000_pic_rwl_late_hold_1 rwl_des 0 sky130_fd_pr__nfet_01v8 L=0.15 W=0.42 nf=1 ad=0.1218 as=0.1218 pd=1.42 ps=1.42 nrd=0.69047619047619  nrs=0.69047619047619 sa=0 sb=0 sd=0 mult=1 m=1
csn_op0_0000_pic_rwl_late_hold_1 sn_op0_0000_pic_rwl_late_hold_1 0 {C_SN}
XMWR_op0_0000_pic_rwl_late_hold_2 sn_op0_0000_pic_rwl_late_hold_2 wwl_des wbl_op0_0000_pic_rwl_late_hold 0 sky130_fd_pr__nfet_01v8 L=0.15 W=0.42 nf=1 ad=0.1218 as=0.1218 pd=1.42 ps=1.42 nrd=0.69047619047619  nrs=0.69047619047619 sa=0 sb=0 sd=0 mult=1 m=1
XMRD_op0_0000_pic_rwl_late_hold_2 rbl_op0_0000_pic_rwl_late_hold sn_op0_0000_pic_rwl_late_hold_2 rwl_des 0 sky130_fd_pr__nfet_01v8 L=0.15 W=0.42 nf=1 ad=0.1218 as=0.1218 pd=1.42 ps=1.42 nrd=0.69047619047619  nrs=0.69047619047619 sa=0 sb=0 sd=0 mult=1 m=1
csn_op0_0000_pic_rwl_late_hold_2 sn_op0_0000_pic_rwl_late_hold_2 0 {C_SN}
XMWR_op0_0000_pic_rwl_late_hold_3 sn_op0_0000_pic_rwl_late_hold_3 wwl_des wbl_op0_0000_pic_rwl_late_hold 0 sky130_fd_pr__nfet_01v8 L=0.15 W=0.42 nf=1 ad=0.1218 as=0.1218 pd=1.42 ps=1.42 nrd=0.69047619047619  nrs=0.69047619047619 sa=0 sb=0 sd=0 mult=1 m=1
XMRD_op0_0000_pic_rwl_late_hold_3 rbl_op0_0000_pic_rwl_late_hold sn_op0_0000_pic_rwl_late_hold_3 rwl_des 0 sky130_fd_pr__nfet_01v8 L=0.15 W=0.42 nf=1 ad=0.1218 as=0.1218 pd=1.42 ps=1.42 nrd=0.69047619047619  nrs=0.69047619047619 sa=0 sb=0 sd=0 mult=1 m=1
csn_op0_0000_pic_rwl_late_hold_3 sn_op0_0000_pic_rwl_late_hold_3 0 {C_SN}
XMN1_op0_0000_pic_rwl_late_hold rbl_op0_0000_pic_rwl_late_hold ref_op0_0000_pic_rwl_late_hold vn_op0_0000_pic_rwl_late_hold 0 sky130_fd_pr__nfet_01v8 L=0.15 W=1 nf=1 ad=0.29 as=0.29 pd=2.58 ps=2.58 mult=1 m=1
XMN2_op0_0000_pic_rwl_late_hold ref_op0_0000_pic_rwl_late_hold rbl_op0_0000_pic_rwl_late_hold vn_op0_0000_pic_rwl_late_hold 0 sky130_fd_pr__nfet_01v8 L=0.15 W=1 nf=1 ad=0.29 as=0.29 pd=2.58 ps=2.58 mult=1 m=1
XMP1_op0_0000_pic_rwl_late_hold rbl_op0_0000_pic_rwl_late_hold ref_op0_0000_pic_rwl_late_hold vp_op0_0000_pic_rwl_late_hold vdd sky130_fd_pr__pfet_01v8 L=0.15 W=2 nf=1 ad=0.58 as=0.58 pd=4.58 ps=4.58 mult=1 m=1
XMP2_op0_0000_pic_rwl_late_hold ref_op0_0000_pic_rwl_late_hold rbl_op0_0000_pic_rwl_late_hold vp_op0_0000_pic_rwl_late_hold vdd sky130_fd_pr__pfet_01v8 L=0.15 W=2 nf=1 ad=0.58 as=0.58 pd=4.58 ps=4.58 mult=1 m=1
XMNF_op0_0000_pic_rwl_late_hold vn_op0_0000_pic_rwl_late_hold en_op0_0000_pic_rwl_late_hold 0 0 sky130_fd_pr__nfet_01v8 L=0.15 W=2 nf=1 ad=0.58 as=0.58 pd=4.58 ps=4.58 mult=1 m=1
XMPH_op0_0000_pic_rwl_late_hold vp_op0_0000_pic_rwl_late_hold enb_op0_0000_pic_rwl_late_hold vdd vdd sky130_fd_pr__pfet_01v8 L=0.15 W=4 nf=1 ad=1.16 as=1.16 pd=8.58 ps=8.58 mult=1 m=1
bd_op0_0000_pic_rwl_late_hold d_op0_0000_pic_rwl_late_hold 0 v=v(rbl_op0_0000_pic_rwl_late_hold)-v(ref_op0_0000_pic_rwl_late_hold)

* ---- instance 28: op1_0900_pic_neg_missing_wb (variant pic_neg_missing_wb; probe dec 11.9 ns, release 34 ns, meas 36 ns) ----
vctl_op1_0900_pic_neg_missing_wb ctl_op1_0900_pic_neg_missing_wb 0 pwl(0.0000e+00 {VDD} 2.0000e-09 {VDD} 2.1000e-09 0)
vrs_op1_0900_pic_neg_missing_wb rwls_op1_0900_pic_neg_missing_wb 0 pwl(0.0000e+00 {VDD} 2.0000e-09 {VDD} 2.1000e-09 0 1.2000e-08 0 1.2100e-08 {VDD})
ven_op1_0900_pic_neg_missing_wb en_op1_0900_pic_neg_missing_wb 0 pwl(0.0000e+00 0 1.1000e-08 0 1.1100e-08 {VDD} 3.4000e-08 {VDD} 3.4100e-08 0)
venb_op1_0900_pic_neg_missing_wb enb_op1_0900_pic_neg_missing_wb 0 pwl(0.0000e+00 {VDD} 1.1000e-08 {VDD} 1.1100e-08 0 3.4000e-08 0 3.4100e-08 {VDD})
vww_op1_0900_pic_neg_missing_wb wwl_op1_0900_pic_neg_missing_wb 0 pwl(0.0000e+00 0)
vwc_op1_0900_pic_neg_missing_wb wbc_op1_0900_pic_neg_missing_wb 0 pwl(0.0000e+00 0)
swb_op1_0900_pic_neg_missing_wb ref_op1_0900_pic_neg_missing_wb wbl_op1_0900_pic_neg_missing_wb wbc_op1_0900_pic_neg_missing_wb 0 swwbl
cwbl_op1_0900_pic_neg_missing_wb wbl_op1_0900_pic_neg_missing_wb 0 {C_WBL}
spa_op1_0900_pic_neg_missing_wb prea rbl_op1_0900_pic_neg_missing_wb ctl_op1_0900_pic_neg_missing_wb 0 swpre
spr_op1_0900_pic_neg_missing_wb pref ref_op1_0900_pic_neg_missing_wb ctl_op1_0900_pic_neg_missing_wb 0 swpre
crbl_op1_0900_pic_neg_missing_wb rbl_op1_0900_pic_neg_missing_wb 0 {C_RBL}
cref_op1_0900_pic_neg_missing_wb ref_op1_0900_pic_neg_missing_wb 0 {C_RBL}   $ ASSUMPTION: ideal matched dummy load
XMWR_op1_0900_pic_neg_missing_wb_0 sn_op1_0900_pic_neg_missing_wb_0 wwl_op1_0900_pic_neg_missing_wb wbl_op1_0900_pic_neg_missing_wb 0 sky130_fd_pr__nfet_01v8 L=0.15 W=0.42 nf=1 ad=0.1218 as=0.1218 pd=1.42 ps=1.42 nrd=0.69047619047619  nrs=0.69047619047619 sa=0 sb=0 sd=0 mult=1 m=1
XMRD_op1_0900_pic_neg_missing_wb_0 rbl_op1_0900_pic_neg_missing_wb sn_op1_0900_pic_neg_missing_wb_0 rwls_op1_0900_pic_neg_missing_wb 0 sky130_fd_pr__nfet_01v8 L=0.15 W=0.42 nf=1 ad=0.1218 as=0.1218 pd=1.42 ps=1.42 nrd=0.69047619047619  nrs=0.69047619047619 sa=0 sb=0 sd=0 mult=1 m=1
csn_op1_0900_pic_neg_missing_wb_0 sn_op1_0900_pic_neg_missing_wb_0 0 {C_SN}
XMWR_op1_0900_pic_neg_missing_wb_1 sn_op1_0900_pic_neg_missing_wb_1 wwl_des wbl_op1_0900_pic_neg_missing_wb 0 sky130_fd_pr__nfet_01v8 L=0.15 W=0.42 nf=1 ad=0.1218 as=0.1218 pd=1.42 ps=1.42 nrd=0.69047619047619  nrs=0.69047619047619 sa=0 sb=0 sd=0 mult=1 m=1
XMRD_op1_0900_pic_neg_missing_wb_1 rbl_op1_0900_pic_neg_missing_wb sn_op1_0900_pic_neg_missing_wb_1 rwl_des 0 sky130_fd_pr__nfet_01v8 L=0.15 W=0.42 nf=1 ad=0.1218 as=0.1218 pd=1.42 ps=1.42 nrd=0.69047619047619  nrs=0.69047619047619 sa=0 sb=0 sd=0 mult=1 m=1
csn_op1_0900_pic_neg_missing_wb_1 sn_op1_0900_pic_neg_missing_wb_1 0 {C_SN}
XMWR_op1_0900_pic_neg_missing_wb_2 sn_op1_0900_pic_neg_missing_wb_2 wwl_des wbl_op1_0900_pic_neg_missing_wb 0 sky130_fd_pr__nfet_01v8 L=0.15 W=0.42 nf=1 ad=0.1218 as=0.1218 pd=1.42 ps=1.42 nrd=0.69047619047619  nrs=0.69047619047619 sa=0 sb=0 sd=0 mult=1 m=1
XMRD_op1_0900_pic_neg_missing_wb_2 rbl_op1_0900_pic_neg_missing_wb sn_op1_0900_pic_neg_missing_wb_2 rwl_des 0 sky130_fd_pr__nfet_01v8 L=0.15 W=0.42 nf=1 ad=0.1218 as=0.1218 pd=1.42 ps=1.42 nrd=0.69047619047619  nrs=0.69047619047619 sa=0 sb=0 sd=0 mult=1 m=1
csn_op1_0900_pic_neg_missing_wb_2 sn_op1_0900_pic_neg_missing_wb_2 0 {C_SN}
XMWR_op1_0900_pic_neg_missing_wb_3 sn_op1_0900_pic_neg_missing_wb_3 wwl_des wbl_op1_0900_pic_neg_missing_wb 0 sky130_fd_pr__nfet_01v8 L=0.15 W=0.42 nf=1 ad=0.1218 as=0.1218 pd=1.42 ps=1.42 nrd=0.69047619047619  nrs=0.69047619047619 sa=0 sb=0 sd=0 mult=1 m=1
XMRD_op1_0900_pic_neg_missing_wb_3 rbl_op1_0900_pic_neg_missing_wb sn_op1_0900_pic_neg_missing_wb_3 rwl_des 0 sky130_fd_pr__nfet_01v8 L=0.15 W=0.42 nf=1 ad=0.1218 as=0.1218 pd=1.42 ps=1.42 nrd=0.69047619047619  nrs=0.69047619047619 sa=0 sb=0 sd=0 mult=1 m=1
csn_op1_0900_pic_neg_missing_wb_3 sn_op1_0900_pic_neg_missing_wb_3 0 {C_SN}
XMN1_op1_0900_pic_neg_missing_wb rbl_op1_0900_pic_neg_missing_wb ref_op1_0900_pic_neg_missing_wb vn_op1_0900_pic_neg_missing_wb 0 sky130_fd_pr__nfet_01v8 L=0.15 W=1 nf=1 ad=0.29 as=0.29 pd=2.58 ps=2.58 mult=1 m=1
XMN2_op1_0900_pic_neg_missing_wb ref_op1_0900_pic_neg_missing_wb rbl_op1_0900_pic_neg_missing_wb vn_op1_0900_pic_neg_missing_wb 0 sky130_fd_pr__nfet_01v8 L=0.15 W=1 nf=1 ad=0.29 as=0.29 pd=2.58 ps=2.58 mult=1 m=1
XMP1_op1_0900_pic_neg_missing_wb rbl_op1_0900_pic_neg_missing_wb ref_op1_0900_pic_neg_missing_wb vp_op1_0900_pic_neg_missing_wb vdd sky130_fd_pr__pfet_01v8 L=0.15 W=2 nf=1 ad=0.58 as=0.58 pd=4.58 ps=4.58 mult=1 m=1
XMP2_op1_0900_pic_neg_missing_wb ref_op1_0900_pic_neg_missing_wb rbl_op1_0900_pic_neg_missing_wb vp_op1_0900_pic_neg_missing_wb vdd sky130_fd_pr__pfet_01v8 L=0.15 W=2 nf=1 ad=0.58 as=0.58 pd=4.58 ps=4.58 mult=1 m=1
XMNF_op1_0900_pic_neg_missing_wb vn_op1_0900_pic_neg_missing_wb en_op1_0900_pic_neg_missing_wb 0 0 sky130_fd_pr__nfet_01v8 L=0.15 W=2 nf=1 ad=0.58 as=0.58 pd=4.58 ps=4.58 mult=1 m=1
XMPH_op1_0900_pic_neg_missing_wb vp_op1_0900_pic_neg_missing_wb enb_op1_0900_pic_neg_missing_wb vdd vdd sky130_fd_pr__pfet_01v8 L=0.15 W=4 nf=1 ad=1.16 as=1.16 pd=8.58 ps=8.58 mult=1 m=1
bd_op1_0900_pic_neg_missing_wb d_op1_0900_pic_neg_missing_wb 0 v=v(rbl_op1_0900_pic_neg_missing_wb)-v(ref_op1_0900_pic_neg_missing_wb)

* ---- instance 29: op1_1000_pic_neg_missing_wb (variant pic_neg_missing_wb; probe dec 11.9 ns, release 34 ns, meas 36 ns) ----
vctl_op1_1000_pic_neg_missing_wb ctl_op1_1000_pic_neg_missing_wb 0 pwl(0.0000e+00 {VDD} 2.0000e-09 {VDD} 2.1000e-09 0)
vrs_op1_1000_pic_neg_missing_wb rwls_op1_1000_pic_neg_missing_wb 0 pwl(0.0000e+00 {VDD} 2.0000e-09 {VDD} 2.1000e-09 0 1.2000e-08 0 1.2100e-08 {VDD})
ven_op1_1000_pic_neg_missing_wb en_op1_1000_pic_neg_missing_wb 0 pwl(0.0000e+00 0 1.1000e-08 0 1.1100e-08 {VDD} 3.4000e-08 {VDD} 3.4100e-08 0)
venb_op1_1000_pic_neg_missing_wb enb_op1_1000_pic_neg_missing_wb 0 pwl(0.0000e+00 {VDD} 1.1000e-08 {VDD} 1.1100e-08 0 3.4000e-08 0 3.4100e-08 {VDD})
vww_op1_1000_pic_neg_missing_wb wwl_op1_1000_pic_neg_missing_wb 0 pwl(0.0000e+00 0)
vwc_op1_1000_pic_neg_missing_wb wbc_op1_1000_pic_neg_missing_wb 0 pwl(0.0000e+00 0)
swb_op1_1000_pic_neg_missing_wb ref_op1_1000_pic_neg_missing_wb wbl_op1_1000_pic_neg_missing_wb wbc_op1_1000_pic_neg_missing_wb 0 swwbl
cwbl_op1_1000_pic_neg_missing_wb wbl_op1_1000_pic_neg_missing_wb 0 {C_WBL}
spa_op1_1000_pic_neg_missing_wb prea rbl_op1_1000_pic_neg_missing_wb ctl_op1_1000_pic_neg_missing_wb 0 swpre
spr_op1_1000_pic_neg_missing_wb pref ref_op1_1000_pic_neg_missing_wb ctl_op1_1000_pic_neg_missing_wb 0 swpre
crbl_op1_1000_pic_neg_missing_wb rbl_op1_1000_pic_neg_missing_wb 0 {C_RBL}
cref_op1_1000_pic_neg_missing_wb ref_op1_1000_pic_neg_missing_wb 0 {C_RBL}   $ ASSUMPTION: ideal matched dummy load
XMWR_op1_1000_pic_neg_missing_wb_0 sn_op1_1000_pic_neg_missing_wb_0 wwl_op1_1000_pic_neg_missing_wb wbl_op1_1000_pic_neg_missing_wb 0 sky130_fd_pr__nfet_01v8 L=0.15 W=0.42 nf=1 ad=0.1218 as=0.1218 pd=1.42 ps=1.42 nrd=0.69047619047619  nrs=0.69047619047619 sa=0 sb=0 sd=0 mult=1 m=1
XMRD_op1_1000_pic_neg_missing_wb_0 rbl_op1_1000_pic_neg_missing_wb sn_op1_1000_pic_neg_missing_wb_0 rwls_op1_1000_pic_neg_missing_wb 0 sky130_fd_pr__nfet_01v8 L=0.15 W=0.42 nf=1 ad=0.1218 as=0.1218 pd=1.42 ps=1.42 nrd=0.69047619047619  nrs=0.69047619047619 sa=0 sb=0 sd=0 mult=1 m=1
csn_op1_1000_pic_neg_missing_wb_0 sn_op1_1000_pic_neg_missing_wb_0 0 {C_SN}
XMWR_op1_1000_pic_neg_missing_wb_1 sn_op1_1000_pic_neg_missing_wb_1 wwl_des wbl_op1_1000_pic_neg_missing_wb 0 sky130_fd_pr__nfet_01v8 L=0.15 W=0.42 nf=1 ad=0.1218 as=0.1218 pd=1.42 ps=1.42 nrd=0.69047619047619  nrs=0.69047619047619 sa=0 sb=0 sd=0 mult=1 m=1
XMRD_op1_1000_pic_neg_missing_wb_1 rbl_op1_1000_pic_neg_missing_wb sn_op1_1000_pic_neg_missing_wb_1 rwl_des 0 sky130_fd_pr__nfet_01v8 L=0.15 W=0.42 nf=1 ad=0.1218 as=0.1218 pd=1.42 ps=1.42 nrd=0.69047619047619  nrs=0.69047619047619 sa=0 sb=0 sd=0 mult=1 m=1
csn_op1_1000_pic_neg_missing_wb_1 sn_op1_1000_pic_neg_missing_wb_1 0 {C_SN}
XMWR_op1_1000_pic_neg_missing_wb_2 sn_op1_1000_pic_neg_missing_wb_2 wwl_des wbl_op1_1000_pic_neg_missing_wb 0 sky130_fd_pr__nfet_01v8 L=0.15 W=0.42 nf=1 ad=0.1218 as=0.1218 pd=1.42 ps=1.42 nrd=0.69047619047619  nrs=0.69047619047619 sa=0 sb=0 sd=0 mult=1 m=1
XMRD_op1_1000_pic_neg_missing_wb_2 rbl_op1_1000_pic_neg_missing_wb sn_op1_1000_pic_neg_missing_wb_2 rwl_des 0 sky130_fd_pr__nfet_01v8 L=0.15 W=0.42 nf=1 ad=0.1218 as=0.1218 pd=1.42 ps=1.42 nrd=0.69047619047619  nrs=0.69047619047619 sa=0 sb=0 sd=0 mult=1 m=1
csn_op1_1000_pic_neg_missing_wb_2 sn_op1_1000_pic_neg_missing_wb_2 0 {C_SN}
XMWR_op1_1000_pic_neg_missing_wb_3 sn_op1_1000_pic_neg_missing_wb_3 wwl_des wbl_op1_1000_pic_neg_missing_wb 0 sky130_fd_pr__nfet_01v8 L=0.15 W=0.42 nf=1 ad=0.1218 as=0.1218 pd=1.42 ps=1.42 nrd=0.69047619047619  nrs=0.69047619047619 sa=0 sb=0 sd=0 mult=1 m=1
XMRD_op1_1000_pic_neg_missing_wb_3 rbl_op1_1000_pic_neg_missing_wb sn_op1_1000_pic_neg_missing_wb_3 rwl_des 0 sky130_fd_pr__nfet_01v8 L=0.15 W=0.42 nf=1 ad=0.1218 as=0.1218 pd=1.42 ps=1.42 nrd=0.69047619047619  nrs=0.69047619047619 sa=0 sb=0 sd=0 mult=1 m=1
csn_op1_1000_pic_neg_missing_wb_3 sn_op1_1000_pic_neg_missing_wb_3 0 {C_SN}
XMN1_op1_1000_pic_neg_missing_wb rbl_op1_1000_pic_neg_missing_wb ref_op1_1000_pic_neg_missing_wb vn_op1_1000_pic_neg_missing_wb 0 sky130_fd_pr__nfet_01v8 L=0.15 W=1 nf=1 ad=0.29 as=0.29 pd=2.58 ps=2.58 mult=1 m=1
XMN2_op1_1000_pic_neg_missing_wb ref_op1_1000_pic_neg_missing_wb rbl_op1_1000_pic_neg_missing_wb vn_op1_1000_pic_neg_missing_wb 0 sky130_fd_pr__nfet_01v8 L=0.15 W=1 nf=1 ad=0.29 as=0.29 pd=2.58 ps=2.58 mult=1 m=1
XMP1_op1_1000_pic_neg_missing_wb rbl_op1_1000_pic_neg_missing_wb ref_op1_1000_pic_neg_missing_wb vp_op1_1000_pic_neg_missing_wb vdd sky130_fd_pr__pfet_01v8 L=0.15 W=2 nf=1 ad=0.58 as=0.58 pd=4.58 ps=4.58 mult=1 m=1
XMP2_op1_1000_pic_neg_missing_wb ref_op1_1000_pic_neg_missing_wb rbl_op1_1000_pic_neg_missing_wb vp_op1_1000_pic_neg_missing_wb vdd sky130_fd_pr__pfet_01v8 L=0.15 W=2 nf=1 ad=0.58 as=0.58 pd=4.58 ps=4.58 mult=1 m=1
XMNF_op1_1000_pic_neg_missing_wb vn_op1_1000_pic_neg_missing_wb en_op1_1000_pic_neg_missing_wb 0 0 sky130_fd_pr__nfet_01v8 L=0.15 W=2 nf=1 ad=0.58 as=0.58 pd=4.58 ps=4.58 mult=1 m=1
XMPH_op1_1000_pic_neg_missing_wb vp_op1_1000_pic_neg_missing_wb enb_op1_1000_pic_neg_missing_wb vdd vdd sky130_fd_pr__pfet_01v8 L=0.15 W=4 nf=1 ad=1.16 as=1.16 pd=8.58 ps=8.58 mult=1 m=1
bd_op1_1000_pic_neg_missing_wb d_op1_1000_pic_neg_missing_wb 0 v=v(rbl_op1_1000_pic_neg_missing_wb)-v(ref_op1_1000_pic_neg_missing_wb)

* ---- instance 30: op0_n100_pic_neg_missing_wb (variant pic_neg_missing_wb; probe dec 11.9 ns, release 34 ns, meas 36 ns) ----
vctl_op0_n100_pic_neg_missing_wb ctl_op0_n100_pic_neg_missing_wb 0 pwl(0.0000e+00 {VDD} 2.0000e-09 {VDD} 2.1000e-09 0)
vrs_op0_n100_pic_neg_missing_wb rwls_op0_n100_pic_neg_missing_wb 0 pwl(0.0000e+00 {VDD} 2.0000e-09 {VDD} 2.1000e-09 0 1.2000e-08 0 1.2100e-08 {VDD})
ven_op0_n100_pic_neg_missing_wb en_op0_n100_pic_neg_missing_wb 0 pwl(0.0000e+00 0 1.1000e-08 0 1.1100e-08 {VDD} 3.4000e-08 {VDD} 3.4100e-08 0)
venb_op0_n100_pic_neg_missing_wb enb_op0_n100_pic_neg_missing_wb 0 pwl(0.0000e+00 {VDD} 1.1000e-08 {VDD} 1.1100e-08 0 3.4000e-08 0 3.4100e-08 {VDD})
vww_op0_n100_pic_neg_missing_wb wwl_op0_n100_pic_neg_missing_wb 0 pwl(0.0000e+00 0)
vwc_op0_n100_pic_neg_missing_wb wbc_op0_n100_pic_neg_missing_wb 0 pwl(0.0000e+00 0)
swb_op0_n100_pic_neg_missing_wb ref_op0_n100_pic_neg_missing_wb wbl_op0_n100_pic_neg_missing_wb wbc_op0_n100_pic_neg_missing_wb 0 swwbl
cwbl_op0_n100_pic_neg_missing_wb wbl_op0_n100_pic_neg_missing_wb 0 {C_WBL}
spa_op0_n100_pic_neg_missing_wb prea rbl_op0_n100_pic_neg_missing_wb ctl_op0_n100_pic_neg_missing_wb 0 swpre
spr_op0_n100_pic_neg_missing_wb pref ref_op0_n100_pic_neg_missing_wb ctl_op0_n100_pic_neg_missing_wb 0 swpre
crbl_op0_n100_pic_neg_missing_wb rbl_op0_n100_pic_neg_missing_wb 0 {C_RBL}
cref_op0_n100_pic_neg_missing_wb ref_op0_n100_pic_neg_missing_wb 0 {C_RBL}   $ ASSUMPTION: ideal matched dummy load
XMWR_op0_n100_pic_neg_missing_wb_0 sn_op0_n100_pic_neg_missing_wb_0 wwl_op0_n100_pic_neg_missing_wb wbl_op0_n100_pic_neg_missing_wb 0 sky130_fd_pr__nfet_01v8 L=0.15 W=0.42 nf=1 ad=0.1218 as=0.1218 pd=1.42 ps=1.42 nrd=0.69047619047619  nrs=0.69047619047619 sa=0 sb=0 sd=0 mult=1 m=1
XMRD_op0_n100_pic_neg_missing_wb_0 rbl_op0_n100_pic_neg_missing_wb sn_op0_n100_pic_neg_missing_wb_0 rwls_op0_n100_pic_neg_missing_wb 0 sky130_fd_pr__nfet_01v8 L=0.15 W=0.42 nf=1 ad=0.1218 as=0.1218 pd=1.42 ps=1.42 nrd=0.69047619047619  nrs=0.69047619047619 sa=0 sb=0 sd=0 mult=1 m=1
csn_op0_n100_pic_neg_missing_wb_0 sn_op0_n100_pic_neg_missing_wb_0 0 {C_SN}
XMWR_op0_n100_pic_neg_missing_wb_1 sn_op0_n100_pic_neg_missing_wb_1 wwl_des wbl_op0_n100_pic_neg_missing_wb 0 sky130_fd_pr__nfet_01v8 L=0.15 W=0.42 nf=1 ad=0.1218 as=0.1218 pd=1.42 ps=1.42 nrd=0.69047619047619  nrs=0.69047619047619 sa=0 sb=0 sd=0 mult=1 m=1
XMRD_op0_n100_pic_neg_missing_wb_1 rbl_op0_n100_pic_neg_missing_wb sn_op0_n100_pic_neg_missing_wb_1 rwl_des 0 sky130_fd_pr__nfet_01v8 L=0.15 W=0.42 nf=1 ad=0.1218 as=0.1218 pd=1.42 ps=1.42 nrd=0.69047619047619  nrs=0.69047619047619 sa=0 sb=0 sd=0 mult=1 m=1
csn_op0_n100_pic_neg_missing_wb_1 sn_op0_n100_pic_neg_missing_wb_1 0 {C_SN}
XMWR_op0_n100_pic_neg_missing_wb_2 sn_op0_n100_pic_neg_missing_wb_2 wwl_des wbl_op0_n100_pic_neg_missing_wb 0 sky130_fd_pr__nfet_01v8 L=0.15 W=0.42 nf=1 ad=0.1218 as=0.1218 pd=1.42 ps=1.42 nrd=0.69047619047619  nrs=0.69047619047619 sa=0 sb=0 sd=0 mult=1 m=1
XMRD_op0_n100_pic_neg_missing_wb_2 rbl_op0_n100_pic_neg_missing_wb sn_op0_n100_pic_neg_missing_wb_2 rwl_des 0 sky130_fd_pr__nfet_01v8 L=0.15 W=0.42 nf=1 ad=0.1218 as=0.1218 pd=1.42 ps=1.42 nrd=0.69047619047619  nrs=0.69047619047619 sa=0 sb=0 sd=0 mult=1 m=1
csn_op0_n100_pic_neg_missing_wb_2 sn_op0_n100_pic_neg_missing_wb_2 0 {C_SN}
XMWR_op0_n100_pic_neg_missing_wb_3 sn_op0_n100_pic_neg_missing_wb_3 wwl_des wbl_op0_n100_pic_neg_missing_wb 0 sky130_fd_pr__nfet_01v8 L=0.15 W=0.42 nf=1 ad=0.1218 as=0.1218 pd=1.42 ps=1.42 nrd=0.69047619047619  nrs=0.69047619047619 sa=0 sb=0 sd=0 mult=1 m=1
XMRD_op0_n100_pic_neg_missing_wb_3 rbl_op0_n100_pic_neg_missing_wb sn_op0_n100_pic_neg_missing_wb_3 rwl_des 0 sky130_fd_pr__nfet_01v8 L=0.15 W=0.42 nf=1 ad=0.1218 as=0.1218 pd=1.42 ps=1.42 nrd=0.69047619047619  nrs=0.69047619047619 sa=0 sb=0 sd=0 mult=1 m=1
csn_op0_n100_pic_neg_missing_wb_3 sn_op0_n100_pic_neg_missing_wb_3 0 {C_SN}
XMN1_op0_n100_pic_neg_missing_wb rbl_op0_n100_pic_neg_missing_wb ref_op0_n100_pic_neg_missing_wb vn_op0_n100_pic_neg_missing_wb 0 sky130_fd_pr__nfet_01v8 L=0.15 W=1 nf=1 ad=0.29 as=0.29 pd=2.58 ps=2.58 mult=1 m=1
XMN2_op0_n100_pic_neg_missing_wb ref_op0_n100_pic_neg_missing_wb rbl_op0_n100_pic_neg_missing_wb vn_op0_n100_pic_neg_missing_wb 0 sky130_fd_pr__nfet_01v8 L=0.15 W=1 nf=1 ad=0.29 as=0.29 pd=2.58 ps=2.58 mult=1 m=1
XMP1_op0_n100_pic_neg_missing_wb rbl_op0_n100_pic_neg_missing_wb ref_op0_n100_pic_neg_missing_wb vp_op0_n100_pic_neg_missing_wb vdd sky130_fd_pr__pfet_01v8 L=0.15 W=2 nf=1 ad=0.58 as=0.58 pd=4.58 ps=4.58 mult=1 m=1
XMP2_op0_n100_pic_neg_missing_wb ref_op0_n100_pic_neg_missing_wb rbl_op0_n100_pic_neg_missing_wb vp_op0_n100_pic_neg_missing_wb vdd sky130_fd_pr__pfet_01v8 L=0.15 W=2 nf=1 ad=0.58 as=0.58 pd=4.58 ps=4.58 mult=1 m=1
XMNF_op0_n100_pic_neg_missing_wb vn_op0_n100_pic_neg_missing_wb en_op0_n100_pic_neg_missing_wb 0 0 sky130_fd_pr__nfet_01v8 L=0.15 W=2 nf=1 ad=0.58 as=0.58 pd=4.58 ps=4.58 mult=1 m=1
XMPH_op0_n100_pic_neg_missing_wb vp_op0_n100_pic_neg_missing_wb enb_op0_n100_pic_neg_missing_wb vdd vdd sky130_fd_pr__pfet_01v8 L=0.15 W=4 nf=1 ad=1.16 as=1.16 pd=8.58 ps=8.58 mult=1 m=1
bd_op0_n100_pic_neg_missing_wb d_op0_n100_pic_neg_missing_wb 0 v=v(rbl_op0_n100_pic_neg_missing_wb)-v(ref_op0_n100_pic_neg_missing_wb)

* ---- instance 31: op0_0000_pic_neg_missing_wb (variant pic_neg_missing_wb; probe dec 11.9 ns, release 34 ns, meas 36 ns) ----
vctl_op0_0000_pic_neg_missing_wb ctl_op0_0000_pic_neg_missing_wb 0 pwl(0.0000e+00 {VDD} 2.0000e-09 {VDD} 2.1000e-09 0)
vrs_op0_0000_pic_neg_missing_wb rwls_op0_0000_pic_neg_missing_wb 0 pwl(0.0000e+00 {VDD} 2.0000e-09 {VDD} 2.1000e-09 0 1.2000e-08 0 1.2100e-08 {VDD})
ven_op0_0000_pic_neg_missing_wb en_op0_0000_pic_neg_missing_wb 0 pwl(0.0000e+00 0 1.1000e-08 0 1.1100e-08 {VDD} 3.4000e-08 {VDD} 3.4100e-08 0)
venb_op0_0000_pic_neg_missing_wb enb_op0_0000_pic_neg_missing_wb 0 pwl(0.0000e+00 {VDD} 1.1000e-08 {VDD} 1.1100e-08 0 3.4000e-08 0 3.4100e-08 {VDD})
vww_op0_0000_pic_neg_missing_wb wwl_op0_0000_pic_neg_missing_wb 0 pwl(0.0000e+00 0)
vwc_op0_0000_pic_neg_missing_wb wbc_op0_0000_pic_neg_missing_wb 0 pwl(0.0000e+00 0)
swb_op0_0000_pic_neg_missing_wb ref_op0_0000_pic_neg_missing_wb wbl_op0_0000_pic_neg_missing_wb wbc_op0_0000_pic_neg_missing_wb 0 swwbl
cwbl_op0_0000_pic_neg_missing_wb wbl_op0_0000_pic_neg_missing_wb 0 {C_WBL}
spa_op0_0000_pic_neg_missing_wb prea rbl_op0_0000_pic_neg_missing_wb ctl_op0_0000_pic_neg_missing_wb 0 swpre
spr_op0_0000_pic_neg_missing_wb pref ref_op0_0000_pic_neg_missing_wb ctl_op0_0000_pic_neg_missing_wb 0 swpre
crbl_op0_0000_pic_neg_missing_wb rbl_op0_0000_pic_neg_missing_wb 0 {C_RBL}
cref_op0_0000_pic_neg_missing_wb ref_op0_0000_pic_neg_missing_wb 0 {C_RBL}   $ ASSUMPTION: ideal matched dummy load
XMWR_op0_0000_pic_neg_missing_wb_0 sn_op0_0000_pic_neg_missing_wb_0 wwl_op0_0000_pic_neg_missing_wb wbl_op0_0000_pic_neg_missing_wb 0 sky130_fd_pr__nfet_01v8 L=0.15 W=0.42 nf=1 ad=0.1218 as=0.1218 pd=1.42 ps=1.42 nrd=0.69047619047619  nrs=0.69047619047619 sa=0 sb=0 sd=0 mult=1 m=1
XMRD_op0_0000_pic_neg_missing_wb_0 rbl_op0_0000_pic_neg_missing_wb sn_op0_0000_pic_neg_missing_wb_0 rwls_op0_0000_pic_neg_missing_wb 0 sky130_fd_pr__nfet_01v8 L=0.15 W=0.42 nf=1 ad=0.1218 as=0.1218 pd=1.42 ps=1.42 nrd=0.69047619047619  nrs=0.69047619047619 sa=0 sb=0 sd=0 mult=1 m=1
csn_op0_0000_pic_neg_missing_wb_0 sn_op0_0000_pic_neg_missing_wb_0 0 {C_SN}
XMWR_op0_0000_pic_neg_missing_wb_1 sn_op0_0000_pic_neg_missing_wb_1 wwl_des wbl_op0_0000_pic_neg_missing_wb 0 sky130_fd_pr__nfet_01v8 L=0.15 W=0.42 nf=1 ad=0.1218 as=0.1218 pd=1.42 ps=1.42 nrd=0.69047619047619  nrs=0.69047619047619 sa=0 sb=0 sd=0 mult=1 m=1
XMRD_op0_0000_pic_neg_missing_wb_1 rbl_op0_0000_pic_neg_missing_wb sn_op0_0000_pic_neg_missing_wb_1 rwl_des 0 sky130_fd_pr__nfet_01v8 L=0.15 W=0.42 nf=1 ad=0.1218 as=0.1218 pd=1.42 ps=1.42 nrd=0.69047619047619  nrs=0.69047619047619 sa=0 sb=0 sd=0 mult=1 m=1
csn_op0_0000_pic_neg_missing_wb_1 sn_op0_0000_pic_neg_missing_wb_1 0 {C_SN}
XMWR_op0_0000_pic_neg_missing_wb_2 sn_op0_0000_pic_neg_missing_wb_2 wwl_des wbl_op0_0000_pic_neg_missing_wb 0 sky130_fd_pr__nfet_01v8 L=0.15 W=0.42 nf=1 ad=0.1218 as=0.1218 pd=1.42 ps=1.42 nrd=0.69047619047619  nrs=0.69047619047619 sa=0 sb=0 sd=0 mult=1 m=1
XMRD_op0_0000_pic_neg_missing_wb_2 rbl_op0_0000_pic_neg_missing_wb sn_op0_0000_pic_neg_missing_wb_2 rwl_des 0 sky130_fd_pr__nfet_01v8 L=0.15 W=0.42 nf=1 ad=0.1218 as=0.1218 pd=1.42 ps=1.42 nrd=0.69047619047619  nrs=0.69047619047619 sa=0 sb=0 sd=0 mult=1 m=1
csn_op0_0000_pic_neg_missing_wb_2 sn_op0_0000_pic_neg_missing_wb_2 0 {C_SN}
XMWR_op0_0000_pic_neg_missing_wb_3 sn_op0_0000_pic_neg_missing_wb_3 wwl_des wbl_op0_0000_pic_neg_missing_wb 0 sky130_fd_pr__nfet_01v8 L=0.15 W=0.42 nf=1 ad=0.1218 as=0.1218 pd=1.42 ps=1.42 nrd=0.69047619047619  nrs=0.69047619047619 sa=0 sb=0 sd=0 mult=1 m=1
XMRD_op0_0000_pic_neg_missing_wb_3 rbl_op0_0000_pic_neg_missing_wb sn_op0_0000_pic_neg_missing_wb_3 rwl_des 0 sky130_fd_pr__nfet_01v8 L=0.15 W=0.42 nf=1 ad=0.1218 as=0.1218 pd=1.42 ps=1.42 nrd=0.69047619047619  nrs=0.69047619047619 sa=0 sb=0 sd=0 mult=1 m=1
csn_op0_0000_pic_neg_missing_wb_3 sn_op0_0000_pic_neg_missing_wb_3 0 {C_SN}
XMN1_op0_0000_pic_neg_missing_wb rbl_op0_0000_pic_neg_missing_wb ref_op0_0000_pic_neg_missing_wb vn_op0_0000_pic_neg_missing_wb 0 sky130_fd_pr__nfet_01v8 L=0.15 W=1 nf=1 ad=0.29 as=0.29 pd=2.58 ps=2.58 mult=1 m=1
XMN2_op0_0000_pic_neg_missing_wb ref_op0_0000_pic_neg_missing_wb rbl_op0_0000_pic_neg_missing_wb vn_op0_0000_pic_neg_missing_wb 0 sky130_fd_pr__nfet_01v8 L=0.15 W=1 nf=1 ad=0.29 as=0.29 pd=2.58 ps=2.58 mult=1 m=1
XMP1_op0_0000_pic_neg_missing_wb rbl_op0_0000_pic_neg_missing_wb ref_op0_0000_pic_neg_missing_wb vp_op0_0000_pic_neg_missing_wb vdd sky130_fd_pr__pfet_01v8 L=0.15 W=2 nf=1 ad=0.58 as=0.58 pd=4.58 ps=4.58 mult=1 m=1
XMP2_op0_0000_pic_neg_missing_wb ref_op0_0000_pic_neg_missing_wb rbl_op0_0000_pic_neg_missing_wb vp_op0_0000_pic_neg_missing_wb vdd sky130_fd_pr__pfet_01v8 L=0.15 W=2 nf=1 ad=0.58 as=0.58 pd=4.58 ps=4.58 mult=1 m=1
XMNF_op0_0000_pic_neg_missing_wb vn_op0_0000_pic_neg_missing_wb en_op0_0000_pic_neg_missing_wb 0 0 sky130_fd_pr__nfet_01v8 L=0.15 W=2 nf=1 ad=0.58 as=0.58 pd=4.58 ps=4.58 mult=1 m=1
XMPH_op0_0000_pic_neg_missing_wb vp_op0_0000_pic_neg_missing_wb enb_op0_0000_pic_neg_missing_wb vdd vdd sky130_fd_pr__pfet_01v8 L=0.15 W=4 nf=1 ad=1.16 as=1.16 pd=8.58 ps=8.58 mult=1 m=1
bd_op0_0000_pic_neg_missing_wb d_op0_0000_pic_neg_missing_wb 0 v=v(rbl_op0_0000_pic_neg_missing_wb)-v(ref_op0_0000_pic_neg_missing_wb)

* ---- instance 32: op1_0900_pw_baseline_analog (variant pw_baseline_analog; probe dec 38.9 ns, release 61 ns, meas 63 ns) ----
vctl_op1_0900_pw_baseline_analog ctl_op1_0900_pw_baseline_analog 0 pwl(0.0000e+00 0 2.4000e-08 0 2.4100e-08 {VDD} 2.6000e-08 {VDD} 2.6100e-08 0)
vrs_op1_0900_pw_baseline_analog rwls_op1_0900_pw_baseline_analog 0 pwl(0.0000e+00 {VDD} 2.8000e-08 {VDD} 2.8100e-08 0 6.1000e-08 0 6.1100e-08 {VDD})
ven_op1_0900_pw_baseline_analog en_op1_0900_pw_baseline_analog 0 pwl(0.0000e+00 0 3.8000e-08 0 3.8100e-08 {VDD} 6.1000e-08 {VDD} 6.1100e-08 0)
venb_op1_0900_pw_baseline_analog enb_op1_0900_pw_baseline_analog 0 pwl(0.0000e+00 {VDD} 3.8000e-08 {VDD} 3.8100e-08 0 6.1000e-08 0 6.1100e-08 {VDD})
vww_op1_0900_pw_baseline_analog wwl_op1_0900_pw_baseline_analog 0 pwl(0.0000e+00 0 1.0000e-09 0 1.1000e-09 {VDD} 2.1000e-08 {VDD} 2.1100e-08 0 3.9000e-08 0 3.9100e-08 {VDD} 5.9000e-08 {VDD} 5.9100e-08 0)
vwc_op1_0900_pw_baseline_analog wbc_op1_0900_pw_baseline_analog 0 pwl(0.0000e+00 0 3.9000e-08 0 3.9100e-08 {VDD} 6.1000e-08 {VDD} 6.1100e-08 0)
* preparation driver (physical regime; write ENABLED): WBL <- 0.9 V until 22 ns, then 0 V; switch open at 23 ns
vpw_op1_0900_pw_baseline_analog wpd_op1_0900_pw_baseline_analog 0 pwl(0 0.9 2.2000e-08 0.9 2.2100e-08 0)
vpc_op1_0900_pw_baseline_analog pctl_op1_0900_pw_baseline_analog 0 pwl(0.0000e+00 {VDD} 2.3000e-08 {VDD} 2.3100e-08 0)
spw_op1_0900_pw_baseline_analog wpd_op1_0900_pw_baseline_analog wbl_op1_0900_pw_baseline_analog pctl_op1_0900_pw_baseline_analog 0 swwbl
swb_op1_0900_pw_baseline_analog ref_op1_0900_pw_baseline_analog wbl_op1_0900_pw_baseline_analog wbc_op1_0900_pw_baseline_analog 0 swwbl
cwbl_op1_0900_pw_baseline_analog wbl_op1_0900_pw_baseline_analog 0 {C_WBL}
spa_op1_0900_pw_baseline_analog prea rbl_op1_0900_pw_baseline_analog ctl_op1_0900_pw_baseline_analog 0 swpre
spr_op1_0900_pw_baseline_analog pref ref_op1_0900_pw_baseline_analog ctl_op1_0900_pw_baseline_analog 0 swpre
crbl_op1_0900_pw_baseline_analog rbl_op1_0900_pw_baseline_analog 0 {C_RBL}
cref_op1_0900_pw_baseline_analog ref_op1_0900_pw_baseline_analog 0 {C_RBL}   $ ASSUMPTION: ideal matched dummy load
XMWR_op1_0900_pw_baseline_analog_0 sn_op1_0900_pw_baseline_analog_0 wwl_op1_0900_pw_baseline_analog wbl_op1_0900_pw_baseline_analog 0 sky130_fd_pr__nfet_01v8 L=0.15 W=0.42 nf=1 ad=0.1218 as=0.1218 pd=1.42 ps=1.42 nrd=0.69047619047619  nrs=0.69047619047619 sa=0 sb=0 sd=0 mult=1 m=1
XMRD_op1_0900_pw_baseline_analog_0 rbl_op1_0900_pw_baseline_analog sn_op1_0900_pw_baseline_analog_0 rwls_op1_0900_pw_baseline_analog 0 sky130_fd_pr__nfet_01v8 L=0.15 W=0.42 nf=1 ad=0.1218 as=0.1218 pd=1.42 ps=1.42 nrd=0.69047619047619  nrs=0.69047619047619 sa=0 sb=0 sd=0 mult=1 m=1
csn_op1_0900_pw_baseline_analog_0 sn_op1_0900_pw_baseline_analog_0 0 {C_SN}
XMWR_op1_0900_pw_baseline_analog_1 sn_op1_0900_pw_baseline_analog_1 wwl_des wbl_op1_0900_pw_baseline_analog 0 sky130_fd_pr__nfet_01v8 L=0.15 W=0.42 nf=1 ad=0.1218 as=0.1218 pd=1.42 ps=1.42 nrd=0.69047619047619  nrs=0.69047619047619 sa=0 sb=0 sd=0 mult=1 m=1
XMRD_op1_0900_pw_baseline_analog_1 rbl_op1_0900_pw_baseline_analog sn_op1_0900_pw_baseline_analog_1 rwl_des 0 sky130_fd_pr__nfet_01v8 L=0.15 W=0.42 nf=1 ad=0.1218 as=0.1218 pd=1.42 ps=1.42 nrd=0.69047619047619  nrs=0.69047619047619 sa=0 sb=0 sd=0 mult=1 m=1
csn_op1_0900_pw_baseline_analog_1 sn_op1_0900_pw_baseline_analog_1 0 {C_SN}
XMWR_op1_0900_pw_baseline_analog_2 sn_op1_0900_pw_baseline_analog_2 wwl_des wbl_op1_0900_pw_baseline_analog 0 sky130_fd_pr__nfet_01v8 L=0.15 W=0.42 nf=1 ad=0.1218 as=0.1218 pd=1.42 ps=1.42 nrd=0.69047619047619  nrs=0.69047619047619 sa=0 sb=0 sd=0 mult=1 m=1
XMRD_op1_0900_pw_baseline_analog_2 rbl_op1_0900_pw_baseline_analog sn_op1_0900_pw_baseline_analog_2 rwl_des 0 sky130_fd_pr__nfet_01v8 L=0.15 W=0.42 nf=1 ad=0.1218 as=0.1218 pd=1.42 ps=1.42 nrd=0.69047619047619  nrs=0.69047619047619 sa=0 sb=0 sd=0 mult=1 m=1
csn_op1_0900_pw_baseline_analog_2 sn_op1_0900_pw_baseline_analog_2 0 {C_SN}
XMWR_op1_0900_pw_baseline_analog_3 sn_op1_0900_pw_baseline_analog_3 wwl_des wbl_op1_0900_pw_baseline_analog 0 sky130_fd_pr__nfet_01v8 L=0.15 W=0.42 nf=1 ad=0.1218 as=0.1218 pd=1.42 ps=1.42 nrd=0.69047619047619  nrs=0.69047619047619 sa=0 sb=0 sd=0 mult=1 m=1
XMRD_op1_0900_pw_baseline_analog_3 rbl_op1_0900_pw_baseline_analog sn_op1_0900_pw_baseline_analog_3 rwl_des 0 sky130_fd_pr__nfet_01v8 L=0.15 W=0.42 nf=1 ad=0.1218 as=0.1218 pd=1.42 ps=1.42 nrd=0.69047619047619  nrs=0.69047619047619 sa=0 sb=0 sd=0 mult=1 m=1
csn_op1_0900_pw_baseline_analog_3 sn_op1_0900_pw_baseline_analog_3 0 {C_SN}
XMN1_op1_0900_pw_baseline_analog rbl_op1_0900_pw_baseline_analog ref_op1_0900_pw_baseline_analog vn_op1_0900_pw_baseline_analog 0 sky130_fd_pr__nfet_01v8 L=0.15 W=1 nf=1 ad=0.29 as=0.29 pd=2.58 ps=2.58 mult=1 m=1
XMN2_op1_0900_pw_baseline_analog ref_op1_0900_pw_baseline_analog rbl_op1_0900_pw_baseline_analog vn_op1_0900_pw_baseline_analog 0 sky130_fd_pr__nfet_01v8 L=0.15 W=1 nf=1 ad=0.29 as=0.29 pd=2.58 ps=2.58 mult=1 m=1
XMP1_op1_0900_pw_baseline_analog rbl_op1_0900_pw_baseline_analog ref_op1_0900_pw_baseline_analog vp_op1_0900_pw_baseline_analog vdd sky130_fd_pr__pfet_01v8 L=0.15 W=2 nf=1 ad=0.58 as=0.58 pd=4.58 ps=4.58 mult=1 m=1
XMP2_op1_0900_pw_baseline_analog ref_op1_0900_pw_baseline_analog rbl_op1_0900_pw_baseline_analog vp_op1_0900_pw_baseline_analog vdd sky130_fd_pr__pfet_01v8 L=0.15 W=2 nf=1 ad=0.58 as=0.58 pd=4.58 ps=4.58 mult=1 m=1
XMNF_op1_0900_pw_baseline_analog vn_op1_0900_pw_baseline_analog en_op1_0900_pw_baseline_analog 0 0 sky130_fd_pr__nfet_01v8 L=0.15 W=2 nf=1 ad=0.58 as=0.58 pd=4.58 ps=4.58 mult=1 m=1
XMPH_op1_0900_pw_baseline_analog vp_op1_0900_pw_baseline_analog enb_op1_0900_pw_baseline_analog vdd vdd sky130_fd_pr__pfet_01v8 L=0.15 W=4 nf=1 ad=1.16 as=1.16 pd=8.58 ps=8.58 mult=1 m=1
bd_op1_0900_pw_baseline_analog d_op1_0900_pw_baseline_analog 0 v=v(rbl_op1_0900_pw_baseline_analog)-v(ref_op1_0900_pw_baseline_analog)

* ---- instance 33: op1_1000_pw_baseline_analog (variant pw_baseline_analog; probe dec 38.9 ns, release 61 ns, meas 63 ns) ----
vctl_op1_1000_pw_baseline_analog ctl_op1_1000_pw_baseline_analog 0 pwl(0.0000e+00 0 2.4000e-08 0 2.4100e-08 {VDD} 2.6000e-08 {VDD} 2.6100e-08 0)
vrs_op1_1000_pw_baseline_analog rwls_op1_1000_pw_baseline_analog 0 pwl(0.0000e+00 {VDD} 2.8000e-08 {VDD} 2.8100e-08 0 6.1000e-08 0 6.1100e-08 {VDD})
ven_op1_1000_pw_baseline_analog en_op1_1000_pw_baseline_analog 0 pwl(0.0000e+00 0 3.8000e-08 0 3.8100e-08 {VDD} 6.1000e-08 {VDD} 6.1100e-08 0)
venb_op1_1000_pw_baseline_analog enb_op1_1000_pw_baseline_analog 0 pwl(0.0000e+00 {VDD} 3.8000e-08 {VDD} 3.8100e-08 0 6.1000e-08 0 6.1100e-08 {VDD})
vww_op1_1000_pw_baseline_analog wwl_op1_1000_pw_baseline_analog 0 pwl(0.0000e+00 0 1.0000e-09 0 1.1000e-09 {VDD} 2.1000e-08 {VDD} 2.1100e-08 0 3.9000e-08 0 3.9100e-08 {VDD} 5.9000e-08 {VDD} 5.9100e-08 0)
vwc_op1_1000_pw_baseline_analog wbc_op1_1000_pw_baseline_analog 0 pwl(0.0000e+00 0 3.9000e-08 0 3.9100e-08 {VDD} 6.1000e-08 {VDD} 6.1100e-08 0)
* preparation driver (physical regime; write ENABLED): WBL <- 1 V until 22 ns, then 0 V; switch open at 23 ns
vpw_op1_1000_pw_baseline_analog wpd_op1_1000_pw_baseline_analog 0 pwl(0 1 2.2000e-08 1 2.2100e-08 0)
vpc_op1_1000_pw_baseline_analog pctl_op1_1000_pw_baseline_analog 0 pwl(0.0000e+00 {VDD} 2.3000e-08 {VDD} 2.3100e-08 0)
spw_op1_1000_pw_baseline_analog wpd_op1_1000_pw_baseline_analog wbl_op1_1000_pw_baseline_analog pctl_op1_1000_pw_baseline_analog 0 swwbl
swb_op1_1000_pw_baseline_analog ref_op1_1000_pw_baseline_analog wbl_op1_1000_pw_baseline_analog wbc_op1_1000_pw_baseline_analog 0 swwbl
cwbl_op1_1000_pw_baseline_analog wbl_op1_1000_pw_baseline_analog 0 {C_WBL}
spa_op1_1000_pw_baseline_analog prea rbl_op1_1000_pw_baseline_analog ctl_op1_1000_pw_baseline_analog 0 swpre
spr_op1_1000_pw_baseline_analog pref ref_op1_1000_pw_baseline_analog ctl_op1_1000_pw_baseline_analog 0 swpre
crbl_op1_1000_pw_baseline_analog rbl_op1_1000_pw_baseline_analog 0 {C_RBL}
cref_op1_1000_pw_baseline_analog ref_op1_1000_pw_baseline_analog 0 {C_RBL}   $ ASSUMPTION: ideal matched dummy load
XMWR_op1_1000_pw_baseline_analog_0 sn_op1_1000_pw_baseline_analog_0 wwl_op1_1000_pw_baseline_analog wbl_op1_1000_pw_baseline_analog 0 sky130_fd_pr__nfet_01v8 L=0.15 W=0.42 nf=1 ad=0.1218 as=0.1218 pd=1.42 ps=1.42 nrd=0.69047619047619  nrs=0.69047619047619 sa=0 sb=0 sd=0 mult=1 m=1
XMRD_op1_1000_pw_baseline_analog_0 rbl_op1_1000_pw_baseline_analog sn_op1_1000_pw_baseline_analog_0 rwls_op1_1000_pw_baseline_analog 0 sky130_fd_pr__nfet_01v8 L=0.15 W=0.42 nf=1 ad=0.1218 as=0.1218 pd=1.42 ps=1.42 nrd=0.69047619047619  nrs=0.69047619047619 sa=0 sb=0 sd=0 mult=1 m=1
csn_op1_1000_pw_baseline_analog_0 sn_op1_1000_pw_baseline_analog_0 0 {C_SN}
XMWR_op1_1000_pw_baseline_analog_1 sn_op1_1000_pw_baseline_analog_1 wwl_des wbl_op1_1000_pw_baseline_analog 0 sky130_fd_pr__nfet_01v8 L=0.15 W=0.42 nf=1 ad=0.1218 as=0.1218 pd=1.42 ps=1.42 nrd=0.69047619047619  nrs=0.69047619047619 sa=0 sb=0 sd=0 mult=1 m=1
XMRD_op1_1000_pw_baseline_analog_1 rbl_op1_1000_pw_baseline_analog sn_op1_1000_pw_baseline_analog_1 rwl_des 0 sky130_fd_pr__nfet_01v8 L=0.15 W=0.42 nf=1 ad=0.1218 as=0.1218 pd=1.42 ps=1.42 nrd=0.69047619047619  nrs=0.69047619047619 sa=0 sb=0 sd=0 mult=1 m=1
csn_op1_1000_pw_baseline_analog_1 sn_op1_1000_pw_baseline_analog_1 0 {C_SN}
XMWR_op1_1000_pw_baseline_analog_2 sn_op1_1000_pw_baseline_analog_2 wwl_des wbl_op1_1000_pw_baseline_analog 0 sky130_fd_pr__nfet_01v8 L=0.15 W=0.42 nf=1 ad=0.1218 as=0.1218 pd=1.42 ps=1.42 nrd=0.69047619047619  nrs=0.69047619047619 sa=0 sb=0 sd=0 mult=1 m=1
XMRD_op1_1000_pw_baseline_analog_2 rbl_op1_1000_pw_baseline_analog sn_op1_1000_pw_baseline_analog_2 rwl_des 0 sky130_fd_pr__nfet_01v8 L=0.15 W=0.42 nf=1 ad=0.1218 as=0.1218 pd=1.42 ps=1.42 nrd=0.69047619047619  nrs=0.69047619047619 sa=0 sb=0 sd=0 mult=1 m=1
csn_op1_1000_pw_baseline_analog_2 sn_op1_1000_pw_baseline_analog_2 0 {C_SN}
XMWR_op1_1000_pw_baseline_analog_3 sn_op1_1000_pw_baseline_analog_3 wwl_des wbl_op1_1000_pw_baseline_analog 0 sky130_fd_pr__nfet_01v8 L=0.15 W=0.42 nf=1 ad=0.1218 as=0.1218 pd=1.42 ps=1.42 nrd=0.69047619047619  nrs=0.69047619047619 sa=0 sb=0 sd=0 mult=1 m=1
XMRD_op1_1000_pw_baseline_analog_3 rbl_op1_1000_pw_baseline_analog sn_op1_1000_pw_baseline_analog_3 rwl_des 0 sky130_fd_pr__nfet_01v8 L=0.15 W=0.42 nf=1 ad=0.1218 as=0.1218 pd=1.42 ps=1.42 nrd=0.69047619047619  nrs=0.69047619047619 sa=0 sb=0 sd=0 mult=1 m=1
csn_op1_1000_pw_baseline_analog_3 sn_op1_1000_pw_baseline_analog_3 0 {C_SN}
XMN1_op1_1000_pw_baseline_analog rbl_op1_1000_pw_baseline_analog ref_op1_1000_pw_baseline_analog vn_op1_1000_pw_baseline_analog 0 sky130_fd_pr__nfet_01v8 L=0.15 W=1 nf=1 ad=0.29 as=0.29 pd=2.58 ps=2.58 mult=1 m=1
XMN2_op1_1000_pw_baseline_analog ref_op1_1000_pw_baseline_analog rbl_op1_1000_pw_baseline_analog vn_op1_1000_pw_baseline_analog 0 sky130_fd_pr__nfet_01v8 L=0.15 W=1 nf=1 ad=0.29 as=0.29 pd=2.58 ps=2.58 mult=1 m=1
XMP1_op1_1000_pw_baseline_analog rbl_op1_1000_pw_baseline_analog ref_op1_1000_pw_baseline_analog vp_op1_1000_pw_baseline_analog vdd sky130_fd_pr__pfet_01v8 L=0.15 W=2 nf=1 ad=0.58 as=0.58 pd=4.58 ps=4.58 mult=1 m=1
XMP2_op1_1000_pw_baseline_analog ref_op1_1000_pw_baseline_analog rbl_op1_1000_pw_baseline_analog vp_op1_1000_pw_baseline_analog vdd sky130_fd_pr__pfet_01v8 L=0.15 W=2 nf=1 ad=0.58 as=0.58 pd=4.58 ps=4.58 mult=1 m=1
XMNF_op1_1000_pw_baseline_analog vn_op1_1000_pw_baseline_analog en_op1_1000_pw_baseline_analog 0 0 sky130_fd_pr__nfet_01v8 L=0.15 W=2 nf=1 ad=0.58 as=0.58 pd=4.58 ps=4.58 mult=1 m=1
XMPH_op1_1000_pw_baseline_analog vp_op1_1000_pw_baseline_analog enb_op1_1000_pw_baseline_analog vdd vdd sky130_fd_pr__pfet_01v8 L=0.15 W=4 nf=1 ad=1.16 as=1.16 pd=8.58 ps=8.58 mult=1 m=1
bd_op1_1000_pw_baseline_analog d_op1_1000_pw_baseline_analog 0 v=v(rbl_op1_1000_pw_baseline_analog)-v(ref_op1_1000_pw_baseline_analog)

* ---- instance 34: op0_n100_pw_baseline_analog (variant pw_baseline_analog; probe dec 38.9 ns, release 61 ns, meas 63 ns) ----
vctl_op0_n100_pw_baseline_analog ctl_op0_n100_pw_baseline_analog 0 pwl(0.0000e+00 0 2.4000e-08 0 2.4100e-08 {VDD} 2.6000e-08 {VDD} 2.6100e-08 0)
vrs_op0_n100_pw_baseline_analog rwls_op0_n100_pw_baseline_analog 0 pwl(0.0000e+00 {VDD} 2.8000e-08 {VDD} 2.8100e-08 0 6.1000e-08 0 6.1100e-08 {VDD})
ven_op0_n100_pw_baseline_analog en_op0_n100_pw_baseline_analog 0 pwl(0.0000e+00 0 3.8000e-08 0 3.8100e-08 {VDD} 6.1000e-08 {VDD} 6.1100e-08 0)
venb_op0_n100_pw_baseline_analog enb_op0_n100_pw_baseline_analog 0 pwl(0.0000e+00 {VDD} 3.8000e-08 {VDD} 3.8100e-08 0 6.1000e-08 0 6.1100e-08 {VDD})
vww_op0_n100_pw_baseline_analog wwl_op0_n100_pw_baseline_analog 0 pwl(0.0000e+00 0 1.0000e-09 0 1.1000e-09 {VDD} 2.1000e-08 {VDD} 2.1100e-08 0 3.9000e-08 0 3.9100e-08 {VDD} 5.9000e-08 {VDD} 5.9100e-08 0)
vwc_op0_n100_pw_baseline_analog wbc_op0_n100_pw_baseline_analog 0 pwl(0.0000e+00 0 3.9000e-08 0 3.9100e-08 {VDD} 6.1000e-08 {VDD} 6.1100e-08 0)
* preparation driver (physical regime; write ENABLED): WBL <- -0.1 V until 22 ns, then 0 V; switch open at 23 ns
vpw_op0_n100_pw_baseline_analog wpd_op0_n100_pw_baseline_analog 0 pwl(0 -0.1 2.2000e-08 -0.1 2.2100e-08 0)
vpc_op0_n100_pw_baseline_analog pctl_op0_n100_pw_baseline_analog 0 pwl(0.0000e+00 {VDD} 2.3000e-08 {VDD} 2.3100e-08 0)
spw_op0_n100_pw_baseline_analog wpd_op0_n100_pw_baseline_analog wbl_op0_n100_pw_baseline_analog pctl_op0_n100_pw_baseline_analog 0 swwbl
swb_op0_n100_pw_baseline_analog ref_op0_n100_pw_baseline_analog wbl_op0_n100_pw_baseline_analog wbc_op0_n100_pw_baseline_analog 0 swwbl
cwbl_op0_n100_pw_baseline_analog wbl_op0_n100_pw_baseline_analog 0 {C_WBL}
spa_op0_n100_pw_baseline_analog prea rbl_op0_n100_pw_baseline_analog ctl_op0_n100_pw_baseline_analog 0 swpre
spr_op0_n100_pw_baseline_analog pref ref_op0_n100_pw_baseline_analog ctl_op0_n100_pw_baseline_analog 0 swpre
crbl_op0_n100_pw_baseline_analog rbl_op0_n100_pw_baseline_analog 0 {C_RBL}
cref_op0_n100_pw_baseline_analog ref_op0_n100_pw_baseline_analog 0 {C_RBL}   $ ASSUMPTION: ideal matched dummy load
XMWR_op0_n100_pw_baseline_analog_0 sn_op0_n100_pw_baseline_analog_0 wwl_op0_n100_pw_baseline_analog wbl_op0_n100_pw_baseline_analog 0 sky130_fd_pr__nfet_01v8 L=0.15 W=0.42 nf=1 ad=0.1218 as=0.1218 pd=1.42 ps=1.42 nrd=0.69047619047619  nrs=0.69047619047619 sa=0 sb=0 sd=0 mult=1 m=1
XMRD_op0_n100_pw_baseline_analog_0 rbl_op0_n100_pw_baseline_analog sn_op0_n100_pw_baseline_analog_0 rwls_op0_n100_pw_baseline_analog 0 sky130_fd_pr__nfet_01v8 L=0.15 W=0.42 nf=1 ad=0.1218 as=0.1218 pd=1.42 ps=1.42 nrd=0.69047619047619  nrs=0.69047619047619 sa=0 sb=0 sd=0 mult=1 m=1
csn_op0_n100_pw_baseline_analog_0 sn_op0_n100_pw_baseline_analog_0 0 {C_SN}
XMWR_op0_n100_pw_baseline_analog_1 sn_op0_n100_pw_baseline_analog_1 wwl_des wbl_op0_n100_pw_baseline_analog 0 sky130_fd_pr__nfet_01v8 L=0.15 W=0.42 nf=1 ad=0.1218 as=0.1218 pd=1.42 ps=1.42 nrd=0.69047619047619  nrs=0.69047619047619 sa=0 sb=0 sd=0 mult=1 m=1
XMRD_op0_n100_pw_baseline_analog_1 rbl_op0_n100_pw_baseline_analog sn_op0_n100_pw_baseline_analog_1 rwl_des 0 sky130_fd_pr__nfet_01v8 L=0.15 W=0.42 nf=1 ad=0.1218 as=0.1218 pd=1.42 ps=1.42 nrd=0.69047619047619  nrs=0.69047619047619 sa=0 sb=0 sd=0 mult=1 m=1
csn_op0_n100_pw_baseline_analog_1 sn_op0_n100_pw_baseline_analog_1 0 {C_SN}
XMWR_op0_n100_pw_baseline_analog_2 sn_op0_n100_pw_baseline_analog_2 wwl_des wbl_op0_n100_pw_baseline_analog 0 sky130_fd_pr__nfet_01v8 L=0.15 W=0.42 nf=1 ad=0.1218 as=0.1218 pd=1.42 ps=1.42 nrd=0.69047619047619  nrs=0.69047619047619 sa=0 sb=0 sd=0 mult=1 m=1
XMRD_op0_n100_pw_baseline_analog_2 rbl_op0_n100_pw_baseline_analog sn_op0_n100_pw_baseline_analog_2 rwl_des 0 sky130_fd_pr__nfet_01v8 L=0.15 W=0.42 nf=1 ad=0.1218 as=0.1218 pd=1.42 ps=1.42 nrd=0.69047619047619  nrs=0.69047619047619 sa=0 sb=0 sd=0 mult=1 m=1
csn_op0_n100_pw_baseline_analog_2 sn_op0_n100_pw_baseline_analog_2 0 {C_SN}
XMWR_op0_n100_pw_baseline_analog_3 sn_op0_n100_pw_baseline_analog_3 wwl_des wbl_op0_n100_pw_baseline_analog 0 sky130_fd_pr__nfet_01v8 L=0.15 W=0.42 nf=1 ad=0.1218 as=0.1218 pd=1.42 ps=1.42 nrd=0.69047619047619  nrs=0.69047619047619 sa=0 sb=0 sd=0 mult=1 m=1
XMRD_op0_n100_pw_baseline_analog_3 rbl_op0_n100_pw_baseline_analog sn_op0_n100_pw_baseline_analog_3 rwl_des 0 sky130_fd_pr__nfet_01v8 L=0.15 W=0.42 nf=1 ad=0.1218 as=0.1218 pd=1.42 ps=1.42 nrd=0.69047619047619  nrs=0.69047619047619 sa=0 sb=0 sd=0 mult=1 m=1
csn_op0_n100_pw_baseline_analog_3 sn_op0_n100_pw_baseline_analog_3 0 {C_SN}
XMN1_op0_n100_pw_baseline_analog rbl_op0_n100_pw_baseline_analog ref_op0_n100_pw_baseline_analog vn_op0_n100_pw_baseline_analog 0 sky130_fd_pr__nfet_01v8 L=0.15 W=1 nf=1 ad=0.29 as=0.29 pd=2.58 ps=2.58 mult=1 m=1
XMN2_op0_n100_pw_baseline_analog ref_op0_n100_pw_baseline_analog rbl_op0_n100_pw_baseline_analog vn_op0_n100_pw_baseline_analog 0 sky130_fd_pr__nfet_01v8 L=0.15 W=1 nf=1 ad=0.29 as=0.29 pd=2.58 ps=2.58 mult=1 m=1
XMP1_op0_n100_pw_baseline_analog rbl_op0_n100_pw_baseline_analog ref_op0_n100_pw_baseline_analog vp_op0_n100_pw_baseline_analog vdd sky130_fd_pr__pfet_01v8 L=0.15 W=2 nf=1 ad=0.58 as=0.58 pd=4.58 ps=4.58 mult=1 m=1
XMP2_op0_n100_pw_baseline_analog ref_op0_n100_pw_baseline_analog rbl_op0_n100_pw_baseline_analog vp_op0_n100_pw_baseline_analog vdd sky130_fd_pr__pfet_01v8 L=0.15 W=2 nf=1 ad=0.58 as=0.58 pd=4.58 ps=4.58 mult=1 m=1
XMNF_op0_n100_pw_baseline_analog vn_op0_n100_pw_baseline_analog en_op0_n100_pw_baseline_analog 0 0 sky130_fd_pr__nfet_01v8 L=0.15 W=2 nf=1 ad=0.58 as=0.58 pd=4.58 ps=4.58 mult=1 m=1
XMPH_op0_n100_pw_baseline_analog vp_op0_n100_pw_baseline_analog enb_op0_n100_pw_baseline_analog vdd vdd sky130_fd_pr__pfet_01v8 L=0.15 W=4 nf=1 ad=1.16 as=1.16 pd=8.58 ps=8.58 mult=1 m=1
bd_op0_n100_pw_baseline_analog d_op0_n100_pw_baseline_analog 0 v=v(rbl_op0_n100_pw_baseline_analog)-v(ref_op0_n100_pw_baseline_analog)

* ---- instance 35: op0_0000_pw_baseline_analog (variant pw_baseline_analog; probe dec 38.9 ns, release 61 ns, meas 63 ns) ----
vctl_op0_0000_pw_baseline_analog ctl_op0_0000_pw_baseline_analog 0 pwl(0.0000e+00 0 2.4000e-08 0 2.4100e-08 {VDD} 2.6000e-08 {VDD} 2.6100e-08 0)
vrs_op0_0000_pw_baseline_analog rwls_op0_0000_pw_baseline_analog 0 pwl(0.0000e+00 {VDD} 2.8000e-08 {VDD} 2.8100e-08 0 6.1000e-08 0 6.1100e-08 {VDD})
ven_op0_0000_pw_baseline_analog en_op0_0000_pw_baseline_analog 0 pwl(0.0000e+00 0 3.8000e-08 0 3.8100e-08 {VDD} 6.1000e-08 {VDD} 6.1100e-08 0)
venb_op0_0000_pw_baseline_analog enb_op0_0000_pw_baseline_analog 0 pwl(0.0000e+00 {VDD} 3.8000e-08 {VDD} 3.8100e-08 0 6.1000e-08 0 6.1100e-08 {VDD})
vww_op0_0000_pw_baseline_analog wwl_op0_0000_pw_baseline_analog 0 pwl(0.0000e+00 0 1.0000e-09 0 1.1000e-09 {VDD} 2.1000e-08 {VDD} 2.1100e-08 0 3.9000e-08 0 3.9100e-08 {VDD} 5.9000e-08 {VDD} 5.9100e-08 0)
vwc_op0_0000_pw_baseline_analog wbc_op0_0000_pw_baseline_analog 0 pwl(0.0000e+00 0 3.9000e-08 0 3.9100e-08 {VDD} 6.1000e-08 {VDD} 6.1100e-08 0)
* preparation driver (physical regime; write ENABLED): WBL <- 0 V until 22 ns, then 0 V; switch open at 23 ns
vpw_op0_0000_pw_baseline_analog wpd_op0_0000_pw_baseline_analog 0 pwl(0 0 2.2000e-08 0 2.2100e-08 0)
vpc_op0_0000_pw_baseline_analog pctl_op0_0000_pw_baseline_analog 0 pwl(0.0000e+00 {VDD} 2.3000e-08 {VDD} 2.3100e-08 0)
spw_op0_0000_pw_baseline_analog wpd_op0_0000_pw_baseline_analog wbl_op0_0000_pw_baseline_analog pctl_op0_0000_pw_baseline_analog 0 swwbl
swb_op0_0000_pw_baseline_analog ref_op0_0000_pw_baseline_analog wbl_op0_0000_pw_baseline_analog wbc_op0_0000_pw_baseline_analog 0 swwbl
cwbl_op0_0000_pw_baseline_analog wbl_op0_0000_pw_baseline_analog 0 {C_WBL}
spa_op0_0000_pw_baseline_analog prea rbl_op0_0000_pw_baseline_analog ctl_op0_0000_pw_baseline_analog 0 swpre
spr_op0_0000_pw_baseline_analog pref ref_op0_0000_pw_baseline_analog ctl_op0_0000_pw_baseline_analog 0 swpre
crbl_op0_0000_pw_baseline_analog rbl_op0_0000_pw_baseline_analog 0 {C_RBL}
cref_op0_0000_pw_baseline_analog ref_op0_0000_pw_baseline_analog 0 {C_RBL}   $ ASSUMPTION: ideal matched dummy load
XMWR_op0_0000_pw_baseline_analog_0 sn_op0_0000_pw_baseline_analog_0 wwl_op0_0000_pw_baseline_analog wbl_op0_0000_pw_baseline_analog 0 sky130_fd_pr__nfet_01v8 L=0.15 W=0.42 nf=1 ad=0.1218 as=0.1218 pd=1.42 ps=1.42 nrd=0.69047619047619  nrs=0.69047619047619 sa=0 sb=0 sd=0 mult=1 m=1
XMRD_op0_0000_pw_baseline_analog_0 rbl_op0_0000_pw_baseline_analog sn_op0_0000_pw_baseline_analog_0 rwls_op0_0000_pw_baseline_analog 0 sky130_fd_pr__nfet_01v8 L=0.15 W=0.42 nf=1 ad=0.1218 as=0.1218 pd=1.42 ps=1.42 nrd=0.69047619047619  nrs=0.69047619047619 sa=0 sb=0 sd=0 mult=1 m=1
csn_op0_0000_pw_baseline_analog_0 sn_op0_0000_pw_baseline_analog_0 0 {C_SN}
XMWR_op0_0000_pw_baseline_analog_1 sn_op0_0000_pw_baseline_analog_1 wwl_des wbl_op0_0000_pw_baseline_analog 0 sky130_fd_pr__nfet_01v8 L=0.15 W=0.42 nf=1 ad=0.1218 as=0.1218 pd=1.42 ps=1.42 nrd=0.69047619047619  nrs=0.69047619047619 sa=0 sb=0 sd=0 mult=1 m=1
XMRD_op0_0000_pw_baseline_analog_1 rbl_op0_0000_pw_baseline_analog sn_op0_0000_pw_baseline_analog_1 rwl_des 0 sky130_fd_pr__nfet_01v8 L=0.15 W=0.42 nf=1 ad=0.1218 as=0.1218 pd=1.42 ps=1.42 nrd=0.69047619047619  nrs=0.69047619047619 sa=0 sb=0 sd=0 mult=1 m=1
csn_op0_0000_pw_baseline_analog_1 sn_op0_0000_pw_baseline_analog_1 0 {C_SN}
XMWR_op0_0000_pw_baseline_analog_2 sn_op0_0000_pw_baseline_analog_2 wwl_des wbl_op0_0000_pw_baseline_analog 0 sky130_fd_pr__nfet_01v8 L=0.15 W=0.42 nf=1 ad=0.1218 as=0.1218 pd=1.42 ps=1.42 nrd=0.69047619047619  nrs=0.69047619047619 sa=0 sb=0 sd=0 mult=1 m=1
XMRD_op0_0000_pw_baseline_analog_2 rbl_op0_0000_pw_baseline_analog sn_op0_0000_pw_baseline_analog_2 rwl_des 0 sky130_fd_pr__nfet_01v8 L=0.15 W=0.42 nf=1 ad=0.1218 as=0.1218 pd=1.42 ps=1.42 nrd=0.69047619047619  nrs=0.69047619047619 sa=0 sb=0 sd=0 mult=1 m=1
csn_op0_0000_pw_baseline_analog_2 sn_op0_0000_pw_baseline_analog_2 0 {C_SN}
XMWR_op0_0000_pw_baseline_analog_3 sn_op0_0000_pw_baseline_analog_3 wwl_des wbl_op0_0000_pw_baseline_analog 0 sky130_fd_pr__nfet_01v8 L=0.15 W=0.42 nf=1 ad=0.1218 as=0.1218 pd=1.42 ps=1.42 nrd=0.69047619047619  nrs=0.69047619047619 sa=0 sb=0 sd=0 mult=1 m=1
XMRD_op0_0000_pw_baseline_analog_3 rbl_op0_0000_pw_baseline_analog sn_op0_0000_pw_baseline_analog_3 rwl_des 0 sky130_fd_pr__nfet_01v8 L=0.15 W=0.42 nf=1 ad=0.1218 as=0.1218 pd=1.42 ps=1.42 nrd=0.69047619047619  nrs=0.69047619047619 sa=0 sb=0 sd=0 mult=1 m=1
csn_op0_0000_pw_baseline_analog_3 sn_op0_0000_pw_baseline_analog_3 0 {C_SN}
XMN1_op0_0000_pw_baseline_analog rbl_op0_0000_pw_baseline_analog ref_op0_0000_pw_baseline_analog vn_op0_0000_pw_baseline_analog 0 sky130_fd_pr__nfet_01v8 L=0.15 W=1 nf=1 ad=0.29 as=0.29 pd=2.58 ps=2.58 mult=1 m=1
XMN2_op0_0000_pw_baseline_analog ref_op0_0000_pw_baseline_analog rbl_op0_0000_pw_baseline_analog vn_op0_0000_pw_baseline_analog 0 sky130_fd_pr__nfet_01v8 L=0.15 W=1 nf=1 ad=0.29 as=0.29 pd=2.58 ps=2.58 mult=1 m=1
XMP1_op0_0000_pw_baseline_analog rbl_op0_0000_pw_baseline_analog ref_op0_0000_pw_baseline_analog vp_op0_0000_pw_baseline_analog vdd sky130_fd_pr__pfet_01v8 L=0.15 W=2 nf=1 ad=0.58 as=0.58 pd=4.58 ps=4.58 mult=1 m=1
XMP2_op0_0000_pw_baseline_analog ref_op0_0000_pw_baseline_analog rbl_op0_0000_pw_baseline_analog vp_op0_0000_pw_baseline_analog vdd sky130_fd_pr__pfet_01v8 L=0.15 W=2 nf=1 ad=0.58 as=0.58 pd=4.58 ps=4.58 mult=1 m=1
XMNF_op0_0000_pw_baseline_analog vn_op0_0000_pw_baseline_analog en_op0_0000_pw_baseline_analog 0 0 sky130_fd_pr__nfet_01v8 L=0.15 W=2 nf=1 ad=0.58 as=0.58 pd=4.58 ps=4.58 mult=1 m=1
XMPH_op0_0000_pw_baseline_analog vp_op0_0000_pw_baseline_analog enb_op0_0000_pw_baseline_analog vdd vdd sky130_fd_pr__pfet_01v8 L=0.15 W=4 nf=1 ad=1.16 as=1.16 pd=8.58 ps=8.58 mult=1 m=1
bd_op0_0000_pw_baseline_analog d_op0_0000_pw_baseline_analog 0 v=v(rbl_op0_0000_pw_baseline_analog)-v(ref_op0_0000_pw_baseline_analog)

* ---- instance 36: op1_0900_pw_rtl_hold (variant pw_rtl_hold; probe dec 35.9 ns, release 58 ns, meas 60 ns) ----
vctl_op1_0900_pw_rtl_hold ctl_op1_0900_pw_rtl_hold 0 pwl(0.0000e+00 0 2.4000e-08 0 2.4100e-08 {VDD} 2.6000e-08 {VDD} 2.6100e-08 0)
vrs_op1_0900_pw_rtl_hold rwls_op1_0900_pw_rtl_hold 0 pwl(0.0000e+00 {VDD} 2.6000e-08 {VDD} 2.6100e-08 0 3.6000e-08 0 3.6100e-08 {VDD})
ven_op1_0900_pw_rtl_hold en_op1_0900_pw_rtl_hold 0 pwl(0.0000e+00 0 3.5000e-08 0 3.5100e-08 {VDD} 5.8000e-08 {VDD} 5.8100e-08 0)
venb_op1_0900_pw_rtl_hold enb_op1_0900_pw_rtl_hold 0 pwl(0.0000e+00 {VDD} 3.5000e-08 {VDD} 3.5100e-08 0 5.8000e-08 0 5.8100e-08 {VDD})
vww_op1_0900_pw_rtl_hold wwl_op1_0900_pw_rtl_hold 0 pwl(0.0000e+00 0 1.0000e-09 0 1.1000e-09 {VDD} 2.1000e-08 {VDD} 2.1100e-08 0 3.6000e-08 0 3.6100e-08 {VDD} 5.6000e-08 {VDD} 5.6100e-08 0)
vwc_op1_0900_pw_rtl_hold wbc_op1_0900_pw_rtl_hold 0 pwl(0.0000e+00 0 3.6000e-08 0 3.6100e-08 {VDD} 5.8000e-08 {VDD} 5.8100e-08 0)
* preparation driver (physical regime; write ENABLED): WBL <- 0.9 V until 22 ns, then 0 V; switch open at 23 ns
vpw_op1_0900_pw_rtl_hold wpd_op1_0900_pw_rtl_hold 0 pwl(0 0.9 2.2000e-08 0.9 2.2100e-08 0)
vpc_op1_0900_pw_rtl_hold pctl_op1_0900_pw_rtl_hold 0 pwl(0.0000e+00 {VDD} 2.3000e-08 {VDD} 2.3100e-08 0)
spw_op1_0900_pw_rtl_hold wpd_op1_0900_pw_rtl_hold wbl_op1_0900_pw_rtl_hold pctl_op1_0900_pw_rtl_hold 0 swwbl
swb_op1_0900_pw_rtl_hold ref_op1_0900_pw_rtl_hold wbl_op1_0900_pw_rtl_hold wbc_op1_0900_pw_rtl_hold 0 swwbl
cwbl_op1_0900_pw_rtl_hold wbl_op1_0900_pw_rtl_hold 0 {C_WBL}
spa_op1_0900_pw_rtl_hold prea rbl_op1_0900_pw_rtl_hold ctl_op1_0900_pw_rtl_hold 0 swpre
spr_op1_0900_pw_rtl_hold pref ref_op1_0900_pw_rtl_hold ctl_op1_0900_pw_rtl_hold 0 swpre
crbl_op1_0900_pw_rtl_hold rbl_op1_0900_pw_rtl_hold 0 {C_RBL}
cref_op1_0900_pw_rtl_hold ref_op1_0900_pw_rtl_hold 0 {C_RBL}   $ ASSUMPTION: ideal matched dummy load
XMWR_op1_0900_pw_rtl_hold_0 sn_op1_0900_pw_rtl_hold_0 wwl_op1_0900_pw_rtl_hold wbl_op1_0900_pw_rtl_hold 0 sky130_fd_pr__nfet_01v8 L=0.15 W=0.42 nf=1 ad=0.1218 as=0.1218 pd=1.42 ps=1.42 nrd=0.69047619047619  nrs=0.69047619047619 sa=0 sb=0 sd=0 mult=1 m=1
XMRD_op1_0900_pw_rtl_hold_0 rbl_op1_0900_pw_rtl_hold sn_op1_0900_pw_rtl_hold_0 rwls_op1_0900_pw_rtl_hold 0 sky130_fd_pr__nfet_01v8 L=0.15 W=0.42 nf=1 ad=0.1218 as=0.1218 pd=1.42 ps=1.42 nrd=0.69047619047619  nrs=0.69047619047619 sa=0 sb=0 sd=0 mult=1 m=1
csn_op1_0900_pw_rtl_hold_0 sn_op1_0900_pw_rtl_hold_0 0 {C_SN}
XMWR_op1_0900_pw_rtl_hold_1 sn_op1_0900_pw_rtl_hold_1 wwl_des wbl_op1_0900_pw_rtl_hold 0 sky130_fd_pr__nfet_01v8 L=0.15 W=0.42 nf=1 ad=0.1218 as=0.1218 pd=1.42 ps=1.42 nrd=0.69047619047619  nrs=0.69047619047619 sa=0 sb=0 sd=0 mult=1 m=1
XMRD_op1_0900_pw_rtl_hold_1 rbl_op1_0900_pw_rtl_hold sn_op1_0900_pw_rtl_hold_1 rwl_des 0 sky130_fd_pr__nfet_01v8 L=0.15 W=0.42 nf=1 ad=0.1218 as=0.1218 pd=1.42 ps=1.42 nrd=0.69047619047619  nrs=0.69047619047619 sa=0 sb=0 sd=0 mult=1 m=1
csn_op1_0900_pw_rtl_hold_1 sn_op1_0900_pw_rtl_hold_1 0 {C_SN}
XMWR_op1_0900_pw_rtl_hold_2 sn_op1_0900_pw_rtl_hold_2 wwl_des wbl_op1_0900_pw_rtl_hold 0 sky130_fd_pr__nfet_01v8 L=0.15 W=0.42 nf=1 ad=0.1218 as=0.1218 pd=1.42 ps=1.42 nrd=0.69047619047619  nrs=0.69047619047619 sa=0 sb=0 sd=0 mult=1 m=1
XMRD_op1_0900_pw_rtl_hold_2 rbl_op1_0900_pw_rtl_hold sn_op1_0900_pw_rtl_hold_2 rwl_des 0 sky130_fd_pr__nfet_01v8 L=0.15 W=0.42 nf=1 ad=0.1218 as=0.1218 pd=1.42 ps=1.42 nrd=0.69047619047619  nrs=0.69047619047619 sa=0 sb=0 sd=0 mult=1 m=1
csn_op1_0900_pw_rtl_hold_2 sn_op1_0900_pw_rtl_hold_2 0 {C_SN}
XMWR_op1_0900_pw_rtl_hold_3 sn_op1_0900_pw_rtl_hold_3 wwl_des wbl_op1_0900_pw_rtl_hold 0 sky130_fd_pr__nfet_01v8 L=0.15 W=0.42 nf=1 ad=0.1218 as=0.1218 pd=1.42 ps=1.42 nrd=0.69047619047619  nrs=0.69047619047619 sa=0 sb=0 sd=0 mult=1 m=1
XMRD_op1_0900_pw_rtl_hold_3 rbl_op1_0900_pw_rtl_hold sn_op1_0900_pw_rtl_hold_3 rwl_des 0 sky130_fd_pr__nfet_01v8 L=0.15 W=0.42 nf=1 ad=0.1218 as=0.1218 pd=1.42 ps=1.42 nrd=0.69047619047619  nrs=0.69047619047619 sa=0 sb=0 sd=0 mult=1 m=1
csn_op1_0900_pw_rtl_hold_3 sn_op1_0900_pw_rtl_hold_3 0 {C_SN}
XMN1_op1_0900_pw_rtl_hold rbl_op1_0900_pw_rtl_hold ref_op1_0900_pw_rtl_hold vn_op1_0900_pw_rtl_hold 0 sky130_fd_pr__nfet_01v8 L=0.15 W=1 nf=1 ad=0.29 as=0.29 pd=2.58 ps=2.58 mult=1 m=1
XMN2_op1_0900_pw_rtl_hold ref_op1_0900_pw_rtl_hold rbl_op1_0900_pw_rtl_hold vn_op1_0900_pw_rtl_hold 0 sky130_fd_pr__nfet_01v8 L=0.15 W=1 nf=1 ad=0.29 as=0.29 pd=2.58 ps=2.58 mult=1 m=1
XMP1_op1_0900_pw_rtl_hold rbl_op1_0900_pw_rtl_hold ref_op1_0900_pw_rtl_hold vp_op1_0900_pw_rtl_hold vdd sky130_fd_pr__pfet_01v8 L=0.15 W=2 nf=1 ad=0.58 as=0.58 pd=4.58 ps=4.58 mult=1 m=1
XMP2_op1_0900_pw_rtl_hold ref_op1_0900_pw_rtl_hold rbl_op1_0900_pw_rtl_hold vp_op1_0900_pw_rtl_hold vdd sky130_fd_pr__pfet_01v8 L=0.15 W=2 nf=1 ad=0.58 as=0.58 pd=4.58 ps=4.58 mult=1 m=1
XMNF_op1_0900_pw_rtl_hold vn_op1_0900_pw_rtl_hold en_op1_0900_pw_rtl_hold 0 0 sky130_fd_pr__nfet_01v8 L=0.15 W=2 nf=1 ad=0.58 as=0.58 pd=4.58 ps=4.58 mult=1 m=1
XMPH_op1_0900_pw_rtl_hold vp_op1_0900_pw_rtl_hold enb_op1_0900_pw_rtl_hold vdd vdd sky130_fd_pr__pfet_01v8 L=0.15 W=4 nf=1 ad=1.16 as=1.16 pd=8.58 ps=8.58 mult=1 m=1
bd_op1_0900_pw_rtl_hold d_op1_0900_pw_rtl_hold 0 v=v(rbl_op1_0900_pw_rtl_hold)-v(ref_op1_0900_pw_rtl_hold)

* ---- instance 37: op1_1000_pw_rtl_hold (variant pw_rtl_hold; probe dec 35.9 ns, release 58 ns, meas 60 ns) ----
vctl_op1_1000_pw_rtl_hold ctl_op1_1000_pw_rtl_hold 0 pwl(0.0000e+00 0 2.4000e-08 0 2.4100e-08 {VDD} 2.6000e-08 {VDD} 2.6100e-08 0)
vrs_op1_1000_pw_rtl_hold rwls_op1_1000_pw_rtl_hold 0 pwl(0.0000e+00 {VDD} 2.6000e-08 {VDD} 2.6100e-08 0 3.6000e-08 0 3.6100e-08 {VDD})
ven_op1_1000_pw_rtl_hold en_op1_1000_pw_rtl_hold 0 pwl(0.0000e+00 0 3.5000e-08 0 3.5100e-08 {VDD} 5.8000e-08 {VDD} 5.8100e-08 0)
venb_op1_1000_pw_rtl_hold enb_op1_1000_pw_rtl_hold 0 pwl(0.0000e+00 {VDD} 3.5000e-08 {VDD} 3.5100e-08 0 5.8000e-08 0 5.8100e-08 {VDD})
vww_op1_1000_pw_rtl_hold wwl_op1_1000_pw_rtl_hold 0 pwl(0.0000e+00 0 1.0000e-09 0 1.1000e-09 {VDD} 2.1000e-08 {VDD} 2.1100e-08 0 3.6000e-08 0 3.6100e-08 {VDD} 5.6000e-08 {VDD} 5.6100e-08 0)
vwc_op1_1000_pw_rtl_hold wbc_op1_1000_pw_rtl_hold 0 pwl(0.0000e+00 0 3.6000e-08 0 3.6100e-08 {VDD} 5.8000e-08 {VDD} 5.8100e-08 0)
* preparation driver (physical regime; write ENABLED): WBL <- 1 V until 22 ns, then 0 V; switch open at 23 ns
vpw_op1_1000_pw_rtl_hold wpd_op1_1000_pw_rtl_hold 0 pwl(0 1 2.2000e-08 1 2.2100e-08 0)
vpc_op1_1000_pw_rtl_hold pctl_op1_1000_pw_rtl_hold 0 pwl(0.0000e+00 {VDD} 2.3000e-08 {VDD} 2.3100e-08 0)
spw_op1_1000_pw_rtl_hold wpd_op1_1000_pw_rtl_hold wbl_op1_1000_pw_rtl_hold pctl_op1_1000_pw_rtl_hold 0 swwbl
swb_op1_1000_pw_rtl_hold ref_op1_1000_pw_rtl_hold wbl_op1_1000_pw_rtl_hold wbc_op1_1000_pw_rtl_hold 0 swwbl
cwbl_op1_1000_pw_rtl_hold wbl_op1_1000_pw_rtl_hold 0 {C_WBL}
spa_op1_1000_pw_rtl_hold prea rbl_op1_1000_pw_rtl_hold ctl_op1_1000_pw_rtl_hold 0 swpre
spr_op1_1000_pw_rtl_hold pref ref_op1_1000_pw_rtl_hold ctl_op1_1000_pw_rtl_hold 0 swpre
crbl_op1_1000_pw_rtl_hold rbl_op1_1000_pw_rtl_hold 0 {C_RBL}
cref_op1_1000_pw_rtl_hold ref_op1_1000_pw_rtl_hold 0 {C_RBL}   $ ASSUMPTION: ideal matched dummy load
XMWR_op1_1000_pw_rtl_hold_0 sn_op1_1000_pw_rtl_hold_0 wwl_op1_1000_pw_rtl_hold wbl_op1_1000_pw_rtl_hold 0 sky130_fd_pr__nfet_01v8 L=0.15 W=0.42 nf=1 ad=0.1218 as=0.1218 pd=1.42 ps=1.42 nrd=0.69047619047619  nrs=0.69047619047619 sa=0 sb=0 sd=0 mult=1 m=1
XMRD_op1_1000_pw_rtl_hold_0 rbl_op1_1000_pw_rtl_hold sn_op1_1000_pw_rtl_hold_0 rwls_op1_1000_pw_rtl_hold 0 sky130_fd_pr__nfet_01v8 L=0.15 W=0.42 nf=1 ad=0.1218 as=0.1218 pd=1.42 ps=1.42 nrd=0.69047619047619  nrs=0.69047619047619 sa=0 sb=0 sd=0 mult=1 m=1
csn_op1_1000_pw_rtl_hold_0 sn_op1_1000_pw_rtl_hold_0 0 {C_SN}
XMWR_op1_1000_pw_rtl_hold_1 sn_op1_1000_pw_rtl_hold_1 wwl_des wbl_op1_1000_pw_rtl_hold 0 sky130_fd_pr__nfet_01v8 L=0.15 W=0.42 nf=1 ad=0.1218 as=0.1218 pd=1.42 ps=1.42 nrd=0.69047619047619  nrs=0.69047619047619 sa=0 sb=0 sd=0 mult=1 m=1
XMRD_op1_1000_pw_rtl_hold_1 rbl_op1_1000_pw_rtl_hold sn_op1_1000_pw_rtl_hold_1 rwl_des 0 sky130_fd_pr__nfet_01v8 L=0.15 W=0.42 nf=1 ad=0.1218 as=0.1218 pd=1.42 ps=1.42 nrd=0.69047619047619  nrs=0.69047619047619 sa=0 sb=0 sd=0 mult=1 m=1
csn_op1_1000_pw_rtl_hold_1 sn_op1_1000_pw_rtl_hold_1 0 {C_SN}
XMWR_op1_1000_pw_rtl_hold_2 sn_op1_1000_pw_rtl_hold_2 wwl_des wbl_op1_1000_pw_rtl_hold 0 sky130_fd_pr__nfet_01v8 L=0.15 W=0.42 nf=1 ad=0.1218 as=0.1218 pd=1.42 ps=1.42 nrd=0.69047619047619  nrs=0.69047619047619 sa=0 sb=0 sd=0 mult=1 m=1
XMRD_op1_1000_pw_rtl_hold_2 rbl_op1_1000_pw_rtl_hold sn_op1_1000_pw_rtl_hold_2 rwl_des 0 sky130_fd_pr__nfet_01v8 L=0.15 W=0.42 nf=1 ad=0.1218 as=0.1218 pd=1.42 ps=1.42 nrd=0.69047619047619  nrs=0.69047619047619 sa=0 sb=0 sd=0 mult=1 m=1
csn_op1_1000_pw_rtl_hold_2 sn_op1_1000_pw_rtl_hold_2 0 {C_SN}
XMWR_op1_1000_pw_rtl_hold_3 sn_op1_1000_pw_rtl_hold_3 wwl_des wbl_op1_1000_pw_rtl_hold 0 sky130_fd_pr__nfet_01v8 L=0.15 W=0.42 nf=1 ad=0.1218 as=0.1218 pd=1.42 ps=1.42 nrd=0.69047619047619  nrs=0.69047619047619 sa=0 sb=0 sd=0 mult=1 m=1
XMRD_op1_1000_pw_rtl_hold_3 rbl_op1_1000_pw_rtl_hold sn_op1_1000_pw_rtl_hold_3 rwl_des 0 sky130_fd_pr__nfet_01v8 L=0.15 W=0.42 nf=1 ad=0.1218 as=0.1218 pd=1.42 ps=1.42 nrd=0.69047619047619  nrs=0.69047619047619 sa=0 sb=0 sd=0 mult=1 m=1
csn_op1_1000_pw_rtl_hold_3 sn_op1_1000_pw_rtl_hold_3 0 {C_SN}
XMN1_op1_1000_pw_rtl_hold rbl_op1_1000_pw_rtl_hold ref_op1_1000_pw_rtl_hold vn_op1_1000_pw_rtl_hold 0 sky130_fd_pr__nfet_01v8 L=0.15 W=1 nf=1 ad=0.29 as=0.29 pd=2.58 ps=2.58 mult=1 m=1
XMN2_op1_1000_pw_rtl_hold ref_op1_1000_pw_rtl_hold rbl_op1_1000_pw_rtl_hold vn_op1_1000_pw_rtl_hold 0 sky130_fd_pr__nfet_01v8 L=0.15 W=1 nf=1 ad=0.29 as=0.29 pd=2.58 ps=2.58 mult=1 m=1
XMP1_op1_1000_pw_rtl_hold rbl_op1_1000_pw_rtl_hold ref_op1_1000_pw_rtl_hold vp_op1_1000_pw_rtl_hold vdd sky130_fd_pr__pfet_01v8 L=0.15 W=2 nf=1 ad=0.58 as=0.58 pd=4.58 ps=4.58 mult=1 m=1
XMP2_op1_1000_pw_rtl_hold ref_op1_1000_pw_rtl_hold rbl_op1_1000_pw_rtl_hold vp_op1_1000_pw_rtl_hold vdd sky130_fd_pr__pfet_01v8 L=0.15 W=2 nf=1 ad=0.58 as=0.58 pd=4.58 ps=4.58 mult=1 m=1
XMNF_op1_1000_pw_rtl_hold vn_op1_1000_pw_rtl_hold en_op1_1000_pw_rtl_hold 0 0 sky130_fd_pr__nfet_01v8 L=0.15 W=2 nf=1 ad=0.58 as=0.58 pd=4.58 ps=4.58 mult=1 m=1
XMPH_op1_1000_pw_rtl_hold vp_op1_1000_pw_rtl_hold enb_op1_1000_pw_rtl_hold vdd vdd sky130_fd_pr__pfet_01v8 L=0.15 W=4 nf=1 ad=1.16 as=1.16 pd=8.58 ps=8.58 mult=1 m=1
bd_op1_1000_pw_rtl_hold d_op1_1000_pw_rtl_hold 0 v=v(rbl_op1_1000_pw_rtl_hold)-v(ref_op1_1000_pw_rtl_hold)

* ---- instance 38: op0_n100_pw_rtl_hold (variant pw_rtl_hold; probe dec 35.9 ns, release 58 ns, meas 60 ns) ----
vctl_op0_n100_pw_rtl_hold ctl_op0_n100_pw_rtl_hold 0 pwl(0.0000e+00 0 2.4000e-08 0 2.4100e-08 {VDD} 2.6000e-08 {VDD} 2.6100e-08 0)
vrs_op0_n100_pw_rtl_hold rwls_op0_n100_pw_rtl_hold 0 pwl(0.0000e+00 {VDD} 2.6000e-08 {VDD} 2.6100e-08 0 3.6000e-08 0 3.6100e-08 {VDD})
ven_op0_n100_pw_rtl_hold en_op0_n100_pw_rtl_hold 0 pwl(0.0000e+00 0 3.5000e-08 0 3.5100e-08 {VDD} 5.8000e-08 {VDD} 5.8100e-08 0)
venb_op0_n100_pw_rtl_hold enb_op0_n100_pw_rtl_hold 0 pwl(0.0000e+00 {VDD} 3.5000e-08 {VDD} 3.5100e-08 0 5.8000e-08 0 5.8100e-08 {VDD})
vww_op0_n100_pw_rtl_hold wwl_op0_n100_pw_rtl_hold 0 pwl(0.0000e+00 0 1.0000e-09 0 1.1000e-09 {VDD} 2.1000e-08 {VDD} 2.1100e-08 0 3.6000e-08 0 3.6100e-08 {VDD} 5.6000e-08 {VDD} 5.6100e-08 0)
vwc_op0_n100_pw_rtl_hold wbc_op0_n100_pw_rtl_hold 0 pwl(0.0000e+00 0 3.6000e-08 0 3.6100e-08 {VDD} 5.8000e-08 {VDD} 5.8100e-08 0)
* preparation driver (physical regime; write ENABLED): WBL <- -0.1 V until 22 ns, then 0 V; switch open at 23 ns
vpw_op0_n100_pw_rtl_hold wpd_op0_n100_pw_rtl_hold 0 pwl(0 -0.1 2.2000e-08 -0.1 2.2100e-08 0)
vpc_op0_n100_pw_rtl_hold pctl_op0_n100_pw_rtl_hold 0 pwl(0.0000e+00 {VDD} 2.3000e-08 {VDD} 2.3100e-08 0)
spw_op0_n100_pw_rtl_hold wpd_op0_n100_pw_rtl_hold wbl_op0_n100_pw_rtl_hold pctl_op0_n100_pw_rtl_hold 0 swwbl
swb_op0_n100_pw_rtl_hold ref_op0_n100_pw_rtl_hold wbl_op0_n100_pw_rtl_hold wbc_op0_n100_pw_rtl_hold 0 swwbl
cwbl_op0_n100_pw_rtl_hold wbl_op0_n100_pw_rtl_hold 0 {C_WBL}
spa_op0_n100_pw_rtl_hold prea rbl_op0_n100_pw_rtl_hold ctl_op0_n100_pw_rtl_hold 0 swpre
spr_op0_n100_pw_rtl_hold pref ref_op0_n100_pw_rtl_hold ctl_op0_n100_pw_rtl_hold 0 swpre
crbl_op0_n100_pw_rtl_hold rbl_op0_n100_pw_rtl_hold 0 {C_RBL}
cref_op0_n100_pw_rtl_hold ref_op0_n100_pw_rtl_hold 0 {C_RBL}   $ ASSUMPTION: ideal matched dummy load
XMWR_op0_n100_pw_rtl_hold_0 sn_op0_n100_pw_rtl_hold_0 wwl_op0_n100_pw_rtl_hold wbl_op0_n100_pw_rtl_hold 0 sky130_fd_pr__nfet_01v8 L=0.15 W=0.42 nf=1 ad=0.1218 as=0.1218 pd=1.42 ps=1.42 nrd=0.69047619047619  nrs=0.69047619047619 sa=0 sb=0 sd=0 mult=1 m=1
XMRD_op0_n100_pw_rtl_hold_0 rbl_op0_n100_pw_rtl_hold sn_op0_n100_pw_rtl_hold_0 rwls_op0_n100_pw_rtl_hold 0 sky130_fd_pr__nfet_01v8 L=0.15 W=0.42 nf=1 ad=0.1218 as=0.1218 pd=1.42 ps=1.42 nrd=0.69047619047619  nrs=0.69047619047619 sa=0 sb=0 sd=0 mult=1 m=1
csn_op0_n100_pw_rtl_hold_0 sn_op0_n100_pw_rtl_hold_0 0 {C_SN}
XMWR_op0_n100_pw_rtl_hold_1 sn_op0_n100_pw_rtl_hold_1 wwl_des wbl_op0_n100_pw_rtl_hold 0 sky130_fd_pr__nfet_01v8 L=0.15 W=0.42 nf=1 ad=0.1218 as=0.1218 pd=1.42 ps=1.42 nrd=0.69047619047619  nrs=0.69047619047619 sa=0 sb=0 sd=0 mult=1 m=1
XMRD_op0_n100_pw_rtl_hold_1 rbl_op0_n100_pw_rtl_hold sn_op0_n100_pw_rtl_hold_1 rwl_des 0 sky130_fd_pr__nfet_01v8 L=0.15 W=0.42 nf=1 ad=0.1218 as=0.1218 pd=1.42 ps=1.42 nrd=0.69047619047619  nrs=0.69047619047619 sa=0 sb=0 sd=0 mult=1 m=1
csn_op0_n100_pw_rtl_hold_1 sn_op0_n100_pw_rtl_hold_1 0 {C_SN}
XMWR_op0_n100_pw_rtl_hold_2 sn_op0_n100_pw_rtl_hold_2 wwl_des wbl_op0_n100_pw_rtl_hold 0 sky130_fd_pr__nfet_01v8 L=0.15 W=0.42 nf=1 ad=0.1218 as=0.1218 pd=1.42 ps=1.42 nrd=0.69047619047619  nrs=0.69047619047619 sa=0 sb=0 sd=0 mult=1 m=1
XMRD_op0_n100_pw_rtl_hold_2 rbl_op0_n100_pw_rtl_hold sn_op0_n100_pw_rtl_hold_2 rwl_des 0 sky130_fd_pr__nfet_01v8 L=0.15 W=0.42 nf=1 ad=0.1218 as=0.1218 pd=1.42 ps=1.42 nrd=0.69047619047619  nrs=0.69047619047619 sa=0 sb=0 sd=0 mult=1 m=1
csn_op0_n100_pw_rtl_hold_2 sn_op0_n100_pw_rtl_hold_2 0 {C_SN}
XMWR_op0_n100_pw_rtl_hold_3 sn_op0_n100_pw_rtl_hold_3 wwl_des wbl_op0_n100_pw_rtl_hold 0 sky130_fd_pr__nfet_01v8 L=0.15 W=0.42 nf=1 ad=0.1218 as=0.1218 pd=1.42 ps=1.42 nrd=0.69047619047619  nrs=0.69047619047619 sa=0 sb=0 sd=0 mult=1 m=1
XMRD_op0_n100_pw_rtl_hold_3 rbl_op0_n100_pw_rtl_hold sn_op0_n100_pw_rtl_hold_3 rwl_des 0 sky130_fd_pr__nfet_01v8 L=0.15 W=0.42 nf=1 ad=0.1218 as=0.1218 pd=1.42 ps=1.42 nrd=0.69047619047619  nrs=0.69047619047619 sa=0 sb=0 sd=0 mult=1 m=1
csn_op0_n100_pw_rtl_hold_3 sn_op0_n100_pw_rtl_hold_3 0 {C_SN}
XMN1_op0_n100_pw_rtl_hold rbl_op0_n100_pw_rtl_hold ref_op0_n100_pw_rtl_hold vn_op0_n100_pw_rtl_hold 0 sky130_fd_pr__nfet_01v8 L=0.15 W=1 nf=1 ad=0.29 as=0.29 pd=2.58 ps=2.58 mult=1 m=1
XMN2_op0_n100_pw_rtl_hold ref_op0_n100_pw_rtl_hold rbl_op0_n100_pw_rtl_hold vn_op0_n100_pw_rtl_hold 0 sky130_fd_pr__nfet_01v8 L=0.15 W=1 nf=1 ad=0.29 as=0.29 pd=2.58 ps=2.58 mult=1 m=1
XMP1_op0_n100_pw_rtl_hold rbl_op0_n100_pw_rtl_hold ref_op0_n100_pw_rtl_hold vp_op0_n100_pw_rtl_hold vdd sky130_fd_pr__pfet_01v8 L=0.15 W=2 nf=1 ad=0.58 as=0.58 pd=4.58 ps=4.58 mult=1 m=1
XMP2_op0_n100_pw_rtl_hold ref_op0_n100_pw_rtl_hold rbl_op0_n100_pw_rtl_hold vp_op0_n100_pw_rtl_hold vdd sky130_fd_pr__pfet_01v8 L=0.15 W=2 nf=1 ad=0.58 as=0.58 pd=4.58 ps=4.58 mult=1 m=1
XMNF_op0_n100_pw_rtl_hold vn_op0_n100_pw_rtl_hold en_op0_n100_pw_rtl_hold 0 0 sky130_fd_pr__nfet_01v8 L=0.15 W=2 nf=1 ad=0.58 as=0.58 pd=4.58 ps=4.58 mult=1 m=1
XMPH_op0_n100_pw_rtl_hold vp_op0_n100_pw_rtl_hold enb_op0_n100_pw_rtl_hold vdd vdd sky130_fd_pr__pfet_01v8 L=0.15 W=4 nf=1 ad=1.16 as=1.16 pd=8.58 ps=8.58 mult=1 m=1
bd_op0_n100_pw_rtl_hold d_op0_n100_pw_rtl_hold 0 v=v(rbl_op0_n100_pw_rtl_hold)-v(ref_op0_n100_pw_rtl_hold)

* ---- instance 39: op0_0000_pw_rtl_hold (variant pw_rtl_hold; probe dec 35.9 ns, release 58 ns, meas 60 ns) ----
vctl_op0_0000_pw_rtl_hold ctl_op0_0000_pw_rtl_hold 0 pwl(0.0000e+00 0 2.4000e-08 0 2.4100e-08 {VDD} 2.6000e-08 {VDD} 2.6100e-08 0)
vrs_op0_0000_pw_rtl_hold rwls_op0_0000_pw_rtl_hold 0 pwl(0.0000e+00 {VDD} 2.6000e-08 {VDD} 2.6100e-08 0 3.6000e-08 0 3.6100e-08 {VDD})
ven_op0_0000_pw_rtl_hold en_op0_0000_pw_rtl_hold 0 pwl(0.0000e+00 0 3.5000e-08 0 3.5100e-08 {VDD} 5.8000e-08 {VDD} 5.8100e-08 0)
venb_op0_0000_pw_rtl_hold enb_op0_0000_pw_rtl_hold 0 pwl(0.0000e+00 {VDD} 3.5000e-08 {VDD} 3.5100e-08 0 5.8000e-08 0 5.8100e-08 {VDD})
vww_op0_0000_pw_rtl_hold wwl_op0_0000_pw_rtl_hold 0 pwl(0.0000e+00 0 1.0000e-09 0 1.1000e-09 {VDD} 2.1000e-08 {VDD} 2.1100e-08 0 3.6000e-08 0 3.6100e-08 {VDD} 5.6000e-08 {VDD} 5.6100e-08 0)
vwc_op0_0000_pw_rtl_hold wbc_op0_0000_pw_rtl_hold 0 pwl(0.0000e+00 0 3.6000e-08 0 3.6100e-08 {VDD} 5.8000e-08 {VDD} 5.8100e-08 0)
* preparation driver (physical regime; write ENABLED): WBL <- 0 V until 22 ns, then 0 V; switch open at 23 ns
vpw_op0_0000_pw_rtl_hold wpd_op0_0000_pw_rtl_hold 0 pwl(0 0 2.2000e-08 0 2.2100e-08 0)
vpc_op0_0000_pw_rtl_hold pctl_op0_0000_pw_rtl_hold 0 pwl(0.0000e+00 {VDD} 2.3000e-08 {VDD} 2.3100e-08 0)
spw_op0_0000_pw_rtl_hold wpd_op0_0000_pw_rtl_hold wbl_op0_0000_pw_rtl_hold pctl_op0_0000_pw_rtl_hold 0 swwbl
swb_op0_0000_pw_rtl_hold ref_op0_0000_pw_rtl_hold wbl_op0_0000_pw_rtl_hold wbc_op0_0000_pw_rtl_hold 0 swwbl
cwbl_op0_0000_pw_rtl_hold wbl_op0_0000_pw_rtl_hold 0 {C_WBL}
spa_op0_0000_pw_rtl_hold prea rbl_op0_0000_pw_rtl_hold ctl_op0_0000_pw_rtl_hold 0 swpre
spr_op0_0000_pw_rtl_hold pref ref_op0_0000_pw_rtl_hold ctl_op0_0000_pw_rtl_hold 0 swpre
crbl_op0_0000_pw_rtl_hold rbl_op0_0000_pw_rtl_hold 0 {C_RBL}
cref_op0_0000_pw_rtl_hold ref_op0_0000_pw_rtl_hold 0 {C_RBL}   $ ASSUMPTION: ideal matched dummy load
XMWR_op0_0000_pw_rtl_hold_0 sn_op0_0000_pw_rtl_hold_0 wwl_op0_0000_pw_rtl_hold wbl_op0_0000_pw_rtl_hold 0 sky130_fd_pr__nfet_01v8 L=0.15 W=0.42 nf=1 ad=0.1218 as=0.1218 pd=1.42 ps=1.42 nrd=0.69047619047619  nrs=0.69047619047619 sa=0 sb=0 sd=0 mult=1 m=1
XMRD_op0_0000_pw_rtl_hold_0 rbl_op0_0000_pw_rtl_hold sn_op0_0000_pw_rtl_hold_0 rwls_op0_0000_pw_rtl_hold 0 sky130_fd_pr__nfet_01v8 L=0.15 W=0.42 nf=1 ad=0.1218 as=0.1218 pd=1.42 ps=1.42 nrd=0.69047619047619  nrs=0.69047619047619 sa=0 sb=0 sd=0 mult=1 m=1
csn_op0_0000_pw_rtl_hold_0 sn_op0_0000_pw_rtl_hold_0 0 {C_SN}
XMWR_op0_0000_pw_rtl_hold_1 sn_op0_0000_pw_rtl_hold_1 wwl_des wbl_op0_0000_pw_rtl_hold 0 sky130_fd_pr__nfet_01v8 L=0.15 W=0.42 nf=1 ad=0.1218 as=0.1218 pd=1.42 ps=1.42 nrd=0.69047619047619  nrs=0.69047619047619 sa=0 sb=0 sd=0 mult=1 m=1
XMRD_op0_0000_pw_rtl_hold_1 rbl_op0_0000_pw_rtl_hold sn_op0_0000_pw_rtl_hold_1 rwl_des 0 sky130_fd_pr__nfet_01v8 L=0.15 W=0.42 nf=1 ad=0.1218 as=0.1218 pd=1.42 ps=1.42 nrd=0.69047619047619  nrs=0.69047619047619 sa=0 sb=0 sd=0 mult=1 m=1
csn_op0_0000_pw_rtl_hold_1 sn_op0_0000_pw_rtl_hold_1 0 {C_SN}
XMWR_op0_0000_pw_rtl_hold_2 sn_op0_0000_pw_rtl_hold_2 wwl_des wbl_op0_0000_pw_rtl_hold 0 sky130_fd_pr__nfet_01v8 L=0.15 W=0.42 nf=1 ad=0.1218 as=0.1218 pd=1.42 ps=1.42 nrd=0.69047619047619  nrs=0.69047619047619 sa=0 sb=0 sd=0 mult=1 m=1
XMRD_op0_0000_pw_rtl_hold_2 rbl_op0_0000_pw_rtl_hold sn_op0_0000_pw_rtl_hold_2 rwl_des 0 sky130_fd_pr__nfet_01v8 L=0.15 W=0.42 nf=1 ad=0.1218 as=0.1218 pd=1.42 ps=1.42 nrd=0.69047619047619  nrs=0.69047619047619 sa=0 sb=0 sd=0 mult=1 m=1
csn_op0_0000_pw_rtl_hold_2 sn_op0_0000_pw_rtl_hold_2 0 {C_SN}
XMWR_op0_0000_pw_rtl_hold_3 sn_op0_0000_pw_rtl_hold_3 wwl_des wbl_op0_0000_pw_rtl_hold 0 sky130_fd_pr__nfet_01v8 L=0.15 W=0.42 nf=1 ad=0.1218 as=0.1218 pd=1.42 ps=1.42 nrd=0.69047619047619  nrs=0.69047619047619 sa=0 sb=0 sd=0 mult=1 m=1
XMRD_op0_0000_pw_rtl_hold_3 rbl_op0_0000_pw_rtl_hold sn_op0_0000_pw_rtl_hold_3 rwl_des 0 sky130_fd_pr__nfet_01v8 L=0.15 W=0.42 nf=1 ad=0.1218 as=0.1218 pd=1.42 ps=1.42 nrd=0.69047619047619  nrs=0.69047619047619 sa=0 sb=0 sd=0 mult=1 m=1
csn_op0_0000_pw_rtl_hold_3 sn_op0_0000_pw_rtl_hold_3 0 {C_SN}
XMN1_op0_0000_pw_rtl_hold rbl_op0_0000_pw_rtl_hold ref_op0_0000_pw_rtl_hold vn_op0_0000_pw_rtl_hold 0 sky130_fd_pr__nfet_01v8 L=0.15 W=1 nf=1 ad=0.29 as=0.29 pd=2.58 ps=2.58 mult=1 m=1
XMN2_op0_0000_pw_rtl_hold ref_op0_0000_pw_rtl_hold rbl_op0_0000_pw_rtl_hold vn_op0_0000_pw_rtl_hold 0 sky130_fd_pr__nfet_01v8 L=0.15 W=1 nf=1 ad=0.29 as=0.29 pd=2.58 ps=2.58 mult=1 m=1
XMP1_op0_0000_pw_rtl_hold rbl_op0_0000_pw_rtl_hold ref_op0_0000_pw_rtl_hold vp_op0_0000_pw_rtl_hold vdd sky130_fd_pr__pfet_01v8 L=0.15 W=2 nf=1 ad=0.58 as=0.58 pd=4.58 ps=4.58 mult=1 m=1
XMP2_op0_0000_pw_rtl_hold ref_op0_0000_pw_rtl_hold rbl_op0_0000_pw_rtl_hold vp_op0_0000_pw_rtl_hold vdd sky130_fd_pr__pfet_01v8 L=0.15 W=2 nf=1 ad=0.58 as=0.58 pd=4.58 ps=4.58 mult=1 m=1
XMNF_op0_0000_pw_rtl_hold vn_op0_0000_pw_rtl_hold en_op0_0000_pw_rtl_hold 0 0 sky130_fd_pr__nfet_01v8 L=0.15 W=2 nf=1 ad=0.58 as=0.58 pd=4.58 ps=4.58 mult=1 m=1
XMPH_op0_0000_pw_rtl_hold vp_op0_0000_pw_rtl_hold enb_op0_0000_pw_rtl_hold vdd vdd sky130_fd_pr__pfet_01v8 L=0.15 W=4 nf=1 ad=1.16 as=1.16 pd=8.58 ps=8.58 mult=1 m=1
bd_op0_0000_pw_rtl_hold d_op0_0000_pw_rtl_hold 0 v=v(rbl_op0_0000_pw_rtl_hold)-v(ref_op0_0000_pw_rtl_hold)

* ---- instance 40: op1_0900_pw_rwl_late_hold (variant pw_rwl_late_hold; probe dec 35.9 ns, release 58 ns, meas 60 ns) ----
vctl_op1_0900_pw_rwl_late_hold ctl_op1_0900_pw_rwl_late_hold 0 pwl(0.0000e+00 0 2.4000e-08 0 2.4100e-08 {VDD} 2.6000e-08 {VDD} 2.6100e-08 0)
vrs_op1_0900_pw_rwl_late_hold rwls_op1_0900_pw_rwl_late_hold 0 pwl(0.0000e+00 {VDD} 2.6000e-08 {VDD} 2.6100e-08 0 5.8000e-08 0 5.8100e-08 {VDD})
ven_op1_0900_pw_rwl_late_hold en_op1_0900_pw_rwl_late_hold 0 pwl(0.0000e+00 0 3.5000e-08 0 3.5100e-08 {VDD} 5.8000e-08 {VDD} 5.8100e-08 0)
venb_op1_0900_pw_rwl_late_hold enb_op1_0900_pw_rwl_late_hold 0 pwl(0.0000e+00 {VDD} 3.5000e-08 {VDD} 3.5100e-08 0 5.8000e-08 0 5.8100e-08 {VDD})
vww_op1_0900_pw_rwl_late_hold wwl_op1_0900_pw_rwl_late_hold 0 pwl(0.0000e+00 0 1.0000e-09 0 1.1000e-09 {VDD} 2.1000e-08 {VDD} 2.1100e-08 0 3.6000e-08 0 3.6100e-08 {VDD} 5.6000e-08 {VDD} 5.6100e-08 0)
vwc_op1_0900_pw_rwl_late_hold wbc_op1_0900_pw_rwl_late_hold 0 pwl(0.0000e+00 0 3.6000e-08 0 3.6100e-08 {VDD} 5.8000e-08 {VDD} 5.8100e-08 0)
* preparation driver (physical regime; write ENABLED): WBL <- 0.9 V until 22 ns, then 0 V; switch open at 23 ns
vpw_op1_0900_pw_rwl_late_hold wpd_op1_0900_pw_rwl_late_hold 0 pwl(0 0.9 2.2000e-08 0.9 2.2100e-08 0)
vpc_op1_0900_pw_rwl_late_hold pctl_op1_0900_pw_rwl_late_hold 0 pwl(0.0000e+00 {VDD} 2.3000e-08 {VDD} 2.3100e-08 0)
spw_op1_0900_pw_rwl_late_hold wpd_op1_0900_pw_rwl_late_hold wbl_op1_0900_pw_rwl_late_hold pctl_op1_0900_pw_rwl_late_hold 0 swwbl
swb_op1_0900_pw_rwl_late_hold ref_op1_0900_pw_rwl_late_hold wbl_op1_0900_pw_rwl_late_hold wbc_op1_0900_pw_rwl_late_hold 0 swwbl
cwbl_op1_0900_pw_rwl_late_hold wbl_op1_0900_pw_rwl_late_hold 0 {C_WBL}
spa_op1_0900_pw_rwl_late_hold prea rbl_op1_0900_pw_rwl_late_hold ctl_op1_0900_pw_rwl_late_hold 0 swpre
spr_op1_0900_pw_rwl_late_hold pref ref_op1_0900_pw_rwl_late_hold ctl_op1_0900_pw_rwl_late_hold 0 swpre
crbl_op1_0900_pw_rwl_late_hold rbl_op1_0900_pw_rwl_late_hold 0 {C_RBL}
cref_op1_0900_pw_rwl_late_hold ref_op1_0900_pw_rwl_late_hold 0 {C_RBL}   $ ASSUMPTION: ideal matched dummy load
XMWR_op1_0900_pw_rwl_late_hold_0 sn_op1_0900_pw_rwl_late_hold_0 wwl_op1_0900_pw_rwl_late_hold wbl_op1_0900_pw_rwl_late_hold 0 sky130_fd_pr__nfet_01v8 L=0.15 W=0.42 nf=1 ad=0.1218 as=0.1218 pd=1.42 ps=1.42 nrd=0.69047619047619  nrs=0.69047619047619 sa=0 sb=0 sd=0 mult=1 m=1
XMRD_op1_0900_pw_rwl_late_hold_0 rbl_op1_0900_pw_rwl_late_hold sn_op1_0900_pw_rwl_late_hold_0 rwls_op1_0900_pw_rwl_late_hold 0 sky130_fd_pr__nfet_01v8 L=0.15 W=0.42 nf=1 ad=0.1218 as=0.1218 pd=1.42 ps=1.42 nrd=0.69047619047619  nrs=0.69047619047619 sa=0 sb=0 sd=0 mult=1 m=1
csn_op1_0900_pw_rwl_late_hold_0 sn_op1_0900_pw_rwl_late_hold_0 0 {C_SN}
XMWR_op1_0900_pw_rwl_late_hold_1 sn_op1_0900_pw_rwl_late_hold_1 wwl_des wbl_op1_0900_pw_rwl_late_hold 0 sky130_fd_pr__nfet_01v8 L=0.15 W=0.42 nf=1 ad=0.1218 as=0.1218 pd=1.42 ps=1.42 nrd=0.69047619047619  nrs=0.69047619047619 sa=0 sb=0 sd=0 mult=1 m=1
XMRD_op1_0900_pw_rwl_late_hold_1 rbl_op1_0900_pw_rwl_late_hold sn_op1_0900_pw_rwl_late_hold_1 rwl_des 0 sky130_fd_pr__nfet_01v8 L=0.15 W=0.42 nf=1 ad=0.1218 as=0.1218 pd=1.42 ps=1.42 nrd=0.69047619047619  nrs=0.69047619047619 sa=0 sb=0 sd=0 mult=1 m=1
csn_op1_0900_pw_rwl_late_hold_1 sn_op1_0900_pw_rwl_late_hold_1 0 {C_SN}
XMWR_op1_0900_pw_rwl_late_hold_2 sn_op1_0900_pw_rwl_late_hold_2 wwl_des wbl_op1_0900_pw_rwl_late_hold 0 sky130_fd_pr__nfet_01v8 L=0.15 W=0.42 nf=1 ad=0.1218 as=0.1218 pd=1.42 ps=1.42 nrd=0.69047619047619  nrs=0.69047619047619 sa=0 sb=0 sd=0 mult=1 m=1
XMRD_op1_0900_pw_rwl_late_hold_2 rbl_op1_0900_pw_rwl_late_hold sn_op1_0900_pw_rwl_late_hold_2 rwl_des 0 sky130_fd_pr__nfet_01v8 L=0.15 W=0.42 nf=1 ad=0.1218 as=0.1218 pd=1.42 ps=1.42 nrd=0.69047619047619  nrs=0.69047619047619 sa=0 sb=0 sd=0 mult=1 m=1
csn_op1_0900_pw_rwl_late_hold_2 sn_op1_0900_pw_rwl_late_hold_2 0 {C_SN}
XMWR_op1_0900_pw_rwl_late_hold_3 sn_op1_0900_pw_rwl_late_hold_3 wwl_des wbl_op1_0900_pw_rwl_late_hold 0 sky130_fd_pr__nfet_01v8 L=0.15 W=0.42 nf=1 ad=0.1218 as=0.1218 pd=1.42 ps=1.42 nrd=0.69047619047619  nrs=0.69047619047619 sa=0 sb=0 sd=0 mult=1 m=1
XMRD_op1_0900_pw_rwl_late_hold_3 rbl_op1_0900_pw_rwl_late_hold sn_op1_0900_pw_rwl_late_hold_3 rwl_des 0 sky130_fd_pr__nfet_01v8 L=0.15 W=0.42 nf=1 ad=0.1218 as=0.1218 pd=1.42 ps=1.42 nrd=0.69047619047619  nrs=0.69047619047619 sa=0 sb=0 sd=0 mult=1 m=1
csn_op1_0900_pw_rwl_late_hold_3 sn_op1_0900_pw_rwl_late_hold_3 0 {C_SN}
XMN1_op1_0900_pw_rwl_late_hold rbl_op1_0900_pw_rwl_late_hold ref_op1_0900_pw_rwl_late_hold vn_op1_0900_pw_rwl_late_hold 0 sky130_fd_pr__nfet_01v8 L=0.15 W=1 nf=1 ad=0.29 as=0.29 pd=2.58 ps=2.58 mult=1 m=1
XMN2_op1_0900_pw_rwl_late_hold ref_op1_0900_pw_rwl_late_hold rbl_op1_0900_pw_rwl_late_hold vn_op1_0900_pw_rwl_late_hold 0 sky130_fd_pr__nfet_01v8 L=0.15 W=1 nf=1 ad=0.29 as=0.29 pd=2.58 ps=2.58 mult=1 m=1
XMP1_op1_0900_pw_rwl_late_hold rbl_op1_0900_pw_rwl_late_hold ref_op1_0900_pw_rwl_late_hold vp_op1_0900_pw_rwl_late_hold vdd sky130_fd_pr__pfet_01v8 L=0.15 W=2 nf=1 ad=0.58 as=0.58 pd=4.58 ps=4.58 mult=1 m=1
XMP2_op1_0900_pw_rwl_late_hold ref_op1_0900_pw_rwl_late_hold rbl_op1_0900_pw_rwl_late_hold vp_op1_0900_pw_rwl_late_hold vdd sky130_fd_pr__pfet_01v8 L=0.15 W=2 nf=1 ad=0.58 as=0.58 pd=4.58 ps=4.58 mult=1 m=1
XMNF_op1_0900_pw_rwl_late_hold vn_op1_0900_pw_rwl_late_hold en_op1_0900_pw_rwl_late_hold 0 0 sky130_fd_pr__nfet_01v8 L=0.15 W=2 nf=1 ad=0.58 as=0.58 pd=4.58 ps=4.58 mult=1 m=1
XMPH_op1_0900_pw_rwl_late_hold vp_op1_0900_pw_rwl_late_hold enb_op1_0900_pw_rwl_late_hold vdd vdd sky130_fd_pr__pfet_01v8 L=0.15 W=4 nf=1 ad=1.16 as=1.16 pd=8.58 ps=8.58 mult=1 m=1
bd_op1_0900_pw_rwl_late_hold d_op1_0900_pw_rwl_late_hold 0 v=v(rbl_op1_0900_pw_rwl_late_hold)-v(ref_op1_0900_pw_rwl_late_hold)

* ---- instance 41: op1_1000_pw_rwl_late_hold (variant pw_rwl_late_hold; probe dec 35.9 ns, release 58 ns, meas 60 ns) ----
vctl_op1_1000_pw_rwl_late_hold ctl_op1_1000_pw_rwl_late_hold 0 pwl(0.0000e+00 0 2.4000e-08 0 2.4100e-08 {VDD} 2.6000e-08 {VDD} 2.6100e-08 0)
vrs_op1_1000_pw_rwl_late_hold rwls_op1_1000_pw_rwl_late_hold 0 pwl(0.0000e+00 {VDD} 2.6000e-08 {VDD} 2.6100e-08 0 5.8000e-08 0 5.8100e-08 {VDD})
ven_op1_1000_pw_rwl_late_hold en_op1_1000_pw_rwl_late_hold 0 pwl(0.0000e+00 0 3.5000e-08 0 3.5100e-08 {VDD} 5.8000e-08 {VDD} 5.8100e-08 0)
venb_op1_1000_pw_rwl_late_hold enb_op1_1000_pw_rwl_late_hold 0 pwl(0.0000e+00 {VDD} 3.5000e-08 {VDD} 3.5100e-08 0 5.8000e-08 0 5.8100e-08 {VDD})
vww_op1_1000_pw_rwl_late_hold wwl_op1_1000_pw_rwl_late_hold 0 pwl(0.0000e+00 0 1.0000e-09 0 1.1000e-09 {VDD} 2.1000e-08 {VDD} 2.1100e-08 0 3.6000e-08 0 3.6100e-08 {VDD} 5.6000e-08 {VDD} 5.6100e-08 0)
vwc_op1_1000_pw_rwl_late_hold wbc_op1_1000_pw_rwl_late_hold 0 pwl(0.0000e+00 0 3.6000e-08 0 3.6100e-08 {VDD} 5.8000e-08 {VDD} 5.8100e-08 0)
* preparation driver (physical regime; write ENABLED): WBL <- 1 V until 22 ns, then 0 V; switch open at 23 ns
vpw_op1_1000_pw_rwl_late_hold wpd_op1_1000_pw_rwl_late_hold 0 pwl(0 1 2.2000e-08 1 2.2100e-08 0)
vpc_op1_1000_pw_rwl_late_hold pctl_op1_1000_pw_rwl_late_hold 0 pwl(0.0000e+00 {VDD} 2.3000e-08 {VDD} 2.3100e-08 0)
spw_op1_1000_pw_rwl_late_hold wpd_op1_1000_pw_rwl_late_hold wbl_op1_1000_pw_rwl_late_hold pctl_op1_1000_pw_rwl_late_hold 0 swwbl
swb_op1_1000_pw_rwl_late_hold ref_op1_1000_pw_rwl_late_hold wbl_op1_1000_pw_rwl_late_hold wbc_op1_1000_pw_rwl_late_hold 0 swwbl
cwbl_op1_1000_pw_rwl_late_hold wbl_op1_1000_pw_rwl_late_hold 0 {C_WBL}
spa_op1_1000_pw_rwl_late_hold prea rbl_op1_1000_pw_rwl_late_hold ctl_op1_1000_pw_rwl_late_hold 0 swpre
spr_op1_1000_pw_rwl_late_hold pref ref_op1_1000_pw_rwl_late_hold ctl_op1_1000_pw_rwl_late_hold 0 swpre
crbl_op1_1000_pw_rwl_late_hold rbl_op1_1000_pw_rwl_late_hold 0 {C_RBL}
cref_op1_1000_pw_rwl_late_hold ref_op1_1000_pw_rwl_late_hold 0 {C_RBL}   $ ASSUMPTION: ideal matched dummy load
XMWR_op1_1000_pw_rwl_late_hold_0 sn_op1_1000_pw_rwl_late_hold_0 wwl_op1_1000_pw_rwl_late_hold wbl_op1_1000_pw_rwl_late_hold 0 sky130_fd_pr__nfet_01v8 L=0.15 W=0.42 nf=1 ad=0.1218 as=0.1218 pd=1.42 ps=1.42 nrd=0.69047619047619  nrs=0.69047619047619 sa=0 sb=0 sd=0 mult=1 m=1
XMRD_op1_1000_pw_rwl_late_hold_0 rbl_op1_1000_pw_rwl_late_hold sn_op1_1000_pw_rwl_late_hold_0 rwls_op1_1000_pw_rwl_late_hold 0 sky130_fd_pr__nfet_01v8 L=0.15 W=0.42 nf=1 ad=0.1218 as=0.1218 pd=1.42 ps=1.42 nrd=0.69047619047619  nrs=0.69047619047619 sa=0 sb=0 sd=0 mult=1 m=1
csn_op1_1000_pw_rwl_late_hold_0 sn_op1_1000_pw_rwl_late_hold_0 0 {C_SN}
XMWR_op1_1000_pw_rwl_late_hold_1 sn_op1_1000_pw_rwl_late_hold_1 wwl_des wbl_op1_1000_pw_rwl_late_hold 0 sky130_fd_pr__nfet_01v8 L=0.15 W=0.42 nf=1 ad=0.1218 as=0.1218 pd=1.42 ps=1.42 nrd=0.69047619047619  nrs=0.69047619047619 sa=0 sb=0 sd=0 mult=1 m=1
XMRD_op1_1000_pw_rwl_late_hold_1 rbl_op1_1000_pw_rwl_late_hold sn_op1_1000_pw_rwl_late_hold_1 rwl_des 0 sky130_fd_pr__nfet_01v8 L=0.15 W=0.42 nf=1 ad=0.1218 as=0.1218 pd=1.42 ps=1.42 nrd=0.69047619047619  nrs=0.69047619047619 sa=0 sb=0 sd=0 mult=1 m=1
csn_op1_1000_pw_rwl_late_hold_1 sn_op1_1000_pw_rwl_late_hold_1 0 {C_SN}
XMWR_op1_1000_pw_rwl_late_hold_2 sn_op1_1000_pw_rwl_late_hold_2 wwl_des wbl_op1_1000_pw_rwl_late_hold 0 sky130_fd_pr__nfet_01v8 L=0.15 W=0.42 nf=1 ad=0.1218 as=0.1218 pd=1.42 ps=1.42 nrd=0.69047619047619  nrs=0.69047619047619 sa=0 sb=0 sd=0 mult=1 m=1
XMRD_op1_1000_pw_rwl_late_hold_2 rbl_op1_1000_pw_rwl_late_hold sn_op1_1000_pw_rwl_late_hold_2 rwl_des 0 sky130_fd_pr__nfet_01v8 L=0.15 W=0.42 nf=1 ad=0.1218 as=0.1218 pd=1.42 ps=1.42 nrd=0.69047619047619  nrs=0.69047619047619 sa=0 sb=0 sd=0 mult=1 m=1
csn_op1_1000_pw_rwl_late_hold_2 sn_op1_1000_pw_rwl_late_hold_2 0 {C_SN}
XMWR_op1_1000_pw_rwl_late_hold_3 sn_op1_1000_pw_rwl_late_hold_3 wwl_des wbl_op1_1000_pw_rwl_late_hold 0 sky130_fd_pr__nfet_01v8 L=0.15 W=0.42 nf=1 ad=0.1218 as=0.1218 pd=1.42 ps=1.42 nrd=0.69047619047619  nrs=0.69047619047619 sa=0 sb=0 sd=0 mult=1 m=1
XMRD_op1_1000_pw_rwl_late_hold_3 rbl_op1_1000_pw_rwl_late_hold sn_op1_1000_pw_rwl_late_hold_3 rwl_des 0 sky130_fd_pr__nfet_01v8 L=0.15 W=0.42 nf=1 ad=0.1218 as=0.1218 pd=1.42 ps=1.42 nrd=0.69047619047619  nrs=0.69047619047619 sa=0 sb=0 sd=0 mult=1 m=1
csn_op1_1000_pw_rwl_late_hold_3 sn_op1_1000_pw_rwl_late_hold_3 0 {C_SN}
XMN1_op1_1000_pw_rwl_late_hold rbl_op1_1000_pw_rwl_late_hold ref_op1_1000_pw_rwl_late_hold vn_op1_1000_pw_rwl_late_hold 0 sky130_fd_pr__nfet_01v8 L=0.15 W=1 nf=1 ad=0.29 as=0.29 pd=2.58 ps=2.58 mult=1 m=1
XMN2_op1_1000_pw_rwl_late_hold ref_op1_1000_pw_rwl_late_hold rbl_op1_1000_pw_rwl_late_hold vn_op1_1000_pw_rwl_late_hold 0 sky130_fd_pr__nfet_01v8 L=0.15 W=1 nf=1 ad=0.29 as=0.29 pd=2.58 ps=2.58 mult=1 m=1
XMP1_op1_1000_pw_rwl_late_hold rbl_op1_1000_pw_rwl_late_hold ref_op1_1000_pw_rwl_late_hold vp_op1_1000_pw_rwl_late_hold vdd sky130_fd_pr__pfet_01v8 L=0.15 W=2 nf=1 ad=0.58 as=0.58 pd=4.58 ps=4.58 mult=1 m=1
XMP2_op1_1000_pw_rwl_late_hold ref_op1_1000_pw_rwl_late_hold rbl_op1_1000_pw_rwl_late_hold vp_op1_1000_pw_rwl_late_hold vdd sky130_fd_pr__pfet_01v8 L=0.15 W=2 nf=1 ad=0.58 as=0.58 pd=4.58 ps=4.58 mult=1 m=1
XMNF_op1_1000_pw_rwl_late_hold vn_op1_1000_pw_rwl_late_hold en_op1_1000_pw_rwl_late_hold 0 0 sky130_fd_pr__nfet_01v8 L=0.15 W=2 nf=1 ad=0.58 as=0.58 pd=4.58 ps=4.58 mult=1 m=1
XMPH_op1_1000_pw_rwl_late_hold vp_op1_1000_pw_rwl_late_hold enb_op1_1000_pw_rwl_late_hold vdd vdd sky130_fd_pr__pfet_01v8 L=0.15 W=4 nf=1 ad=1.16 as=1.16 pd=8.58 ps=8.58 mult=1 m=1
bd_op1_1000_pw_rwl_late_hold d_op1_1000_pw_rwl_late_hold 0 v=v(rbl_op1_1000_pw_rwl_late_hold)-v(ref_op1_1000_pw_rwl_late_hold)

* ---- instance 42: op0_n100_pw_rwl_late_hold (variant pw_rwl_late_hold; probe dec 35.9 ns, release 58 ns, meas 60 ns) ----
vctl_op0_n100_pw_rwl_late_hold ctl_op0_n100_pw_rwl_late_hold 0 pwl(0.0000e+00 0 2.4000e-08 0 2.4100e-08 {VDD} 2.6000e-08 {VDD} 2.6100e-08 0)
vrs_op0_n100_pw_rwl_late_hold rwls_op0_n100_pw_rwl_late_hold 0 pwl(0.0000e+00 {VDD} 2.6000e-08 {VDD} 2.6100e-08 0 5.8000e-08 0 5.8100e-08 {VDD})
ven_op0_n100_pw_rwl_late_hold en_op0_n100_pw_rwl_late_hold 0 pwl(0.0000e+00 0 3.5000e-08 0 3.5100e-08 {VDD} 5.8000e-08 {VDD} 5.8100e-08 0)
venb_op0_n100_pw_rwl_late_hold enb_op0_n100_pw_rwl_late_hold 0 pwl(0.0000e+00 {VDD} 3.5000e-08 {VDD} 3.5100e-08 0 5.8000e-08 0 5.8100e-08 {VDD})
vww_op0_n100_pw_rwl_late_hold wwl_op0_n100_pw_rwl_late_hold 0 pwl(0.0000e+00 0 1.0000e-09 0 1.1000e-09 {VDD} 2.1000e-08 {VDD} 2.1100e-08 0 3.6000e-08 0 3.6100e-08 {VDD} 5.6000e-08 {VDD} 5.6100e-08 0)
vwc_op0_n100_pw_rwl_late_hold wbc_op0_n100_pw_rwl_late_hold 0 pwl(0.0000e+00 0 3.6000e-08 0 3.6100e-08 {VDD} 5.8000e-08 {VDD} 5.8100e-08 0)
* preparation driver (physical regime; write ENABLED): WBL <- -0.1 V until 22 ns, then 0 V; switch open at 23 ns
vpw_op0_n100_pw_rwl_late_hold wpd_op0_n100_pw_rwl_late_hold 0 pwl(0 -0.1 2.2000e-08 -0.1 2.2100e-08 0)
vpc_op0_n100_pw_rwl_late_hold pctl_op0_n100_pw_rwl_late_hold 0 pwl(0.0000e+00 {VDD} 2.3000e-08 {VDD} 2.3100e-08 0)
spw_op0_n100_pw_rwl_late_hold wpd_op0_n100_pw_rwl_late_hold wbl_op0_n100_pw_rwl_late_hold pctl_op0_n100_pw_rwl_late_hold 0 swwbl
swb_op0_n100_pw_rwl_late_hold ref_op0_n100_pw_rwl_late_hold wbl_op0_n100_pw_rwl_late_hold wbc_op0_n100_pw_rwl_late_hold 0 swwbl
cwbl_op0_n100_pw_rwl_late_hold wbl_op0_n100_pw_rwl_late_hold 0 {C_WBL}
spa_op0_n100_pw_rwl_late_hold prea rbl_op0_n100_pw_rwl_late_hold ctl_op0_n100_pw_rwl_late_hold 0 swpre
spr_op0_n100_pw_rwl_late_hold pref ref_op0_n100_pw_rwl_late_hold ctl_op0_n100_pw_rwl_late_hold 0 swpre
crbl_op0_n100_pw_rwl_late_hold rbl_op0_n100_pw_rwl_late_hold 0 {C_RBL}
cref_op0_n100_pw_rwl_late_hold ref_op0_n100_pw_rwl_late_hold 0 {C_RBL}   $ ASSUMPTION: ideal matched dummy load
XMWR_op0_n100_pw_rwl_late_hold_0 sn_op0_n100_pw_rwl_late_hold_0 wwl_op0_n100_pw_rwl_late_hold wbl_op0_n100_pw_rwl_late_hold 0 sky130_fd_pr__nfet_01v8 L=0.15 W=0.42 nf=1 ad=0.1218 as=0.1218 pd=1.42 ps=1.42 nrd=0.69047619047619  nrs=0.69047619047619 sa=0 sb=0 sd=0 mult=1 m=1
XMRD_op0_n100_pw_rwl_late_hold_0 rbl_op0_n100_pw_rwl_late_hold sn_op0_n100_pw_rwl_late_hold_0 rwls_op0_n100_pw_rwl_late_hold 0 sky130_fd_pr__nfet_01v8 L=0.15 W=0.42 nf=1 ad=0.1218 as=0.1218 pd=1.42 ps=1.42 nrd=0.69047619047619  nrs=0.69047619047619 sa=0 sb=0 sd=0 mult=1 m=1
csn_op0_n100_pw_rwl_late_hold_0 sn_op0_n100_pw_rwl_late_hold_0 0 {C_SN}
XMWR_op0_n100_pw_rwl_late_hold_1 sn_op0_n100_pw_rwl_late_hold_1 wwl_des wbl_op0_n100_pw_rwl_late_hold 0 sky130_fd_pr__nfet_01v8 L=0.15 W=0.42 nf=1 ad=0.1218 as=0.1218 pd=1.42 ps=1.42 nrd=0.69047619047619  nrs=0.69047619047619 sa=0 sb=0 sd=0 mult=1 m=1
XMRD_op0_n100_pw_rwl_late_hold_1 rbl_op0_n100_pw_rwl_late_hold sn_op0_n100_pw_rwl_late_hold_1 rwl_des 0 sky130_fd_pr__nfet_01v8 L=0.15 W=0.42 nf=1 ad=0.1218 as=0.1218 pd=1.42 ps=1.42 nrd=0.69047619047619  nrs=0.69047619047619 sa=0 sb=0 sd=0 mult=1 m=1
csn_op0_n100_pw_rwl_late_hold_1 sn_op0_n100_pw_rwl_late_hold_1 0 {C_SN}
XMWR_op0_n100_pw_rwl_late_hold_2 sn_op0_n100_pw_rwl_late_hold_2 wwl_des wbl_op0_n100_pw_rwl_late_hold 0 sky130_fd_pr__nfet_01v8 L=0.15 W=0.42 nf=1 ad=0.1218 as=0.1218 pd=1.42 ps=1.42 nrd=0.69047619047619  nrs=0.69047619047619 sa=0 sb=0 sd=0 mult=1 m=1
XMRD_op0_n100_pw_rwl_late_hold_2 rbl_op0_n100_pw_rwl_late_hold sn_op0_n100_pw_rwl_late_hold_2 rwl_des 0 sky130_fd_pr__nfet_01v8 L=0.15 W=0.42 nf=1 ad=0.1218 as=0.1218 pd=1.42 ps=1.42 nrd=0.69047619047619  nrs=0.69047619047619 sa=0 sb=0 sd=0 mult=1 m=1
csn_op0_n100_pw_rwl_late_hold_2 sn_op0_n100_pw_rwl_late_hold_2 0 {C_SN}
XMWR_op0_n100_pw_rwl_late_hold_3 sn_op0_n100_pw_rwl_late_hold_3 wwl_des wbl_op0_n100_pw_rwl_late_hold 0 sky130_fd_pr__nfet_01v8 L=0.15 W=0.42 nf=1 ad=0.1218 as=0.1218 pd=1.42 ps=1.42 nrd=0.69047619047619  nrs=0.69047619047619 sa=0 sb=0 sd=0 mult=1 m=1
XMRD_op0_n100_pw_rwl_late_hold_3 rbl_op0_n100_pw_rwl_late_hold sn_op0_n100_pw_rwl_late_hold_3 rwl_des 0 sky130_fd_pr__nfet_01v8 L=0.15 W=0.42 nf=1 ad=0.1218 as=0.1218 pd=1.42 ps=1.42 nrd=0.69047619047619  nrs=0.69047619047619 sa=0 sb=0 sd=0 mult=1 m=1
csn_op0_n100_pw_rwl_late_hold_3 sn_op0_n100_pw_rwl_late_hold_3 0 {C_SN}
XMN1_op0_n100_pw_rwl_late_hold rbl_op0_n100_pw_rwl_late_hold ref_op0_n100_pw_rwl_late_hold vn_op0_n100_pw_rwl_late_hold 0 sky130_fd_pr__nfet_01v8 L=0.15 W=1 nf=1 ad=0.29 as=0.29 pd=2.58 ps=2.58 mult=1 m=1
XMN2_op0_n100_pw_rwl_late_hold ref_op0_n100_pw_rwl_late_hold rbl_op0_n100_pw_rwl_late_hold vn_op0_n100_pw_rwl_late_hold 0 sky130_fd_pr__nfet_01v8 L=0.15 W=1 nf=1 ad=0.29 as=0.29 pd=2.58 ps=2.58 mult=1 m=1
XMP1_op0_n100_pw_rwl_late_hold rbl_op0_n100_pw_rwl_late_hold ref_op0_n100_pw_rwl_late_hold vp_op0_n100_pw_rwl_late_hold vdd sky130_fd_pr__pfet_01v8 L=0.15 W=2 nf=1 ad=0.58 as=0.58 pd=4.58 ps=4.58 mult=1 m=1
XMP2_op0_n100_pw_rwl_late_hold ref_op0_n100_pw_rwl_late_hold rbl_op0_n100_pw_rwl_late_hold vp_op0_n100_pw_rwl_late_hold vdd sky130_fd_pr__pfet_01v8 L=0.15 W=2 nf=1 ad=0.58 as=0.58 pd=4.58 ps=4.58 mult=1 m=1
XMNF_op0_n100_pw_rwl_late_hold vn_op0_n100_pw_rwl_late_hold en_op0_n100_pw_rwl_late_hold 0 0 sky130_fd_pr__nfet_01v8 L=0.15 W=2 nf=1 ad=0.58 as=0.58 pd=4.58 ps=4.58 mult=1 m=1
XMPH_op0_n100_pw_rwl_late_hold vp_op0_n100_pw_rwl_late_hold enb_op0_n100_pw_rwl_late_hold vdd vdd sky130_fd_pr__pfet_01v8 L=0.15 W=4 nf=1 ad=1.16 as=1.16 pd=8.58 ps=8.58 mult=1 m=1
bd_op0_n100_pw_rwl_late_hold d_op0_n100_pw_rwl_late_hold 0 v=v(rbl_op0_n100_pw_rwl_late_hold)-v(ref_op0_n100_pw_rwl_late_hold)

* ---- instance 43: op0_0000_pw_rwl_late_hold (variant pw_rwl_late_hold; probe dec 35.9 ns, release 58 ns, meas 60 ns) ----
vctl_op0_0000_pw_rwl_late_hold ctl_op0_0000_pw_rwl_late_hold 0 pwl(0.0000e+00 0 2.4000e-08 0 2.4100e-08 {VDD} 2.6000e-08 {VDD} 2.6100e-08 0)
vrs_op0_0000_pw_rwl_late_hold rwls_op0_0000_pw_rwl_late_hold 0 pwl(0.0000e+00 {VDD} 2.6000e-08 {VDD} 2.6100e-08 0 5.8000e-08 0 5.8100e-08 {VDD})
ven_op0_0000_pw_rwl_late_hold en_op0_0000_pw_rwl_late_hold 0 pwl(0.0000e+00 0 3.5000e-08 0 3.5100e-08 {VDD} 5.8000e-08 {VDD} 5.8100e-08 0)
venb_op0_0000_pw_rwl_late_hold enb_op0_0000_pw_rwl_late_hold 0 pwl(0.0000e+00 {VDD} 3.5000e-08 {VDD} 3.5100e-08 0 5.8000e-08 0 5.8100e-08 {VDD})
vww_op0_0000_pw_rwl_late_hold wwl_op0_0000_pw_rwl_late_hold 0 pwl(0.0000e+00 0 1.0000e-09 0 1.1000e-09 {VDD} 2.1000e-08 {VDD} 2.1100e-08 0 3.6000e-08 0 3.6100e-08 {VDD} 5.6000e-08 {VDD} 5.6100e-08 0)
vwc_op0_0000_pw_rwl_late_hold wbc_op0_0000_pw_rwl_late_hold 0 pwl(0.0000e+00 0 3.6000e-08 0 3.6100e-08 {VDD} 5.8000e-08 {VDD} 5.8100e-08 0)
* preparation driver (physical regime; write ENABLED): WBL <- 0 V until 22 ns, then 0 V; switch open at 23 ns
vpw_op0_0000_pw_rwl_late_hold wpd_op0_0000_pw_rwl_late_hold 0 pwl(0 0 2.2000e-08 0 2.2100e-08 0)
vpc_op0_0000_pw_rwl_late_hold pctl_op0_0000_pw_rwl_late_hold 0 pwl(0.0000e+00 {VDD} 2.3000e-08 {VDD} 2.3100e-08 0)
spw_op0_0000_pw_rwl_late_hold wpd_op0_0000_pw_rwl_late_hold wbl_op0_0000_pw_rwl_late_hold pctl_op0_0000_pw_rwl_late_hold 0 swwbl
swb_op0_0000_pw_rwl_late_hold ref_op0_0000_pw_rwl_late_hold wbl_op0_0000_pw_rwl_late_hold wbc_op0_0000_pw_rwl_late_hold 0 swwbl
cwbl_op0_0000_pw_rwl_late_hold wbl_op0_0000_pw_rwl_late_hold 0 {C_WBL}
spa_op0_0000_pw_rwl_late_hold prea rbl_op0_0000_pw_rwl_late_hold ctl_op0_0000_pw_rwl_late_hold 0 swpre
spr_op0_0000_pw_rwl_late_hold pref ref_op0_0000_pw_rwl_late_hold ctl_op0_0000_pw_rwl_late_hold 0 swpre
crbl_op0_0000_pw_rwl_late_hold rbl_op0_0000_pw_rwl_late_hold 0 {C_RBL}
cref_op0_0000_pw_rwl_late_hold ref_op0_0000_pw_rwl_late_hold 0 {C_RBL}   $ ASSUMPTION: ideal matched dummy load
XMWR_op0_0000_pw_rwl_late_hold_0 sn_op0_0000_pw_rwl_late_hold_0 wwl_op0_0000_pw_rwl_late_hold wbl_op0_0000_pw_rwl_late_hold 0 sky130_fd_pr__nfet_01v8 L=0.15 W=0.42 nf=1 ad=0.1218 as=0.1218 pd=1.42 ps=1.42 nrd=0.69047619047619  nrs=0.69047619047619 sa=0 sb=0 sd=0 mult=1 m=1
XMRD_op0_0000_pw_rwl_late_hold_0 rbl_op0_0000_pw_rwl_late_hold sn_op0_0000_pw_rwl_late_hold_0 rwls_op0_0000_pw_rwl_late_hold 0 sky130_fd_pr__nfet_01v8 L=0.15 W=0.42 nf=1 ad=0.1218 as=0.1218 pd=1.42 ps=1.42 nrd=0.69047619047619  nrs=0.69047619047619 sa=0 sb=0 sd=0 mult=1 m=1
csn_op0_0000_pw_rwl_late_hold_0 sn_op0_0000_pw_rwl_late_hold_0 0 {C_SN}
XMWR_op0_0000_pw_rwl_late_hold_1 sn_op0_0000_pw_rwl_late_hold_1 wwl_des wbl_op0_0000_pw_rwl_late_hold 0 sky130_fd_pr__nfet_01v8 L=0.15 W=0.42 nf=1 ad=0.1218 as=0.1218 pd=1.42 ps=1.42 nrd=0.69047619047619  nrs=0.69047619047619 sa=0 sb=0 sd=0 mult=1 m=1
XMRD_op0_0000_pw_rwl_late_hold_1 rbl_op0_0000_pw_rwl_late_hold sn_op0_0000_pw_rwl_late_hold_1 rwl_des 0 sky130_fd_pr__nfet_01v8 L=0.15 W=0.42 nf=1 ad=0.1218 as=0.1218 pd=1.42 ps=1.42 nrd=0.69047619047619  nrs=0.69047619047619 sa=0 sb=0 sd=0 mult=1 m=1
csn_op0_0000_pw_rwl_late_hold_1 sn_op0_0000_pw_rwl_late_hold_1 0 {C_SN}
XMWR_op0_0000_pw_rwl_late_hold_2 sn_op0_0000_pw_rwl_late_hold_2 wwl_des wbl_op0_0000_pw_rwl_late_hold 0 sky130_fd_pr__nfet_01v8 L=0.15 W=0.42 nf=1 ad=0.1218 as=0.1218 pd=1.42 ps=1.42 nrd=0.69047619047619  nrs=0.69047619047619 sa=0 sb=0 sd=0 mult=1 m=1
XMRD_op0_0000_pw_rwl_late_hold_2 rbl_op0_0000_pw_rwl_late_hold sn_op0_0000_pw_rwl_late_hold_2 rwl_des 0 sky130_fd_pr__nfet_01v8 L=0.15 W=0.42 nf=1 ad=0.1218 as=0.1218 pd=1.42 ps=1.42 nrd=0.69047619047619  nrs=0.69047619047619 sa=0 sb=0 sd=0 mult=1 m=1
csn_op0_0000_pw_rwl_late_hold_2 sn_op0_0000_pw_rwl_late_hold_2 0 {C_SN}
XMWR_op0_0000_pw_rwl_late_hold_3 sn_op0_0000_pw_rwl_late_hold_3 wwl_des wbl_op0_0000_pw_rwl_late_hold 0 sky130_fd_pr__nfet_01v8 L=0.15 W=0.42 nf=1 ad=0.1218 as=0.1218 pd=1.42 ps=1.42 nrd=0.69047619047619  nrs=0.69047619047619 sa=0 sb=0 sd=0 mult=1 m=1
XMRD_op0_0000_pw_rwl_late_hold_3 rbl_op0_0000_pw_rwl_late_hold sn_op0_0000_pw_rwl_late_hold_3 rwl_des 0 sky130_fd_pr__nfet_01v8 L=0.15 W=0.42 nf=1 ad=0.1218 as=0.1218 pd=1.42 ps=1.42 nrd=0.69047619047619  nrs=0.69047619047619 sa=0 sb=0 sd=0 mult=1 m=1
csn_op0_0000_pw_rwl_late_hold_3 sn_op0_0000_pw_rwl_late_hold_3 0 {C_SN}
XMN1_op0_0000_pw_rwl_late_hold rbl_op0_0000_pw_rwl_late_hold ref_op0_0000_pw_rwl_late_hold vn_op0_0000_pw_rwl_late_hold 0 sky130_fd_pr__nfet_01v8 L=0.15 W=1 nf=1 ad=0.29 as=0.29 pd=2.58 ps=2.58 mult=1 m=1
XMN2_op0_0000_pw_rwl_late_hold ref_op0_0000_pw_rwl_late_hold rbl_op0_0000_pw_rwl_late_hold vn_op0_0000_pw_rwl_late_hold 0 sky130_fd_pr__nfet_01v8 L=0.15 W=1 nf=1 ad=0.29 as=0.29 pd=2.58 ps=2.58 mult=1 m=1
XMP1_op0_0000_pw_rwl_late_hold rbl_op0_0000_pw_rwl_late_hold ref_op0_0000_pw_rwl_late_hold vp_op0_0000_pw_rwl_late_hold vdd sky130_fd_pr__pfet_01v8 L=0.15 W=2 nf=1 ad=0.58 as=0.58 pd=4.58 ps=4.58 mult=1 m=1
XMP2_op0_0000_pw_rwl_late_hold ref_op0_0000_pw_rwl_late_hold rbl_op0_0000_pw_rwl_late_hold vp_op0_0000_pw_rwl_late_hold vdd sky130_fd_pr__pfet_01v8 L=0.15 W=2 nf=1 ad=0.58 as=0.58 pd=4.58 ps=4.58 mult=1 m=1
XMNF_op0_0000_pw_rwl_late_hold vn_op0_0000_pw_rwl_late_hold en_op0_0000_pw_rwl_late_hold 0 0 sky130_fd_pr__nfet_01v8 L=0.15 W=2 nf=1 ad=0.58 as=0.58 pd=4.58 ps=4.58 mult=1 m=1
XMPH_op0_0000_pw_rwl_late_hold vp_op0_0000_pw_rwl_late_hold enb_op0_0000_pw_rwl_late_hold vdd vdd sky130_fd_pr__pfet_01v8 L=0.15 W=4 nf=1 ad=1.16 as=1.16 pd=8.58 ps=8.58 mult=1 m=1
bd_op0_0000_pw_rwl_late_hold d_op0_0000_pw_rwl_late_hold 0 v=v(rbl_op0_0000_pw_rwl_late_hold)-v(ref_op0_0000_pw_rwl_late_hold)

* ---- instance 44: op1_0900_pw_neg_missing_wb (variant pw_neg_missing_wb; probe dec 35.9 ns, release 58 ns, meas 60 ns) ----
vctl_op1_0900_pw_neg_missing_wb ctl_op1_0900_pw_neg_missing_wb 0 pwl(0.0000e+00 0 2.4000e-08 0 2.4100e-08 {VDD} 2.6000e-08 {VDD} 2.6100e-08 0)
vrs_op1_0900_pw_neg_missing_wb rwls_op1_0900_pw_neg_missing_wb 0 pwl(0.0000e+00 {VDD} 2.6000e-08 {VDD} 2.6100e-08 0 3.6000e-08 0 3.6100e-08 {VDD})
ven_op1_0900_pw_neg_missing_wb en_op1_0900_pw_neg_missing_wb 0 pwl(0.0000e+00 0 3.5000e-08 0 3.5100e-08 {VDD} 5.8000e-08 {VDD} 5.8100e-08 0)
venb_op1_0900_pw_neg_missing_wb enb_op1_0900_pw_neg_missing_wb 0 pwl(0.0000e+00 {VDD} 3.5000e-08 {VDD} 3.5100e-08 0 5.8000e-08 0 5.8100e-08 {VDD})
vww_op1_0900_pw_neg_missing_wb wwl_op1_0900_pw_neg_missing_wb 0 pwl(0.0000e+00 0 1.0000e-09 0 1.1000e-09 {VDD} 2.1000e-08 {VDD} 2.1100e-08 0)
vwc_op1_0900_pw_neg_missing_wb wbc_op1_0900_pw_neg_missing_wb 0 pwl(0.0000e+00 0)
* preparation driver (physical regime; write ENABLED): WBL <- 0.9 V until 22 ns, then 0 V; switch open at 23 ns
vpw_op1_0900_pw_neg_missing_wb wpd_op1_0900_pw_neg_missing_wb 0 pwl(0 0.9 2.2000e-08 0.9 2.2100e-08 0)
vpc_op1_0900_pw_neg_missing_wb pctl_op1_0900_pw_neg_missing_wb 0 pwl(0.0000e+00 {VDD} 2.3000e-08 {VDD} 2.3100e-08 0)
spw_op1_0900_pw_neg_missing_wb wpd_op1_0900_pw_neg_missing_wb wbl_op1_0900_pw_neg_missing_wb pctl_op1_0900_pw_neg_missing_wb 0 swwbl
swb_op1_0900_pw_neg_missing_wb ref_op1_0900_pw_neg_missing_wb wbl_op1_0900_pw_neg_missing_wb wbc_op1_0900_pw_neg_missing_wb 0 swwbl
cwbl_op1_0900_pw_neg_missing_wb wbl_op1_0900_pw_neg_missing_wb 0 {C_WBL}
spa_op1_0900_pw_neg_missing_wb prea rbl_op1_0900_pw_neg_missing_wb ctl_op1_0900_pw_neg_missing_wb 0 swpre
spr_op1_0900_pw_neg_missing_wb pref ref_op1_0900_pw_neg_missing_wb ctl_op1_0900_pw_neg_missing_wb 0 swpre
crbl_op1_0900_pw_neg_missing_wb rbl_op1_0900_pw_neg_missing_wb 0 {C_RBL}
cref_op1_0900_pw_neg_missing_wb ref_op1_0900_pw_neg_missing_wb 0 {C_RBL}   $ ASSUMPTION: ideal matched dummy load
XMWR_op1_0900_pw_neg_missing_wb_0 sn_op1_0900_pw_neg_missing_wb_0 wwl_op1_0900_pw_neg_missing_wb wbl_op1_0900_pw_neg_missing_wb 0 sky130_fd_pr__nfet_01v8 L=0.15 W=0.42 nf=1 ad=0.1218 as=0.1218 pd=1.42 ps=1.42 nrd=0.69047619047619  nrs=0.69047619047619 sa=0 sb=0 sd=0 mult=1 m=1
XMRD_op1_0900_pw_neg_missing_wb_0 rbl_op1_0900_pw_neg_missing_wb sn_op1_0900_pw_neg_missing_wb_0 rwls_op1_0900_pw_neg_missing_wb 0 sky130_fd_pr__nfet_01v8 L=0.15 W=0.42 nf=1 ad=0.1218 as=0.1218 pd=1.42 ps=1.42 nrd=0.69047619047619  nrs=0.69047619047619 sa=0 sb=0 sd=0 mult=1 m=1
csn_op1_0900_pw_neg_missing_wb_0 sn_op1_0900_pw_neg_missing_wb_0 0 {C_SN}
XMWR_op1_0900_pw_neg_missing_wb_1 sn_op1_0900_pw_neg_missing_wb_1 wwl_des wbl_op1_0900_pw_neg_missing_wb 0 sky130_fd_pr__nfet_01v8 L=0.15 W=0.42 nf=1 ad=0.1218 as=0.1218 pd=1.42 ps=1.42 nrd=0.69047619047619  nrs=0.69047619047619 sa=0 sb=0 sd=0 mult=1 m=1
XMRD_op1_0900_pw_neg_missing_wb_1 rbl_op1_0900_pw_neg_missing_wb sn_op1_0900_pw_neg_missing_wb_1 rwl_des 0 sky130_fd_pr__nfet_01v8 L=0.15 W=0.42 nf=1 ad=0.1218 as=0.1218 pd=1.42 ps=1.42 nrd=0.69047619047619  nrs=0.69047619047619 sa=0 sb=0 sd=0 mult=1 m=1
csn_op1_0900_pw_neg_missing_wb_1 sn_op1_0900_pw_neg_missing_wb_1 0 {C_SN}
XMWR_op1_0900_pw_neg_missing_wb_2 sn_op1_0900_pw_neg_missing_wb_2 wwl_des wbl_op1_0900_pw_neg_missing_wb 0 sky130_fd_pr__nfet_01v8 L=0.15 W=0.42 nf=1 ad=0.1218 as=0.1218 pd=1.42 ps=1.42 nrd=0.69047619047619  nrs=0.69047619047619 sa=0 sb=0 sd=0 mult=1 m=1
XMRD_op1_0900_pw_neg_missing_wb_2 rbl_op1_0900_pw_neg_missing_wb sn_op1_0900_pw_neg_missing_wb_2 rwl_des 0 sky130_fd_pr__nfet_01v8 L=0.15 W=0.42 nf=1 ad=0.1218 as=0.1218 pd=1.42 ps=1.42 nrd=0.69047619047619  nrs=0.69047619047619 sa=0 sb=0 sd=0 mult=1 m=1
csn_op1_0900_pw_neg_missing_wb_2 sn_op1_0900_pw_neg_missing_wb_2 0 {C_SN}
XMWR_op1_0900_pw_neg_missing_wb_3 sn_op1_0900_pw_neg_missing_wb_3 wwl_des wbl_op1_0900_pw_neg_missing_wb 0 sky130_fd_pr__nfet_01v8 L=0.15 W=0.42 nf=1 ad=0.1218 as=0.1218 pd=1.42 ps=1.42 nrd=0.69047619047619  nrs=0.69047619047619 sa=0 sb=0 sd=0 mult=1 m=1
XMRD_op1_0900_pw_neg_missing_wb_3 rbl_op1_0900_pw_neg_missing_wb sn_op1_0900_pw_neg_missing_wb_3 rwl_des 0 sky130_fd_pr__nfet_01v8 L=0.15 W=0.42 nf=1 ad=0.1218 as=0.1218 pd=1.42 ps=1.42 nrd=0.69047619047619  nrs=0.69047619047619 sa=0 sb=0 sd=0 mult=1 m=1
csn_op1_0900_pw_neg_missing_wb_3 sn_op1_0900_pw_neg_missing_wb_3 0 {C_SN}
XMN1_op1_0900_pw_neg_missing_wb rbl_op1_0900_pw_neg_missing_wb ref_op1_0900_pw_neg_missing_wb vn_op1_0900_pw_neg_missing_wb 0 sky130_fd_pr__nfet_01v8 L=0.15 W=1 nf=1 ad=0.29 as=0.29 pd=2.58 ps=2.58 mult=1 m=1
XMN2_op1_0900_pw_neg_missing_wb ref_op1_0900_pw_neg_missing_wb rbl_op1_0900_pw_neg_missing_wb vn_op1_0900_pw_neg_missing_wb 0 sky130_fd_pr__nfet_01v8 L=0.15 W=1 nf=1 ad=0.29 as=0.29 pd=2.58 ps=2.58 mult=1 m=1
XMP1_op1_0900_pw_neg_missing_wb rbl_op1_0900_pw_neg_missing_wb ref_op1_0900_pw_neg_missing_wb vp_op1_0900_pw_neg_missing_wb vdd sky130_fd_pr__pfet_01v8 L=0.15 W=2 nf=1 ad=0.58 as=0.58 pd=4.58 ps=4.58 mult=1 m=1
XMP2_op1_0900_pw_neg_missing_wb ref_op1_0900_pw_neg_missing_wb rbl_op1_0900_pw_neg_missing_wb vp_op1_0900_pw_neg_missing_wb vdd sky130_fd_pr__pfet_01v8 L=0.15 W=2 nf=1 ad=0.58 as=0.58 pd=4.58 ps=4.58 mult=1 m=1
XMNF_op1_0900_pw_neg_missing_wb vn_op1_0900_pw_neg_missing_wb en_op1_0900_pw_neg_missing_wb 0 0 sky130_fd_pr__nfet_01v8 L=0.15 W=2 nf=1 ad=0.58 as=0.58 pd=4.58 ps=4.58 mult=1 m=1
XMPH_op1_0900_pw_neg_missing_wb vp_op1_0900_pw_neg_missing_wb enb_op1_0900_pw_neg_missing_wb vdd vdd sky130_fd_pr__pfet_01v8 L=0.15 W=4 nf=1 ad=1.16 as=1.16 pd=8.58 ps=8.58 mult=1 m=1
bd_op1_0900_pw_neg_missing_wb d_op1_0900_pw_neg_missing_wb 0 v=v(rbl_op1_0900_pw_neg_missing_wb)-v(ref_op1_0900_pw_neg_missing_wb)

* ---- instance 45: op1_1000_pw_neg_missing_wb (variant pw_neg_missing_wb; probe dec 35.9 ns, release 58 ns, meas 60 ns) ----
vctl_op1_1000_pw_neg_missing_wb ctl_op1_1000_pw_neg_missing_wb 0 pwl(0.0000e+00 0 2.4000e-08 0 2.4100e-08 {VDD} 2.6000e-08 {VDD} 2.6100e-08 0)
vrs_op1_1000_pw_neg_missing_wb rwls_op1_1000_pw_neg_missing_wb 0 pwl(0.0000e+00 {VDD} 2.6000e-08 {VDD} 2.6100e-08 0 3.6000e-08 0 3.6100e-08 {VDD})
ven_op1_1000_pw_neg_missing_wb en_op1_1000_pw_neg_missing_wb 0 pwl(0.0000e+00 0 3.5000e-08 0 3.5100e-08 {VDD} 5.8000e-08 {VDD} 5.8100e-08 0)
venb_op1_1000_pw_neg_missing_wb enb_op1_1000_pw_neg_missing_wb 0 pwl(0.0000e+00 {VDD} 3.5000e-08 {VDD} 3.5100e-08 0 5.8000e-08 0 5.8100e-08 {VDD})
vww_op1_1000_pw_neg_missing_wb wwl_op1_1000_pw_neg_missing_wb 0 pwl(0.0000e+00 0 1.0000e-09 0 1.1000e-09 {VDD} 2.1000e-08 {VDD} 2.1100e-08 0)
vwc_op1_1000_pw_neg_missing_wb wbc_op1_1000_pw_neg_missing_wb 0 pwl(0.0000e+00 0)
* preparation driver (physical regime; write ENABLED): WBL <- 1 V until 22 ns, then 0 V; switch open at 23 ns
vpw_op1_1000_pw_neg_missing_wb wpd_op1_1000_pw_neg_missing_wb 0 pwl(0 1 2.2000e-08 1 2.2100e-08 0)
vpc_op1_1000_pw_neg_missing_wb pctl_op1_1000_pw_neg_missing_wb 0 pwl(0.0000e+00 {VDD} 2.3000e-08 {VDD} 2.3100e-08 0)
spw_op1_1000_pw_neg_missing_wb wpd_op1_1000_pw_neg_missing_wb wbl_op1_1000_pw_neg_missing_wb pctl_op1_1000_pw_neg_missing_wb 0 swwbl
swb_op1_1000_pw_neg_missing_wb ref_op1_1000_pw_neg_missing_wb wbl_op1_1000_pw_neg_missing_wb wbc_op1_1000_pw_neg_missing_wb 0 swwbl
cwbl_op1_1000_pw_neg_missing_wb wbl_op1_1000_pw_neg_missing_wb 0 {C_WBL}
spa_op1_1000_pw_neg_missing_wb prea rbl_op1_1000_pw_neg_missing_wb ctl_op1_1000_pw_neg_missing_wb 0 swpre
spr_op1_1000_pw_neg_missing_wb pref ref_op1_1000_pw_neg_missing_wb ctl_op1_1000_pw_neg_missing_wb 0 swpre
crbl_op1_1000_pw_neg_missing_wb rbl_op1_1000_pw_neg_missing_wb 0 {C_RBL}
cref_op1_1000_pw_neg_missing_wb ref_op1_1000_pw_neg_missing_wb 0 {C_RBL}   $ ASSUMPTION: ideal matched dummy load
XMWR_op1_1000_pw_neg_missing_wb_0 sn_op1_1000_pw_neg_missing_wb_0 wwl_op1_1000_pw_neg_missing_wb wbl_op1_1000_pw_neg_missing_wb 0 sky130_fd_pr__nfet_01v8 L=0.15 W=0.42 nf=1 ad=0.1218 as=0.1218 pd=1.42 ps=1.42 nrd=0.69047619047619  nrs=0.69047619047619 sa=0 sb=0 sd=0 mult=1 m=1
XMRD_op1_1000_pw_neg_missing_wb_0 rbl_op1_1000_pw_neg_missing_wb sn_op1_1000_pw_neg_missing_wb_0 rwls_op1_1000_pw_neg_missing_wb 0 sky130_fd_pr__nfet_01v8 L=0.15 W=0.42 nf=1 ad=0.1218 as=0.1218 pd=1.42 ps=1.42 nrd=0.69047619047619  nrs=0.69047619047619 sa=0 sb=0 sd=0 mult=1 m=1
csn_op1_1000_pw_neg_missing_wb_0 sn_op1_1000_pw_neg_missing_wb_0 0 {C_SN}
XMWR_op1_1000_pw_neg_missing_wb_1 sn_op1_1000_pw_neg_missing_wb_1 wwl_des wbl_op1_1000_pw_neg_missing_wb 0 sky130_fd_pr__nfet_01v8 L=0.15 W=0.42 nf=1 ad=0.1218 as=0.1218 pd=1.42 ps=1.42 nrd=0.69047619047619  nrs=0.69047619047619 sa=0 sb=0 sd=0 mult=1 m=1
XMRD_op1_1000_pw_neg_missing_wb_1 rbl_op1_1000_pw_neg_missing_wb sn_op1_1000_pw_neg_missing_wb_1 rwl_des 0 sky130_fd_pr__nfet_01v8 L=0.15 W=0.42 nf=1 ad=0.1218 as=0.1218 pd=1.42 ps=1.42 nrd=0.69047619047619  nrs=0.69047619047619 sa=0 sb=0 sd=0 mult=1 m=1
csn_op1_1000_pw_neg_missing_wb_1 sn_op1_1000_pw_neg_missing_wb_1 0 {C_SN}
XMWR_op1_1000_pw_neg_missing_wb_2 sn_op1_1000_pw_neg_missing_wb_2 wwl_des wbl_op1_1000_pw_neg_missing_wb 0 sky130_fd_pr__nfet_01v8 L=0.15 W=0.42 nf=1 ad=0.1218 as=0.1218 pd=1.42 ps=1.42 nrd=0.69047619047619  nrs=0.69047619047619 sa=0 sb=0 sd=0 mult=1 m=1
XMRD_op1_1000_pw_neg_missing_wb_2 rbl_op1_1000_pw_neg_missing_wb sn_op1_1000_pw_neg_missing_wb_2 rwl_des 0 sky130_fd_pr__nfet_01v8 L=0.15 W=0.42 nf=1 ad=0.1218 as=0.1218 pd=1.42 ps=1.42 nrd=0.69047619047619  nrs=0.69047619047619 sa=0 sb=0 sd=0 mult=1 m=1
csn_op1_1000_pw_neg_missing_wb_2 sn_op1_1000_pw_neg_missing_wb_2 0 {C_SN}
XMWR_op1_1000_pw_neg_missing_wb_3 sn_op1_1000_pw_neg_missing_wb_3 wwl_des wbl_op1_1000_pw_neg_missing_wb 0 sky130_fd_pr__nfet_01v8 L=0.15 W=0.42 nf=1 ad=0.1218 as=0.1218 pd=1.42 ps=1.42 nrd=0.69047619047619  nrs=0.69047619047619 sa=0 sb=0 sd=0 mult=1 m=1
XMRD_op1_1000_pw_neg_missing_wb_3 rbl_op1_1000_pw_neg_missing_wb sn_op1_1000_pw_neg_missing_wb_3 rwl_des 0 sky130_fd_pr__nfet_01v8 L=0.15 W=0.42 nf=1 ad=0.1218 as=0.1218 pd=1.42 ps=1.42 nrd=0.69047619047619  nrs=0.69047619047619 sa=0 sb=0 sd=0 mult=1 m=1
csn_op1_1000_pw_neg_missing_wb_3 sn_op1_1000_pw_neg_missing_wb_3 0 {C_SN}
XMN1_op1_1000_pw_neg_missing_wb rbl_op1_1000_pw_neg_missing_wb ref_op1_1000_pw_neg_missing_wb vn_op1_1000_pw_neg_missing_wb 0 sky130_fd_pr__nfet_01v8 L=0.15 W=1 nf=1 ad=0.29 as=0.29 pd=2.58 ps=2.58 mult=1 m=1
XMN2_op1_1000_pw_neg_missing_wb ref_op1_1000_pw_neg_missing_wb rbl_op1_1000_pw_neg_missing_wb vn_op1_1000_pw_neg_missing_wb 0 sky130_fd_pr__nfet_01v8 L=0.15 W=1 nf=1 ad=0.29 as=0.29 pd=2.58 ps=2.58 mult=1 m=1
XMP1_op1_1000_pw_neg_missing_wb rbl_op1_1000_pw_neg_missing_wb ref_op1_1000_pw_neg_missing_wb vp_op1_1000_pw_neg_missing_wb vdd sky130_fd_pr__pfet_01v8 L=0.15 W=2 nf=1 ad=0.58 as=0.58 pd=4.58 ps=4.58 mult=1 m=1
XMP2_op1_1000_pw_neg_missing_wb ref_op1_1000_pw_neg_missing_wb rbl_op1_1000_pw_neg_missing_wb vp_op1_1000_pw_neg_missing_wb vdd sky130_fd_pr__pfet_01v8 L=0.15 W=2 nf=1 ad=0.58 as=0.58 pd=4.58 ps=4.58 mult=1 m=1
XMNF_op1_1000_pw_neg_missing_wb vn_op1_1000_pw_neg_missing_wb en_op1_1000_pw_neg_missing_wb 0 0 sky130_fd_pr__nfet_01v8 L=0.15 W=2 nf=1 ad=0.58 as=0.58 pd=4.58 ps=4.58 mult=1 m=1
XMPH_op1_1000_pw_neg_missing_wb vp_op1_1000_pw_neg_missing_wb enb_op1_1000_pw_neg_missing_wb vdd vdd sky130_fd_pr__pfet_01v8 L=0.15 W=4 nf=1 ad=1.16 as=1.16 pd=8.58 ps=8.58 mult=1 m=1
bd_op1_1000_pw_neg_missing_wb d_op1_1000_pw_neg_missing_wb 0 v=v(rbl_op1_1000_pw_neg_missing_wb)-v(ref_op1_1000_pw_neg_missing_wb)

* ---- instance 46: op0_n100_pw_neg_missing_wb (variant pw_neg_missing_wb; probe dec 35.9 ns, release 58 ns, meas 60 ns) ----
vctl_op0_n100_pw_neg_missing_wb ctl_op0_n100_pw_neg_missing_wb 0 pwl(0.0000e+00 0 2.4000e-08 0 2.4100e-08 {VDD} 2.6000e-08 {VDD} 2.6100e-08 0)
vrs_op0_n100_pw_neg_missing_wb rwls_op0_n100_pw_neg_missing_wb 0 pwl(0.0000e+00 {VDD} 2.6000e-08 {VDD} 2.6100e-08 0 3.6000e-08 0 3.6100e-08 {VDD})
ven_op0_n100_pw_neg_missing_wb en_op0_n100_pw_neg_missing_wb 0 pwl(0.0000e+00 0 3.5000e-08 0 3.5100e-08 {VDD} 5.8000e-08 {VDD} 5.8100e-08 0)
venb_op0_n100_pw_neg_missing_wb enb_op0_n100_pw_neg_missing_wb 0 pwl(0.0000e+00 {VDD} 3.5000e-08 {VDD} 3.5100e-08 0 5.8000e-08 0 5.8100e-08 {VDD})
vww_op0_n100_pw_neg_missing_wb wwl_op0_n100_pw_neg_missing_wb 0 pwl(0.0000e+00 0 1.0000e-09 0 1.1000e-09 {VDD} 2.1000e-08 {VDD} 2.1100e-08 0)
vwc_op0_n100_pw_neg_missing_wb wbc_op0_n100_pw_neg_missing_wb 0 pwl(0.0000e+00 0)
* preparation driver (physical regime; write ENABLED): WBL <- -0.1 V until 22 ns, then 0 V; switch open at 23 ns
vpw_op0_n100_pw_neg_missing_wb wpd_op0_n100_pw_neg_missing_wb 0 pwl(0 -0.1 2.2000e-08 -0.1 2.2100e-08 0)
vpc_op0_n100_pw_neg_missing_wb pctl_op0_n100_pw_neg_missing_wb 0 pwl(0.0000e+00 {VDD} 2.3000e-08 {VDD} 2.3100e-08 0)
spw_op0_n100_pw_neg_missing_wb wpd_op0_n100_pw_neg_missing_wb wbl_op0_n100_pw_neg_missing_wb pctl_op0_n100_pw_neg_missing_wb 0 swwbl
swb_op0_n100_pw_neg_missing_wb ref_op0_n100_pw_neg_missing_wb wbl_op0_n100_pw_neg_missing_wb wbc_op0_n100_pw_neg_missing_wb 0 swwbl
cwbl_op0_n100_pw_neg_missing_wb wbl_op0_n100_pw_neg_missing_wb 0 {C_WBL}
spa_op0_n100_pw_neg_missing_wb prea rbl_op0_n100_pw_neg_missing_wb ctl_op0_n100_pw_neg_missing_wb 0 swpre
spr_op0_n100_pw_neg_missing_wb pref ref_op0_n100_pw_neg_missing_wb ctl_op0_n100_pw_neg_missing_wb 0 swpre
crbl_op0_n100_pw_neg_missing_wb rbl_op0_n100_pw_neg_missing_wb 0 {C_RBL}
cref_op0_n100_pw_neg_missing_wb ref_op0_n100_pw_neg_missing_wb 0 {C_RBL}   $ ASSUMPTION: ideal matched dummy load
XMWR_op0_n100_pw_neg_missing_wb_0 sn_op0_n100_pw_neg_missing_wb_0 wwl_op0_n100_pw_neg_missing_wb wbl_op0_n100_pw_neg_missing_wb 0 sky130_fd_pr__nfet_01v8 L=0.15 W=0.42 nf=1 ad=0.1218 as=0.1218 pd=1.42 ps=1.42 nrd=0.69047619047619  nrs=0.69047619047619 sa=0 sb=0 sd=0 mult=1 m=1
XMRD_op0_n100_pw_neg_missing_wb_0 rbl_op0_n100_pw_neg_missing_wb sn_op0_n100_pw_neg_missing_wb_0 rwls_op0_n100_pw_neg_missing_wb 0 sky130_fd_pr__nfet_01v8 L=0.15 W=0.42 nf=1 ad=0.1218 as=0.1218 pd=1.42 ps=1.42 nrd=0.69047619047619  nrs=0.69047619047619 sa=0 sb=0 sd=0 mult=1 m=1
csn_op0_n100_pw_neg_missing_wb_0 sn_op0_n100_pw_neg_missing_wb_0 0 {C_SN}
XMWR_op0_n100_pw_neg_missing_wb_1 sn_op0_n100_pw_neg_missing_wb_1 wwl_des wbl_op0_n100_pw_neg_missing_wb 0 sky130_fd_pr__nfet_01v8 L=0.15 W=0.42 nf=1 ad=0.1218 as=0.1218 pd=1.42 ps=1.42 nrd=0.69047619047619  nrs=0.69047619047619 sa=0 sb=0 sd=0 mult=1 m=1
XMRD_op0_n100_pw_neg_missing_wb_1 rbl_op0_n100_pw_neg_missing_wb sn_op0_n100_pw_neg_missing_wb_1 rwl_des 0 sky130_fd_pr__nfet_01v8 L=0.15 W=0.42 nf=1 ad=0.1218 as=0.1218 pd=1.42 ps=1.42 nrd=0.69047619047619  nrs=0.69047619047619 sa=0 sb=0 sd=0 mult=1 m=1
csn_op0_n100_pw_neg_missing_wb_1 sn_op0_n100_pw_neg_missing_wb_1 0 {C_SN}
XMWR_op0_n100_pw_neg_missing_wb_2 sn_op0_n100_pw_neg_missing_wb_2 wwl_des wbl_op0_n100_pw_neg_missing_wb 0 sky130_fd_pr__nfet_01v8 L=0.15 W=0.42 nf=1 ad=0.1218 as=0.1218 pd=1.42 ps=1.42 nrd=0.69047619047619  nrs=0.69047619047619 sa=0 sb=0 sd=0 mult=1 m=1
XMRD_op0_n100_pw_neg_missing_wb_2 rbl_op0_n100_pw_neg_missing_wb sn_op0_n100_pw_neg_missing_wb_2 rwl_des 0 sky130_fd_pr__nfet_01v8 L=0.15 W=0.42 nf=1 ad=0.1218 as=0.1218 pd=1.42 ps=1.42 nrd=0.69047619047619  nrs=0.69047619047619 sa=0 sb=0 sd=0 mult=1 m=1
csn_op0_n100_pw_neg_missing_wb_2 sn_op0_n100_pw_neg_missing_wb_2 0 {C_SN}
XMWR_op0_n100_pw_neg_missing_wb_3 sn_op0_n100_pw_neg_missing_wb_3 wwl_des wbl_op0_n100_pw_neg_missing_wb 0 sky130_fd_pr__nfet_01v8 L=0.15 W=0.42 nf=1 ad=0.1218 as=0.1218 pd=1.42 ps=1.42 nrd=0.69047619047619  nrs=0.69047619047619 sa=0 sb=0 sd=0 mult=1 m=1
XMRD_op0_n100_pw_neg_missing_wb_3 rbl_op0_n100_pw_neg_missing_wb sn_op0_n100_pw_neg_missing_wb_3 rwl_des 0 sky130_fd_pr__nfet_01v8 L=0.15 W=0.42 nf=1 ad=0.1218 as=0.1218 pd=1.42 ps=1.42 nrd=0.69047619047619  nrs=0.69047619047619 sa=0 sb=0 sd=0 mult=1 m=1
csn_op0_n100_pw_neg_missing_wb_3 sn_op0_n100_pw_neg_missing_wb_3 0 {C_SN}
XMN1_op0_n100_pw_neg_missing_wb rbl_op0_n100_pw_neg_missing_wb ref_op0_n100_pw_neg_missing_wb vn_op0_n100_pw_neg_missing_wb 0 sky130_fd_pr__nfet_01v8 L=0.15 W=1 nf=1 ad=0.29 as=0.29 pd=2.58 ps=2.58 mult=1 m=1
XMN2_op0_n100_pw_neg_missing_wb ref_op0_n100_pw_neg_missing_wb rbl_op0_n100_pw_neg_missing_wb vn_op0_n100_pw_neg_missing_wb 0 sky130_fd_pr__nfet_01v8 L=0.15 W=1 nf=1 ad=0.29 as=0.29 pd=2.58 ps=2.58 mult=1 m=1
XMP1_op0_n100_pw_neg_missing_wb rbl_op0_n100_pw_neg_missing_wb ref_op0_n100_pw_neg_missing_wb vp_op0_n100_pw_neg_missing_wb vdd sky130_fd_pr__pfet_01v8 L=0.15 W=2 nf=1 ad=0.58 as=0.58 pd=4.58 ps=4.58 mult=1 m=1
XMP2_op0_n100_pw_neg_missing_wb ref_op0_n100_pw_neg_missing_wb rbl_op0_n100_pw_neg_missing_wb vp_op0_n100_pw_neg_missing_wb vdd sky130_fd_pr__pfet_01v8 L=0.15 W=2 nf=1 ad=0.58 as=0.58 pd=4.58 ps=4.58 mult=1 m=1
XMNF_op0_n100_pw_neg_missing_wb vn_op0_n100_pw_neg_missing_wb en_op0_n100_pw_neg_missing_wb 0 0 sky130_fd_pr__nfet_01v8 L=0.15 W=2 nf=1 ad=0.58 as=0.58 pd=4.58 ps=4.58 mult=1 m=1
XMPH_op0_n100_pw_neg_missing_wb vp_op0_n100_pw_neg_missing_wb enb_op0_n100_pw_neg_missing_wb vdd vdd sky130_fd_pr__pfet_01v8 L=0.15 W=4 nf=1 ad=1.16 as=1.16 pd=8.58 ps=8.58 mult=1 m=1
bd_op0_n100_pw_neg_missing_wb d_op0_n100_pw_neg_missing_wb 0 v=v(rbl_op0_n100_pw_neg_missing_wb)-v(ref_op0_n100_pw_neg_missing_wb)

* ---- instance 47: op0_0000_pw_neg_missing_wb (variant pw_neg_missing_wb; probe dec 35.9 ns, release 58 ns, meas 60 ns) ----
vctl_op0_0000_pw_neg_missing_wb ctl_op0_0000_pw_neg_missing_wb 0 pwl(0.0000e+00 0 2.4000e-08 0 2.4100e-08 {VDD} 2.6000e-08 {VDD} 2.6100e-08 0)
vrs_op0_0000_pw_neg_missing_wb rwls_op0_0000_pw_neg_missing_wb 0 pwl(0.0000e+00 {VDD} 2.6000e-08 {VDD} 2.6100e-08 0 3.6000e-08 0 3.6100e-08 {VDD})
ven_op0_0000_pw_neg_missing_wb en_op0_0000_pw_neg_missing_wb 0 pwl(0.0000e+00 0 3.5000e-08 0 3.5100e-08 {VDD} 5.8000e-08 {VDD} 5.8100e-08 0)
venb_op0_0000_pw_neg_missing_wb enb_op0_0000_pw_neg_missing_wb 0 pwl(0.0000e+00 {VDD} 3.5000e-08 {VDD} 3.5100e-08 0 5.8000e-08 0 5.8100e-08 {VDD})
vww_op0_0000_pw_neg_missing_wb wwl_op0_0000_pw_neg_missing_wb 0 pwl(0.0000e+00 0 1.0000e-09 0 1.1000e-09 {VDD} 2.1000e-08 {VDD} 2.1100e-08 0)
vwc_op0_0000_pw_neg_missing_wb wbc_op0_0000_pw_neg_missing_wb 0 pwl(0.0000e+00 0)
* preparation driver (physical regime; write ENABLED): WBL <- 0 V until 22 ns, then 0 V; switch open at 23 ns
vpw_op0_0000_pw_neg_missing_wb wpd_op0_0000_pw_neg_missing_wb 0 pwl(0 0 2.2000e-08 0 2.2100e-08 0)
vpc_op0_0000_pw_neg_missing_wb pctl_op0_0000_pw_neg_missing_wb 0 pwl(0.0000e+00 {VDD} 2.3000e-08 {VDD} 2.3100e-08 0)
spw_op0_0000_pw_neg_missing_wb wpd_op0_0000_pw_neg_missing_wb wbl_op0_0000_pw_neg_missing_wb pctl_op0_0000_pw_neg_missing_wb 0 swwbl
swb_op0_0000_pw_neg_missing_wb ref_op0_0000_pw_neg_missing_wb wbl_op0_0000_pw_neg_missing_wb wbc_op0_0000_pw_neg_missing_wb 0 swwbl
cwbl_op0_0000_pw_neg_missing_wb wbl_op0_0000_pw_neg_missing_wb 0 {C_WBL}
spa_op0_0000_pw_neg_missing_wb prea rbl_op0_0000_pw_neg_missing_wb ctl_op0_0000_pw_neg_missing_wb 0 swpre
spr_op0_0000_pw_neg_missing_wb pref ref_op0_0000_pw_neg_missing_wb ctl_op0_0000_pw_neg_missing_wb 0 swpre
crbl_op0_0000_pw_neg_missing_wb rbl_op0_0000_pw_neg_missing_wb 0 {C_RBL}
cref_op0_0000_pw_neg_missing_wb ref_op0_0000_pw_neg_missing_wb 0 {C_RBL}   $ ASSUMPTION: ideal matched dummy load
XMWR_op0_0000_pw_neg_missing_wb_0 sn_op0_0000_pw_neg_missing_wb_0 wwl_op0_0000_pw_neg_missing_wb wbl_op0_0000_pw_neg_missing_wb 0 sky130_fd_pr__nfet_01v8 L=0.15 W=0.42 nf=1 ad=0.1218 as=0.1218 pd=1.42 ps=1.42 nrd=0.69047619047619  nrs=0.69047619047619 sa=0 sb=0 sd=0 mult=1 m=1
XMRD_op0_0000_pw_neg_missing_wb_0 rbl_op0_0000_pw_neg_missing_wb sn_op0_0000_pw_neg_missing_wb_0 rwls_op0_0000_pw_neg_missing_wb 0 sky130_fd_pr__nfet_01v8 L=0.15 W=0.42 nf=1 ad=0.1218 as=0.1218 pd=1.42 ps=1.42 nrd=0.69047619047619  nrs=0.69047619047619 sa=0 sb=0 sd=0 mult=1 m=1
csn_op0_0000_pw_neg_missing_wb_0 sn_op0_0000_pw_neg_missing_wb_0 0 {C_SN}
XMWR_op0_0000_pw_neg_missing_wb_1 sn_op0_0000_pw_neg_missing_wb_1 wwl_des wbl_op0_0000_pw_neg_missing_wb 0 sky130_fd_pr__nfet_01v8 L=0.15 W=0.42 nf=1 ad=0.1218 as=0.1218 pd=1.42 ps=1.42 nrd=0.69047619047619  nrs=0.69047619047619 sa=0 sb=0 sd=0 mult=1 m=1
XMRD_op0_0000_pw_neg_missing_wb_1 rbl_op0_0000_pw_neg_missing_wb sn_op0_0000_pw_neg_missing_wb_1 rwl_des 0 sky130_fd_pr__nfet_01v8 L=0.15 W=0.42 nf=1 ad=0.1218 as=0.1218 pd=1.42 ps=1.42 nrd=0.69047619047619  nrs=0.69047619047619 sa=0 sb=0 sd=0 mult=1 m=1
csn_op0_0000_pw_neg_missing_wb_1 sn_op0_0000_pw_neg_missing_wb_1 0 {C_SN}
XMWR_op0_0000_pw_neg_missing_wb_2 sn_op0_0000_pw_neg_missing_wb_2 wwl_des wbl_op0_0000_pw_neg_missing_wb 0 sky130_fd_pr__nfet_01v8 L=0.15 W=0.42 nf=1 ad=0.1218 as=0.1218 pd=1.42 ps=1.42 nrd=0.69047619047619  nrs=0.69047619047619 sa=0 sb=0 sd=0 mult=1 m=1
XMRD_op0_0000_pw_neg_missing_wb_2 rbl_op0_0000_pw_neg_missing_wb sn_op0_0000_pw_neg_missing_wb_2 rwl_des 0 sky130_fd_pr__nfet_01v8 L=0.15 W=0.42 nf=1 ad=0.1218 as=0.1218 pd=1.42 ps=1.42 nrd=0.69047619047619  nrs=0.69047619047619 sa=0 sb=0 sd=0 mult=1 m=1
csn_op0_0000_pw_neg_missing_wb_2 sn_op0_0000_pw_neg_missing_wb_2 0 {C_SN}
XMWR_op0_0000_pw_neg_missing_wb_3 sn_op0_0000_pw_neg_missing_wb_3 wwl_des wbl_op0_0000_pw_neg_missing_wb 0 sky130_fd_pr__nfet_01v8 L=0.15 W=0.42 nf=1 ad=0.1218 as=0.1218 pd=1.42 ps=1.42 nrd=0.69047619047619  nrs=0.69047619047619 sa=0 sb=0 sd=0 mult=1 m=1
XMRD_op0_0000_pw_neg_missing_wb_3 rbl_op0_0000_pw_neg_missing_wb sn_op0_0000_pw_neg_missing_wb_3 rwl_des 0 sky130_fd_pr__nfet_01v8 L=0.15 W=0.42 nf=1 ad=0.1218 as=0.1218 pd=1.42 ps=1.42 nrd=0.69047619047619  nrs=0.69047619047619 sa=0 sb=0 sd=0 mult=1 m=1
csn_op0_0000_pw_neg_missing_wb_3 sn_op0_0000_pw_neg_missing_wb_3 0 {C_SN}
XMN1_op0_0000_pw_neg_missing_wb rbl_op0_0000_pw_neg_missing_wb ref_op0_0000_pw_neg_missing_wb vn_op0_0000_pw_neg_missing_wb 0 sky130_fd_pr__nfet_01v8 L=0.15 W=1 nf=1 ad=0.29 as=0.29 pd=2.58 ps=2.58 mult=1 m=1
XMN2_op0_0000_pw_neg_missing_wb ref_op0_0000_pw_neg_missing_wb rbl_op0_0000_pw_neg_missing_wb vn_op0_0000_pw_neg_missing_wb 0 sky130_fd_pr__nfet_01v8 L=0.15 W=1 nf=1 ad=0.29 as=0.29 pd=2.58 ps=2.58 mult=1 m=1
XMP1_op0_0000_pw_neg_missing_wb rbl_op0_0000_pw_neg_missing_wb ref_op0_0000_pw_neg_missing_wb vp_op0_0000_pw_neg_missing_wb vdd sky130_fd_pr__pfet_01v8 L=0.15 W=2 nf=1 ad=0.58 as=0.58 pd=4.58 ps=4.58 mult=1 m=1
XMP2_op0_0000_pw_neg_missing_wb ref_op0_0000_pw_neg_missing_wb rbl_op0_0000_pw_neg_missing_wb vp_op0_0000_pw_neg_missing_wb vdd sky130_fd_pr__pfet_01v8 L=0.15 W=2 nf=1 ad=0.58 as=0.58 pd=4.58 ps=4.58 mult=1 m=1
XMNF_op0_0000_pw_neg_missing_wb vn_op0_0000_pw_neg_missing_wb en_op0_0000_pw_neg_missing_wb 0 0 sky130_fd_pr__nfet_01v8 L=0.15 W=2 nf=1 ad=0.58 as=0.58 pd=4.58 ps=4.58 mult=1 m=1
XMPH_op0_0000_pw_neg_missing_wb vp_op0_0000_pw_neg_missing_wb enb_op0_0000_pw_neg_missing_wb vdd vdd sky130_fd_pr__pfet_01v8 L=0.15 W=4 nf=1 ad=1.16 as=1.16 pd=8.58 ps=8.58 mult=1 m=1
bd_op0_0000_pw_neg_missing_wb d_op0_0000_pw_neg_missing_wb 0 v=v(rbl_op0_0000_pw_neg_missing_wb)-v(ref_op0_0000_pw_neg_missing_wb)

* ---- instance 48: op1_0900_pwnw_rwl_late_hold (variant pwnw_rwl_late_hold; probe dec 35.9 ns, release 58 ns, meas 60 ns) ----
vctl_op1_0900_pwnw_rwl_late_hold ctl_op1_0900_pwnw_rwl_late_hold 0 pwl(0.0000e+00 0 2.4000e-08 0 2.4100e-08 {VDD} 2.6000e-08 {VDD} 2.6100e-08 0)
vrs_op1_0900_pwnw_rwl_late_hold rwls_op1_0900_pwnw_rwl_late_hold 0 pwl(0.0000e+00 {VDD} 2.6000e-08 {VDD} 2.6100e-08 0 5.8000e-08 0 5.8100e-08 {VDD})
ven_op1_0900_pwnw_rwl_late_hold en_op1_0900_pwnw_rwl_late_hold 0 pwl(0.0000e+00 0 3.5000e-08 0 3.5100e-08 {VDD} 5.8000e-08 {VDD} 5.8100e-08 0)
venb_op1_0900_pwnw_rwl_late_hold enb_op1_0900_pwnw_rwl_late_hold 0 pwl(0.0000e+00 {VDD} 3.5000e-08 {VDD} 3.5100e-08 0 5.8000e-08 0 5.8100e-08 {VDD})
vww_op1_0900_pwnw_rwl_late_hold wwl_op1_0900_pwnw_rwl_late_hold 0 pwl(0.0000e+00 0 3.6000e-08 0 3.6100e-08 {VDD} 5.6000e-08 {VDD} 5.6100e-08 0)
vwc_op1_0900_pwnw_rwl_late_hold wbc_op1_0900_pwnw_rwl_late_hold 0 pwl(0.0000e+00 0 3.6000e-08 0 3.6100e-08 {VDD} 5.8000e-08 {VDD} 5.8100e-08 0)
* preparation driver (physical regime; write DELETED (init negative control)): WBL <- 0.9 V until 22 ns, then 0 V; switch open at 23 ns
vpw_op1_0900_pwnw_rwl_late_hold wpd_op1_0900_pwnw_rwl_late_hold 0 pwl(0 0.9 2.2000e-08 0.9 2.2100e-08 0)
vpc_op1_0900_pwnw_rwl_late_hold pctl_op1_0900_pwnw_rwl_late_hold 0 pwl(0.0000e+00 {VDD} 2.3000e-08 {VDD} 2.3100e-08 0)
spw_op1_0900_pwnw_rwl_late_hold wpd_op1_0900_pwnw_rwl_late_hold wbl_op1_0900_pwnw_rwl_late_hold pctl_op1_0900_pwnw_rwl_late_hold 0 swwbl
swb_op1_0900_pwnw_rwl_late_hold ref_op1_0900_pwnw_rwl_late_hold wbl_op1_0900_pwnw_rwl_late_hold wbc_op1_0900_pwnw_rwl_late_hold 0 swwbl
cwbl_op1_0900_pwnw_rwl_late_hold wbl_op1_0900_pwnw_rwl_late_hold 0 {C_WBL}
spa_op1_0900_pwnw_rwl_late_hold prea rbl_op1_0900_pwnw_rwl_late_hold ctl_op1_0900_pwnw_rwl_late_hold 0 swpre
spr_op1_0900_pwnw_rwl_late_hold pref ref_op1_0900_pwnw_rwl_late_hold ctl_op1_0900_pwnw_rwl_late_hold 0 swpre
crbl_op1_0900_pwnw_rwl_late_hold rbl_op1_0900_pwnw_rwl_late_hold 0 {C_RBL}
cref_op1_0900_pwnw_rwl_late_hold ref_op1_0900_pwnw_rwl_late_hold 0 {C_RBL}   $ ASSUMPTION: ideal matched dummy load
XMWR_op1_0900_pwnw_rwl_late_hold_0 sn_op1_0900_pwnw_rwl_late_hold_0 wwl_op1_0900_pwnw_rwl_late_hold wbl_op1_0900_pwnw_rwl_late_hold 0 sky130_fd_pr__nfet_01v8 L=0.15 W=0.42 nf=1 ad=0.1218 as=0.1218 pd=1.42 ps=1.42 nrd=0.69047619047619  nrs=0.69047619047619 sa=0 sb=0 sd=0 mult=1 m=1
XMRD_op1_0900_pwnw_rwl_late_hold_0 rbl_op1_0900_pwnw_rwl_late_hold sn_op1_0900_pwnw_rwl_late_hold_0 rwls_op1_0900_pwnw_rwl_late_hold 0 sky130_fd_pr__nfet_01v8 L=0.15 W=0.42 nf=1 ad=0.1218 as=0.1218 pd=1.42 ps=1.42 nrd=0.69047619047619  nrs=0.69047619047619 sa=0 sb=0 sd=0 mult=1 m=1
csn_op1_0900_pwnw_rwl_late_hold_0 sn_op1_0900_pwnw_rwl_late_hold_0 0 {C_SN}
XMWR_op1_0900_pwnw_rwl_late_hold_1 sn_op1_0900_pwnw_rwl_late_hold_1 wwl_des wbl_op1_0900_pwnw_rwl_late_hold 0 sky130_fd_pr__nfet_01v8 L=0.15 W=0.42 nf=1 ad=0.1218 as=0.1218 pd=1.42 ps=1.42 nrd=0.69047619047619  nrs=0.69047619047619 sa=0 sb=0 sd=0 mult=1 m=1
XMRD_op1_0900_pwnw_rwl_late_hold_1 rbl_op1_0900_pwnw_rwl_late_hold sn_op1_0900_pwnw_rwl_late_hold_1 rwl_des 0 sky130_fd_pr__nfet_01v8 L=0.15 W=0.42 nf=1 ad=0.1218 as=0.1218 pd=1.42 ps=1.42 nrd=0.69047619047619  nrs=0.69047619047619 sa=0 sb=0 sd=0 mult=1 m=1
csn_op1_0900_pwnw_rwl_late_hold_1 sn_op1_0900_pwnw_rwl_late_hold_1 0 {C_SN}
XMWR_op1_0900_pwnw_rwl_late_hold_2 sn_op1_0900_pwnw_rwl_late_hold_2 wwl_des wbl_op1_0900_pwnw_rwl_late_hold 0 sky130_fd_pr__nfet_01v8 L=0.15 W=0.42 nf=1 ad=0.1218 as=0.1218 pd=1.42 ps=1.42 nrd=0.69047619047619  nrs=0.69047619047619 sa=0 sb=0 sd=0 mult=1 m=1
XMRD_op1_0900_pwnw_rwl_late_hold_2 rbl_op1_0900_pwnw_rwl_late_hold sn_op1_0900_pwnw_rwl_late_hold_2 rwl_des 0 sky130_fd_pr__nfet_01v8 L=0.15 W=0.42 nf=1 ad=0.1218 as=0.1218 pd=1.42 ps=1.42 nrd=0.69047619047619  nrs=0.69047619047619 sa=0 sb=0 sd=0 mult=1 m=1
csn_op1_0900_pwnw_rwl_late_hold_2 sn_op1_0900_pwnw_rwl_late_hold_2 0 {C_SN}
XMWR_op1_0900_pwnw_rwl_late_hold_3 sn_op1_0900_pwnw_rwl_late_hold_3 wwl_des wbl_op1_0900_pwnw_rwl_late_hold 0 sky130_fd_pr__nfet_01v8 L=0.15 W=0.42 nf=1 ad=0.1218 as=0.1218 pd=1.42 ps=1.42 nrd=0.69047619047619  nrs=0.69047619047619 sa=0 sb=0 sd=0 mult=1 m=1
XMRD_op1_0900_pwnw_rwl_late_hold_3 rbl_op1_0900_pwnw_rwl_late_hold sn_op1_0900_pwnw_rwl_late_hold_3 rwl_des 0 sky130_fd_pr__nfet_01v8 L=0.15 W=0.42 nf=1 ad=0.1218 as=0.1218 pd=1.42 ps=1.42 nrd=0.69047619047619  nrs=0.69047619047619 sa=0 sb=0 sd=0 mult=1 m=1
csn_op1_0900_pwnw_rwl_late_hold_3 sn_op1_0900_pwnw_rwl_late_hold_3 0 {C_SN}
XMN1_op1_0900_pwnw_rwl_late_hold rbl_op1_0900_pwnw_rwl_late_hold ref_op1_0900_pwnw_rwl_late_hold vn_op1_0900_pwnw_rwl_late_hold 0 sky130_fd_pr__nfet_01v8 L=0.15 W=1 nf=1 ad=0.29 as=0.29 pd=2.58 ps=2.58 mult=1 m=1
XMN2_op1_0900_pwnw_rwl_late_hold ref_op1_0900_pwnw_rwl_late_hold rbl_op1_0900_pwnw_rwl_late_hold vn_op1_0900_pwnw_rwl_late_hold 0 sky130_fd_pr__nfet_01v8 L=0.15 W=1 nf=1 ad=0.29 as=0.29 pd=2.58 ps=2.58 mult=1 m=1
XMP1_op1_0900_pwnw_rwl_late_hold rbl_op1_0900_pwnw_rwl_late_hold ref_op1_0900_pwnw_rwl_late_hold vp_op1_0900_pwnw_rwl_late_hold vdd sky130_fd_pr__pfet_01v8 L=0.15 W=2 nf=1 ad=0.58 as=0.58 pd=4.58 ps=4.58 mult=1 m=1
XMP2_op1_0900_pwnw_rwl_late_hold ref_op1_0900_pwnw_rwl_late_hold rbl_op1_0900_pwnw_rwl_late_hold vp_op1_0900_pwnw_rwl_late_hold vdd sky130_fd_pr__pfet_01v8 L=0.15 W=2 nf=1 ad=0.58 as=0.58 pd=4.58 ps=4.58 mult=1 m=1
XMNF_op1_0900_pwnw_rwl_late_hold vn_op1_0900_pwnw_rwl_late_hold en_op1_0900_pwnw_rwl_late_hold 0 0 sky130_fd_pr__nfet_01v8 L=0.15 W=2 nf=1 ad=0.58 as=0.58 pd=4.58 ps=4.58 mult=1 m=1
XMPH_op1_0900_pwnw_rwl_late_hold vp_op1_0900_pwnw_rwl_late_hold enb_op1_0900_pwnw_rwl_late_hold vdd vdd sky130_fd_pr__pfet_01v8 L=0.15 W=4 nf=1 ad=1.16 as=1.16 pd=8.58 ps=8.58 mult=1 m=1
bd_op1_0900_pwnw_rwl_late_hold d_op1_0900_pwnw_rwl_late_hold 0 v=v(rbl_op1_0900_pwnw_rwl_late_hold)-v(ref_op1_0900_pwnw_rwl_late_hold)

* ---- instance 49: op1_1000_pwnw_rwl_late_hold (variant pwnw_rwl_late_hold; probe dec 35.9 ns, release 58 ns, meas 60 ns) ----
vctl_op1_1000_pwnw_rwl_late_hold ctl_op1_1000_pwnw_rwl_late_hold 0 pwl(0.0000e+00 0 2.4000e-08 0 2.4100e-08 {VDD} 2.6000e-08 {VDD} 2.6100e-08 0)
vrs_op1_1000_pwnw_rwl_late_hold rwls_op1_1000_pwnw_rwl_late_hold 0 pwl(0.0000e+00 {VDD} 2.6000e-08 {VDD} 2.6100e-08 0 5.8000e-08 0 5.8100e-08 {VDD})
ven_op1_1000_pwnw_rwl_late_hold en_op1_1000_pwnw_rwl_late_hold 0 pwl(0.0000e+00 0 3.5000e-08 0 3.5100e-08 {VDD} 5.8000e-08 {VDD} 5.8100e-08 0)
venb_op1_1000_pwnw_rwl_late_hold enb_op1_1000_pwnw_rwl_late_hold 0 pwl(0.0000e+00 {VDD} 3.5000e-08 {VDD} 3.5100e-08 0 5.8000e-08 0 5.8100e-08 {VDD})
vww_op1_1000_pwnw_rwl_late_hold wwl_op1_1000_pwnw_rwl_late_hold 0 pwl(0.0000e+00 0 3.6000e-08 0 3.6100e-08 {VDD} 5.6000e-08 {VDD} 5.6100e-08 0)
vwc_op1_1000_pwnw_rwl_late_hold wbc_op1_1000_pwnw_rwl_late_hold 0 pwl(0.0000e+00 0 3.6000e-08 0 3.6100e-08 {VDD} 5.8000e-08 {VDD} 5.8100e-08 0)
* preparation driver (physical regime; write DELETED (init negative control)): WBL <- 1 V until 22 ns, then 0 V; switch open at 23 ns
vpw_op1_1000_pwnw_rwl_late_hold wpd_op1_1000_pwnw_rwl_late_hold 0 pwl(0 1 2.2000e-08 1 2.2100e-08 0)
vpc_op1_1000_pwnw_rwl_late_hold pctl_op1_1000_pwnw_rwl_late_hold 0 pwl(0.0000e+00 {VDD} 2.3000e-08 {VDD} 2.3100e-08 0)
spw_op1_1000_pwnw_rwl_late_hold wpd_op1_1000_pwnw_rwl_late_hold wbl_op1_1000_pwnw_rwl_late_hold pctl_op1_1000_pwnw_rwl_late_hold 0 swwbl
swb_op1_1000_pwnw_rwl_late_hold ref_op1_1000_pwnw_rwl_late_hold wbl_op1_1000_pwnw_rwl_late_hold wbc_op1_1000_pwnw_rwl_late_hold 0 swwbl
cwbl_op1_1000_pwnw_rwl_late_hold wbl_op1_1000_pwnw_rwl_late_hold 0 {C_WBL}
spa_op1_1000_pwnw_rwl_late_hold prea rbl_op1_1000_pwnw_rwl_late_hold ctl_op1_1000_pwnw_rwl_late_hold 0 swpre
spr_op1_1000_pwnw_rwl_late_hold pref ref_op1_1000_pwnw_rwl_late_hold ctl_op1_1000_pwnw_rwl_late_hold 0 swpre
crbl_op1_1000_pwnw_rwl_late_hold rbl_op1_1000_pwnw_rwl_late_hold 0 {C_RBL}
cref_op1_1000_pwnw_rwl_late_hold ref_op1_1000_pwnw_rwl_late_hold 0 {C_RBL}   $ ASSUMPTION: ideal matched dummy load
XMWR_op1_1000_pwnw_rwl_late_hold_0 sn_op1_1000_pwnw_rwl_late_hold_0 wwl_op1_1000_pwnw_rwl_late_hold wbl_op1_1000_pwnw_rwl_late_hold 0 sky130_fd_pr__nfet_01v8 L=0.15 W=0.42 nf=1 ad=0.1218 as=0.1218 pd=1.42 ps=1.42 nrd=0.69047619047619  nrs=0.69047619047619 sa=0 sb=0 sd=0 mult=1 m=1
XMRD_op1_1000_pwnw_rwl_late_hold_0 rbl_op1_1000_pwnw_rwl_late_hold sn_op1_1000_pwnw_rwl_late_hold_0 rwls_op1_1000_pwnw_rwl_late_hold 0 sky130_fd_pr__nfet_01v8 L=0.15 W=0.42 nf=1 ad=0.1218 as=0.1218 pd=1.42 ps=1.42 nrd=0.69047619047619  nrs=0.69047619047619 sa=0 sb=0 sd=0 mult=1 m=1
csn_op1_1000_pwnw_rwl_late_hold_0 sn_op1_1000_pwnw_rwl_late_hold_0 0 {C_SN}
XMWR_op1_1000_pwnw_rwl_late_hold_1 sn_op1_1000_pwnw_rwl_late_hold_1 wwl_des wbl_op1_1000_pwnw_rwl_late_hold 0 sky130_fd_pr__nfet_01v8 L=0.15 W=0.42 nf=1 ad=0.1218 as=0.1218 pd=1.42 ps=1.42 nrd=0.69047619047619  nrs=0.69047619047619 sa=0 sb=0 sd=0 mult=1 m=1
XMRD_op1_1000_pwnw_rwl_late_hold_1 rbl_op1_1000_pwnw_rwl_late_hold sn_op1_1000_pwnw_rwl_late_hold_1 rwl_des 0 sky130_fd_pr__nfet_01v8 L=0.15 W=0.42 nf=1 ad=0.1218 as=0.1218 pd=1.42 ps=1.42 nrd=0.69047619047619  nrs=0.69047619047619 sa=0 sb=0 sd=0 mult=1 m=1
csn_op1_1000_pwnw_rwl_late_hold_1 sn_op1_1000_pwnw_rwl_late_hold_1 0 {C_SN}
XMWR_op1_1000_pwnw_rwl_late_hold_2 sn_op1_1000_pwnw_rwl_late_hold_2 wwl_des wbl_op1_1000_pwnw_rwl_late_hold 0 sky130_fd_pr__nfet_01v8 L=0.15 W=0.42 nf=1 ad=0.1218 as=0.1218 pd=1.42 ps=1.42 nrd=0.69047619047619  nrs=0.69047619047619 sa=0 sb=0 sd=0 mult=1 m=1
XMRD_op1_1000_pwnw_rwl_late_hold_2 rbl_op1_1000_pwnw_rwl_late_hold sn_op1_1000_pwnw_rwl_late_hold_2 rwl_des 0 sky130_fd_pr__nfet_01v8 L=0.15 W=0.42 nf=1 ad=0.1218 as=0.1218 pd=1.42 ps=1.42 nrd=0.69047619047619  nrs=0.69047619047619 sa=0 sb=0 sd=0 mult=1 m=1
csn_op1_1000_pwnw_rwl_late_hold_2 sn_op1_1000_pwnw_rwl_late_hold_2 0 {C_SN}
XMWR_op1_1000_pwnw_rwl_late_hold_3 sn_op1_1000_pwnw_rwl_late_hold_3 wwl_des wbl_op1_1000_pwnw_rwl_late_hold 0 sky130_fd_pr__nfet_01v8 L=0.15 W=0.42 nf=1 ad=0.1218 as=0.1218 pd=1.42 ps=1.42 nrd=0.69047619047619  nrs=0.69047619047619 sa=0 sb=0 sd=0 mult=1 m=1
XMRD_op1_1000_pwnw_rwl_late_hold_3 rbl_op1_1000_pwnw_rwl_late_hold sn_op1_1000_pwnw_rwl_late_hold_3 rwl_des 0 sky130_fd_pr__nfet_01v8 L=0.15 W=0.42 nf=1 ad=0.1218 as=0.1218 pd=1.42 ps=1.42 nrd=0.69047619047619  nrs=0.69047619047619 sa=0 sb=0 sd=0 mult=1 m=1
csn_op1_1000_pwnw_rwl_late_hold_3 sn_op1_1000_pwnw_rwl_late_hold_3 0 {C_SN}
XMN1_op1_1000_pwnw_rwl_late_hold rbl_op1_1000_pwnw_rwl_late_hold ref_op1_1000_pwnw_rwl_late_hold vn_op1_1000_pwnw_rwl_late_hold 0 sky130_fd_pr__nfet_01v8 L=0.15 W=1 nf=1 ad=0.29 as=0.29 pd=2.58 ps=2.58 mult=1 m=1
XMN2_op1_1000_pwnw_rwl_late_hold ref_op1_1000_pwnw_rwl_late_hold rbl_op1_1000_pwnw_rwl_late_hold vn_op1_1000_pwnw_rwl_late_hold 0 sky130_fd_pr__nfet_01v8 L=0.15 W=1 nf=1 ad=0.29 as=0.29 pd=2.58 ps=2.58 mult=1 m=1
XMP1_op1_1000_pwnw_rwl_late_hold rbl_op1_1000_pwnw_rwl_late_hold ref_op1_1000_pwnw_rwl_late_hold vp_op1_1000_pwnw_rwl_late_hold vdd sky130_fd_pr__pfet_01v8 L=0.15 W=2 nf=1 ad=0.58 as=0.58 pd=4.58 ps=4.58 mult=1 m=1
XMP2_op1_1000_pwnw_rwl_late_hold ref_op1_1000_pwnw_rwl_late_hold rbl_op1_1000_pwnw_rwl_late_hold vp_op1_1000_pwnw_rwl_late_hold vdd sky130_fd_pr__pfet_01v8 L=0.15 W=2 nf=1 ad=0.58 as=0.58 pd=4.58 ps=4.58 mult=1 m=1
XMNF_op1_1000_pwnw_rwl_late_hold vn_op1_1000_pwnw_rwl_late_hold en_op1_1000_pwnw_rwl_late_hold 0 0 sky130_fd_pr__nfet_01v8 L=0.15 W=2 nf=1 ad=0.58 as=0.58 pd=4.58 ps=4.58 mult=1 m=1
XMPH_op1_1000_pwnw_rwl_late_hold vp_op1_1000_pwnw_rwl_late_hold enb_op1_1000_pwnw_rwl_late_hold vdd vdd sky130_fd_pr__pfet_01v8 L=0.15 W=4 nf=1 ad=1.16 as=1.16 pd=8.58 ps=8.58 mult=1 m=1
bd_op1_1000_pwnw_rwl_late_hold d_op1_1000_pwnw_rwl_late_hold 0 v=v(rbl_op1_1000_pwnw_rwl_late_hold)-v(ref_op1_1000_pwnw_rwl_late_hold)

* ---- instance 50: op0_n100_pwnw_rwl_late_hold (variant pwnw_rwl_late_hold; probe dec 35.9 ns, release 58 ns, meas 60 ns) ----
vctl_op0_n100_pwnw_rwl_late_hold ctl_op0_n100_pwnw_rwl_late_hold 0 pwl(0.0000e+00 0 2.4000e-08 0 2.4100e-08 {VDD} 2.6000e-08 {VDD} 2.6100e-08 0)
vrs_op0_n100_pwnw_rwl_late_hold rwls_op0_n100_pwnw_rwl_late_hold 0 pwl(0.0000e+00 {VDD} 2.6000e-08 {VDD} 2.6100e-08 0 5.8000e-08 0 5.8100e-08 {VDD})
ven_op0_n100_pwnw_rwl_late_hold en_op0_n100_pwnw_rwl_late_hold 0 pwl(0.0000e+00 0 3.5000e-08 0 3.5100e-08 {VDD} 5.8000e-08 {VDD} 5.8100e-08 0)
venb_op0_n100_pwnw_rwl_late_hold enb_op0_n100_pwnw_rwl_late_hold 0 pwl(0.0000e+00 {VDD} 3.5000e-08 {VDD} 3.5100e-08 0 5.8000e-08 0 5.8100e-08 {VDD})
vww_op0_n100_pwnw_rwl_late_hold wwl_op0_n100_pwnw_rwl_late_hold 0 pwl(0.0000e+00 0 3.6000e-08 0 3.6100e-08 {VDD} 5.6000e-08 {VDD} 5.6100e-08 0)
vwc_op0_n100_pwnw_rwl_late_hold wbc_op0_n100_pwnw_rwl_late_hold 0 pwl(0.0000e+00 0 3.6000e-08 0 3.6100e-08 {VDD} 5.8000e-08 {VDD} 5.8100e-08 0)
* preparation driver (physical regime; write DELETED (init negative control)): WBL <- -0.1 V until 22 ns, then 0 V; switch open at 23 ns
vpw_op0_n100_pwnw_rwl_late_hold wpd_op0_n100_pwnw_rwl_late_hold 0 pwl(0 -0.1 2.2000e-08 -0.1 2.2100e-08 0)
vpc_op0_n100_pwnw_rwl_late_hold pctl_op0_n100_pwnw_rwl_late_hold 0 pwl(0.0000e+00 {VDD} 2.3000e-08 {VDD} 2.3100e-08 0)
spw_op0_n100_pwnw_rwl_late_hold wpd_op0_n100_pwnw_rwl_late_hold wbl_op0_n100_pwnw_rwl_late_hold pctl_op0_n100_pwnw_rwl_late_hold 0 swwbl
swb_op0_n100_pwnw_rwl_late_hold ref_op0_n100_pwnw_rwl_late_hold wbl_op0_n100_pwnw_rwl_late_hold wbc_op0_n100_pwnw_rwl_late_hold 0 swwbl
cwbl_op0_n100_pwnw_rwl_late_hold wbl_op0_n100_pwnw_rwl_late_hold 0 {C_WBL}
spa_op0_n100_pwnw_rwl_late_hold prea rbl_op0_n100_pwnw_rwl_late_hold ctl_op0_n100_pwnw_rwl_late_hold 0 swpre
spr_op0_n100_pwnw_rwl_late_hold pref ref_op0_n100_pwnw_rwl_late_hold ctl_op0_n100_pwnw_rwl_late_hold 0 swpre
crbl_op0_n100_pwnw_rwl_late_hold rbl_op0_n100_pwnw_rwl_late_hold 0 {C_RBL}
cref_op0_n100_pwnw_rwl_late_hold ref_op0_n100_pwnw_rwl_late_hold 0 {C_RBL}   $ ASSUMPTION: ideal matched dummy load
XMWR_op0_n100_pwnw_rwl_late_hold_0 sn_op0_n100_pwnw_rwl_late_hold_0 wwl_op0_n100_pwnw_rwl_late_hold wbl_op0_n100_pwnw_rwl_late_hold 0 sky130_fd_pr__nfet_01v8 L=0.15 W=0.42 nf=1 ad=0.1218 as=0.1218 pd=1.42 ps=1.42 nrd=0.69047619047619  nrs=0.69047619047619 sa=0 sb=0 sd=0 mult=1 m=1
XMRD_op0_n100_pwnw_rwl_late_hold_0 rbl_op0_n100_pwnw_rwl_late_hold sn_op0_n100_pwnw_rwl_late_hold_0 rwls_op0_n100_pwnw_rwl_late_hold 0 sky130_fd_pr__nfet_01v8 L=0.15 W=0.42 nf=1 ad=0.1218 as=0.1218 pd=1.42 ps=1.42 nrd=0.69047619047619  nrs=0.69047619047619 sa=0 sb=0 sd=0 mult=1 m=1
csn_op0_n100_pwnw_rwl_late_hold_0 sn_op0_n100_pwnw_rwl_late_hold_0 0 {C_SN}
XMWR_op0_n100_pwnw_rwl_late_hold_1 sn_op0_n100_pwnw_rwl_late_hold_1 wwl_des wbl_op0_n100_pwnw_rwl_late_hold 0 sky130_fd_pr__nfet_01v8 L=0.15 W=0.42 nf=1 ad=0.1218 as=0.1218 pd=1.42 ps=1.42 nrd=0.69047619047619  nrs=0.69047619047619 sa=0 sb=0 sd=0 mult=1 m=1
XMRD_op0_n100_pwnw_rwl_late_hold_1 rbl_op0_n100_pwnw_rwl_late_hold sn_op0_n100_pwnw_rwl_late_hold_1 rwl_des 0 sky130_fd_pr__nfet_01v8 L=0.15 W=0.42 nf=1 ad=0.1218 as=0.1218 pd=1.42 ps=1.42 nrd=0.69047619047619  nrs=0.69047619047619 sa=0 sb=0 sd=0 mult=1 m=1
csn_op0_n100_pwnw_rwl_late_hold_1 sn_op0_n100_pwnw_rwl_late_hold_1 0 {C_SN}
XMWR_op0_n100_pwnw_rwl_late_hold_2 sn_op0_n100_pwnw_rwl_late_hold_2 wwl_des wbl_op0_n100_pwnw_rwl_late_hold 0 sky130_fd_pr__nfet_01v8 L=0.15 W=0.42 nf=1 ad=0.1218 as=0.1218 pd=1.42 ps=1.42 nrd=0.69047619047619  nrs=0.69047619047619 sa=0 sb=0 sd=0 mult=1 m=1
XMRD_op0_n100_pwnw_rwl_late_hold_2 rbl_op0_n100_pwnw_rwl_late_hold sn_op0_n100_pwnw_rwl_late_hold_2 rwl_des 0 sky130_fd_pr__nfet_01v8 L=0.15 W=0.42 nf=1 ad=0.1218 as=0.1218 pd=1.42 ps=1.42 nrd=0.69047619047619  nrs=0.69047619047619 sa=0 sb=0 sd=0 mult=1 m=1
csn_op0_n100_pwnw_rwl_late_hold_2 sn_op0_n100_pwnw_rwl_late_hold_2 0 {C_SN}
XMWR_op0_n100_pwnw_rwl_late_hold_3 sn_op0_n100_pwnw_rwl_late_hold_3 wwl_des wbl_op0_n100_pwnw_rwl_late_hold 0 sky130_fd_pr__nfet_01v8 L=0.15 W=0.42 nf=1 ad=0.1218 as=0.1218 pd=1.42 ps=1.42 nrd=0.69047619047619  nrs=0.69047619047619 sa=0 sb=0 sd=0 mult=1 m=1
XMRD_op0_n100_pwnw_rwl_late_hold_3 rbl_op0_n100_pwnw_rwl_late_hold sn_op0_n100_pwnw_rwl_late_hold_3 rwl_des 0 sky130_fd_pr__nfet_01v8 L=0.15 W=0.42 nf=1 ad=0.1218 as=0.1218 pd=1.42 ps=1.42 nrd=0.69047619047619  nrs=0.69047619047619 sa=0 sb=0 sd=0 mult=1 m=1
csn_op0_n100_pwnw_rwl_late_hold_3 sn_op0_n100_pwnw_rwl_late_hold_3 0 {C_SN}
XMN1_op0_n100_pwnw_rwl_late_hold rbl_op0_n100_pwnw_rwl_late_hold ref_op0_n100_pwnw_rwl_late_hold vn_op0_n100_pwnw_rwl_late_hold 0 sky130_fd_pr__nfet_01v8 L=0.15 W=1 nf=1 ad=0.29 as=0.29 pd=2.58 ps=2.58 mult=1 m=1
XMN2_op0_n100_pwnw_rwl_late_hold ref_op0_n100_pwnw_rwl_late_hold rbl_op0_n100_pwnw_rwl_late_hold vn_op0_n100_pwnw_rwl_late_hold 0 sky130_fd_pr__nfet_01v8 L=0.15 W=1 nf=1 ad=0.29 as=0.29 pd=2.58 ps=2.58 mult=1 m=1
XMP1_op0_n100_pwnw_rwl_late_hold rbl_op0_n100_pwnw_rwl_late_hold ref_op0_n100_pwnw_rwl_late_hold vp_op0_n100_pwnw_rwl_late_hold vdd sky130_fd_pr__pfet_01v8 L=0.15 W=2 nf=1 ad=0.58 as=0.58 pd=4.58 ps=4.58 mult=1 m=1
XMP2_op0_n100_pwnw_rwl_late_hold ref_op0_n100_pwnw_rwl_late_hold rbl_op0_n100_pwnw_rwl_late_hold vp_op0_n100_pwnw_rwl_late_hold vdd sky130_fd_pr__pfet_01v8 L=0.15 W=2 nf=1 ad=0.58 as=0.58 pd=4.58 ps=4.58 mult=1 m=1
XMNF_op0_n100_pwnw_rwl_late_hold vn_op0_n100_pwnw_rwl_late_hold en_op0_n100_pwnw_rwl_late_hold 0 0 sky130_fd_pr__nfet_01v8 L=0.15 W=2 nf=1 ad=0.58 as=0.58 pd=4.58 ps=4.58 mult=1 m=1
XMPH_op0_n100_pwnw_rwl_late_hold vp_op0_n100_pwnw_rwl_late_hold enb_op0_n100_pwnw_rwl_late_hold vdd vdd sky130_fd_pr__pfet_01v8 L=0.15 W=4 nf=1 ad=1.16 as=1.16 pd=8.58 ps=8.58 mult=1 m=1
bd_op0_n100_pwnw_rwl_late_hold d_op0_n100_pwnw_rwl_late_hold 0 v=v(rbl_op0_n100_pwnw_rwl_late_hold)-v(ref_op0_n100_pwnw_rwl_late_hold)

* ---- instance 51: op0_0000_pwnw_rwl_late_hold (variant pwnw_rwl_late_hold; probe dec 35.9 ns, release 58 ns, meas 60 ns) ----
vctl_op0_0000_pwnw_rwl_late_hold ctl_op0_0000_pwnw_rwl_late_hold 0 pwl(0.0000e+00 0 2.4000e-08 0 2.4100e-08 {VDD} 2.6000e-08 {VDD} 2.6100e-08 0)
vrs_op0_0000_pwnw_rwl_late_hold rwls_op0_0000_pwnw_rwl_late_hold 0 pwl(0.0000e+00 {VDD} 2.6000e-08 {VDD} 2.6100e-08 0 5.8000e-08 0 5.8100e-08 {VDD})
ven_op0_0000_pwnw_rwl_late_hold en_op0_0000_pwnw_rwl_late_hold 0 pwl(0.0000e+00 0 3.5000e-08 0 3.5100e-08 {VDD} 5.8000e-08 {VDD} 5.8100e-08 0)
venb_op0_0000_pwnw_rwl_late_hold enb_op0_0000_pwnw_rwl_late_hold 0 pwl(0.0000e+00 {VDD} 3.5000e-08 {VDD} 3.5100e-08 0 5.8000e-08 0 5.8100e-08 {VDD})
vww_op0_0000_pwnw_rwl_late_hold wwl_op0_0000_pwnw_rwl_late_hold 0 pwl(0.0000e+00 0 3.6000e-08 0 3.6100e-08 {VDD} 5.6000e-08 {VDD} 5.6100e-08 0)
vwc_op0_0000_pwnw_rwl_late_hold wbc_op0_0000_pwnw_rwl_late_hold 0 pwl(0.0000e+00 0 3.6000e-08 0 3.6100e-08 {VDD} 5.8000e-08 {VDD} 5.8100e-08 0)
* preparation driver (physical regime; write DELETED (init negative control)): WBL <- 0 V until 22 ns, then 0 V; switch open at 23 ns
vpw_op0_0000_pwnw_rwl_late_hold wpd_op0_0000_pwnw_rwl_late_hold 0 pwl(0 0 2.2000e-08 0 2.2100e-08 0)
vpc_op0_0000_pwnw_rwl_late_hold pctl_op0_0000_pwnw_rwl_late_hold 0 pwl(0.0000e+00 {VDD} 2.3000e-08 {VDD} 2.3100e-08 0)
spw_op0_0000_pwnw_rwl_late_hold wpd_op0_0000_pwnw_rwl_late_hold wbl_op0_0000_pwnw_rwl_late_hold pctl_op0_0000_pwnw_rwl_late_hold 0 swwbl
swb_op0_0000_pwnw_rwl_late_hold ref_op0_0000_pwnw_rwl_late_hold wbl_op0_0000_pwnw_rwl_late_hold wbc_op0_0000_pwnw_rwl_late_hold 0 swwbl
cwbl_op0_0000_pwnw_rwl_late_hold wbl_op0_0000_pwnw_rwl_late_hold 0 {C_WBL}
spa_op0_0000_pwnw_rwl_late_hold prea rbl_op0_0000_pwnw_rwl_late_hold ctl_op0_0000_pwnw_rwl_late_hold 0 swpre
spr_op0_0000_pwnw_rwl_late_hold pref ref_op0_0000_pwnw_rwl_late_hold ctl_op0_0000_pwnw_rwl_late_hold 0 swpre
crbl_op0_0000_pwnw_rwl_late_hold rbl_op0_0000_pwnw_rwl_late_hold 0 {C_RBL}
cref_op0_0000_pwnw_rwl_late_hold ref_op0_0000_pwnw_rwl_late_hold 0 {C_RBL}   $ ASSUMPTION: ideal matched dummy load
XMWR_op0_0000_pwnw_rwl_late_hold_0 sn_op0_0000_pwnw_rwl_late_hold_0 wwl_op0_0000_pwnw_rwl_late_hold wbl_op0_0000_pwnw_rwl_late_hold 0 sky130_fd_pr__nfet_01v8 L=0.15 W=0.42 nf=1 ad=0.1218 as=0.1218 pd=1.42 ps=1.42 nrd=0.69047619047619  nrs=0.69047619047619 sa=0 sb=0 sd=0 mult=1 m=1
XMRD_op0_0000_pwnw_rwl_late_hold_0 rbl_op0_0000_pwnw_rwl_late_hold sn_op0_0000_pwnw_rwl_late_hold_0 rwls_op0_0000_pwnw_rwl_late_hold 0 sky130_fd_pr__nfet_01v8 L=0.15 W=0.42 nf=1 ad=0.1218 as=0.1218 pd=1.42 ps=1.42 nrd=0.69047619047619  nrs=0.69047619047619 sa=0 sb=0 sd=0 mult=1 m=1
csn_op0_0000_pwnw_rwl_late_hold_0 sn_op0_0000_pwnw_rwl_late_hold_0 0 {C_SN}
XMWR_op0_0000_pwnw_rwl_late_hold_1 sn_op0_0000_pwnw_rwl_late_hold_1 wwl_des wbl_op0_0000_pwnw_rwl_late_hold 0 sky130_fd_pr__nfet_01v8 L=0.15 W=0.42 nf=1 ad=0.1218 as=0.1218 pd=1.42 ps=1.42 nrd=0.69047619047619  nrs=0.69047619047619 sa=0 sb=0 sd=0 mult=1 m=1
XMRD_op0_0000_pwnw_rwl_late_hold_1 rbl_op0_0000_pwnw_rwl_late_hold sn_op0_0000_pwnw_rwl_late_hold_1 rwl_des 0 sky130_fd_pr__nfet_01v8 L=0.15 W=0.42 nf=1 ad=0.1218 as=0.1218 pd=1.42 ps=1.42 nrd=0.69047619047619  nrs=0.69047619047619 sa=0 sb=0 sd=0 mult=1 m=1
csn_op0_0000_pwnw_rwl_late_hold_1 sn_op0_0000_pwnw_rwl_late_hold_1 0 {C_SN}
XMWR_op0_0000_pwnw_rwl_late_hold_2 sn_op0_0000_pwnw_rwl_late_hold_2 wwl_des wbl_op0_0000_pwnw_rwl_late_hold 0 sky130_fd_pr__nfet_01v8 L=0.15 W=0.42 nf=1 ad=0.1218 as=0.1218 pd=1.42 ps=1.42 nrd=0.69047619047619  nrs=0.69047619047619 sa=0 sb=0 sd=0 mult=1 m=1
XMRD_op0_0000_pwnw_rwl_late_hold_2 rbl_op0_0000_pwnw_rwl_late_hold sn_op0_0000_pwnw_rwl_late_hold_2 rwl_des 0 sky130_fd_pr__nfet_01v8 L=0.15 W=0.42 nf=1 ad=0.1218 as=0.1218 pd=1.42 ps=1.42 nrd=0.69047619047619  nrs=0.69047619047619 sa=0 sb=0 sd=0 mult=1 m=1
csn_op0_0000_pwnw_rwl_late_hold_2 sn_op0_0000_pwnw_rwl_late_hold_2 0 {C_SN}
XMWR_op0_0000_pwnw_rwl_late_hold_3 sn_op0_0000_pwnw_rwl_late_hold_3 wwl_des wbl_op0_0000_pwnw_rwl_late_hold 0 sky130_fd_pr__nfet_01v8 L=0.15 W=0.42 nf=1 ad=0.1218 as=0.1218 pd=1.42 ps=1.42 nrd=0.69047619047619  nrs=0.69047619047619 sa=0 sb=0 sd=0 mult=1 m=1
XMRD_op0_0000_pwnw_rwl_late_hold_3 rbl_op0_0000_pwnw_rwl_late_hold sn_op0_0000_pwnw_rwl_late_hold_3 rwl_des 0 sky130_fd_pr__nfet_01v8 L=0.15 W=0.42 nf=1 ad=0.1218 as=0.1218 pd=1.42 ps=1.42 nrd=0.69047619047619  nrs=0.69047619047619 sa=0 sb=0 sd=0 mult=1 m=1
csn_op0_0000_pwnw_rwl_late_hold_3 sn_op0_0000_pwnw_rwl_late_hold_3 0 {C_SN}
XMN1_op0_0000_pwnw_rwl_late_hold rbl_op0_0000_pwnw_rwl_late_hold ref_op0_0000_pwnw_rwl_late_hold vn_op0_0000_pwnw_rwl_late_hold 0 sky130_fd_pr__nfet_01v8 L=0.15 W=1 nf=1 ad=0.29 as=0.29 pd=2.58 ps=2.58 mult=1 m=1
XMN2_op0_0000_pwnw_rwl_late_hold ref_op0_0000_pwnw_rwl_late_hold rbl_op0_0000_pwnw_rwl_late_hold vn_op0_0000_pwnw_rwl_late_hold 0 sky130_fd_pr__nfet_01v8 L=0.15 W=1 nf=1 ad=0.29 as=0.29 pd=2.58 ps=2.58 mult=1 m=1
XMP1_op0_0000_pwnw_rwl_late_hold rbl_op0_0000_pwnw_rwl_late_hold ref_op0_0000_pwnw_rwl_late_hold vp_op0_0000_pwnw_rwl_late_hold vdd sky130_fd_pr__pfet_01v8 L=0.15 W=2 nf=1 ad=0.58 as=0.58 pd=4.58 ps=4.58 mult=1 m=1
XMP2_op0_0000_pwnw_rwl_late_hold ref_op0_0000_pwnw_rwl_late_hold rbl_op0_0000_pwnw_rwl_late_hold vp_op0_0000_pwnw_rwl_late_hold vdd sky130_fd_pr__pfet_01v8 L=0.15 W=2 nf=1 ad=0.58 as=0.58 pd=4.58 ps=4.58 mult=1 m=1
XMNF_op0_0000_pwnw_rwl_late_hold vn_op0_0000_pwnw_rwl_late_hold en_op0_0000_pwnw_rwl_late_hold 0 0 sky130_fd_pr__nfet_01v8 L=0.15 W=2 nf=1 ad=0.58 as=0.58 pd=4.58 ps=4.58 mult=1 m=1
XMPH_op0_0000_pwnw_rwl_late_hold vp_op0_0000_pwnw_rwl_late_hold enb_op0_0000_pwnw_rwl_late_hold vdd vdd sky130_fd_pr__pfet_01v8 L=0.15 W=4 nf=1 ad=1.16 as=1.16 pd=8.58 ps=8.58 mult=1 m=1
bd_op0_0000_pwnw_rwl_late_hold d_op0_0000_pwnw_rwl_late_hold 0 v=v(rbl_op0_0000_pwnw_rwl_late_hold)-v(ref_op0_0000_pwnw_rwl_late_hold)

* ---- instance 52: refw (variant reference_write; probe dec 14.9 ns, release 37 ns, meas 39 ns) ----
vctl_refw ctl_refw 0 pwl(0.0000e+00 {VDD} 2.0000e-09 {VDD} 2.1000e-09 0)
vrs_refw rwls_refw 0 pwl(0.0000e+00 {VDD} 4.0000e-09 {VDD} 4.1000e-09 0 3.7000e-08 0 3.7100e-08 {VDD})
ven_refw en_refw 0 pwl(0.0000e+00 0 1.4000e-08 0 1.4100e-08 {VDD} 3.7000e-08 {VDD} 3.7100e-08 0)
venb_refw enb_refw 0 pwl(0.0000e+00 {VDD} 1.4000e-08 {VDD} 1.4100e-08 0 3.7000e-08 0 3.7100e-08 {VDD})
vww_refw wwl_refw 0 pwl(0.0000e+00 0 1.5000e-08 0 1.5100e-08 {VDD} 3.5000e-08 {VDD} 3.5100e-08 0)
vwc_refw wbc_refw 0 pwl(0.0000e+00 0 1.5000e-08 0 1.5100e-08 {VDD} 3.7000e-08 {VDD} 3.7100e-08 0)
* reference write: ideal 1.8 V WBL; rbl/ref/latch idle (no read)
vwbr_refw wbl_refw 0 dc {VDD}
cwbl_refw wbl_refw 0 {C_WBL}
spa_refw prea rbl_refw ctl_refw 0 swpre
spr_refw pref ref_refw ctl_refw 0 swpre
crbl_refw rbl_refw 0 {C_RBL}
cref_refw ref_refw 0 {C_RBL}   $ ASSUMPTION: ideal matched dummy load
XMWR_refw_0 sn_refw_0 wwl_refw wbl_refw 0 sky130_fd_pr__nfet_01v8 L=0.15 W=0.42 nf=1 ad=0.1218 as=0.1218 pd=1.42 ps=1.42 nrd=0.69047619047619  nrs=0.69047619047619 sa=0 sb=0 sd=0 mult=1 m=1
XMRD_refw_0 rbl_refw sn_refw_0 rwls_refw 0 sky130_fd_pr__nfet_01v8 L=0.15 W=0.42 nf=1 ad=0.1218 as=0.1218 pd=1.42 ps=1.42 nrd=0.69047619047619  nrs=0.69047619047619 sa=0 sb=0 sd=0 mult=1 m=1
csn_refw_0 sn_refw_0 0 {C_SN}
XMWR_refw_1 sn_refw_1 wwl_des wbl_refw 0 sky130_fd_pr__nfet_01v8 L=0.15 W=0.42 nf=1 ad=0.1218 as=0.1218 pd=1.42 ps=1.42 nrd=0.69047619047619  nrs=0.69047619047619 sa=0 sb=0 sd=0 mult=1 m=1
XMRD_refw_1 rbl_refw sn_refw_1 rwl_des 0 sky130_fd_pr__nfet_01v8 L=0.15 W=0.42 nf=1 ad=0.1218 as=0.1218 pd=1.42 ps=1.42 nrd=0.69047619047619  nrs=0.69047619047619 sa=0 sb=0 sd=0 mult=1 m=1
csn_refw_1 sn_refw_1 0 {C_SN}
XMWR_refw_2 sn_refw_2 wwl_des wbl_refw 0 sky130_fd_pr__nfet_01v8 L=0.15 W=0.42 nf=1 ad=0.1218 as=0.1218 pd=1.42 ps=1.42 nrd=0.69047619047619  nrs=0.69047619047619 sa=0 sb=0 sd=0 mult=1 m=1
XMRD_refw_2 rbl_refw sn_refw_2 rwl_des 0 sky130_fd_pr__nfet_01v8 L=0.15 W=0.42 nf=1 ad=0.1218 as=0.1218 pd=1.42 ps=1.42 nrd=0.69047619047619  nrs=0.69047619047619 sa=0 sb=0 sd=0 mult=1 m=1
csn_refw_2 sn_refw_2 0 {C_SN}
XMWR_refw_3 sn_refw_3 wwl_des wbl_refw 0 sky130_fd_pr__nfet_01v8 L=0.15 W=0.42 nf=1 ad=0.1218 as=0.1218 pd=1.42 ps=1.42 nrd=0.69047619047619  nrs=0.69047619047619 sa=0 sb=0 sd=0 mult=1 m=1
XMRD_refw_3 rbl_refw sn_refw_3 rwl_des 0 sky130_fd_pr__nfet_01v8 L=0.15 W=0.42 nf=1 ad=0.1218 as=0.1218 pd=1.42 ps=1.42 nrd=0.69047619047619  nrs=0.69047619047619 sa=0 sb=0 sd=0 mult=1 m=1
csn_refw_3 sn_refw_3 0 {C_SN}
XMN1_refw rbl_refw ref_refw vn_refw 0 sky130_fd_pr__nfet_01v8 L=0.15 W=1 nf=1 ad=0.29 as=0.29 pd=2.58 ps=2.58 mult=1 m=1
XMN2_refw ref_refw rbl_refw vn_refw 0 sky130_fd_pr__nfet_01v8 L=0.15 W=1 nf=1 ad=0.29 as=0.29 pd=2.58 ps=2.58 mult=1 m=1
XMP1_refw rbl_refw ref_refw vp_refw vdd sky130_fd_pr__pfet_01v8 L=0.15 W=2 nf=1 ad=0.58 as=0.58 pd=4.58 ps=4.58 mult=1 m=1
XMP2_refw ref_refw rbl_refw vp_refw vdd sky130_fd_pr__pfet_01v8 L=0.15 W=2 nf=1 ad=0.58 as=0.58 pd=4.58 ps=4.58 mult=1 m=1
XMNF_refw vn_refw en_refw 0 0 sky130_fd_pr__nfet_01v8 L=0.15 W=2 nf=1 ad=0.58 as=0.58 pd=4.58 ps=4.58 mult=1 m=1
XMPH_refw vp_refw enb_refw vdd vdd sky130_fd_pr__pfet_01v8 L=0.15 W=4 nf=1 ad=1.16 as=1.16 pd=8.58 ps=8.58 mult=1 m=1
bd_refw d_refw 0 v=v(rbl_refw)-v(ref_refw)

* initial conditions (tran uic)
.ic v(wbl_op1_0900_baseline_analog)=0 v(rbl_op1_0900_baseline_analog)=1.8 v(ref_op1_0900_baseline_analog)=0 v(sn_op1_0900_baseline_analog_0)=0.9 v(sn_op1_0900_baseline_analog_1)=0.9 v(sn_op1_0900_baseline_analog_2)=0.9
.ic v(sn_op1_0900_baseline_analog_3)=0.9 v(vn_op1_0900_baseline_analog)=0.45 v(vp_op1_0900_baseline_analog)=1.35 v(wbl_op1_1000_baseline_analog)=0 v(rbl_op1_1000_baseline_analog)=1.8 v(ref_op1_1000_baseline_analog)=0
.ic v(sn_op1_1000_baseline_analog_0)=1 v(sn_op1_1000_baseline_analog_1)=1 v(sn_op1_1000_baseline_analog_2)=1 v(sn_op1_1000_baseline_analog_3)=1 v(vn_op1_1000_baseline_analog)=0.45 v(vp_op1_1000_baseline_analog)=1.35
.ic v(wbl_op0_n100_baseline_analog)=0 v(rbl_op0_n100_baseline_analog)=1.8 v(ref_op0_n100_baseline_analog)=0 v(sn_op0_n100_baseline_analog_0)=-0.1 v(sn_op0_n100_baseline_analog_1)=-0.1 v(sn_op0_n100_baseline_analog_2)=-0.1
.ic v(sn_op0_n100_baseline_analog_3)=-0.1 v(vn_op0_n100_baseline_analog)=0.45 v(vp_op0_n100_baseline_analog)=1.35 v(wbl_op0_0000_baseline_analog)=0 v(rbl_op0_0000_baseline_analog)=1.8 v(ref_op0_0000_baseline_analog)=0
.ic v(sn_op0_0000_baseline_analog_0)=0 v(sn_op0_0000_baseline_analog_1)=0 v(sn_op0_0000_baseline_analog_2)=0 v(sn_op0_0000_baseline_analog_3)=0 v(vn_op0_0000_baseline_analog)=0.45 v(vp_op0_0000_baseline_analog)=1.35
.ic v(wbl_op1_0900_rtl_hold)=0 v(rbl_op1_0900_rtl_hold)=1.8 v(ref_op1_0900_rtl_hold)=0 v(sn_op1_0900_rtl_hold_0)=0.9 v(sn_op1_0900_rtl_hold_1)=0.9 v(sn_op1_0900_rtl_hold_2)=0.9
.ic v(sn_op1_0900_rtl_hold_3)=0.9 v(vn_op1_0900_rtl_hold)=0.45 v(vp_op1_0900_rtl_hold)=1.35 v(wbl_op1_1000_rtl_hold)=0 v(rbl_op1_1000_rtl_hold)=1.8 v(ref_op1_1000_rtl_hold)=0
.ic v(sn_op1_1000_rtl_hold_0)=1 v(sn_op1_1000_rtl_hold_1)=1 v(sn_op1_1000_rtl_hold_2)=1 v(sn_op1_1000_rtl_hold_3)=1 v(vn_op1_1000_rtl_hold)=0.45 v(vp_op1_1000_rtl_hold)=1.35
.ic v(wbl_op0_n100_rtl_hold)=0 v(rbl_op0_n100_rtl_hold)=1.8 v(ref_op0_n100_rtl_hold)=0 v(sn_op0_n100_rtl_hold_0)=-0.1 v(sn_op0_n100_rtl_hold_1)=-0.1 v(sn_op0_n100_rtl_hold_2)=-0.1
.ic v(sn_op0_n100_rtl_hold_3)=-0.1 v(vn_op0_n100_rtl_hold)=0.45 v(vp_op0_n100_rtl_hold)=1.35 v(wbl_op0_0000_rtl_hold)=0 v(rbl_op0_0000_rtl_hold)=1.8 v(ref_op0_0000_rtl_hold)=0
.ic v(sn_op0_0000_rtl_hold_0)=0 v(sn_op0_0000_rtl_hold_1)=0 v(sn_op0_0000_rtl_hold_2)=0 v(sn_op0_0000_rtl_hold_3)=0 v(vn_op0_0000_rtl_hold)=0.45 v(vp_op0_0000_rtl_hold)=1.35
.ic v(wbl_op1_0900_rwl_late_hold)=0 v(rbl_op1_0900_rwl_late_hold)=1.8 v(ref_op1_0900_rwl_late_hold)=0 v(sn_op1_0900_rwl_late_hold_0)=0.9 v(sn_op1_0900_rwl_late_hold_1)=0.9 v(sn_op1_0900_rwl_late_hold_2)=0.9
.ic v(sn_op1_0900_rwl_late_hold_3)=0.9 v(vn_op1_0900_rwl_late_hold)=0.45 v(vp_op1_0900_rwl_late_hold)=1.35 v(wbl_op1_1000_rwl_late_hold)=0 v(rbl_op1_1000_rwl_late_hold)=1.8 v(ref_op1_1000_rwl_late_hold)=0
.ic v(sn_op1_1000_rwl_late_hold_0)=1 v(sn_op1_1000_rwl_late_hold_1)=1 v(sn_op1_1000_rwl_late_hold_2)=1 v(sn_op1_1000_rwl_late_hold_3)=1 v(vn_op1_1000_rwl_late_hold)=0.45 v(vp_op1_1000_rwl_late_hold)=1.35
.ic v(wbl_op0_n100_rwl_late_hold)=0 v(rbl_op0_n100_rwl_late_hold)=1.8 v(ref_op0_n100_rwl_late_hold)=0 v(sn_op0_n100_rwl_late_hold_0)=-0.1 v(sn_op0_n100_rwl_late_hold_1)=-0.1 v(sn_op0_n100_rwl_late_hold_2)=-0.1
.ic v(sn_op0_n100_rwl_late_hold_3)=-0.1 v(vn_op0_n100_rwl_late_hold)=0.45 v(vp_op0_n100_rwl_late_hold)=1.35 v(wbl_op0_0000_rwl_late_hold)=0 v(rbl_op0_0000_rwl_late_hold)=1.8 v(ref_op0_0000_rwl_late_hold)=0
.ic v(sn_op0_0000_rwl_late_hold_0)=0 v(sn_op0_0000_rwl_late_hold_1)=0 v(sn_op0_0000_rwl_late_hold_2)=0 v(sn_op0_0000_rwl_late_hold_3)=0 v(vn_op0_0000_rwl_late_hold)=0.45 v(vp_op0_0000_rwl_late_hold)=1.35
.ic v(wbl_op1_0900_neg_missing_wb)=0 v(rbl_op1_0900_neg_missing_wb)=1.8 v(ref_op1_0900_neg_missing_wb)=0 v(sn_op1_0900_neg_missing_wb_0)=0.9 v(sn_op1_0900_neg_missing_wb_1)=0.9 v(sn_op1_0900_neg_missing_wb_2)=0.9
.ic v(sn_op1_0900_neg_missing_wb_3)=0.9 v(vn_op1_0900_neg_missing_wb)=0.45 v(vp_op1_0900_neg_missing_wb)=1.35 v(wbl_op1_1000_neg_missing_wb)=0 v(rbl_op1_1000_neg_missing_wb)=1.8 v(ref_op1_1000_neg_missing_wb)=0
.ic v(sn_op1_1000_neg_missing_wb_0)=1 v(sn_op1_1000_neg_missing_wb_1)=1 v(sn_op1_1000_neg_missing_wb_2)=1 v(sn_op1_1000_neg_missing_wb_3)=1 v(vn_op1_1000_neg_missing_wb)=0.45 v(vp_op1_1000_neg_missing_wb)=1.35
.ic v(wbl_op0_n100_neg_missing_wb)=0 v(rbl_op0_n100_neg_missing_wb)=1.8 v(ref_op0_n100_neg_missing_wb)=0 v(sn_op0_n100_neg_missing_wb_0)=-0.1 v(sn_op0_n100_neg_missing_wb_1)=-0.1 v(sn_op0_n100_neg_missing_wb_2)=-0.1
.ic v(sn_op0_n100_neg_missing_wb_3)=-0.1 v(vn_op0_n100_neg_missing_wb)=0.45 v(vp_op0_n100_neg_missing_wb)=1.35 v(wbl_op0_0000_neg_missing_wb)=0 v(rbl_op0_0000_neg_missing_wb)=1.8 v(ref_op0_0000_neg_missing_wb)=0
.ic v(sn_op0_0000_neg_missing_wb_0)=0 v(sn_op0_0000_neg_missing_wb_1)=0 v(sn_op0_0000_neg_missing_wb_2)=0 v(sn_op0_0000_neg_missing_wb_3)=0 v(vn_op0_0000_neg_missing_wb)=0.45 v(vp_op0_0000_neg_missing_wb)=1.35
.ic v(wbl_op1_0900_pic_baseline_analog)=0 v(rbl_op1_0900_pic_baseline_analog)=1.8 v(ref_op1_0900_pic_baseline_analog)=0 v(sn_op1_0900_pic_baseline_analog_0)=0.9 v(sn_op1_0900_pic_baseline_analog_1)=0.9 v(sn_op1_0900_pic_baseline_analog_2)=0.9
.ic v(sn_op1_0900_pic_baseline_analog_3)=0.9 v(vn_op1_0900_pic_baseline_analog)=0.45 v(vp_op1_0900_pic_baseline_analog)=1.35 v(wbl_op1_1000_pic_baseline_analog)=0 v(rbl_op1_1000_pic_baseline_analog)=1.8 v(ref_op1_1000_pic_baseline_analog)=0
.ic v(sn_op1_1000_pic_baseline_analog_0)=1 v(sn_op1_1000_pic_baseline_analog_1)=1 v(sn_op1_1000_pic_baseline_analog_2)=1 v(sn_op1_1000_pic_baseline_analog_3)=1 v(vn_op1_1000_pic_baseline_analog)=0.45 v(vp_op1_1000_pic_baseline_analog)=1.35
.ic v(wbl_op0_n100_pic_baseline_analog)=0 v(rbl_op0_n100_pic_baseline_analog)=1.8 v(ref_op0_n100_pic_baseline_analog)=0 v(sn_op0_n100_pic_baseline_analog_0)=-0.1 v(sn_op0_n100_pic_baseline_analog_1)=-0.1 v(sn_op0_n100_pic_baseline_analog_2)=-0.1
.ic v(sn_op0_n100_pic_baseline_analog_3)=-0.1 v(vn_op0_n100_pic_baseline_analog)=0.45 v(vp_op0_n100_pic_baseline_analog)=1.35 v(wbl_op0_0000_pic_baseline_analog)=0 v(rbl_op0_0000_pic_baseline_analog)=1.8 v(ref_op0_0000_pic_baseline_analog)=0
.ic v(sn_op0_0000_pic_baseline_analog_0)=0 v(sn_op0_0000_pic_baseline_analog_1)=0 v(sn_op0_0000_pic_baseline_analog_2)=0 v(sn_op0_0000_pic_baseline_analog_3)=0 v(vn_op0_0000_pic_baseline_analog)=0.45 v(vp_op0_0000_pic_baseline_analog)=1.35
.ic v(wbl_op1_0900_pic_rtl_hold)=0 v(rbl_op1_0900_pic_rtl_hold)=1.8 v(ref_op1_0900_pic_rtl_hold)=0 v(sn_op1_0900_pic_rtl_hold_0)=0.9 v(sn_op1_0900_pic_rtl_hold_1)=0.9 v(sn_op1_0900_pic_rtl_hold_2)=0.9
.ic v(sn_op1_0900_pic_rtl_hold_3)=0.9 v(vn_op1_0900_pic_rtl_hold)=0.45 v(vp_op1_0900_pic_rtl_hold)=1.35 v(wbl_op1_1000_pic_rtl_hold)=0 v(rbl_op1_1000_pic_rtl_hold)=1.8 v(ref_op1_1000_pic_rtl_hold)=0
.ic v(sn_op1_1000_pic_rtl_hold_0)=1 v(sn_op1_1000_pic_rtl_hold_1)=1 v(sn_op1_1000_pic_rtl_hold_2)=1 v(sn_op1_1000_pic_rtl_hold_3)=1 v(vn_op1_1000_pic_rtl_hold)=0.45 v(vp_op1_1000_pic_rtl_hold)=1.35
.ic v(wbl_op0_n100_pic_rtl_hold)=0 v(rbl_op0_n100_pic_rtl_hold)=1.8 v(ref_op0_n100_pic_rtl_hold)=0 v(sn_op0_n100_pic_rtl_hold_0)=-0.1 v(sn_op0_n100_pic_rtl_hold_1)=-0.1 v(sn_op0_n100_pic_rtl_hold_2)=-0.1
.ic v(sn_op0_n100_pic_rtl_hold_3)=-0.1 v(vn_op0_n100_pic_rtl_hold)=0.45 v(vp_op0_n100_pic_rtl_hold)=1.35 v(wbl_op0_0000_pic_rtl_hold)=0 v(rbl_op0_0000_pic_rtl_hold)=1.8 v(ref_op0_0000_pic_rtl_hold)=0
.ic v(sn_op0_0000_pic_rtl_hold_0)=0 v(sn_op0_0000_pic_rtl_hold_1)=0 v(sn_op0_0000_pic_rtl_hold_2)=0 v(sn_op0_0000_pic_rtl_hold_3)=0 v(vn_op0_0000_pic_rtl_hold)=0.45 v(vp_op0_0000_pic_rtl_hold)=1.35
.ic v(wbl_op1_0900_pic_rwl_late_hold)=0 v(rbl_op1_0900_pic_rwl_late_hold)=1.8 v(ref_op1_0900_pic_rwl_late_hold)=0 v(sn_op1_0900_pic_rwl_late_hold_0)=0.9 v(sn_op1_0900_pic_rwl_late_hold_1)=0.9 v(sn_op1_0900_pic_rwl_late_hold_2)=0.9
.ic v(sn_op1_0900_pic_rwl_late_hold_3)=0.9 v(vn_op1_0900_pic_rwl_late_hold)=0.45 v(vp_op1_0900_pic_rwl_late_hold)=1.35 v(wbl_op1_1000_pic_rwl_late_hold)=0 v(rbl_op1_1000_pic_rwl_late_hold)=1.8 v(ref_op1_1000_pic_rwl_late_hold)=0
.ic v(sn_op1_1000_pic_rwl_late_hold_0)=1 v(sn_op1_1000_pic_rwl_late_hold_1)=1 v(sn_op1_1000_pic_rwl_late_hold_2)=1 v(sn_op1_1000_pic_rwl_late_hold_3)=1 v(vn_op1_1000_pic_rwl_late_hold)=0.45 v(vp_op1_1000_pic_rwl_late_hold)=1.35
.ic v(wbl_op0_n100_pic_rwl_late_hold)=0 v(rbl_op0_n100_pic_rwl_late_hold)=1.8 v(ref_op0_n100_pic_rwl_late_hold)=0 v(sn_op0_n100_pic_rwl_late_hold_0)=-0.1 v(sn_op0_n100_pic_rwl_late_hold_1)=-0.1 v(sn_op0_n100_pic_rwl_late_hold_2)=-0.1
.ic v(sn_op0_n100_pic_rwl_late_hold_3)=-0.1 v(vn_op0_n100_pic_rwl_late_hold)=0.45 v(vp_op0_n100_pic_rwl_late_hold)=1.35 v(wbl_op0_0000_pic_rwl_late_hold)=0 v(rbl_op0_0000_pic_rwl_late_hold)=1.8 v(ref_op0_0000_pic_rwl_late_hold)=0
.ic v(sn_op0_0000_pic_rwl_late_hold_0)=0 v(sn_op0_0000_pic_rwl_late_hold_1)=0 v(sn_op0_0000_pic_rwl_late_hold_2)=0 v(sn_op0_0000_pic_rwl_late_hold_3)=0 v(vn_op0_0000_pic_rwl_late_hold)=0.45 v(vp_op0_0000_pic_rwl_late_hold)=1.35
.ic v(wbl_op1_0900_pic_neg_missing_wb)=0 v(rbl_op1_0900_pic_neg_missing_wb)=1.8 v(ref_op1_0900_pic_neg_missing_wb)=0 v(sn_op1_0900_pic_neg_missing_wb_0)=0.9 v(sn_op1_0900_pic_neg_missing_wb_1)=0.9 v(sn_op1_0900_pic_neg_missing_wb_2)=0.9
.ic v(sn_op1_0900_pic_neg_missing_wb_3)=0.9 v(vn_op1_0900_pic_neg_missing_wb)=0.45 v(vp_op1_0900_pic_neg_missing_wb)=1.35 v(wbl_op1_1000_pic_neg_missing_wb)=0 v(rbl_op1_1000_pic_neg_missing_wb)=1.8 v(ref_op1_1000_pic_neg_missing_wb)=0
.ic v(sn_op1_1000_pic_neg_missing_wb_0)=1 v(sn_op1_1000_pic_neg_missing_wb_1)=1 v(sn_op1_1000_pic_neg_missing_wb_2)=1 v(sn_op1_1000_pic_neg_missing_wb_3)=1 v(vn_op1_1000_pic_neg_missing_wb)=0.45 v(vp_op1_1000_pic_neg_missing_wb)=1.35
.ic v(wbl_op0_n100_pic_neg_missing_wb)=0 v(rbl_op0_n100_pic_neg_missing_wb)=1.8 v(ref_op0_n100_pic_neg_missing_wb)=0 v(sn_op0_n100_pic_neg_missing_wb_0)=-0.1 v(sn_op0_n100_pic_neg_missing_wb_1)=-0.1 v(sn_op0_n100_pic_neg_missing_wb_2)=-0.1
.ic v(sn_op0_n100_pic_neg_missing_wb_3)=-0.1 v(vn_op0_n100_pic_neg_missing_wb)=0.45 v(vp_op0_n100_pic_neg_missing_wb)=1.35 v(wbl_op0_0000_pic_neg_missing_wb)=0 v(rbl_op0_0000_pic_neg_missing_wb)=1.8 v(ref_op0_0000_pic_neg_missing_wb)=0
.ic v(sn_op0_0000_pic_neg_missing_wb_0)=0 v(sn_op0_0000_pic_neg_missing_wb_1)=0 v(sn_op0_0000_pic_neg_missing_wb_2)=0 v(sn_op0_0000_pic_neg_missing_wb_3)=0 v(vn_op0_0000_pic_neg_missing_wb)=0.45 v(vp_op0_0000_pic_neg_missing_wb)=1.35
.ic v(wbl_op1_0900_pw_baseline_analog)=0 v(rbl_op1_0900_pw_baseline_analog)=1.8 v(ref_op1_0900_pw_baseline_analog)=0 v(sn_op1_0900_pw_baseline_analog_0)=0 v(sn_op1_0900_pw_baseline_analog_1)=0.9 v(sn_op1_0900_pw_baseline_analog_2)=0.9
.ic v(sn_op1_0900_pw_baseline_analog_3)=0.9 v(vn_op1_0900_pw_baseline_analog)=0.45 v(vp_op1_0900_pw_baseline_analog)=1.35 v(wbl_op1_1000_pw_baseline_analog)=0 v(rbl_op1_1000_pw_baseline_analog)=1.8 v(ref_op1_1000_pw_baseline_analog)=0
.ic v(sn_op1_1000_pw_baseline_analog_0)=0 v(sn_op1_1000_pw_baseline_analog_1)=1 v(sn_op1_1000_pw_baseline_analog_2)=1 v(sn_op1_1000_pw_baseline_analog_3)=1 v(vn_op1_1000_pw_baseline_analog)=0.45 v(vp_op1_1000_pw_baseline_analog)=1.35
.ic v(wbl_op0_n100_pw_baseline_analog)=0 v(rbl_op0_n100_pw_baseline_analog)=1.8 v(ref_op0_n100_pw_baseline_analog)=0 v(sn_op0_n100_pw_baseline_analog_0)=1.2 v(sn_op0_n100_pw_baseline_analog_1)=-0.1 v(sn_op0_n100_pw_baseline_analog_2)=-0.1
.ic v(sn_op0_n100_pw_baseline_analog_3)=-0.1 v(vn_op0_n100_pw_baseline_analog)=0.45 v(vp_op0_n100_pw_baseline_analog)=1.35 v(wbl_op0_0000_pw_baseline_analog)=0 v(rbl_op0_0000_pw_baseline_analog)=1.8 v(ref_op0_0000_pw_baseline_analog)=0
.ic v(sn_op0_0000_pw_baseline_analog_0)=1.2 v(sn_op0_0000_pw_baseline_analog_1)=0 v(sn_op0_0000_pw_baseline_analog_2)=0 v(sn_op0_0000_pw_baseline_analog_3)=0 v(vn_op0_0000_pw_baseline_analog)=0.45 v(vp_op0_0000_pw_baseline_analog)=1.35
.ic v(wbl_op1_0900_pw_rtl_hold)=0 v(rbl_op1_0900_pw_rtl_hold)=1.8 v(ref_op1_0900_pw_rtl_hold)=0 v(sn_op1_0900_pw_rtl_hold_0)=0 v(sn_op1_0900_pw_rtl_hold_1)=0.9 v(sn_op1_0900_pw_rtl_hold_2)=0.9
.ic v(sn_op1_0900_pw_rtl_hold_3)=0.9 v(vn_op1_0900_pw_rtl_hold)=0.45 v(vp_op1_0900_pw_rtl_hold)=1.35 v(wbl_op1_1000_pw_rtl_hold)=0 v(rbl_op1_1000_pw_rtl_hold)=1.8 v(ref_op1_1000_pw_rtl_hold)=0
.ic v(sn_op1_1000_pw_rtl_hold_0)=0 v(sn_op1_1000_pw_rtl_hold_1)=1 v(sn_op1_1000_pw_rtl_hold_2)=1 v(sn_op1_1000_pw_rtl_hold_3)=1 v(vn_op1_1000_pw_rtl_hold)=0.45 v(vp_op1_1000_pw_rtl_hold)=1.35
.ic v(wbl_op0_n100_pw_rtl_hold)=0 v(rbl_op0_n100_pw_rtl_hold)=1.8 v(ref_op0_n100_pw_rtl_hold)=0 v(sn_op0_n100_pw_rtl_hold_0)=1.2 v(sn_op0_n100_pw_rtl_hold_1)=-0.1 v(sn_op0_n100_pw_rtl_hold_2)=-0.1
.ic v(sn_op0_n100_pw_rtl_hold_3)=-0.1 v(vn_op0_n100_pw_rtl_hold)=0.45 v(vp_op0_n100_pw_rtl_hold)=1.35 v(wbl_op0_0000_pw_rtl_hold)=0 v(rbl_op0_0000_pw_rtl_hold)=1.8 v(ref_op0_0000_pw_rtl_hold)=0
.ic v(sn_op0_0000_pw_rtl_hold_0)=1.2 v(sn_op0_0000_pw_rtl_hold_1)=0 v(sn_op0_0000_pw_rtl_hold_2)=0 v(sn_op0_0000_pw_rtl_hold_3)=0 v(vn_op0_0000_pw_rtl_hold)=0.45 v(vp_op0_0000_pw_rtl_hold)=1.35
.ic v(wbl_op1_0900_pw_rwl_late_hold)=0 v(rbl_op1_0900_pw_rwl_late_hold)=1.8 v(ref_op1_0900_pw_rwl_late_hold)=0 v(sn_op1_0900_pw_rwl_late_hold_0)=0 v(sn_op1_0900_pw_rwl_late_hold_1)=0.9 v(sn_op1_0900_pw_rwl_late_hold_2)=0.9
.ic v(sn_op1_0900_pw_rwl_late_hold_3)=0.9 v(vn_op1_0900_pw_rwl_late_hold)=0.45 v(vp_op1_0900_pw_rwl_late_hold)=1.35 v(wbl_op1_1000_pw_rwl_late_hold)=0 v(rbl_op1_1000_pw_rwl_late_hold)=1.8 v(ref_op1_1000_pw_rwl_late_hold)=0
.ic v(sn_op1_1000_pw_rwl_late_hold_0)=0 v(sn_op1_1000_pw_rwl_late_hold_1)=1 v(sn_op1_1000_pw_rwl_late_hold_2)=1 v(sn_op1_1000_pw_rwl_late_hold_3)=1 v(vn_op1_1000_pw_rwl_late_hold)=0.45 v(vp_op1_1000_pw_rwl_late_hold)=1.35
.ic v(wbl_op0_n100_pw_rwl_late_hold)=0 v(rbl_op0_n100_pw_rwl_late_hold)=1.8 v(ref_op0_n100_pw_rwl_late_hold)=0 v(sn_op0_n100_pw_rwl_late_hold_0)=1.2 v(sn_op0_n100_pw_rwl_late_hold_1)=-0.1 v(sn_op0_n100_pw_rwl_late_hold_2)=-0.1
.ic v(sn_op0_n100_pw_rwl_late_hold_3)=-0.1 v(vn_op0_n100_pw_rwl_late_hold)=0.45 v(vp_op0_n100_pw_rwl_late_hold)=1.35 v(wbl_op0_0000_pw_rwl_late_hold)=0 v(rbl_op0_0000_pw_rwl_late_hold)=1.8 v(ref_op0_0000_pw_rwl_late_hold)=0
.ic v(sn_op0_0000_pw_rwl_late_hold_0)=1.2 v(sn_op0_0000_pw_rwl_late_hold_1)=0 v(sn_op0_0000_pw_rwl_late_hold_2)=0 v(sn_op0_0000_pw_rwl_late_hold_3)=0 v(vn_op0_0000_pw_rwl_late_hold)=0.45 v(vp_op0_0000_pw_rwl_late_hold)=1.35
.ic v(wbl_op1_0900_pw_neg_missing_wb)=0 v(rbl_op1_0900_pw_neg_missing_wb)=1.8 v(ref_op1_0900_pw_neg_missing_wb)=0 v(sn_op1_0900_pw_neg_missing_wb_0)=0 v(sn_op1_0900_pw_neg_missing_wb_1)=0.9 v(sn_op1_0900_pw_neg_missing_wb_2)=0.9
.ic v(sn_op1_0900_pw_neg_missing_wb_3)=0.9 v(vn_op1_0900_pw_neg_missing_wb)=0.45 v(vp_op1_0900_pw_neg_missing_wb)=1.35 v(wbl_op1_1000_pw_neg_missing_wb)=0 v(rbl_op1_1000_pw_neg_missing_wb)=1.8 v(ref_op1_1000_pw_neg_missing_wb)=0
.ic v(sn_op1_1000_pw_neg_missing_wb_0)=0 v(sn_op1_1000_pw_neg_missing_wb_1)=1 v(sn_op1_1000_pw_neg_missing_wb_2)=1 v(sn_op1_1000_pw_neg_missing_wb_3)=1 v(vn_op1_1000_pw_neg_missing_wb)=0.45 v(vp_op1_1000_pw_neg_missing_wb)=1.35
.ic v(wbl_op0_n100_pw_neg_missing_wb)=0 v(rbl_op0_n100_pw_neg_missing_wb)=1.8 v(ref_op0_n100_pw_neg_missing_wb)=0 v(sn_op0_n100_pw_neg_missing_wb_0)=1.2 v(sn_op0_n100_pw_neg_missing_wb_1)=-0.1 v(sn_op0_n100_pw_neg_missing_wb_2)=-0.1
.ic v(sn_op0_n100_pw_neg_missing_wb_3)=-0.1 v(vn_op0_n100_pw_neg_missing_wb)=0.45 v(vp_op0_n100_pw_neg_missing_wb)=1.35 v(wbl_op0_0000_pw_neg_missing_wb)=0 v(rbl_op0_0000_pw_neg_missing_wb)=1.8 v(ref_op0_0000_pw_neg_missing_wb)=0
.ic v(sn_op0_0000_pw_neg_missing_wb_0)=1.2 v(sn_op0_0000_pw_neg_missing_wb_1)=0 v(sn_op0_0000_pw_neg_missing_wb_2)=0 v(sn_op0_0000_pw_neg_missing_wb_3)=0 v(vn_op0_0000_pw_neg_missing_wb)=0.45 v(vp_op0_0000_pw_neg_missing_wb)=1.35
.ic v(wbl_op1_0900_pwnw_rwl_late_hold)=0 v(rbl_op1_0900_pwnw_rwl_late_hold)=1.8 v(ref_op1_0900_pwnw_rwl_late_hold)=0 v(sn_op1_0900_pwnw_rwl_late_hold_0)=0 v(sn_op1_0900_pwnw_rwl_late_hold_1)=0.9 v(sn_op1_0900_pwnw_rwl_late_hold_2)=0.9
.ic v(sn_op1_0900_pwnw_rwl_late_hold_3)=0.9 v(vn_op1_0900_pwnw_rwl_late_hold)=0.45 v(vp_op1_0900_pwnw_rwl_late_hold)=1.35 v(wbl_op1_1000_pwnw_rwl_late_hold)=0 v(rbl_op1_1000_pwnw_rwl_late_hold)=1.8 v(ref_op1_1000_pwnw_rwl_late_hold)=0
.ic v(sn_op1_1000_pwnw_rwl_late_hold_0)=0 v(sn_op1_1000_pwnw_rwl_late_hold_1)=1 v(sn_op1_1000_pwnw_rwl_late_hold_2)=1 v(sn_op1_1000_pwnw_rwl_late_hold_3)=1 v(vn_op1_1000_pwnw_rwl_late_hold)=0.45 v(vp_op1_1000_pwnw_rwl_late_hold)=1.35
.ic v(wbl_op0_n100_pwnw_rwl_late_hold)=0 v(rbl_op0_n100_pwnw_rwl_late_hold)=1.8 v(ref_op0_n100_pwnw_rwl_late_hold)=0 v(sn_op0_n100_pwnw_rwl_late_hold_0)=1.2 v(sn_op0_n100_pwnw_rwl_late_hold_1)=-0.1 v(sn_op0_n100_pwnw_rwl_late_hold_2)=-0.1
.ic v(sn_op0_n100_pwnw_rwl_late_hold_3)=-0.1 v(vn_op0_n100_pwnw_rwl_late_hold)=0.45 v(vp_op0_n100_pwnw_rwl_late_hold)=1.35 v(wbl_op0_0000_pwnw_rwl_late_hold)=0 v(rbl_op0_0000_pwnw_rwl_late_hold)=1.8 v(ref_op0_0000_pwnw_rwl_late_hold)=0
.ic v(sn_op0_0000_pwnw_rwl_late_hold_0)=1.2 v(sn_op0_0000_pwnw_rwl_late_hold_1)=0 v(sn_op0_0000_pwnw_rwl_late_hold_2)=0 v(sn_op0_0000_pwnw_rwl_late_hold_3)=0 v(vn_op0_0000_pwnw_rwl_late_hold)=0.45 v(vp_op0_0000_pwnw_rwl_late_hold)=1.35
.ic v(wbl_refw)=1.8 v(rbl_refw)=1.8 v(ref_refw)=0 v(sn_refw_0)=0 v(sn_refw_1)=0 v(sn_refw_2)=0
.ic v(sn_refw_3)=0 v(vn_refw)=0.45 v(vp_refw)=1.35
* explicit idle-high RWL pin initial conditions (pin_ic and physical regimes ONLY; legacy has none)
.ic v(rwls_op1_0900_pic_baseline_analog)=1.8 v(rwls_op1_1000_pic_baseline_analog)=1.8 v(rwls_op0_n100_pic_baseline_analog)=1.8 v(rwls_op0_0000_pic_baseline_analog)=1.8
.ic v(rwls_op1_0900_pic_rtl_hold)=1.8 v(rwls_op1_1000_pic_rtl_hold)=1.8 v(rwls_op0_n100_pic_rtl_hold)=1.8 v(rwls_op0_0000_pic_rtl_hold)=1.8
.ic v(rwls_op1_0900_pic_rwl_late_hold)=1.8 v(rwls_op1_1000_pic_rwl_late_hold)=1.8 v(rwls_op0_n100_pic_rwl_late_hold)=1.8 v(rwls_op0_0000_pic_rwl_late_hold)=1.8
.ic v(rwls_op1_0900_pic_neg_missing_wb)=1.8 v(rwls_op1_1000_pic_neg_missing_wb)=1.8 v(rwls_op0_n100_pic_neg_missing_wb)=1.8 v(rwls_op0_0000_pic_neg_missing_wb)=1.8
.ic v(rwls_op1_0900_pw_baseline_analog)=1.8 v(rwls_op1_1000_pw_baseline_analog)=1.8 v(rwls_op0_n100_pw_baseline_analog)=1.8 v(rwls_op0_0000_pw_baseline_analog)=1.8
.ic v(rwls_op1_0900_pw_rtl_hold)=1.8 v(rwls_op1_1000_pw_rtl_hold)=1.8 v(rwls_op0_n100_pw_rtl_hold)=1.8 v(rwls_op0_0000_pw_rtl_hold)=1.8
.ic v(rwls_op1_0900_pw_rwl_late_hold)=1.8 v(rwls_op1_1000_pw_rwl_late_hold)=1.8 v(rwls_op0_n100_pw_rwl_late_hold)=1.8 v(rwls_op0_0000_pw_rwl_late_hold)=1.8
.ic v(rwls_op1_0900_pw_neg_missing_wb)=1.8 v(rwls_op1_1000_pw_neg_missing_wb)=1.8 v(rwls_op0_n100_pw_neg_missing_wb)=1.8 v(rwls_op0_0000_pw_neg_missing_wb)=1.8
.ic v(rwls_op1_0900_pwnw_rwl_late_hold)=1.8 v(rwls_op1_1000_pwnw_rwl_late_hold)=1.8 v(rwls_op0_n100_pwnw_rwl_late_hold)=1.8 v(rwls_op0_0000_pwnw_rwl_late_hold)=1.8
