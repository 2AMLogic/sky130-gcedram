* GENERATED by sim/loaded-column/gen_column_requests.py -- DO NOT EDIT BY HAND.
* Loaded four-row 2T gain-cell column, re-qualification grid for issue #169.
* age=refresh_bound  selected_row=0  patterns=16 independent instances
* Circuit, stimulus and measurement instants come from
* sim/loaded-column/tb_loaded_column.spice.tmpl and run_loaded_column.py;
* the two device cards are copied verbatim from design/gain_cell_2t.spice
* (sha256:7d1fe877ee5a7789e5b6f4b29788e1ecd927112de99e3156ba246eb2dcb73ad5), re-sized only when a knob changes W.
* ALL timing / bias / loading below is a labelled ASSUMPTION -- see
* sim/loaded-column/README.md. Nothing here is a ratified spec value.
*
* Instance <tag> = one electrically independent 4-row column holding one
* stored pattern. Instances share only ideal voltage sources, so no
* instance loads another; vam_r<r>_<tag> is a 0 V ammeter in series with
* that cell's read-device rwl terminal (i_into_rbl = +i(vam)).

.param VDD = 1.8
.param VRBL = 0.9
.param TEDGE = 1.000000e-10
.param TW0 = 1.000000e-09
.param TWSTEP = 2.500000e-08
.param TWPULSE = 2.000000e-08
.param TBL_LAG = 2.000000e-09
.param THOLD0 = 1.000000e-07
.param TPRE_GAP = 2.000000e-09
.param TREAD_PULSE = 2.000000e-08
.param TTAIL = 5.000000e-09
.param T_READ = 5.050945000e-06
.param VWL = 1.8
.param VRWL_SEL = 0
.param C_RBL = 1.000000e-14
.param VSN1 = 0
.param DV_LAT = 0.1
.GLOBAL GND

* shared write wordlines (row r pulses at TW0 + r*TWSTEP)
vwl_0 wl_0 0 pulse(0 {VWL} {TW0+0*TWSTEP} {TEDGE} {TEDGE} {TWPULSE-TEDGE} 1)
vwl_1 wl_1 0 pulse(0 {VWL} {TW0+1*TWSTEP} {TEDGE} {TEDGE} {TWPULSE-TEDGE} 1)
vwl_2 wl_2 0 pulse(0 {VWL} {TW0+2*TWSTEP} {TEDGE} {TEDGE} {TWPULSE-TEDGE} 1)
vwl_3 wl_3 0 pulse(0 {VWL} {TW0+3*TWSTEP} {TEDGE} {TEDGE} {TWPULSE-TEDGE} 1)

* shared read wordlines: row 0 is the selected row and falls to VRWL_SEL
vrwl_0 rwl_0 0 pwl(0 {VDD} {T_READ} {VDD} {T_READ+TEDGE} {VRWL_SEL} {T_READ+TREAD_PULSE} {VRWL_SEL} {T_READ+TREAD_PULSE+TEDGE} {VDD})
vrwl_1 rwl_1 0 pwl(0 {VDD} {T_READ} {VDD} {T_READ+TEDGE} {VDD} {T_READ+TREAD_PULSE} {VDD} {T_READ+TREAD_PULSE+TEDGE} {VDD})
vrwl_2 rwl_2 0 pwl(0 {VDD} {T_READ} {VDD} {T_READ+TEDGE} {VDD} {T_READ+TREAD_PULSE} {VDD} {T_READ+TREAD_PULSE+TEDGE} {VDD})
vrwl_3 rwl_3 0 pwl(0 {VDD} {T_READ} {VDD} {T_READ+TEDGE} {VDD} {T_READ+TREAD_PULSE} {VDD} {T_READ+TREAD_PULSE+TEDGE} {VDD})

* shared precharge: ideal switch from a VRBL source, opened TPRE_GAP before the read
vpre pre 0 dc {VRBL}
vctl ctl 0 pwl(0 {VDD} {T_READ-TPRE_GAP} {VDD} {T_READ-TPRE_GAP+TEDGE} 0)
.model swpre sw(vt=0.9 vh=0.1 ron=100 roff=1e12)

* ---- instance p00: stored pattern rows3210=0000
v_bl_p00 bl_p00 0 pwl(0 0 {TW0+0*TWSTEP-TEDGE} 0 {TW0+0*TWSTEP} {VDD*0} {TW0+0*TWSTEP+TWPULSE+TBL_LAG} {VDD*0} {TW0+0*TWSTEP+TWPULSE+TBL_LAG+TEDGE} 0 {TW0+1*TWSTEP-TEDGE} 0 {TW0+1*TWSTEP} {VDD*0} {TW0+1*TWSTEP+TWPULSE+TBL_LAG} {VDD*0} {TW0+1*TWSTEP+TWPULSE+TBL_LAG+TEDGE} 0 {TW0+2*TWSTEP-TEDGE} 0 {TW0+2*TWSTEP} {VDD*0} {TW0+2*TWSTEP+TWPULSE+TBL_LAG} {VDD*0} {TW0+2*TWSTEP+TWPULSE+TBL_LAG+TEDGE} 0 {TW0+3*TWSTEP-TEDGE} 0 {TW0+3*TWSTEP} {VDD*0} {TW0+3*TWSTEP+TWPULSE+TBL_LAG} {VDD*0} {TW0+3*TWSTEP+TWPULSE+TBL_LAG+TEDGE} 0)
XM_WR_r0_p00 sn_r0_p00 wl_0 bl_p00 GND sky130_fd_pr__nfet_01v8 L=0.15 W=0.42 nf=1 ad=0.1218 as=0.1218 pd=1.42 ps=1.42 nrd=0.69047619047619  nrs=0.69047619047619 sa=0 sb=0 sd=0 mult=1 m=1
vam_r0_p00 rwl_0 rwlx_r0_p00 dc 0
XM_RD_r0_p00 rbl_p00 sn_r0_p00 rwlx_r0_p00 GND sky130_fd_pr__nfet_01v8 L=0.15 W=0.42 nf=1 ad=0.1218 as=0.1218 pd=1.42 ps=1.42 nrd=0.69047619047619  nrs=0.69047619047619 sa=0 sb=0 sd=0 mult=1 m=1
c_sn_r0_p00 sn_r0_p00 0 6.727410e-16
XM_WR_r1_p00 sn_r1_p00 wl_1 bl_p00 GND sky130_fd_pr__nfet_01v8 L=0.15 W=0.42 nf=1 ad=0.1218 as=0.1218 pd=1.42 ps=1.42 nrd=0.69047619047619  nrs=0.69047619047619 sa=0 sb=0 sd=0 mult=1 m=1
vam_r1_p00 rwl_1 rwlx_r1_p00 dc 0
XM_RD_r1_p00 rbl_p00 sn_r1_p00 rwlx_r1_p00 GND sky130_fd_pr__nfet_01v8 L=0.15 W=0.42 nf=1 ad=0.1218 as=0.1218 pd=1.42 ps=1.42 nrd=0.69047619047619  nrs=0.69047619047619 sa=0 sb=0 sd=0 mult=1 m=1
c_sn_r1_p00 sn_r1_p00 0 6.727410e-16
XM_WR_r2_p00 sn_r2_p00 wl_2 bl_p00 GND sky130_fd_pr__nfet_01v8 L=0.15 W=0.42 nf=1 ad=0.1218 as=0.1218 pd=1.42 ps=1.42 nrd=0.69047619047619  nrs=0.69047619047619 sa=0 sb=0 sd=0 mult=1 m=1
vam_r2_p00 rwl_2 rwlx_r2_p00 dc 0
XM_RD_r2_p00 rbl_p00 sn_r2_p00 rwlx_r2_p00 GND sky130_fd_pr__nfet_01v8 L=0.15 W=0.42 nf=1 ad=0.1218 as=0.1218 pd=1.42 ps=1.42 nrd=0.69047619047619  nrs=0.69047619047619 sa=0 sb=0 sd=0 mult=1 m=1
c_sn_r2_p00 sn_r2_p00 0 6.727410e-16
XM_WR_r3_p00 sn_r3_p00 wl_3 bl_p00 GND sky130_fd_pr__nfet_01v8 L=0.15 W=0.42 nf=1 ad=0.1218 as=0.1218 pd=1.42 ps=1.42 nrd=0.69047619047619  nrs=0.69047619047619 sa=0 sb=0 sd=0 mult=1 m=1
vam_r3_p00 rwl_3 rwlx_r3_p00 dc 0
XM_RD_r3_p00 rbl_p00 sn_r3_p00 rwlx_r3_p00 GND sky130_fd_pr__nfet_01v8 L=0.15 W=0.42 nf=1 ad=0.1218 as=0.1218 pd=1.42 ps=1.42 nrd=0.69047619047619  nrs=0.69047619047619 sa=0 sb=0 sd=0 mult=1 m=1
c_sn_r3_p00 sn_r3_p00 0 6.727410e-16
c_rbl_p00 rbl_p00 0 {C_RBL}
spre_p00 pre rbl_p00 ctl 0 swpre

* ---- instance p01: stored pattern rows3210=0001
v_bl_p01 bl_p01 0 pwl(0 0 {TW0+0*TWSTEP-TEDGE} 0 {TW0+0*TWSTEP} {VDD*1} {TW0+0*TWSTEP+TWPULSE+TBL_LAG} {VDD*1} {TW0+0*TWSTEP+TWPULSE+TBL_LAG+TEDGE} 0 {TW0+1*TWSTEP-TEDGE} 0 {TW0+1*TWSTEP} {VDD*0} {TW0+1*TWSTEP+TWPULSE+TBL_LAG} {VDD*0} {TW0+1*TWSTEP+TWPULSE+TBL_LAG+TEDGE} 0 {TW0+2*TWSTEP-TEDGE} 0 {TW0+2*TWSTEP} {VDD*0} {TW0+2*TWSTEP+TWPULSE+TBL_LAG} {VDD*0} {TW0+2*TWSTEP+TWPULSE+TBL_LAG+TEDGE} 0 {TW0+3*TWSTEP-TEDGE} 0 {TW0+3*TWSTEP} {VDD*0} {TW0+3*TWSTEP+TWPULSE+TBL_LAG} {VDD*0} {TW0+3*TWSTEP+TWPULSE+TBL_LAG+TEDGE} 0)
XM_WR_r0_p01 sn_r0_p01 wl_0 bl_p01 GND sky130_fd_pr__nfet_01v8 L=0.15 W=0.42 nf=1 ad=0.1218 as=0.1218 pd=1.42 ps=1.42 nrd=0.69047619047619  nrs=0.69047619047619 sa=0 sb=0 sd=0 mult=1 m=1
vam_r0_p01 rwl_0 rwlx_r0_p01 dc 0
XM_RD_r0_p01 rbl_p01 sn_r0_p01 rwlx_r0_p01 GND sky130_fd_pr__nfet_01v8 L=0.15 W=0.42 nf=1 ad=0.1218 as=0.1218 pd=1.42 ps=1.42 nrd=0.69047619047619  nrs=0.69047619047619 sa=0 sb=0 sd=0 mult=1 m=1
c_sn_r0_p01 sn_r0_p01 0 6.727410e-16
XM_WR_r1_p01 sn_r1_p01 wl_1 bl_p01 GND sky130_fd_pr__nfet_01v8 L=0.15 W=0.42 nf=1 ad=0.1218 as=0.1218 pd=1.42 ps=1.42 nrd=0.69047619047619  nrs=0.69047619047619 sa=0 sb=0 sd=0 mult=1 m=1
vam_r1_p01 rwl_1 rwlx_r1_p01 dc 0
XM_RD_r1_p01 rbl_p01 sn_r1_p01 rwlx_r1_p01 GND sky130_fd_pr__nfet_01v8 L=0.15 W=0.42 nf=1 ad=0.1218 as=0.1218 pd=1.42 ps=1.42 nrd=0.69047619047619  nrs=0.69047619047619 sa=0 sb=0 sd=0 mult=1 m=1
c_sn_r1_p01 sn_r1_p01 0 6.727410e-16
XM_WR_r2_p01 sn_r2_p01 wl_2 bl_p01 GND sky130_fd_pr__nfet_01v8 L=0.15 W=0.42 nf=1 ad=0.1218 as=0.1218 pd=1.42 ps=1.42 nrd=0.69047619047619  nrs=0.69047619047619 sa=0 sb=0 sd=0 mult=1 m=1
vam_r2_p01 rwl_2 rwlx_r2_p01 dc 0
XM_RD_r2_p01 rbl_p01 sn_r2_p01 rwlx_r2_p01 GND sky130_fd_pr__nfet_01v8 L=0.15 W=0.42 nf=1 ad=0.1218 as=0.1218 pd=1.42 ps=1.42 nrd=0.69047619047619  nrs=0.69047619047619 sa=0 sb=0 sd=0 mult=1 m=1
c_sn_r2_p01 sn_r2_p01 0 6.727410e-16
XM_WR_r3_p01 sn_r3_p01 wl_3 bl_p01 GND sky130_fd_pr__nfet_01v8 L=0.15 W=0.42 nf=1 ad=0.1218 as=0.1218 pd=1.42 ps=1.42 nrd=0.69047619047619  nrs=0.69047619047619 sa=0 sb=0 sd=0 mult=1 m=1
vam_r3_p01 rwl_3 rwlx_r3_p01 dc 0
XM_RD_r3_p01 rbl_p01 sn_r3_p01 rwlx_r3_p01 GND sky130_fd_pr__nfet_01v8 L=0.15 W=0.42 nf=1 ad=0.1218 as=0.1218 pd=1.42 ps=1.42 nrd=0.69047619047619  nrs=0.69047619047619 sa=0 sb=0 sd=0 mult=1 m=1
c_sn_r3_p01 sn_r3_p01 0 6.727410e-16
c_rbl_p01 rbl_p01 0 {C_RBL}
spre_p01 pre rbl_p01 ctl 0 swpre

* ---- instance p02: stored pattern rows3210=0010
v_bl_p02 bl_p02 0 pwl(0 0 {TW0+0*TWSTEP-TEDGE} 0 {TW0+0*TWSTEP} {VDD*0} {TW0+0*TWSTEP+TWPULSE+TBL_LAG} {VDD*0} {TW0+0*TWSTEP+TWPULSE+TBL_LAG+TEDGE} 0 {TW0+1*TWSTEP-TEDGE} 0 {TW0+1*TWSTEP} {VDD*1} {TW0+1*TWSTEP+TWPULSE+TBL_LAG} {VDD*1} {TW0+1*TWSTEP+TWPULSE+TBL_LAG+TEDGE} 0 {TW0+2*TWSTEP-TEDGE} 0 {TW0+2*TWSTEP} {VDD*0} {TW0+2*TWSTEP+TWPULSE+TBL_LAG} {VDD*0} {TW0+2*TWSTEP+TWPULSE+TBL_LAG+TEDGE} 0 {TW0+3*TWSTEP-TEDGE} 0 {TW0+3*TWSTEP} {VDD*0} {TW0+3*TWSTEP+TWPULSE+TBL_LAG} {VDD*0} {TW0+3*TWSTEP+TWPULSE+TBL_LAG+TEDGE} 0)
XM_WR_r0_p02 sn_r0_p02 wl_0 bl_p02 GND sky130_fd_pr__nfet_01v8 L=0.15 W=0.42 nf=1 ad=0.1218 as=0.1218 pd=1.42 ps=1.42 nrd=0.69047619047619  nrs=0.69047619047619 sa=0 sb=0 sd=0 mult=1 m=1
vam_r0_p02 rwl_0 rwlx_r0_p02 dc 0
XM_RD_r0_p02 rbl_p02 sn_r0_p02 rwlx_r0_p02 GND sky130_fd_pr__nfet_01v8 L=0.15 W=0.42 nf=1 ad=0.1218 as=0.1218 pd=1.42 ps=1.42 nrd=0.69047619047619  nrs=0.69047619047619 sa=0 sb=0 sd=0 mult=1 m=1
c_sn_r0_p02 sn_r0_p02 0 6.727410e-16
XM_WR_r1_p02 sn_r1_p02 wl_1 bl_p02 GND sky130_fd_pr__nfet_01v8 L=0.15 W=0.42 nf=1 ad=0.1218 as=0.1218 pd=1.42 ps=1.42 nrd=0.69047619047619  nrs=0.69047619047619 sa=0 sb=0 sd=0 mult=1 m=1
vam_r1_p02 rwl_1 rwlx_r1_p02 dc 0
XM_RD_r1_p02 rbl_p02 sn_r1_p02 rwlx_r1_p02 GND sky130_fd_pr__nfet_01v8 L=0.15 W=0.42 nf=1 ad=0.1218 as=0.1218 pd=1.42 ps=1.42 nrd=0.69047619047619  nrs=0.69047619047619 sa=0 sb=0 sd=0 mult=1 m=1
c_sn_r1_p02 sn_r1_p02 0 6.727410e-16
XM_WR_r2_p02 sn_r2_p02 wl_2 bl_p02 GND sky130_fd_pr__nfet_01v8 L=0.15 W=0.42 nf=1 ad=0.1218 as=0.1218 pd=1.42 ps=1.42 nrd=0.69047619047619  nrs=0.69047619047619 sa=0 sb=0 sd=0 mult=1 m=1
vam_r2_p02 rwl_2 rwlx_r2_p02 dc 0
XM_RD_r2_p02 rbl_p02 sn_r2_p02 rwlx_r2_p02 GND sky130_fd_pr__nfet_01v8 L=0.15 W=0.42 nf=1 ad=0.1218 as=0.1218 pd=1.42 ps=1.42 nrd=0.69047619047619  nrs=0.69047619047619 sa=0 sb=0 sd=0 mult=1 m=1
c_sn_r2_p02 sn_r2_p02 0 6.727410e-16
XM_WR_r3_p02 sn_r3_p02 wl_3 bl_p02 GND sky130_fd_pr__nfet_01v8 L=0.15 W=0.42 nf=1 ad=0.1218 as=0.1218 pd=1.42 ps=1.42 nrd=0.69047619047619  nrs=0.69047619047619 sa=0 sb=0 sd=0 mult=1 m=1
vam_r3_p02 rwl_3 rwlx_r3_p02 dc 0
XM_RD_r3_p02 rbl_p02 sn_r3_p02 rwlx_r3_p02 GND sky130_fd_pr__nfet_01v8 L=0.15 W=0.42 nf=1 ad=0.1218 as=0.1218 pd=1.42 ps=1.42 nrd=0.69047619047619  nrs=0.69047619047619 sa=0 sb=0 sd=0 mult=1 m=1
c_sn_r3_p02 sn_r3_p02 0 6.727410e-16
c_rbl_p02 rbl_p02 0 {C_RBL}
spre_p02 pre rbl_p02 ctl 0 swpre

* ---- instance p03: stored pattern rows3210=0011
v_bl_p03 bl_p03 0 pwl(0 0 {TW0+0*TWSTEP-TEDGE} 0 {TW0+0*TWSTEP} {VDD*1} {TW0+0*TWSTEP+TWPULSE+TBL_LAG} {VDD*1} {TW0+0*TWSTEP+TWPULSE+TBL_LAG+TEDGE} 0 {TW0+1*TWSTEP-TEDGE} 0 {TW0+1*TWSTEP} {VDD*1} {TW0+1*TWSTEP+TWPULSE+TBL_LAG} {VDD*1} {TW0+1*TWSTEP+TWPULSE+TBL_LAG+TEDGE} 0 {TW0+2*TWSTEP-TEDGE} 0 {TW0+2*TWSTEP} {VDD*0} {TW0+2*TWSTEP+TWPULSE+TBL_LAG} {VDD*0} {TW0+2*TWSTEP+TWPULSE+TBL_LAG+TEDGE} 0 {TW0+3*TWSTEP-TEDGE} 0 {TW0+3*TWSTEP} {VDD*0} {TW0+3*TWSTEP+TWPULSE+TBL_LAG} {VDD*0} {TW0+3*TWSTEP+TWPULSE+TBL_LAG+TEDGE} 0)
XM_WR_r0_p03 sn_r0_p03 wl_0 bl_p03 GND sky130_fd_pr__nfet_01v8 L=0.15 W=0.42 nf=1 ad=0.1218 as=0.1218 pd=1.42 ps=1.42 nrd=0.69047619047619  nrs=0.69047619047619 sa=0 sb=0 sd=0 mult=1 m=1
vam_r0_p03 rwl_0 rwlx_r0_p03 dc 0
XM_RD_r0_p03 rbl_p03 sn_r0_p03 rwlx_r0_p03 GND sky130_fd_pr__nfet_01v8 L=0.15 W=0.42 nf=1 ad=0.1218 as=0.1218 pd=1.42 ps=1.42 nrd=0.69047619047619  nrs=0.69047619047619 sa=0 sb=0 sd=0 mult=1 m=1
c_sn_r0_p03 sn_r0_p03 0 6.727410e-16
XM_WR_r1_p03 sn_r1_p03 wl_1 bl_p03 GND sky130_fd_pr__nfet_01v8 L=0.15 W=0.42 nf=1 ad=0.1218 as=0.1218 pd=1.42 ps=1.42 nrd=0.69047619047619  nrs=0.69047619047619 sa=0 sb=0 sd=0 mult=1 m=1
vam_r1_p03 rwl_1 rwlx_r1_p03 dc 0
XM_RD_r1_p03 rbl_p03 sn_r1_p03 rwlx_r1_p03 GND sky130_fd_pr__nfet_01v8 L=0.15 W=0.42 nf=1 ad=0.1218 as=0.1218 pd=1.42 ps=1.42 nrd=0.69047619047619  nrs=0.69047619047619 sa=0 sb=0 sd=0 mult=1 m=1
c_sn_r1_p03 sn_r1_p03 0 6.727410e-16
XM_WR_r2_p03 sn_r2_p03 wl_2 bl_p03 GND sky130_fd_pr__nfet_01v8 L=0.15 W=0.42 nf=1 ad=0.1218 as=0.1218 pd=1.42 ps=1.42 nrd=0.69047619047619  nrs=0.69047619047619 sa=0 sb=0 sd=0 mult=1 m=1
vam_r2_p03 rwl_2 rwlx_r2_p03 dc 0
XM_RD_r2_p03 rbl_p03 sn_r2_p03 rwlx_r2_p03 GND sky130_fd_pr__nfet_01v8 L=0.15 W=0.42 nf=1 ad=0.1218 as=0.1218 pd=1.42 ps=1.42 nrd=0.69047619047619  nrs=0.69047619047619 sa=0 sb=0 sd=0 mult=1 m=1
c_sn_r2_p03 sn_r2_p03 0 6.727410e-16
XM_WR_r3_p03 sn_r3_p03 wl_3 bl_p03 GND sky130_fd_pr__nfet_01v8 L=0.15 W=0.42 nf=1 ad=0.1218 as=0.1218 pd=1.42 ps=1.42 nrd=0.69047619047619  nrs=0.69047619047619 sa=0 sb=0 sd=0 mult=1 m=1
vam_r3_p03 rwl_3 rwlx_r3_p03 dc 0
XM_RD_r3_p03 rbl_p03 sn_r3_p03 rwlx_r3_p03 GND sky130_fd_pr__nfet_01v8 L=0.15 W=0.42 nf=1 ad=0.1218 as=0.1218 pd=1.42 ps=1.42 nrd=0.69047619047619  nrs=0.69047619047619 sa=0 sb=0 sd=0 mult=1 m=1
c_sn_r3_p03 sn_r3_p03 0 6.727410e-16
c_rbl_p03 rbl_p03 0 {C_RBL}
spre_p03 pre rbl_p03 ctl 0 swpre

* ---- instance p04: stored pattern rows3210=0100
v_bl_p04 bl_p04 0 pwl(0 0 {TW0+0*TWSTEP-TEDGE} 0 {TW0+0*TWSTEP} {VDD*0} {TW0+0*TWSTEP+TWPULSE+TBL_LAG} {VDD*0} {TW0+0*TWSTEP+TWPULSE+TBL_LAG+TEDGE} 0 {TW0+1*TWSTEP-TEDGE} 0 {TW0+1*TWSTEP} {VDD*0} {TW0+1*TWSTEP+TWPULSE+TBL_LAG} {VDD*0} {TW0+1*TWSTEP+TWPULSE+TBL_LAG+TEDGE} 0 {TW0+2*TWSTEP-TEDGE} 0 {TW0+2*TWSTEP} {VDD*1} {TW0+2*TWSTEP+TWPULSE+TBL_LAG} {VDD*1} {TW0+2*TWSTEP+TWPULSE+TBL_LAG+TEDGE} 0 {TW0+3*TWSTEP-TEDGE} 0 {TW0+3*TWSTEP} {VDD*0} {TW0+3*TWSTEP+TWPULSE+TBL_LAG} {VDD*0} {TW0+3*TWSTEP+TWPULSE+TBL_LAG+TEDGE} 0)
XM_WR_r0_p04 sn_r0_p04 wl_0 bl_p04 GND sky130_fd_pr__nfet_01v8 L=0.15 W=0.42 nf=1 ad=0.1218 as=0.1218 pd=1.42 ps=1.42 nrd=0.69047619047619  nrs=0.69047619047619 sa=0 sb=0 sd=0 mult=1 m=1
vam_r0_p04 rwl_0 rwlx_r0_p04 dc 0
XM_RD_r0_p04 rbl_p04 sn_r0_p04 rwlx_r0_p04 GND sky130_fd_pr__nfet_01v8 L=0.15 W=0.42 nf=1 ad=0.1218 as=0.1218 pd=1.42 ps=1.42 nrd=0.69047619047619  nrs=0.69047619047619 sa=0 sb=0 sd=0 mult=1 m=1
c_sn_r0_p04 sn_r0_p04 0 6.727410e-16
XM_WR_r1_p04 sn_r1_p04 wl_1 bl_p04 GND sky130_fd_pr__nfet_01v8 L=0.15 W=0.42 nf=1 ad=0.1218 as=0.1218 pd=1.42 ps=1.42 nrd=0.69047619047619  nrs=0.69047619047619 sa=0 sb=0 sd=0 mult=1 m=1
vam_r1_p04 rwl_1 rwlx_r1_p04 dc 0
XM_RD_r1_p04 rbl_p04 sn_r1_p04 rwlx_r1_p04 GND sky130_fd_pr__nfet_01v8 L=0.15 W=0.42 nf=1 ad=0.1218 as=0.1218 pd=1.42 ps=1.42 nrd=0.69047619047619  nrs=0.69047619047619 sa=0 sb=0 sd=0 mult=1 m=1
c_sn_r1_p04 sn_r1_p04 0 6.727410e-16
XM_WR_r2_p04 sn_r2_p04 wl_2 bl_p04 GND sky130_fd_pr__nfet_01v8 L=0.15 W=0.42 nf=1 ad=0.1218 as=0.1218 pd=1.42 ps=1.42 nrd=0.69047619047619  nrs=0.69047619047619 sa=0 sb=0 sd=0 mult=1 m=1
vam_r2_p04 rwl_2 rwlx_r2_p04 dc 0
XM_RD_r2_p04 rbl_p04 sn_r2_p04 rwlx_r2_p04 GND sky130_fd_pr__nfet_01v8 L=0.15 W=0.42 nf=1 ad=0.1218 as=0.1218 pd=1.42 ps=1.42 nrd=0.69047619047619  nrs=0.69047619047619 sa=0 sb=0 sd=0 mult=1 m=1
c_sn_r2_p04 sn_r2_p04 0 6.727410e-16
XM_WR_r3_p04 sn_r3_p04 wl_3 bl_p04 GND sky130_fd_pr__nfet_01v8 L=0.15 W=0.42 nf=1 ad=0.1218 as=0.1218 pd=1.42 ps=1.42 nrd=0.69047619047619  nrs=0.69047619047619 sa=0 sb=0 sd=0 mult=1 m=1
vam_r3_p04 rwl_3 rwlx_r3_p04 dc 0
XM_RD_r3_p04 rbl_p04 sn_r3_p04 rwlx_r3_p04 GND sky130_fd_pr__nfet_01v8 L=0.15 W=0.42 nf=1 ad=0.1218 as=0.1218 pd=1.42 ps=1.42 nrd=0.69047619047619  nrs=0.69047619047619 sa=0 sb=0 sd=0 mult=1 m=1
c_sn_r3_p04 sn_r3_p04 0 6.727410e-16
c_rbl_p04 rbl_p04 0 {C_RBL}
spre_p04 pre rbl_p04 ctl 0 swpre

* ---- instance p05: stored pattern rows3210=0101
v_bl_p05 bl_p05 0 pwl(0 0 {TW0+0*TWSTEP-TEDGE} 0 {TW0+0*TWSTEP} {VDD*1} {TW0+0*TWSTEP+TWPULSE+TBL_LAG} {VDD*1} {TW0+0*TWSTEP+TWPULSE+TBL_LAG+TEDGE} 0 {TW0+1*TWSTEP-TEDGE} 0 {TW0+1*TWSTEP} {VDD*0} {TW0+1*TWSTEP+TWPULSE+TBL_LAG} {VDD*0} {TW0+1*TWSTEP+TWPULSE+TBL_LAG+TEDGE} 0 {TW0+2*TWSTEP-TEDGE} 0 {TW0+2*TWSTEP} {VDD*1} {TW0+2*TWSTEP+TWPULSE+TBL_LAG} {VDD*1} {TW0+2*TWSTEP+TWPULSE+TBL_LAG+TEDGE} 0 {TW0+3*TWSTEP-TEDGE} 0 {TW0+3*TWSTEP} {VDD*0} {TW0+3*TWSTEP+TWPULSE+TBL_LAG} {VDD*0} {TW0+3*TWSTEP+TWPULSE+TBL_LAG+TEDGE} 0)
XM_WR_r0_p05 sn_r0_p05 wl_0 bl_p05 GND sky130_fd_pr__nfet_01v8 L=0.15 W=0.42 nf=1 ad=0.1218 as=0.1218 pd=1.42 ps=1.42 nrd=0.69047619047619  nrs=0.69047619047619 sa=0 sb=0 sd=0 mult=1 m=1
vam_r0_p05 rwl_0 rwlx_r0_p05 dc 0
XM_RD_r0_p05 rbl_p05 sn_r0_p05 rwlx_r0_p05 GND sky130_fd_pr__nfet_01v8 L=0.15 W=0.42 nf=1 ad=0.1218 as=0.1218 pd=1.42 ps=1.42 nrd=0.69047619047619  nrs=0.69047619047619 sa=0 sb=0 sd=0 mult=1 m=1
c_sn_r0_p05 sn_r0_p05 0 6.727410e-16
XM_WR_r1_p05 sn_r1_p05 wl_1 bl_p05 GND sky130_fd_pr__nfet_01v8 L=0.15 W=0.42 nf=1 ad=0.1218 as=0.1218 pd=1.42 ps=1.42 nrd=0.69047619047619  nrs=0.69047619047619 sa=0 sb=0 sd=0 mult=1 m=1
vam_r1_p05 rwl_1 rwlx_r1_p05 dc 0
XM_RD_r1_p05 rbl_p05 sn_r1_p05 rwlx_r1_p05 GND sky130_fd_pr__nfet_01v8 L=0.15 W=0.42 nf=1 ad=0.1218 as=0.1218 pd=1.42 ps=1.42 nrd=0.69047619047619  nrs=0.69047619047619 sa=0 sb=0 sd=0 mult=1 m=1
c_sn_r1_p05 sn_r1_p05 0 6.727410e-16
XM_WR_r2_p05 sn_r2_p05 wl_2 bl_p05 GND sky130_fd_pr__nfet_01v8 L=0.15 W=0.42 nf=1 ad=0.1218 as=0.1218 pd=1.42 ps=1.42 nrd=0.69047619047619  nrs=0.69047619047619 sa=0 sb=0 sd=0 mult=1 m=1
vam_r2_p05 rwl_2 rwlx_r2_p05 dc 0
XM_RD_r2_p05 rbl_p05 sn_r2_p05 rwlx_r2_p05 GND sky130_fd_pr__nfet_01v8 L=0.15 W=0.42 nf=1 ad=0.1218 as=0.1218 pd=1.42 ps=1.42 nrd=0.69047619047619  nrs=0.69047619047619 sa=0 sb=0 sd=0 mult=1 m=1
c_sn_r2_p05 sn_r2_p05 0 6.727410e-16
XM_WR_r3_p05 sn_r3_p05 wl_3 bl_p05 GND sky130_fd_pr__nfet_01v8 L=0.15 W=0.42 nf=1 ad=0.1218 as=0.1218 pd=1.42 ps=1.42 nrd=0.69047619047619  nrs=0.69047619047619 sa=0 sb=0 sd=0 mult=1 m=1
vam_r3_p05 rwl_3 rwlx_r3_p05 dc 0
XM_RD_r3_p05 rbl_p05 sn_r3_p05 rwlx_r3_p05 GND sky130_fd_pr__nfet_01v8 L=0.15 W=0.42 nf=1 ad=0.1218 as=0.1218 pd=1.42 ps=1.42 nrd=0.69047619047619  nrs=0.69047619047619 sa=0 sb=0 sd=0 mult=1 m=1
c_sn_r3_p05 sn_r3_p05 0 6.727410e-16
c_rbl_p05 rbl_p05 0 {C_RBL}
spre_p05 pre rbl_p05 ctl 0 swpre

* ---- instance p06: stored pattern rows3210=0110
v_bl_p06 bl_p06 0 pwl(0 0 {TW0+0*TWSTEP-TEDGE} 0 {TW0+0*TWSTEP} {VDD*0} {TW0+0*TWSTEP+TWPULSE+TBL_LAG} {VDD*0} {TW0+0*TWSTEP+TWPULSE+TBL_LAG+TEDGE} 0 {TW0+1*TWSTEP-TEDGE} 0 {TW0+1*TWSTEP} {VDD*1} {TW0+1*TWSTEP+TWPULSE+TBL_LAG} {VDD*1} {TW0+1*TWSTEP+TWPULSE+TBL_LAG+TEDGE} 0 {TW0+2*TWSTEP-TEDGE} 0 {TW0+2*TWSTEP} {VDD*1} {TW0+2*TWSTEP+TWPULSE+TBL_LAG} {VDD*1} {TW0+2*TWSTEP+TWPULSE+TBL_LAG+TEDGE} 0 {TW0+3*TWSTEP-TEDGE} 0 {TW0+3*TWSTEP} {VDD*0} {TW0+3*TWSTEP+TWPULSE+TBL_LAG} {VDD*0} {TW0+3*TWSTEP+TWPULSE+TBL_LAG+TEDGE} 0)
XM_WR_r0_p06 sn_r0_p06 wl_0 bl_p06 GND sky130_fd_pr__nfet_01v8 L=0.15 W=0.42 nf=1 ad=0.1218 as=0.1218 pd=1.42 ps=1.42 nrd=0.69047619047619  nrs=0.69047619047619 sa=0 sb=0 sd=0 mult=1 m=1
vam_r0_p06 rwl_0 rwlx_r0_p06 dc 0
XM_RD_r0_p06 rbl_p06 sn_r0_p06 rwlx_r0_p06 GND sky130_fd_pr__nfet_01v8 L=0.15 W=0.42 nf=1 ad=0.1218 as=0.1218 pd=1.42 ps=1.42 nrd=0.69047619047619  nrs=0.69047619047619 sa=0 sb=0 sd=0 mult=1 m=1
c_sn_r0_p06 sn_r0_p06 0 6.727410e-16
XM_WR_r1_p06 sn_r1_p06 wl_1 bl_p06 GND sky130_fd_pr__nfet_01v8 L=0.15 W=0.42 nf=1 ad=0.1218 as=0.1218 pd=1.42 ps=1.42 nrd=0.69047619047619  nrs=0.69047619047619 sa=0 sb=0 sd=0 mult=1 m=1
vam_r1_p06 rwl_1 rwlx_r1_p06 dc 0
XM_RD_r1_p06 rbl_p06 sn_r1_p06 rwlx_r1_p06 GND sky130_fd_pr__nfet_01v8 L=0.15 W=0.42 nf=1 ad=0.1218 as=0.1218 pd=1.42 ps=1.42 nrd=0.69047619047619  nrs=0.69047619047619 sa=0 sb=0 sd=0 mult=1 m=1
c_sn_r1_p06 sn_r1_p06 0 6.727410e-16
XM_WR_r2_p06 sn_r2_p06 wl_2 bl_p06 GND sky130_fd_pr__nfet_01v8 L=0.15 W=0.42 nf=1 ad=0.1218 as=0.1218 pd=1.42 ps=1.42 nrd=0.69047619047619  nrs=0.69047619047619 sa=0 sb=0 sd=0 mult=1 m=1
vam_r2_p06 rwl_2 rwlx_r2_p06 dc 0
XM_RD_r2_p06 rbl_p06 sn_r2_p06 rwlx_r2_p06 GND sky130_fd_pr__nfet_01v8 L=0.15 W=0.42 nf=1 ad=0.1218 as=0.1218 pd=1.42 ps=1.42 nrd=0.69047619047619  nrs=0.69047619047619 sa=0 sb=0 sd=0 mult=1 m=1
c_sn_r2_p06 sn_r2_p06 0 6.727410e-16
XM_WR_r3_p06 sn_r3_p06 wl_3 bl_p06 GND sky130_fd_pr__nfet_01v8 L=0.15 W=0.42 nf=1 ad=0.1218 as=0.1218 pd=1.42 ps=1.42 nrd=0.69047619047619  nrs=0.69047619047619 sa=0 sb=0 sd=0 mult=1 m=1
vam_r3_p06 rwl_3 rwlx_r3_p06 dc 0
XM_RD_r3_p06 rbl_p06 sn_r3_p06 rwlx_r3_p06 GND sky130_fd_pr__nfet_01v8 L=0.15 W=0.42 nf=1 ad=0.1218 as=0.1218 pd=1.42 ps=1.42 nrd=0.69047619047619  nrs=0.69047619047619 sa=0 sb=0 sd=0 mult=1 m=1
c_sn_r3_p06 sn_r3_p06 0 6.727410e-16
c_rbl_p06 rbl_p06 0 {C_RBL}
spre_p06 pre rbl_p06 ctl 0 swpre

* ---- instance p07: stored pattern rows3210=0111
v_bl_p07 bl_p07 0 pwl(0 0 {TW0+0*TWSTEP-TEDGE} 0 {TW0+0*TWSTEP} {VDD*1} {TW0+0*TWSTEP+TWPULSE+TBL_LAG} {VDD*1} {TW0+0*TWSTEP+TWPULSE+TBL_LAG+TEDGE} 0 {TW0+1*TWSTEP-TEDGE} 0 {TW0+1*TWSTEP} {VDD*1} {TW0+1*TWSTEP+TWPULSE+TBL_LAG} {VDD*1} {TW0+1*TWSTEP+TWPULSE+TBL_LAG+TEDGE} 0 {TW0+2*TWSTEP-TEDGE} 0 {TW0+2*TWSTEP} {VDD*1} {TW0+2*TWSTEP+TWPULSE+TBL_LAG} {VDD*1} {TW0+2*TWSTEP+TWPULSE+TBL_LAG+TEDGE} 0 {TW0+3*TWSTEP-TEDGE} 0 {TW0+3*TWSTEP} {VDD*0} {TW0+3*TWSTEP+TWPULSE+TBL_LAG} {VDD*0} {TW0+3*TWSTEP+TWPULSE+TBL_LAG+TEDGE} 0)
XM_WR_r0_p07 sn_r0_p07 wl_0 bl_p07 GND sky130_fd_pr__nfet_01v8 L=0.15 W=0.42 nf=1 ad=0.1218 as=0.1218 pd=1.42 ps=1.42 nrd=0.69047619047619  nrs=0.69047619047619 sa=0 sb=0 sd=0 mult=1 m=1
vam_r0_p07 rwl_0 rwlx_r0_p07 dc 0
XM_RD_r0_p07 rbl_p07 sn_r0_p07 rwlx_r0_p07 GND sky130_fd_pr__nfet_01v8 L=0.15 W=0.42 nf=1 ad=0.1218 as=0.1218 pd=1.42 ps=1.42 nrd=0.69047619047619  nrs=0.69047619047619 sa=0 sb=0 sd=0 mult=1 m=1
c_sn_r0_p07 sn_r0_p07 0 6.727410e-16
XM_WR_r1_p07 sn_r1_p07 wl_1 bl_p07 GND sky130_fd_pr__nfet_01v8 L=0.15 W=0.42 nf=1 ad=0.1218 as=0.1218 pd=1.42 ps=1.42 nrd=0.69047619047619  nrs=0.69047619047619 sa=0 sb=0 sd=0 mult=1 m=1
vam_r1_p07 rwl_1 rwlx_r1_p07 dc 0
XM_RD_r1_p07 rbl_p07 sn_r1_p07 rwlx_r1_p07 GND sky130_fd_pr__nfet_01v8 L=0.15 W=0.42 nf=1 ad=0.1218 as=0.1218 pd=1.42 ps=1.42 nrd=0.69047619047619  nrs=0.69047619047619 sa=0 sb=0 sd=0 mult=1 m=1
c_sn_r1_p07 sn_r1_p07 0 6.727410e-16
XM_WR_r2_p07 sn_r2_p07 wl_2 bl_p07 GND sky130_fd_pr__nfet_01v8 L=0.15 W=0.42 nf=1 ad=0.1218 as=0.1218 pd=1.42 ps=1.42 nrd=0.69047619047619  nrs=0.69047619047619 sa=0 sb=0 sd=0 mult=1 m=1
vam_r2_p07 rwl_2 rwlx_r2_p07 dc 0
XM_RD_r2_p07 rbl_p07 sn_r2_p07 rwlx_r2_p07 GND sky130_fd_pr__nfet_01v8 L=0.15 W=0.42 nf=1 ad=0.1218 as=0.1218 pd=1.42 ps=1.42 nrd=0.69047619047619  nrs=0.69047619047619 sa=0 sb=0 sd=0 mult=1 m=1
c_sn_r2_p07 sn_r2_p07 0 6.727410e-16
XM_WR_r3_p07 sn_r3_p07 wl_3 bl_p07 GND sky130_fd_pr__nfet_01v8 L=0.15 W=0.42 nf=1 ad=0.1218 as=0.1218 pd=1.42 ps=1.42 nrd=0.69047619047619  nrs=0.69047619047619 sa=0 sb=0 sd=0 mult=1 m=1
vam_r3_p07 rwl_3 rwlx_r3_p07 dc 0
XM_RD_r3_p07 rbl_p07 sn_r3_p07 rwlx_r3_p07 GND sky130_fd_pr__nfet_01v8 L=0.15 W=0.42 nf=1 ad=0.1218 as=0.1218 pd=1.42 ps=1.42 nrd=0.69047619047619  nrs=0.69047619047619 sa=0 sb=0 sd=0 mult=1 m=1
c_sn_r3_p07 sn_r3_p07 0 6.727410e-16
c_rbl_p07 rbl_p07 0 {C_RBL}
spre_p07 pre rbl_p07 ctl 0 swpre

* ---- instance p08: stored pattern rows3210=1000
v_bl_p08 bl_p08 0 pwl(0 0 {TW0+0*TWSTEP-TEDGE} 0 {TW0+0*TWSTEP} {VDD*0} {TW0+0*TWSTEP+TWPULSE+TBL_LAG} {VDD*0} {TW0+0*TWSTEP+TWPULSE+TBL_LAG+TEDGE} 0 {TW0+1*TWSTEP-TEDGE} 0 {TW0+1*TWSTEP} {VDD*0} {TW0+1*TWSTEP+TWPULSE+TBL_LAG} {VDD*0} {TW0+1*TWSTEP+TWPULSE+TBL_LAG+TEDGE} 0 {TW0+2*TWSTEP-TEDGE} 0 {TW0+2*TWSTEP} {VDD*0} {TW0+2*TWSTEP+TWPULSE+TBL_LAG} {VDD*0} {TW0+2*TWSTEP+TWPULSE+TBL_LAG+TEDGE} 0 {TW0+3*TWSTEP-TEDGE} 0 {TW0+3*TWSTEP} {VDD*1} {TW0+3*TWSTEP+TWPULSE+TBL_LAG} {VDD*1} {TW0+3*TWSTEP+TWPULSE+TBL_LAG+TEDGE} 0)
XM_WR_r0_p08 sn_r0_p08 wl_0 bl_p08 GND sky130_fd_pr__nfet_01v8 L=0.15 W=0.42 nf=1 ad=0.1218 as=0.1218 pd=1.42 ps=1.42 nrd=0.69047619047619  nrs=0.69047619047619 sa=0 sb=0 sd=0 mult=1 m=1
vam_r0_p08 rwl_0 rwlx_r0_p08 dc 0
XM_RD_r0_p08 rbl_p08 sn_r0_p08 rwlx_r0_p08 GND sky130_fd_pr__nfet_01v8 L=0.15 W=0.42 nf=1 ad=0.1218 as=0.1218 pd=1.42 ps=1.42 nrd=0.69047619047619  nrs=0.69047619047619 sa=0 sb=0 sd=0 mult=1 m=1
c_sn_r0_p08 sn_r0_p08 0 6.727410e-16
XM_WR_r1_p08 sn_r1_p08 wl_1 bl_p08 GND sky130_fd_pr__nfet_01v8 L=0.15 W=0.42 nf=1 ad=0.1218 as=0.1218 pd=1.42 ps=1.42 nrd=0.69047619047619  nrs=0.69047619047619 sa=0 sb=0 sd=0 mult=1 m=1
vam_r1_p08 rwl_1 rwlx_r1_p08 dc 0
XM_RD_r1_p08 rbl_p08 sn_r1_p08 rwlx_r1_p08 GND sky130_fd_pr__nfet_01v8 L=0.15 W=0.42 nf=1 ad=0.1218 as=0.1218 pd=1.42 ps=1.42 nrd=0.69047619047619  nrs=0.69047619047619 sa=0 sb=0 sd=0 mult=1 m=1
c_sn_r1_p08 sn_r1_p08 0 6.727410e-16
XM_WR_r2_p08 sn_r2_p08 wl_2 bl_p08 GND sky130_fd_pr__nfet_01v8 L=0.15 W=0.42 nf=1 ad=0.1218 as=0.1218 pd=1.42 ps=1.42 nrd=0.69047619047619  nrs=0.69047619047619 sa=0 sb=0 sd=0 mult=1 m=1
vam_r2_p08 rwl_2 rwlx_r2_p08 dc 0
XM_RD_r2_p08 rbl_p08 sn_r2_p08 rwlx_r2_p08 GND sky130_fd_pr__nfet_01v8 L=0.15 W=0.42 nf=1 ad=0.1218 as=0.1218 pd=1.42 ps=1.42 nrd=0.69047619047619  nrs=0.69047619047619 sa=0 sb=0 sd=0 mult=1 m=1
c_sn_r2_p08 sn_r2_p08 0 6.727410e-16
XM_WR_r3_p08 sn_r3_p08 wl_3 bl_p08 GND sky130_fd_pr__nfet_01v8 L=0.15 W=0.42 nf=1 ad=0.1218 as=0.1218 pd=1.42 ps=1.42 nrd=0.69047619047619  nrs=0.69047619047619 sa=0 sb=0 sd=0 mult=1 m=1
vam_r3_p08 rwl_3 rwlx_r3_p08 dc 0
XM_RD_r3_p08 rbl_p08 sn_r3_p08 rwlx_r3_p08 GND sky130_fd_pr__nfet_01v8 L=0.15 W=0.42 nf=1 ad=0.1218 as=0.1218 pd=1.42 ps=1.42 nrd=0.69047619047619  nrs=0.69047619047619 sa=0 sb=0 sd=0 mult=1 m=1
c_sn_r3_p08 sn_r3_p08 0 6.727410e-16
c_rbl_p08 rbl_p08 0 {C_RBL}
spre_p08 pre rbl_p08 ctl 0 swpre

* ---- instance p09: stored pattern rows3210=1001
v_bl_p09 bl_p09 0 pwl(0 0 {TW0+0*TWSTEP-TEDGE} 0 {TW0+0*TWSTEP} {VDD*1} {TW0+0*TWSTEP+TWPULSE+TBL_LAG} {VDD*1} {TW0+0*TWSTEP+TWPULSE+TBL_LAG+TEDGE} 0 {TW0+1*TWSTEP-TEDGE} 0 {TW0+1*TWSTEP} {VDD*0} {TW0+1*TWSTEP+TWPULSE+TBL_LAG} {VDD*0} {TW0+1*TWSTEP+TWPULSE+TBL_LAG+TEDGE} 0 {TW0+2*TWSTEP-TEDGE} 0 {TW0+2*TWSTEP} {VDD*0} {TW0+2*TWSTEP+TWPULSE+TBL_LAG} {VDD*0} {TW0+2*TWSTEP+TWPULSE+TBL_LAG+TEDGE} 0 {TW0+3*TWSTEP-TEDGE} 0 {TW0+3*TWSTEP} {VDD*1} {TW0+3*TWSTEP+TWPULSE+TBL_LAG} {VDD*1} {TW0+3*TWSTEP+TWPULSE+TBL_LAG+TEDGE} 0)
XM_WR_r0_p09 sn_r0_p09 wl_0 bl_p09 GND sky130_fd_pr__nfet_01v8 L=0.15 W=0.42 nf=1 ad=0.1218 as=0.1218 pd=1.42 ps=1.42 nrd=0.69047619047619  nrs=0.69047619047619 sa=0 sb=0 sd=0 mult=1 m=1
vam_r0_p09 rwl_0 rwlx_r0_p09 dc 0
XM_RD_r0_p09 rbl_p09 sn_r0_p09 rwlx_r0_p09 GND sky130_fd_pr__nfet_01v8 L=0.15 W=0.42 nf=1 ad=0.1218 as=0.1218 pd=1.42 ps=1.42 nrd=0.69047619047619  nrs=0.69047619047619 sa=0 sb=0 sd=0 mult=1 m=1
c_sn_r0_p09 sn_r0_p09 0 6.727410e-16
XM_WR_r1_p09 sn_r1_p09 wl_1 bl_p09 GND sky130_fd_pr__nfet_01v8 L=0.15 W=0.42 nf=1 ad=0.1218 as=0.1218 pd=1.42 ps=1.42 nrd=0.69047619047619  nrs=0.69047619047619 sa=0 sb=0 sd=0 mult=1 m=1
vam_r1_p09 rwl_1 rwlx_r1_p09 dc 0
XM_RD_r1_p09 rbl_p09 sn_r1_p09 rwlx_r1_p09 GND sky130_fd_pr__nfet_01v8 L=0.15 W=0.42 nf=1 ad=0.1218 as=0.1218 pd=1.42 ps=1.42 nrd=0.69047619047619  nrs=0.69047619047619 sa=0 sb=0 sd=0 mult=1 m=1
c_sn_r1_p09 sn_r1_p09 0 6.727410e-16
XM_WR_r2_p09 sn_r2_p09 wl_2 bl_p09 GND sky130_fd_pr__nfet_01v8 L=0.15 W=0.42 nf=1 ad=0.1218 as=0.1218 pd=1.42 ps=1.42 nrd=0.69047619047619  nrs=0.69047619047619 sa=0 sb=0 sd=0 mult=1 m=1
vam_r2_p09 rwl_2 rwlx_r2_p09 dc 0
XM_RD_r2_p09 rbl_p09 sn_r2_p09 rwlx_r2_p09 GND sky130_fd_pr__nfet_01v8 L=0.15 W=0.42 nf=1 ad=0.1218 as=0.1218 pd=1.42 ps=1.42 nrd=0.69047619047619  nrs=0.69047619047619 sa=0 sb=0 sd=0 mult=1 m=1
c_sn_r2_p09 sn_r2_p09 0 6.727410e-16
XM_WR_r3_p09 sn_r3_p09 wl_3 bl_p09 GND sky130_fd_pr__nfet_01v8 L=0.15 W=0.42 nf=1 ad=0.1218 as=0.1218 pd=1.42 ps=1.42 nrd=0.69047619047619  nrs=0.69047619047619 sa=0 sb=0 sd=0 mult=1 m=1
vam_r3_p09 rwl_3 rwlx_r3_p09 dc 0
XM_RD_r3_p09 rbl_p09 sn_r3_p09 rwlx_r3_p09 GND sky130_fd_pr__nfet_01v8 L=0.15 W=0.42 nf=1 ad=0.1218 as=0.1218 pd=1.42 ps=1.42 nrd=0.69047619047619  nrs=0.69047619047619 sa=0 sb=0 sd=0 mult=1 m=1
c_sn_r3_p09 sn_r3_p09 0 6.727410e-16
c_rbl_p09 rbl_p09 0 {C_RBL}
spre_p09 pre rbl_p09 ctl 0 swpre

* ---- instance p10: stored pattern rows3210=1010
v_bl_p10 bl_p10 0 pwl(0 0 {TW0+0*TWSTEP-TEDGE} 0 {TW0+0*TWSTEP} {VDD*0} {TW0+0*TWSTEP+TWPULSE+TBL_LAG} {VDD*0} {TW0+0*TWSTEP+TWPULSE+TBL_LAG+TEDGE} 0 {TW0+1*TWSTEP-TEDGE} 0 {TW0+1*TWSTEP} {VDD*1} {TW0+1*TWSTEP+TWPULSE+TBL_LAG} {VDD*1} {TW0+1*TWSTEP+TWPULSE+TBL_LAG+TEDGE} 0 {TW0+2*TWSTEP-TEDGE} 0 {TW0+2*TWSTEP} {VDD*0} {TW0+2*TWSTEP+TWPULSE+TBL_LAG} {VDD*0} {TW0+2*TWSTEP+TWPULSE+TBL_LAG+TEDGE} 0 {TW0+3*TWSTEP-TEDGE} 0 {TW0+3*TWSTEP} {VDD*1} {TW0+3*TWSTEP+TWPULSE+TBL_LAG} {VDD*1} {TW0+3*TWSTEP+TWPULSE+TBL_LAG+TEDGE} 0)
XM_WR_r0_p10 sn_r0_p10 wl_0 bl_p10 GND sky130_fd_pr__nfet_01v8 L=0.15 W=0.42 nf=1 ad=0.1218 as=0.1218 pd=1.42 ps=1.42 nrd=0.69047619047619  nrs=0.69047619047619 sa=0 sb=0 sd=0 mult=1 m=1
vam_r0_p10 rwl_0 rwlx_r0_p10 dc 0
XM_RD_r0_p10 rbl_p10 sn_r0_p10 rwlx_r0_p10 GND sky130_fd_pr__nfet_01v8 L=0.15 W=0.42 nf=1 ad=0.1218 as=0.1218 pd=1.42 ps=1.42 nrd=0.69047619047619  nrs=0.69047619047619 sa=0 sb=0 sd=0 mult=1 m=1
c_sn_r0_p10 sn_r0_p10 0 6.727410e-16
XM_WR_r1_p10 sn_r1_p10 wl_1 bl_p10 GND sky130_fd_pr__nfet_01v8 L=0.15 W=0.42 nf=1 ad=0.1218 as=0.1218 pd=1.42 ps=1.42 nrd=0.69047619047619  nrs=0.69047619047619 sa=0 sb=0 sd=0 mult=1 m=1
vam_r1_p10 rwl_1 rwlx_r1_p10 dc 0
XM_RD_r1_p10 rbl_p10 sn_r1_p10 rwlx_r1_p10 GND sky130_fd_pr__nfet_01v8 L=0.15 W=0.42 nf=1 ad=0.1218 as=0.1218 pd=1.42 ps=1.42 nrd=0.69047619047619  nrs=0.69047619047619 sa=0 sb=0 sd=0 mult=1 m=1
c_sn_r1_p10 sn_r1_p10 0 6.727410e-16
XM_WR_r2_p10 sn_r2_p10 wl_2 bl_p10 GND sky130_fd_pr__nfet_01v8 L=0.15 W=0.42 nf=1 ad=0.1218 as=0.1218 pd=1.42 ps=1.42 nrd=0.69047619047619  nrs=0.69047619047619 sa=0 sb=0 sd=0 mult=1 m=1
vam_r2_p10 rwl_2 rwlx_r2_p10 dc 0
XM_RD_r2_p10 rbl_p10 sn_r2_p10 rwlx_r2_p10 GND sky130_fd_pr__nfet_01v8 L=0.15 W=0.42 nf=1 ad=0.1218 as=0.1218 pd=1.42 ps=1.42 nrd=0.69047619047619  nrs=0.69047619047619 sa=0 sb=0 sd=0 mult=1 m=1
c_sn_r2_p10 sn_r2_p10 0 6.727410e-16
XM_WR_r3_p10 sn_r3_p10 wl_3 bl_p10 GND sky130_fd_pr__nfet_01v8 L=0.15 W=0.42 nf=1 ad=0.1218 as=0.1218 pd=1.42 ps=1.42 nrd=0.69047619047619  nrs=0.69047619047619 sa=0 sb=0 sd=0 mult=1 m=1
vam_r3_p10 rwl_3 rwlx_r3_p10 dc 0
XM_RD_r3_p10 rbl_p10 sn_r3_p10 rwlx_r3_p10 GND sky130_fd_pr__nfet_01v8 L=0.15 W=0.42 nf=1 ad=0.1218 as=0.1218 pd=1.42 ps=1.42 nrd=0.69047619047619  nrs=0.69047619047619 sa=0 sb=0 sd=0 mult=1 m=1
c_sn_r3_p10 sn_r3_p10 0 6.727410e-16
c_rbl_p10 rbl_p10 0 {C_RBL}
spre_p10 pre rbl_p10 ctl 0 swpre

* ---- instance p11: stored pattern rows3210=1011
v_bl_p11 bl_p11 0 pwl(0 0 {TW0+0*TWSTEP-TEDGE} 0 {TW0+0*TWSTEP} {VDD*1} {TW0+0*TWSTEP+TWPULSE+TBL_LAG} {VDD*1} {TW0+0*TWSTEP+TWPULSE+TBL_LAG+TEDGE} 0 {TW0+1*TWSTEP-TEDGE} 0 {TW0+1*TWSTEP} {VDD*1} {TW0+1*TWSTEP+TWPULSE+TBL_LAG} {VDD*1} {TW0+1*TWSTEP+TWPULSE+TBL_LAG+TEDGE} 0 {TW0+2*TWSTEP-TEDGE} 0 {TW0+2*TWSTEP} {VDD*0} {TW0+2*TWSTEP+TWPULSE+TBL_LAG} {VDD*0} {TW0+2*TWSTEP+TWPULSE+TBL_LAG+TEDGE} 0 {TW0+3*TWSTEP-TEDGE} 0 {TW0+3*TWSTEP} {VDD*1} {TW0+3*TWSTEP+TWPULSE+TBL_LAG} {VDD*1} {TW0+3*TWSTEP+TWPULSE+TBL_LAG+TEDGE} 0)
XM_WR_r0_p11 sn_r0_p11 wl_0 bl_p11 GND sky130_fd_pr__nfet_01v8 L=0.15 W=0.42 nf=1 ad=0.1218 as=0.1218 pd=1.42 ps=1.42 nrd=0.69047619047619  nrs=0.69047619047619 sa=0 sb=0 sd=0 mult=1 m=1
vam_r0_p11 rwl_0 rwlx_r0_p11 dc 0
XM_RD_r0_p11 rbl_p11 sn_r0_p11 rwlx_r0_p11 GND sky130_fd_pr__nfet_01v8 L=0.15 W=0.42 nf=1 ad=0.1218 as=0.1218 pd=1.42 ps=1.42 nrd=0.69047619047619  nrs=0.69047619047619 sa=0 sb=0 sd=0 mult=1 m=1
c_sn_r0_p11 sn_r0_p11 0 6.727410e-16
XM_WR_r1_p11 sn_r1_p11 wl_1 bl_p11 GND sky130_fd_pr__nfet_01v8 L=0.15 W=0.42 nf=1 ad=0.1218 as=0.1218 pd=1.42 ps=1.42 nrd=0.69047619047619  nrs=0.69047619047619 sa=0 sb=0 sd=0 mult=1 m=1
vam_r1_p11 rwl_1 rwlx_r1_p11 dc 0
XM_RD_r1_p11 rbl_p11 sn_r1_p11 rwlx_r1_p11 GND sky130_fd_pr__nfet_01v8 L=0.15 W=0.42 nf=1 ad=0.1218 as=0.1218 pd=1.42 ps=1.42 nrd=0.69047619047619  nrs=0.69047619047619 sa=0 sb=0 sd=0 mult=1 m=1
c_sn_r1_p11 sn_r1_p11 0 6.727410e-16
XM_WR_r2_p11 sn_r2_p11 wl_2 bl_p11 GND sky130_fd_pr__nfet_01v8 L=0.15 W=0.42 nf=1 ad=0.1218 as=0.1218 pd=1.42 ps=1.42 nrd=0.69047619047619  nrs=0.69047619047619 sa=0 sb=0 sd=0 mult=1 m=1
vam_r2_p11 rwl_2 rwlx_r2_p11 dc 0
XM_RD_r2_p11 rbl_p11 sn_r2_p11 rwlx_r2_p11 GND sky130_fd_pr__nfet_01v8 L=0.15 W=0.42 nf=1 ad=0.1218 as=0.1218 pd=1.42 ps=1.42 nrd=0.69047619047619  nrs=0.69047619047619 sa=0 sb=0 sd=0 mult=1 m=1
c_sn_r2_p11 sn_r2_p11 0 6.727410e-16
XM_WR_r3_p11 sn_r3_p11 wl_3 bl_p11 GND sky130_fd_pr__nfet_01v8 L=0.15 W=0.42 nf=1 ad=0.1218 as=0.1218 pd=1.42 ps=1.42 nrd=0.69047619047619  nrs=0.69047619047619 sa=0 sb=0 sd=0 mult=1 m=1
vam_r3_p11 rwl_3 rwlx_r3_p11 dc 0
XM_RD_r3_p11 rbl_p11 sn_r3_p11 rwlx_r3_p11 GND sky130_fd_pr__nfet_01v8 L=0.15 W=0.42 nf=1 ad=0.1218 as=0.1218 pd=1.42 ps=1.42 nrd=0.69047619047619  nrs=0.69047619047619 sa=0 sb=0 sd=0 mult=1 m=1
c_sn_r3_p11 sn_r3_p11 0 6.727410e-16
c_rbl_p11 rbl_p11 0 {C_RBL}
spre_p11 pre rbl_p11 ctl 0 swpre

* ---- instance p12: stored pattern rows3210=1100
v_bl_p12 bl_p12 0 pwl(0 0 {TW0+0*TWSTEP-TEDGE} 0 {TW0+0*TWSTEP} {VDD*0} {TW0+0*TWSTEP+TWPULSE+TBL_LAG} {VDD*0} {TW0+0*TWSTEP+TWPULSE+TBL_LAG+TEDGE} 0 {TW0+1*TWSTEP-TEDGE} 0 {TW0+1*TWSTEP} {VDD*0} {TW0+1*TWSTEP+TWPULSE+TBL_LAG} {VDD*0} {TW0+1*TWSTEP+TWPULSE+TBL_LAG+TEDGE} 0 {TW0+2*TWSTEP-TEDGE} 0 {TW0+2*TWSTEP} {VDD*1} {TW0+2*TWSTEP+TWPULSE+TBL_LAG} {VDD*1} {TW0+2*TWSTEP+TWPULSE+TBL_LAG+TEDGE} 0 {TW0+3*TWSTEP-TEDGE} 0 {TW0+3*TWSTEP} {VDD*1} {TW0+3*TWSTEP+TWPULSE+TBL_LAG} {VDD*1} {TW0+3*TWSTEP+TWPULSE+TBL_LAG+TEDGE} 0)
XM_WR_r0_p12 sn_r0_p12 wl_0 bl_p12 GND sky130_fd_pr__nfet_01v8 L=0.15 W=0.42 nf=1 ad=0.1218 as=0.1218 pd=1.42 ps=1.42 nrd=0.69047619047619  nrs=0.69047619047619 sa=0 sb=0 sd=0 mult=1 m=1
vam_r0_p12 rwl_0 rwlx_r0_p12 dc 0
XM_RD_r0_p12 rbl_p12 sn_r0_p12 rwlx_r0_p12 GND sky130_fd_pr__nfet_01v8 L=0.15 W=0.42 nf=1 ad=0.1218 as=0.1218 pd=1.42 ps=1.42 nrd=0.69047619047619  nrs=0.69047619047619 sa=0 sb=0 sd=0 mult=1 m=1
c_sn_r0_p12 sn_r0_p12 0 6.727410e-16
XM_WR_r1_p12 sn_r1_p12 wl_1 bl_p12 GND sky130_fd_pr__nfet_01v8 L=0.15 W=0.42 nf=1 ad=0.1218 as=0.1218 pd=1.42 ps=1.42 nrd=0.69047619047619  nrs=0.69047619047619 sa=0 sb=0 sd=0 mult=1 m=1
vam_r1_p12 rwl_1 rwlx_r1_p12 dc 0
XM_RD_r1_p12 rbl_p12 sn_r1_p12 rwlx_r1_p12 GND sky130_fd_pr__nfet_01v8 L=0.15 W=0.42 nf=1 ad=0.1218 as=0.1218 pd=1.42 ps=1.42 nrd=0.69047619047619  nrs=0.69047619047619 sa=0 sb=0 sd=0 mult=1 m=1
c_sn_r1_p12 sn_r1_p12 0 6.727410e-16
XM_WR_r2_p12 sn_r2_p12 wl_2 bl_p12 GND sky130_fd_pr__nfet_01v8 L=0.15 W=0.42 nf=1 ad=0.1218 as=0.1218 pd=1.42 ps=1.42 nrd=0.69047619047619  nrs=0.69047619047619 sa=0 sb=0 sd=0 mult=1 m=1
vam_r2_p12 rwl_2 rwlx_r2_p12 dc 0
XM_RD_r2_p12 rbl_p12 sn_r2_p12 rwlx_r2_p12 GND sky130_fd_pr__nfet_01v8 L=0.15 W=0.42 nf=1 ad=0.1218 as=0.1218 pd=1.42 ps=1.42 nrd=0.69047619047619  nrs=0.69047619047619 sa=0 sb=0 sd=0 mult=1 m=1
c_sn_r2_p12 sn_r2_p12 0 6.727410e-16
XM_WR_r3_p12 sn_r3_p12 wl_3 bl_p12 GND sky130_fd_pr__nfet_01v8 L=0.15 W=0.42 nf=1 ad=0.1218 as=0.1218 pd=1.42 ps=1.42 nrd=0.69047619047619  nrs=0.69047619047619 sa=0 sb=0 sd=0 mult=1 m=1
vam_r3_p12 rwl_3 rwlx_r3_p12 dc 0
XM_RD_r3_p12 rbl_p12 sn_r3_p12 rwlx_r3_p12 GND sky130_fd_pr__nfet_01v8 L=0.15 W=0.42 nf=1 ad=0.1218 as=0.1218 pd=1.42 ps=1.42 nrd=0.69047619047619  nrs=0.69047619047619 sa=0 sb=0 sd=0 mult=1 m=1
c_sn_r3_p12 sn_r3_p12 0 6.727410e-16
c_rbl_p12 rbl_p12 0 {C_RBL}
spre_p12 pre rbl_p12 ctl 0 swpre

* ---- instance p13: stored pattern rows3210=1101
v_bl_p13 bl_p13 0 pwl(0 0 {TW0+0*TWSTEP-TEDGE} 0 {TW0+0*TWSTEP} {VDD*1} {TW0+0*TWSTEP+TWPULSE+TBL_LAG} {VDD*1} {TW0+0*TWSTEP+TWPULSE+TBL_LAG+TEDGE} 0 {TW0+1*TWSTEP-TEDGE} 0 {TW0+1*TWSTEP} {VDD*0} {TW0+1*TWSTEP+TWPULSE+TBL_LAG} {VDD*0} {TW0+1*TWSTEP+TWPULSE+TBL_LAG+TEDGE} 0 {TW0+2*TWSTEP-TEDGE} 0 {TW0+2*TWSTEP} {VDD*1} {TW0+2*TWSTEP+TWPULSE+TBL_LAG} {VDD*1} {TW0+2*TWSTEP+TWPULSE+TBL_LAG+TEDGE} 0 {TW0+3*TWSTEP-TEDGE} 0 {TW0+3*TWSTEP} {VDD*1} {TW0+3*TWSTEP+TWPULSE+TBL_LAG} {VDD*1} {TW0+3*TWSTEP+TWPULSE+TBL_LAG+TEDGE} 0)
XM_WR_r0_p13 sn_r0_p13 wl_0 bl_p13 GND sky130_fd_pr__nfet_01v8 L=0.15 W=0.42 nf=1 ad=0.1218 as=0.1218 pd=1.42 ps=1.42 nrd=0.69047619047619  nrs=0.69047619047619 sa=0 sb=0 sd=0 mult=1 m=1
vam_r0_p13 rwl_0 rwlx_r0_p13 dc 0
XM_RD_r0_p13 rbl_p13 sn_r0_p13 rwlx_r0_p13 GND sky130_fd_pr__nfet_01v8 L=0.15 W=0.42 nf=1 ad=0.1218 as=0.1218 pd=1.42 ps=1.42 nrd=0.69047619047619  nrs=0.69047619047619 sa=0 sb=0 sd=0 mult=1 m=1
c_sn_r0_p13 sn_r0_p13 0 6.727410e-16
XM_WR_r1_p13 sn_r1_p13 wl_1 bl_p13 GND sky130_fd_pr__nfet_01v8 L=0.15 W=0.42 nf=1 ad=0.1218 as=0.1218 pd=1.42 ps=1.42 nrd=0.69047619047619  nrs=0.69047619047619 sa=0 sb=0 sd=0 mult=1 m=1
vam_r1_p13 rwl_1 rwlx_r1_p13 dc 0
XM_RD_r1_p13 rbl_p13 sn_r1_p13 rwlx_r1_p13 GND sky130_fd_pr__nfet_01v8 L=0.15 W=0.42 nf=1 ad=0.1218 as=0.1218 pd=1.42 ps=1.42 nrd=0.69047619047619  nrs=0.69047619047619 sa=0 sb=0 sd=0 mult=1 m=1
c_sn_r1_p13 sn_r1_p13 0 6.727410e-16
XM_WR_r2_p13 sn_r2_p13 wl_2 bl_p13 GND sky130_fd_pr__nfet_01v8 L=0.15 W=0.42 nf=1 ad=0.1218 as=0.1218 pd=1.42 ps=1.42 nrd=0.69047619047619  nrs=0.69047619047619 sa=0 sb=0 sd=0 mult=1 m=1
vam_r2_p13 rwl_2 rwlx_r2_p13 dc 0
XM_RD_r2_p13 rbl_p13 sn_r2_p13 rwlx_r2_p13 GND sky130_fd_pr__nfet_01v8 L=0.15 W=0.42 nf=1 ad=0.1218 as=0.1218 pd=1.42 ps=1.42 nrd=0.69047619047619  nrs=0.69047619047619 sa=0 sb=0 sd=0 mult=1 m=1
c_sn_r2_p13 sn_r2_p13 0 6.727410e-16
XM_WR_r3_p13 sn_r3_p13 wl_3 bl_p13 GND sky130_fd_pr__nfet_01v8 L=0.15 W=0.42 nf=1 ad=0.1218 as=0.1218 pd=1.42 ps=1.42 nrd=0.69047619047619  nrs=0.69047619047619 sa=0 sb=0 sd=0 mult=1 m=1
vam_r3_p13 rwl_3 rwlx_r3_p13 dc 0
XM_RD_r3_p13 rbl_p13 sn_r3_p13 rwlx_r3_p13 GND sky130_fd_pr__nfet_01v8 L=0.15 W=0.42 nf=1 ad=0.1218 as=0.1218 pd=1.42 ps=1.42 nrd=0.69047619047619  nrs=0.69047619047619 sa=0 sb=0 sd=0 mult=1 m=1
c_sn_r3_p13 sn_r3_p13 0 6.727410e-16
c_rbl_p13 rbl_p13 0 {C_RBL}
spre_p13 pre rbl_p13 ctl 0 swpre

* ---- instance p14: stored pattern rows3210=1110
v_bl_p14 bl_p14 0 pwl(0 0 {TW0+0*TWSTEP-TEDGE} 0 {TW0+0*TWSTEP} {VDD*0} {TW0+0*TWSTEP+TWPULSE+TBL_LAG} {VDD*0} {TW0+0*TWSTEP+TWPULSE+TBL_LAG+TEDGE} 0 {TW0+1*TWSTEP-TEDGE} 0 {TW0+1*TWSTEP} {VDD*1} {TW0+1*TWSTEP+TWPULSE+TBL_LAG} {VDD*1} {TW0+1*TWSTEP+TWPULSE+TBL_LAG+TEDGE} 0 {TW0+2*TWSTEP-TEDGE} 0 {TW0+2*TWSTEP} {VDD*1} {TW0+2*TWSTEP+TWPULSE+TBL_LAG} {VDD*1} {TW0+2*TWSTEP+TWPULSE+TBL_LAG+TEDGE} 0 {TW0+3*TWSTEP-TEDGE} 0 {TW0+3*TWSTEP} {VDD*1} {TW0+3*TWSTEP+TWPULSE+TBL_LAG} {VDD*1} {TW0+3*TWSTEP+TWPULSE+TBL_LAG+TEDGE} 0)
XM_WR_r0_p14 sn_r0_p14 wl_0 bl_p14 GND sky130_fd_pr__nfet_01v8 L=0.15 W=0.42 nf=1 ad=0.1218 as=0.1218 pd=1.42 ps=1.42 nrd=0.69047619047619  nrs=0.69047619047619 sa=0 sb=0 sd=0 mult=1 m=1
vam_r0_p14 rwl_0 rwlx_r0_p14 dc 0
XM_RD_r0_p14 rbl_p14 sn_r0_p14 rwlx_r0_p14 GND sky130_fd_pr__nfet_01v8 L=0.15 W=0.42 nf=1 ad=0.1218 as=0.1218 pd=1.42 ps=1.42 nrd=0.69047619047619  nrs=0.69047619047619 sa=0 sb=0 sd=0 mult=1 m=1
c_sn_r0_p14 sn_r0_p14 0 6.727410e-16
XM_WR_r1_p14 sn_r1_p14 wl_1 bl_p14 GND sky130_fd_pr__nfet_01v8 L=0.15 W=0.42 nf=1 ad=0.1218 as=0.1218 pd=1.42 ps=1.42 nrd=0.69047619047619  nrs=0.69047619047619 sa=0 sb=0 sd=0 mult=1 m=1
vam_r1_p14 rwl_1 rwlx_r1_p14 dc 0
XM_RD_r1_p14 rbl_p14 sn_r1_p14 rwlx_r1_p14 GND sky130_fd_pr__nfet_01v8 L=0.15 W=0.42 nf=1 ad=0.1218 as=0.1218 pd=1.42 ps=1.42 nrd=0.69047619047619  nrs=0.69047619047619 sa=0 sb=0 sd=0 mult=1 m=1
c_sn_r1_p14 sn_r1_p14 0 6.727410e-16
XM_WR_r2_p14 sn_r2_p14 wl_2 bl_p14 GND sky130_fd_pr__nfet_01v8 L=0.15 W=0.42 nf=1 ad=0.1218 as=0.1218 pd=1.42 ps=1.42 nrd=0.69047619047619  nrs=0.69047619047619 sa=0 sb=0 sd=0 mult=1 m=1
vam_r2_p14 rwl_2 rwlx_r2_p14 dc 0
XM_RD_r2_p14 rbl_p14 sn_r2_p14 rwlx_r2_p14 GND sky130_fd_pr__nfet_01v8 L=0.15 W=0.42 nf=1 ad=0.1218 as=0.1218 pd=1.42 ps=1.42 nrd=0.69047619047619  nrs=0.69047619047619 sa=0 sb=0 sd=0 mult=1 m=1
c_sn_r2_p14 sn_r2_p14 0 6.727410e-16
XM_WR_r3_p14 sn_r3_p14 wl_3 bl_p14 GND sky130_fd_pr__nfet_01v8 L=0.15 W=0.42 nf=1 ad=0.1218 as=0.1218 pd=1.42 ps=1.42 nrd=0.69047619047619  nrs=0.69047619047619 sa=0 sb=0 sd=0 mult=1 m=1
vam_r3_p14 rwl_3 rwlx_r3_p14 dc 0
XM_RD_r3_p14 rbl_p14 sn_r3_p14 rwlx_r3_p14 GND sky130_fd_pr__nfet_01v8 L=0.15 W=0.42 nf=1 ad=0.1218 as=0.1218 pd=1.42 ps=1.42 nrd=0.69047619047619  nrs=0.69047619047619 sa=0 sb=0 sd=0 mult=1 m=1
c_sn_r3_p14 sn_r3_p14 0 6.727410e-16
c_rbl_p14 rbl_p14 0 {C_RBL}
spre_p14 pre rbl_p14 ctl 0 swpre

* ---- instance p15: stored pattern rows3210=1111
v_bl_p15 bl_p15 0 pwl(0 0 {TW0+0*TWSTEP-TEDGE} 0 {TW0+0*TWSTEP} {VDD*1} {TW0+0*TWSTEP+TWPULSE+TBL_LAG} {VDD*1} {TW0+0*TWSTEP+TWPULSE+TBL_LAG+TEDGE} 0 {TW0+1*TWSTEP-TEDGE} 0 {TW0+1*TWSTEP} {VDD*1} {TW0+1*TWSTEP+TWPULSE+TBL_LAG} {VDD*1} {TW0+1*TWSTEP+TWPULSE+TBL_LAG+TEDGE} 0 {TW0+2*TWSTEP-TEDGE} 0 {TW0+2*TWSTEP} {VDD*1} {TW0+2*TWSTEP+TWPULSE+TBL_LAG} {VDD*1} {TW0+2*TWSTEP+TWPULSE+TBL_LAG+TEDGE} 0 {TW0+3*TWSTEP-TEDGE} 0 {TW0+3*TWSTEP} {VDD*1} {TW0+3*TWSTEP+TWPULSE+TBL_LAG} {VDD*1} {TW0+3*TWSTEP+TWPULSE+TBL_LAG+TEDGE} 0)
XM_WR_r0_p15 sn_r0_p15 wl_0 bl_p15 GND sky130_fd_pr__nfet_01v8 L=0.15 W=0.42 nf=1 ad=0.1218 as=0.1218 pd=1.42 ps=1.42 nrd=0.69047619047619  nrs=0.69047619047619 sa=0 sb=0 sd=0 mult=1 m=1
vam_r0_p15 rwl_0 rwlx_r0_p15 dc 0
XM_RD_r0_p15 rbl_p15 sn_r0_p15 rwlx_r0_p15 GND sky130_fd_pr__nfet_01v8 L=0.15 W=0.42 nf=1 ad=0.1218 as=0.1218 pd=1.42 ps=1.42 nrd=0.69047619047619  nrs=0.69047619047619 sa=0 sb=0 sd=0 mult=1 m=1
c_sn_r0_p15 sn_r0_p15 0 6.727410e-16
XM_WR_r1_p15 sn_r1_p15 wl_1 bl_p15 GND sky130_fd_pr__nfet_01v8 L=0.15 W=0.42 nf=1 ad=0.1218 as=0.1218 pd=1.42 ps=1.42 nrd=0.69047619047619  nrs=0.69047619047619 sa=0 sb=0 sd=0 mult=1 m=1
vam_r1_p15 rwl_1 rwlx_r1_p15 dc 0
XM_RD_r1_p15 rbl_p15 sn_r1_p15 rwlx_r1_p15 GND sky130_fd_pr__nfet_01v8 L=0.15 W=0.42 nf=1 ad=0.1218 as=0.1218 pd=1.42 ps=1.42 nrd=0.69047619047619  nrs=0.69047619047619 sa=0 sb=0 sd=0 mult=1 m=1
c_sn_r1_p15 sn_r1_p15 0 6.727410e-16
XM_WR_r2_p15 sn_r2_p15 wl_2 bl_p15 GND sky130_fd_pr__nfet_01v8 L=0.15 W=0.42 nf=1 ad=0.1218 as=0.1218 pd=1.42 ps=1.42 nrd=0.69047619047619  nrs=0.69047619047619 sa=0 sb=0 sd=0 mult=1 m=1
vam_r2_p15 rwl_2 rwlx_r2_p15 dc 0
XM_RD_r2_p15 rbl_p15 sn_r2_p15 rwlx_r2_p15 GND sky130_fd_pr__nfet_01v8 L=0.15 W=0.42 nf=1 ad=0.1218 as=0.1218 pd=1.42 ps=1.42 nrd=0.69047619047619  nrs=0.69047619047619 sa=0 sb=0 sd=0 mult=1 m=1
c_sn_r2_p15 sn_r2_p15 0 6.727410e-16
XM_WR_r3_p15 sn_r3_p15 wl_3 bl_p15 GND sky130_fd_pr__nfet_01v8 L=0.15 W=0.42 nf=1 ad=0.1218 as=0.1218 pd=1.42 ps=1.42 nrd=0.69047619047619  nrs=0.69047619047619 sa=0 sb=0 sd=0 mult=1 m=1
vam_r3_p15 rwl_3 rwlx_r3_p15 dc 0
XM_RD_r3_p15 rbl_p15 sn_r3_p15 rwlx_r3_p15 GND sky130_fd_pr__nfet_01v8 L=0.15 W=0.42 nf=1 ad=0.1218 as=0.1218 pd=1.42 ps=1.42 nrd=0.69047619047619  nrs=0.69047619047619 sa=0 sb=0 sd=0 mult=1 m=1
c_sn_r3_p15 sn_r3_p15 0 6.727410e-16
c_rbl_p15 rbl_p15 0 {C_RBL}
spre_p15 pre rbl_p15 ctl 0 swpre

* initial conditions (no uic: the operating point honours them as constraints)
.ic v(rbl_p00)={VRBL} v(sn_r0_p00)={VDD*1} v(sn_r1_p00)={VDD*1} v(sn_r2_p00)={VDD*1} v(sn_r3_p00)={VDD*1}
.ic v(rbl_p01)={VRBL} v(sn_r0_p01)={VDD*0} v(sn_r1_p01)={VDD*1} v(sn_r2_p01)={VDD*1} v(sn_r3_p01)={VDD*1}
.ic v(rbl_p02)={VRBL} v(sn_r0_p02)={VDD*1} v(sn_r1_p02)={VDD*0} v(sn_r2_p02)={VDD*1} v(sn_r3_p02)={VDD*1}
.ic v(rbl_p03)={VRBL} v(sn_r0_p03)={VDD*0} v(sn_r1_p03)={VDD*0} v(sn_r2_p03)={VDD*1} v(sn_r3_p03)={VDD*1}
.ic v(rbl_p04)={VRBL} v(sn_r0_p04)={VDD*1} v(sn_r1_p04)={VDD*1} v(sn_r2_p04)={VDD*0} v(sn_r3_p04)={VDD*1}
.ic v(rbl_p05)={VRBL} v(sn_r0_p05)={VDD*0} v(sn_r1_p05)={VDD*1} v(sn_r2_p05)={VDD*0} v(sn_r3_p05)={VDD*1}
.ic v(rbl_p06)={VRBL} v(sn_r0_p06)={VDD*1} v(sn_r1_p06)={VDD*0} v(sn_r2_p06)={VDD*0} v(sn_r3_p06)={VDD*1}
.ic v(rbl_p07)={VRBL} v(sn_r0_p07)={VDD*0} v(sn_r1_p07)={VDD*0} v(sn_r2_p07)={VDD*0} v(sn_r3_p07)={VDD*1}
.ic v(rbl_p08)={VRBL} v(sn_r0_p08)={VDD*1} v(sn_r1_p08)={VDD*1} v(sn_r2_p08)={VDD*1} v(sn_r3_p08)={VDD*0}
.ic v(rbl_p09)={VRBL} v(sn_r0_p09)={VDD*0} v(sn_r1_p09)={VDD*1} v(sn_r2_p09)={VDD*1} v(sn_r3_p09)={VDD*0}
.ic v(rbl_p10)={VRBL} v(sn_r0_p10)={VDD*1} v(sn_r1_p10)={VDD*0} v(sn_r2_p10)={VDD*1} v(sn_r3_p10)={VDD*0}
.ic v(rbl_p11)={VRBL} v(sn_r0_p11)={VDD*0} v(sn_r1_p11)={VDD*0} v(sn_r2_p11)={VDD*1} v(sn_r3_p11)={VDD*0}
.ic v(rbl_p12)={VRBL} v(sn_r0_p12)={VDD*1} v(sn_r1_p12)={VDD*1} v(sn_r2_p12)={VDD*0} v(sn_r3_p12)={VDD*0}
.ic v(rbl_p13)={VRBL} v(sn_r0_p13)={VDD*0} v(sn_r1_p13)={VDD*1} v(sn_r2_p13)={VDD*0} v(sn_r3_p13)={VDD*0}
.ic v(rbl_p14)={VRBL} v(sn_r0_p14)={VDD*1} v(sn_r1_p14)={VDD*0} v(sn_r2_p14)={VDD*0} v(sn_r3_p14)={VDD*0}
.ic v(rbl_p15)={VRBL} v(sn_r0_p15)={VDD*0} v(sn_r1_p15)={VDD*0} v(sn_r2_p15)={VDD*0} v(sn_r3_p15)={VDD*0}
