* loaded 4-row 2T column, ref_crbl_10f, age refresh_bound (issue #88). GENERATED by gen_column_klt.py;
* do not edit. CIRCUIT BODY for `klt sim` (no .control/.end; klt appends .lib/.temp).
* 64 independent column instances (4 selected rows x 16 stored patterns), one tran.
* Phase 2 stimulus/timing (sim/loaded-column/tb_loaded_column.spice.tmpl); cards from
* design/gain_cell_2t.spice (design).
* C_RBL = 1e-14 F : ASSUMPTION (contract value). Lumped on rbl; no other extracted
* bitline parasitic is added (the lumped value IS the bitline load, not an addition to it).
* ASSUMPTIONS: 4-row column (STUDY-ASSUMPTION, N_rows not ratified), ideal drivers and
* precharge switch, global corners only, t_sense and latency droop per Phase 2.

.param VDD = 1.8
.param VRBL = 0.9
.param TEDGE = 1e-10
.param TW0 = 1e-09
.param TWSTEP = 2.5e-08
.param TWPULSE = 2e-08
.param TBL_LAG = 2e-09
.param THOLD0 = 1e-07
.param TPRE_GAP = 2e-09
.param TREAD_PULSE = 2e-08
.param TTAIL = 5e-09
.param T_READ = 5.050945e-06
.param VWL = {VDD}
.param C_RBL = 1e-14
.param C_SN = 6.053540e-16
.param T_HLEAD = 2.5e-10
.param T_LATE = 5.075645e-06

* ---- shared ideal sources ----
vwl_0 wl_0 0 pulse(0 {VWL} {TW0+0*TWSTEP} {TEDGE} {TEDGE} {TWPULSE-TEDGE} 1)
vwl_1 wl_1 0 pulse(0 {VWL} {TW0+1*TWSTEP} {TEDGE} {TEDGE} {TWPULSE-TEDGE} 1)
vwl_2 wl_2 0 pulse(0 {VWL} {TW0+2*TWSTEP} {TEDGE} {TEDGE} {TWPULSE-TEDGE} 1)
vwl_3 wl_3 0 pulse(0 {VWL} {TW0+3*TWSTEP} {TEDGE} {TEDGE} {TWPULSE-TEDGE} 1)
vblp00 blp00 0 pwl(0 0 {TW0+0*TWSTEP-TEDGE} 0 {TW0+0*TWSTEP} {VDD*0} {TW0+0*TWSTEP+TWPULSE+TBL_LAG} {VDD*0} {TW0+0*TWSTEP+TWPULSE+TBL_LAG+TEDGE} 0 {TW0+1*TWSTEP-TEDGE} 0 {TW0+1*TWSTEP} {VDD*0} {TW0+1*TWSTEP+TWPULSE+TBL_LAG} {VDD*0} {TW0+1*TWSTEP+TWPULSE+TBL_LAG+TEDGE} 0 {TW0+2*TWSTEP-TEDGE} 0 {TW0+2*TWSTEP} {VDD*0} {TW0+2*TWSTEP+TWPULSE+TBL_LAG} {VDD*0} {TW0+2*TWSTEP+TWPULSE+TBL_LAG+TEDGE} 0 {TW0+3*TWSTEP-TEDGE} 0 {TW0+3*TWSTEP} {VDD*0} {TW0+3*TWSTEP+TWPULSE+TBL_LAG} {VDD*0} {TW0+3*TWSTEP+TWPULSE+TBL_LAG+TEDGE} 0)
vblp01 blp01 0 pwl(0 0 {TW0+0*TWSTEP-TEDGE} 0 {TW0+0*TWSTEP} {VDD*1} {TW0+0*TWSTEP+TWPULSE+TBL_LAG} {VDD*1} {TW0+0*TWSTEP+TWPULSE+TBL_LAG+TEDGE} 0 {TW0+1*TWSTEP-TEDGE} 0 {TW0+1*TWSTEP} {VDD*0} {TW0+1*TWSTEP+TWPULSE+TBL_LAG} {VDD*0} {TW0+1*TWSTEP+TWPULSE+TBL_LAG+TEDGE} 0 {TW0+2*TWSTEP-TEDGE} 0 {TW0+2*TWSTEP} {VDD*0} {TW0+2*TWSTEP+TWPULSE+TBL_LAG} {VDD*0} {TW0+2*TWSTEP+TWPULSE+TBL_LAG+TEDGE} 0 {TW0+3*TWSTEP-TEDGE} 0 {TW0+3*TWSTEP} {VDD*0} {TW0+3*TWSTEP+TWPULSE+TBL_LAG} {VDD*0} {TW0+3*TWSTEP+TWPULSE+TBL_LAG+TEDGE} 0)
vblp02 blp02 0 pwl(0 0 {TW0+0*TWSTEP-TEDGE} 0 {TW0+0*TWSTEP} {VDD*0} {TW0+0*TWSTEP+TWPULSE+TBL_LAG} {VDD*0} {TW0+0*TWSTEP+TWPULSE+TBL_LAG+TEDGE} 0 {TW0+1*TWSTEP-TEDGE} 0 {TW0+1*TWSTEP} {VDD*1} {TW0+1*TWSTEP+TWPULSE+TBL_LAG} {VDD*1} {TW0+1*TWSTEP+TWPULSE+TBL_LAG+TEDGE} 0 {TW0+2*TWSTEP-TEDGE} 0 {TW0+2*TWSTEP} {VDD*0} {TW0+2*TWSTEP+TWPULSE+TBL_LAG} {VDD*0} {TW0+2*TWSTEP+TWPULSE+TBL_LAG+TEDGE} 0 {TW0+3*TWSTEP-TEDGE} 0 {TW0+3*TWSTEP} {VDD*0} {TW0+3*TWSTEP+TWPULSE+TBL_LAG} {VDD*0} {TW0+3*TWSTEP+TWPULSE+TBL_LAG+TEDGE} 0)
vblp03 blp03 0 pwl(0 0 {TW0+0*TWSTEP-TEDGE} 0 {TW0+0*TWSTEP} {VDD*1} {TW0+0*TWSTEP+TWPULSE+TBL_LAG} {VDD*1} {TW0+0*TWSTEP+TWPULSE+TBL_LAG+TEDGE} 0 {TW0+1*TWSTEP-TEDGE} 0 {TW0+1*TWSTEP} {VDD*1} {TW0+1*TWSTEP+TWPULSE+TBL_LAG} {VDD*1} {TW0+1*TWSTEP+TWPULSE+TBL_LAG+TEDGE} 0 {TW0+2*TWSTEP-TEDGE} 0 {TW0+2*TWSTEP} {VDD*0} {TW0+2*TWSTEP+TWPULSE+TBL_LAG} {VDD*0} {TW0+2*TWSTEP+TWPULSE+TBL_LAG+TEDGE} 0 {TW0+3*TWSTEP-TEDGE} 0 {TW0+3*TWSTEP} {VDD*0} {TW0+3*TWSTEP+TWPULSE+TBL_LAG} {VDD*0} {TW0+3*TWSTEP+TWPULSE+TBL_LAG+TEDGE} 0)
vblp04 blp04 0 pwl(0 0 {TW0+0*TWSTEP-TEDGE} 0 {TW0+0*TWSTEP} {VDD*0} {TW0+0*TWSTEP+TWPULSE+TBL_LAG} {VDD*0} {TW0+0*TWSTEP+TWPULSE+TBL_LAG+TEDGE} 0 {TW0+1*TWSTEP-TEDGE} 0 {TW0+1*TWSTEP} {VDD*0} {TW0+1*TWSTEP+TWPULSE+TBL_LAG} {VDD*0} {TW0+1*TWSTEP+TWPULSE+TBL_LAG+TEDGE} 0 {TW0+2*TWSTEP-TEDGE} 0 {TW0+2*TWSTEP} {VDD*1} {TW0+2*TWSTEP+TWPULSE+TBL_LAG} {VDD*1} {TW0+2*TWSTEP+TWPULSE+TBL_LAG+TEDGE} 0 {TW0+3*TWSTEP-TEDGE} 0 {TW0+3*TWSTEP} {VDD*0} {TW0+3*TWSTEP+TWPULSE+TBL_LAG} {VDD*0} {TW0+3*TWSTEP+TWPULSE+TBL_LAG+TEDGE} 0)
vblp05 blp05 0 pwl(0 0 {TW0+0*TWSTEP-TEDGE} 0 {TW0+0*TWSTEP} {VDD*1} {TW0+0*TWSTEP+TWPULSE+TBL_LAG} {VDD*1} {TW0+0*TWSTEP+TWPULSE+TBL_LAG+TEDGE} 0 {TW0+1*TWSTEP-TEDGE} 0 {TW0+1*TWSTEP} {VDD*0} {TW0+1*TWSTEP+TWPULSE+TBL_LAG} {VDD*0} {TW0+1*TWSTEP+TWPULSE+TBL_LAG+TEDGE} 0 {TW0+2*TWSTEP-TEDGE} 0 {TW0+2*TWSTEP} {VDD*1} {TW0+2*TWSTEP+TWPULSE+TBL_LAG} {VDD*1} {TW0+2*TWSTEP+TWPULSE+TBL_LAG+TEDGE} 0 {TW0+3*TWSTEP-TEDGE} 0 {TW0+3*TWSTEP} {VDD*0} {TW0+3*TWSTEP+TWPULSE+TBL_LAG} {VDD*0} {TW0+3*TWSTEP+TWPULSE+TBL_LAG+TEDGE} 0)
vblp06 blp06 0 pwl(0 0 {TW0+0*TWSTEP-TEDGE} 0 {TW0+0*TWSTEP} {VDD*0} {TW0+0*TWSTEP+TWPULSE+TBL_LAG} {VDD*0} {TW0+0*TWSTEP+TWPULSE+TBL_LAG+TEDGE} 0 {TW0+1*TWSTEP-TEDGE} 0 {TW0+1*TWSTEP} {VDD*1} {TW0+1*TWSTEP+TWPULSE+TBL_LAG} {VDD*1} {TW0+1*TWSTEP+TWPULSE+TBL_LAG+TEDGE} 0 {TW0+2*TWSTEP-TEDGE} 0 {TW0+2*TWSTEP} {VDD*1} {TW0+2*TWSTEP+TWPULSE+TBL_LAG} {VDD*1} {TW0+2*TWSTEP+TWPULSE+TBL_LAG+TEDGE} 0 {TW0+3*TWSTEP-TEDGE} 0 {TW0+3*TWSTEP} {VDD*0} {TW0+3*TWSTEP+TWPULSE+TBL_LAG} {VDD*0} {TW0+3*TWSTEP+TWPULSE+TBL_LAG+TEDGE} 0)
vblp07 blp07 0 pwl(0 0 {TW0+0*TWSTEP-TEDGE} 0 {TW0+0*TWSTEP} {VDD*1} {TW0+0*TWSTEP+TWPULSE+TBL_LAG} {VDD*1} {TW0+0*TWSTEP+TWPULSE+TBL_LAG+TEDGE} 0 {TW0+1*TWSTEP-TEDGE} 0 {TW0+1*TWSTEP} {VDD*1} {TW0+1*TWSTEP+TWPULSE+TBL_LAG} {VDD*1} {TW0+1*TWSTEP+TWPULSE+TBL_LAG+TEDGE} 0 {TW0+2*TWSTEP-TEDGE} 0 {TW0+2*TWSTEP} {VDD*1} {TW0+2*TWSTEP+TWPULSE+TBL_LAG} {VDD*1} {TW0+2*TWSTEP+TWPULSE+TBL_LAG+TEDGE} 0 {TW0+3*TWSTEP-TEDGE} 0 {TW0+3*TWSTEP} {VDD*0} {TW0+3*TWSTEP+TWPULSE+TBL_LAG} {VDD*0} {TW0+3*TWSTEP+TWPULSE+TBL_LAG+TEDGE} 0)
vblp08 blp08 0 pwl(0 0 {TW0+0*TWSTEP-TEDGE} 0 {TW0+0*TWSTEP} {VDD*0} {TW0+0*TWSTEP+TWPULSE+TBL_LAG} {VDD*0} {TW0+0*TWSTEP+TWPULSE+TBL_LAG+TEDGE} 0 {TW0+1*TWSTEP-TEDGE} 0 {TW0+1*TWSTEP} {VDD*0} {TW0+1*TWSTEP+TWPULSE+TBL_LAG} {VDD*0} {TW0+1*TWSTEP+TWPULSE+TBL_LAG+TEDGE} 0 {TW0+2*TWSTEP-TEDGE} 0 {TW0+2*TWSTEP} {VDD*0} {TW0+2*TWSTEP+TWPULSE+TBL_LAG} {VDD*0} {TW0+2*TWSTEP+TWPULSE+TBL_LAG+TEDGE} 0 {TW0+3*TWSTEP-TEDGE} 0 {TW0+3*TWSTEP} {VDD*1} {TW0+3*TWSTEP+TWPULSE+TBL_LAG} {VDD*1} {TW0+3*TWSTEP+TWPULSE+TBL_LAG+TEDGE} 0)
vblp09 blp09 0 pwl(0 0 {TW0+0*TWSTEP-TEDGE} 0 {TW0+0*TWSTEP} {VDD*1} {TW0+0*TWSTEP+TWPULSE+TBL_LAG} {VDD*1} {TW0+0*TWSTEP+TWPULSE+TBL_LAG+TEDGE} 0 {TW0+1*TWSTEP-TEDGE} 0 {TW0+1*TWSTEP} {VDD*0} {TW0+1*TWSTEP+TWPULSE+TBL_LAG} {VDD*0} {TW0+1*TWSTEP+TWPULSE+TBL_LAG+TEDGE} 0 {TW0+2*TWSTEP-TEDGE} 0 {TW0+2*TWSTEP} {VDD*0} {TW0+2*TWSTEP+TWPULSE+TBL_LAG} {VDD*0} {TW0+2*TWSTEP+TWPULSE+TBL_LAG+TEDGE} 0 {TW0+3*TWSTEP-TEDGE} 0 {TW0+3*TWSTEP} {VDD*1} {TW0+3*TWSTEP+TWPULSE+TBL_LAG} {VDD*1} {TW0+3*TWSTEP+TWPULSE+TBL_LAG+TEDGE} 0)
vblp10 blp10 0 pwl(0 0 {TW0+0*TWSTEP-TEDGE} 0 {TW0+0*TWSTEP} {VDD*0} {TW0+0*TWSTEP+TWPULSE+TBL_LAG} {VDD*0} {TW0+0*TWSTEP+TWPULSE+TBL_LAG+TEDGE} 0 {TW0+1*TWSTEP-TEDGE} 0 {TW0+1*TWSTEP} {VDD*1} {TW0+1*TWSTEP+TWPULSE+TBL_LAG} {VDD*1} {TW0+1*TWSTEP+TWPULSE+TBL_LAG+TEDGE} 0 {TW0+2*TWSTEP-TEDGE} 0 {TW0+2*TWSTEP} {VDD*0} {TW0+2*TWSTEP+TWPULSE+TBL_LAG} {VDD*0} {TW0+2*TWSTEP+TWPULSE+TBL_LAG+TEDGE} 0 {TW0+3*TWSTEP-TEDGE} 0 {TW0+3*TWSTEP} {VDD*1} {TW0+3*TWSTEP+TWPULSE+TBL_LAG} {VDD*1} {TW0+3*TWSTEP+TWPULSE+TBL_LAG+TEDGE} 0)
vblp11 blp11 0 pwl(0 0 {TW0+0*TWSTEP-TEDGE} 0 {TW0+0*TWSTEP} {VDD*1} {TW0+0*TWSTEP+TWPULSE+TBL_LAG} {VDD*1} {TW0+0*TWSTEP+TWPULSE+TBL_LAG+TEDGE} 0 {TW0+1*TWSTEP-TEDGE} 0 {TW0+1*TWSTEP} {VDD*1} {TW0+1*TWSTEP+TWPULSE+TBL_LAG} {VDD*1} {TW0+1*TWSTEP+TWPULSE+TBL_LAG+TEDGE} 0 {TW0+2*TWSTEP-TEDGE} 0 {TW0+2*TWSTEP} {VDD*0} {TW0+2*TWSTEP+TWPULSE+TBL_LAG} {VDD*0} {TW0+2*TWSTEP+TWPULSE+TBL_LAG+TEDGE} 0 {TW0+3*TWSTEP-TEDGE} 0 {TW0+3*TWSTEP} {VDD*1} {TW0+3*TWSTEP+TWPULSE+TBL_LAG} {VDD*1} {TW0+3*TWSTEP+TWPULSE+TBL_LAG+TEDGE} 0)
vblp12 blp12 0 pwl(0 0 {TW0+0*TWSTEP-TEDGE} 0 {TW0+0*TWSTEP} {VDD*0} {TW0+0*TWSTEP+TWPULSE+TBL_LAG} {VDD*0} {TW0+0*TWSTEP+TWPULSE+TBL_LAG+TEDGE} 0 {TW0+1*TWSTEP-TEDGE} 0 {TW0+1*TWSTEP} {VDD*0} {TW0+1*TWSTEP+TWPULSE+TBL_LAG} {VDD*0} {TW0+1*TWSTEP+TWPULSE+TBL_LAG+TEDGE} 0 {TW0+2*TWSTEP-TEDGE} 0 {TW0+2*TWSTEP} {VDD*1} {TW0+2*TWSTEP+TWPULSE+TBL_LAG} {VDD*1} {TW0+2*TWSTEP+TWPULSE+TBL_LAG+TEDGE} 0 {TW0+3*TWSTEP-TEDGE} 0 {TW0+3*TWSTEP} {VDD*1} {TW0+3*TWSTEP+TWPULSE+TBL_LAG} {VDD*1} {TW0+3*TWSTEP+TWPULSE+TBL_LAG+TEDGE} 0)
vblp13 blp13 0 pwl(0 0 {TW0+0*TWSTEP-TEDGE} 0 {TW0+0*TWSTEP} {VDD*1} {TW0+0*TWSTEP+TWPULSE+TBL_LAG} {VDD*1} {TW0+0*TWSTEP+TWPULSE+TBL_LAG+TEDGE} 0 {TW0+1*TWSTEP-TEDGE} 0 {TW0+1*TWSTEP} {VDD*0} {TW0+1*TWSTEP+TWPULSE+TBL_LAG} {VDD*0} {TW0+1*TWSTEP+TWPULSE+TBL_LAG+TEDGE} 0 {TW0+2*TWSTEP-TEDGE} 0 {TW0+2*TWSTEP} {VDD*1} {TW0+2*TWSTEP+TWPULSE+TBL_LAG} {VDD*1} {TW0+2*TWSTEP+TWPULSE+TBL_LAG+TEDGE} 0 {TW0+3*TWSTEP-TEDGE} 0 {TW0+3*TWSTEP} {VDD*1} {TW0+3*TWSTEP+TWPULSE+TBL_LAG} {VDD*1} {TW0+3*TWSTEP+TWPULSE+TBL_LAG+TEDGE} 0)
vblp14 blp14 0 pwl(0 0 {TW0+0*TWSTEP-TEDGE} 0 {TW0+0*TWSTEP} {VDD*0} {TW0+0*TWSTEP+TWPULSE+TBL_LAG} {VDD*0} {TW0+0*TWSTEP+TWPULSE+TBL_LAG+TEDGE} 0 {TW0+1*TWSTEP-TEDGE} 0 {TW0+1*TWSTEP} {VDD*1} {TW0+1*TWSTEP+TWPULSE+TBL_LAG} {VDD*1} {TW0+1*TWSTEP+TWPULSE+TBL_LAG+TEDGE} 0 {TW0+2*TWSTEP-TEDGE} 0 {TW0+2*TWSTEP} {VDD*1} {TW0+2*TWSTEP+TWPULSE+TBL_LAG} {VDD*1} {TW0+2*TWSTEP+TWPULSE+TBL_LAG+TEDGE} 0 {TW0+3*TWSTEP-TEDGE} 0 {TW0+3*TWSTEP} {VDD*1} {TW0+3*TWSTEP+TWPULSE+TBL_LAG} {VDD*1} {TW0+3*TWSTEP+TWPULSE+TBL_LAG+TEDGE} 0)
vblp15 blp15 0 pwl(0 0 {TW0+0*TWSTEP-TEDGE} 0 {TW0+0*TWSTEP} {VDD*1} {TW0+0*TWSTEP+TWPULSE+TBL_LAG} {VDD*1} {TW0+0*TWSTEP+TWPULSE+TBL_LAG+TEDGE} 0 {TW0+1*TWSTEP-TEDGE} 0 {TW0+1*TWSTEP} {VDD*1} {TW0+1*TWSTEP+TWPULSE+TBL_LAG} {VDD*1} {TW0+1*TWSTEP+TWPULSE+TBL_LAG+TEDGE} 0 {TW0+2*TWSTEP-TEDGE} 0 {TW0+2*TWSTEP} {VDD*1} {TW0+2*TWSTEP+TWPULSE+TBL_LAG} {VDD*1} {TW0+2*TWSTEP+TWPULSE+TBL_LAG+TEDGE} 0 {TW0+3*TWSTEP-TEDGE} 0 {TW0+3*TWSTEP} {VDD*1} {TW0+3*TWSTEP+TWPULSE+TBL_LAG} {VDD*1} {TW0+3*TWSTEP+TWPULSE+TBL_LAG+TEDGE} 0)
vrwls rwls 0 pwl(0 {VDD} {T_READ} {VDD} {T_READ+TEDGE} 0 {T_READ+TREAD_PULSE} 0 {T_READ+TREAD_PULSE+TEDGE} {VDD})
vrwld rwld 0 dc {VDD}
vpre pre 0 dc {VRBL}
vctl ctl 0 pwl(0 {VDD} {T_READ-TPRE_GAP} {VDD} {T_READ-TPRE_GAP+TEDGE} 0)
vhctl hctl 0 pwl(0 {VDD} {T_READ-T_HLEAD} {VDD} {T_READ-T_HLEAD+TEDGE} 0)
vlate late 0 pwl(0 0 {T_LATE} 0 {T_LATE+TEDGE} 2)
.model swpre sw(vt=0.9 vh=0.1 ron=100 roff=1e12)

* ---- case s0p00: selected row 0, pattern rows3210 0000 ----
XM_WR_0_0_s0p00 sn0_s0p00 wl_0 blp00 GND sky130_fd_pr__nfet_01v8 L=0.15 W=0.42 nf=1 ad=0.1218 as=0.1218 pd=1.42 ps=1.42 nrd=0.69047619047619  nrs=0.69047619047619 sa=0 sb=0 sd=0 mult=1 m=1
XM_RD_0_0_s0p00 rbl_s0p00 sn0_s0p00 rwls GND sky130_fd_pr__nfet_01v8 L=0.15 W=0.42 nf=1 ad=0.1218 as=0.1218 pd=1.42 ps=1.42 nrd=0.69047619047619  nrs=0.69047619047619 sa=0 sb=0 sd=0 mult=1 m=1
XM_WR_1_0_s0p00 sn1_s0p00 wl_1 blp00 GND sky130_fd_pr__nfet_01v8 L=0.15 W=0.42 nf=1 ad=0.1218 as=0.1218 pd=1.42 ps=1.42 nrd=0.69047619047619  nrs=0.69047619047619 sa=0 sb=0 sd=0 mult=1 m=1
XM_RD_1_0_s0p00 rbl_s0p00 sn1_s0p00 rwld GND sky130_fd_pr__nfet_01v8 L=0.15 W=0.42 nf=1 ad=0.1218 as=0.1218 pd=1.42 ps=1.42 nrd=0.69047619047619  nrs=0.69047619047619 sa=0 sb=0 sd=0 mult=1 m=1
XM_WR_2_0_s0p00 sn2_s0p00 wl_2 blp00 GND sky130_fd_pr__nfet_01v8 L=0.15 W=0.42 nf=1 ad=0.1218 as=0.1218 pd=1.42 ps=1.42 nrd=0.69047619047619  nrs=0.69047619047619 sa=0 sb=0 sd=0 mult=1 m=1
XM_RD_2_0_s0p00 rbl_s0p00 sn2_s0p00 rwld GND sky130_fd_pr__nfet_01v8 L=0.15 W=0.42 nf=1 ad=0.1218 as=0.1218 pd=1.42 ps=1.42 nrd=0.69047619047619  nrs=0.69047619047619 sa=0 sb=0 sd=0 mult=1 m=1
XM_WR_3_0_s0p00 sn3_s0p00 wl_3 blp00 GND sky130_fd_pr__nfet_01v8 L=0.15 W=0.42 nf=1 ad=0.1218 as=0.1218 pd=1.42 ps=1.42 nrd=0.69047619047619  nrs=0.69047619047619 sa=0 sb=0 sd=0 mult=1 m=1
XM_RD_3_0_s0p00 rbl_s0p00 sn3_s0p00 rwld GND sky130_fd_pr__nfet_01v8 L=0.15 W=0.42 nf=1 ad=0.1218 as=0.1218 pd=1.42 ps=1.42 nrd=0.69047619047619  nrs=0.69047619047619 sa=0 sb=0 sd=0 mult=1 m=1
csn0_s0p00 sn0_s0p00 0 {C_SN}
csn1_s0p00 sn1_s0p00 0 {C_SN}
csn2_s0p00 sn2_s0p00 0 {C_SN}
csn3_s0p00 sn3_s0p00 0 {C_SN}
crbl_s0p00 rbl_s0p00 0 {C_RBL}
spre_s0p00 pre rbl_s0p00 ctl 0 swpre
ehb_s0p00 hb_s0p00 0 rbl_s0p00 0 1
shb_s0p00 hb_s0p00 hold_s0p00 hctl 0 swpre
chold_s0p00 hold_s0p00 0 1e-12
bdl_s0p00 dl_s0p00 0 v=v(rbl_s0p00)-v(hold_s0p00)+0.1-v(late)

* ---- case s0p01: selected row 0, pattern rows3210 0001 ----
XM_WR_0_0_s0p01 sn0_s0p01 wl_0 blp01 GND sky130_fd_pr__nfet_01v8 L=0.15 W=0.42 nf=1 ad=0.1218 as=0.1218 pd=1.42 ps=1.42 nrd=0.69047619047619  nrs=0.69047619047619 sa=0 sb=0 sd=0 mult=1 m=1
XM_RD_0_0_s0p01 rbl_s0p01 sn0_s0p01 rwls GND sky130_fd_pr__nfet_01v8 L=0.15 W=0.42 nf=1 ad=0.1218 as=0.1218 pd=1.42 ps=1.42 nrd=0.69047619047619  nrs=0.69047619047619 sa=0 sb=0 sd=0 mult=1 m=1
XM_WR_1_0_s0p01 sn1_s0p01 wl_1 blp01 GND sky130_fd_pr__nfet_01v8 L=0.15 W=0.42 nf=1 ad=0.1218 as=0.1218 pd=1.42 ps=1.42 nrd=0.69047619047619  nrs=0.69047619047619 sa=0 sb=0 sd=0 mult=1 m=1
XM_RD_1_0_s0p01 rbl_s0p01 sn1_s0p01 rwld GND sky130_fd_pr__nfet_01v8 L=0.15 W=0.42 nf=1 ad=0.1218 as=0.1218 pd=1.42 ps=1.42 nrd=0.69047619047619  nrs=0.69047619047619 sa=0 sb=0 sd=0 mult=1 m=1
XM_WR_2_0_s0p01 sn2_s0p01 wl_2 blp01 GND sky130_fd_pr__nfet_01v8 L=0.15 W=0.42 nf=1 ad=0.1218 as=0.1218 pd=1.42 ps=1.42 nrd=0.69047619047619  nrs=0.69047619047619 sa=0 sb=0 sd=0 mult=1 m=1
XM_RD_2_0_s0p01 rbl_s0p01 sn2_s0p01 rwld GND sky130_fd_pr__nfet_01v8 L=0.15 W=0.42 nf=1 ad=0.1218 as=0.1218 pd=1.42 ps=1.42 nrd=0.69047619047619  nrs=0.69047619047619 sa=0 sb=0 sd=0 mult=1 m=1
XM_WR_3_0_s0p01 sn3_s0p01 wl_3 blp01 GND sky130_fd_pr__nfet_01v8 L=0.15 W=0.42 nf=1 ad=0.1218 as=0.1218 pd=1.42 ps=1.42 nrd=0.69047619047619  nrs=0.69047619047619 sa=0 sb=0 sd=0 mult=1 m=1
XM_RD_3_0_s0p01 rbl_s0p01 sn3_s0p01 rwld GND sky130_fd_pr__nfet_01v8 L=0.15 W=0.42 nf=1 ad=0.1218 as=0.1218 pd=1.42 ps=1.42 nrd=0.69047619047619  nrs=0.69047619047619 sa=0 sb=0 sd=0 mult=1 m=1
csn0_s0p01 sn0_s0p01 0 {C_SN}
csn1_s0p01 sn1_s0p01 0 {C_SN}
csn2_s0p01 sn2_s0p01 0 {C_SN}
csn3_s0p01 sn3_s0p01 0 {C_SN}
crbl_s0p01 rbl_s0p01 0 {C_RBL}
spre_s0p01 pre rbl_s0p01 ctl 0 swpre
ehb_s0p01 hb_s0p01 0 rbl_s0p01 0 1
shb_s0p01 hb_s0p01 hold_s0p01 hctl 0 swpre
chold_s0p01 hold_s0p01 0 1e-12
bdl_s0p01 dl_s0p01 0 v=v(rbl_s0p01)-v(hold_s0p01)+0.1-v(late)

* ---- case s0p02: selected row 0, pattern rows3210 0010 ----
XM_WR_0_0_s0p02 sn0_s0p02 wl_0 blp02 GND sky130_fd_pr__nfet_01v8 L=0.15 W=0.42 nf=1 ad=0.1218 as=0.1218 pd=1.42 ps=1.42 nrd=0.69047619047619  nrs=0.69047619047619 sa=0 sb=0 sd=0 mult=1 m=1
XM_RD_0_0_s0p02 rbl_s0p02 sn0_s0p02 rwls GND sky130_fd_pr__nfet_01v8 L=0.15 W=0.42 nf=1 ad=0.1218 as=0.1218 pd=1.42 ps=1.42 nrd=0.69047619047619  nrs=0.69047619047619 sa=0 sb=0 sd=0 mult=1 m=1
XM_WR_1_0_s0p02 sn1_s0p02 wl_1 blp02 GND sky130_fd_pr__nfet_01v8 L=0.15 W=0.42 nf=1 ad=0.1218 as=0.1218 pd=1.42 ps=1.42 nrd=0.69047619047619  nrs=0.69047619047619 sa=0 sb=0 sd=0 mult=1 m=1
XM_RD_1_0_s0p02 rbl_s0p02 sn1_s0p02 rwld GND sky130_fd_pr__nfet_01v8 L=0.15 W=0.42 nf=1 ad=0.1218 as=0.1218 pd=1.42 ps=1.42 nrd=0.69047619047619  nrs=0.69047619047619 sa=0 sb=0 sd=0 mult=1 m=1
XM_WR_2_0_s0p02 sn2_s0p02 wl_2 blp02 GND sky130_fd_pr__nfet_01v8 L=0.15 W=0.42 nf=1 ad=0.1218 as=0.1218 pd=1.42 ps=1.42 nrd=0.69047619047619  nrs=0.69047619047619 sa=0 sb=0 sd=0 mult=1 m=1
XM_RD_2_0_s0p02 rbl_s0p02 sn2_s0p02 rwld GND sky130_fd_pr__nfet_01v8 L=0.15 W=0.42 nf=1 ad=0.1218 as=0.1218 pd=1.42 ps=1.42 nrd=0.69047619047619  nrs=0.69047619047619 sa=0 sb=0 sd=0 mult=1 m=1
XM_WR_3_0_s0p02 sn3_s0p02 wl_3 blp02 GND sky130_fd_pr__nfet_01v8 L=0.15 W=0.42 nf=1 ad=0.1218 as=0.1218 pd=1.42 ps=1.42 nrd=0.69047619047619  nrs=0.69047619047619 sa=0 sb=0 sd=0 mult=1 m=1
XM_RD_3_0_s0p02 rbl_s0p02 sn3_s0p02 rwld GND sky130_fd_pr__nfet_01v8 L=0.15 W=0.42 nf=1 ad=0.1218 as=0.1218 pd=1.42 ps=1.42 nrd=0.69047619047619  nrs=0.69047619047619 sa=0 sb=0 sd=0 mult=1 m=1
csn0_s0p02 sn0_s0p02 0 {C_SN}
csn1_s0p02 sn1_s0p02 0 {C_SN}
csn2_s0p02 sn2_s0p02 0 {C_SN}
csn3_s0p02 sn3_s0p02 0 {C_SN}
crbl_s0p02 rbl_s0p02 0 {C_RBL}
spre_s0p02 pre rbl_s0p02 ctl 0 swpre
ehb_s0p02 hb_s0p02 0 rbl_s0p02 0 1
shb_s0p02 hb_s0p02 hold_s0p02 hctl 0 swpre
chold_s0p02 hold_s0p02 0 1e-12
bdl_s0p02 dl_s0p02 0 v=v(rbl_s0p02)-v(hold_s0p02)+0.1-v(late)

* ---- case s0p03: selected row 0, pattern rows3210 0011 ----
XM_WR_0_0_s0p03 sn0_s0p03 wl_0 blp03 GND sky130_fd_pr__nfet_01v8 L=0.15 W=0.42 nf=1 ad=0.1218 as=0.1218 pd=1.42 ps=1.42 nrd=0.69047619047619  nrs=0.69047619047619 sa=0 sb=0 sd=0 mult=1 m=1
XM_RD_0_0_s0p03 rbl_s0p03 sn0_s0p03 rwls GND sky130_fd_pr__nfet_01v8 L=0.15 W=0.42 nf=1 ad=0.1218 as=0.1218 pd=1.42 ps=1.42 nrd=0.69047619047619  nrs=0.69047619047619 sa=0 sb=0 sd=0 mult=1 m=1
XM_WR_1_0_s0p03 sn1_s0p03 wl_1 blp03 GND sky130_fd_pr__nfet_01v8 L=0.15 W=0.42 nf=1 ad=0.1218 as=0.1218 pd=1.42 ps=1.42 nrd=0.69047619047619  nrs=0.69047619047619 sa=0 sb=0 sd=0 mult=1 m=1
XM_RD_1_0_s0p03 rbl_s0p03 sn1_s0p03 rwld GND sky130_fd_pr__nfet_01v8 L=0.15 W=0.42 nf=1 ad=0.1218 as=0.1218 pd=1.42 ps=1.42 nrd=0.69047619047619  nrs=0.69047619047619 sa=0 sb=0 sd=0 mult=1 m=1
XM_WR_2_0_s0p03 sn2_s0p03 wl_2 blp03 GND sky130_fd_pr__nfet_01v8 L=0.15 W=0.42 nf=1 ad=0.1218 as=0.1218 pd=1.42 ps=1.42 nrd=0.69047619047619  nrs=0.69047619047619 sa=0 sb=0 sd=0 mult=1 m=1
XM_RD_2_0_s0p03 rbl_s0p03 sn2_s0p03 rwld GND sky130_fd_pr__nfet_01v8 L=0.15 W=0.42 nf=1 ad=0.1218 as=0.1218 pd=1.42 ps=1.42 nrd=0.69047619047619  nrs=0.69047619047619 sa=0 sb=0 sd=0 mult=1 m=1
XM_WR_3_0_s0p03 sn3_s0p03 wl_3 blp03 GND sky130_fd_pr__nfet_01v8 L=0.15 W=0.42 nf=1 ad=0.1218 as=0.1218 pd=1.42 ps=1.42 nrd=0.69047619047619  nrs=0.69047619047619 sa=0 sb=0 sd=0 mult=1 m=1
XM_RD_3_0_s0p03 rbl_s0p03 sn3_s0p03 rwld GND sky130_fd_pr__nfet_01v8 L=0.15 W=0.42 nf=1 ad=0.1218 as=0.1218 pd=1.42 ps=1.42 nrd=0.69047619047619  nrs=0.69047619047619 sa=0 sb=0 sd=0 mult=1 m=1
csn0_s0p03 sn0_s0p03 0 {C_SN}
csn1_s0p03 sn1_s0p03 0 {C_SN}
csn2_s0p03 sn2_s0p03 0 {C_SN}
csn3_s0p03 sn3_s0p03 0 {C_SN}
crbl_s0p03 rbl_s0p03 0 {C_RBL}
spre_s0p03 pre rbl_s0p03 ctl 0 swpre
ehb_s0p03 hb_s0p03 0 rbl_s0p03 0 1
shb_s0p03 hb_s0p03 hold_s0p03 hctl 0 swpre
chold_s0p03 hold_s0p03 0 1e-12
bdl_s0p03 dl_s0p03 0 v=v(rbl_s0p03)-v(hold_s0p03)+0.1-v(late)

* ---- case s0p04: selected row 0, pattern rows3210 0100 ----
XM_WR_0_0_s0p04 sn0_s0p04 wl_0 blp04 GND sky130_fd_pr__nfet_01v8 L=0.15 W=0.42 nf=1 ad=0.1218 as=0.1218 pd=1.42 ps=1.42 nrd=0.69047619047619  nrs=0.69047619047619 sa=0 sb=0 sd=0 mult=1 m=1
XM_RD_0_0_s0p04 rbl_s0p04 sn0_s0p04 rwls GND sky130_fd_pr__nfet_01v8 L=0.15 W=0.42 nf=1 ad=0.1218 as=0.1218 pd=1.42 ps=1.42 nrd=0.69047619047619  nrs=0.69047619047619 sa=0 sb=0 sd=0 mult=1 m=1
XM_WR_1_0_s0p04 sn1_s0p04 wl_1 blp04 GND sky130_fd_pr__nfet_01v8 L=0.15 W=0.42 nf=1 ad=0.1218 as=0.1218 pd=1.42 ps=1.42 nrd=0.69047619047619  nrs=0.69047619047619 sa=0 sb=0 sd=0 mult=1 m=1
XM_RD_1_0_s0p04 rbl_s0p04 sn1_s0p04 rwld GND sky130_fd_pr__nfet_01v8 L=0.15 W=0.42 nf=1 ad=0.1218 as=0.1218 pd=1.42 ps=1.42 nrd=0.69047619047619  nrs=0.69047619047619 sa=0 sb=0 sd=0 mult=1 m=1
XM_WR_2_0_s0p04 sn2_s0p04 wl_2 blp04 GND sky130_fd_pr__nfet_01v8 L=0.15 W=0.42 nf=1 ad=0.1218 as=0.1218 pd=1.42 ps=1.42 nrd=0.69047619047619  nrs=0.69047619047619 sa=0 sb=0 sd=0 mult=1 m=1
XM_RD_2_0_s0p04 rbl_s0p04 sn2_s0p04 rwld GND sky130_fd_pr__nfet_01v8 L=0.15 W=0.42 nf=1 ad=0.1218 as=0.1218 pd=1.42 ps=1.42 nrd=0.69047619047619  nrs=0.69047619047619 sa=0 sb=0 sd=0 mult=1 m=1
XM_WR_3_0_s0p04 sn3_s0p04 wl_3 blp04 GND sky130_fd_pr__nfet_01v8 L=0.15 W=0.42 nf=1 ad=0.1218 as=0.1218 pd=1.42 ps=1.42 nrd=0.69047619047619  nrs=0.69047619047619 sa=0 sb=0 sd=0 mult=1 m=1
XM_RD_3_0_s0p04 rbl_s0p04 sn3_s0p04 rwld GND sky130_fd_pr__nfet_01v8 L=0.15 W=0.42 nf=1 ad=0.1218 as=0.1218 pd=1.42 ps=1.42 nrd=0.69047619047619  nrs=0.69047619047619 sa=0 sb=0 sd=0 mult=1 m=1
csn0_s0p04 sn0_s0p04 0 {C_SN}
csn1_s0p04 sn1_s0p04 0 {C_SN}
csn2_s0p04 sn2_s0p04 0 {C_SN}
csn3_s0p04 sn3_s0p04 0 {C_SN}
crbl_s0p04 rbl_s0p04 0 {C_RBL}
spre_s0p04 pre rbl_s0p04 ctl 0 swpre
ehb_s0p04 hb_s0p04 0 rbl_s0p04 0 1
shb_s0p04 hb_s0p04 hold_s0p04 hctl 0 swpre
chold_s0p04 hold_s0p04 0 1e-12
bdl_s0p04 dl_s0p04 0 v=v(rbl_s0p04)-v(hold_s0p04)+0.1-v(late)

* ---- case s0p05: selected row 0, pattern rows3210 0101 ----
XM_WR_0_0_s0p05 sn0_s0p05 wl_0 blp05 GND sky130_fd_pr__nfet_01v8 L=0.15 W=0.42 nf=1 ad=0.1218 as=0.1218 pd=1.42 ps=1.42 nrd=0.69047619047619  nrs=0.69047619047619 sa=0 sb=0 sd=0 mult=1 m=1
XM_RD_0_0_s0p05 rbl_s0p05 sn0_s0p05 rwls GND sky130_fd_pr__nfet_01v8 L=0.15 W=0.42 nf=1 ad=0.1218 as=0.1218 pd=1.42 ps=1.42 nrd=0.69047619047619  nrs=0.69047619047619 sa=0 sb=0 sd=0 mult=1 m=1
XM_WR_1_0_s0p05 sn1_s0p05 wl_1 blp05 GND sky130_fd_pr__nfet_01v8 L=0.15 W=0.42 nf=1 ad=0.1218 as=0.1218 pd=1.42 ps=1.42 nrd=0.69047619047619  nrs=0.69047619047619 sa=0 sb=0 sd=0 mult=1 m=1
XM_RD_1_0_s0p05 rbl_s0p05 sn1_s0p05 rwld GND sky130_fd_pr__nfet_01v8 L=0.15 W=0.42 nf=1 ad=0.1218 as=0.1218 pd=1.42 ps=1.42 nrd=0.69047619047619  nrs=0.69047619047619 sa=0 sb=0 sd=0 mult=1 m=1
XM_WR_2_0_s0p05 sn2_s0p05 wl_2 blp05 GND sky130_fd_pr__nfet_01v8 L=0.15 W=0.42 nf=1 ad=0.1218 as=0.1218 pd=1.42 ps=1.42 nrd=0.69047619047619  nrs=0.69047619047619 sa=0 sb=0 sd=0 mult=1 m=1
XM_RD_2_0_s0p05 rbl_s0p05 sn2_s0p05 rwld GND sky130_fd_pr__nfet_01v8 L=0.15 W=0.42 nf=1 ad=0.1218 as=0.1218 pd=1.42 ps=1.42 nrd=0.69047619047619  nrs=0.69047619047619 sa=0 sb=0 sd=0 mult=1 m=1
XM_WR_3_0_s0p05 sn3_s0p05 wl_3 blp05 GND sky130_fd_pr__nfet_01v8 L=0.15 W=0.42 nf=1 ad=0.1218 as=0.1218 pd=1.42 ps=1.42 nrd=0.69047619047619  nrs=0.69047619047619 sa=0 sb=0 sd=0 mult=1 m=1
XM_RD_3_0_s0p05 rbl_s0p05 sn3_s0p05 rwld GND sky130_fd_pr__nfet_01v8 L=0.15 W=0.42 nf=1 ad=0.1218 as=0.1218 pd=1.42 ps=1.42 nrd=0.69047619047619  nrs=0.69047619047619 sa=0 sb=0 sd=0 mult=1 m=1
csn0_s0p05 sn0_s0p05 0 {C_SN}
csn1_s0p05 sn1_s0p05 0 {C_SN}
csn2_s0p05 sn2_s0p05 0 {C_SN}
csn3_s0p05 sn3_s0p05 0 {C_SN}
crbl_s0p05 rbl_s0p05 0 {C_RBL}
spre_s0p05 pre rbl_s0p05 ctl 0 swpre
ehb_s0p05 hb_s0p05 0 rbl_s0p05 0 1
shb_s0p05 hb_s0p05 hold_s0p05 hctl 0 swpre
chold_s0p05 hold_s0p05 0 1e-12
bdl_s0p05 dl_s0p05 0 v=v(rbl_s0p05)-v(hold_s0p05)+0.1-v(late)

* ---- case s0p06: selected row 0, pattern rows3210 0110 ----
XM_WR_0_0_s0p06 sn0_s0p06 wl_0 blp06 GND sky130_fd_pr__nfet_01v8 L=0.15 W=0.42 nf=1 ad=0.1218 as=0.1218 pd=1.42 ps=1.42 nrd=0.69047619047619  nrs=0.69047619047619 sa=0 sb=0 sd=0 mult=1 m=1
XM_RD_0_0_s0p06 rbl_s0p06 sn0_s0p06 rwls GND sky130_fd_pr__nfet_01v8 L=0.15 W=0.42 nf=1 ad=0.1218 as=0.1218 pd=1.42 ps=1.42 nrd=0.69047619047619  nrs=0.69047619047619 sa=0 sb=0 sd=0 mult=1 m=1
XM_WR_1_0_s0p06 sn1_s0p06 wl_1 blp06 GND sky130_fd_pr__nfet_01v8 L=0.15 W=0.42 nf=1 ad=0.1218 as=0.1218 pd=1.42 ps=1.42 nrd=0.69047619047619  nrs=0.69047619047619 sa=0 sb=0 sd=0 mult=1 m=1
XM_RD_1_0_s0p06 rbl_s0p06 sn1_s0p06 rwld GND sky130_fd_pr__nfet_01v8 L=0.15 W=0.42 nf=1 ad=0.1218 as=0.1218 pd=1.42 ps=1.42 nrd=0.69047619047619  nrs=0.69047619047619 sa=0 sb=0 sd=0 mult=1 m=1
XM_WR_2_0_s0p06 sn2_s0p06 wl_2 blp06 GND sky130_fd_pr__nfet_01v8 L=0.15 W=0.42 nf=1 ad=0.1218 as=0.1218 pd=1.42 ps=1.42 nrd=0.69047619047619  nrs=0.69047619047619 sa=0 sb=0 sd=0 mult=1 m=1
XM_RD_2_0_s0p06 rbl_s0p06 sn2_s0p06 rwld GND sky130_fd_pr__nfet_01v8 L=0.15 W=0.42 nf=1 ad=0.1218 as=0.1218 pd=1.42 ps=1.42 nrd=0.69047619047619  nrs=0.69047619047619 sa=0 sb=0 sd=0 mult=1 m=1
XM_WR_3_0_s0p06 sn3_s0p06 wl_3 blp06 GND sky130_fd_pr__nfet_01v8 L=0.15 W=0.42 nf=1 ad=0.1218 as=0.1218 pd=1.42 ps=1.42 nrd=0.69047619047619  nrs=0.69047619047619 sa=0 sb=0 sd=0 mult=1 m=1
XM_RD_3_0_s0p06 rbl_s0p06 sn3_s0p06 rwld GND sky130_fd_pr__nfet_01v8 L=0.15 W=0.42 nf=1 ad=0.1218 as=0.1218 pd=1.42 ps=1.42 nrd=0.69047619047619  nrs=0.69047619047619 sa=0 sb=0 sd=0 mult=1 m=1
csn0_s0p06 sn0_s0p06 0 {C_SN}
csn1_s0p06 sn1_s0p06 0 {C_SN}
csn2_s0p06 sn2_s0p06 0 {C_SN}
csn3_s0p06 sn3_s0p06 0 {C_SN}
crbl_s0p06 rbl_s0p06 0 {C_RBL}
spre_s0p06 pre rbl_s0p06 ctl 0 swpre
ehb_s0p06 hb_s0p06 0 rbl_s0p06 0 1
shb_s0p06 hb_s0p06 hold_s0p06 hctl 0 swpre
chold_s0p06 hold_s0p06 0 1e-12
bdl_s0p06 dl_s0p06 0 v=v(rbl_s0p06)-v(hold_s0p06)+0.1-v(late)

* ---- case s0p07: selected row 0, pattern rows3210 0111 ----
XM_WR_0_0_s0p07 sn0_s0p07 wl_0 blp07 GND sky130_fd_pr__nfet_01v8 L=0.15 W=0.42 nf=1 ad=0.1218 as=0.1218 pd=1.42 ps=1.42 nrd=0.69047619047619  nrs=0.69047619047619 sa=0 sb=0 sd=0 mult=1 m=1
XM_RD_0_0_s0p07 rbl_s0p07 sn0_s0p07 rwls GND sky130_fd_pr__nfet_01v8 L=0.15 W=0.42 nf=1 ad=0.1218 as=0.1218 pd=1.42 ps=1.42 nrd=0.69047619047619  nrs=0.69047619047619 sa=0 sb=0 sd=0 mult=1 m=1
XM_WR_1_0_s0p07 sn1_s0p07 wl_1 blp07 GND sky130_fd_pr__nfet_01v8 L=0.15 W=0.42 nf=1 ad=0.1218 as=0.1218 pd=1.42 ps=1.42 nrd=0.69047619047619  nrs=0.69047619047619 sa=0 sb=0 sd=0 mult=1 m=1
XM_RD_1_0_s0p07 rbl_s0p07 sn1_s0p07 rwld GND sky130_fd_pr__nfet_01v8 L=0.15 W=0.42 nf=1 ad=0.1218 as=0.1218 pd=1.42 ps=1.42 nrd=0.69047619047619  nrs=0.69047619047619 sa=0 sb=0 sd=0 mult=1 m=1
XM_WR_2_0_s0p07 sn2_s0p07 wl_2 blp07 GND sky130_fd_pr__nfet_01v8 L=0.15 W=0.42 nf=1 ad=0.1218 as=0.1218 pd=1.42 ps=1.42 nrd=0.69047619047619  nrs=0.69047619047619 sa=0 sb=0 sd=0 mult=1 m=1
XM_RD_2_0_s0p07 rbl_s0p07 sn2_s0p07 rwld GND sky130_fd_pr__nfet_01v8 L=0.15 W=0.42 nf=1 ad=0.1218 as=0.1218 pd=1.42 ps=1.42 nrd=0.69047619047619  nrs=0.69047619047619 sa=0 sb=0 sd=0 mult=1 m=1
XM_WR_3_0_s0p07 sn3_s0p07 wl_3 blp07 GND sky130_fd_pr__nfet_01v8 L=0.15 W=0.42 nf=1 ad=0.1218 as=0.1218 pd=1.42 ps=1.42 nrd=0.69047619047619  nrs=0.69047619047619 sa=0 sb=0 sd=0 mult=1 m=1
XM_RD_3_0_s0p07 rbl_s0p07 sn3_s0p07 rwld GND sky130_fd_pr__nfet_01v8 L=0.15 W=0.42 nf=1 ad=0.1218 as=0.1218 pd=1.42 ps=1.42 nrd=0.69047619047619  nrs=0.69047619047619 sa=0 sb=0 sd=0 mult=1 m=1
csn0_s0p07 sn0_s0p07 0 {C_SN}
csn1_s0p07 sn1_s0p07 0 {C_SN}
csn2_s0p07 sn2_s0p07 0 {C_SN}
csn3_s0p07 sn3_s0p07 0 {C_SN}
crbl_s0p07 rbl_s0p07 0 {C_RBL}
spre_s0p07 pre rbl_s0p07 ctl 0 swpre
ehb_s0p07 hb_s0p07 0 rbl_s0p07 0 1
shb_s0p07 hb_s0p07 hold_s0p07 hctl 0 swpre
chold_s0p07 hold_s0p07 0 1e-12
bdl_s0p07 dl_s0p07 0 v=v(rbl_s0p07)-v(hold_s0p07)+0.1-v(late)

* ---- case s0p08: selected row 0, pattern rows3210 1000 ----
XM_WR_0_0_s0p08 sn0_s0p08 wl_0 blp08 GND sky130_fd_pr__nfet_01v8 L=0.15 W=0.42 nf=1 ad=0.1218 as=0.1218 pd=1.42 ps=1.42 nrd=0.69047619047619  nrs=0.69047619047619 sa=0 sb=0 sd=0 mult=1 m=1
XM_RD_0_0_s0p08 rbl_s0p08 sn0_s0p08 rwls GND sky130_fd_pr__nfet_01v8 L=0.15 W=0.42 nf=1 ad=0.1218 as=0.1218 pd=1.42 ps=1.42 nrd=0.69047619047619  nrs=0.69047619047619 sa=0 sb=0 sd=0 mult=1 m=1
XM_WR_1_0_s0p08 sn1_s0p08 wl_1 blp08 GND sky130_fd_pr__nfet_01v8 L=0.15 W=0.42 nf=1 ad=0.1218 as=0.1218 pd=1.42 ps=1.42 nrd=0.69047619047619  nrs=0.69047619047619 sa=0 sb=0 sd=0 mult=1 m=1
XM_RD_1_0_s0p08 rbl_s0p08 sn1_s0p08 rwld GND sky130_fd_pr__nfet_01v8 L=0.15 W=0.42 nf=1 ad=0.1218 as=0.1218 pd=1.42 ps=1.42 nrd=0.69047619047619  nrs=0.69047619047619 sa=0 sb=0 sd=0 mult=1 m=1
XM_WR_2_0_s0p08 sn2_s0p08 wl_2 blp08 GND sky130_fd_pr__nfet_01v8 L=0.15 W=0.42 nf=1 ad=0.1218 as=0.1218 pd=1.42 ps=1.42 nrd=0.69047619047619  nrs=0.69047619047619 sa=0 sb=0 sd=0 mult=1 m=1
XM_RD_2_0_s0p08 rbl_s0p08 sn2_s0p08 rwld GND sky130_fd_pr__nfet_01v8 L=0.15 W=0.42 nf=1 ad=0.1218 as=0.1218 pd=1.42 ps=1.42 nrd=0.69047619047619  nrs=0.69047619047619 sa=0 sb=0 sd=0 mult=1 m=1
XM_WR_3_0_s0p08 sn3_s0p08 wl_3 blp08 GND sky130_fd_pr__nfet_01v8 L=0.15 W=0.42 nf=1 ad=0.1218 as=0.1218 pd=1.42 ps=1.42 nrd=0.69047619047619  nrs=0.69047619047619 sa=0 sb=0 sd=0 mult=1 m=1
XM_RD_3_0_s0p08 rbl_s0p08 sn3_s0p08 rwld GND sky130_fd_pr__nfet_01v8 L=0.15 W=0.42 nf=1 ad=0.1218 as=0.1218 pd=1.42 ps=1.42 nrd=0.69047619047619  nrs=0.69047619047619 sa=0 sb=0 sd=0 mult=1 m=1
csn0_s0p08 sn0_s0p08 0 {C_SN}
csn1_s0p08 sn1_s0p08 0 {C_SN}
csn2_s0p08 sn2_s0p08 0 {C_SN}
csn3_s0p08 sn3_s0p08 0 {C_SN}
crbl_s0p08 rbl_s0p08 0 {C_RBL}
spre_s0p08 pre rbl_s0p08 ctl 0 swpre
ehb_s0p08 hb_s0p08 0 rbl_s0p08 0 1
shb_s0p08 hb_s0p08 hold_s0p08 hctl 0 swpre
chold_s0p08 hold_s0p08 0 1e-12
bdl_s0p08 dl_s0p08 0 v=v(rbl_s0p08)-v(hold_s0p08)+0.1-v(late)

* ---- case s0p09: selected row 0, pattern rows3210 1001 ----
XM_WR_0_0_s0p09 sn0_s0p09 wl_0 blp09 GND sky130_fd_pr__nfet_01v8 L=0.15 W=0.42 nf=1 ad=0.1218 as=0.1218 pd=1.42 ps=1.42 nrd=0.69047619047619  nrs=0.69047619047619 sa=0 sb=0 sd=0 mult=1 m=1
XM_RD_0_0_s0p09 rbl_s0p09 sn0_s0p09 rwls GND sky130_fd_pr__nfet_01v8 L=0.15 W=0.42 nf=1 ad=0.1218 as=0.1218 pd=1.42 ps=1.42 nrd=0.69047619047619  nrs=0.69047619047619 sa=0 sb=0 sd=0 mult=1 m=1
XM_WR_1_0_s0p09 sn1_s0p09 wl_1 blp09 GND sky130_fd_pr__nfet_01v8 L=0.15 W=0.42 nf=1 ad=0.1218 as=0.1218 pd=1.42 ps=1.42 nrd=0.69047619047619  nrs=0.69047619047619 sa=0 sb=0 sd=0 mult=1 m=1
XM_RD_1_0_s0p09 rbl_s0p09 sn1_s0p09 rwld GND sky130_fd_pr__nfet_01v8 L=0.15 W=0.42 nf=1 ad=0.1218 as=0.1218 pd=1.42 ps=1.42 nrd=0.69047619047619  nrs=0.69047619047619 sa=0 sb=0 sd=0 mult=1 m=1
XM_WR_2_0_s0p09 sn2_s0p09 wl_2 blp09 GND sky130_fd_pr__nfet_01v8 L=0.15 W=0.42 nf=1 ad=0.1218 as=0.1218 pd=1.42 ps=1.42 nrd=0.69047619047619  nrs=0.69047619047619 sa=0 sb=0 sd=0 mult=1 m=1
XM_RD_2_0_s0p09 rbl_s0p09 sn2_s0p09 rwld GND sky130_fd_pr__nfet_01v8 L=0.15 W=0.42 nf=1 ad=0.1218 as=0.1218 pd=1.42 ps=1.42 nrd=0.69047619047619  nrs=0.69047619047619 sa=0 sb=0 sd=0 mult=1 m=1
XM_WR_3_0_s0p09 sn3_s0p09 wl_3 blp09 GND sky130_fd_pr__nfet_01v8 L=0.15 W=0.42 nf=1 ad=0.1218 as=0.1218 pd=1.42 ps=1.42 nrd=0.69047619047619  nrs=0.69047619047619 sa=0 sb=0 sd=0 mult=1 m=1
XM_RD_3_0_s0p09 rbl_s0p09 sn3_s0p09 rwld GND sky130_fd_pr__nfet_01v8 L=0.15 W=0.42 nf=1 ad=0.1218 as=0.1218 pd=1.42 ps=1.42 nrd=0.69047619047619  nrs=0.69047619047619 sa=0 sb=0 sd=0 mult=1 m=1
csn0_s0p09 sn0_s0p09 0 {C_SN}
csn1_s0p09 sn1_s0p09 0 {C_SN}
csn2_s0p09 sn2_s0p09 0 {C_SN}
csn3_s0p09 sn3_s0p09 0 {C_SN}
crbl_s0p09 rbl_s0p09 0 {C_RBL}
spre_s0p09 pre rbl_s0p09 ctl 0 swpre
ehb_s0p09 hb_s0p09 0 rbl_s0p09 0 1
shb_s0p09 hb_s0p09 hold_s0p09 hctl 0 swpre
chold_s0p09 hold_s0p09 0 1e-12
bdl_s0p09 dl_s0p09 0 v=v(rbl_s0p09)-v(hold_s0p09)+0.1-v(late)

* ---- case s0p10: selected row 0, pattern rows3210 1010 ----
XM_WR_0_0_s0p10 sn0_s0p10 wl_0 blp10 GND sky130_fd_pr__nfet_01v8 L=0.15 W=0.42 nf=1 ad=0.1218 as=0.1218 pd=1.42 ps=1.42 nrd=0.69047619047619  nrs=0.69047619047619 sa=0 sb=0 sd=0 mult=1 m=1
XM_RD_0_0_s0p10 rbl_s0p10 sn0_s0p10 rwls GND sky130_fd_pr__nfet_01v8 L=0.15 W=0.42 nf=1 ad=0.1218 as=0.1218 pd=1.42 ps=1.42 nrd=0.69047619047619  nrs=0.69047619047619 sa=0 sb=0 sd=0 mult=1 m=1
XM_WR_1_0_s0p10 sn1_s0p10 wl_1 blp10 GND sky130_fd_pr__nfet_01v8 L=0.15 W=0.42 nf=1 ad=0.1218 as=0.1218 pd=1.42 ps=1.42 nrd=0.69047619047619  nrs=0.69047619047619 sa=0 sb=0 sd=0 mult=1 m=1
XM_RD_1_0_s0p10 rbl_s0p10 sn1_s0p10 rwld GND sky130_fd_pr__nfet_01v8 L=0.15 W=0.42 nf=1 ad=0.1218 as=0.1218 pd=1.42 ps=1.42 nrd=0.69047619047619  nrs=0.69047619047619 sa=0 sb=0 sd=0 mult=1 m=1
XM_WR_2_0_s0p10 sn2_s0p10 wl_2 blp10 GND sky130_fd_pr__nfet_01v8 L=0.15 W=0.42 nf=1 ad=0.1218 as=0.1218 pd=1.42 ps=1.42 nrd=0.69047619047619  nrs=0.69047619047619 sa=0 sb=0 sd=0 mult=1 m=1
XM_RD_2_0_s0p10 rbl_s0p10 sn2_s0p10 rwld GND sky130_fd_pr__nfet_01v8 L=0.15 W=0.42 nf=1 ad=0.1218 as=0.1218 pd=1.42 ps=1.42 nrd=0.69047619047619  nrs=0.69047619047619 sa=0 sb=0 sd=0 mult=1 m=1
XM_WR_3_0_s0p10 sn3_s0p10 wl_3 blp10 GND sky130_fd_pr__nfet_01v8 L=0.15 W=0.42 nf=1 ad=0.1218 as=0.1218 pd=1.42 ps=1.42 nrd=0.69047619047619  nrs=0.69047619047619 sa=0 sb=0 sd=0 mult=1 m=1
XM_RD_3_0_s0p10 rbl_s0p10 sn3_s0p10 rwld GND sky130_fd_pr__nfet_01v8 L=0.15 W=0.42 nf=1 ad=0.1218 as=0.1218 pd=1.42 ps=1.42 nrd=0.69047619047619  nrs=0.69047619047619 sa=0 sb=0 sd=0 mult=1 m=1
csn0_s0p10 sn0_s0p10 0 {C_SN}
csn1_s0p10 sn1_s0p10 0 {C_SN}
csn2_s0p10 sn2_s0p10 0 {C_SN}
csn3_s0p10 sn3_s0p10 0 {C_SN}
crbl_s0p10 rbl_s0p10 0 {C_RBL}
spre_s0p10 pre rbl_s0p10 ctl 0 swpre
ehb_s0p10 hb_s0p10 0 rbl_s0p10 0 1
shb_s0p10 hb_s0p10 hold_s0p10 hctl 0 swpre
chold_s0p10 hold_s0p10 0 1e-12
bdl_s0p10 dl_s0p10 0 v=v(rbl_s0p10)-v(hold_s0p10)+0.1-v(late)

* ---- case s0p11: selected row 0, pattern rows3210 1011 ----
XM_WR_0_0_s0p11 sn0_s0p11 wl_0 blp11 GND sky130_fd_pr__nfet_01v8 L=0.15 W=0.42 nf=1 ad=0.1218 as=0.1218 pd=1.42 ps=1.42 nrd=0.69047619047619  nrs=0.69047619047619 sa=0 sb=0 sd=0 mult=1 m=1
XM_RD_0_0_s0p11 rbl_s0p11 sn0_s0p11 rwls GND sky130_fd_pr__nfet_01v8 L=0.15 W=0.42 nf=1 ad=0.1218 as=0.1218 pd=1.42 ps=1.42 nrd=0.69047619047619  nrs=0.69047619047619 sa=0 sb=0 sd=0 mult=1 m=1
XM_WR_1_0_s0p11 sn1_s0p11 wl_1 blp11 GND sky130_fd_pr__nfet_01v8 L=0.15 W=0.42 nf=1 ad=0.1218 as=0.1218 pd=1.42 ps=1.42 nrd=0.69047619047619  nrs=0.69047619047619 sa=0 sb=0 sd=0 mult=1 m=1
XM_RD_1_0_s0p11 rbl_s0p11 sn1_s0p11 rwld GND sky130_fd_pr__nfet_01v8 L=0.15 W=0.42 nf=1 ad=0.1218 as=0.1218 pd=1.42 ps=1.42 nrd=0.69047619047619  nrs=0.69047619047619 sa=0 sb=0 sd=0 mult=1 m=1
XM_WR_2_0_s0p11 sn2_s0p11 wl_2 blp11 GND sky130_fd_pr__nfet_01v8 L=0.15 W=0.42 nf=1 ad=0.1218 as=0.1218 pd=1.42 ps=1.42 nrd=0.69047619047619  nrs=0.69047619047619 sa=0 sb=0 sd=0 mult=1 m=1
XM_RD_2_0_s0p11 rbl_s0p11 sn2_s0p11 rwld GND sky130_fd_pr__nfet_01v8 L=0.15 W=0.42 nf=1 ad=0.1218 as=0.1218 pd=1.42 ps=1.42 nrd=0.69047619047619  nrs=0.69047619047619 sa=0 sb=0 sd=0 mult=1 m=1
XM_WR_3_0_s0p11 sn3_s0p11 wl_3 blp11 GND sky130_fd_pr__nfet_01v8 L=0.15 W=0.42 nf=1 ad=0.1218 as=0.1218 pd=1.42 ps=1.42 nrd=0.69047619047619  nrs=0.69047619047619 sa=0 sb=0 sd=0 mult=1 m=1
XM_RD_3_0_s0p11 rbl_s0p11 sn3_s0p11 rwld GND sky130_fd_pr__nfet_01v8 L=0.15 W=0.42 nf=1 ad=0.1218 as=0.1218 pd=1.42 ps=1.42 nrd=0.69047619047619  nrs=0.69047619047619 sa=0 sb=0 sd=0 mult=1 m=1
csn0_s0p11 sn0_s0p11 0 {C_SN}
csn1_s0p11 sn1_s0p11 0 {C_SN}
csn2_s0p11 sn2_s0p11 0 {C_SN}
csn3_s0p11 sn3_s0p11 0 {C_SN}
crbl_s0p11 rbl_s0p11 0 {C_RBL}
spre_s0p11 pre rbl_s0p11 ctl 0 swpre
ehb_s0p11 hb_s0p11 0 rbl_s0p11 0 1
shb_s0p11 hb_s0p11 hold_s0p11 hctl 0 swpre
chold_s0p11 hold_s0p11 0 1e-12
bdl_s0p11 dl_s0p11 0 v=v(rbl_s0p11)-v(hold_s0p11)+0.1-v(late)

* ---- case s0p12: selected row 0, pattern rows3210 1100 ----
XM_WR_0_0_s0p12 sn0_s0p12 wl_0 blp12 GND sky130_fd_pr__nfet_01v8 L=0.15 W=0.42 nf=1 ad=0.1218 as=0.1218 pd=1.42 ps=1.42 nrd=0.69047619047619  nrs=0.69047619047619 sa=0 sb=0 sd=0 mult=1 m=1
XM_RD_0_0_s0p12 rbl_s0p12 sn0_s0p12 rwls GND sky130_fd_pr__nfet_01v8 L=0.15 W=0.42 nf=1 ad=0.1218 as=0.1218 pd=1.42 ps=1.42 nrd=0.69047619047619  nrs=0.69047619047619 sa=0 sb=0 sd=0 mult=1 m=1
XM_WR_1_0_s0p12 sn1_s0p12 wl_1 blp12 GND sky130_fd_pr__nfet_01v8 L=0.15 W=0.42 nf=1 ad=0.1218 as=0.1218 pd=1.42 ps=1.42 nrd=0.69047619047619  nrs=0.69047619047619 sa=0 sb=0 sd=0 mult=1 m=1
XM_RD_1_0_s0p12 rbl_s0p12 sn1_s0p12 rwld GND sky130_fd_pr__nfet_01v8 L=0.15 W=0.42 nf=1 ad=0.1218 as=0.1218 pd=1.42 ps=1.42 nrd=0.69047619047619  nrs=0.69047619047619 sa=0 sb=0 sd=0 mult=1 m=1
XM_WR_2_0_s0p12 sn2_s0p12 wl_2 blp12 GND sky130_fd_pr__nfet_01v8 L=0.15 W=0.42 nf=1 ad=0.1218 as=0.1218 pd=1.42 ps=1.42 nrd=0.69047619047619  nrs=0.69047619047619 sa=0 sb=0 sd=0 mult=1 m=1
XM_RD_2_0_s0p12 rbl_s0p12 sn2_s0p12 rwld GND sky130_fd_pr__nfet_01v8 L=0.15 W=0.42 nf=1 ad=0.1218 as=0.1218 pd=1.42 ps=1.42 nrd=0.69047619047619  nrs=0.69047619047619 sa=0 sb=0 sd=0 mult=1 m=1
XM_WR_3_0_s0p12 sn3_s0p12 wl_3 blp12 GND sky130_fd_pr__nfet_01v8 L=0.15 W=0.42 nf=1 ad=0.1218 as=0.1218 pd=1.42 ps=1.42 nrd=0.69047619047619  nrs=0.69047619047619 sa=0 sb=0 sd=0 mult=1 m=1
XM_RD_3_0_s0p12 rbl_s0p12 sn3_s0p12 rwld GND sky130_fd_pr__nfet_01v8 L=0.15 W=0.42 nf=1 ad=0.1218 as=0.1218 pd=1.42 ps=1.42 nrd=0.69047619047619  nrs=0.69047619047619 sa=0 sb=0 sd=0 mult=1 m=1
csn0_s0p12 sn0_s0p12 0 {C_SN}
csn1_s0p12 sn1_s0p12 0 {C_SN}
csn2_s0p12 sn2_s0p12 0 {C_SN}
csn3_s0p12 sn3_s0p12 0 {C_SN}
crbl_s0p12 rbl_s0p12 0 {C_RBL}
spre_s0p12 pre rbl_s0p12 ctl 0 swpre
ehb_s0p12 hb_s0p12 0 rbl_s0p12 0 1
shb_s0p12 hb_s0p12 hold_s0p12 hctl 0 swpre
chold_s0p12 hold_s0p12 0 1e-12
bdl_s0p12 dl_s0p12 0 v=v(rbl_s0p12)-v(hold_s0p12)+0.1-v(late)

* ---- case s0p13: selected row 0, pattern rows3210 1101 ----
XM_WR_0_0_s0p13 sn0_s0p13 wl_0 blp13 GND sky130_fd_pr__nfet_01v8 L=0.15 W=0.42 nf=1 ad=0.1218 as=0.1218 pd=1.42 ps=1.42 nrd=0.69047619047619  nrs=0.69047619047619 sa=0 sb=0 sd=0 mult=1 m=1
XM_RD_0_0_s0p13 rbl_s0p13 sn0_s0p13 rwls GND sky130_fd_pr__nfet_01v8 L=0.15 W=0.42 nf=1 ad=0.1218 as=0.1218 pd=1.42 ps=1.42 nrd=0.69047619047619  nrs=0.69047619047619 sa=0 sb=0 sd=0 mult=1 m=1
XM_WR_1_0_s0p13 sn1_s0p13 wl_1 blp13 GND sky130_fd_pr__nfet_01v8 L=0.15 W=0.42 nf=1 ad=0.1218 as=0.1218 pd=1.42 ps=1.42 nrd=0.69047619047619  nrs=0.69047619047619 sa=0 sb=0 sd=0 mult=1 m=1
XM_RD_1_0_s0p13 rbl_s0p13 sn1_s0p13 rwld GND sky130_fd_pr__nfet_01v8 L=0.15 W=0.42 nf=1 ad=0.1218 as=0.1218 pd=1.42 ps=1.42 nrd=0.69047619047619  nrs=0.69047619047619 sa=0 sb=0 sd=0 mult=1 m=1
XM_WR_2_0_s0p13 sn2_s0p13 wl_2 blp13 GND sky130_fd_pr__nfet_01v8 L=0.15 W=0.42 nf=1 ad=0.1218 as=0.1218 pd=1.42 ps=1.42 nrd=0.69047619047619  nrs=0.69047619047619 sa=0 sb=0 sd=0 mult=1 m=1
XM_RD_2_0_s0p13 rbl_s0p13 sn2_s0p13 rwld GND sky130_fd_pr__nfet_01v8 L=0.15 W=0.42 nf=1 ad=0.1218 as=0.1218 pd=1.42 ps=1.42 nrd=0.69047619047619  nrs=0.69047619047619 sa=0 sb=0 sd=0 mult=1 m=1
XM_WR_3_0_s0p13 sn3_s0p13 wl_3 blp13 GND sky130_fd_pr__nfet_01v8 L=0.15 W=0.42 nf=1 ad=0.1218 as=0.1218 pd=1.42 ps=1.42 nrd=0.69047619047619  nrs=0.69047619047619 sa=0 sb=0 sd=0 mult=1 m=1
XM_RD_3_0_s0p13 rbl_s0p13 sn3_s0p13 rwld GND sky130_fd_pr__nfet_01v8 L=0.15 W=0.42 nf=1 ad=0.1218 as=0.1218 pd=1.42 ps=1.42 nrd=0.69047619047619  nrs=0.69047619047619 sa=0 sb=0 sd=0 mult=1 m=1
csn0_s0p13 sn0_s0p13 0 {C_SN}
csn1_s0p13 sn1_s0p13 0 {C_SN}
csn2_s0p13 sn2_s0p13 0 {C_SN}
csn3_s0p13 sn3_s0p13 0 {C_SN}
crbl_s0p13 rbl_s0p13 0 {C_RBL}
spre_s0p13 pre rbl_s0p13 ctl 0 swpre
ehb_s0p13 hb_s0p13 0 rbl_s0p13 0 1
shb_s0p13 hb_s0p13 hold_s0p13 hctl 0 swpre
chold_s0p13 hold_s0p13 0 1e-12
bdl_s0p13 dl_s0p13 0 v=v(rbl_s0p13)-v(hold_s0p13)+0.1-v(late)

* ---- case s0p14: selected row 0, pattern rows3210 1110 ----
XM_WR_0_0_s0p14 sn0_s0p14 wl_0 blp14 GND sky130_fd_pr__nfet_01v8 L=0.15 W=0.42 nf=1 ad=0.1218 as=0.1218 pd=1.42 ps=1.42 nrd=0.69047619047619  nrs=0.69047619047619 sa=0 sb=0 sd=0 mult=1 m=1
XM_RD_0_0_s0p14 rbl_s0p14 sn0_s0p14 rwls GND sky130_fd_pr__nfet_01v8 L=0.15 W=0.42 nf=1 ad=0.1218 as=0.1218 pd=1.42 ps=1.42 nrd=0.69047619047619  nrs=0.69047619047619 sa=0 sb=0 sd=0 mult=1 m=1
XM_WR_1_0_s0p14 sn1_s0p14 wl_1 blp14 GND sky130_fd_pr__nfet_01v8 L=0.15 W=0.42 nf=1 ad=0.1218 as=0.1218 pd=1.42 ps=1.42 nrd=0.69047619047619  nrs=0.69047619047619 sa=0 sb=0 sd=0 mult=1 m=1
XM_RD_1_0_s0p14 rbl_s0p14 sn1_s0p14 rwld GND sky130_fd_pr__nfet_01v8 L=0.15 W=0.42 nf=1 ad=0.1218 as=0.1218 pd=1.42 ps=1.42 nrd=0.69047619047619  nrs=0.69047619047619 sa=0 sb=0 sd=0 mult=1 m=1
XM_WR_2_0_s0p14 sn2_s0p14 wl_2 blp14 GND sky130_fd_pr__nfet_01v8 L=0.15 W=0.42 nf=1 ad=0.1218 as=0.1218 pd=1.42 ps=1.42 nrd=0.69047619047619  nrs=0.69047619047619 sa=0 sb=0 sd=0 mult=1 m=1
XM_RD_2_0_s0p14 rbl_s0p14 sn2_s0p14 rwld GND sky130_fd_pr__nfet_01v8 L=0.15 W=0.42 nf=1 ad=0.1218 as=0.1218 pd=1.42 ps=1.42 nrd=0.69047619047619  nrs=0.69047619047619 sa=0 sb=0 sd=0 mult=1 m=1
XM_WR_3_0_s0p14 sn3_s0p14 wl_3 blp14 GND sky130_fd_pr__nfet_01v8 L=0.15 W=0.42 nf=1 ad=0.1218 as=0.1218 pd=1.42 ps=1.42 nrd=0.69047619047619  nrs=0.69047619047619 sa=0 sb=0 sd=0 mult=1 m=1
XM_RD_3_0_s0p14 rbl_s0p14 sn3_s0p14 rwld GND sky130_fd_pr__nfet_01v8 L=0.15 W=0.42 nf=1 ad=0.1218 as=0.1218 pd=1.42 ps=1.42 nrd=0.69047619047619  nrs=0.69047619047619 sa=0 sb=0 sd=0 mult=1 m=1
csn0_s0p14 sn0_s0p14 0 {C_SN}
csn1_s0p14 sn1_s0p14 0 {C_SN}
csn2_s0p14 sn2_s0p14 0 {C_SN}
csn3_s0p14 sn3_s0p14 0 {C_SN}
crbl_s0p14 rbl_s0p14 0 {C_RBL}
spre_s0p14 pre rbl_s0p14 ctl 0 swpre
ehb_s0p14 hb_s0p14 0 rbl_s0p14 0 1
shb_s0p14 hb_s0p14 hold_s0p14 hctl 0 swpre
chold_s0p14 hold_s0p14 0 1e-12
bdl_s0p14 dl_s0p14 0 v=v(rbl_s0p14)-v(hold_s0p14)+0.1-v(late)

* ---- case s0p15: selected row 0, pattern rows3210 1111 ----
XM_WR_0_0_s0p15 sn0_s0p15 wl_0 blp15 GND sky130_fd_pr__nfet_01v8 L=0.15 W=0.42 nf=1 ad=0.1218 as=0.1218 pd=1.42 ps=1.42 nrd=0.69047619047619  nrs=0.69047619047619 sa=0 sb=0 sd=0 mult=1 m=1
XM_RD_0_0_s0p15 rbl_s0p15 sn0_s0p15 rwls GND sky130_fd_pr__nfet_01v8 L=0.15 W=0.42 nf=1 ad=0.1218 as=0.1218 pd=1.42 ps=1.42 nrd=0.69047619047619  nrs=0.69047619047619 sa=0 sb=0 sd=0 mult=1 m=1
XM_WR_1_0_s0p15 sn1_s0p15 wl_1 blp15 GND sky130_fd_pr__nfet_01v8 L=0.15 W=0.42 nf=1 ad=0.1218 as=0.1218 pd=1.42 ps=1.42 nrd=0.69047619047619  nrs=0.69047619047619 sa=0 sb=0 sd=0 mult=1 m=1
XM_RD_1_0_s0p15 rbl_s0p15 sn1_s0p15 rwld GND sky130_fd_pr__nfet_01v8 L=0.15 W=0.42 nf=1 ad=0.1218 as=0.1218 pd=1.42 ps=1.42 nrd=0.69047619047619  nrs=0.69047619047619 sa=0 sb=0 sd=0 mult=1 m=1
XM_WR_2_0_s0p15 sn2_s0p15 wl_2 blp15 GND sky130_fd_pr__nfet_01v8 L=0.15 W=0.42 nf=1 ad=0.1218 as=0.1218 pd=1.42 ps=1.42 nrd=0.69047619047619  nrs=0.69047619047619 sa=0 sb=0 sd=0 mult=1 m=1
XM_RD_2_0_s0p15 rbl_s0p15 sn2_s0p15 rwld GND sky130_fd_pr__nfet_01v8 L=0.15 W=0.42 nf=1 ad=0.1218 as=0.1218 pd=1.42 ps=1.42 nrd=0.69047619047619  nrs=0.69047619047619 sa=0 sb=0 sd=0 mult=1 m=1
XM_WR_3_0_s0p15 sn3_s0p15 wl_3 blp15 GND sky130_fd_pr__nfet_01v8 L=0.15 W=0.42 nf=1 ad=0.1218 as=0.1218 pd=1.42 ps=1.42 nrd=0.69047619047619  nrs=0.69047619047619 sa=0 sb=0 sd=0 mult=1 m=1
XM_RD_3_0_s0p15 rbl_s0p15 sn3_s0p15 rwld GND sky130_fd_pr__nfet_01v8 L=0.15 W=0.42 nf=1 ad=0.1218 as=0.1218 pd=1.42 ps=1.42 nrd=0.69047619047619  nrs=0.69047619047619 sa=0 sb=0 sd=0 mult=1 m=1
csn0_s0p15 sn0_s0p15 0 {C_SN}
csn1_s0p15 sn1_s0p15 0 {C_SN}
csn2_s0p15 sn2_s0p15 0 {C_SN}
csn3_s0p15 sn3_s0p15 0 {C_SN}
crbl_s0p15 rbl_s0p15 0 {C_RBL}
spre_s0p15 pre rbl_s0p15 ctl 0 swpre
ehb_s0p15 hb_s0p15 0 rbl_s0p15 0 1
shb_s0p15 hb_s0p15 hold_s0p15 hctl 0 swpre
chold_s0p15 hold_s0p15 0 1e-12
bdl_s0p15 dl_s0p15 0 v=v(rbl_s0p15)-v(hold_s0p15)+0.1-v(late)

* ---- case s1p00: selected row 1, pattern rows3210 0000 ----
XM_WR_0_0_s1p00 sn0_s1p00 wl_0 blp00 GND sky130_fd_pr__nfet_01v8 L=0.15 W=0.42 nf=1 ad=0.1218 as=0.1218 pd=1.42 ps=1.42 nrd=0.69047619047619  nrs=0.69047619047619 sa=0 sb=0 sd=0 mult=1 m=1
XM_RD_0_0_s1p00 rbl_s1p00 sn0_s1p00 rwld GND sky130_fd_pr__nfet_01v8 L=0.15 W=0.42 nf=1 ad=0.1218 as=0.1218 pd=1.42 ps=1.42 nrd=0.69047619047619  nrs=0.69047619047619 sa=0 sb=0 sd=0 mult=1 m=1
XM_WR_1_0_s1p00 sn1_s1p00 wl_1 blp00 GND sky130_fd_pr__nfet_01v8 L=0.15 W=0.42 nf=1 ad=0.1218 as=0.1218 pd=1.42 ps=1.42 nrd=0.69047619047619  nrs=0.69047619047619 sa=0 sb=0 sd=0 mult=1 m=1
XM_RD_1_0_s1p00 rbl_s1p00 sn1_s1p00 rwls GND sky130_fd_pr__nfet_01v8 L=0.15 W=0.42 nf=1 ad=0.1218 as=0.1218 pd=1.42 ps=1.42 nrd=0.69047619047619  nrs=0.69047619047619 sa=0 sb=0 sd=0 mult=1 m=1
XM_WR_2_0_s1p00 sn2_s1p00 wl_2 blp00 GND sky130_fd_pr__nfet_01v8 L=0.15 W=0.42 nf=1 ad=0.1218 as=0.1218 pd=1.42 ps=1.42 nrd=0.69047619047619  nrs=0.69047619047619 sa=0 sb=0 sd=0 mult=1 m=1
XM_RD_2_0_s1p00 rbl_s1p00 sn2_s1p00 rwld GND sky130_fd_pr__nfet_01v8 L=0.15 W=0.42 nf=1 ad=0.1218 as=0.1218 pd=1.42 ps=1.42 nrd=0.69047619047619  nrs=0.69047619047619 sa=0 sb=0 sd=0 mult=1 m=1
XM_WR_3_0_s1p00 sn3_s1p00 wl_3 blp00 GND sky130_fd_pr__nfet_01v8 L=0.15 W=0.42 nf=1 ad=0.1218 as=0.1218 pd=1.42 ps=1.42 nrd=0.69047619047619  nrs=0.69047619047619 sa=0 sb=0 sd=0 mult=1 m=1
XM_RD_3_0_s1p00 rbl_s1p00 sn3_s1p00 rwld GND sky130_fd_pr__nfet_01v8 L=0.15 W=0.42 nf=1 ad=0.1218 as=0.1218 pd=1.42 ps=1.42 nrd=0.69047619047619  nrs=0.69047619047619 sa=0 sb=0 sd=0 mult=1 m=1
csn0_s1p00 sn0_s1p00 0 {C_SN}
csn1_s1p00 sn1_s1p00 0 {C_SN}
csn2_s1p00 sn2_s1p00 0 {C_SN}
csn3_s1p00 sn3_s1p00 0 {C_SN}
crbl_s1p00 rbl_s1p00 0 {C_RBL}
spre_s1p00 pre rbl_s1p00 ctl 0 swpre
ehb_s1p00 hb_s1p00 0 rbl_s1p00 0 1
shb_s1p00 hb_s1p00 hold_s1p00 hctl 0 swpre
chold_s1p00 hold_s1p00 0 1e-12
bdl_s1p00 dl_s1p00 0 v=v(rbl_s1p00)-v(hold_s1p00)+0.1-v(late)

* ---- case s1p01: selected row 1, pattern rows3210 0001 ----
XM_WR_0_0_s1p01 sn0_s1p01 wl_0 blp01 GND sky130_fd_pr__nfet_01v8 L=0.15 W=0.42 nf=1 ad=0.1218 as=0.1218 pd=1.42 ps=1.42 nrd=0.69047619047619  nrs=0.69047619047619 sa=0 sb=0 sd=0 mult=1 m=1
XM_RD_0_0_s1p01 rbl_s1p01 sn0_s1p01 rwld GND sky130_fd_pr__nfet_01v8 L=0.15 W=0.42 nf=1 ad=0.1218 as=0.1218 pd=1.42 ps=1.42 nrd=0.69047619047619  nrs=0.69047619047619 sa=0 sb=0 sd=0 mult=1 m=1
XM_WR_1_0_s1p01 sn1_s1p01 wl_1 blp01 GND sky130_fd_pr__nfet_01v8 L=0.15 W=0.42 nf=1 ad=0.1218 as=0.1218 pd=1.42 ps=1.42 nrd=0.69047619047619  nrs=0.69047619047619 sa=0 sb=0 sd=0 mult=1 m=1
XM_RD_1_0_s1p01 rbl_s1p01 sn1_s1p01 rwls GND sky130_fd_pr__nfet_01v8 L=0.15 W=0.42 nf=1 ad=0.1218 as=0.1218 pd=1.42 ps=1.42 nrd=0.69047619047619  nrs=0.69047619047619 sa=0 sb=0 sd=0 mult=1 m=1
XM_WR_2_0_s1p01 sn2_s1p01 wl_2 blp01 GND sky130_fd_pr__nfet_01v8 L=0.15 W=0.42 nf=1 ad=0.1218 as=0.1218 pd=1.42 ps=1.42 nrd=0.69047619047619  nrs=0.69047619047619 sa=0 sb=0 sd=0 mult=1 m=1
XM_RD_2_0_s1p01 rbl_s1p01 sn2_s1p01 rwld GND sky130_fd_pr__nfet_01v8 L=0.15 W=0.42 nf=1 ad=0.1218 as=0.1218 pd=1.42 ps=1.42 nrd=0.69047619047619  nrs=0.69047619047619 sa=0 sb=0 sd=0 mult=1 m=1
XM_WR_3_0_s1p01 sn3_s1p01 wl_3 blp01 GND sky130_fd_pr__nfet_01v8 L=0.15 W=0.42 nf=1 ad=0.1218 as=0.1218 pd=1.42 ps=1.42 nrd=0.69047619047619  nrs=0.69047619047619 sa=0 sb=0 sd=0 mult=1 m=1
XM_RD_3_0_s1p01 rbl_s1p01 sn3_s1p01 rwld GND sky130_fd_pr__nfet_01v8 L=0.15 W=0.42 nf=1 ad=0.1218 as=0.1218 pd=1.42 ps=1.42 nrd=0.69047619047619  nrs=0.69047619047619 sa=0 sb=0 sd=0 mult=1 m=1
csn0_s1p01 sn0_s1p01 0 {C_SN}
csn1_s1p01 sn1_s1p01 0 {C_SN}
csn2_s1p01 sn2_s1p01 0 {C_SN}
csn3_s1p01 sn3_s1p01 0 {C_SN}
crbl_s1p01 rbl_s1p01 0 {C_RBL}
spre_s1p01 pre rbl_s1p01 ctl 0 swpre
ehb_s1p01 hb_s1p01 0 rbl_s1p01 0 1
shb_s1p01 hb_s1p01 hold_s1p01 hctl 0 swpre
chold_s1p01 hold_s1p01 0 1e-12
bdl_s1p01 dl_s1p01 0 v=v(rbl_s1p01)-v(hold_s1p01)+0.1-v(late)

* ---- case s1p02: selected row 1, pattern rows3210 0010 ----
XM_WR_0_0_s1p02 sn0_s1p02 wl_0 blp02 GND sky130_fd_pr__nfet_01v8 L=0.15 W=0.42 nf=1 ad=0.1218 as=0.1218 pd=1.42 ps=1.42 nrd=0.69047619047619  nrs=0.69047619047619 sa=0 sb=0 sd=0 mult=1 m=1
XM_RD_0_0_s1p02 rbl_s1p02 sn0_s1p02 rwld GND sky130_fd_pr__nfet_01v8 L=0.15 W=0.42 nf=1 ad=0.1218 as=0.1218 pd=1.42 ps=1.42 nrd=0.69047619047619  nrs=0.69047619047619 sa=0 sb=0 sd=0 mult=1 m=1
XM_WR_1_0_s1p02 sn1_s1p02 wl_1 blp02 GND sky130_fd_pr__nfet_01v8 L=0.15 W=0.42 nf=1 ad=0.1218 as=0.1218 pd=1.42 ps=1.42 nrd=0.69047619047619  nrs=0.69047619047619 sa=0 sb=0 sd=0 mult=1 m=1
XM_RD_1_0_s1p02 rbl_s1p02 sn1_s1p02 rwls GND sky130_fd_pr__nfet_01v8 L=0.15 W=0.42 nf=1 ad=0.1218 as=0.1218 pd=1.42 ps=1.42 nrd=0.69047619047619  nrs=0.69047619047619 sa=0 sb=0 sd=0 mult=1 m=1
XM_WR_2_0_s1p02 sn2_s1p02 wl_2 blp02 GND sky130_fd_pr__nfet_01v8 L=0.15 W=0.42 nf=1 ad=0.1218 as=0.1218 pd=1.42 ps=1.42 nrd=0.69047619047619  nrs=0.69047619047619 sa=0 sb=0 sd=0 mult=1 m=1
XM_RD_2_0_s1p02 rbl_s1p02 sn2_s1p02 rwld GND sky130_fd_pr__nfet_01v8 L=0.15 W=0.42 nf=1 ad=0.1218 as=0.1218 pd=1.42 ps=1.42 nrd=0.69047619047619  nrs=0.69047619047619 sa=0 sb=0 sd=0 mult=1 m=1
XM_WR_3_0_s1p02 sn3_s1p02 wl_3 blp02 GND sky130_fd_pr__nfet_01v8 L=0.15 W=0.42 nf=1 ad=0.1218 as=0.1218 pd=1.42 ps=1.42 nrd=0.69047619047619  nrs=0.69047619047619 sa=0 sb=0 sd=0 mult=1 m=1
XM_RD_3_0_s1p02 rbl_s1p02 sn3_s1p02 rwld GND sky130_fd_pr__nfet_01v8 L=0.15 W=0.42 nf=1 ad=0.1218 as=0.1218 pd=1.42 ps=1.42 nrd=0.69047619047619  nrs=0.69047619047619 sa=0 sb=0 sd=0 mult=1 m=1
csn0_s1p02 sn0_s1p02 0 {C_SN}
csn1_s1p02 sn1_s1p02 0 {C_SN}
csn2_s1p02 sn2_s1p02 0 {C_SN}
csn3_s1p02 sn3_s1p02 0 {C_SN}
crbl_s1p02 rbl_s1p02 0 {C_RBL}
spre_s1p02 pre rbl_s1p02 ctl 0 swpre
ehb_s1p02 hb_s1p02 0 rbl_s1p02 0 1
shb_s1p02 hb_s1p02 hold_s1p02 hctl 0 swpre
chold_s1p02 hold_s1p02 0 1e-12
bdl_s1p02 dl_s1p02 0 v=v(rbl_s1p02)-v(hold_s1p02)+0.1-v(late)

* ---- case s1p03: selected row 1, pattern rows3210 0011 ----
XM_WR_0_0_s1p03 sn0_s1p03 wl_0 blp03 GND sky130_fd_pr__nfet_01v8 L=0.15 W=0.42 nf=1 ad=0.1218 as=0.1218 pd=1.42 ps=1.42 nrd=0.69047619047619  nrs=0.69047619047619 sa=0 sb=0 sd=0 mult=1 m=1
XM_RD_0_0_s1p03 rbl_s1p03 sn0_s1p03 rwld GND sky130_fd_pr__nfet_01v8 L=0.15 W=0.42 nf=1 ad=0.1218 as=0.1218 pd=1.42 ps=1.42 nrd=0.69047619047619  nrs=0.69047619047619 sa=0 sb=0 sd=0 mult=1 m=1
XM_WR_1_0_s1p03 sn1_s1p03 wl_1 blp03 GND sky130_fd_pr__nfet_01v8 L=0.15 W=0.42 nf=1 ad=0.1218 as=0.1218 pd=1.42 ps=1.42 nrd=0.69047619047619  nrs=0.69047619047619 sa=0 sb=0 sd=0 mult=1 m=1
XM_RD_1_0_s1p03 rbl_s1p03 sn1_s1p03 rwls GND sky130_fd_pr__nfet_01v8 L=0.15 W=0.42 nf=1 ad=0.1218 as=0.1218 pd=1.42 ps=1.42 nrd=0.69047619047619  nrs=0.69047619047619 sa=0 sb=0 sd=0 mult=1 m=1
XM_WR_2_0_s1p03 sn2_s1p03 wl_2 blp03 GND sky130_fd_pr__nfet_01v8 L=0.15 W=0.42 nf=1 ad=0.1218 as=0.1218 pd=1.42 ps=1.42 nrd=0.69047619047619  nrs=0.69047619047619 sa=0 sb=0 sd=0 mult=1 m=1
XM_RD_2_0_s1p03 rbl_s1p03 sn2_s1p03 rwld GND sky130_fd_pr__nfet_01v8 L=0.15 W=0.42 nf=1 ad=0.1218 as=0.1218 pd=1.42 ps=1.42 nrd=0.69047619047619  nrs=0.69047619047619 sa=0 sb=0 sd=0 mult=1 m=1
XM_WR_3_0_s1p03 sn3_s1p03 wl_3 blp03 GND sky130_fd_pr__nfet_01v8 L=0.15 W=0.42 nf=1 ad=0.1218 as=0.1218 pd=1.42 ps=1.42 nrd=0.69047619047619  nrs=0.69047619047619 sa=0 sb=0 sd=0 mult=1 m=1
XM_RD_3_0_s1p03 rbl_s1p03 sn3_s1p03 rwld GND sky130_fd_pr__nfet_01v8 L=0.15 W=0.42 nf=1 ad=0.1218 as=0.1218 pd=1.42 ps=1.42 nrd=0.69047619047619  nrs=0.69047619047619 sa=0 sb=0 sd=0 mult=1 m=1
csn0_s1p03 sn0_s1p03 0 {C_SN}
csn1_s1p03 sn1_s1p03 0 {C_SN}
csn2_s1p03 sn2_s1p03 0 {C_SN}
csn3_s1p03 sn3_s1p03 0 {C_SN}
crbl_s1p03 rbl_s1p03 0 {C_RBL}
spre_s1p03 pre rbl_s1p03 ctl 0 swpre
ehb_s1p03 hb_s1p03 0 rbl_s1p03 0 1
shb_s1p03 hb_s1p03 hold_s1p03 hctl 0 swpre
chold_s1p03 hold_s1p03 0 1e-12
bdl_s1p03 dl_s1p03 0 v=v(rbl_s1p03)-v(hold_s1p03)+0.1-v(late)

* ---- case s1p04: selected row 1, pattern rows3210 0100 ----
XM_WR_0_0_s1p04 sn0_s1p04 wl_0 blp04 GND sky130_fd_pr__nfet_01v8 L=0.15 W=0.42 nf=1 ad=0.1218 as=0.1218 pd=1.42 ps=1.42 nrd=0.69047619047619  nrs=0.69047619047619 sa=0 sb=0 sd=0 mult=1 m=1
XM_RD_0_0_s1p04 rbl_s1p04 sn0_s1p04 rwld GND sky130_fd_pr__nfet_01v8 L=0.15 W=0.42 nf=1 ad=0.1218 as=0.1218 pd=1.42 ps=1.42 nrd=0.69047619047619  nrs=0.69047619047619 sa=0 sb=0 sd=0 mult=1 m=1
XM_WR_1_0_s1p04 sn1_s1p04 wl_1 blp04 GND sky130_fd_pr__nfet_01v8 L=0.15 W=0.42 nf=1 ad=0.1218 as=0.1218 pd=1.42 ps=1.42 nrd=0.69047619047619  nrs=0.69047619047619 sa=0 sb=0 sd=0 mult=1 m=1
XM_RD_1_0_s1p04 rbl_s1p04 sn1_s1p04 rwls GND sky130_fd_pr__nfet_01v8 L=0.15 W=0.42 nf=1 ad=0.1218 as=0.1218 pd=1.42 ps=1.42 nrd=0.69047619047619  nrs=0.69047619047619 sa=0 sb=0 sd=0 mult=1 m=1
XM_WR_2_0_s1p04 sn2_s1p04 wl_2 blp04 GND sky130_fd_pr__nfet_01v8 L=0.15 W=0.42 nf=1 ad=0.1218 as=0.1218 pd=1.42 ps=1.42 nrd=0.69047619047619  nrs=0.69047619047619 sa=0 sb=0 sd=0 mult=1 m=1
XM_RD_2_0_s1p04 rbl_s1p04 sn2_s1p04 rwld GND sky130_fd_pr__nfet_01v8 L=0.15 W=0.42 nf=1 ad=0.1218 as=0.1218 pd=1.42 ps=1.42 nrd=0.69047619047619  nrs=0.69047619047619 sa=0 sb=0 sd=0 mult=1 m=1
XM_WR_3_0_s1p04 sn3_s1p04 wl_3 blp04 GND sky130_fd_pr__nfet_01v8 L=0.15 W=0.42 nf=1 ad=0.1218 as=0.1218 pd=1.42 ps=1.42 nrd=0.69047619047619  nrs=0.69047619047619 sa=0 sb=0 sd=0 mult=1 m=1
XM_RD_3_0_s1p04 rbl_s1p04 sn3_s1p04 rwld GND sky130_fd_pr__nfet_01v8 L=0.15 W=0.42 nf=1 ad=0.1218 as=0.1218 pd=1.42 ps=1.42 nrd=0.69047619047619  nrs=0.69047619047619 sa=0 sb=0 sd=0 mult=1 m=1
csn0_s1p04 sn0_s1p04 0 {C_SN}
csn1_s1p04 sn1_s1p04 0 {C_SN}
csn2_s1p04 sn2_s1p04 0 {C_SN}
csn3_s1p04 sn3_s1p04 0 {C_SN}
crbl_s1p04 rbl_s1p04 0 {C_RBL}
spre_s1p04 pre rbl_s1p04 ctl 0 swpre
ehb_s1p04 hb_s1p04 0 rbl_s1p04 0 1
shb_s1p04 hb_s1p04 hold_s1p04 hctl 0 swpre
chold_s1p04 hold_s1p04 0 1e-12
bdl_s1p04 dl_s1p04 0 v=v(rbl_s1p04)-v(hold_s1p04)+0.1-v(late)

* ---- case s1p05: selected row 1, pattern rows3210 0101 ----
XM_WR_0_0_s1p05 sn0_s1p05 wl_0 blp05 GND sky130_fd_pr__nfet_01v8 L=0.15 W=0.42 nf=1 ad=0.1218 as=0.1218 pd=1.42 ps=1.42 nrd=0.69047619047619  nrs=0.69047619047619 sa=0 sb=0 sd=0 mult=1 m=1
XM_RD_0_0_s1p05 rbl_s1p05 sn0_s1p05 rwld GND sky130_fd_pr__nfet_01v8 L=0.15 W=0.42 nf=1 ad=0.1218 as=0.1218 pd=1.42 ps=1.42 nrd=0.69047619047619  nrs=0.69047619047619 sa=0 sb=0 sd=0 mult=1 m=1
XM_WR_1_0_s1p05 sn1_s1p05 wl_1 blp05 GND sky130_fd_pr__nfet_01v8 L=0.15 W=0.42 nf=1 ad=0.1218 as=0.1218 pd=1.42 ps=1.42 nrd=0.69047619047619  nrs=0.69047619047619 sa=0 sb=0 sd=0 mult=1 m=1
XM_RD_1_0_s1p05 rbl_s1p05 sn1_s1p05 rwls GND sky130_fd_pr__nfet_01v8 L=0.15 W=0.42 nf=1 ad=0.1218 as=0.1218 pd=1.42 ps=1.42 nrd=0.69047619047619  nrs=0.69047619047619 sa=0 sb=0 sd=0 mult=1 m=1
XM_WR_2_0_s1p05 sn2_s1p05 wl_2 blp05 GND sky130_fd_pr__nfet_01v8 L=0.15 W=0.42 nf=1 ad=0.1218 as=0.1218 pd=1.42 ps=1.42 nrd=0.69047619047619  nrs=0.69047619047619 sa=0 sb=0 sd=0 mult=1 m=1
XM_RD_2_0_s1p05 rbl_s1p05 sn2_s1p05 rwld GND sky130_fd_pr__nfet_01v8 L=0.15 W=0.42 nf=1 ad=0.1218 as=0.1218 pd=1.42 ps=1.42 nrd=0.69047619047619  nrs=0.69047619047619 sa=0 sb=0 sd=0 mult=1 m=1
XM_WR_3_0_s1p05 sn3_s1p05 wl_3 blp05 GND sky130_fd_pr__nfet_01v8 L=0.15 W=0.42 nf=1 ad=0.1218 as=0.1218 pd=1.42 ps=1.42 nrd=0.69047619047619  nrs=0.69047619047619 sa=0 sb=0 sd=0 mult=1 m=1
XM_RD_3_0_s1p05 rbl_s1p05 sn3_s1p05 rwld GND sky130_fd_pr__nfet_01v8 L=0.15 W=0.42 nf=1 ad=0.1218 as=0.1218 pd=1.42 ps=1.42 nrd=0.69047619047619  nrs=0.69047619047619 sa=0 sb=0 sd=0 mult=1 m=1
csn0_s1p05 sn0_s1p05 0 {C_SN}
csn1_s1p05 sn1_s1p05 0 {C_SN}
csn2_s1p05 sn2_s1p05 0 {C_SN}
csn3_s1p05 sn3_s1p05 0 {C_SN}
crbl_s1p05 rbl_s1p05 0 {C_RBL}
spre_s1p05 pre rbl_s1p05 ctl 0 swpre
ehb_s1p05 hb_s1p05 0 rbl_s1p05 0 1
shb_s1p05 hb_s1p05 hold_s1p05 hctl 0 swpre
chold_s1p05 hold_s1p05 0 1e-12
bdl_s1p05 dl_s1p05 0 v=v(rbl_s1p05)-v(hold_s1p05)+0.1-v(late)

* ---- case s1p06: selected row 1, pattern rows3210 0110 ----
XM_WR_0_0_s1p06 sn0_s1p06 wl_0 blp06 GND sky130_fd_pr__nfet_01v8 L=0.15 W=0.42 nf=1 ad=0.1218 as=0.1218 pd=1.42 ps=1.42 nrd=0.69047619047619  nrs=0.69047619047619 sa=0 sb=0 sd=0 mult=1 m=1
XM_RD_0_0_s1p06 rbl_s1p06 sn0_s1p06 rwld GND sky130_fd_pr__nfet_01v8 L=0.15 W=0.42 nf=1 ad=0.1218 as=0.1218 pd=1.42 ps=1.42 nrd=0.69047619047619  nrs=0.69047619047619 sa=0 sb=0 sd=0 mult=1 m=1
XM_WR_1_0_s1p06 sn1_s1p06 wl_1 blp06 GND sky130_fd_pr__nfet_01v8 L=0.15 W=0.42 nf=1 ad=0.1218 as=0.1218 pd=1.42 ps=1.42 nrd=0.69047619047619  nrs=0.69047619047619 sa=0 sb=0 sd=0 mult=1 m=1
XM_RD_1_0_s1p06 rbl_s1p06 sn1_s1p06 rwls GND sky130_fd_pr__nfet_01v8 L=0.15 W=0.42 nf=1 ad=0.1218 as=0.1218 pd=1.42 ps=1.42 nrd=0.69047619047619  nrs=0.69047619047619 sa=0 sb=0 sd=0 mult=1 m=1
XM_WR_2_0_s1p06 sn2_s1p06 wl_2 blp06 GND sky130_fd_pr__nfet_01v8 L=0.15 W=0.42 nf=1 ad=0.1218 as=0.1218 pd=1.42 ps=1.42 nrd=0.69047619047619  nrs=0.69047619047619 sa=0 sb=0 sd=0 mult=1 m=1
XM_RD_2_0_s1p06 rbl_s1p06 sn2_s1p06 rwld GND sky130_fd_pr__nfet_01v8 L=0.15 W=0.42 nf=1 ad=0.1218 as=0.1218 pd=1.42 ps=1.42 nrd=0.69047619047619  nrs=0.69047619047619 sa=0 sb=0 sd=0 mult=1 m=1
XM_WR_3_0_s1p06 sn3_s1p06 wl_3 blp06 GND sky130_fd_pr__nfet_01v8 L=0.15 W=0.42 nf=1 ad=0.1218 as=0.1218 pd=1.42 ps=1.42 nrd=0.69047619047619  nrs=0.69047619047619 sa=0 sb=0 sd=0 mult=1 m=1
XM_RD_3_0_s1p06 rbl_s1p06 sn3_s1p06 rwld GND sky130_fd_pr__nfet_01v8 L=0.15 W=0.42 nf=1 ad=0.1218 as=0.1218 pd=1.42 ps=1.42 nrd=0.69047619047619  nrs=0.69047619047619 sa=0 sb=0 sd=0 mult=1 m=1
csn0_s1p06 sn0_s1p06 0 {C_SN}
csn1_s1p06 sn1_s1p06 0 {C_SN}
csn2_s1p06 sn2_s1p06 0 {C_SN}
csn3_s1p06 sn3_s1p06 0 {C_SN}
crbl_s1p06 rbl_s1p06 0 {C_RBL}
spre_s1p06 pre rbl_s1p06 ctl 0 swpre
ehb_s1p06 hb_s1p06 0 rbl_s1p06 0 1
shb_s1p06 hb_s1p06 hold_s1p06 hctl 0 swpre
chold_s1p06 hold_s1p06 0 1e-12
bdl_s1p06 dl_s1p06 0 v=v(rbl_s1p06)-v(hold_s1p06)+0.1-v(late)

* ---- case s1p07: selected row 1, pattern rows3210 0111 ----
XM_WR_0_0_s1p07 sn0_s1p07 wl_0 blp07 GND sky130_fd_pr__nfet_01v8 L=0.15 W=0.42 nf=1 ad=0.1218 as=0.1218 pd=1.42 ps=1.42 nrd=0.69047619047619  nrs=0.69047619047619 sa=0 sb=0 sd=0 mult=1 m=1
XM_RD_0_0_s1p07 rbl_s1p07 sn0_s1p07 rwld GND sky130_fd_pr__nfet_01v8 L=0.15 W=0.42 nf=1 ad=0.1218 as=0.1218 pd=1.42 ps=1.42 nrd=0.69047619047619  nrs=0.69047619047619 sa=0 sb=0 sd=0 mult=1 m=1
XM_WR_1_0_s1p07 sn1_s1p07 wl_1 blp07 GND sky130_fd_pr__nfet_01v8 L=0.15 W=0.42 nf=1 ad=0.1218 as=0.1218 pd=1.42 ps=1.42 nrd=0.69047619047619  nrs=0.69047619047619 sa=0 sb=0 sd=0 mult=1 m=1
XM_RD_1_0_s1p07 rbl_s1p07 sn1_s1p07 rwls GND sky130_fd_pr__nfet_01v8 L=0.15 W=0.42 nf=1 ad=0.1218 as=0.1218 pd=1.42 ps=1.42 nrd=0.69047619047619  nrs=0.69047619047619 sa=0 sb=0 sd=0 mult=1 m=1
XM_WR_2_0_s1p07 sn2_s1p07 wl_2 blp07 GND sky130_fd_pr__nfet_01v8 L=0.15 W=0.42 nf=1 ad=0.1218 as=0.1218 pd=1.42 ps=1.42 nrd=0.69047619047619  nrs=0.69047619047619 sa=0 sb=0 sd=0 mult=1 m=1
XM_RD_2_0_s1p07 rbl_s1p07 sn2_s1p07 rwld GND sky130_fd_pr__nfet_01v8 L=0.15 W=0.42 nf=1 ad=0.1218 as=0.1218 pd=1.42 ps=1.42 nrd=0.69047619047619  nrs=0.69047619047619 sa=0 sb=0 sd=0 mult=1 m=1
XM_WR_3_0_s1p07 sn3_s1p07 wl_3 blp07 GND sky130_fd_pr__nfet_01v8 L=0.15 W=0.42 nf=1 ad=0.1218 as=0.1218 pd=1.42 ps=1.42 nrd=0.69047619047619  nrs=0.69047619047619 sa=0 sb=0 sd=0 mult=1 m=1
XM_RD_3_0_s1p07 rbl_s1p07 sn3_s1p07 rwld GND sky130_fd_pr__nfet_01v8 L=0.15 W=0.42 nf=1 ad=0.1218 as=0.1218 pd=1.42 ps=1.42 nrd=0.69047619047619  nrs=0.69047619047619 sa=0 sb=0 sd=0 mult=1 m=1
csn0_s1p07 sn0_s1p07 0 {C_SN}
csn1_s1p07 sn1_s1p07 0 {C_SN}
csn2_s1p07 sn2_s1p07 0 {C_SN}
csn3_s1p07 sn3_s1p07 0 {C_SN}
crbl_s1p07 rbl_s1p07 0 {C_RBL}
spre_s1p07 pre rbl_s1p07 ctl 0 swpre
ehb_s1p07 hb_s1p07 0 rbl_s1p07 0 1
shb_s1p07 hb_s1p07 hold_s1p07 hctl 0 swpre
chold_s1p07 hold_s1p07 0 1e-12
bdl_s1p07 dl_s1p07 0 v=v(rbl_s1p07)-v(hold_s1p07)+0.1-v(late)

* ---- case s1p08: selected row 1, pattern rows3210 1000 ----
XM_WR_0_0_s1p08 sn0_s1p08 wl_0 blp08 GND sky130_fd_pr__nfet_01v8 L=0.15 W=0.42 nf=1 ad=0.1218 as=0.1218 pd=1.42 ps=1.42 nrd=0.69047619047619  nrs=0.69047619047619 sa=0 sb=0 sd=0 mult=1 m=1
XM_RD_0_0_s1p08 rbl_s1p08 sn0_s1p08 rwld GND sky130_fd_pr__nfet_01v8 L=0.15 W=0.42 nf=1 ad=0.1218 as=0.1218 pd=1.42 ps=1.42 nrd=0.69047619047619  nrs=0.69047619047619 sa=0 sb=0 sd=0 mult=1 m=1
XM_WR_1_0_s1p08 sn1_s1p08 wl_1 blp08 GND sky130_fd_pr__nfet_01v8 L=0.15 W=0.42 nf=1 ad=0.1218 as=0.1218 pd=1.42 ps=1.42 nrd=0.69047619047619  nrs=0.69047619047619 sa=0 sb=0 sd=0 mult=1 m=1
XM_RD_1_0_s1p08 rbl_s1p08 sn1_s1p08 rwls GND sky130_fd_pr__nfet_01v8 L=0.15 W=0.42 nf=1 ad=0.1218 as=0.1218 pd=1.42 ps=1.42 nrd=0.69047619047619  nrs=0.69047619047619 sa=0 sb=0 sd=0 mult=1 m=1
XM_WR_2_0_s1p08 sn2_s1p08 wl_2 blp08 GND sky130_fd_pr__nfet_01v8 L=0.15 W=0.42 nf=1 ad=0.1218 as=0.1218 pd=1.42 ps=1.42 nrd=0.69047619047619  nrs=0.69047619047619 sa=0 sb=0 sd=0 mult=1 m=1
XM_RD_2_0_s1p08 rbl_s1p08 sn2_s1p08 rwld GND sky130_fd_pr__nfet_01v8 L=0.15 W=0.42 nf=1 ad=0.1218 as=0.1218 pd=1.42 ps=1.42 nrd=0.69047619047619  nrs=0.69047619047619 sa=0 sb=0 sd=0 mult=1 m=1
XM_WR_3_0_s1p08 sn3_s1p08 wl_3 blp08 GND sky130_fd_pr__nfet_01v8 L=0.15 W=0.42 nf=1 ad=0.1218 as=0.1218 pd=1.42 ps=1.42 nrd=0.69047619047619  nrs=0.69047619047619 sa=0 sb=0 sd=0 mult=1 m=1
XM_RD_3_0_s1p08 rbl_s1p08 sn3_s1p08 rwld GND sky130_fd_pr__nfet_01v8 L=0.15 W=0.42 nf=1 ad=0.1218 as=0.1218 pd=1.42 ps=1.42 nrd=0.69047619047619  nrs=0.69047619047619 sa=0 sb=0 sd=0 mult=1 m=1
csn0_s1p08 sn0_s1p08 0 {C_SN}
csn1_s1p08 sn1_s1p08 0 {C_SN}
csn2_s1p08 sn2_s1p08 0 {C_SN}
csn3_s1p08 sn3_s1p08 0 {C_SN}
crbl_s1p08 rbl_s1p08 0 {C_RBL}
spre_s1p08 pre rbl_s1p08 ctl 0 swpre
ehb_s1p08 hb_s1p08 0 rbl_s1p08 0 1
shb_s1p08 hb_s1p08 hold_s1p08 hctl 0 swpre
chold_s1p08 hold_s1p08 0 1e-12
bdl_s1p08 dl_s1p08 0 v=v(rbl_s1p08)-v(hold_s1p08)+0.1-v(late)

* ---- case s1p09: selected row 1, pattern rows3210 1001 ----
XM_WR_0_0_s1p09 sn0_s1p09 wl_0 blp09 GND sky130_fd_pr__nfet_01v8 L=0.15 W=0.42 nf=1 ad=0.1218 as=0.1218 pd=1.42 ps=1.42 nrd=0.69047619047619  nrs=0.69047619047619 sa=0 sb=0 sd=0 mult=1 m=1
XM_RD_0_0_s1p09 rbl_s1p09 sn0_s1p09 rwld GND sky130_fd_pr__nfet_01v8 L=0.15 W=0.42 nf=1 ad=0.1218 as=0.1218 pd=1.42 ps=1.42 nrd=0.69047619047619  nrs=0.69047619047619 sa=0 sb=0 sd=0 mult=1 m=1
XM_WR_1_0_s1p09 sn1_s1p09 wl_1 blp09 GND sky130_fd_pr__nfet_01v8 L=0.15 W=0.42 nf=1 ad=0.1218 as=0.1218 pd=1.42 ps=1.42 nrd=0.69047619047619  nrs=0.69047619047619 sa=0 sb=0 sd=0 mult=1 m=1
XM_RD_1_0_s1p09 rbl_s1p09 sn1_s1p09 rwls GND sky130_fd_pr__nfet_01v8 L=0.15 W=0.42 nf=1 ad=0.1218 as=0.1218 pd=1.42 ps=1.42 nrd=0.69047619047619  nrs=0.69047619047619 sa=0 sb=0 sd=0 mult=1 m=1
XM_WR_2_0_s1p09 sn2_s1p09 wl_2 blp09 GND sky130_fd_pr__nfet_01v8 L=0.15 W=0.42 nf=1 ad=0.1218 as=0.1218 pd=1.42 ps=1.42 nrd=0.69047619047619  nrs=0.69047619047619 sa=0 sb=0 sd=0 mult=1 m=1
XM_RD_2_0_s1p09 rbl_s1p09 sn2_s1p09 rwld GND sky130_fd_pr__nfet_01v8 L=0.15 W=0.42 nf=1 ad=0.1218 as=0.1218 pd=1.42 ps=1.42 nrd=0.69047619047619  nrs=0.69047619047619 sa=0 sb=0 sd=0 mult=1 m=1
XM_WR_3_0_s1p09 sn3_s1p09 wl_3 blp09 GND sky130_fd_pr__nfet_01v8 L=0.15 W=0.42 nf=1 ad=0.1218 as=0.1218 pd=1.42 ps=1.42 nrd=0.69047619047619  nrs=0.69047619047619 sa=0 sb=0 sd=0 mult=1 m=1
XM_RD_3_0_s1p09 rbl_s1p09 sn3_s1p09 rwld GND sky130_fd_pr__nfet_01v8 L=0.15 W=0.42 nf=1 ad=0.1218 as=0.1218 pd=1.42 ps=1.42 nrd=0.69047619047619  nrs=0.69047619047619 sa=0 sb=0 sd=0 mult=1 m=1
csn0_s1p09 sn0_s1p09 0 {C_SN}
csn1_s1p09 sn1_s1p09 0 {C_SN}
csn2_s1p09 sn2_s1p09 0 {C_SN}
csn3_s1p09 sn3_s1p09 0 {C_SN}
crbl_s1p09 rbl_s1p09 0 {C_RBL}
spre_s1p09 pre rbl_s1p09 ctl 0 swpre
ehb_s1p09 hb_s1p09 0 rbl_s1p09 0 1
shb_s1p09 hb_s1p09 hold_s1p09 hctl 0 swpre
chold_s1p09 hold_s1p09 0 1e-12
bdl_s1p09 dl_s1p09 0 v=v(rbl_s1p09)-v(hold_s1p09)+0.1-v(late)

* ---- case s1p10: selected row 1, pattern rows3210 1010 ----
XM_WR_0_0_s1p10 sn0_s1p10 wl_0 blp10 GND sky130_fd_pr__nfet_01v8 L=0.15 W=0.42 nf=1 ad=0.1218 as=0.1218 pd=1.42 ps=1.42 nrd=0.69047619047619  nrs=0.69047619047619 sa=0 sb=0 sd=0 mult=1 m=1
XM_RD_0_0_s1p10 rbl_s1p10 sn0_s1p10 rwld GND sky130_fd_pr__nfet_01v8 L=0.15 W=0.42 nf=1 ad=0.1218 as=0.1218 pd=1.42 ps=1.42 nrd=0.69047619047619  nrs=0.69047619047619 sa=0 sb=0 sd=0 mult=1 m=1
XM_WR_1_0_s1p10 sn1_s1p10 wl_1 blp10 GND sky130_fd_pr__nfet_01v8 L=0.15 W=0.42 nf=1 ad=0.1218 as=0.1218 pd=1.42 ps=1.42 nrd=0.69047619047619  nrs=0.69047619047619 sa=0 sb=0 sd=0 mult=1 m=1
XM_RD_1_0_s1p10 rbl_s1p10 sn1_s1p10 rwls GND sky130_fd_pr__nfet_01v8 L=0.15 W=0.42 nf=1 ad=0.1218 as=0.1218 pd=1.42 ps=1.42 nrd=0.69047619047619  nrs=0.69047619047619 sa=0 sb=0 sd=0 mult=1 m=1
XM_WR_2_0_s1p10 sn2_s1p10 wl_2 blp10 GND sky130_fd_pr__nfet_01v8 L=0.15 W=0.42 nf=1 ad=0.1218 as=0.1218 pd=1.42 ps=1.42 nrd=0.69047619047619  nrs=0.69047619047619 sa=0 sb=0 sd=0 mult=1 m=1
XM_RD_2_0_s1p10 rbl_s1p10 sn2_s1p10 rwld GND sky130_fd_pr__nfet_01v8 L=0.15 W=0.42 nf=1 ad=0.1218 as=0.1218 pd=1.42 ps=1.42 nrd=0.69047619047619  nrs=0.69047619047619 sa=0 sb=0 sd=0 mult=1 m=1
XM_WR_3_0_s1p10 sn3_s1p10 wl_3 blp10 GND sky130_fd_pr__nfet_01v8 L=0.15 W=0.42 nf=1 ad=0.1218 as=0.1218 pd=1.42 ps=1.42 nrd=0.69047619047619  nrs=0.69047619047619 sa=0 sb=0 sd=0 mult=1 m=1
XM_RD_3_0_s1p10 rbl_s1p10 sn3_s1p10 rwld GND sky130_fd_pr__nfet_01v8 L=0.15 W=0.42 nf=1 ad=0.1218 as=0.1218 pd=1.42 ps=1.42 nrd=0.69047619047619  nrs=0.69047619047619 sa=0 sb=0 sd=0 mult=1 m=1
csn0_s1p10 sn0_s1p10 0 {C_SN}
csn1_s1p10 sn1_s1p10 0 {C_SN}
csn2_s1p10 sn2_s1p10 0 {C_SN}
csn3_s1p10 sn3_s1p10 0 {C_SN}
crbl_s1p10 rbl_s1p10 0 {C_RBL}
spre_s1p10 pre rbl_s1p10 ctl 0 swpre
ehb_s1p10 hb_s1p10 0 rbl_s1p10 0 1
shb_s1p10 hb_s1p10 hold_s1p10 hctl 0 swpre
chold_s1p10 hold_s1p10 0 1e-12
bdl_s1p10 dl_s1p10 0 v=v(rbl_s1p10)-v(hold_s1p10)+0.1-v(late)

* ---- case s1p11: selected row 1, pattern rows3210 1011 ----
XM_WR_0_0_s1p11 sn0_s1p11 wl_0 blp11 GND sky130_fd_pr__nfet_01v8 L=0.15 W=0.42 nf=1 ad=0.1218 as=0.1218 pd=1.42 ps=1.42 nrd=0.69047619047619  nrs=0.69047619047619 sa=0 sb=0 sd=0 mult=1 m=1
XM_RD_0_0_s1p11 rbl_s1p11 sn0_s1p11 rwld GND sky130_fd_pr__nfet_01v8 L=0.15 W=0.42 nf=1 ad=0.1218 as=0.1218 pd=1.42 ps=1.42 nrd=0.69047619047619  nrs=0.69047619047619 sa=0 sb=0 sd=0 mult=1 m=1
XM_WR_1_0_s1p11 sn1_s1p11 wl_1 blp11 GND sky130_fd_pr__nfet_01v8 L=0.15 W=0.42 nf=1 ad=0.1218 as=0.1218 pd=1.42 ps=1.42 nrd=0.69047619047619  nrs=0.69047619047619 sa=0 sb=0 sd=0 mult=1 m=1
XM_RD_1_0_s1p11 rbl_s1p11 sn1_s1p11 rwls GND sky130_fd_pr__nfet_01v8 L=0.15 W=0.42 nf=1 ad=0.1218 as=0.1218 pd=1.42 ps=1.42 nrd=0.69047619047619  nrs=0.69047619047619 sa=0 sb=0 sd=0 mult=1 m=1
XM_WR_2_0_s1p11 sn2_s1p11 wl_2 blp11 GND sky130_fd_pr__nfet_01v8 L=0.15 W=0.42 nf=1 ad=0.1218 as=0.1218 pd=1.42 ps=1.42 nrd=0.69047619047619  nrs=0.69047619047619 sa=0 sb=0 sd=0 mult=1 m=1
XM_RD_2_0_s1p11 rbl_s1p11 sn2_s1p11 rwld GND sky130_fd_pr__nfet_01v8 L=0.15 W=0.42 nf=1 ad=0.1218 as=0.1218 pd=1.42 ps=1.42 nrd=0.69047619047619  nrs=0.69047619047619 sa=0 sb=0 sd=0 mult=1 m=1
XM_WR_3_0_s1p11 sn3_s1p11 wl_3 blp11 GND sky130_fd_pr__nfet_01v8 L=0.15 W=0.42 nf=1 ad=0.1218 as=0.1218 pd=1.42 ps=1.42 nrd=0.69047619047619  nrs=0.69047619047619 sa=0 sb=0 sd=0 mult=1 m=1
XM_RD_3_0_s1p11 rbl_s1p11 sn3_s1p11 rwld GND sky130_fd_pr__nfet_01v8 L=0.15 W=0.42 nf=1 ad=0.1218 as=0.1218 pd=1.42 ps=1.42 nrd=0.69047619047619  nrs=0.69047619047619 sa=0 sb=0 sd=0 mult=1 m=1
csn0_s1p11 sn0_s1p11 0 {C_SN}
csn1_s1p11 sn1_s1p11 0 {C_SN}
csn2_s1p11 sn2_s1p11 0 {C_SN}
csn3_s1p11 sn3_s1p11 0 {C_SN}
crbl_s1p11 rbl_s1p11 0 {C_RBL}
spre_s1p11 pre rbl_s1p11 ctl 0 swpre
ehb_s1p11 hb_s1p11 0 rbl_s1p11 0 1
shb_s1p11 hb_s1p11 hold_s1p11 hctl 0 swpre
chold_s1p11 hold_s1p11 0 1e-12
bdl_s1p11 dl_s1p11 0 v=v(rbl_s1p11)-v(hold_s1p11)+0.1-v(late)

* ---- case s1p12: selected row 1, pattern rows3210 1100 ----
XM_WR_0_0_s1p12 sn0_s1p12 wl_0 blp12 GND sky130_fd_pr__nfet_01v8 L=0.15 W=0.42 nf=1 ad=0.1218 as=0.1218 pd=1.42 ps=1.42 nrd=0.69047619047619  nrs=0.69047619047619 sa=0 sb=0 sd=0 mult=1 m=1
XM_RD_0_0_s1p12 rbl_s1p12 sn0_s1p12 rwld GND sky130_fd_pr__nfet_01v8 L=0.15 W=0.42 nf=1 ad=0.1218 as=0.1218 pd=1.42 ps=1.42 nrd=0.69047619047619  nrs=0.69047619047619 sa=0 sb=0 sd=0 mult=1 m=1
XM_WR_1_0_s1p12 sn1_s1p12 wl_1 blp12 GND sky130_fd_pr__nfet_01v8 L=0.15 W=0.42 nf=1 ad=0.1218 as=0.1218 pd=1.42 ps=1.42 nrd=0.69047619047619  nrs=0.69047619047619 sa=0 sb=0 sd=0 mult=1 m=1
XM_RD_1_0_s1p12 rbl_s1p12 sn1_s1p12 rwls GND sky130_fd_pr__nfet_01v8 L=0.15 W=0.42 nf=1 ad=0.1218 as=0.1218 pd=1.42 ps=1.42 nrd=0.69047619047619  nrs=0.69047619047619 sa=0 sb=0 sd=0 mult=1 m=1
XM_WR_2_0_s1p12 sn2_s1p12 wl_2 blp12 GND sky130_fd_pr__nfet_01v8 L=0.15 W=0.42 nf=1 ad=0.1218 as=0.1218 pd=1.42 ps=1.42 nrd=0.69047619047619  nrs=0.69047619047619 sa=0 sb=0 sd=0 mult=1 m=1
XM_RD_2_0_s1p12 rbl_s1p12 sn2_s1p12 rwld GND sky130_fd_pr__nfet_01v8 L=0.15 W=0.42 nf=1 ad=0.1218 as=0.1218 pd=1.42 ps=1.42 nrd=0.69047619047619  nrs=0.69047619047619 sa=0 sb=0 sd=0 mult=1 m=1
XM_WR_3_0_s1p12 sn3_s1p12 wl_3 blp12 GND sky130_fd_pr__nfet_01v8 L=0.15 W=0.42 nf=1 ad=0.1218 as=0.1218 pd=1.42 ps=1.42 nrd=0.69047619047619  nrs=0.69047619047619 sa=0 sb=0 sd=0 mult=1 m=1
XM_RD_3_0_s1p12 rbl_s1p12 sn3_s1p12 rwld GND sky130_fd_pr__nfet_01v8 L=0.15 W=0.42 nf=1 ad=0.1218 as=0.1218 pd=1.42 ps=1.42 nrd=0.69047619047619  nrs=0.69047619047619 sa=0 sb=0 sd=0 mult=1 m=1
csn0_s1p12 sn0_s1p12 0 {C_SN}
csn1_s1p12 sn1_s1p12 0 {C_SN}
csn2_s1p12 sn2_s1p12 0 {C_SN}
csn3_s1p12 sn3_s1p12 0 {C_SN}
crbl_s1p12 rbl_s1p12 0 {C_RBL}
spre_s1p12 pre rbl_s1p12 ctl 0 swpre
ehb_s1p12 hb_s1p12 0 rbl_s1p12 0 1
shb_s1p12 hb_s1p12 hold_s1p12 hctl 0 swpre
chold_s1p12 hold_s1p12 0 1e-12
bdl_s1p12 dl_s1p12 0 v=v(rbl_s1p12)-v(hold_s1p12)+0.1-v(late)

* ---- case s1p13: selected row 1, pattern rows3210 1101 ----
XM_WR_0_0_s1p13 sn0_s1p13 wl_0 blp13 GND sky130_fd_pr__nfet_01v8 L=0.15 W=0.42 nf=1 ad=0.1218 as=0.1218 pd=1.42 ps=1.42 nrd=0.69047619047619  nrs=0.69047619047619 sa=0 sb=0 sd=0 mult=1 m=1
XM_RD_0_0_s1p13 rbl_s1p13 sn0_s1p13 rwld GND sky130_fd_pr__nfet_01v8 L=0.15 W=0.42 nf=1 ad=0.1218 as=0.1218 pd=1.42 ps=1.42 nrd=0.69047619047619  nrs=0.69047619047619 sa=0 sb=0 sd=0 mult=1 m=1
XM_WR_1_0_s1p13 sn1_s1p13 wl_1 blp13 GND sky130_fd_pr__nfet_01v8 L=0.15 W=0.42 nf=1 ad=0.1218 as=0.1218 pd=1.42 ps=1.42 nrd=0.69047619047619  nrs=0.69047619047619 sa=0 sb=0 sd=0 mult=1 m=1
XM_RD_1_0_s1p13 rbl_s1p13 sn1_s1p13 rwls GND sky130_fd_pr__nfet_01v8 L=0.15 W=0.42 nf=1 ad=0.1218 as=0.1218 pd=1.42 ps=1.42 nrd=0.69047619047619  nrs=0.69047619047619 sa=0 sb=0 sd=0 mult=1 m=1
XM_WR_2_0_s1p13 sn2_s1p13 wl_2 blp13 GND sky130_fd_pr__nfet_01v8 L=0.15 W=0.42 nf=1 ad=0.1218 as=0.1218 pd=1.42 ps=1.42 nrd=0.69047619047619  nrs=0.69047619047619 sa=0 sb=0 sd=0 mult=1 m=1
XM_RD_2_0_s1p13 rbl_s1p13 sn2_s1p13 rwld GND sky130_fd_pr__nfet_01v8 L=0.15 W=0.42 nf=1 ad=0.1218 as=0.1218 pd=1.42 ps=1.42 nrd=0.69047619047619  nrs=0.69047619047619 sa=0 sb=0 sd=0 mult=1 m=1
XM_WR_3_0_s1p13 sn3_s1p13 wl_3 blp13 GND sky130_fd_pr__nfet_01v8 L=0.15 W=0.42 nf=1 ad=0.1218 as=0.1218 pd=1.42 ps=1.42 nrd=0.69047619047619  nrs=0.69047619047619 sa=0 sb=0 sd=0 mult=1 m=1
XM_RD_3_0_s1p13 rbl_s1p13 sn3_s1p13 rwld GND sky130_fd_pr__nfet_01v8 L=0.15 W=0.42 nf=1 ad=0.1218 as=0.1218 pd=1.42 ps=1.42 nrd=0.69047619047619  nrs=0.69047619047619 sa=0 sb=0 sd=0 mult=1 m=1
csn0_s1p13 sn0_s1p13 0 {C_SN}
csn1_s1p13 sn1_s1p13 0 {C_SN}
csn2_s1p13 sn2_s1p13 0 {C_SN}
csn3_s1p13 sn3_s1p13 0 {C_SN}
crbl_s1p13 rbl_s1p13 0 {C_RBL}
spre_s1p13 pre rbl_s1p13 ctl 0 swpre
ehb_s1p13 hb_s1p13 0 rbl_s1p13 0 1
shb_s1p13 hb_s1p13 hold_s1p13 hctl 0 swpre
chold_s1p13 hold_s1p13 0 1e-12
bdl_s1p13 dl_s1p13 0 v=v(rbl_s1p13)-v(hold_s1p13)+0.1-v(late)

* ---- case s1p14: selected row 1, pattern rows3210 1110 ----
XM_WR_0_0_s1p14 sn0_s1p14 wl_0 blp14 GND sky130_fd_pr__nfet_01v8 L=0.15 W=0.42 nf=1 ad=0.1218 as=0.1218 pd=1.42 ps=1.42 nrd=0.69047619047619  nrs=0.69047619047619 sa=0 sb=0 sd=0 mult=1 m=1
XM_RD_0_0_s1p14 rbl_s1p14 sn0_s1p14 rwld GND sky130_fd_pr__nfet_01v8 L=0.15 W=0.42 nf=1 ad=0.1218 as=0.1218 pd=1.42 ps=1.42 nrd=0.69047619047619  nrs=0.69047619047619 sa=0 sb=0 sd=0 mult=1 m=1
XM_WR_1_0_s1p14 sn1_s1p14 wl_1 blp14 GND sky130_fd_pr__nfet_01v8 L=0.15 W=0.42 nf=1 ad=0.1218 as=0.1218 pd=1.42 ps=1.42 nrd=0.69047619047619  nrs=0.69047619047619 sa=0 sb=0 sd=0 mult=1 m=1
XM_RD_1_0_s1p14 rbl_s1p14 sn1_s1p14 rwls GND sky130_fd_pr__nfet_01v8 L=0.15 W=0.42 nf=1 ad=0.1218 as=0.1218 pd=1.42 ps=1.42 nrd=0.69047619047619  nrs=0.69047619047619 sa=0 sb=0 sd=0 mult=1 m=1
XM_WR_2_0_s1p14 sn2_s1p14 wl_2 blp14 GND sky130_fd_pr__nfet_01v8 L=0.15 W=0.42 nf=1 ad=0.1218 as=0.1218 pd=1.42 ps=1.42 nrd=0.69047619047619  nrs=0.69047619047619 sa=0 sb=0 sd=0 mult=1 m=1
XM_RD_2_0_s1p14 rbl_s1p14 sn2_s1p14 rwld GND sky130_fd_pr__nfet_01v8 L=0.15 W=0.42 nf=1 ad=0.1218 as=0.1218 pd=1.42 ps=1.42 nrd=0.69047619047619  nrs=0.69047619047619 sa=0 sb=0 sd=0 mult=1 m=1
XM_WR_3_0_s1p14 sn3_s1p14 wl_3 blp14 GND sky130_fd_pr__nfet_01v8 L=0.15 W=0.42 nf=1 ad=0.1218 as=0.1218 pd=1.42 ps=1.42 nrd=0.69047619047619  nrs=0.69047619047619 sa=0 sb=0 sd=0 mult=1 m=1
XM_RD_3_0_s1p14 rbl_s1p14 sn3_s1p14 rwld GND sky130_fd_pr__nfet_01v8 L=0.15 W=0.42 nf=1 ad=0.1218 as=0.1218 pd=1.42 ps=1.42 nrd=0.69047619047619  nrs=0.69047619047619 sa=0 sb=0 sd=0 mult=1 m=1
csn0_s1p14 sn0_s1p14 0 {C_SN}
csn1_s1p14 sn1_s1p14 0 {C_SN}
csn2_s1p14 sn2_s1p14 0 {C_SN}
csn3_s1p14 sn3_s1p14 0 {C_SN}
crbl_s1p14 rbl_s1p14 0 {C_RBL}
spre_s1p14 pre rbl_s1p14 ctl 0 swpre
ehb_s1p14 hb_s1p14 0 rbl_s1p14 0 1
shb_s1p14 hb_s1p14 hold_s1p14 hctl 0 swpre
chold_s1p14 hold_s1p14 0 1e-12
bdl_s1p14 dl_s1p14 0 v=v(rbl_s1p14)-v(hold_s1p14)+0.1-v(late)

* ---- case s1p15: selected row 1, pattern rows3210 1111 ----
XM_WR_0_0_s1p15 sn0_s1p15 wl_0 blp15 GND sky130_fd_pr__nfet_01v8 L=0.15 W=0.42 nf=1 ad=0.1218 as=0.1218 pd=1.42 ps=1.42 nrd=0.69047619047619  nrs=0.69047619047619 sa=0 sb=0 sd=0 mult=1 m=1
XM_RD_0_0_s1p15 rbl_s1p15 sn0_s1p15 rwld GND sky130_fd_pr__nfet_01v8 L=0.15 W=0.42 nf=1 ad=0.1218 as=0.1218 pd=1.42 ps=1.42 nrd=0.69047619047619  nrs=0.69047619047619 sa=0 sb=0 sd=0 mult=1 m=1
XM_WR_1_0_s1p15 sn1_s1p15 wl_1 blp15 GND sky130_fd_pr__nfet_01v8 L=0.15 W=0.42 nf=1 ad=0.1218 as=0.1218 pd=1.42 ps=1.42 nrd=0.69047619047619  nrs=0.69047619047619 sa=0 sb=0 sd=0 mult=1 m=1
XM_RD_1_0_s1p15 rbl_s1p15 sn1_s1p15 rwls GND sky130_fd_pr__nfet_01v8 L=0.15 W=0.42 nf=1 ad=0.1218 as=0.1218 pd=1.42 ps=1.42 nrd=0.69047619047619  nrs=0.69047619047619 sa=0 sb=0 sd=0 mult=1 m=1
XM_WR_2_0_s1p15 sn2_s1p15 wl_2 blp15 GND sky130_fd_pr__nfet_01v8 L=0.15 W=0.42 nf=1 ad=0.1218 as=0.1218 pd=1.42 ps=1.42 nrd=0.69047619047619  nrs=0.69047619047619 sa=0 sb=0 sd=0 mult=1 m=1
XM_RD_2_0_s1p15 rbl_s1p15 sn2_s1p15 rwld GND sky130_fd_pr__nfet_01v8 L=0.15 W=0.42 nf=1 ad=0.1218 as=0.1218 pd=1.42 ps=1.42 nrd=0.69047619047619  nrs=0.69047619047619 sa=0 sb=0 sd=0 mult=1 m=1
XM_WR_3_0_s1p15 sn3_s1p15 wl_3 blp15 GND sky130_fd_pr__nfet_01v8 L=0.15 W=0.42 nf=1 ad=0.1218 as=0.1218 pd=1.42 ps=1.42 nrd=0.69047619047619  nrs=0.69047619047619 sa=0 sb=0 sd=0 mult=1 m=1
XM_RD_3_0_s1p15 rbl_s1p15 sn3_s1p15 rwld GND sky130_fd_pr__nfet_01v8 L=0.15 W=0.42 nf=1 ad=0.1218 as=0.1218 pd=1.42 ps=1.42 nrd=0.69047619047619  nrs=0.69047619047619 sa=0 sb=0 sd=0 mult=1 m=1
csn0_s1p15 sn0_s1p15 0 {C_SN}
csn1_s1p15 sn1_s1p15 0 {C_SN}
csn2_s1p15 sn2_s1p15 0 {C_SN}
csn3_s1p15 sn3_s1p15 0 {C_SN}
crbl_s1p15 rbl_s1p15 0 {C_RBL}
spre_s1p15 pre rbl_s1p15 ctl 0 swpre
ehb_s1p15 hb_s1p15 0 rbl_s1p15 0 1
shb_s1p15 hb_s1p15 hold_s1p15 hctl 0 swpre
chold_s1p15 hold_s1p15 0 1e-12
bdl_s1p15 dl_s1p15 0 v=v(rbl_s1p15)-v(hold_s1p15)+0.1-v(late)

* ---- case s2p00: selected row 2, pattern rows3210 0000 ----
XM_WR_0_0_s2p00 sn0_s2p00 wl_0 blp00 GND sky130_fd_pr__nfet_01v8 L=0.15 W=0.42 nf=1 ad=0.1218 as=0.1218 pd=1.42 ps=1.42 nrd=0.69047619047619  nrs=0.69047619047619 sa=0 sb=0 sd=0 mult=1 m=1
XM_RD_0_0_s2p00 rbl_s2p00 sn0_s2p00 rwld GND sky130_fd_pr__nfet_01v8 L=0.15 W=0.42 nf=1 ad=0.1218 as=0.1218 pd=1.42 ps=1.42 nrd=0.69047619047619  nrs=0.69047619047619 sa=0 sb=0 sd=0 mult=1 m=1
XM_WR_1_0_s2p00 sn1_s2p00 wl_1 blp00 GND sky130_fd_pr__nfet_01v8 L=0.15 W=0.42 nf=1 ad=0.1218 as=0.1218 pd=1.42 ps=1.42 nrd=0.69047619047619  nrs=0.69047619047619 sa=0 sb=0 sd=0 mult=1 m=1
XM_RD_1_0_s2p00 rbl_s2p00 sn1_s2p00 rwld GND sky130_fd_pr__nfet_01v8 L=0.15 W=0.42 nf=1 ad=0.1218 as=0.1218 pd=1.42 ps=1.42 nrd=0.69047619047619  nrs=0.69047619047619 sa=0 sb=0 sd=0 mult=1 m=1
XM_WR_2_0_s2p00 sn2_s2p00 wl_2 blp00 GND sky130_fd_pr__nfet_01v8 L=0.15 W=0.42 nf=1 ad=0.1218 as=0.1218 pd=1.42 ps=1.42 nrd=0.69047619047619  nrs=0.69047619047619 sa=0 sb=0 sd=0 mult=1 m=1
XM_RD_2_0_s2p00 rbl_s2p00 sn2_s2p00 rwls GND sky130_fd_pr__nfet_01v8 L=0.15 W=0.42 nf=1 ad=0.1218 as=0.1218 pd=1.42 ps=1.42 nrd=0.69047619047619  nrs=0.69047619047619 sa=0 sb=0 sd=0 mult=1 m=1
XM_WR_3_0_s2p00 sn3_s2p00 wl_3 blp00 GND sky130_fd_pr__nfet_01v8 L=0.15 W=0.42 nf=1 ad=0.1218 as=0.1218 pd=1.42 ps=1.42 nrd=0.69047619047619  nrs=0.69047619047619 sa=0 sb=0 sd=0 mult=1 m=1
XM_RD_3_0_s2p00 rbl_s2p00 sn3_s2p00 rwld GND sky130_fd_pr__nfet_01v8 L=0.15 W=0.42 nf=1 ad=0.1218 as=0.1218 pd=1.42 ps=1.42 nrd=0.69047619047619  nrs=0.69047619047619 sa=0 sb=0 sd=0 mult=1 m=1
csn0_s2p00 sn0_s2p00 0 {C_SN}
csn1_s2p00 sn1_s2p00 0 {C_SN}
csn2_s2p00 sn2_s2p00 0 {C_SN}
csn3_s2p00 sn3_s2p00 0 {C_SN}
crbl_s2p00 rbl_s2p00 0 {C_RBL}
spre_s2p00 pre rbl_s2p00 ctl 0 swpre
ehb_s2p00 hb_s2p00 0 rbl_s2p00 0 1
shb_s2p00 hb_s2p00 hold_s2p00 hctl 0 swpre
chold_s2p00 hold_s2p00 0 1e-12
bdl_s2p00 dl_s2p00 0 v=v(rbl_s2p00)-v(hold_s2p00)+0.1-v(late)

* ---- case s2p01: selected row 2, pattern rows3210 0001 ----
XM_WR_0_0_s2p01 sn0_s2p01 wl_0 blp01 GND sky130_fd_pr__nfet_01v8 L=0.15 W=0.42 nf=1 ad=0.1218 as=0.1218 pd=1.42 ps=1.42 nrd=0.69047619047619  nrs=0.69047619047619 sa=0 sb=0 sd=0 mult=1 m=1
XM_RD_0_0_s2p01 rbl_s2p01 sn0_s2p01 rwld GND sky130_fd_pr__nfet_01v8 L=0.15 W=0.42 nf=1 ad=0.1218 as=0.1218 pd=1.42 ps=1.42 nrd=0.69047619047619  nrs=0.69047619047619 sa=0 sb=0 sd=0 mult=1 m=1
XM_WR_1_0_s2p01 sn1_s2p01 wl_1 blp01 GND sky130_fd_pr__nfet_01v8 L=0.15 W=0.42 nf=1 ad=0.1218 as=0.1218 pd=1.42 ps=1.42 nrd=0.69047619047619  nrs=0.69047619047619 sa=0 sb=0 sd=0 mult=1 m=1
XM_RD_1_0_s2p01 rbl_s2p01 sn1_s2p01 rwld GND sky130_fd_pr__nfet_01v8 L=0.15 W=0.42 nf=1 ad=0.1218 as=0.1218 pd=1.42 ps=1.42 nrd=0.69047619047619  nrs=0.69047619047619 sa=0 sb=0 sd=0 mult=1 m=1
XM_WR_2_0_s2p01 sn2_s2p01 wl_2 blp01 GND sky130_fd_pr__nfet_01v8 L=0.15 W=0.42 nf=1 ad=0.1218 as=0.1218 pd=1.42 ps=1.42 nrd=0.69047619047619  nrs=0.69047619047619 sa=0 sb=0 sd=0 mult=1 m=1
XM_RD_2_0_s2p01 rbl_s2p01 sn2_s2p01 rwls GND sky130_fd_pr__nfet_01v8 L=0.15 W=0.42 nf=1 ad=0.1218 as=0.1218 pd=1.42 ps=1.42 nrd=0.69047619047619  nrs=0.69047619047619 sa=0 sb=0 sd=0 mult=1 m=1
XM_WR_3_0_s2p01 sn3_s2p01 wl_3 blp01 GND sky130_fd_pr__nfet_01v8 L=0.15 W=0.42 nf=1 ad=0.1218 as=0.1218 pd=1.42 ps=1.42 nrd=0.69047619047619  nrs=0.69047619047619 sa=0 sb=0 sd=0 mult=1 m=1
XM_RD_3_0_s2p01 rbl_s2p01 sn3_s2p01 rwld GND sky130_fd_pr__nfet_01v8 L=0.15 W=0.42 nf=1 ad=0.1218 as=0.1218 pd=1.42 ps=1.42 nrd=0.69047619047619  nrs=0.69047619047619 sa=0 sb=0 sd=0 mult=1 m=1
csn0_s2p01 sn0_s2p01 0 {C_SN}
csn1_s2p01 sn1_s2p01 0 {C_SN}
csn2_s2p01 sn2_s2p01 0 {C_SN}
csn3_s2p01 sn3_s2p01 0 {C_SN}
crbl_s2p01 rbl_s2p01 0 {C_RBL}
spre_s2p01 pre rbl_s2p01 ctl 0 swpre
ehb_s2p01 hb_s2p01 0 rbl_s2p01 0 1
shb_s2p01 hb_s2p01 hold_s2p01 hctl 0 swpre
chold_s2p01 hold_s2p01 0 1e-12
bdl_s2p01 dl_s2p01 0 v=v(rbl_s2p01)-v(hold_s2p01)+0.1-v(late)

* ---- case s2p02: selected row 2, pattern rows3210 0010 ----
XM_WR_0_0_s2p02 sn0_s2p02 wl_0 blp02 GND sky130_fd_pr__nfet_01v8 L=0.15 W=0.42 nf=1 ad=0.1218 as=0.1218 pd=1.42 ps=1.42 nrd=0.69047619047619  nrs=0.69047619047619 sa=0 sb=0 sd=0 mult=1 m=1
XM_RD_0_0_s2p02 rbl_s2p02 sn0_s2p02 rwld GND sky130_fd_pr__nfet_01v8 L=0.15 W=0.42 nf=1 ad=0.1218 as=0.1218 pd=1.42 ps=1.42 nrd=0.69047619047619  nrs=0.69047619047619 sa=0 sb=0 sd=0 mult=1 m=1
XM_WR_1_0_s2p02 sn1_s2p02 wl_1 blp02 GND sky130_fd_pr__nfet_01v8 L=0.15 W=0.42 nf=1 ad=0.1218 as=0.1218 pd=1.42 ps=1.42 nrd=0.69047619047619  nrs=0.69047619047619 sa=0 sb=0 sd=0 mult=1 m=1
XM_RD_1_0_s2p02 rbl_s2p02 sn1_s2p02 rwld GND sky130_fd_pr__nfet_01v8 L=0.15 W=0.42 nf=1 ad=0.1218 as=0.1218 pd=1.42 ps=1.42 nrd=0.69047619047619  nrs=0.69047619047619 sa=0 sb=0 sd=0 mult=1 m=1
XM_WR_2_0_s2p02 sn2_s2p02 wl_2 blp02 GND sky130_fd_pr__nfet_01v8 L=0.15 W=0.42 nf=1 ad=0.1218 as=0.1218 pd=1.42 ps=1.42 nrd=0.69047619047619  nrs=0.69047619047619 sa=0 sb=0 sd=0 mult=1 m=1
XM_RD_2_0_s2p02 rbl_s2p02 sn2_s2p02 rwls GND sky130_fd_pr__nfet_01v8 L=0.15 W=0.42 nf=1 ad=0.1218 as=0.1218 pd=1.42 ps=1.42 nrd=0.69047619047619  nrs=0.69047619047619 sa=0 sb=0 sd=0 mult=1 m=1
XM_WR_3_0_s2p02 sn3_s2p02 wl_3 blp02 GND sky130_fd_pr__nfet_01v8 L=0.15 W=0.42 nf=1 ad=0.1218 as=0.1218 pd=1.42 ps=1.42 nrd=0.69047619047619  nrs=0.69047619047619 sa=0 sb=0 sd=0 mult=1 m=1
XM_RD_3_0_s2p02 rbl_s2p02 sn3_s2p02 rwld GND sky130_fd_pr__nfet_01v8 L=0.15 W=0.42 nf=1 ad=0.1218 as=0.1218 pd=1.42 ps=1.42 nrd=0.69047619047619  nrs=0.69047619047619 sa=0 sb=0 sd=0 mult=1 m=1
csn0_s2p02 sn0_s2p02 0 {C_SN}
csn1_s2p02 sn1_s2p02 0 {C_SN}
csn2_s2p02 sn2_s2p02 0 {C_SN}
csn3_s2p02 sn3_s2p02 0 {C_SN}
crbl_s2p02 rbl_s2p02 0 {C_RBL}
spre_s2p02 pre rbl_s2p02 ctl 0 swpre
ehb_s2p02 hb_s2p02 0 rbl_s2p02 0 1
shb_s2p02 hb_s2p02 hold_s2p02 hctl 0 swpre
chold_s2p02 hold_s2p02 0 1e-12
bdl_s2p02 dl_s2p02 0 v=v(rbl_s2p02)-v(hold_s2p02)+0.1-v(late)

* ---- case s2p03: selected row 2, pattern rows3210 0011 ----
XM_WR_0_0_s2p03 sn0_s2p03 wl_0 blp03 GND sky130_fd_pr__nfet_01v8 L=0.15 W=0.42 nf=1 ad=0.1218 as=0.1218 pd=1.42 ps=1.42 nrd=0.69047619047619  nrs=0.69047619047619 sa=0 sb=0 sd=0 mult=1 m=1
XM_RD_0_0_s2p03 rbl_s2p03 sn0_s2p03 rwld GND sky130_fd_pr__nfet_01v8 L=0.15 W=0.42 nf=1 ad=0.1218 as=0.1218 pd=1.42 ps=1.42 nrd=0.69047619047619  nrs=0.69047619047619 sa=0 sb=0 sd=0 mult=1 m=1
XM_WR_1_0_s2p03 sn1_s2p03 wl_1 blp03 GND sky130_fd_pr__nfet_01v8 L=0.15 W=0.42 nf=1 ad=0.1218 as=0.1218 pd=1.42 ps=1.42 nrd=0.69047619047619  nrs=0.69047619047619 sa=0 sb=0 sd=0 mult=1 m=1
XM_RD_1_0_s2p03 rbl_s2p03 sn1_s2p03 rwld GND sky130_fd_pr__nfet_01v8 L=0.15 W=0.42 nf=1 ad=0.1218 as=0.1218 pd=1.42 ps=1.42 nrd=0.69047619047619  nrs=0.69047619047619 sa=0 sb=0 sd=0 mult=1 m=1
XM_WR_2_0_s2p03 sn2_s2p03 wl_2 blp03 GND sky130_fd_pr__nfet_01v8 L=0.15 W=0.42 nf=1 ad=0.1218 as=0.1218 pd=1.42 ps=1.42 nrd=0.69047619047619  nrs=0.69047619047619 sa=0 sb=0 sd=0 mult=1 m=1
XM_RD_2_0_s2p03 rbl_s2p03 sn2_s2p03 rwls GND sky130_fd_pr__nfet_01v8 L=0.15 W=0.42 nf=1 ad=0.1218 as=0.1218 pd=1.42 ps=1.42 nrd=0.69047619047619  nrs=0.69047619047619 sa=0 sb=0 sd=0 mult=1 m=1
XM_WR_3_0_s2p03 sn3_s2p03 wl_3 blp03 GND sky130_fd_pr__nfet_01v8 L=0.15 W=0.42 nf=1 ad=0.1218 as=0.1218 pd=1.42 ps=1.42 nrd=0.69047619047619  nrs=0.69047619047619 sa=0 sb=0 sd=0 mult=1 m=1
XM_RD_3_0_s2p03 rbl_s2p03 sn3_s2p03 rwld GND sky130_fd_pr__nfet_01v8 L=0.15 W=0.42 nf=1 ad=0.1218 as=0.1218 pd=1.42 ps=1.42 nrd=0.69047619047619  nrs=0.69047619047619 sa=0 sb=0 sd=0 mult=1 m=1
csn0_s2p03 sn0_s2p03 0 {C_SN}
csn1_s2p03 sn1_s2p03 0 {C_SN}
csn2_s2p03 sn2_s2p03 0 {C_SN}
csn3_s2p03 sn3_s2p03 0 {C_SN}
crbl_s2p03 rbl_s2p03 0 {C_RBL}
spre_s2p03 pre rbl_s2p03 ctl 0 swpre
ehb_s2p03 hb_s2p03 0 rbl_s2p03 0 1
shb_s2p03 hb_s2p03 hold_s2p03 hctl 0 swpre
chold_s2p03 hold_s2p03 0 1e-12
bdl_s2p03 dl_s2p03 0 v=v(rbl_s2p03)-v(hold_s2p03)+0.1-v(late)

* ---- case s2p04: selected row 2, pattern rows3210 0100 ----
XM_WR_0_0_s2p04 sn0_s2p04 wl_0 blp04 GND sky130_fd_pr__nfet_01v8 L=0.15 W=0.42 nf=1 ad=0.1218 as=0.1218 pd=1.42 ps=1.42 nrd=0.69047619047619  nrs=0.69047619047619 sa=0 sb=0 sd=0 mult=1 m=1
XM_RD_0_0_s2p04 rbl_s2p04 sn0_s2p04 rwld GND sky130_fd_pr__nfet_01v8 L=0.15 W=0.42 nf=1 ad=0.1218 as=0.1218 pd=1.42 ps=1.42 nrd=0.69047619047619  nrs=0.69047619047619 sa=0 sb=0 sd=0 mult=1 m=1
XM_WR_1_0_s2p04 sn1_s2p04 wl_1 blp04 GND sky130_fd_pr__nfet_01v8 L=0.15 W=0.42 nf=1 ad=0.1218 as=0.1218 pd=1.42 ps=1.42 nrd=0.69047619047619  nrs=0.69047619047619 sa=0 sb=0 sd=0 mult=1 m=1
XM_RD_1_0_s2p04 rbl_s2p04 sn1_s2p04 rwld GND sky130_fd_pr__nfet_01v8 L=0.15 W=0.42 nf=1 ad=0.1218 as=0.1218 pd=1.42 ps=1.42 nrd=0.69047619047619  nrs=0.69047619047619 sa=0 sb=0 sd=0 mult=1 m=1
XM_WR_2_0_s2p04 sn2_s2p04 wl_2 blp04 GND sky130_fd_pr__nfet_01v8 L=0.15 W=0.42 nf=1 ad=0.1218 as=0.1218 pd=1.42 ps=1.42 nrd=0.69047619047619  nrs=0.69047619047619 sa=0 sb=0 sd=0 mult=1 m=1
XM_RD_2_0_s2p04 rbl_s2p04 sn2_s2p04 rwls GND sky130_fd_pr__nfet_01v8 L=0.15 W=0.42 nf=1 ad=0.1218 as=0.1218 pd=1.42 ps=1.42 nrd=0.69047619047619  nrs=0.69047619047619 sa=0 sb=0 sd=0 mult=1 m=1
XM_WR_3_0_s2p04 sn3_s2p04 wl_3 blp04 GND sky130_fd_pr__nfet_01v8 L=0.15 W=0.42 nf=1 ad=0.1218 as=0.1218 pd=1.42 ps=1.42 nrd=0.69047619047619  nrs=0.69047619047619 sa=0 sb=0 sd=0 mult=1 m=1
XM_RD_3_0_s2p04 rbl_s2p04 sn3_s2p04 rwld GND sky130_fd_pr__nfet_01v8 L=0.15 W=0.42 nf=1 ad=0.1218 as=0.1218 pd=1.42 ps=1.42 nrd=0.69047619047619  nrs=0.69047619047619 sa=0 sb=0 sd=0 mult=1 m=1
csn0_s2p04 sn0_s2p04 0 {C_SN}
csn1_s2p04 sn1_s2p04 0 {C_SN}
csn2_s2p04 sn2_s2p04 0 {C_SN}
csn3_s2p04 sn3_s2p04 0 {C_SN}
crbl_s2p04 rbl_s2p04 0 {C_RBL}
spre_s2p04 pre rbl_s2p04 ctl 0 swpre
ehb_s2p04 hb_s2p04 0 rbl_s2p04 0 1
shb_s2p04 hb_s2p04 hold_s2p04 hctl 0 swpre
chold_s2p04 hold_s2p04 0 1e-12
bdl_s2p04 dl_s2p04 0 v=v(rbl_s2p04)-v(hold_s2p04)+0.1-v(late)

* ---- case s2p05: selected row 2, pattern rows3210 0101 ----
XM_WR_0_0_s2p05 sn0_s2p05 wl_0 blp05 GND sky130_fd_pr__nfet_01v8 L=0.15 W=0.42 nf=1 ad=0.1218 as=0.1218 pd=1.42 ps=1.42 nrd=0.69047619047619  nrs=0.69047619047619 sa=0 sb=0 sd=0 mult=1 m=1
XM_RD_0_0_s2p05 rbl_s2p05 sn0_s2p05 rwld GND sky130_fd_pr__nfet_01v8 L=0.15 W=0.42 nf=1 ad=0.1218 as=0.1218 pd=1.42 ps=1.42 nrd=0.69047619047619  nrs=0.69047619047619 sa=0 sb=0 sd=0 mult=1 m=1
XM_WR_1_0_s2p05 sn1_s2p05 wl_1 blp05 GND sky130_fd_pr__nfet_01v8 L=0.15 W=0.42 nf=1 ad=0.1218 as=0.1218 pd=1.42 ps=1.42 nrd=0.69047619047619  nrs=0.69047619047619 sa=0 sb=0 sd=0 mult=1 m=1
XM_RD_1_0_s2p05 rbl_s2p05 sn1_s2p05 rwld GND sky130_fd_pr__nfet_01v8 L=0.15 W=0.42 nf=1 ad=0.1218 as=0.1218 pd=1.42 ps=1.42 nrd=0.69047619047619  nrs=0.69047619047619 sa=0 sb=0 sd=0 mult=1 m=1
XM_WR_2_0_s2p05 sn2_s2p05 wl_2 blp05 GND sky130_fd_pr__nfet_01v8 L=0.15 W=0.42 nf=1 ad=0.1218 as=0.1218 pd=1.42 ps=1.42 nrd=0.69047619047619  nrs=0.69047619047619 sa=0 sb=0 sd=0 mult=1 m=1
XM_RD_2_0_s2p05 rbl_s2p05 sn2_s2p05 rwls GND sky130_fd_pr__nfet_01v8 L=0.15 W=0.42 nf=1 ad=0.1218 as=0.1218 pd=1.42 ps=1.42 nrd=0.69047619047619  nrs=0.69047619047619 sa=0 sb=0 sd=0 mult=1 m=1
XM_WR_3_0_s2p05 sn3_s2p05 wl_3 blp05 GND sky130_fd_pr__nfet_01v8 L=0.15 W=0.42 nf=1 ad=0.1218 as=0.1218 pd=1.42 ps=1.42 nrd=0.69047619047619  nrs=0.69047619047619 sa=0 sb=0 sd=0 mult=1 m=1
XM_RD_3_0_s2p05 rbl_s2p05 sn3_s2p05 rwld GND sky130_fd_pr__nfet_01v8 L=0.15 W=0.42 nf=1 ad=0.1218 as=0.1218 pd=1.42 ps=1.42 nrd=0.69047619047619  nrs=0.69047619047619 sa=0 sb=0 sd=0 mult=1 m=1
csn0_s2p05 sn0_s2p05 0 {C_SN}
csn1_s2p05 sn1_s2p05 0 {C_SN}
csn2_s2p05 sn2_s2p05 0 {C_SN}
csn3_s2p05 sn3_s2p05 0 {C_SN}
crbl_s2p05 rbl_s2p05 0 {C_RBL}
spre_s2p05 pre rbl_s2p05 ctl 0 swpre
ehb_s2p05 hb_s2p05 0 rbl_s2p05 0 1
shb_s2p05 hb_s2p05 hold_s2p05 hctl 0 swpre
chold_s2p05 hold_s2p05 0 1e-12
bdl_s2p05 dl_s2p05 0 v=v(rbl_s2p05)-v(hold_s2p05)+0.1-v(late)

* ---- case s2p06: selected row 2, pattern rows3210 0110 ----
XM_WR_0_0_s2p06 sn0_s2p06 wl_0 blp06 GND sky130_fd_pr__nfet_01v8 L=0.15 W=0.42 nf=1 ad=0.1218 as=0.1218 pd=1.42 ps=1.42 nrd=0.69047619047619  nrs=0.69047619047619 sa=0 sb=0 sd=0 mult=1 m=1
XM_RD_0_0_s2p06 rbl_s2p06 sn0_s2p06 rwld GND sky130_fd_pr__nfet_01v8 L=0.15 W=0.42 nf=1 ad=0.1218 as=0.1218 pd=1.42 ps=1.42 nrd=0.69047619047619  nrs=0.69047619047619 sa=0 sb=0 sd=0 mult=1 m=1
XM_WR_1_0_s2p06 sn1_s2p06 wl_1 blp06 GND sky130_fd_pr__nfet_01v8 L=0.15 W=0.42 nf=1 ad=0.1218 as=0.1218 pd=1.42 ps=1.42 nrd=0.69047619047619  nrs=0.69047619047619 sa=0 sb=0 sd=0 mult=1 m=1
XM_RD_1_0_s2p06 rbl_s2p06 sn1_s2p06 rwld GND sky130_fd_pr__nfet_01v8 L=0.15 W=0.42 nf=1 ad=0.1218 as=0.1218 pd=1.42 ps=1.42 nrd=0.69047619047619  nrs=0.69047619047619 sa=0 sb=0 sd=0 mult=1 m=1
XM_WR_2_0_s2p06 sn2_s2p06 wl_2 blp06 GND sky130_fd_pr__nfet_01v8 L=0.15 W=0.42 nf=1 ad=0.1218 as=0.1218 pd=1.42 ps=1.42 nrd=0.69047619047619  nrs=0.69047619047619 sa=0 sb=0 sd=0 mult=1 m=1
XM_RD_2_0_s2p06 rbl_s2p06 sn2_s2p06 rwls GND sky130_fd_pr__nfet_01v8 L=0.15 W=0.42 nf=1 ad=0.1218 as=0.1218 pd=1.42 ps=1.42 nrd=0.69047619047619  nrs=0.69047619047619 sa=0 sb=0 sd=0 mult=1 m=1
XM_WR_3_0_s2p06 sn3_s2p06 wl_3 blp06 GND sky130_fd_pr__nfet_01v8 L=0.15 W=0.42 nf=1 ad=0.1218 as=0.1218 pd=1.42 ps=1.42 nrd=0.69047619047619  nrs=0.69047619047619 sa=0 sb=0 sd=0 mult=1 m=1
XM_RD_3_0_s2p06 rbl_s2p06 sn3_s2p06 rwld GND sky130_fd_pr__nfet_01v8 L=0.15 W=0.42 nf=1 ad=0.1218 as=0.1218 pd=1.42 ps=1.42 nrd=0.69047619047619  nrs=0.69047619047619 sa=0 sb=0 sd=0 mult=1 m=1
csn0_s2p06 sn0_s2p06 0 {C_SN}
csn1_s2p06 sn1_s2p06 0 {C_SN}
csn2_s2p06 sn2_s2p06 0 {C_SN}
csn3_s2p06 sn3_s2p06 0 {C_SN}
crbl_s2p06 rbl_s2p06 0 {C_RBL}
spre_s2p06 pre rbl_s2p06 ctl 0 swpre
ehb_s2p06 hb_s2p06 0 rbl_s2p06 0 1
shb_s2p06 hb_s2p06 hold_s2p06 hctl 0 swpre
chold_s2p06 hold_s2p06 0 1e-12
bdl_s2p06 dl_s2p06 0 v=v(rbl_s2p06)-v(hold_s2p06)+0.1-v(late)

* ---- case s2p07: selected row 2, pattern rows3210 0111 ----
XM_WR_0_0_s2p07 sn0_s2p07 wl_0 blp07 GND sky130_fd_pr__nfet_01v8 L=0.15 W=0.42 nf=1 ad=0.1218 as=0.1218 pd=1.42 ps=1.42 nrd=0.69047619047619  nrs=0.69047619047619 sa=0 sb=0 sd=0 mult=1 m=1
XM_RD_0_0_s2p07 rbl_s2p07 sn0_s2p07 rwld GND sky130_fd_pr__nfet_01v8 L=0.15 W=0.42 nf=1 ad=0.1218 as=0.1218 pd=1.42 ps=1.42 nrd=0.69047619047619  nrs=0.69047619047619 sa=0 sb=0 sd=0 mult=1 m=1
XM_WR_1_0_s2p07 sn1_s2p07 wl_1 blp07 GND sky130_fd_pr__nfet_01v8 L=0.15 W=0.42 nf=1 ad=0.1218 as=0.1218 pd=1.42 ps=1.42 nrd=0.69047619047619  nrs=0.69047619047619 sa=0 sb=0 sd=0 mult=1 m=1
XM_RD_1_0_s2p07 rbl_s2p07 sn1_s2p07 rwld GND sky130_fd_pr__nfet_01v8 L=0.15 W=0.42 nf=1 ad=0.1218 as=0.1218 pd=1.42 ps=1.42 nrd=0.69047619047619  nrs=0.69047619047619 sa=0 sb=0 sd=0 mult=1 m=1
XM_WR_2_0_s2p07 sn2_s2p07 wl_2 blp07 GND sky130_fd_pr__nfet_01v8 L=0.15 W=0.42 nf=1 ad=0.1218 as=0.1218 pd=1.42 ps=1.42 nrd=0.69047619047619  nrs=0.69047619047619 sa=0 sb=0 sd=0 mult=1 m=1
XM_RD_2_0_s2p07 rbl_s2p07 sn2_s2p07 rwls GND sky130_fd_pr__nfet_01v8 L=0.15 W=0.42 nf=1 ad=0.1218 as=0.1218 pd=1.42 ps=1.42 nrd=0.69047619047619  nrs=0.69047619047619 sa=0 sb=0 sd=0 mult=1 m=1
XM_WR_3_0_s2p07 sn3_s2p07 wl_3 blp07 GND sky130_fd_pr__nfet_01v8 L=0.15 W=0.42 nf=1 ad=0.1218 as=0.1218 pd=1.42 ps=1.42 nrd=0.69047619047619  nrs=0.69047619047619 sa=0 sb=0 sd=0 mult=1 m=1
XM_RD_3_0_s2p07 rbl_s2p07 sn3_s2p07 rwld GND sky130_fd_pr__nfet_01v8 L=0.15 W=0.42 nf=1 ad=0.1218 as=0.1218 pd=1.42 ps=1.42 nrd=0.69047619047619  nrs=0.69047619047619 sa=0 sb=0 sd=0 mult=1 m=1
csn0_s2p07 sn0_s2p07 0 {C_SN}
csn1_s2p07 sn1_s2p07 0 {C_SN}
csn2_s2p07 sn2_s2p07 0 {C_SN}
csn3_s2p07 sn3_s2p07 0 {C_SN}
crbl_s2p07 rbl_s2p07 0 {C_RBL}
spre_s2p07 pre rbl_s2p07 ctl 0 swpre
ehb_s2p07 hb_s2p07 0 rbl_s2p07 0 1
shb_s2p07 hb_s2p07 hold_s2p07 hctl 0 swpre
chold_s2p07 hold_s2p07 0 1e-12
bdl_s2p07 dl_s2p07 0 v=v(rbl_s2p07)-v(hold_s2p07)+0.1-v(late)

* ---- case s2p08: selected row 2, pattern rows3210 1000 ----
XM_WR_0_0_s2p08 sn0_s2p08 wl_0 blp08 GND sky130_fd_pr__nfet_01v8 L=0.15 W=0.42 nf=1 ad=0.1218 as=0.1218 pd=1.42 ps=1.42 nrd=0.69047619047619  nrs=0.69047619047619 sa=0 sb=0 sd=0 mult=1 m=1
XM_RD_0_0_s2p08 rbl_s2p08 sn0_s2p08 rwld GND sky130_fd_pr__nfet_01v8 L=0.15 W=0.42 nf=1 ad=0.1218 as=0.1218 pd=1.42 ps=1.42 nrd=0.69047619047619  nrs=0.69047619047619 sa=0 sb=0 sd=0 mult=1 m=1
XM_WR_1_0_s2p08 sn1_s2p08 wl_1 blp08 GND sky130_fd_pr__nfet_01v8 L=0.15 W=0.42 nf=1 ad=0.1218 as=0.1218 pd=1.42 ps=1.42 nrd=0.69047619047619  nrs=0.69047619047619 sa=0 sb=0 sd=0 mult=1 m=1
XM_RD_1_0_s2p08 rbl_s2p08 sn1_s2p08 rwld GND sky130_fd_pr__nfet_01v8 L=0.15 W=0.42 nf=1 ad=0.1218 as=0.1218 pd=1.42 ps=1.42 nrd=0.69047619047619  nrs=0.69047619047619 sa=0 sb=0 sd=0 mult=1 m=1
XM_WR_2_0_s2p08 sn2_s2p08 wl_2 blp08 GND sky130_fd_pr__nfet_01v8 L=0.15 W=0.42 nf=1 ad=0.1218 as=0.1218 pd=1.42 ps=1.42 nrd=0.69047619047619  nrs=0.69047619047619 sa=0 sb=0 sd=0 mult=1 m=1
XM_RD_2_0_s2p08 rbl_s2p08 sn2_s2p08 rwls GND sky130_fd_pr__nfet_01v8 L=0.15 W=0.42 nf=1 ad=0.1218 as=0.1218 pd=1.42 ps=1.42 nrd=0.69047619047619  nrs=0.69047619047619 sa=0 sb=0 sd=0 mult=1 m=1
XM_WR_3_0_s2p08 sn3_s2p08 wl_3 blp08 GND sky130_fd_pr__nfet_01v8 L=0.15 W=0.42 nf=1 ad=0.1218 as=0.1218 pd=1.42 ps=1.42 nrd=0.69047619047619  nrs=0.69047619047619 sa=0 sb=0 sd=0 mult=1 m=1
XM_RD_3_0_s2p08 rbl_s2p08 sn3_s2p08 rwld GND sky130_fd_pr__nfet_01v8 L=0.15 W=0.42 nf=1 ad=0.1218 as=0.1218 pd=1.42 ps=1.42 nrd=0.69047619047619  nrs=0.69047619047619 sa=0 sb=0 sd=0 mult=1 m=1
csn0_s2p08 sn0_s2p08 0 {C_SN}
csn1_s2p08 sn1_s2p08 0 {C_SN}
csn2_s2p08 sn2_s2p08 0 {C_SN}
csn3_s2p08 sn3_s2p08 0 {C_SN}
crbl_s2p08 rbl_s2p08 0 {C_RBL}
spre_s2p08 pre rbl_s2p08 ctl 0 swpre
ehb_s2p08 hb_s2p08 0 rbl_s2p08 0 1
shb_s2p08 hb_s2p08 hold_s2p08 hctl 0 swpre
chold_s2p08 hold_s2p08 0 1e-12
bdl_s2p08 dl_s2p08 0 v=v(rbl_s2p08)-v(hold_s2p08)+0.1-v(late)

* ---- case s2p09: selected row 2, pattern rows3210 1001 ----
XM_WR_0_0_s2p09 sn0_s2p09 wl_0 blp09 GND sky130_fd_pr__nfet_01v8 L=0.15 W=0.42 nf=1 ad=0.1218 as=0.1218 pd=1.42 ps=1.42 nrd=0.69047619047619  nrs=0.69047619047619 sa=0 sb=0 sd=0 mult=1 m=1
XM_RD_0_0_s2p09 rbl_s2p09 sn0_s2p09 rwld GND sky130_fd_pr__nfet_01v8 L=0.15 W=0.42 nf=1 ad=0.1218 as=0.1218 pd=1.42 ps=1.42 nrd=0.69047619047619  nrs=0.69047619047619 sa=0 sb=0 sd=0 mult=1 m=1
XM_WR_1_0_s2p09 sn1_s2p09 wl_1 blp09 GND sky130_fd_pr__nfet_01v8 L=0.15 W=0.42 nf=1 ad=0.1218 as=0.1218 pd=1.42 ps=1.42 nrd=0.69047619047619  nrs=0.69047619047619 sa=0 sb=0 sd=0 mult=1 m=1
XM_RD_1_0_s2p09 rbl_s2p09 sn1_s2p09 rwld GND sky130_fd_pr__nfet_01v8 L=0.15 W=0.42 nf=1 ad=0.1218 as=0.1218 pd=1.42 ps=1.42 nrd=0.69047619047619  nrs=0.69047619047619 sa=0 sb=0 sd=0 mult=1 m=1
XM_WR_2_0_s2p09 sn2_s2p09 wl_2 blp09 GND sky130_fd_pr__nfet_01v8 L=0.15 W=0.42 nf=1 ad=0.1218 as=0.1218 pd=1.42 ps=1.42 nrd=0.69047619047619  nrs=0.69047619047619 sa=0 sb=0 sd=0 mult=1 m=1
XM_RD_2_0_s2p09 rbl_s2p09 sn2_s2p09 rwls GND sky130_fd_pr__nfet_01v8 L=0.15 W=0.42 nf=1 ad=0.1218 as=0.1218 pd=1.42 ps=1.42 nrd=0.69047619047619  nrs=0.69047619047619 sa=0 sb=0 sd=0 mult=1 m=1
XM_WR_3_0_s2p09 sn3_s2p09 wl_3 blp09 GND sky130_fd_pr__nfet_01v8 L=0.15 W=0.42 nf=1 ad=0.1218 as=0.1218 pd=1.42 ps=1.42 nrd=0.69047619047619  nrs=0.69047619047619 sa=0 sb=0 sd=0 mult=1 m=1
XM_RD_3_0_s2p09 rbl_s2p09 sn3_s2p09 rwld GND sky130_fd_pr__nfet_01v8 L=0.15 W=0.42 nf=1 ad=0.1218 as=0.1218 pd=1.42 ps=1.42 nrd=0.69047619047619  nrs=0.69047619047619 sa=0 sb=0 sd=0 mult=1 m=1
csn0_s2p09 sn0_s2p09 0 {C_SN}
csn1_s2p09 sn1_s2p09 0 {C_SN}
csn2_s2p09 sn2_s2p09 0 {C_SN}
csn3_s2p09 sn3_s2p09 0 {C_SN}
crbl_s2p09 rbl_s2p09 0 {C_RBL}
spre_s2p09 pre rbl_s2p09 ctl 0 swpre
ehb_s2p09 hb_s2p09 0 rbl_s2p09 0 1
shb_s2p09 hb_s2p09 hold_s2p09 hctl 0 swpre
chold_s2p09 hold_s2p09 0 1e-12
bdl_s2p09 dl_s2p09 0 v=v(rbl_s2p09)-v(hold_s2p09)+0.1-v(late)

* ---- case s2p10: selected row 2, pattern rows3210 1010 ----
XM_WR_0_0_s2p10 sn0_s2p10 wl_0 blp10 GND sky130_fd_pr__nfet_01v8 L=0.15 W=0.42 nf=1 ad=0.1218 as=0.1218 pd=1.42 ps=1.42 nrd=0.69047619047619  nrs=0.69047619047619 sa=0 sb=0 sd=0 mult=1 m=1
XM_RD_0_0_s2p10 rbl_s2p10 sn0_s2p10 rwld GND sky130_fd_pr__nfet_01v8 L=0.15 W=0.42 nf=1 ad=0.1218 as=0.1218 pd=1.42 ps=1.42 nrd=0.69047619047619  nrs=0.69047619047619 sa=0 sb=0 sd=0 mult=1 m=1
XM_WR_1_0_s2p10 sn1_s2p10 wl_1 blp10 GND sky130_fd_pr__nfet_01v8 L=0.15 W=0.42 nf=1 ad=0.1218 as=0.1218 pd=1.42 ps=1.42 nrd=0.69047619047619  nrs=0.69047619047619 sa=0 sb=0 sd=0 mult=1 m=1
XM_RD_1_0_s2p10 rbl_s2p10 sn1_s2p10 rwld GND sky130_fd_pr__nfet_01v8 L=0.15 W=0.42 nf=1 ad=0.1218 as=0.1218 pd=1.42 ps=1.42 nrd=0.69047619047619  nrs=0.69047619047619 sa=0 sb=0 sd=0 mult=1 m=1
XM_WR_2_0_s2p10 sn2_s2p10 wl_2 blp10 GND sky130_fd_pr__nfet_01v8 L=0.15 W=0.42 nf=1 ad=0.1218 as=0.1218 pd=1.42 ps=1.42 nrd=0.69047619047619  nrs=0.69047619047619 sa=0 sb=0 sd=0 mult=1 m=1
XM_RD_2_0_s2p10 rbl_s2p10 sn2_s2p10 rwls GND sky130_fd_pr__nfet_01v8 L=0.15 W=0.42 nf=1 ad=0.1218 as=0.1218 pd=1.42 ps=1.42 nrd=0.69047619047619  nrs=0.69047619047619 sa=0 sb=0 sd=0 mult=1 m=1
XM_WR_3_0_s2p10 sn3_s2p10 wl_3 blp10 GND sky130_fd_pr__nfet_01v8 L=0.15 W=0.42 nf=1 ad=0.1218 as=0.1218 pd=1.42 ps=1.42 nrd=0.69047619047619  nrs=0.69047619047619 sa=0 sb=0 sd=0 mult=1 m=1
XM_RD_3_0_s2p10 rbl_s2p10 sn3_s2p10 rwld GND sky130_fd_pr__nfet_01v8 L=0.15 W=0.42 nf=1 ad=0.1218 as=0.1218 pd=1.42 ps=1.42 nrd=0.69047619047619  nrs=0.69047619047619 sa=0 sb=0 sd=0 mult=1 m=1
csn0_s2p10 sn0_s2p10 0 {C_SN}
csn1_s2p10 sn1_s2p10 0 {C_SN}
csn2_s2p10 sn2_s2p10 0 {C_SN}
csn3_s2p10 sn3_s2p10 0 {C_SN}
crbl_s2p10 rbl_s2p10 0 {C_RBL}
spre_s2p10 pre rbl_s2p10 ctl 0 swpre
ehb_s2p10 hb_s2p10 0 rbl_s2p10 0 1
shb_s2p10 hb_s2p10 hold_s2p10 hctl 0 swpre
chold_s2p10 hold_s2p10 0 1e-12
bdl_s2p10 dl_s2p10 0 v=v(rbl_s2p10)-v(hold_s2p10)+0.1-v(late)

* ---- case s2p11: selected row 2, pattern rows3210 1011 ----
XM_WR_0_0_s2p11 sn0_s2p11 wl_0 blp11 GND sky130_fd_pr__nfet_01v8 L=0.15 W=0.42 nf=1 ad=0.1218 as=0.1218 pd=1.42 ps=1.42 nrd=0.69047619047619  nrs=0.69047619047619 sa=0 sb=0 sd=0 mult=1 m=1
XM_RD_0_0_s2p11 rbl_s2p11 sn0_s2p11 rwld GND sky130_fd_pr__nfet_01v8 L=0.15 W=0.42 nf=1 ad=0.1218 as=0.1218 pd=1.42 ps=1.42 nrd=0.69047619047619  nrs=0.69047619047619 sa=0 sb=0 sd=0 mult=1 m=1
XM_WR_1_0_s2p11 sn1_s2p11 wl_1 blp11 GND sky130_fd_pr__nfet_01v8 L=0.15 W=0.42 nf=1 ad=0.1218 as=0.1218 pd=1.42 ps=1.42 nrd=0.69047619047619  nrs=0.69047619047619 sa=0 sb=0 sd=0 mult=1 m=1
XM_RD_1_0_s2p11 rbl_s2p11 sn1_s2p11 rwld GND sky130_fd_pr__nfet_01v8 L=0.15 W=0.42 nf=1 ad=0.1218 as=0.1218 pd=1.42 ps=1.42 nrd=0.69047619047619  nrs=0.69047619047619 sa=0 sb=0 sd=0 mult=1 m=1
XM_WR_2_0_s2p11 sn2_s2p11 wl_2 blp11 GND sky130_fd_pr__nfet_01v8 L=0.15 W=0.42 nf=1 ad=0.1218 as=0.1218 pd=1.42 ps=1.42 nrd=0.69047619047619  nrs=0.69047619047619 sa=0 sb=0 sd=0 mult=1 m=1
XM_RD_2_0_s2p11 rbl_s2p11 sn2_s2p11 rwls GND sky130_fd_pr__nfet_01v8 L=0.15 W=0.42 nf=1 ad=0.1218 as=0.1218 pd=1.42 ps=1.42 nrd=0.69047619047619  nrs=0.69047619047619 sa=0 sb=0 sd=0 mult=1 m=1
XM_WR_3_0_s2p11 sn3_s2p11 wl_3 blp11 GND sky130_fd_pr__nfet_01v8 L=0.15 W=0.42 nf=1 ad=0.1218 as=0.1218 pd=1.42 ps=1.42 nrd=0.69047619047619  nrs=0.69047619047619 sa=0 sb=0 sd=0 mult=1 m=1
XM_RD_3_0_s2p11 rbl_s2p11 sn3_s2p11 rwld GND sky130_fd_pr__nfet_01v8 L=0.15 W=0.42 nf=1 ad=0.1218 as=0.1218 pd=1.42 ps=1.42 nrd=0.69047619047619  nrs=0.69047619047619 sa=0 sb=0 sd=0 mult=1 m=1
csn0_s2p11 sn0_s2p11 0 {C_SN}
csn1_s2p11 sn1_s2p11 0 {C_SN}
csn2_s2p11 sn2_s2p11 0 {C_SN}
csn3_s2p11 sn3_s2p11 0 {C_SN}
crbl_s2p11 rbl_s2p11 0 {C_RBL}
spre_s2p11 pre rbl_s2p11 ctl 0 swpre
ehb_s2p11 hb_s2p11 0 rbl_s2p11 0 1
shb_s2p11 hb_s2p11 hold_s2p11 hctl 0 swpre
chold_s2p11 hold_s2p11 0 1e-12
bdl_s2p11 dl_s2p11 0 v=v(rbl_s2p11)-v(hold_s2p11)+0.1-v(late)

* ---- case s2p12: selected row 2, pattern rows3210 1100 ----
XM_WR_0_0_s2p12 sn0_s2p12 wl_0 blp12 GND sky130_fd_pr__nfet_01v8 L=0.15 W=0.42 nf=1 ad=0.1218 as=0.1218 pd=1.42 ps=1.42 nrd=0.69047619047619  nrs=0.69047619047619 sa=0 sb=0 sd=0 mult=1 m=1
XM_RD_0_0_s2p12 rbl_s2p12 sn0_s2p12 rwld GND sky130_fd_pr__nfet_01v8 L=0.15 W=0.42 nf=1 ad=0.1218 as=0.1218 pd=1.42 ps=1.42 nrd=0.69047619047619  nrs=0.69047619047619 sa=0 sb=0 sd=0 mult=1 m=1
XM_WR_1_0_s2p12 sn1_s2p12 wl_1 blp12 GND sky130_fd_pr__nfet_01v8 L=0.15 W=0.42 nf=1 ad=0.1218 as=0.1218 pd=1.42 ps=1.42 nrd=0.69047619047619  nrs=0.69047619047619 sa=0 sb=0 sd=0 mult=1 m=1
XM_RD_1_0_s2p12 rbl_s2p12 sn1_s2p12 rwld GND sky130_fd_pr__nfet_01v8 L=0.15 W=0.42 nf=1 ad=0.1218 as=0.1218 pd=1.42 ps=1.42 nrd=0.69047619047619  nrs=0.69047619047619 sa=0 sb=0 sd=0 mult=1 m=1
XM_WR_2_0_s2p12 sn2_s2p12 wl_2 blp12 GND sky130_fd_pr__nfet_01v8 L=0.15 W=0.42 nf=1 ad=0.1218 as=0.1218 pd=1.42 ps=1.42 nrd=0.69047619047619  nrs=0.69047619047619 sa=0 sb=0 sd=0 mult=1 m=1
XM_RD_2_0_s2p12 rbl_s2p12 sn2_s2p12 rwls GND sky130_fd_pr__nfet_01v8 L=0.15 W=0.42 nf=1 ad=0.1218 as=0.1218 pd=1.42 ps=1.42 nrd=0.69047619047619  nrs=0.69047619047619 sa=0 sb=0 sd=0 mult=1 m=1
XM_WR_3_0_s2p12 sn3_s2p12 wl_3 blp12 GND sky130_fd_pr__nfet_01v8 L=0.15 W=0.42 nf=1 ad=0.1218 as=0.1218 pd=1.42 ps=1.42 nrd=0.69047619047619  nrs=0.69047619047619 sa=0 sb=0 sd=0 mult=1 m=1
XM_RD_3_0_s2p12 rbl_s2p12 sn3_s2p12 rwld GND sky130_fd_pr__nfet_01v8 L=0.15 W=0.42 nf=1 ad=0.1218 as=0.1218 pd=1.42 ps=1.42 nrd=0.69047619047619  nrs=0.69047619047619 sa=0 sb=0 sd=0 mult=1 m=1
csn0_s2p12 sn0_s2p12 0 {C_SN}
csn1_s2p12 sn1_s2p12 0 {C_SN}
csn2_s2p12 sn2_s2p12 0 {C_SN}
csn3_s2p12 sn3_s2p12 0 {C_SN}
crbl_s2p12 rbl_s2p12 0 {C_RBL}
spre_s2p12 pre rbl_s2p12 ctl 0 swpre
ehb_s2p12 hb_s2p12 0 rbl_s2p12 0 1
shb_s2p12 hb_s2p12 hold_s2p12 hctl 0 swpre
chold_s2p12 hold_s2p12 0 1e-12
bdl_s2p12 dl_s2p12 0 v=v(rbl_s2p12)-v(hold_s2p12)+0.1-v(late)

* ---- case s2p13: selected row 2, pattern rows3210 1101 ----
XM_WR_0_0_s2p13 sn0_s2p13 wl_0 blp13 GND sky130_fd_pr__nfet_01v8 L=0.15 W=0.42 nf=1 ad=0.1218 as=0.1218 pd=1.42 ps=1.42 nrd=0.69047619047619  nrs=0.69047619047619 sa=0 sb=0 sd=0 mult=1 m=1
XM_RD_0_0_s2p13 rbl_s2p13 sn0_s2p13 rwld GND sky130_fd_pr__nfet_01v8 L=0.15 W=0.42 nf=1 ad=0.1218 as=0.1218 pd=1.42 ps=1.42 nrd=0.69047619047619  nrs=0.69047619047619 sa=0 sb=0 sd=0 mult=1 m=1
XM_WR_1_0_s2p13 sn1_s2p13 wl_1 blp13 GND sky130_fd_pr__nfet_01v8 L=0.15 W=0.42 nf=1 ad=0.1218 as=0.1218 pd=1.42 ps=1.42 nrd=0.69047619047619  nrs=0.69047619047619 sa=0 sb=0 sd=0 mult=1 m=1
XM_RD_1_0_s2p13 rbl_s2p13 sn1_s2p13 rwld GND sky130_fd_pr__nfet_01v8 L=0.15 W=0.42 nf=1 ad=0.1218 as=0.1218 pd=1.42 ps=1.42 nrd=0.69047619047619  nrs=0.69047619047619 sa=0 sb=0 sd=0 mult=1 m=1
XM_WR_2_0_s2p13 sn2_s2p13 wl_2 blp13 GND sky130_fd_pr__nfet_01v8 L=0.15 W=0.42 nf=1 ad=0.1218 as=0.1218 pd=1.42 ps=1.42 nrd=0.69047619047619  nrs=0.69047619047619 sa=0 sb=0 sd=0 mult=1 m=1
XM_RD_2_0_s2p13 rbl_s2p13 sn2_s2p13 rwls GND sky130_fd_pr__nfet_01v8 L=0.15 W=0.42 nf=1 ad=0.1218 as=0.1218 pd=1.42 ps=1.42 nrd=0.69047619047619  nrs=0.69047619047619 sa=0 sb=0 sd=0 mult=1 m=1
XM_WR_3_0_s2p13 sn3_s2p13 wl_3 blp13 GND sky130_fd_pr__nfet_01v8 L=0.15 W=0.42 nf=1 ad=0.1218 as=0.1218 pd=1.42 ps=1.42 nrd=0.69047619047619  nrs=0.69047619047619 sa=0 sb=0 sd=0 mult=1 m=1
XM_RD_3_0_s2p13 rbl_s2p13 sn3_s2p13 rwld GND sky130_fd_pr__nfet_01v8 L=0.15 W=0.42 nf=1 ad=0.1218 as=0.1218 pd=1.42 ps=1.42 nrd=0.69047619047619  nrs=0.69047619047619 sa=0 sb=0 sd=0 mult=1 m=1
csn0_s2p13 sn0_s2p13 0 {C_SN}
csn1_s2p13 sn1_s2p13 0 {C_SN}
csn2_s2p13 sn2_s2p13 0 {C_SN}
csn3_s2p13 sn3_s2p13 0 {C_SN}
crbl_s2p13 rbl_s2p13 0 {C_RBL}
spre_s2p13 pre rbl_s2p13 ctl 0 swpre
ehb_s2p13 hb_s2p13 0 rbl_s2p13 0 1
shb_s2p13 hb_s2p13 hold_s2p13 hctl 0 swpre
chold_s2p13 hold_s2p13 0 1e-12
bdl_s2p13 dl_s2p13 0 v=v(rbl_s2p13)-v(hold_s2p13)+0.1-v(late)

* ---- case s2p14: selected row 2, pattern rows3210 1110 ----
XM_WR_0_0_s2p14 sn0_s2p14 wl_0 blp14 GND sky130_fd_pr__nfet_01v8 L=0.15 W=0.42 nf=1 ad=0.1218 as=0.1218 pd=1.42 ps=1.42 nrd=0.69047619047619  nrs=0.69047619047619 sa=0 sb=0 sd=0 mult=1 m=1
XM_RD_0_0_s2p14 rbl_s2p14 sn0_s2p14 rwld GND sky130_fd_pr__nfet_01v8 L=0.15 W=0.42 nf=1 ad=0.1218 as=0.1218 pd=1.42 ps=1.42 nrd=0.69047619047619  nrs=0.69047619047619 sa=0 sb=0 sd=0 mult=1 m=1
XM_WR_1_0_s2p14 sn1_s2p14 wl_1 blp14 GND sky130_fd_pr__nfet_01v8 L=0.15 W=0.42 nf=1 ad=0.1218 as=0.1218 pd=1.42 ps=1.42 nrd=0.69047619047619  nrs=0.69047619047619 sa=0 sb=0 sd=0 mult=1 m=1
XM_RD_1_0_s2p14 rbl_s2p14 sn1_s2p14 rwld GND sky130_fd_pr__nfet_01v8 L=0.15 W=0.42 nf=1 ad=0.1218 as=0.1218 pd=1.42 ps=1.42 nrd=0.69047619047619  nrs=0.69047619047619 sa=0 sb=0 sd=0 mult=1 m=1
XM_WR_2_0_s2p14 sn2_s2p14 wl_2 blp14 GND sky130_fd_pr__nfet_01v8 L=0.15 W=0.42 nf=1 ad=0.1218 as=0.1218 pd=1.42 ps=1.42 nrd=0.69047619047619  nrs=0.69047619047619 sa=0 sb=0 sd=0 mult=1 m=1
XM_RD_2_0_s2p14 rbl_s2p14 sn2_s2p14 rwls GND sky130_fd_pr__nfet_01v8 L=0.15 W=0.42 nf=1 ad=0.1218 as=0.1218 pd=1.42 ps=1.42 nrd=0.69047619047619  nrs=0.69047619047619 sa=0 sb=0 sd=0 mult=1 m=1
XM_WR_3_0_s2p14 sn3_s2p14 wl_3 blp14 GND sky130_fd_pr__nfet_01v8 L=0.15 W=0.42 nf=1 ad=0.1218 as=0.1218 pd=1.42 ps=1.42 nrd=0.69047619047619  nrs=0.69047619047619 sa=0 sb=0 sd=0 mult=1 m=1
XM_RD_3_0_s2p14 rbl_s2p14 sn3_s2p14 rwld GND sky130_fd_pr__nfet_01v8 L=0.15 W=0.42 nf=1 ad=0.1218 as=0.1218 pd=1.42 ps=1.42 nrd=0.69047619047619  nrs=0.69047619047619 sa=0 sb=0 sd=0 mult=1 m=1
csn0_s2p14 sn0_s2p14 0 {C_SN}
csn1_s2p14 sn1_s2p14 0 {C_SN}
csn2_s2p14 sn2_s2p14 0 {C_SN}
csn3_s2p14 sn3_s2p14 0 {C_SN}
crbl_s2p14 rbl_s2p14 0 {C_RBL}
spre_s2p14 pre rbl_s2p14 ctl 0 swpre
ehb_s2p14 hb_s2p14 0 rbl_s2p14 0 1
shb_s2p14 hb_s2p14 hold_s2p14 hctl 0 swpre
chold_s2p14 hold_s2p14 0 1e-12
bdl_s2p14 dl_s2p14 0 v=v(rbl_s2p14)-v(hold_s2p14)+0.1-v(late)

* ---- case s2p15: selected row 2, pattern rows3210 1111 ----
XM_WR_0_0_s2p15 sn0_s2p15 wl_0 blp15 GND sky130_fd_pr__nfet_01v8 L=0.15 W=0.42 nf=1 ad=0.1218 as=0.1218 pd=1.42 ps=1.42 nrd=0.69047619047619  nrs=0.69047619047619 sa=0 sb=0 sd=0 mult=1 m=1
XM_RD_0_0_s2p15 rbl_s2p15 sn0_s2p15 rwld GND sky130_fd_pr__nfet_01v8 L=0.15 W=0.42 nf=1 ad=0.1218 as=0.1218 pd=1.42 ps=1.42 nrd=0.69047619047619  nrs=0.69047619047619 sa=0 sb=0 sd=0 mult=1 m=1
XM_WR_1_0_s2p15 sn1_s2p15 wl_1 blp15 GND sky130_fd_pr__nfet_01v8 L=0.15 W=0.42 nf=1 ad=0.1218 as=0.1218 pd=1.42 ps=1.42 nrd=0.69047619047619  nrs=0.69047619047619 sa=0 sb=0 sd=0 mult=1 m=1
XM_RD_1_0_s2p15 rbl_s2p15 sn1_s2p15 rwld GND sky130_fd_pr__nfet_01v8 L=0.15 W=0.42 nf=1 ad=0.1218 as=0.1218 pd=1.42 ps=1.42 nrd=0.69047619047619  nrs=0.69047619047619 sa=0 sb=0 sd=0 mult=1 m=1
XM_WR_2_0_s2p15 sn2_s2p15 wl_2 blp15 GND sky130_fd_pr__nfet_01v8 L=0.15 W=0.42 nf=1 ad=0.1218 as=0.1218 pd=1.42 ps=1.42 nrd=0.69047619047619  nrs=0.69047619047619 sa=0 sb=0 sd=0 mult=1 m=1
XM_RD_2_0_s2p15 rbl_s2p15 sn2_s2p15 rwls GND sky130_fd_pr__nfet_01v8 L=0.15 W=0.42 nf=1 ad=0.1218 as=0.1218 pd=1.42 ps=1.42 nrd=0.69047619047619  nrs=0.69047619047619 sa=0 sb=0 sd=0 mult=1 m=1
XM_WR_3_0_s2p15 sn3_s2p15 wl_3 blp15 GND sky130_fd_pr__nfet_01v8 L=0.15 W=0.42 nf=1 ad=0.1218 as=0.1218 pd=1.42 ps=1.42 nrd=0.69047619047619  nrs=0.69047619047619 sa=0 sb=0 sd=0 mult=1 m=1
XM_RD_3_0_s2p15 rbl_s2p15 sn3_s2p15 rwld GND sky130_fd_pr__nfet_01v8 L=0.15 W=0.42 nf=1 ad=0.1218 as=0.1218 pd=1.42 ps=1.42 nrd=0.69047619047619  nrs=0.69047619047619 sa=0 sb=0 sd=0 mult=1 m=1
csn0_s2p15 sn0_s2p15 0 {C_SN}
csn1_s2p15 sn1_s2p15 0 {C_SN}
csn2_s2p15 sn2_s2p15 0 {C_SN}
csn3_s2p15 sn3_s2p15 0 {C_SN}
crbl_s2p15 rbl_s2p15 0 {C_RBL}
spre_s2p15 pre rbl_s2p15 ctl 0 swpre
ehb_s2p15 hb_s2p15 0 rbl_s2p15 0 1
shb_s2p15 hb_s2p15 hold_s2p15 hctl 0 swpre
chold_s2p15 hold_s2p15 0 1e-12
bdl_s2p15 dl_s2p15 0 v=v(rbl_s2p15)-v(hold_s2p15)+0.1-v(late)

* ---- case s3p00: selected row 3, pattern rows3210 0000 ----
XM_WR_0_0_s3p00 sn0_s3p00 wl_0 blp00 GND sky130_fd_pr__nfet_01v8 L=0.15 W=0.42 nf=1 ad=0.1218 as=0.1218 pd=1.42 ps=1.42 nrd=0.69047619047619  nrs=0.69047619047619 sa=0 sb=0 sd=0 mult=1 m=1
XM_RD_0_0_s3p00 rbl_s3p00 sn0_s3p00 rwld GND sky130_fd_pr__nfet_01v8 L=0.15 W=0.42 nf=1 ad=0.1218 as=0.1218 pd=1.42 ps=1.42 nrd=0.69047619047619  nrs=0.69047619047619 sa=0 sb=0 sd=0 mult=1 m=1
XM_WR_1_0_s3p00 sn1_s3p00 wl_1 blp00 GND sky130_fd_pr__nfet_01v8 L=0.15 W=0.42 nf=1 ad=0.1218 as=0.1218 pd=1.42 ps=1.42 nrd=0.69047619047619  nrs=0.69047619047619 sa=0 sb=0 sd=0 mult=1 m=1
XM_RD_1_0_s3p00 rbl_s3p00 sn1_s3p00 rwld GND sky130_fd_pr__nfet_01v8 L=0.15 W=0.42 nf=1 ad=0.1218 as=0.1218 pd=1.42 ps=1.42 nrd=0.69047619047619  nrs=0.69047619047619 sa=0 sb=0 sd=0 mult=1 m=1
XM_WR_2_0_s3p00 sn2_s3p00 wl_2 blp00 GND sky130_fd_pr__nfet_01v8 L=0.15 W=0.42 nf=1 ad=0.1218 as=0.1218 pd=1.42 ps=1.42 nrd=0.69047619047619  nrs=0.69047619047619 sa=0 sb=0 sd=0 mult=1 m=1
XM_RD_2_0_s3p00 rbl_s3p00 sn2_s3p00 rwld GND sky130_fd_pr__nfet_01v8 L=0.15 W=0.42 nf=1 ad=0.1218 as=0.1218 pd=1.42 ps=1.42 nrd=0.69047619047619  nrs=0.69047619047619 sa=0 sb=0 sd=0 mult=1 m=1
XM_WR_3_0_s3p00 sn3_s3p00 wl_3 blp00 GND sky130_fd_pr__nfet_01v8 L=0.15 W=0.42 nf=1 ad=0.1218 as=0.1218 pd=1.42 ps=1.42 nrd=0.69047619047619  nrs=0.69047619047619 sa=0 sb=0 sd=0 mult=1 m=1
XM_RD_3_0_s3p00 rbl_s3p00 sn3_s3p00 rwls GND sky130_fd_pr__nfet_01v8 L=0.15 W=0.42 nf=1 ad=0.1218 as=0.1218 pd=1.42 ps=1.42 nrd=0.69047619047619  nrs=0.69047619047619 sa=0 sb=0 sd=0 mult=1 m=1
csn0_s3p00 sn0_s3p00 0 {C_SN}
csn1_s3p00 sn1_s3p00 0 {C_SN}
csn2_s3p00 sn2_s3p00 0 {C_SN}
csn3_s3p00 sn3_s3p00 0 {C_SN}
crbl_s3p00 rbl_s3p00 0 {C_RBL}
spre_s3p00 pre rbl_s3p00 ctl 0 swpre
ehb_s3p00 hb_s3p00 0 rbl_s3p00 0 1
shb_s3p00 hb_s3p00 hold_s3p00 hctl 0 swpre
chold_s3p00 hold_s3p00 0 1e-12
bdl_s3p00 dl_s3p00 0 v=v(rbl_s3p00)-v(hold_s3p00)+0.1-v(late)

* ---- case s3p01: selected row 3, pattern rows3210 0001 ----
XM_WR_0_0_s3p01 sn0_s3p01 wl_0 blp01 GND sky130_fd_pr__nfet_01v8 L=0.15 W=0.42 nf=1 ad=0.1218 as=0.1218 pd=1.42 ps=1.42 nrd=0.69047619047619  nrs=0.69047619047619 sa=0 sb=0 sd=0 mult=1 m=1
XM_RD_0_0_s3p01 rbl_s3p01 sn0_s3p01 rwld GND sky130_fd_pr__nfet_01v8 L=0.15 W=0.42 nf=1 ad=0.1218 as=0.1218 pd=1.42 ps=1.42 nrd=0.69047619047619  nrs=0.69047619047619 sa=0 sb=0 sd=0 mult=1 m=1
XM_WR_1_0_s3p01 sn1_s3p01 wl_1 blp01 GND sky130_fd_pr__nfet_01v8 L=0.15 W=0.42 nf=1 ad=0.1218 as=0.1218 pd=1.42 ps=1.42 nrd=0.69047619047619  nrs=0.69047619047619 sa=0 sb=0 sd=0 mult=1 m=1
XM_RD_1_0_s3p01 rbl_s3p01 sn1_s3p01 rwld GND sky130_fd_pr__nfet_01v8 L=0.15 W=0.42 nf=1 ad=0.1218 as=0.1218 pd=1.42 ps=1.42 nrd=0.69047619047619  nrs=0.69047619047619 sa=0 sb=0 sd=0 mult=1 m=1
XM_WR_2_0_s3p01 sn2_s3p01 wl_2 blp01 GND sky130_fd_pr__nfet_01v8 L=0.15 W=0.42 nf=1 ad=0.1218 as=0.1218 pd=1.42 ps=1.42 nrd=0.69047619047619  nrs=0.69047619047619 sa=0 sb=0 sd=0 mult=1 m=1
XM_RD_2_0_s3p01 rbl_s3p01 sn2_s3p01 rwld GND sky130_fd_pr__nfet_01v8 L=0.15 W=0.42 nf=1 ad=0.1218 as=0.1218 pd=1.42 ps=1.42 nrd=0.69047619047619  nrs=0.69047619047619 sa=0 sb=0 sd=0 mult=1 m=1
XM_WR_3_0_s3p01 sn3_s3p01 wl_3 blp01 GND sky130_fd_pr__nfet_01v8 L=0.15 W=0.42 nf=1 ad=0.1218 as=0.1218 pd=1.42 ps=1.42 nrd=0.69047619047619  nrs=0.69047619047619 sa=0 sb=0 sd=0 mult=1 m=1
XM_RD_3_0_s3p01 rbl_s3p01 sn3_s3p01 rwls GND sky130_fd_pr__nfet_01v8 L=0.15 W=0.42 nf=1 ad=0.1218 as=0.1218 pd=1.42 ps=1.42 nrd=0.69047619047619  nrs=0.69047619047619 sa=0 sb=0 sd=0 mult=1 m=1
csn0_s3p01 sn0_s3p01 0 {C_SN}
csn1_s3p01 sn1_s3p01 0 {C_SN}
csn2_s3p01 sn2_s3p01 0 {C_SN}
csn3_s3p01 sn3_s3p01 0 {C_SN}
crbl_s3p01 rbl_s3p01 0 {C_RBL}
spre_s3p01 pre rbl_s3p01 ctl 0 swpre
ehb_s3p01 hb_s3p01 0 rbl_s3p01 0 1
shb_s3p01 hb_s3p01 hold_s3p01 hctl 0 swpre
chold_s3p01 hold_s3p01 0 1e-12
bdl_s3p01 dl_s3p01 0 v=v(rbl_s3p01)-v(hold_s3p01)+0.1-v(late)

* ---- case s3p02: selected row 3, pattern rows3210 0010 ----
XM_WR_0_0_s3p02 sn0_s3p02 wl_0 blp02 GND sky130_fd_pr__nfet_01v8 L=0.15 W=0.42 nf=1 ad=0.1218 as=0.1218 pd=1.42 ps=1.42 nrd=0.69047619047619  nrs=0.69047619047619 sa=0 sb=0 sd=0 mult=1 m=1
XM_RD_0_0_s3p02 rbl_s3p02 sn0_s3p02 rwld GND sky130_fd_pr__nfet_01v8 L=0.15 W=0.42 nf=1 ad=0.1218 as=0.1218 pd=1.42 ps=1.42 nrd=0.69047619047619  nrs=0.69047619047619 sa=0 sb=0 sd=0 mult=1 m=1
XM_WR_1_0_s3p02 sn1_s3p02 wl_1 blp02 GND sky130_fd_pr__nfet_01v8 L=0.15 W=0.42 nf=1 ad=0.1218 as=0.1218 pd=1.42 ps=1.42 nrd=0.69047619047619  nrs=0.69047619047619 sa=0 sb=0 sd=0 mult=1 m=1
XM_RD_1_0_s3p02 rbl_s3p02 sn1_s3p02 rwld GND sky130_fd_pr__nfet_01v8 L=0.15 W=0.42 nf=1 ad=0.1218 as=0.1218 pd=1.42 ps=1.42 nrd=0.69047619047619  nrs=0.69047619047619 sa=0 sb=0 sd=0 mult=1 m=1
XM_WR_2_0_s3p02 sn2_s3p02 wl_2 blp02 GND sky130_fd_pr__nfet_01v8 L=0.15 W=0.42 nf=1 ad=0.1218 as=0.1218 pd=1.42 ps=1.42 nrd=0.69047619047619  nrs=0.69047619047619 sa=0 sb=0 sd=0 mult=1 m=1
XM_RD_2_0_s3p02 rbl_s3p02 sn2_s3p02 rwld GND sky130_fd_pr__nfet_01v8 L=0.15 W=0.42 nf=1 ad=0.1218 as=0.1218 pd=1.42 ps=1.42 nrd=0.69047619047619  nrs=0.69047619047619 sa=0 sb=0 sd=0 mult=1 m=1
XM_WR_3_0_s3p02 sn3_s3p02 wl_3 blp02 GND sky130_fd_pr__nfet_01v8 L=0.15 W=0.42 nf=1 ad=0.1218 as=0.1218 pd=1.42 ps=1.42 nrd=0.69047619047619  nrs=0.69047619047619 sa=0 sb=0 sd=0 mult=1 m=1
XM_RD_3_0_s3p02 rbl_s3p02 sn3_s3p02 rwls GND sky130_fd_pr__nfet_01v8 L=0.15 W=0.42 nf=1 ad=0.1218 as=0.1218 pd=1.42 ps=1.42 nrd=0.69047619047619  nrs=0.69047619047619 sa=0 sb=0 sd=0 mult=1 m=1
csn0_s3p02 sn0_s3p02 0 {C_SN}
csn1_s3p02 sn1_s3p02 0 {C_SN}
csn2_s3p02 sn2_s3p02 0 {C_SN}
csn3_s3p02 sn3_s3p02 0 {C_SN}
crbl_s3p02 rbl_s3p02 0 {C_RBL}
spre_s3p02 pre rbl_s3p02 ctl 0 swpre
ehb_s3p02 hb_s3p02 0 rbl_s3p02 0 1
shb_s3p02 hb_s3p02 hold_s3p02 hctl 0 swpre
chold_s3p02 hold_s3p02 0 1e-12
bdl_s3p02 dl_s3p02 0 v=v(rbl_s3p02)-v(hold_s3p02)+0.1-v(late)

* ---- case s3p03: selected row 3, pattern rows3210 0011 ----
XM_WR_0_0_s3p03 sn0_s3p03 wl_0 blp03 GND sky130_fd_pr__nfet_01v8 L=0.15 W=0.42 nf=1 ad=0.1218 as=0.1218 pd=1.42 ps=1.42 nrd=0.69047619047619  nrs=0.69047619047619 sa=0 sb=0 sd=0 mult=1 m=1
XM_RD_0_0_s3p03 rbl_s3p03 sn0_s3p03 rwld GND sky130_fd_pr__nfet_01v8 L=0.15 W=0.42 nf=1 ad=0.1218 as=0.1218 pd=1.42 ps=1.42 nrd=0.69047619047619  nrs=0.69047619047619 sa=0 sb=0 sd=0 mult=1 m=1
XM_WR_1_0_s3p03 sn1_s3p03 wl_1 blp03 GND sky130_fd_pr__nfet_01v8 L=0.15 W=0.42 nf=1 ad=0.1218 as=0.1218 pd=1.42 ps=1.42 nrd=0.69047619047619  nrs=0.69047619047619 sa=0 sb=0 sd=0 mult=1 m=1
XM_RD_1_0_s3p03 rbl_s3p03 sn1_s3p03 rwld GND sky130_fd_pr__nfet_01v8 L=0.15 W=0.42 nf=1 ad=0.1218 as=0.1218 pd=1.42 ps=1.42 nrd=0.69047619047619  nrs=0.69047619047619 sa=0 sb=0 sd=0 mult=1 m=1
XM_WR_2_0_s3p03 sn2_s3p03 wl_2 blp03 GND sky130_fd_pr__nfet_01v8 L=0.15 W=0.42 nf=1 ad=0.1218 as=0.1218 pd=1.42 ps=1.42 nrd=0.69047619047619  nrs=0.69047619047619 sa=0 sb=0 sd=0 mult=1 m=1
XM_RD_2_0_s3p03 rbl_s3p03 sn2_s3p03 rwld GND sky130_fd_pr__nfet_01v8 L=0.15 W=0.42 nf=1 ad=0.1218 as=0.1218 pd=1.42 ps=1.42 nrd=0.69047619047619  nrs=0.69047619047619 sa=0 sb=0 sd=0 mult=1 m=1
XM_WR_3_0_s3p03 sn3_s3p03 wl_3 blp03 GND sky130_fd_pr__nfet_01v8 L=0.15 W=0.42 nf=1 ad=0.1218 as=0.1218 pd=1.42 ps=1.42 nrd=0.69047619047619  nrs=0.69047619047619 sa=0 sb=0 sd=0 mult=1 m=1
XM_RD_3_0_s3p03 rbl_s3p03 sn3_s3p03 rwls GND sky130_fd_pr__nfet_01v8 L=0.15 W=0.42 nf=1 ad=0.1218 as=0.1218 pd=1.42 ps=1.42 nrd=0.69047619047619  nrs=0.69047619047619 sa=0 sb=0 sd=0 mult=1 m=1
csn0_s3p03 sn0_s3p03 0 {C_SN}
csn1_s3p03 sn1_s3p03 0 {C_SN}
csn2_s3p03 sn2_s3p03 0 {C_SN}
csn3_s3p03 sn3_s3p03 0 {C_SN}
crbl_s3p03 rbl_s3p03 0 {C_RBL}
spre_s3p03 pre rbl_s3p03 ctl 0 swpre
ehb_s3p03 hb_s3p03 0 rbl_s3p03 0 1
shb_s3p03 hb_s3p03 hold_s3p03 hctl 0 swpre
chold_s3p03 hold_s3p03 0 1e-12
bdl_s3p03 dl_s3p03 0 v=v(rbl_s3p03)-v(hold_s3p03)+0.1-v(late)

* ---- case s3p04: selected row 3, pattern rows3210 0100 ----
XM_WR_0_0_s3p04 sn0_s3p04 wl_0 blp04 GND sky130_fd_pr__nfet_01v8 L=0.15 W=0.42 nf=1 ad=0.1218 as=0.1218 pd=1.42 ps=1.42 nrd=0.69047619047619  nrs=0.69047619047619 sa=0 sb=0 sd=0 mult=1 m=1
XM_RD_0_0_s3p04 rbl_s3p04 sn0_s3p04 rwld GND sky130_fd_pr__nfet_01v8 L=0.15 W=0.42 nf=1 ad=0.1218 as=0.1218 pd=1.42 ps=1.42 nrd=0.69047619047619  nrs=0.69047619047619 sa=0 sb=0 sd=0 mult=1 m=1
XM_WR_1_0_s3p04 sn1_s3p04 wl_1 blp04 GND sky130_fd_pr__nfet_01v8 L=0.15 W=0.42 nf=1 ad=0.1218 as=0.1218 pd=1.42 ps=1.42 nrd=0.69047619047619  nrs=0.69047619047619 sa=0 sb=0 sd=0 mult=1 m=1
XM_RD_1_0_s3p04 rbl_s3p04 sn1_s3p04 rwld GND sky130_fd_pr__nfet_01v8 L=0.15 W=0.42 nf=1 ad=0.1218 as=0.1218 pd=1.42 ps=1.42 nrd=0.69047619047619  nrs=0.69047619047619 sa=0 sb=0 sd=0 mult=1 m=1
XM_WR_2_0_s3p04 sn2_s3p04 wl_2 blp04 GND sky130_fd_pr__nfet_01v8 L=0.15 W=0.42 nf=1 ad=0.1218 as=0.1218 pd=1.42 ps=1.42 nrd=0.69047619047619  nrs=0.69047619047619 sa=0 sb=0 sd=0 mult=1 m=1
XM_RD_2_0_s3p04 rbl_s3p04 sn2_s3p04 rwld GND sky130_fd_pr__nfet_01v8 L=0.15 W=0.42 nf=1 ad=0.1218 as=0.1218 pd=1.42 ps=1.42 nrd=0.69047619047619  nrs=0.69047619047619 sa=0 sb=0 sd=0 mult=1 m=1
XM_WR_3_0_s3p04 sn3_s3p04 wl_3 blp04 GND sky130_fd_pr__nfet_01v8 L=0.15 W=0.42 nf=1 ad=0.1218 as=0.1218 pd=1.42 ps=1.42 nrd=0.69047619047619  nrs=0.69047619047619 sa=0 sb=0 sd=0 mult=1 m=1
XM_RD_3_0_s3p04 rbl_s3p04 sn3_s3p04 rwls GND sky130_fd_pr__nfet_01v8 L=0.15 W=0.42 nf=1 ad=0.1218 as=0.1218 pd=1.42 ps=1.42 nrd=0.69047619047619  nrs=0.69047619047619 sa=0 sb=0 sd=0 mult=1 m=1
csn0_s3p04 sn0_s3p04 0 {C_SN}
csn1_s3p04 sn1_s3p04 0 {C_SN}
csn2_s3p04 sn2_s3p04 0 {C_SN}
csn3_s3p04 sn3_s3p04 0 {C_SN}
crbl_s3p04 rbl_s3p04 0 {C_RBL}
spre_s3p04 pre rbl_s3p04 ctl 0 swpre
ehb_s3p04 hb_s3p04 0 rbl_s3p04 0 1
shb_s3p04 hb_s3p04 hold_s3p04 hctl 0 swpre
chold_s3p04 hold_s3p04 0 1e-12
bdl_s3p04 dl_s3p04 0 v=v(rbl_s3p04)-v(hold_s3p04)+0.1-v(late)

* ---- case s3p05: selected row 3, pattern rows3210 0101 ----
XM_WR_0_0_s3p05 sn0_s3p05 wl_0 blp05 GND sky130_fd_pr__nfet_01v8 L=0.15 W=0.42 nf=1 ad=0.1218 as=0.1218 pd=1.42 ps=1.42 nrd=0.69047619047619  nrs=0.69047619047619 sa=0 sb=0 sd=0 mult=1 m=1
XM_RD_0_0_s3p05 rbl_s3p05 sn0_s3p05 rwld GND sky130_fd_pr__nfet_01v8 L=0.15 W=0.42 nf=1 ad=0.1218 as=0.1218 pd=1.42 ps=1.42 nrd=0.69047619047619  nrs=0.69047619047619 sa=0 sb=0 sd=0 mult=1 m=1
XM_WR_1_0_s3p05 sn1_s3p05 wl_1 blp05 GND sky130_fd_pr__nfet_01v8 L=0.15 W=0.42 nf=1 ad=0.1218 as=0.1218 pd=1.42 ps=1.42 nrd=0.69047619047619  nrs=0.69047619047619 sa=0 sb=0 sd=0 mult=1 m=1
XM_RD_1_0_s3p05 rbl_s3p05 sn1_s3p05 rwld GND sky130_fd_pr__nfet_01v8 L=0.15 W=0.42 nf=1 ad=0.1218 as=0.1218 pd=1.42 ps=1.42 nrd=0.69047619047619  nrs=0.69047619047619 sa=0 sb=0 sd=0 mult=1 m=1
XM_WR_2_0_s3p05 sn2_s3p05 wl_2 blp05 GND sky130_fd_pr__nfet_01v8 L=0.15 W=0.42 nf=1 ad=0.1218 as=0.1218 pd=1.42 ps=1.42 nrd=0.69047619047619  nrs=0.69047619047619 sa=0 sb=0 sd=0 mult=1 m=1
XM_RD_2_0_s3p05 rbl_s3p05 sn2_s3p05 rwld GND sky130_fd_pr__nfet_01v8 L=0.15 W=0.42 nf=1 ad=0.1218 as=0.1218 pd=1.42 ps=1.42 nrd=0.69047619047619  nrs=0.69047619047619 sa=0 sb=0 sd=0 mult=1 m=1
XM_WR_3_0_s3p05 sn3_s3p05 wl_3 blp05 GND sky130_fd_pr__nfet_01v8 L=0.15 W=0.42 nf=1 ad=0.1218 as=0.1218 pd=1.42 ps=1.42 nrd=0.69047619047619  nrs=0.69047619047619 sa=0 sb=0 sd=0 mult=1 m=1
XM_RD_3_0_s3p05 rbl_s3p05 sn3_s3p05 rwls GND sky130_fd_pr__nfet_01v8 L=0.15 W=0.42 nf=1 ad=0.1218 as=0.1218 pd=1.42 ps=1.42 nrd=0.69047619047619  nrs=0.69047619047619 sa=0 sb=0 sd=0 mult=1 m=1
csn0_s3p05 sn0_s3p05 0 {C_SN}
csn1_s3p05 sn1_s3p05 0 {C_SN}
csn2_s3p05 sn2_s3p05 0 {C_SN}
csn3_s3p05 sn3_s3p05 0 {C_SN}
crbl_s3p05 rbl_s3p05 0 {C_RBL}
spre_s3p05 pre rbl_s3p05 ctl 0 swpre
ehb_s3p05 hb_s3p05 0 rbl_s3p05 0 1
shb_s3p05 hb_s3p05 hold_s3p05 hctl 0 swpre
chold_s3p05 hold_s3p05 0 1e-12
bdl_s3p05 dl_s3p05 0 v=v(rbl_s3p05)-v(hold_s3p05)+0.1-v(late)

* ---- case s3p06: selected row 3, pattern rows3210 0110 ----
XM_WR_0_0_s3p06 sn0_s3p06 wl_0 blp06 GND sky130_fd_pr__nfet_01v8 L=0.15 W=0.42 nf=1 ad=0.1218 as=0.1218 pd=1.42 ps=1.42 nrd=0.69047619047619  nrs=0.69047619047619 sa=0 sb=0 sd=0 mult=1 m=1
XM_RD_0_0_s3p06 rbl_s3p06 sn0_s3p06 rwld GND sky130_fd_pr__nfet_01v8 L=0.15 W=0.42 nf=1 ad=0.1218 as=0.1218 pd=1.42 ps=1.42 nrd=0.69047619047619  nrs=0.69047619047619 sa=0 sb=0 sd=0 mult=1 m=1
XM_WR_1_0_s3p06 sn1_s3p06 wl_1 blp06 GND sky130_fd_pr__nfet_01v8 L=0.15 W=0.42 nf=1 ad=0.1218 as=0.1218 pd=1.42 ps=1.42 nrd=0.69047619047619  nrs=0.69047619047619 sa=0 sb=0 sd=0 mult=1 m=1
XM_RD_1_0_s3p06 rbl_s3p06 sn1_s3p06 rwld GND sky130_fd_pr__nfet_01v8 L=0.15 W=0.42 nf=1 ad=0.1218 as=0.1218 pd=1.42 ps=1.42 nrd=0.69047619047619  nrs=0.69047619047619 sa=0 sb=0 sd=0 mult=1 m=1
XM_WR_2_0_s3p06 sn2_s3p06 wl_2 blp06 GND sky130_fd_pr__nfet_01v8 L=0.15 W=0.42 nf=1 ad=0.1218 as=0.1218 pd=1.42 ps=1.42 nrd=0.69047619047619  nrs=0.69047619047619 sa=0 sb=0 sd=0 mult=1 m=1
XM_RD_2_0_s3p06 rbl_s3p06 sn2_s3p06 rwld GND sky130_fd_pr__nfet_01v8 L=0.15 W=0.42 nf=1 ad=0.1218 as=0.1218 pd=1.42 ps=1.42 nrd=0.69047619047619  nrs=0.69047619047619 sa=0 sb=0 sd=0 mult=1 m=1
XM_WR_3_0_s3p06 sn3_s3p06 wl_3 blp06 GND sky130_fd_pr__nfet_01v8 L=0.15 W=0.42 nf=1 ad=0.1218 as=0.1218 pd=1.42 ps=1.42 nrd=0.69047619047619  nrs=0.69047619047619 sa=0 sb=0 sd=0 mult=1 m=1
XM_RD_3_0_s3p06 rbl_s3p06 sn3_s3p06 rwls GND sky130_fd_pr__nfet_01v8 L=0.15 W=0.42 nf=1 ad=0.1218 as=0.1218 pd=1.42 ps=1.42 nrd=0.69047619047619  nrs=0.69047619047619 sa=0 sb=0 sd=0 mult=1 m=1
csn0_s3p06 sn0_s3p06 0 {C_SN}
csn1_s3p06 sn1_s3p06 0 {C_SN}
csn2_s3p06 sn2_s3p06 0 {C_SN}
csn3_s3p06 sn3_s3p06 0 {C_SN}
crbl_s3p06 rbl_s3p06 0 {C_RBL}
spre_s3p06 pre rbl_s3p06 ctl 0 swpre
ehb_s3p06 hb_s3p06 0 rbl_s3p06 0 1
shb_s3p06 hb_s3p06 hold_s3p06 hctl 0 swpre
chold_s3p06 hold_s3p06 0 1e-12
bdl_s3p06 dl_s3p06 0 v=v(rbl_s3p06)-v(hold_s3p06)+0.1-v(late)

* ---- case s3p07: selected row 3, pattern rows3210 0111 ----
XM_WR_0_0_s3p07 sn0_s3p07 wl_0 blp07 GND sky130_fd_pr__nfet_01v8 L=0.15 W=0.42 nf=1 ad=0.1218 as=0.1218 pd=1.42 ps=1.42 nrd=0.69047619047619  nrs=0.69047619047619 sa=0 sb=0 sd=0 mult=1 m=1
XM_RD_0_0_s3p07 rbl_s3p07 sn0_s3p07 rwld GND sky130_fd_pr__nfet_01v8 L=0.15 W=0.42 nf=1 ad=0.1218 as=0.1218 pd=1.42 ps=1.42 nrd=0.69047619047619  nrs=0.69047619047619 sa=0 sb=0 sd=0 mult=1 m=1
XM_WR_1_0_s3p07 sn1_s3p07 wl_1 blp07 GND sky130_fd_pr__nfet_01v8 L=0.15 W=0.42 nf=1 ad=0.1218 as=0.1218 pd=1.42 ps=1.42 nrd=0.69047619047619  nrs=0.69047619047619 sa=0 sb=0 sd=0 mult=1 m=1
XM_RD_1_0_s3p07 rbl_s3p07 sn1_s3p07 rwld GND sky130_fd_pr__nfet_01v8 L=0.15 W=0.42 nf=1 ad=0.1218 as=0.1218 pd=1.42 ps=1.42 nrd=0.69047619047619  nrs=0.69047619047619 sa=0 sb=0 sd=0 mult=1 m=1
XM_WR_2_0_s3p07 sn2_s3p07 wl_2 blp07 GND sky130_fd_pr__nfet_01v8 L=0.15 W=0.42 nf=1 ad=0.1218 as=0.1218 pd=1.42 ps=1.42 nrd=0.69047619047619  nrs=0.69047619047619 sa=0 sb=0 sd=0 mult=1 m=1
XM_RD_2_0_s3p07 rbl_s3p07 sn2_s3p07 rwld GND sky130_fd_pr__nfet_01v8 L=0.15 W=0.42 nf=1 ad=0.1218 as=0.1218 pd=1.42 ps=1.42 nrd=0.69047619047619  nrs=0.69047619047619 sa=0 sb=0 sd=0 mult=1 m=1
XM_WR_3_0_s3p07 sn3_s3p07 wl_3 blp07 GND sky130_fd_pr__nfet_01v8 L=0.15 W=0.42 nf=1 ad=0.1218 as=0.1218 pd=1.42 ps=1.42 nrd=0.69047619047619  nrs=0.69047619047619 sa=0 sb=0 sd=0 mult=1 m=1
XM_RD_3_0_s3p07 rbl_s3p07 sn3_s3p07 rwls GND sky130_fd_pr__nfet_01v8 L=0.15 W=0.42 nf=1 ad=0.1218 as=0.1218 pd=1.42 ps=1.42 nrd=0.69047619047619  nrs=0.69047619047619 sa=0 sb=0 sd=0 mult=1 m=1
csn0_s3p07 sn0_s3p07 0 {C_SN}
csn1_s3p07 sn1_s3p07 0 {C_SN}
csn2_s3p07 sn2_s3p07 0 {C_SN}
csn3_s3p07 sn3_s3p07 0 {C_SN}
crbl_s3p07 rbl_s3p07 0 {C_RBL}
spre_s3p07 pre rbl_s3p07 ctl 0 swpre
ehb_s3p07 hb_s3p07 0 rbl_s3p07 0 1
shb_s3p07 hb_s3p07 hold_s3p07 hctl 0 swpre
chold_s3p07 hold_s3p07 0 1e-12
bdl_s3p07 dl_s3p07 0 v=v(rbl_s3p07)-v(hold_s3p07)+0.1-v(late)

* ---- case s3p08: selected row 3, pattern rows3210 1000 ----
XM_WR_0_0_s3p08 sn0_s3p08 wl_0 blp08 GND sky130_fd_pr__nfet_01v8 L=0.15 W=0.42 nf=1 ad=0.1218 as=0.1218 pd=1.42 ps=1.42 nrd=0.69047619047619  nrs=0.69047619047619 sa=0 sb=0 sd=0 mult=1 m=1
XM_RD_0_0_s3p08 rbl_s3p08 sn0_s3p08 rwld GND sky130_fd_pr__nfet_01v8 L=0.15 W=0.42 nf=1 ad=0.1218 as=0.1218 pd=1.42 ps=1.42 nrd=0.69047619047619  nrs=0.69047619047619 sa=0 sb=0 sd=0 mult=1 m=1
XM_WR_1_0_s3p08 sn1_s3p08 wl_1 blp08 GND sky130_fd_pr__nfet_01v8 L=0.15 W=0.42 nf=1 ad=0.1218 as=0.1218 pd=1.42 ps=1.42 nrd=0.69047619047619  nrs=0.69047619047619 sa=0 sb=0 sd=0 mult=1 m=1
XM_RD_1_0_s3p08 rbl_s3p08 sn1_s3p08 rwld GND sky130_fd_pr__nfet_01v8 L=0.15 W=0.42 nf=1 ad=0.1218 as=0.1218 pd=1.42 ps=1.42 nrd=0.69047619047619  nrs=0.69047619047619 sa=0 sb=0 sd=0 mult=1 m=1
XM_WR_2_0_s3p08 sn2_s3p08 wl_2 blp08 GND sky130_fd_pr__nfet_01v8 L=0.15 W=0.42 nf=1 ad=0.1218 as=0.1218 pd=1.42 ps=1.42 nrd=0.69047619047619  nrs=0.69047619047619 sa=0 sb=0 sd=0 mult=1 m=1
XM_RD_2_0_s3p08 rbl_s3p08 sn2_s3p08 rwld GND sky130_fd_pr__nfet_01v8 L=0.15 W=0.42 nf=1 ad=0.1218 as=0.1218 pd=1.42 ps=1.42 nrd=0.69047619047619  nrs=0.69047619047619 sa=0 sb=0 sd=0 mult=1 m=1
XM_WR_3_0_s3p08 sn3_s3p08 wl_3 blp08 GND sky130_fd_pr__nfet_01v8 L=0.15 W=0.42 nf=1 ad=0.1218 as=0.1218 pd=1.42 ps=1.42 nrd=0.69047619047619  nrs=0.69047619047619 sa=0 sb=0 sd=0 mult=1 m=1
XM_RD_3_0_s3p08 rbl_s3p08 sn3_s3p08 rwls GND sky130_fd_pr__nfet_01v8 L=0.15 W=0.42 nf=1 ad=0.1218 as=0.1218 pd=1.42 ps=1.42 nrd=0.69047619047619  nrs=0.69047619047619 sa=0 sb=0 sd=0 mult=1 m=1
csn0_s3p08 sn0_s3p08 0 {C_SN}
csn1_s3p08 sn1_s3p08 0 {C_SN}
csn2_s3p08 sn2_s3p08 0 {C_SN}
csn3_s3p08 sn3_s3p08 0 {C_SN}
crbl_s3p08 rbl_s3p08 0 {C_RBL}
spre_s3p08 pre rbl_s3p08 ctl 0 swpre
ehb_s3p08 hb_s3p08 0 rbl_s3p08 0 1
shb_s3p08 hb_s3p08 hold_s3p08 hctl 0 swpre
chold_s3p08 hold_s3p08 0 1e-12
bdl_s3p08 dl_s3p08 0 v=v(rbl_s3p08)-v(hold_s3p08)+0.1-v(late)

* ---- case s3p09: selected row 3, pattern rows3210 1001 ----
XM_WR_0_0_s3p09 sn0_s3p09 wl_0 blp09 GND sky130_fd_pr__nfet_01v8 L=0.15 W=0.42 nf=1 ad=0.1218 as=0.1218 pd=1.42 ps=1.42 nrd=0.69047619047619  nrs=0.69047619047619 sa=0 sb=0 sd=0 mult=1 m=1
XM_RD_0_0_s3p09 rbl_s3p09 sn0_s3p09 rwld GND sky130_fd_pr__nfet_01v8 L=0.15 W=0.42 nf=1 ad=0.1218 as=0.1218 pd=1.42 ps=1.42 nrd=0.69047619047619  nrs=0.69047619047619 sa=0 sb=0 sd=0 mult=1 m=1
XM_WR_1_0_s3p09 sn1_s3p09 wl_1 blp09 GND sky130_fd_pr__nfet_01v8 L=0.15 W=0.42 nf=1 ad=0.1218 as=0.1218 pd=1.42 ps=1.42 nrd=0.69047619047619  nrs=0.69047619047619 sa=0 sb=0 sd=0 mult=1 m=1
XM_RD_1_0_s3p09 rbl_s3p09 sn1_s3p09 rwld GND sky130_fd_pr__nfet_01v8 L=0.15 W=0.42 nf=1 ad=0.1218 as=0.1218 pd=1.42 ps=1.42 nrd=0.69047619047619  nrs=0.69047619047619 sa=0 sb=0 sd=0 mult=1 m=1
XM_WR_2_0_s3p09 sn2_s3p09 wl_2 blp09 GND sky130_fd_pr__nfet_01v8 L=0.15 W=0.42 nf=1 ad=0.1218 as=0.1218 pd=1.42 ps=1.42 nrd=0.69047619047619  nrs=0.69047619047619 sa=0 sb=0 sd=0 mult=1 m=1
XM_RD_2_0_s3p09 rbl_s3p09 sn2_s3p09 rwld GND sky130_fd_pr__nfet_01v8 L=0.15 W=0.42 nf=1 ad=0.1218 as=0.1218 pd=1.42 ps=1.42 nrd=0.69047619047619  nrs=0.69047619047619 sa=0 sb=0 sd=0 mult=1 m=1
XM_WR_3_0_s3p09 sn3_s3p09 wl_3 blp09 GND sky130_fd_pr__nfet_01v8 L=0.15 W=0.42 nf=1 ad=0.1218 as=0.1218 pd=1.42 ps=1.42 nrd=0.69047619047619  nrs=0.69047619047619 sa=0 sb=0 sd=0 mult=1 m=1
XM_RD_3_0_s3p09 rbl_s3p09 sn3_s3p09 rwls GND sky130_fd_pr__nfet_01v8 L=0.15 W=0.42 nf=1 ad=0.1218 as=0.1218 pd=1.42 ps=1.42 nrd=0.69047619047619  nrs=0.69047619047619 sa=0 sb=0 sd=0 mult=1 m=1
csn0_s3p09 sn0_s3p09 0 {C_SN}
csn1_s3p09 sn1_s3p09 0 {C_SN}
csn2_s3p09 sn2_s3p09 0 {C_SN}
csn3_s3p09 sn3_s3p09 0 {C_SN}
crbl_s3p09 rbl_s3p09 0 {C_RBL}
spre_s3p09 pre rbl_s3p09 ctl 0 swpre
ehb_s3p09 hb_s3p09 0 rbl_s3p09 0 1
shb_s3p09 hb_s3p09 hold_s3p09 hctl 0 swpre
chold_s3p09 hold_s3p09 0 1e-12
bdl_s3p09 dl_s3p09 0 v=v(rbl_s3p09)-v(hold_s3p09)+0.1-v(late)

* ---- case s3p10: selected row 3, pattern rows3210 1010 ----
XM_WR_0_0_s3p10 sn0_s3p10 wl_0 blp10 GND sky130_fd_pr__nfet_01v8 L=0.15 W=0.42 nf=1 ad=0.1218 as=0.1218 pd=1.42 ps=1.42 nrd=0.69047619047619  nrs=0.69047619047619 sa=0 sb=0 sd=0 mult=1 m=1
XM_RD_0_0_s3p10 rbl_s3p10 sn0_s3p10 rwld GND sky130_fd_pr__nfet_01v8 L=0.15 W=0.42 nf=1 ad=0.1218 as=0.1218 pd=1.42 ps=1.42 nrd=0.69047619047619  nrs=0.69047619047619 sa=0 sb=0 sd=0 mult=1 m=1
XM_WR_1_0_s3p10 sn1_s3p10 wl_1 blp10 GND sky130_fd_pr__nfet_01v8 L=0.15 W=0.42 nf=1 ad=0.1218 as=0.1218 pd=1.42 ps=1.42 nrd=0.69047619047619  nrs=0.69047619047619 sa=0 sb=0 sd=0 mult=1 m=1
XM_RD_1_0_s3p10 rbl_s3p10 sn1_s3p10 rwld GND sky130_fd_pr__nfet_01v8 L=0.15 W=0.42 nf=1 ad=0.1218 as=0.1218 pd=1.42 ps=1.42 nrd=0.69047619047619  nrs=0.69047619047619 sa=0 sb=0 sd=0 mult=1 m=1
XM_WR_2_0_s3p10 sn2_s3p10 wl_2 blp10 GND sky130_fd_pr__nfet_01v8 L=0.15 W=0.42 nf=1 ad=0.1218 as=0.1218 pd=1.42 ps=1.42 nrd=0.69047619047619  nrs=0.69047619047619 sa=0 sb=0 sd=0 mult=1 m=1
XM_RD_2_0_s3p10 rbl_s3p10 sn2_s3p10 rwld GND sky130_fd_pr__nfet_01v8 L=0.15 W=0.42 nf=1 ad=0.1218 as=0.1218 pd=1.42 ps=1.42 nrd=0.69047619047619  nrs=0.69047619047619 sa=0 sb=0 sd=0 mult=1 m=1
XM_WR_3_0_s3p10 sn3_s3p10 wl_3 blp10 GND sky130_fd_pr__nfet_01v8 L=0.15 W=0.42 nf=1 ad=0.1218 as=0.1218 pd=1.42 ps=1.42 nrd=0.69047619047619  nrs=0.69047619047619 sa=0 sb=0 sd=0 mult=1 m=1
XM_RD_3_0_s3p10 rbl_s3p10 sn3_s3p10 rwls GND sky130_fd_pr__nfet_01v8 L=0.15 W=0.42 nf=1 ad=0.1218 as=0.1218 pd=1.42 ps=1.42 nrd=0.69047619047619  nrs=0.69047619047619 sa=0 sb=0 sd=0 mult=1 m=1
csn0_s3p10 sn0_s3p10 0 {C_SN}
csn1_s3p10 sn1_s3p10 0 {C_SN}
csn2_s3p10 sn2_s3p10 0 {C_SN}
csn3_s3p10 sn3_s3p10 0 {C_SN}
crbl_s3p10 rbl_s3p10 0 {C_RBL}
spre_s3p10 pre rbl_s3p10 ctl 0 swpre
ehb_s3p10 hb_s3p10 0 rbl_s3p10 0 1
shb_s3p10 hb_s3p10 hold_s3p10 hctl 0 swpre
chold_s3p10 hold_s3p10 0 1e-12
bdl_s3p10 dl_s3p10 0 v=v(rbl_s3p10)-v(hold_s3p10)+0.1-v(late)

* ---- case s3p11: selected row 3, pattern rows3210 1011 ----
XM_WR_0_0_s3p11 sn0_s3p11 wl_0 blp11 GND sky130_fd_pr__nfet_01v8 L=0.15 W=0.42 nf=1 ad=0.1218 as=0.1218 pd=1.42 ps=1.42 nrd=0.69047619047619  nrs=0.69047619047619 sa=0 sb=0 sd=0 mult=1 m=1
XM_RD_0_0_s3p11 rbl_s3p11 sn0_s3p11 rwld GND sky130_fd_pr__nfet_01v8 L=0.15 W=0.42 nf=1 ad=0.1218 as=0.1218 pd=1.42 ps=1.42 nrd=0.69047619047619  nrs=0.69047619047619 sa=0 sb=0 sd=0 mult=1 m=1
XM_WR_1_0_s3p11 sn1_s3p11 wl_1 blp11 GND sky130_fd_pr__nfet_01v8 L=0.15 W=0.42 nf=1 ad=0.1218 as=0.1218 pd=1.42 ps=1.42 nrd=0.69047619047619  nrs=0.69047619047619 sa=0 sb=0 sd=0 mult=1 m=1
XM_RD_1_0_s3p11 rbl_s3p11 sn1_s3p11 rwld GND sky130_fd_pr__nfet_01v8 L=0.15 W=0.42 nf=1 ad=0.1218 as=0.1218 pd=1.42 ps=1.42 nrd=0.69047619047619  nrs=0.69047619047619 sa=0 sb=0 sd=0 mult=1 m=1
XM_WR_2_0_s3p11 sn2_s3p11 wl_2 blp11 GND sky130_fd_pr__nfet_01v8 L=0.15 W=0.42 nf=1 ad=0.1218 as=0.1218 pd=1.42 ps=1.42 nrd=0.69047619047619  nrs=0.69047619047619 sa=0 sb=0 sd=0 mult=1 m=1
XM_RD_2_0_s3p11 rbl_s3p11 sn2_s3p11 rwld GND sky130_fd_pr__nfet_01v8 L=0.15 W=0.42 nf=1 ad=0.1218 as=0.1218 pd=1.42 ps=1.42 nrd=0.69047619047619  nrs=0.69047619047619 sa=0 sb=0 sd=0 mult=1 m=1
XM_WR_3_0_s3p11 sn3_s3p11 wl_3 blp11 GND sky130_fd_pr__nfet_01v8 L=0.15 W=0.42 nf=1 ad=0.1218 as=0.1218 pd=1.42 ps=1.42 nrd=0.69047619047619  nrs=0.69047619047619 sa=0 sb=0 sd=0 mult=1 m=1
XM_RD_3_0_s3p11 rbl_s3p11 sn3_s3p11 rwls GND sky130_fd_pr__nfet_01v8 L=0.15 W=0.42 nf=1 ad=0.1218 as=0.1218 pd=1.42 ps=1.42 nrd=0.69047619047619  nrs=0.69047619047619 sa=0 sb=0 sd=0 mult=1 m=1
csn0_s3p11 sn0_s3p11 0 {C_SN}
csn1_s3p11 sn1_s3p11 0 {C_SN}
csn2_s3p11 sn2_s3p11 0 {C_SN}
csn3_s3p11 sn3_s3p11 0 {C_SN}
crbl_s3p11 rbl_s3p11 0 {C_RBL}
spre_s3p11 pre rbl_s3p11 ctl 0 swpre
ehb_s3p11 hb_s3p11 0 rbl_s3p11 0 1
shb_s3p11 hb_s3p11 hold_s3p11 hctl 0 swpre
chold_s3p11 hold_s3p11 0 1e-12
bdl_s3p11 dl_s3p11 0 v=v(rbl_s3p11)-v(hold_s3p11)+0.1-v(late)

* ---- case s3p12: selected row 3, pattern rows3210 1100 ----
XM_WR_0_0_s3p12 sn0_s3p12 wl_0 blp12 GND sky130_fd_pr__nfet_01v8 L=0.15 W=0.42 nf=1 ad=0.1218 as=0.1218 pd=1.42 ps=1.42 nrd=0.69047619047619  nrs=0.69047619047619 sa=0 sb=0 sd=0 mult=1 m=1
XM_RD_0_0_s3p12 rbl_s3p12 sn0_s3p12 rwld GND sky130_fd_pr__nfet_01v8 L=0.15 W=0.42 nf=1 ad=0.1218 as=0.1218 pd=1.42 ps=1.42 nrd=0.69047619047619  nrs=0.69047619047619 sa=0 sb=0 sd=0 mult=1 m=1
XM_WR_1_0_s3p12 sn1_s3p12 wl_1 blp12 GND sky130_fd_pr__nfet_01v8 L=0.15 W=0.42 nf=1 ad=0.1218 as=0.1218 pd=1.42 ps=1.42 nrd=0.69047619047619  nrs=0.69047619047619 sa=0 sb=0 sd=0 mult=1 m=1
XM_RD_1_0_s3p12 rbl_s3p12 sn1_s3p12 rwld GND sky130_fd_pr__nfet_01v8 L=0.15 W=0.42 nf=1 ad=0.1218 as=0.1218 pd=1.42 ps=1.42 nrd=0.69047619047619  nrs=0.69047619047619 sa=0 sb=0 sd=0 mult=1 m=1
XM_WR_2_0_s3p12 sn2_s3p12 wl_2 blp12 GND sky130_fd_pr__nfet_01v8 L=0.15 W=0.42 nf=1 ad=0.1218 as=0.1218 pd=1.42 ps=1.42 nrd=0.69047619047619  nrs=0.69047619047619 sa=0 sb=0 sd=0 mult=1 m=1
XM_RD_2_0_s3p12 rbl_s3p12 sn2_s3p12 rwld GND sky130_fd_pr__nfet_01v8 L=0.15 W=0.42 nf=1 ad=0.1218 as=0.1218 pd=1.42 ps=1.42 nrd=0.69047619047619  nrs=0.69047619047619 sa=0 sb=0 sd=0 mult=1 m=1
XM_WR_3_0_s3p12 sn3_s3p12 wl_3 blp12 GND sky130_fd_pr__nfet_01v8 L=0.15 W=0.42 nf=1 ad=0.1218 as=0.1218 pd=1.42 ps=1.42 nrd=0.69047619047619  nrs=0.69047619047619 sa=0 sb=0 sd=0 mult=1 m=1
XM_RD_3_0_s3p12 rbl_s3p12 sn3_s3p12 rwls GND sky130_fd_pr__nfet_01v8 L=0.15 W=0.42 nf=1 ad=0.1218 as=0.1218 pd=1.42 ps=1.42 nrd=0.69047619047619  nrs=0.69047619047619 sa=0 sb=0 sd=0 mult=1 m=1
csn0_s3p12 sn0_s3p12 0 {C_SN}
csn1_s3p12 sn1_s3p12 0 {C_SN}
csn2_s3p12 sn2_s3p12 0 {C_SN}
csn3_s3p12 sn3_s3p12 0 {C_SN}
crbl_s3p12 rbl_s3p12 0 {C_RBL}
spre_s3p12 pre rbl_s3p12 ctl 0 swpre
ehb_s3p12 hb_s3p12 0 rbl_s3p12 0 1
shb_s3p12 hb_s3p12 hold_s3p12 hctl 0 swpre
chold_s3p12 hold_s3p12 0 1e-12
bdl_s3p12 dl_s3p12 0 v=v(rbl_s3p12)-v(hold_s3p12)+0.1-v(late)

* ---- case s3p13: selected row 3, pattern rows3210 1101 ----
XM_WR_0_0_s3p13 sn0_s3p13 wl_0 blp13 GND sky130_fd_pr__nfet_01v8 L=0.15 W=0.42 nf=1 ad=0.1218 as=0.1218 pd=1.42 ps=1.42 nrd=0.69047619047619  nrs=0.69047619047619 sa=0 sb=0 sd=0 mult=1 m=1
XM_RD_0_0_s3p13 rbl_s3p13 sn0_s3p13 rwld GND sky130_fd_pr__nfet_01v8 L=0.15 W=0.42 nf=1 ad=0.1218 as=0.1218 pd=1.42 ps=1.42 nrd=0.69047619047619  nrs=0.69047619047619 sa=0 sb=0 sd=0 mult=1 m=1
XM_WR_1_0_s3p13 sn1_s3p13 wl_1 blp13 GND sky130_fd_pr__nfet_01v8 L=0.15 W=0.42 nf=1 ad=0.1218 as=0.1218 pd=1.42 ps=1.42 nrd=0.69047619047619  nrs=0.69047619047619 sa=0 sb=0 sd=0 mult=1 m=1
XM_RD_1_0_s3p13 rbl_s3p13 sn1_s3p13 rwld GND sky130_fd_pr__nfet_01v8 L=0.15 W=0.42 nf=1 ad=0.1218 as=0.1218 pd=1.42 ps=1.42 nrd=0.69047619047619  nrs=0.69047619047619 sa=0 sb=0 sd=0 mult=1 m=1
XM_WR_2_0_s3p13 sn2_s3p13 wl_2 blp13 GND sky130_fd_pr__nfet_01v8 L=0.15 W=0.42 nf=1 ad=0.1218 as=0.1218 pd=1.42 ps=1.42 nrd=0.69047619047619  nrs=0.69047619047619 sa=0 sb=0 sd=0 mult=1 m=1
XM_RD_2_0_s3p13 rbl_s3p13 sn2_s3p13 rwld GND sky130_fd_pr__nfet_01v8 L=0.15 W=0.42 nf=1 ad=0.1218 as=0.1218 pd=1.42 ps=1.42 nrd=0.69047619047619  nrs=0.69047619047619 sa=0 sb=0 sd=0 mult=1 m=1
XM_WR_3_0_s3p13 sn3_s3p13 wl_3 blp13 GND sky130_fd_pr__nfet_01v8 L=0.15 W=0.42 nf=1 ad=0.1218 as=0.1218 pd=1.42 ps=1.42 nrd=0.69047619047619  nrs=0.69047619047619 sa=0 sb=0 sd=0 mult=1 m=1
XM_RD_3_0_s3p13 rbl_s3p13 sn3_s3p13 rwls GND sky130_fd_pr__nfet_01v8 L=0.15 W=0.42 nf=1 ad=0.1218 as=0.1218 pd=1.42 ps=1.42 nrd=0.69047619047619  nrs=0.69047619047619 sa=0 sb=0 sd=0 mult=1 m=1
csn0_s3p13 sn0_s3p13 0 {C_SN}
csn1_s3p13 sn1_s3p13 0 {C_SN}
csn2_s3p13 sn2_s3p13 0 {C_SN}
csn3_s3p13 sn3_s3p13 0 {C_SN}
crbl_s3p13 rbl_s3p13 0 {C_RBL}
spre_s3p13 pre rbl_s3p13 ctl 0 swpre
ehb_s3p13 hb_s3p13 0 rbl_s3p13 0 1
shb_s3p13 hb_s3p13 hold_s3p13 hctl 0 swpre
chold_s3p13 hold_s3p13 0 1e-12
bdl_s3p13 dl_s3p13 0 v=v(rbl_s3p13)-v(hold_s3p13)+0.1-v(late)

* ---- case s3p14: selected row 3, pattern rows3210 1110 ----
XM_WR_0_0_s3p14 sn0_s3p14 wl_0 blp14 GND sky130_fd_pr__nfet_01v8 L=0.15 W=0.42 nf=1 ad=0.1218 as=0.1218 pd=1.42 ps=1.42 nrd=0.69047619047619  nrs=0.69047619047619 sa=0 sb=0 sd=0 mult=1 m=1
XM_RD_0_0_s3p14 rbl_s3p14 sn0_s3p14 rwld GND sky130_fd_pr__nfet_01v8 L=0.15 W=0.42 nf=1 ad=0.1218 as=0.1218 pd=1.42 ps=1.42 nrd=0.69047619047619  nrs=0.69047619047619 sa=0 sb=0 sd=0 mult=1 m=1
XM_WR_1_0_s3p14 sn1_s3p14 wl_1 blp14 GND sky130_fd_pr__nfet_01v8 L=0.15 W=0.42 nf=1 ad=0.1218 as=0.1218 pd=1.42 ps=1.42 nrd=0.69047619047619  nrs=0.69047619047619 sa=0 sb=0 sd=0 mult=1 m=1
XM_RD_1_0_s3p14 rbl_s3p14 sn1_s3p14 rwld GND sky130_fd_pr__nfet_01v8 L=0.15 W=0.42 nf=1 ad=0.1218 as=0.1218 pd=1.42 ps=1.42 nrd=0.69047619047619  nrs=0.69047619047619 sa=0 sb=0 sd=0 mult=1 m=1
XM_WR_2_0_s3p14 sn2_s3p14 wl_2 blp14 GND sky130_fd_pr__nfet_01v8 L=0.15 W=0.42 nf=1 ad=0.1218 as=0.1218 pd=1.42 ps=1.42 nrd=0.69047619047619  nrs=0.69047619047619 sa=0 sb=0 sd=0 mult=1 m=1
XM_RD_2_0_s3p14 rbl_s3p14 sn2_s3p14 rwld GND sky130_fd_pr__nfet_01v8 L=0.15 W=0.42 nf=1 ad=0.1218 as=0.1218 pd=1.42 ps=1.42 nrd=0.69047619047619  nrs=0.69047619047619 sa=0 sb=0 sd=0 mult=1 m=1
XM_WR_3_0_s3p14 sn3_s3p14 wl_3 blp14 GND sky130_fd_pr__nfet_01v8 L=0.15 W=0.42 nf=1 ad=0.1218 as=0.1218 pd=1.42 ps=1.42 nrd=0.69047619047619  nrs=0.69047619047619 sa=0 sb=0 sd=0 mult=1 m=1
XM_RD_3_0_s3p14 rbl_s3p14 sn3_s3p14 rwls GND sky130_fd_pr__nfet_01v8 L=0.15 W=0.42 nf=1 ad=0.1218 as=0.1218 pd=1.42 ps=1.42 nrd=0.69047619047619  nrs=0.69047619047619 sa=0 sb=0 sd=0 mult=1 m=1
csn0_s3p14 sn0_s3p14 0 {C_SN}
csn1_s3p14 sn1_s3p14 0 {C_SN}
csn2_s3p14 sn2_s3p14 0 {C_SN}
csn3_s3p14 sn3_s3p14 0 {C_SN}
crbl_s3p14 rbl_s3p14 0 {C_RBL}
spre_s3p14 pre rbl_s3p14 ctl 0 swpre
ehb_s3p14 hb_s3p14 0 rbl_s3p14 0 1
shb_s3p14 hb_s3p14 hold_s3p14 hctl 0 swpre
chold_s3p14 hold_s3p14 0 1e-12
bdl_s3p14 dl_s3p14 0 v=v(rbl_s3p14)-v(hold_s3p14)+0.1-v(late)

* ---- case s3p15: selected row 3, pattern rows3210 1111 ----
XM_WR_0_0_s3p15 sn0_s3p15 wl_0 blp15 GND sky130_fd_pr__nfet_01v8 L=0.15 W=0.42 nf=1 ad=0.1218 as=0.1218 pd=1.42 ps=1.42 nrd=0.69047619047619  nrs=0.69047619047619 sa=0 sb=0 sd=0 mult=1 m=1
XM_RD_0_0_s3p15 rbl_s3p15 sn0_s3p15 rwld GND sky130_fd_pr__nfet_01v8 L=0.15 W=0.42 nf=1 ad=0.1218 as=0.1218 pd=1.42 ps=1.42 nrd=0.69047619047619  nrs=0.69047619047619 sa=0 sb=0 sd=0 mult=1 m=1
XM_WR_1_0_s3p15 sn1_s3p15 wl_1 blp15 GND sky130_fd_pr__nfet_01v8 L=0.15 W=0.42 nf=1 ad=0.1218 as=0.1218 pd=1.42 ps=1.42 nrd=0.69047619047619  nrs=0.69047619047619 sa=0 sb=0 sd=0 mult=1 m=1
XM_RD_1_0_s3p15 rbl_s3p15 sn1_s3p15 rwld GND sky130_fd_pr__nfet_01v8 L=0.15 W=0.42 nf=1 ad=0.1218 as=0.1218 pd=1.42 ps=1.42 nrd=0.69047619047619  nrs=0.69047619047619 sa=0 sb=0 sd=0 mult=1 m=1
XM_WR_2_0_s3p15 sn2_s3p15 wl_2 blp15 GND sky130_fd_pr__nfet_01v8 L=0.15 W=0.42 nf=1 ad=0.1218 as=0.1218 pd=1.42 ps=1.42 nrd=0.69047619047619  nrs=0.69047619047619 sa=0 sb=0 sd=0 mult=1 m=1
XM_RD_2_0_s3p15 rbl_s3p15 sn2_s3p15 rwld GND sky130_fd_pr__nfet_01v8 L=0.15 W=0.42 nf=1 ad=0.1218 as=0.1218 pd=1.42 ps=1.42 nrd=0.69047619047619  nrs=0.69047619047619 sa=0 sb=0 sd=0 mult=1 m=1
XM_WR_3_0_s3p15 sn3_s3p15 wl_3 blp15 GND sky130_fd_pr__nfet_01v8 L=0.15 W=0.42 nf=1 ad=0.1218 as=0.1218 pd=1.42 ps=1.42 nrd=0.69047619047619  nrs=0.69047619047619 sa=0 sb=0 sd=0 mult=1 m=1
XM_RD_3_0_s3p15 rbl_s3p15 sn3_s3p15 rwls GND sky130_fd_pr__nfet_01v8 L=0.15 W=0.42 nf=1 ad=0.1218 as=0.1218 pd=1.42 ps=1.42 nrd=0.69047619047619  nrs=0.69047619047619 sa=0 sb=0 sd=0 mult=1 m=1
csn0_s3p15 sn0_s3p15 0 {C_SN}
csn1_s3p15 sn1_s3p15 0 {C_SN}
csn2_s3p15 sn2_s3p15 0 {C_SN}
csn3_s3p15 sn3_s3p15 0 {C_SN}
crbl_s3p15 rbl_s3p15 0 {C_RBL}
spre_s3p15 pre rbl_s3p15 ctl 0 swpre
ehb_s3p15 hb_s3p15 0 rbl_s3p15 0 1
shb_s3p15 hb_s3p15 hold_s3p15 hctl 0 swpre
chold_s3p15 hold_s3p15 0 1e-12
bdl_s3p15 dl_s3p15 0 v=v(rbl_s3p15)-v(hold_s3p15)+0.1-v(late)

* initial conditions (Phase 2: .ic, no uic)
.ic v(rbl_s0p00)={VRBL} v(hold_s0p00)={VRBL} v(sn0_s0p00)=1.8 v(sn1_s0p00)=1.8 v(sn2_s0p00)=1.8 v(sn3_s0p00)=1.8
.ic v(rbl_s0p01)={VRBL} v(hold_s0p01)={VRBL} v(sn0_s0p01)=0 v(sn1_s0p01)=1.8 v(sn2_s0p01)=1.8 v(sn3_s0p01)=1.8
.ic v(rbl_s0p02)={VRBL} v(hold_s0p02)={VRBL} v(sn0_s0p02)=1.8 v(sn1_s0p02)=0 v(sn2_s0p02)=1.8 v(sn3_s0p02)=1.8
.ic v(rbl_s0p03)={VRBL} v(hold_s0p03)={VRBL} v(sn0_s0p03)=0 v(sn1_s0p03)=0 v(sn2_s0p03)=1.8 v(sn3_s0p03)=1.8
.ic v(rbl_s0p04)={VRBL} v(hold_s0p04)={VRBL} v(sn0_s0p04)=1.8 v(sn1_s0p04)=1.8 v(sn2_s0p04)=0 v(sn3_s0p04)=1.8
.ic v(rbl_s0p05)={VRBL} v(hold_s0p05)={VRBL} v(sn0_s0p05)=0 v(sn1_s0p05)=1.8 v(sn2_s0p05)=0 v(sn3_s0p05)=1.8
.ic v(rbl_s0p06)={VRBL} v(hold_s0p06)={VRBL} v(sn0_s0p06)=1.8 v(sn1_s0p06)=0 v(sn2_s0p06)=0 v(sn3_s0p06)=1.8
.ic v(rbl_s0p07)={VRBL} v(hold_s0p07)={VRBL} v(sn0_s0p07)=0 v(sn1_s0p07)=0 v(sn2_s0p07)=0 v(sn3_s0p07)=1.8
.ic v(rbl_s0p08)={VRBL} v(hold_s0p08)={VRBL} v(sn0_s0p08)=1.8 v(sn1_s0p08)=1.8 v(sn2_s0p08)=1.8 v(sn3_s0p08)=0
.ic v(rbl_s0p09)={VRBL} v(hold_s0p09)={VRBL} v(sn0_s0p09)=0 v(sn1_s0p09)=1.8 v(sn2_s0p09)=1.8 v(sn3_s0p09)=0
.ic v(rbl_s0p10)={VRBL} v(hold_s0p10)={VRBL} v(sn0_s0p10)=1.8 v(sn1_s0p10)=0 v(sn2_s0p10)=1.8 v(sn3_s0p10)=0
.ic v(rbl_s0p11)={VRBL} v(hold_s0p11)={VRBL} v(sn0_s0p11)=0 v(sn1_s0p11)=0 v(sn2_s0p11)=1.8 v(sn3_s0p11)=0
.ic v(rbl_s0p12)={VRBL} v(hold_s0p12)={VRBL} v(sn0_s0p12)=1.8 v(sn1_s0p12)=1.8 v(sn2_s0p12)=0 v(sn3_s0p12)=0
.ic v(rbl_s0p13)={VRBL} v(hold_s0p13)={VRBL} v(sn0_s0p13)=0 v(sn1_s0p13)=1.8 v(sn2_s0p13)=0 v(sn3_s0p13)=0
.ic v(rbl_s0p14)={VRBL} v(hold_s0p14)={VRBL} v(sn0_s0p14)=1.8 v(sn1_s0p14)=0 v(sn2_s0p14)=0 v(sn3_s0p14)=0
.ic v(rbl_s0p15)={VRBL} v(hold_s0p15)={VRBL} v(sn0_s0p15)=0 v(sn1_s0p15)=0 v(sn2_s0p15)=0 v(sn3_s0p15)=0
.ic v(rbl_s1p00)={VRBL} v(hold_s1p00)={VRBL} v(sn0_s1p00)=1.8 v(sn1_s1p00)=1.8 v(sn2_s1p00)=1.8 v(sn3_s1p00)=1.8
.ic v(rbl_s1p01)={VRBL} v(hold_s1p01)={VRBL} v(sn0_s1p01)=0 v(sn1_s1p01)=1.8 v(sn2_s1p01)=1.8 v(sn3_s1p01)=1.8
.ic v(rbl_s1p02)={VRBL} v(hold_s1p02)={VRBL} v(sn0_s1p02)=1.8 v(sn1_s1p02)=0 v(sn2_s1p02)=1.8 v(sn3_s1p02)=1.8
.ic v(rbl_s1p03)={VRBL} v(hold_s1p03)={VRBL} v(sn0_s1p03)=0 v(sn1_s1p03)=0 v(sn2_s1p03)=1.8 v(sn3_s1p03)=1.8
.ic v(rbl_s1p04)={VRBL} v(hold_s1p04)={VRBL} v(sn0_s1p04)=1.8 v(sn1_s1p04)=1.8 v(sn2_s1p04)=0 v(sn3_s1p04)=1.8
.ic v(rbl_s1p05)={VRBL} v(hold_s1p05)={VRBL} v(sn0_s1p05)=0 v(sn1_s1p05)=1.8 v(sn2_s1p05)=0 v(sn3_s1p05)=1.8
.ic v(rbl_s1p06)={VRBL} v(hold_s1p06)={VRBL} v(sn0_s1p06)=1.8 v(sn1_s1p06)=0 v(sn2_s1p06)=0 v(sn3_s1p06)=1.8
.ic v(rbl_s1p07)={VRBL} v(hold_s1p07)={VRBL} v(sn0_s1p07)=0 v(sn1_s1p07)=0 v(sn2_s1p07)=0 v(sn3_s1p07)=1.8
.ic v(rbl_s1p08)={VRBL} v(hold_s1p08)={VRBL} v(sn0_s1p08)=1.8 v(sn1_s1p08)=1.8 v(sn2_s1p08)=1.8 v(sn3_s1p08)=0
.ic v(rbl_s1p09)={VRBL} v(hold_s1p09)={VRBL} v(sn0_s1p09)=0 v(sn1_s1p09)=1.8 v(sn2_s1p09)=1.8 v(sn3_s1p09)=0
.ic v(rbl_s1p10)={VRBL} v(hold_s1p10)={VRBL} v(sn0_s1p10)=1.8 v(sn1_s1p10)=0 v(sn2_s1p10)=1.8 v(sn3_s1p10)=0
.ic v(rbl_s1p11)={VRBL} v(hold_s1p11)={VRBL} v(sn0_s1p11)=0 v(sn1_s1p11)=0 v(sn2_s1p11)=1.8 v(sn3_s1p11)=0
.ic v(rbl_s1p12)={VRBL} v(hold_s1p12)={VRBL} v(sn0_s1p12)=1.8 v(sn1_s1p12)=1.8 v(sn2_s1p12)=0 v(sn3_s1p12)=0
.ic v(rbl_s1p13)={VRBL} v(hold_s1p13)={VRBL} v(sn0_s1p13)=0 v(sn1_s1p13)=1.8 v(sn2_s1p13)=0 v(sn3_s1p13)=0
.ic v(rbl_s1p14)={VRBL} v(hold_s1p14)={VRBL} v(sn0_s1p14)=1.8 v(sn1_s1p14)=0 v(sn2_s1p14)=0 v(sn3_s1p14)=0
.ic v(rbl_s1p15)={VRBL} v(hold_s1p15)={VRBL} v(sn0_s1p15)=0 v(sn1_s1p15)=0 v(sn2_s1p15)=0 v(sn3_s1p15)=0
.ic v(rbl_s2p00)={VRBL} v(hold_s2p00)={VRBL} v(sn0_s2p00)=1.8 v(sn1_s2p00)=1.8 v(sn2_s2p00)=1.8 v(sn3_s2p00)=1.8
.ic v(rbl_s2p01)={VRBL} v(hold_s2p01)={VRBL} v(sn0_s2p01)=0 v(sn1_s2p01)=1.8 v(sn2_s2p01)=1.8 v(sn3_s2p01)=1.8
.ic v(rbl_s2p02)={VRBL} v(hold_s2p02)={VRBL} v(sn0_s2p02)=1.8 v(sn1_s2p02)=0 v(sn2_s2p02)=1.8 v(sn3_s2p02)=1.8
.ic v(rbl_s2p03)={VRBL} v(hold_s2p03)={VRBL} v(sn0_s2p03)=0 v(sn1_s2p03)=0 v(sn2_s2p03)=1.8 v(sn3_s2p03)=1.8
.ic v(rbl_s2p04)={VRBL} v(hold_s2p04)={VRBL} v(sn0_s2p04)=1.8 v(sn1_s2p04)=1.8 v(sn2_s2p04)=0 v(sn3_s2p04)=1.8
.ic v(rbl_s2p05)={VRBL} v(hold_s2p05)={VRBL} v(sn0_s2p05)=0 v(sn1_s2p05)=1.8 v(sn2_s2p05)=0 v(sn3_s2p05)=1.8
.ic v(rbl_s2p06)={VRBL} v(hold_s2p06)={VRBL} v(sn0_s2p06)=1.8 v(sn1_s2p06)=0 v(sn2_s2p06)=0 v(sn3_s2p06)=1.8
.ic v(rbl_s2p07)={VRBL} v(hold_s2p07)={VRBL} v(sn0_s2p07)=0 v(sn1_s2p07)=0 v(sn2_s2p07)=0 v(sn3_s2p07)=1.8
.ic v(rbl_s2p08)={VRBL} v(hold_s2p08)={VRBL} v(sn0_s2p08)=1.8 v(sn1_s2p08)=1.8 v(sn2_s2p08)=1.8 v(sn3_s2p08)=0
.ic v(rbl_s2p09)={VRBL} v(hold_s2p09)={VRBL} v(sn0_s2p09)=0 v(sn1_s2p09)=1.8 v(sn2_s2p09)=1.8 v(sn3_s2p09)=0
.ic v(rbl_s2p10)={VRBL} v(hold_s2p10)={VRBL} v(sn0_s2p10)=1.8 v(sn1_s2p10)=0 v(sn2_s2p10)=1.8 v(sn3_s2p10)=0
.ic v(rbl_s2p11)={VRBL} v(hold_s2p11)={VRBL} v(sn0_s2p11)=0 v(sn1_s2p11)=0 v(sn2_s2p11)=1.8 v(sn3_s2p11)=0
.ic v(rbl_s2p12)={VRBL} v(hold_s2p12)={VRBL} v(sn0_s2p12)=1.8 v(sn1_s2p12)=1.8 v(sn2_s2p12)=0 v(sn3_s2p12)=0
.ic v(rbl_s2p13)={VRBL} v(hold_s2p13)={VRBL} v(sn0_s2p13)=0 v(sn1_s2p13)=1.8 v(sn2_s2p13)=0 v(sn3_s2p13)=0
.ic v(rbl_s2p14)={VRBL} v(hold_s2p14)={VRBL} v(sn0_s2p14)=1.8 v(sn1_s2p14)=0 v(sn2_s2p14)=0 v(sn3_s2p14)=0
.ic v(rbl_s2p15)={VRBL} v(hold_s2p15)={VRBL} v(sn0_s2p15)=0 v(sn1_s2p15)=0 v(sn2_s2p15)=0 v(sn3_s2p15)=0
.ic v(rbl_s3p00)={VRBL} v(hold_s3p00)={VRBL} v(sn0_s3p00)=1.8 v(sn1_s3p00)=1.8 v(sn2_s3p00)=1.8 v(sn3_s3p00)=1.8
.ic v(rbl_s3p01)={VRBL} v(hold_s3p01)={VRBL} v(sn0_s3p01)=0 v(sn1_s3p01)=1.8 v(sn2_s3p01)=1.8 v(sn3_s3p01)=1.8
.ic v(rbl_s3p02)={VRBL} v(hold_s3p02)={VRBL} v(sn0_s3p02)=1.8 v(sn1_s3p02)=0 v(sn2_s3p02)=1.8 v(sn3_s3p02)=1.8
.ic v(rbl_s3p03)={VRBL} v(hold_s3p03)={VRBL} v(sn0_s3p03)=0 v(sn1_s3p03)=0 v(sn2_s3p03)=1.8 v(sn3_s3p03)=1.8
.ic v(rbl_s3p04)={VRBL} v(hold_s3p04)={VRBL} v(sn0_s3p04)=1.8 v(sn1_s3p04)=1.8 v(sn2_s3p04)=0 v(sn3_s3p04)=1.8
.ic v(rbl_s3p05)={VRBL} v(hold_s3p05)={VRBL} v(sn0_s3p05)=0 v(sn1_s3p05)=1.8 v(sn2_s3p05)=0 v(sn3_s3p05)=1.8
.ic v(rbl_s3p06)={VRBL} v(hold_s3p06)={VRBL} v(sn0_s3p06)=1.8 v(sn1_s3p06)=0 v(sn2_s3p06)=0 v(sn3_s3p06)=1.8
.ic v(rbl_s3p07)={VRBL} v(hold_s3p07)={VRBL} v(sn0_s3p07)=0 v(sn1_s3p07)=0 v(sn2_s3p07)=0 v(sn3_s3p07)=1.8
.ic v(rbl_s3p08)={VRBL} v(hold_s3p08)={VRBL} v(sn0_s3p08)=1.8 v(sn1_s3p08)=1.8 v(sn2_s3p08)=1.8 v(sn3_s3p08)=0
.ic v(rbl_s3p09)={VRBL} v(hold_s3p09)={VRBL} v(sn0_s3p09)=0 v(sn1_s3p09)=1.8 v(sn2_s3p09)=1.8 v(sn3_s3p09)=0
.ic v(rbl_s3p10)={VRBL} v(hold_s3p10)={VRBL} v(sn0_s3p10)=1.8 v(sn1_s3p10)=0 v(sn2_s3p10)=1.8 v(sn3_s3p10)=0
.ic v(rbl_s3p11)={VRBL} v(hold_s3p11)={VRBL} v(sn0_s3p11)=0 v(sn1_s3p11)=0 v(sn2_s3p11)=1.8 v(sn3_s3p11)=0
.ic v(rbl_s3p12)={VRBL} v(hold_s3p12)={VRBL} v(sn0_s3p12)=1.8 v(sn1_s3p12)=1.8 v(sn2_s3p12)=0 v(sn3_s3p12)=0
.ic v(rbl_s3p13)={VRBL} v(hold_s3p13)={VRBL} v(sn0_s3p13)=0 v(sn1_s3p13)=1.8 v(sn2_s3p13)=0 v(sn3_s3p13)=0
.ic v(rbl_s3p14)={VRBL} v(hold_s3p14)={VRBL} v(sn0_s3p14)=1.8 v(sn1_s3p14)=0 v(sn2_s3p14)=0 v(sn3_s3p14)=0
.ic v(rbl_s3p15)={VRBL} v(hold_s3p15)={VRBL} v(sn0_s3p15)=0 v(sn1_s3p15)=0 v(sn2_s3p15)=0 v(sn3_s3p15)=0
