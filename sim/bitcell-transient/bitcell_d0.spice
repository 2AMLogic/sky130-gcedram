* bitcell_d0.spice -- 2T-min bitcell write / read / hold transient, stored '0' (issue #182).
* GENERATED by gen_bitcell_transient.py; do not edit. Circuit body for `klt sim`: the PDK .lib / .temp
* are appended per corner by klt; analysis and .meas cards are in request_*.json.
* Same circuit as tb_bitcell_transient.spice.tmpl (phase timing / bias parsed from its .param block).
* Device cards copied verbatim from design/gain_cell_2t.spice (sha256:7d1fe877ee5a7789e5b6f4b29788e1ecd927112de99e3156ba246eb2dcb73ad5).
* c_sn = 0.672741 fF: extracted total for `sn` (layout/gain_cell_2t.extract.parasitics.json).
.param VDD    = 1.8
.param VRBL   = 0.9
.param TEDGE       = 1.000000e-10
.param TWL_ON      = 1.000000e-09
.param TWL_OFF     = 2.100000e-08
.param TBL_OFF     = 2.300000e-08
.param TRWL_ON     = 3.000000e-08
.param TRWL_OFF    = 5.000000e-08
.param THOLD_START = 5.500000e-08
.param VBL_DATA = 0
.param VSN_INIT = 1.8
XM_WR sn wl bl GND sky130_fd_pr__nfet_01v8 L=0.15 W=0.42 nf=1 ad=0.1218 as=0.1218 pd=1.42 ps=1.42 nrd=0.69047619047619
+ nrs=0.69047619047619 sa=0 sb=0 sd=0 mult=1 m=1
XM_RD rbl sn rwl GND sky130_fd_pr__nfet_01v8 L=0.15 W=0.42 nf=1 ad=0.1218 as=0.1218 pd=1.42 ps=1.42 nrd=0.69047619047619
+ nrs=0.69047619047619 sa=0 sb=0 sd=0 mult=1 m=1
.GLOBAL GND
c_sn sn 0 6.727410e-16
vwl  wl  0 pulse(0 {VDD} {TWL_ON} {TEDGE} {TEDGE} {TWL_OFF-TWL_ON-TEDGE} 1)
vbl  bl  0 pwl(0 {VBL_DATA} {TBL_OFF} {VBL_DATA} {TBL_OFF+TEDGE} 0)
vrwl rwl 0 pwl(0 {VDD} {TRWL_ON} {VDD} {TRWL_ON+TEDGE} 0 {TRWL_OFF} 0 {TRWL_OFF+TEDGE} {VDD})
vrbl rbl 0 dc {VRBL}
.ic v(sn)={VSN_INIT}
