** sch_path: design/gain_cell_2t.sch
**.subckt gain_cell_2t wl bl rwl rbl
*.ipin wl
*.ipin bl
*.ipin rwl
*.opin rbl
XM_WR sn wl bl GND sky130_fd_pr__nfet_01v8 L=0.15 W=0.42 nf=1 ad=0.1218 as=0.1218 pd=1.42 ps=1.42 nrd=0.69047619047619
+ nrs=0.69047619047619 sa=0 sb=0 sd=0 mult=1 m=1
XM_RD rbl sn rwl GND sky130_fd_pr__nfet_01v8 L=0.15 W=0.42 nf=1 ad=0.1218 as=0.1218 pd=1.42 ps=1.42 nrd=0.69047619047619
+ nrs=0.69047619047619 sa=0 sb=0 sd=0 mult=1 m=1
**.ends
.GLOBAL GND
.end
