* column_periphery.spice -- column-periphery slice netlist (precharge, write driver, isolation), derived (issue #114).
* Regenerate with: ./design/regen_netlist.sh (requires PDK_ROOT/PDK, see
* design/README.md). --check verifies this file is not stale relative to
* a fresh regeneration from design/column_periphery.sch -- staleness is failure.
*
* Provenance: sha256 of the source schematic this netlist derives from
* (reproduce with: sha256sum design/column_periphery.sch). This is the
* file-content hash, not a git commit reference, so it stays meaningful
* in a shallow clone and does not drift when an unrelated commit
* elsewhere touches HEAD.
*   design/column_periphery.sch: sha256:8f90e5e3528b12e3451393f330ea510a294eddc1116ce719105a1346a0899668
*
* Every device instance below is one of {sky130_fd_pr__nfet_01v8, sky130_fd_pr__pfet_01v8} --
* mechanically by this script, not by review alone.
** sch_path: design/column_periphery.sch
**.subckt column_periphery rbl sbl ref sref wbl pre_b vpre dinb wen wenb sel selb vdd
*.iopin rbl
*.iopin sbl
*.iopin ref
*.iopin sref
*.iopin wbl
*.ipin pre_b
*.iopin vpre
*.ipin dinb
*.ipin wen
*.ipin wenb
*.ipin sel
*.ipin selb
*.iopin vdd
XMPPRE rbl pre_b vpre vpre sky130_fd_pr__pfet_01v8 L=0.15 W=4 nf=1 ad=1.16 as=1.16 pd=8.58 ps=8.58 nrd=0.0725
+ nrs=0.0725 sa=0 sb=0 sd=0 mult=1 m=1
XMPU1 x dinb vdd vdd sky130_fd_pr__pfet_01v8 L=0.15 W=1 nf=1 ad=0.29 as=0.29 pd=2.58 ps=2.58 nrd=0.29
+ nrs=0.29 sa=0 sb=0 sd=0 mult=1 m=1
XMPU2 wbl wenb x vdd sky130_fd_pr__pfet_01v8 L=0.15 W=1 nf=1 ad=0.29 as=0.29 pd=2.58 ps=2.58 nrd=0.29
+ nrs=0.29 sa=0 sb=0 sd=0 mult=1 m=1
XMND2 wbl wen y GND sky130_fd_pr__nfet_01v8 L=0.15 W=0.5 nf=1 ad=0.145 as=0.145 pd=1.58 ps=1.58 nrd=0.58
+ nrs=0.58 sa=0 sb=0 sd=0 mult=1 m=1
XMND1 y dinb GND GND sky130_fd_pr__nfet_01v8 L=0.15 W=0.5 nf=1 ad=0.145 as=0.145 pd=1.58 ps=1.58 nrd=0.58
+ nrs=0.58 sa=0 sb=0 sd=0 mult=1 m=1
XMNI wbl wenb GND GND sky130_fd_pr__nfet_01v8 L=0.15 W=0.42 nf=1 ad=0.1218 as=0.1218 pd=1.42 ps=1.42
+ nrd=0.69047619047619 nrs=0.69047619047619 sa=0 sb=0 sd=0 mult=1 m=1
XMNS sbl sel rbl GND sky130_fd_pr__nfet_01v8 L=0.15 W=1 nf=1 ad=0.29 as=0.29 pd=2.58 ps=2.58 nrd=0.29
+ nrs=0.29 sa=0 sb=0 sd=0 mult=1 m=1
XMPS sbl selb rbl vdd sky130_fd_pr__pfet_01v8 L=0.15 W=2 nf=1 ad=0.58 as=0.58 pd=4.58 ps=4.58 nrd=0.145
+ nrs=0.145 sa=0 sb=0 sd=0 mult=1 m=1
XMNSR sref sel ref GND sky130_fd_pr__nfet_01v8 L=0.15 W=1 nf=1 ad=0.29 as=0.29 pd=2.58 ps=2.58 nrd=0.29
+ nrs=0.29 sa=0 sb=0 sd=0 mult=1 m=1
XMPSR sref selb ref vdd sky130_fd_pr__pfet_01v8 L=0.15 W=2 nf=1 ad=0.58 as=0.58 pd=4.58 ps=4.58 nrd=0.145
+ nrs=0.145 sa=0 sb=0 sd=0 mult=1 m=1
**.ends
.GLOBAL GND
.end
